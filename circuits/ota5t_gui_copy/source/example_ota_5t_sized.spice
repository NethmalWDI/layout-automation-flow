** sch_path: /foss/designs/PROJECTS/llm-analog-sizing/results/example_ota_5t/example_ota_5t_sized.sch
**.subckt example_ota_5t_sized VDD OUTP INP INN VSS
*.ipin INP
*.ipin INN
*.opin OUTP
*.iopin VDD
*.iopin VSS
XM3 net3 net3 VDD VDD sky130_fd_pr__pfet_01v8 L=1 W=8 nf=1 ad=2.32 as=2.32 pd=16.58 ps=16.58 nrd=0.03625 nrs=0.03625 sa=0 sb=0
+ sd=0 mult=1
XM4 OUTP net3 VDD VDD sky130_fd_pr__pfet_01v8 L=1 W=8 nf=1 ad=2.32 as=2.32 pd=16.58 ps=16.58 nrd=0.03625 nrs=0.03625 sa=0 sb=0
+ sd=0 mult=1
XM1 net3 INP net1 VSS sky130_fd_pr__nfet_01v8 L=0.5 W=24 nf=1 ad=6.96 as=6.96 pd=48.58 ps=48.58 nrd=0.0120833333333333
+ nrs=0.0120833333333333 sa=0 sb=0 sd=0 mult=1
XM2 OUTP INN net1 VSS sky130_fd_pr__nfet_01v8 L=0.5 W=24 nf=1 ad=6.96 as=6.96 pd=48.58 ps=48.58 nrd=0.0120833333333333
+ nrs=0.0120833333333333 sa=0 sb=0 sd=0 mult=1
XM5 net1 net2 VSS VSS sky130_fd_pr__nfet_01v8 L=1 W=24 nf=1 ad=6.96 as=6.96 pd=48.58 ps=48.58 nrd=0.0120833333333333
+ nrs=0.0120833333333333 sa=0 sb=0 sd=0 mult=1
V1 net2 VSS 0.75
**.ends
.end
