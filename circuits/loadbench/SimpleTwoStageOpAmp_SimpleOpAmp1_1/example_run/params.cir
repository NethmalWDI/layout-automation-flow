.param param_lDiodeTransistorNmos1=2
.param param_wDiodeTransistorNmos1=137
.param param_mDiodeTransistorNmos1=1

.param param_lDiodeTransistorPmos2=2
.param param_wDiodeTransistorPmos2=7
.param param_mDiodeTransistorPmos2=1

.param param_lNormalTransistorNmos3=1
.param param_wNormalTransistorNmos3=454
.param param_mNormalTransistorNmos3=1

.param param_lNormalTransistorNmos4=param_lDiodeTransistorNmos1
.param param_wNormalTransistorNmos4=param_wDiodeTransistorNmos1
.param param_mNormalTransistorNmos4=param_mDiodeTransistorNmos1

.param param_lNormalTransistorPmos5=param_lDiodeTransistorPmos2
.param param_wNormalTransistorPmos5=599
.param param_mNormalTransistorPmos5=1

.param param_lNormalTransistorPmos6=2
.param param_wNormalTransistorPmos6=282
.param param_mNormalTransistorPmos6=1

.param param_lNormalTransistorPmos7=param_lNormalTransistorPmos6
.param param_wNormalTransistorPmos7=param_wNormalTransistorPmos6
.param param_mNormalTransistorPmos7=param_mNormalTransistorPmos6

.param param_lNormalTransistorPmos8=param_lDiodeTransistorPmos2
.param param_wNormalTransistorPmos8=180
.param param_mNormalTransistorPmos8=1

.param param_cCapacitor2=3.10001e-12
