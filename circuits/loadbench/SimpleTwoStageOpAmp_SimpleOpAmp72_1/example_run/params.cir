.param param_lDiodeTransistorNmos1=7e-6
.param param_wDiodeTransistorNmos1=29e-6
.param param_mDiodeTransistorNmos1=1

.param param_lDiodeTransistorNmos2=7e-6
.param param_wDiodeTransistorNmos2=171e-6
.param param_mDiodeTransistorNmos2=1

.param param_lDiodeTransistorNmos3=10e-6
.param param_wDiodeTransistorNmos3=204e-6
.param param_mDiodeTransistorNmos3=1

.param param_lDiodeTransistorPmos4=2e-6
.param param_wDiodeTransistorPmos4=95e-6
.param param_mDiodeTransistorPmos4=1

.param param_lDiodeTransistorPmos5=3e-6
.param param_wDiodeTransistorPmos5=22e-6
.param param_mDiodeTransistorPmos5=1

.param param_lNormalTransistorNmos6=3e-6
.param param_wNormalTransistorNmos6=392e-6
.param param_mNormalTransistorNmos6=1

.param param_lNormalTransistorNmos7=param_lDiodeTransistorNmos2
.param param_wNormalTransistorNmos7=149e-6
.param param_mNormalTransistorNmos7=1

.param param_lNormalTransistorNmos8=param_lDiodeTransistorNmos2
.param param_wNormalTransistorNmos8=217e-6
.param param_mNormalTransistorNmos8=1

.param param_lNormalTransistorNmos9=param_lDiodeTransistorNmos3
.param param_wNormalTransistorNmos9=param_wDiodeTransistorNmos3
.param param_mNormalTransistorNmos9=param_mDiodeTransistorNmos3

.param param_lNormalTransistorNmos10=3e-6
.param param_wNormalTransistorNmos10=34e-6
.param param_mNormalTransistorNmos10=1

.param param_lNormalTransistorNmos11=param_lNormalTransistorNmos10
.param param_wNormalTransistorNmos11=param_wNormalTransistorNmos10
.param param_mNormalTransistorNmos11=param_mNormalTransistorNmos10

.param param_lNormalTransistorNmos12=param_lDiodeTransistorNmos1
.param param_wNormalTransistorNmos12=param_wDiodeTransistorNmos2
.param param_mNormalTransistorNmos12=1

.param param_lNormalTransistorNmos13=param_lDiodeTransistorNmos2
.param param_wNormalTransistorNmos13=param_wDiodeTransistorNmos1
.param param_mNormalTransistorNmos13=1

.param param_lNormalTransistorPmos14=param_lDiodeTransistorPmos4
.param param_wNormalTransistorPmos14=549e-6
.param param_mNormalTransistorPmos14=1

.param param_lNormalTransistorPmos15=3e-6
.param param_wNormalTransistorPmos15=201e-6
.param param_mNormalTransistorPmos15=1

.param param_lNormalTransistorPmos16=param_lNormalTransistorPmos15
.param param_wNormalTransistorPmos16=param_wNormalTransistorPmos15
.param param_mNormalTransistorPmos16=param_mNormalTransistorPmos15

.param param_lNormalTransistorPmos17=param_lDiodeTransistorPmos4
.param param_wNormalTransistorPmos17=133e-6
.param param_mNormalTransistorPmos17=1

.param param_lNormalTransistorPmos18=param_lDiodeTransistorPmos4
.param param_wNormalTransistorPmos18=param_wNormalTransistorPmos17
.param param_mNormalTransistorPmos18=param_mNormalTransistorPmos17

.param param_cCapacitor2=9.10001e-12
