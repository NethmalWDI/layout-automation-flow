.param param_lDiodeTransistorNmos1=1e-6
.param param_wDiodeTransistorNmos1=26e-6
.param param_mDiodeTransistorNmos1=1

.param param_lDiodeTransistorPmos2=3e-6
.param param_wDiodeTransistorPmos2=5e-6
.param param_mDiodeTransistorPmos2=1

.param param_lNormalTransistorNmos3=1e-6
.param param_wNormalTransistorNmos3=353e-6
.param param_mNormalTransistorNmos3=1

.param param_lNormalTransistorNmos4=1e-6
.param param_wNormalTransistorNmos4=55e-6
.param param_mNormalTransistorNmos4=1

.param param_lNormalTransistorNmos5=6e-6
.param param_wNormalTransistorNmos5=494e-6
.param param_mNormalTransistorNmos5=1

.param param_lNormalTransistorNmos6=param_lNormalTransistorNmos5
.param param_wNormalTransistorNmos6=param_wNormalTransistorNmos5
.param param_mNormalTransistorNmos6=param_mNormalTransistorNmos5

.param param_lNormalTransistorNmos7=param_lNormalTransistorNmos4
.param param_wNormalTransistorNmos7=param_wNormalTransistorNmos4
.param param_mNormalTransistorNmos7=param_mNormalTransistorNmos4

.param param_lNormalTransistorNmos8=1e-6
.param param_wNormalTransistorNmos8=568e-6
.param param_mNormalTransistorNmos8=1

.param param_lNormalTransistorPmos9=param_lDiodeTransistorPmos2
.param param_wNormalTransistorPmos9=125e-6
.param param_mNormalTransistorPmos9=1

.param param_lNormalTransistorPmos10=param_lDiodeTransistorPmos2
.param param_wNormalTransistorPmos10=534e-6
.param param_mNormalTransistorPmos10=1

.param param_lNormalTransistorPmos11=4e-6
.param param_wNormalTransistorPmos11=370e-6
.param param_mNormalTransistorPmos11=1

.param param_lNormalTransistorPmos12=param_lNormalTransistorPmos11
.param param_wNormalTransistorPmos12=param_wNormalTransistorPmos11
.param param_mNormalTransistorPmos12=param_mNormalTransistorPmos11

.param param_lNormalTransistorPmos13=param_lDiodeTransistorPmos2
.param param_wNormalTransistorPmos13=155e-6
.param param_mNormalTransistorPmos13=1

.param param_cCapacitor2=2.30001e-12
