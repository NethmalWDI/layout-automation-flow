.param param_lDiodeTransistorNmos1=4e-6
.param param_wDiodeTransistorNmos1=4e-6
.param param_mDiodeTransistorNmos1=1

.param param_lDiodeTransistorNmos2=9e-6
.param param_wDiodeTransistorNmos2=168e-6
.param param_mDiodeTransistorNmos2=1

.param param_lDiodeTransistorPmos3=6e-6
.param param_wDiodeTransistorPmos3=95e-6
.param param_mDiodeTransistorPmos3=1

.param param_lDiodeTransistorPmos4=1e-6
.param param_wDiodeTransistorPmos4=69e-6
.param param_mDiodeTransistorPmos4=1

.param param_lDiodeTransistorPmos5=10e-6
.param param_wDiodeTransistorPmos5=101e-6
.param param_mDiodeTransistorPmos5=1

.param param_lNormalTransistorNmos6=param_lDiodeTransistorNmos1
.param param_wNormalTransistorNmos6=65e-6
.param param_mNormalTransistorNmos6=1

.param param_lNormalTransistorNmos7=param_lDiodeTransistorNmos1
.param param_wNormalTransistorNmos7=600e-6
.param param_mNormalTransistorNmos7=1

.param param_lNormalTransistorNmos8=1e-6
.param param_wNormalTransistorNmos8=16e-6
.param param_mNormalTransistorNmos8=1

.param param_lNormalTransistorNmos9=param_lDiodeTransistorNmos1
.param param_wNormalTransistorNmos9=20e-6
.param param_mNormalTransistorNmos9=1

.param param_lNormalTransistorNmos10=param_lNormalTransistorNmos8
.param param_wNormalTransistorNmos10=param_wNormalTransistorNmos8
.param param_mNormalTransistorNmos10=param_mNormalTransistorNmos8

.param param_lNormalTransistorNmos11=param_lDiodeTransistorNmos1
.param param_wNormalTransistorNmos11=25e-6
.param param_mNormalTransistorNmos11=1

.param param_lNormalTransistorNmos12=9e-6
.param param_wNormalTransistorNmos12=194e-6
.param param_mNormalTransistorNmos12=1

.param param_lNormalTransistorPmos13=1e-6
.param param_wNormalTransistorPmos13=456e-6
.param param_mNormalTransistorPmos13=1

.param param_lNormalTransistorPmos14=6e-6
.param param_wNormalTransistorPmos14=432e-6
.param param_mNormalTransistorPmos14=1

.param param_lNormalTransistorPmos15=param_lDiodeTransistorPmos4
.param param_wNormalTransistorPmos15=594e-6
.param param_mNormalTransistorPmos15=1

.param param_lNormalTransistorPmos16=param_lDiodeTransistorPmos5
.param param_wNormalTransistorPmos16=101e-6
.param param_mNormalTransistorPmos16=1

.param param_cCapacitor2=2.30001e-12
