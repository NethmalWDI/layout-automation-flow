* NGSPICE file created from M1.ext - technology: sky130A

.subckt sky130_fd_pr__nfet_01v8_LZQSHP B
X0 S G D B sky130_fd_pr__nfet_01v8 ad=6.96 pd=48.58 as=6.96 ps=48.58 w=24 l=0.5
.ends

.subckt M1
XM1_pc VSUBS sky130_fd_pr__nfet_01v8_LZQSHP
.ends
