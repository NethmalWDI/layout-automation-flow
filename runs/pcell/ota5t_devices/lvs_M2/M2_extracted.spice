* NGSPICE file created from M2_flat.ext - technology: sky130A

.subckt M2_flat M2_pc.B M2_pc.D M2_pc.S M2_pc.G
X0 M2_pc.S M2_pc.G M2_pc.D M2_pc.B sky130_fd_pr__nfet_01v8 ad=6.96 pd=48.58 as=6.96 ps=48.58 w=24 l=0.5
.ends
