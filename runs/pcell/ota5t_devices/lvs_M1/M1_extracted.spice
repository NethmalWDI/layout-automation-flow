* NGSPICE file created from M1_flat.ext - technology: sky130A

.subckt M1_flat M1_pc.B M1_pc.D M1_pc.S M1_pc.G
X0 M1_pc.S M1_pc.G M1_pc.D M1_pc.B sky130_fd_pr__nfet_01v8 ad=6.96 pd=48.58 as=6.96 ps=48.58 w=24 l=0.5
.ends
