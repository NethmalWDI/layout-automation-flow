* NGSPICE file created from M5_flat.ext - technology: sky130A

.subckt M5_flat M5_pc.B M5_pc.D M5_pc.S M5_pc.G
X0 M5_pc.S M5_pc.G M5_pc.D M5_pc.B sky130_fd_pr__nfet_01v8 ad=6.96 pd=48.58 as=6.96 ps=48.58 w=24 l=1
.ends
