* NGSPICE file created from M3_flat.ext - technology: sky130A

.subckt M3_flat M3_pc.B M3_pc.D M3_pc.S M3_pc.G
X0 M3_pc.S M3_pc.G M3_pc.D M3_pc.B sky130_fd_pr__pfet_01v8 ad=2.32 pd=16.58 as=2.32 ps=16.58 w=8 l=1
.ends
