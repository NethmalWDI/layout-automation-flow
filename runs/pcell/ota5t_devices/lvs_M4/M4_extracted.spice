* NGSPICE file created from M4_flat.ext - technology: sky130A

.subckt M4_flat M4_pc.B M4_pc.D M4_pc.S M4_pc.G
X0 M4_pc.S M4_pc.G M4_pc.D M4_pc.B sky130_fd_pr__pfet_01v8 ad=2.32 pd=16.58 as=2.32 ps=16.58 w=8 l=1
.ends
