.subckt five_transistor_ota vss vdd vout vinn vinp id
XM5 id id vss vss sky130_fd_pr__nfet_01v8 L=150e-9 w=10.5e-7 nf=10 stack=3
XM4 source id vss vss sky130_fd_pr__nfet_01v8 L=150e-9 w=10.5e-7 nf=10 stack=3
XM3 vout vinn source vss sky130_fd_pr__nfet_01v8 L=150e-9 w=10.5e-7 nf=20 stack=3
XM0 net8 vinp source vss sky130_fd_pr__nfet_01v8 L=150e-9 w=10.5e-7 nf=20 stack=3
XM2 vout net8 vdd vdd sky130_fd_pr__pfet_01v8 L=150e-9 w=10.5e-7 nf=20 stack=3
XM1 net8 net8 vdd vdd sky130_fd_pr__pfet_01v8 L=150e-9 w=10.5e-7 nf=20 stack=3
.ends five_transistor_ota
