.subckt five_transistor_ota vss vdd vout vinn vinp id
XM5_f0_s0 id id XM5_f0_n1 vss sky130_fd_pr__nfet_01v8 L=0.15 W=1.05 nf=1
XM5_f0_s1 XM5_f0_n1 id XM5_f0_n2 vss sky130_fd_pr__nfet_01v8 L=0.15 W=1.05 nf=1
XM5_f0_s2 XM5_f0_n2 id vss vss sky130_fd_pr__nfet_01v8 L=0.15 W=1.05 nf=1
XM5_f1_s0 id id XM5_f1_n1 vss sky130_fd_pr__nfet_01v8 L=0.15 W=1.05 nf=1
XM5_f1_s1 XM5_f1_n1 id XM5_f1_n2 vss sky130_fd_pr__nfet_01v8 L=0.15 W=1.05 nf=1
XM5_f1_s2 XM5_f1_n2 id vss vss sky130_fd_pr__nfet_01v8 L=0.15 W=1.05 nf=1
XM5_f2_s0 id id XM5_f2_n1 vss sky130_fd_pr__nfet_01v8 L=0.15 W=1.05 nf=1
XM5_f2_s1 XM5_f2_n1 id XM5_f2_n2 vss sky130_fd_pr__nfet_01v8 L=0.15 W=1.05 nf=1
XM5_f2_s2 XM5_f2_n2 id vss vss sky130_fd_pr__nfet_01v8 L=0.15 W=1.05 nf=1
XM5_f3_s0 id id XM5_f3_n1 vss sky130_fd_pr__nfet_01v8 L=0.15 W=1.05 nf=1
XM5_f3_s1 XM5_f3_n1 id XM5_f3_n2 vss sky130_fd_pr__nfet_01v8 L=0.15 W=1.05 nf=1
XM5_f3_s2 XM5_f3_n2 id vss vss sky130_fd_pr__nfet_01v8 L=0.15 W=1.05 nf=1
XM5_f4_s0 id id XM5_f4_n1 vss sky130_fd_pr__nfet_01v8 L=0.15 W=1.05 nf=1
XM5_f4_s1 XM5_f4_n1 id XM5_f4_n2 vss sky130_fd_pr__nfet_01v8 L=0.15 W=1.05 nf=1
XM5_f4_s2 XM5_f4_n2 id vss vss sky130_fd_pr__nfet_01v8 L=0.15 W=1.05 nf=1
XM5_f5_s0 id id XM5_f5_n1 vss sky130_fd_pr__nfet_01v8 L=0.15 W=1.05 nf=1
XM5_f5_s1 XM5_f5_n1 id XM5_f5_n2 vss sky130_fd_pr__nfet_01v8 L=0.15 W=1.05 nf=1
XM5_f5_s2 XM5_f5_n2 id vss vss sky130_fd_pr__nfet_01v8 L=0.15 W=1.05 nf=1
XM5_f6_s0 id id XM5_f6_n1 vss sky130_fd_pr__nfet_01v8 L=0.15 W=1.05 nf=1
XM5_f6_s1 XM5_f6_n1 id XM5_f6_n2 vss sky130_fd_pr__nfet_01v8 L=0.15 W=1.05 nf=1
XM5_f6_s2 XM5_f6_n2 id vss vss sky130_fd_pr__nfet_01v8 L=0.15 W=1.05 nf=1
XM5_f7_s0 id id XM5_f7_n1 vss sky130_fd_pr__nfet_01v8 L=0.15 W=1.05 nf=1
XM5_f7_s1 XM5_f7_n1 id XM5_f7_n2 vss sky130_fd_pr__nfet_01v8 L=0.15 W=1.05 nf=1
XM5_f7_s2 XM5_f7_n2 id vss vss sky130_fd_pr__nfet_01v8 L=0.15 W=1.05 nf=1
XM5_f8_s0 id id XM5_f8_n1 vss sky130_fd_pr__nfet_01v8 L=0.15 W=1.05 nf=1
XM5_f8_s1 XM5_f8_n1 id XM5_f8_n2 vss sky130_fd_pr__nfet_01v8 L=0.15 W=1.05 nf=1
XM5_f8_s2 XM5_f8_n2 id vss vss sky130_fd_pr__nfet_01v8 L=0.15 W=1.05 nf=1
XM5_f9_s0 id id XM5_f9_n1 vss sky130_fd_pr__nfet_01v8 L=0.15 W=1.05 nf=1
XM5_f9_s1 XM5_f9_n1 id XM5_f9_n2 vss sky130_fd_pr__nfet_01v8 L=0.15 W=1.05 nf=1
XM5_f9_s2 XM5_f9_n2 id vss vss sky130_fd_pr__nfet_01v8 L=0.15 W=1.05 nf=1
XM4_f0_s0 source id XM4_f0_n1 vss sky130_fd_pr__nfet_01v8 L=0.15 W=1.05 nf=1
XM4_f0_s1 XM4_f0_n1 id XM4_f0_n2 vss sky130_fd_pr__nfet_01v8 L=0.15 W=1.05 nf=1
XM4_f0_s2 XM4_f0_n2 id vss vss sky130_fd_pr__nfet_01v8 L=0.15 W=1.05 nf=1
XM4_f1_s0 source id XM4_f1_n1 vss sky130_fd_pr__nfet_01v8 L=0.15 W=1.05 nf=1
XM4_f1_s1 XM4_f1_n1 id XM4_f1_n2 vss sky130_fd_pr__nfet_01v8 L=0.15 W=1.05 nf=1
XM4_f1_s2 XM4_f1_n2 id vss vss sky130_fd_pr__nfet_01v8 L=0.15 W=1.05 nf=1
XM4_f2_s0 source id XM4_f2_n1 vss sky130_fd_pr__nfet_01v8 L=0.15 W=1.05 nf=1
XM4_f2_s1 XM4_f2_n1 id XM4_f2_n2 vss sky130_fd_pr__nfet_01v8 L=0.15 W=1.05 nf=1
XM4_f2_s2 XM4_f2_n2 id vss vss sky130_fd_pr__nfet_01v8 L=0.15 W=1.05 nf=1
XM4_f3_s0 source id XM4_f3_n1 vss sky130_fd_pr__nfet_01v8 L=0.15 W=1.05 nf=1
XM4_f3_s1 XM4_f3_n1 id XM4_f3_n2 vss sky130_fd_pr__nfet_01v8 L=0.15 W=1.05 nf=1
XM4_f3_s2 XM4_f3_n2 id vss vss sky130_fd_pr__nfet_01v8 L=0.15 W=1.05 nf=1
XM4_f4_s0 source id XM4_f4_n1 vss sky130_fd_pr__nfet_01v8 L=0.15 W=1.05 nf=1
XM4_f4_s1 XM4_f4_n1 id XM4_f4_n2 vss sky130_fd_pr__nfet_01v8 L=0.15 W=1.05 nf=1
XM4_f4_s2 XM4_f4_n2 id vss vss sky130_fd_pr__nfet_01v8 L=0.15 W=1.05 nf=1
XM4_f5_s0 source id XM4_f5_n1 vss sky130_fd_pr__nfet_01v8 L=0.15 W=1.05 nf=1
XM4_f5_s1 XM4_f5_n1 id XM4_f5_n2 vss sky130_fd_pr__nfet_01v8 L=0.15 W=1.05 nf=1
XM4_f5_s2 XM4_f5_n2 id vss vss sky130_fd_pr__nfet_01v8 L=0.15 W=1.05 nf=1
XM4_f6_s0 source id XM4_f6_n1 vss sky130_fd_pr__nfet_01v8 L=0.15 W=1.05 nf=1
XM4_f6_s1 XM4_f6_n1 id XM4_f6_n2 vss sky130_fd_pr__nfet_01v8 L=0.15 W=1.05 nf=1
XM4_f6_s2 XM4_f6_n2 id vss vss sky130_fd_pr__nfet_01v8 L=0.15 W=1.05 nf=1
XM4_f7_s0 source id XM4_f7_n1 vss sky130_fd_pr__nfet_01v8 L=0.15 W=1.05 nf=1
XM4_f7_s1 XM4_f7_n1 id XM4_f7_n2 vss sky130_fd_pr__nfet_01v8 L=0.15 W=1.05 nf=1
XM4_f7_s2 XM4_f7_n2 id vss vss sky130_fd_pr__nfet_01v8 L=0.15 W=1.05 nf=1
XM4_f8_s0 source id XM4_f8_n1 vss sky130_fd_pr__nfet_01v8 L=0.15 W=1.05 nf=1
XM4_f8_s1 XM4_f8_n1 id XM4_f8_n2 vss sky130_fd_pr__nfet_01v8 L=0.15 W=1.05 nf=1
XM4_f8_s2 XM4_f8_n2 id vss vss sky130_fd_pr__nfet_01v8 L=0.15 W=1.05 nf=1
XM4_f9_s0 source id XM4_f9_n1 vss sky130_fd_pr__nfet_01v8 L=0.15 W=1.05 nf=1
XM4_f9_s1 XM4_f9_n1 id XM4_f9_n2 vss sky130_fd_pr__nfet_01v8 L=0.15 W=1.05 nf=1
XM4_f9_s2 XM4_f9_n2 id vss vss sky130_fd_pr__nfet_01v8 L=0.15 W=1.05 nf=1
XM3_f0_s0 vout vinn XM3_f0_n1 vss sky130_fd_pr__nfet_01v8 L=0.15 W=1.05 nf=1
XM3_f0_s1 XM3_f0_n1 vinn XM3_f0_n2 vss sky130_fd_pr__nfet_01v8 L=0.15 W=1.05 nf=1
XM3_f0_s2 XM3_f0_n2 vinn source vss sky130_fd_pr__nfet_01v8 L=0.15 W=1.05 nf=1
XM3_f1_s0 vout vinn XM3_f1_n1 vss sky130_fd_pr__nfet_01v8 L=0.15 W=1.05 nf=1
XM3_f1_s1 XM3_f1_n1 vinn XM3_f1_n2 vss sky130_fd_pr__nfet_01v8 L=0.15 W=1.05 nf=1
XM3_f1_s2 XM3_f1_n2 vinn source vss sky130_fd_pr__nfet_01v8 L=0.15 W=1.05 nf=1
XM3_f2_s0 vout vinn XM3_f2_n1 vss sky130_fd_pr__nfet_01v8 L=0.15 W=1.05 nf=1
XM3_f2_s1 XM3_f2_n1 vinn XM3_f2_n2 vss sky130_fd_pr__nfet_01v8 L=0.15 W=1.05 nf=1
XM3_f2_s2 XM3_f2_n2 vinn source vss sky130_fd_pr__nfet_01v8 L=0.15 W=1.05 nf=1
XM3_f3_s0 vout vinn XM3_f3_n1 vss sky130_fd_pr__nfet_01v8 L=0.15 W=1.05 nf=1
XM3_f3_s1 XM3_f3_n1 vinn XM3_f3_n2 vss sky130_fd_pr__nfet_01v8 L=0.15 W=1.05 nf=1
XM3_f3_s2 XM3_f3_n2 vinn source vss sky130_fd_pr__nfet_01v8 L=0.15 W=1.05 nf=1
XM3_f4_s0 vout vinn XM3_f4_n1 vss sky130_fd_pr__nfet_01v8 L=0.15 W=1.05 nf=1
XM3_f4_s1 XM3_f4_n1 vinn XM3_f4_n2 vss sky130_fd_pr__nfet_01v8 L=0.15 W=1.05 nf=1
XM3_f4_s2 XM3_f4_n2 vinn source vss sky130_fd_pr__nfet_01v8 L=0.15 W=1.05 nf=1
XM3_f5_s0 vout vinn XM3_f5_n1 vss sky130_fd_pr__nfet_01v8 L=0.15 W=1.05 nf=1
XM3_f5_s1 XM3_f5_n1 vinn XM3_f5_n2 vss sky130_fd_pr__nfet_01v8 L=0.15 W=1.05 nf=1
XM3_f5_s2 XM3_f5_n2 vinn source vss sky130_fd_pr__nfet_01v8 L=0.15 W=1.05 nf=1
XM3_f6_s0 vout vinn XM3_f6_n1 vss sky130_fd_pr__nfet_01v8 L=0.15 W=1.05 nf=1
XM3_f6_s1 XM3_f6_n1 vinn XM3_f6_n2 vss sky130_fd_pr__nfet_01v8 L=0.15 W=1.05 nf=1
XM3_f6_s2 XM3_f6_n2 vinn source vss sky130_fd_pr__nfet_01v8 L=0.15 W=1.05 nf=1
XM3_f7_s0 vout vinn XM3_f7_n1 vss sky130_fd_pr__nfet_01v8 L=0.15 W=1.05 nf=1
XM3_f7_s1 XM3_f7_n1 vinn XM3_f7_n2 vss sky130_fd_pr__nfet_01v8 L=0.15 W=1.05 nf=1
XM3_f7_s2 XM3_f7_n2 vinn source vss sky130_fd_pr__nfet_01v8 L=0.15 W=1.05 nf=1
XM3_f8_s0 vout vinn XM3_f8_n1 vss sky130_fd_pr__nfet_01v8 L=0.15 W=1.05 nf=1
XM3_f8_s1 XM3_f8_n1 vinn XM3_f8_n2 vss sky130_fd_pr__nfet_01v8 L=0.15 W=1.05 nf=1
XM3_f8_s2 XM3_f8_n2 vinn source vss sky130_fd_pr__nfet_01v8 L=0.15 W=1.05 nf=1
XM3_f9_s0 vout vinn XM3_f9_n1 vss sky130_fd_pr__nfet_01v8 L=0.15 W=1.05 nf=1
XM3_f9_s1 XM3_f9_n1 vinn XM3_f9_n2 vss sky130_fd_pr__nfet_01v8 L=0.15 W=1.05 nf=1
XM3_f9_s2 XM3_f9_n2 vinn source vss sky130_fd_pr__nfet_01v8 L=0.15 W=1.05 nf=1
XM3_f10_s0 vout vinn XM3_f10_n1 vss sky130_fd_pr__nfet_01v8 L=0.15 W=1.05 nf=1
XM3_f10_s1 XM3_f10_n1 vinn XM3_f10_n2 vss sky130_fd_pr__nfet_01v8 L=0.15 W=1.05 nf=1
XM3_f10_s2 XM3_f10_n2 vinn source vss sky130_fd_pr__nfet_01v8 L=0.15 W=1.05 nf=1
XM3_f11_s0 vout vinn XM3_f11_n1 vss sky130_fd_pr__nfet_01v8 L=0.15 W=1.05 nf=1
XM3_f11_s1 XM3_f11_n1 vinn XM3_f11_n2 vss sky130_fd_pr__nfet_01v8 L=0.15 W=1.05 nf=1
XM3_f11_s2 XM3_f11_n2 vinn source vss sky130_fd_pr__nfet_01v8 L=0.15 W=1.05 nf=1
XM3_f12_s0 vout vinn XM3_f12_n1 vss sky130_fd_pr__nfet_01v8 L=0.15 W=1.05 nf=1
XM3_f12_s1 XM3_f12_n1 vinn XM3_f12_n2 vss sky130_fd_pr__nfet_01v8 L=0.15 W=1.05 nf=1
XM3_f12_s2 XM3_f12_n2 vinn source vss sky130_fd_pr__nfet_01v8 L=0.15 W=1.05 nf=1
XM3_f13_s0 vout vinn XM3_f13_n1 vss sky130_fd_pr__nfet_01v8 L=0.15 W=1.05 nf=1
XM3_f13_s1 XM3_f13_n1 vinn XM3_f13_n2 vss sky130_fd_pr__nfet_01v8 L=0.15 W=1.05 nf=1
XM3_f13_s2 XM3_f13_n2 vinn source vss sky130_fd_pr__nfet_01v8 L=0.15 W=1.05 nf=1
XM3_f14_s0 vout vinn XM3_f14_n1 vss sky130_fd_pr__nfet_01v8 L=0.15 W=1.05 nf=1
XM3_f14_s1 XM3_f14_n1 vinn XM3_f14_n2 vss sky130_fd_pr__nfet_01v8 L=0.15 W=1.05 nf=1
XM3_f14_s2 XM3_f14_n2 vinn source vss sky130_fd_pr__nfet_01v8 L=0.15 W=1.05 nf=1
XM3_f15_s0 vout vinn XM3_f15_n1 vss sky130_fd_pr__nfet_01v8 L=0.15 W=1.05 nf=1
XM3_f15_s1 XM3_f15_n1 vinn XM3_f15_n2 vss sky130_fd_pr__nfet_01v8 L=0.15 W=1.05 nf=1
XM3_f15_s2 XM3_f15_n2 vinn source vss sky130_fd_pr__nfet_01v8 L=0.15 W=1.05 nf=1
XM3_f16_s0 vout vinn XM3_f16_n1 vss sky130_fd_pr__nfet_01v8 L=0.15 W=1.05 nf=1
XM3_f16_s1 XM3_f16_n1 vinn XM3_f16_n2 vss sky130_fd_pr__nfet_01v8 L=0.15 W=1.05 nf=1
XM3_f16_s2 XM3_f16_n2 vinn source vss sky130_fd_pr__nfet_01v8 L=0.15 W=1.05 nf=1
XM3_f17_s0 vout vinn XM3_f17_n1 vss sky130_fd_pr__nfet_01v8 L=0.15 W=1.05 nf=1
XM3_f17_s1 XM3_f17_n1 vinn XM3_f17_n2 vss sky130_fd_pr__nfet_01v8 L=0.15 W=1.05 nf=1
XM3_f17_s2 XM3_f17_n2 vinn source vss sky130_fd_pr__nfet_01v8 L=0.15 W=1.05 nf=1
XM3_f18_s0 vout vinn XM3_f18_n1 vss sky130_fd_pr__nfet_01v8 L=0.15 W=1.05 nf=1
XM3_f18_s1 XM3_f18_n1 vinn XM3_f18_n2 vss sky130_fd_pr__nfet_01v8 L=0.15 W=1.05 nf=1
XM3_f18_s2 XM3_f18_n2 vinn source vss sky130_fd_pr__nfet_01v8 L=0.15 W=1.05 nf=1
XM3_f19_s0 vout vinn XM3_f19_n1 vss sky130_fd_pr__nfet_01v8 L=0.15 W=1.05 nf=1
XM3_f19_s1 XM3_f19_n1 vinn XM3_f19_n2 vss sky130_fd_pr__nfet_01v8 L=0.15 W=1.05 nf=1
XM3_f19_s2 XM3_f19_n2 vinn source vss sky130_fd_pr__nfet_01v8 L=0.15 W=1.05 nf=1
XM0_f0_s0 net8 vinp XM0_f0_n1 vss sky130_fd_pr__nfet_01v8 L=0.15 W=1.05 nf=1
XM0_f0_s1 XM0_f0_n1 vinp XM0_f0_n2 vss sky130_fd_pr__nfet_01v8 L=0.15 W=1.05 nf=1
XM0_f0_s2 XM0_f0_n2 vinp source vss sky130_fd_pr__nfet_01v8 L=0.15 W=1.05 nf=1
XM0_f1_s0 net8 vinp XM0_f1_n1 vss sky130_fd_pr__nfet_01v8 L=0.15 W=1.05 nf=1
XM0_f1_s1 XM0_f1_n1 vinp XM0_f1_n2 vss sky130_fd_pr__nfet_01v8 L=0.15 W=1.05 nf=1
XM0_f1_s2 XM0_f1_n2 vinp source vss sky130_fd_pr__nfet_01v8 L=0.15 W=1.05 nf=1
XM0_f2_s0 net8 vinp XM0_f2_n1 vss sky130_fd_pr__nfet_01v8 L=0.15 W=1.05 nf=1
XM0_f2_s1 XM0_f2_n1 vinp XM0_f2_n2 vss sky130_fd_pr__nfet_01v8 L=0.15 W=1.05 nf=1
XM0_f2_s2 XM0_f2_n2 vinp source vss sky130_fd_pr__nfet_01v8 L=0.15 W=1.05 nf=1
XM0_f3_s0 net8 vinp XM0_f3_n1 vss sky130_fd_pr__nfet_01v8 L=0.15 W=1.05 nf=1
XM0_f3_s1 XM0_f3_n1 vinp XM0_f3_n2 vss sky130_fd_pr__nfet_01v8 L=0.15 W=1.05 nf=1
XM0_f3_s2 XM0_f3_n2 vinp source vss sky130_fd_pr__nfet_01v8 L=0.15 W=1.05 nf=1
XM0_f4_s0 net8 vinp XM0_f4_n1 vss sky130_fd_pr__nfet_01v8 L=0.15 W=1.05 nf=1
XM0_f4_s1 XM0_f4_n1 vinp XM0_f4_n2 vss sky130_fd_pr__nfet_01v8 L=0.15 W=1.05 nf=1
XM0_f4_s2 XM0_f4_n2 vinp source vss sky130_fd_pr__nfet_01v8 L=0.15 W=1.05 nf=1
XM0_f5_s0 net8 vinp XM0_f5_n1 vss sky130_fd_pr__nfet_01v8 L=0.15 W=1.05 nf=1
XM0_f5_s1 XM0_f5_n1 vinp XM0_f5_n2 vss sky130_fd_pr__nfet_01v8 L=0.15 W=1.05 nf=1
XM0_f5_s2 XM0_f5_n2 vinp source vss sky130_fd_pr__nfet_01v8 L=0.15 W=1.05 nf=1
XM0_f6_s0 net8 vinp XM0_f6_n1 vss sky130_fd_pr__nfet_01v8 L=0.15 W=1.05 nf=1
XM0_f6_s1 XM0_f6_n1 vinp XM0_f6_n2 vss sky130_fd_pr__nfet_01v8 L=0.15 W=1.05 nf=1
XM0_f6_s2 XM0_f6_n2 vinp source vss sky130_fd_pr__nfet_01v8 L=0.15 W=1.05 nf=1
XM0_f7_s0 net8 vinp XM0_f7_n1 vss sky130_fd_pr__nfet_01v8 L=0.15 W=1.05 nf=1
XM0_f7_s1 XM0_f7_n1 vinp XM0_f7_n2 vss sky130_fd_pr__nfet_01v8 L=0.15 W=1.05 nf=1
XM0_f7_s2 XM0_f7_n2 vinp source vss sky130_fd_pr__nfet_01v8 L=0.15 W=1.05 nf=1
XM0_f8_s0 net8 vinp XM0_f8_n1 vss sky130_fd_pr__nfet_01v8 L=0.15 W=1.05 nf=1
XM0_f8_s1 XM0_f8_n1 vinp XM0_f8_n2 vss sky130_fd_pr__nfet_01v8 L=0.15 W=1.05 nf=1
XM0_f8_s2 XM0_f8_n2 vinp source vss sky130_fd_pr__nfet_01v8 L=0.15 W=1.05 nf=1
XM0_f9_s0 net8 vinp XM0_f9_n1 vss sky130_fd_pr__nfet_01v8 L=0.15 W=1.05 nf=1
XM0_f9_s1 XM0_f9_n1 vinp XM0_f9_n2 vss sky130_fd_pr__nfet_01v8 L=0.15 W=1.05 nf=1
XM0_f9_s2 XM0_f9_n2 vinp source vss sky130_fd_pr__nfet_01v8 L=0.15 W=1.05 nf=1
XM0_f10_s0 net8 vinp XM0_f10_n1 vss sky130_fd_pr__nfet_01v8 L=0.15 W=1.05 nf=1
XM0_f10_s1 XM0_f10_n1 vinp XM0_f10_n2 vss sky130_fd_pr__nfet_01v8 L=0.15 W=1.05 nf=1
XM0_f10_s2 XM0_f10_n2 vinp source vss sky130_fd_pr__nfet_01v8 L=0.15 W=1.05 nf=1
XM0_f11_s0 net8 vinp XM0_f11_n1 vss sky130_fd_pr__nfet_01v8 L=0.15 W=1.05 nf=1
XM0_f11_s1 XM0_f11_n1 vinp XM0_f11_n2 vss sky130_fd_pr__nfet_01v8 L=0.15 W=1.05 nf=1
XM0_f11_s2 XM0_f11_n2 vinp source vss sky130_fd_pr__nfet_01v8 L=0.15 W=1.05 nf=1
XM0_f12_s0 net8 vinp XM0_f12_n1 vss sky130_fd_pr__nfet_01v8 L=0.15 W=1.05 nf=1
XM0_f12_s1 XM0_f12_n1 vinp XM0_f12_n2 vss sky130_fd_pr__nfet_01v8 L=0.15 W=1.05 nf=1
XM0_f12_s2 XM0_f12_n2 vinp source vss sky130_fd_pr__nfet_01v8 L=0.15 W=1.05 nf=1
XM0_f13_s0 net8 vinp XM0_f13_n1 vss sky130_fd_pr__nfet_01v8 L=0.15 W=1.05 nf=1
XM0_f13_s1 XM0_f13_n1 vinp XM0_f13_n2 vss sky130_fd_pr__nfet_01v8 L=0.15 W=1.05 nf=1
XM0_f13_s2 XM0_f13_n2 vinp source vss sky130_fd_pr__nfet_01v8 L=0.15 W=1.05 nf=1
XM0_f14_s0 net8 vinp XM0_f14_n1 vss sky130_fd_pr__nfet_01v8 L=0.15 W=1.05 nf=1
XM0_f14_s1 XM0_f14_n1 vinp XM0_f14_n2 vss sky130_fd_pr__nfet_01v8 L=0.15 W=1.05 nf=1
XM0_f14_s2 XM0_f14_n2 vinp source vss sky130_fd_pr__nfet_01v8 L=0.15 W=1.05 nf=1
XM0_f15_s0 net8 vinp XM0_f15_n1 vss sky130_fd_pr__nfet_01v8 L=0.15 W=1.05 nf=1
XM0_f15_s1 XM0_f15_n1 vinp XM0_f15_n2 vss sky130_fd_pr__nfet_01v8 L=0.15 W=1.05 nf=1
XM0_f15_s2 XM0_f15_n2 vinp source vss sky130_fd_pr__nfet_01v8 L=0.15 W=1.05 nf=1
XM0_f16_s0 net8 vinp XM0_f16_n1 vss sky130_fd_pr__nfet_01v8 L=0.15 W=1.05 nf=1
XM0_f16_s1 XM0_f16_n1 vinp XM0_f16_n2 vss sky130_fd_pr__nfet_01v8 L=0.15 W=1.05 nf=1
XM0_f16_s2 XM0_f16_n2 vinp source vss sky130_fd_pr__nfet_01v8 L=0.15 W=1.05 nf=1
XM0_f17_s0 net8 vinp XM0_f17_n1 vss sky130_fd_pr__nfet_01v8 L=0.15 W=1.05 nf=1
XM0_f17_s1 XM0_f17_n1 vinp XM0_f17_n2 vss sky130_fd_pr__nfet_01v8 L=0.15 W=1.05 nf=1
XM0_f17_s2 XM0_f17_n2 vinp source vss sky130_fd_pr__nfet_01v8 L=0.15 W=1.05 nf=1
XM0_f18_s0 net8 vinp XM0_f18_n1 vss sky130_fd_pr__nfet_01v8 L=0.15 W=1.05 nf=1
XM0_f18_s1 XM0_f18_n1 vinp XM0_f18_n2 vss sky130_fd_pr__nfet_01v8 L=0.15 W=1.05 nf=1
XM0_f18_s2 XM0_f18_n2 vinp source vss sky130_fd_pr__nfet_01v8 L=0.15 W=1.05 nf=1
XM0_f19_s0 net8 vinp XM0_f19_n1 vss sky130_fd_pr__nfet_01v8 L=0.15 W=1.05 nf=1
XM0_f19_s1 XM0_f19_n1 vinp XM0_f19_n2 vss sky130_fd_pr__nfet_01v8 L=0.15 W=1.05 nf=1
XM0_f19_s2 XM0_f19_n2 vinp source vss sky130_fd_pr__nfet_01v8 L=0.15 W=1.05 nf=1
XM2_f0_s0 vout net8 XM2_f0_n1 vdd sky130_fd_pr__pfet_01v8 L=0.15 W=1.05 nf=1
XM2_f0_s1 XM2_f0_n1 net8 XM2_f0_n2 vdd sky130_fd_pr__pfet_01v8 L=0.15 W=1.05 nf=1
XM2_f0_s2 XM2_f0_n2 net8 vdd vdd sky130_fd_pr__pfet_01v8 L=0.15 W=1.05 nf=1
XM2_f1_s0 vout net8 XM2_f1_n1 vdd sky130_fd_pr__pfet_01v8 L=0.15 W=1.05 nf=1
XM2_f1_s1 XM2_f1_n1 net8 XM2_f1_n2 vdd sky130_fd_pr__pfet_01v8 L=0.15 W=1.05 nf=1
XM2_f1_s2 XM2_f1_n2 net8 vdd vdd sky130_fd_pr__pfet_01v8 L=0.15 W=1.05 nf=1
XM2_f2_s0 vout net8 XM2_f2_n1 vdd sky130_fd_pr__pfet_01v8 L=0.15 W=1.05 nf=1
XM2_f2_s1 XM2_f2_n1 net8 XM2_f2_n2 vdd sky130_fd_pr__pfet_01v8 L=0.15 W=1.05 nf=1
XM2_f2_s2 XM2_f2_n2 net8 vdd vdd sky130_fd_pr__pfet_01v8 L=0.15 W=1.05 nf=1
XM2_f3_s0 vout net8 XM2_f3_n1 vdd sky130_fd_pr__pfet_01v8 L=0.15 W=1.05 nf=1
XM2_f3_s1 XM2_f3_n1 net8 XM2_f3_n2 vdd sky130_fd_pr__pfet_01v8 L=0.15 W=1.05 nf=1
XM2_f3_s2 XM2_f3_n2 net8 vdd vdd sky130_fd_pr__pfet_01v8 L=0.15 W=1.05 nf=1
XM2_f4_s0 vout net8 XM2_f4_n1 vdd sky130_fd_pr__pfet_01v8 L=0.15 W=1.05 nf=1
XM2_f4_s1 XM2_f4_n1 net8 XM2_f4_n2 vdd sky130_fd_pr__pfet_01v8 L=0.15 W=1.05 nf=1
XM2_f4_s2 XM2_f4_n2 net8 vdd vdd sky130_fd_pr__pfet_01v8 L=0.15 W=1.05 nf=1
XM2_f5_s0 vout net8 XM2_f5_n1 vdd sky130_fd_pr__pfet_01v8 L=0.15 W=1.05 nf=1
XM2_f5_s1 XM2_f5_n1 net8 XM2_f5_n2 vdd sky130_fd_pr__pfet_01v8 L=0.15 W=1.05 nf=1
XM2_f5_s2 XM2_f5_n2 net8 vdd vdd sky130_fd_pr__pfet_01v8 L=0.15 W=1.05 nf=1
XM2_f6_s0 vout net8 XM2_f6_n1 vdd sky130_fd_pr__pfet_01v8 L=0.15 W=1.05 nf=1
XM2_f6_s1 XM2_f6_n1 net8 XM2_f6_n2 vdd sky130_fd_pr__pfet_01v8 L=0.15 W=1.05 nf=1
XM2_f6_s2 XM2_f6_n2 net8 vdd vdd sky130_fd_pr__pfet_01v8 L=0.15 W=1.05 nf=1
XM2_f7_s0 vout net8 XM2_f7_n1 vdd sky130_fd_pr__pfet_01v8 L=0.15 W=1.05 nf=1
XM2_f7_s1 XM2_f7_n1 net8 XM2_f7_n2 vdd sky130_fd_pr__pfet_01v8 L=0.15 W=1.05 nf=1
XM2_f7_s2 XM2_f7_n2 net8 vdd vdd sky130_fd_pr__pfet_01v8 L=0.15 W=1.05 nf=1
XM2_f8_s0 vout net8 XM2_f8_n1 vdd sky130_fd_pr__pfet_01v8 L=0.15 W=1.05 nf=1
XM2_f8_s1 XM2_f8_n1 net8 XM2_f8_n2 vdd sky130_fd_pr__pfet_01v8 L=0.15 W=1.05 nf=1
XM2_f8_s2 XM2_f8_n2 net8 vdd vdd sky130_fd_pr__pfet_01v8 L=0.15 W=1.05 nf=1
XM2_f9_s0 vout net8 XM2_f9_n1 vdd sky130_fd_pr__pfet_01v8 L=0.15 W=1.05 nf=1
XM2_f9_s1 XM2_f9_n1 net8 XM2_f9_n2 vdd sky130_fd_pr__pfet_01v8 L=0.15 W=1.05 nf=1
XM2_f9_s2 XM2_f9_n2 net8 vdd vdd sky130_fd_pr__pfet_01v8 L=0.15 W=1.05 nf=1
XM2_f10_s0 vout net8 XM2_f10_n1 vdd sky130_fd_pr__pfet_01v8 L=0.15 W=1.05 nf=1
XM2_f10_s1 XM2_f10_n1 net8 XM2_f10_n2 vdd sky130_fd_pr__pfet_01v8 L=0.15 W=1.05 nf=1
XM2_f10_s2 XM2_f10_n2 net8 vdd vdd sky130_fd_pr__pfet_01v8 L=0.15 W=1.05 nf=1
XM2_f11_s0 vout net8 XM2_f11_n1 vdd sky130_fd_pr__pfet_01v8 L=0.15 W=1.05 nf=1
XM2_f11_s1 XM2_f11_n1 net8 XM2_f11_n2 vdd sky130_fd_pr__pfet_01v8 L=0.15 W=1.05 nf=1
XM2_f11_s2 XM2_f11_n2 net8 vdd vdd sky130_fd_pr__pfet_01v8 L=0.15 W=1.05 nf=1
XM2_f12_s0 vout net8 XM2_f12_n1 vdd sky130_fd_pr__pfet_01v8 L=0.15 W=1.05 nf=1
XM2_f12_s1 XM2_f12_n1 net8 XM2_f12_n2 vdd sky130_fd_pr__pfet_01v8 L=0.15 W=1.05 nf=1
XM2_f12_s2 XM2_f12_n2 net8 vdd vdd sky130_fd_pr__pfet_01v8 L=0.15 W=1.05 nf=1
XM2_f13_s0 vout net8 XM2_f13_n1 vdd sky130_fd_pr__pfet_01v8 L=0.15 W=1.05 nf=1
XM2_f13_s1 XM2_f13_n1 net8 XM2_f13_n2 vdd sky130_fd_pr__pfet_01v8 L=0.15 W=1.05 nf=1
XM2_f13_s2 XM2_f13_n2 net8 vdd vdd sky130_fd_pr__pfet_01v8 L=0.15 W=1.05 nf=1
XM2_f14_s0 vout net8 XM2_f14_n1 vdd sky130_fd_pr__pfet_01v8 L=0.15 W=1.05 nf=1
XM2_f14_s1 XM2_f14_n1 net8 XM2_f14_n2 vdd sky130_fd_pr__pfet_01v8 L=0.15 W=1.05 nf=1
XM2_f14_s2 XM2_f14_n2 net8 vdd vdd sky130_fd_pr__pfet_01v8 L=0.15 W=1.05 nf=1
XM2_f15_s0 vout net8 XM2_f15_n1 vdd sky130_fd_pr__pfet_01v8 L=0.15 W=1.05 nf=1
XM2_f15_s1 XM2_f15_n1 net8 XM2_f15_n2 vdd sky130_fd_pr__pfet_01v8 L=0.15 W=1.05 nf=1
XM2_f15_s2 XM2_f15_n2 net8 vdd vdd sky130_fd_pr__pfet_01v8 L=0.15 W=1.05 nf=1
XM2_f16_s0 vout net8 XM2_f16_n1 vdd sky130_fd_pr__pfet_01v8 L=0.15 W=1.05 nf=1
XM2_f16_s1 XM2_f16_n1 net8 XM2_f16_n2 vdd sky130_fd_pr__pfet_01v8 L=0.15 W=1.05 nf=1
XM2_f16_s2 XM2_f16_n2 net8 vdd vdd sky130_fd_pr__pfet_01v8 L=0.15 W=1.05 nf=1
XM2_f17_s0 vout net8 XM2_f17_n1 vdd sky130_fd_pr__pfet_01v8 L=0.15 W=1.05 nf=1
XM2_f17_s1 XM2_f17_n1 net8 XM2_f17_n2 vdd sky130_fd_pr__pfet_01v8 L=0.15 W=1.05 nf=1
XM2_f17_s2 XM2_f17_n2 net8 vdd vdd sky130_fd_pr__pfet_01v8 L=0.15 W=1.05 nf=1
XM2_f18_s0 vout net8 XM2_f18_n1 vdd sky130_fd_pr__pfet_01v8 L=0.15 W=1.05 nf=1
XM2_f18_s1 XM2_f18_n1 net8 XM2_f18_n2 vdd sky130_fd_pr__pfet_01v8 L=0.15 W=1.05 nf=1
XM2_f18_s2 XM2_f18_n2 net8 vdd vdd sky130_fd_pr__pfet_01v8 L=0.15 W=1.05 nf=1
XM2_f19_s0 vout net8 XM2_f19_n1 vdd sky130_fd_pr__pfet_01v8 L=0.15 W=1.05 nf=1
XM2_f19_s1 XM2_f19_n1 net8 XM2_f19_n2 vdd sky130_fd_pr__pfet_01v8 L=0.15 W=1.05 nf=1
XM2_f19_s2 XM2_f19_n2 net8 vdd vdd sky130_fd_pr__pfet_01v8 L=0.15 W=1.05 nf=1
XM1_f0_s0 net8 net8 XM1_f0_n1 vdd sky130_fd_pr__pfet_01v8 L=0.15 W=1.05 nf=1
XM1_f0_s1 XM1_f0_n1 net8 XM1_f0_n2 vdd sky130_fd_pr__pfet_01v8 L=0.15 W=1.05 nf=1
XM1_f0_s2 XM1_f0_n2 net8 vdd vdd sky130_fd_pr__pfet_01v8 L=0.15 W=1.05 nf=1
XM1_f1_s0 net8 net8 XM1_f1_n1 vdd sky130_fd_pr__pfet_01v8 L=0.15 W=1.05 nf=1
XM1_f1_s1 XM1_f1_n1 net8 XM1_f1_n2 vdd sky130_fd_pr__pfet_01v8 L=0.15 W=1.05 nf=1
XM1_f1_s2 XM1_f1_n2 net8 vdd vdd sky130_fd_pr__pfet_01v8 L=0.15 W=1.05 nf=1
XM1_f2_s0 net8 net8 XM1_f2_n1 vdd sky130_fd_pr__pfet_01v8 L=0.15 W=1.05 nf=1
XM1_f2_s1 XM1_f2_n1 net8 XM1_f2_n2 vdd sky130_fd_pr__pfet_01v8 L=0.15 W=1.05 nf=1
XM1_f2_s2 XM1_f2_n2 net8 vdd vdd sky130_fd_pr__pfet_01v8 L=0.15 W=1.05 nf=1
XM1_f3_s0 net8 net8 XM1_f3_n1 vdd sky130_fd_pr__pfet_01v8 L=0.15 W=1.05 nf=1
XM1_f3_s1 XM1_f3_n1 net8 XM1_f3_n2 vdd sky130_fd_pr__pfet_01v8 L=0.15 W=1.05 nf=1
XM1_f3_s2 XM1_f3_n2 net8 vdd vdd sky130_fd_pr__pfet_01v8 L=0.15 W=1.05 nf=1
XM1_f4_s0 net8 net8 XM1_f4_n1 vdd sky130_fd_pr__pfet_01v8 L=0.15 W=1.05 nf=1
XM1_f4_s1 XM1_f4_n1 net8 XM1_f4_n2 vdd sky130_fd_pr__pfet_01v8 L=0.15 W=1.05 nf=1
XM1_f4_s2 XM1_f4_n2 net8 vdd vdd sky130_fd_pr__pfet_01v8 L=0.15 W=1.05 nf=1
XM1_f5_s0 net8 net8 XM1_f5_n1 vdd sky130_fd_pr__pfet_01v8 L=0.15 W=1.05 nf=1
XM1_f5_s1 XM1_f5_n1 net8 XM1_f5_n2 vdd sky130_fd_pr__pfet_01v8 L=0.15 W=1.05 nf=1
XM1_f5_s2 XM1_f5_n2 net8 vdd vdd sky130_fd_pr__pfet_01v8 L=0.15 W=1.05 nf=1
XM1_f6_s0 net8 net8 XM1_f6_n1 vdd sky130_fd_pr__pfet_01v8 L=0.15 W=1.05 nf=1
XM1_f6_s1 XM1_f6_n1 net8 XM1_f6_n2 vdd sky130_fd_pr__pfet_01v8 L=0.15 W=1.05 nf=1
XM1_f6_s2 XM1_f6_n2 net8 vdd vdd sky130_fd_pr__pfet_01v8 L=0.15 W=1.05 nf=1
XM1_f7_s0 net8 net8 XM1_f7_n1 vdd sky130_fd_pr__pfet_01v8 L=0.15 W=1.05 nf=1
XM1_f7_s1 XM1_f7_n1 net8 XM1_f7_n2 vdd sky130_fd_pr__pfet_01v8 L=0.15 W=1.05 nf=1
XM1_f7_s2 XM1_f7_n2 net8 vdd vdd sky130_fd_pr__pfet_01v8 L=0.15 W=1.05 nf=1
XM1_f8_s0 net8 net8 XM1_f8_n1 vdd sky130_fd_pr__pfet_01v8 L=0.15 W=1.05 nf=1
XM1_f8_s1 XM1_f8_n1 net8 XM1_f8_n2 vdd sky130_fd_pr__pfet_01v8 L=0.15 W=1.05 nf=1
XM1_f8_s2 XM1_f8_n2 net8 vdd vdd sky130_fd_pr__pfet_01v8 L=0.15 W=1.05 nf=1
XM1_f9_s0 net8 net8 XM1_f9_n1 vdd sky130_fd_pr__pfet_01v8 L=0.15 W=1.05 nf=1
XM1_f9_s1 XM1_f9_n1 net8 XM1_f9_n2 vdd sky130_fd_pr__pfet_01v8 L=0.15 W=1.05 nf=1
XM1_f9_s2 XM1_f9_n2 net8 vdd vdd sky130_fd_pr__pfet_01v8 L=0.15 W=1.05 nf=1
XM1_f10_s0 net8 net8 XM1_f10_n1 vdd sky130_fd_pr__pfet_01v8 L=0.15 W=1.05 nf=1
XM1_f10_s1 XM1_f10_n1 net8 XM1_f10_n2 vdd sky130_fd_pr__pfet_01v8 L=0.15 W=1.05 nf=1
XM1_f10_s2 XM1_f10_n2 net8 vdd vdd sky130_fd_pr__pfet_01v8 L=0.15 W=1.05 nf=1
XM1_f11_s0 net8 net8 XM1_f11_n1 vdd sky130_fd_pr__pfet_01v8 L=0.15 W=1.05 nf=1
XM1_f11_s1 XM1_f11_n1 net8 XM1_f11_n2 vdd sky130_fd_pr__pfet_01v8 L=0.15 W=1.05 nf=1
XM1_f11_s2 XM1_f11_n2 net8 vdd vdd sky130_fd_pr__pfet_01v8 L=0.15 W=1.05 nf=1
XM1_f12_s0 net8 net8 XM1_f12_n1 vdd sky130_fd_pr__pfet_01v8 L=0.15 W=1.05 nf=1
XM1_f12_s1 XM1_f12_n1 net8 XM1_f12_n2 vdd sky130_fd_pr__pfet_01v8 L=0.15 W=1.05 nf=1
XM1_f12_s2 XM1_f12_n2 net8 vdd vdd sky130_fd_pr__pfet_01v8 L=0.15 W=1.05 nf=1
XM1_f13_s0 net8 net8 XM1_f13_n1 vdd sky130_fd_pr__pfet_01v8 L=0.15 W=1.05 nf=1
XM1_f13_s1 XM1_f13_n1 net8 XM1_f13_n2 vdd sky130_fd_pr__pfet_01v8 L=0.15 W=1.05 nf=1
XM1_f13_s2 XM1_f13_n2 net8 vdd vdd sky130_fd_pr__pfet_01v8 L=0.15 W=1.05 nf=1
XM1_f14_s0 net8 net8 XM1_f14_n1 vdd sky130_fd_pr__pfet_01v8 L=0.15 W=1.05 nf=1
XM1_f14_s1 XM1_f14_n1 net8 XM1_f14_n2 vdd sky130_fd_pr__pfet_01v8 L=0.15 W=1.05 nf=1
XM1_f14_s2 XM1_f14_n2 net8 vdd vdd sky130_fd_pr__pfet_01v8 L=0.15 W=1.05 nf=1
XM1_f15_s0 net8 net8 XM1_f15_n1 vdd sky130_fd_pr__pfet_01v8 L=0.15 W=1.05 nf=1
XM1_f15_s1 XM1_f15_n1 net8 XM1_f15_n2 vdd sky130_fd_pr__pfet_01v8 L=0.15 W=1.05 nf=1
XM1_f15_s2 XM1_f15_n2 net8 vdd vdd sky130_fd_pr__pfet_01v8 L=0.15 W=1.05 nf=1
XM1_f16_s0 net8 net8 XM1_f16_n1 vdd sky130_fd_pr__pfet_01v8 L=0.15 W=1.05 nf=1
XM1_f16_s1 XM1_f16_n1 net8 XM1_f16_n2 vdd sky130_fd_pr__pfet_01v8 L=0.15 W=1.05 nf=1
XM1_f16_s2 XM1_f16_n2 net8 vdd vdd sky130_fd_pr__pfet_01v8 L=0.15 W=1.05 nf=1
XM1_f17_s0 net8 net8 XM1_f17_n1 vdd sky130_fd_pr__pfet_01v8 L=0.15 W=1.05 nf=1
XM1_f17_s1 XM1_f17_n1 net8 XM1_f17_n2 vdd sky130_fd_pr__pfet_01v8 L=0.15 W=1.05 nf=1
XM1_f17_s2 XM1_f17_n2 net8 vdd vdd sky130_fd_pr__pfet_01v8 L=0.15 W=1.05 nf=1
XM1_f18_s0 net8 net8 XM1_f18_n1 vdd sky130_fd_pr__pfet_01v8 L=0.15 W=1.05 nf=1
XM1_f18_s1 XM1_f18_n1 net8 XM1_f18_n2 vdd sky130_fd_pr__pfet_01v8 L=0.15 W=1.05 nf=1
XM1_f18_s2 XM1_f18_n2 net8 vdd vdd sky130_fd_pr__pfet_01v8 L=0.15 W=1.05 nf=1
XM1_f19_s0 net8 net8 XM1_f19_n1 vdd sky130_fd_pr__pfet_01v8 L=0.15 W=1.05 nf=1
XM1_f19_s1 XM1_f19_n1 net8 XM1_f19_n2 vdd sky130_fd_pr__pfet_01v8 L=0.15 W=1.05 nf=1
XM1_f19_s2 XM1_f19_n2 net8 vdd vdd sky130_fd_pr__pfet_01v8 L=0.15 W=1.05 nf=1
.ends five_transistor_ota
