* NGSPICE file created from FIVE_TRANSISTOR_OTA_0.ext - technology: sky130A

.subckt DP_NMOS_B_8176578_X5_Y2_1792774757 a_413_2408# a_200_252# a_200_1428# a_402_462#
+ a_147_462# a_402_1638#
X0 a_3154_462# a_200_1428# a_3068_462# a_413_2408# sky130_fd_pr__nfet_01v8 ad=0.147 pd=1.33 as=0.147 ps=1.33 w=1.05 l=0.15
X1 a_746_1638# a_200_252# a_147_462# a_413_2408# sky130_fd_pr__nfet_01v8 ad=0.147 pd=1.33 as=0.147 ps=1.33 w=1.05 l=0.15
X2 a_1348_1638# a_200_1428# a_1262_1638# a_413_2408# sky130_fd_pr__nfet_01v8 ad=0.147 pd=1.33 as=0.147 ps=1.33 w=1.05 l=0.15
X3 a_488_1638# a_200_1428# a_402_1638# a_413_2408# sky130_fd_pr__nfet_01v8 ad=0.147 pd=1.33 as=0.147 ps=1.33 w=1.05 l=0.15
X4 a_5218_1638# a_200_252# a_5132_1638# a_413_2408# sky130_fd_pr__nfet_01v8 ad=0.147 pd=1.33 as=0.147 ps=1.33 w=1.05 l=0.15
X5 a_3584_462# a_200_252# a_402_462# a_413_2408# sky130_fd_pr__nfet_01v8 ad=0.147 pd=1.33 as=0.147 ps=1.33 w=1.05 l=0.15
X6 a_3154_1638# a_200_252# a_3068_1638# a_413_2408# sky130_fd_pr__nfet_01v8 ad=0.147 pd=1.33 as=0.147 ps=1.33 w=1.05 l=0.15
X7 a_1090_462# a_200_1428# a_1004_462# a_413_2408# sky130_fd_pr__nfet_01v8 ad=0.147 pd=1.33 as=0.147 ps=1.33 w=1.05 l=0.15
X8 a_230_1638# a_200_1428# a_147_462# a_413_2408# sky130_fd_pr__nfet_01v8 ad=0.147 pd=1.33 as=0.27825 ps=2.63 w=1.05 l=0.15
X9 a_4100_462# a_200_1428# a_402_1638# a_413_2408# sky130_fd_pr__nfet_01v8 ad=0.147 pd=1.33 as=0.147 ps=1.33 w=1.05 l=0.15
X10 a_147_462# a_200_1428# a_3670_1638# a_413_2408# sky130_fd_pr__nfet_01v8 ad=0.147 pd=1.33 as=0.147 ps=1.33 w=1.05 l=0.15
X11 a_402_1638# a_200_1428# a_3928_462# a_413_2408# sky130_fd_pr__nfet_01v8 ad=0.147 pd=1.33 as=0.147 ps=1.33 w=1.05 l=0.15
X12 a_832_1638# a_200_252# a_746_1638# a_413_2408# sky130_fd_pr__nfet_01v8 ad=0.147 pd=1.33 as=0.147 ps=1.33 w=1.05 l=0.15
X13 a_402_1638# a_200_1428# a_1348_1638# a_413_2408# sky130_fd_pr__nfet_01v8 ad=0.147 pd=1.33 as=0.147 ps=1.33 w=1.05 l=0.15
X14 a_1520_462# a_200_252# a_402_462# a_413_2408# sky130_fd_pr__nfet_01v8 ad=0.147 pd=1.33 as=0.147 ps=1.33 w=1.05 l=0.15
X15 a_402_1638# a_200_1428# a_3412_1638# a_413_2408# sky130_fd_pr__nfet_01v8 ad=0.147 pd=1.33 as=0.147 ps=1.33 w=1.05 l=0.15
X16 a_574_1638# a_200_1428# a_488_1638# a_413_2408# sky130_fd_pr__nfet_01v8 ad=0.147 pd=1.33 as=0.147 ps=1.33 w=1.05 l=0.15
X17 a_402_462# a_200_252# a_1348_462# a_413_2408# sky130_fd_pr__nfet_01v8 ad=0.147 pd=1.33 as=0.147 ps=1.33 w=1.05 l=0.15
X18 a_147_462# a_200_252# a_1090_1638# a_413_2408# sky130_fd_pr__nfet_01v8 ad=0.147 pd=1.33 as=0.147 ps=1.33 w=1.05 l=0.15
X19 a_4444_462# a_200_252# a_4358_462# a_413_2408# sky130_fd_pr__nfet_01v8 ad=0.147 pd=1.33 as=0.147 ps=1.33 w=1.05 l=0.15
X20 a_147_462# a_200_252# a_5218_1638# a_413_2408# sky130_fd_pr__nfet_01v8 ad=0.27825 pd=2.63 as=0.147 ps=1.33 w=1.05 l=0.15
X21 a_147_462# a_200_252# a_3154_1638# a_413_2408# sky130_fd_pr__nfet_01v8 ad=0.147 pd=1.33 as=0.147 ps=1.33 w=1.05 l=0.15
X22 a_316_1638# a_200_1428# a_230_1638# a_413_2408# sky130_fd_pr__nfet_01v8 ad=0.147 pd=1.33 as=0.147 ps=1.33 w=1.05 l=0.15
X23 a_1864_462# a_200_1428# a_1778_462# a_413_2408# sky130_fd_pr__nfet_01v8 ad=0.147 pd=1.33 as=0.147 ps=1.33 w=1.05 l=0.15
X24 a_1778_1638# a_200_252# a_147_462# a_413_2408# sky130_fd_pr__nfet_01v8 ad=0.147 pd=1.33 as=0.147 ps=1.33 w=1.05 l=0.15
X25 a_4874_462# a_200_1428# a_147_462# a_413_2408# sky130_fd_pr__nfet_01v8 ad=0.147 pd=1.33 as=0.147 ps=1.33 w=1.05 l=0.15
X26 a_3842_1638# a_200_252# a_147_462# a_413_2408# sky130_fd_pr__nfet_01v8 ad=0.147 pd=1.33 as=0.147 ps=1.33 w=1.05 l=0.15
X27 a_402_462# a_200_252# a_832_1638# a_413_2408# sky130_fd_pr__nfet_01v8 ad=0.147 pd=1.33 as=0.147 ps=1.33 w=1.05 l=0.15
X28 a_402_462# a_200_252# a_316_462# a_413_2408# sky130_fd_pr__nfet_01v8 ad=0.147 pd=1.33 as=0.147 ps=1.33 w=1.05 l=0.15
X29 a_2380_462# a_200_252# a_2294_462# a_413_2408# sky130_fd_pr__nfet_01v8 ad=0.147 pd=1.33 as=0.147 ps=1.33 w=1.05 l=0.15
X30 a_3584_1638# a_200_1428# a_402_1638# a_413_2408# sky130_fd_pr__nfet_01v8 ad=0.147 pd=1.33 as=0.147 ps=1.33 w=1.05 l=0.15
X31 a_147_462# a_200_1428# a_574_1638# a_413_2408# sky130_fd_pr__nfet_01v8 ad=0.147 pd=1.33 as=0.147 ps=1.33 w=1.05 l=0.15
X32 a_1262_1638# a_200_1428# a_147_462# a_413_2408# sky130_fd_pr__nfet_01v8 ad=0.147 pd=1.33 as=0.147 ps=1.33 w=1.05 l=0.15
X33 a_3326_1638# a_200_1428# a_147_462# a_413_2408# sky130_fd_pr__nfet_01v8 ad=0.147 pd=1.33 as=0.147 ps=1.33 w=1.05 l=0.15
X34 a_402_1638# a_200_1428# a_316_1638# a_413_2408# sky130_fd_pr__nfet_01v8 ad=0.147 pd=1.33 as=0.147 ps=1.33 w=1.05 l=0.15
X35 a_2810_462# a_200_1428# a_147_462# a_413_2408# sky130_fd_pr__nfet_01v8 ad=0.147 pd=1.33 as=0.147 ps=1.33 w=1.05 l=0.15
X36 a_746_462# a_200_1428# a_147_462# a_413_2408# sky130_fd_pr__nfet_01v8 ad=0.147 pd=1.33 as=0.147 ps=1.33 w=1.05 l=0.15
X37 a_1864_1638# a_200_252# a_1778_1638# a_413_2408# sky130_fd_pr__nfet_01v8 ad=0.147 pd=1.33 as=0.147 ps=1.33 w=1.05 l=0.15
X38 a_3928_1638# a_200_252# a_3842_1638# a_413_2408# sky130_fd_pr__nfet_01v8 ad=0.147 pd=1.33 as=0.147 ps=1.33 w=1.05 l=0.15
X39 a_1004_1638# a_200_252# a_402_462# a_413_2408# sky130_fd_pr__nfet_01v8 ad=0.147 pd=1.33 as=0.147 ps=1.33 w=1.05 l=0.15
X40 a_1606_1638# a_200_1428# a_1520_1638# a_413_2408# sky130_fd_pr__nfet_01v8 ad=0.147 pd=1.33 as=0.147 ps=1.33 w=1.05 l=0.15
X41 a_147_462# a_200_1428# a_3154_462# a_413_2408# sky130_fd_pr__nfet_01v8 ad=0.147 pd=1.33 as=0.147 ps=1.33 w=1.05 l=0.15
X42 a_3670_1638# a_200_1428# a_3584_1638# a_413_2408# sky130_fd_pr__nfet_01v8 ad=0.147 pd=1.33 as=0.147 ps=1.33 w=1.05 l=0.15
X43 a_3326_462# a_200_252# a_147_462# a_413_2408# sky130_fd_pr__nfet_01v8 ad=0.147 pd=1.33 as=0.147 ps=1.33 w=1.05 l=0.15
X44 a_3412_1638# a_200_1428# a_3326_1638# a_413_2408# sky130_fd_pr__nfet_01v8 ad=0.147 pd=1.33 as=0.147 ps=1.33 w=1.05 l=0.15
X45 a_3670_462# a_200_252# a_3584_462# a_413_2408# sky130_fd_pr__nfet_01v8 ad=0.147 pd=1.33 as=0.147 ps=1.33 w=1.05 l=0.15
X46 a_1090_1638# a_200_252# a_1004_1638# a_413_2408# sky130_fd_pr__nfet_01v8 ad=0.147 pd=1.33 as=0.147 ps=1.33 w=1.05 l=0.15
X47 a_402_462# a_200_252# a_1864_1638# a_413_2408# sky130_fd_pr__nfet_01v8 ad=0.147 pd=1.33 as=0.147 ps=1.33 w=1.05 l=0.15
X48 a_402_462# a_200_252# a_3928_1638# a_413_2408# sky130_fd_pr__nfet_01v8 ad=0.147 pd=1.33 as=0.147 ps=1.33 w=1.05 l=0.15
X49 a_147_462# a_200_1428# a_1606_1638# a_413_2408# sky130_fd_pr__nfet_01v8 ad=0.147 pd=1.33 as=0.147 ps=1.33 w=1.05 l=0.15
X50 a_147_462# a_200_1428# a_1090_462# a_413_2408# sky130_fd_pr__nfet_01v8 ad=0.147 pd=1.33 as=0.147 ps=1.33 w=1.05 l=0.15
X51 a_4186_462# a_200_1428# a_4100_462# a_413_2408# sky130_fd_pr__nfet_01v8 ad=0.147 pd=1.33 as=0.147 ps=1.33 w=1.05 l=0.15
X52 a_402_462# a_200_252# a_4444_462# a_413_2408# sky130_fd_pr__nfet_01v8 ad=0.147 pd=1.33 as=0.147 ps=1.33 w=1.05 l=0.15
X53 a_1606_462# a_200_252# a_1520_462# a_413_2408# sky130_fd_pr__nfet_01v8 ad=0.147 pd=1.33 as=0.147 ps=1.33 w=1.05 l=0.15
X54 a_4616_462# a_200_252# a_402_462# a_413_2408# sky130_fd_pr__nfet_01v8 ad=0.147 pd=1.33 as=0.147 ps=1.33 w=1.05 l=0.15
X55 a_402_1638# a_200_1428# a_1864_462# a_413_2408# sky130_fd_pr__nfet_01v8 ad=0.147 pd=1.33 as=0.147 ps=1.33 w=1.05 l=0.15
X56 a_4960_462# a_200_1428# a_4874_462# a_413_2408# sky130_fd_pr__nfet_01v8 ad=0.147 pd=1.33 as=0.147 ps=1.33 w=1.05 l=0.15
X57 a_2122_462# a_200_1428# a_2036_462# a_413_2408# sky130_fd_pr__nfet_01v8 ad=0.147 pd=1.33 as=0.147 ps=1.33 w=1.05 l=0.15
X58 a_1520_1638# a_200_1428# a_402_1638# a_413_2408# sky130_fd_pr__nfet_01v8 ad=0.147 pd=1.33 as=0.147 ps=1.33 w=1.05 l=0.15
X59 a_2036_462# a_200_1428# a_402_1638# a_413_2408# sky130_fd_pr__nfet_01v8 ad=0.147 pd=1.33 as=0.147 ps=1.33 w=1.05 l=0.15
X60 a_402_1638# a_200_1428# a_4960_462# a_413_2408# sky130_fd_pr__nfet_01v8 ad=0.147 pd=1.33 as=0.147 ps=1.33 w=1.05 l=0.15
X61 a_4358_1638# a_200_1428# a_147_462# a_413_2408# sky130_fd_pr__nfet_01v8 ad=0.147 pd=1.33 as=0.147 ps=1.33 w=1.05 l=0.15
X62 a_402_462# a_200_252# a_2380_462# a_413_2408# sky130_fd_pr__nfet_01v8 ad=0.147 pd=1.33 as=0.147 ps=1.33 w=1.05 l=0.15
X63 a_488_462# a_200_252# a_402_462# a_413_2408# sky130_fd_pr__nfet_01v8 ad=0.147 pd=1.33 as=0.147 ps=1.33 w=1.05 l=0.15
X64 a_2036_1638# a_200_252# a_402_462# a_413_2408# sky130_fd_pr__nfet_01v8 ad=0.147 pd=1.33 as=0.147 ps=1.33 w=1.05 l=0.15
X65 a_832_462# a_200_1428# a_746_462# a_413_2408# sky130_fd_pr__nfet_01v8 ad=0.147 pd=1.33 as=0.147 ps=1.33 w=1.05 l=0.15
X66 a_402_1638# a_200_1428# a_832_462# a_413_2408# sky130_fd_pr__nfet_01v8 ad=0.147 pd=1.33 as=0.147 ps=1.33 w=1.05 l=0.15
X67 a_2896_462# a_200_1428# a_2810_462# a_413_2408# sky130_fd_pr__nfet_01v8 ad=0.147 pd=1.33 as=0.147 ps=1.33 w=1.05 l=0.15
X68 a_2638_1638# a_200_1428# a_2552_1638# a_413_2408# sky130_fd_pr__nfet_01v8 ad=0.147 pd=1.33 as=0.147 ps=1.33 w=1.05 l=0.15
X69 a_3412_462# a_200_252# a_3326_462# a_413_2408# sky130_fd_pr__nfet_01v8 ad=0.147 pd=1.33 as=0.147 ps=1.33 w=1.05 l=0.15
X70 a_4444_1638# a_200_1428# a_4358_1638# a_413_2408# sky130_fd_pr__nfet_01v8 ad=0.147 pd=1.33 as=0.147 ps=1.33 w=1.05 l=0.15
X71 a_4186_1638# a_200_252# a_4100_1638# a_413_2408# sky130_fd_pr__nfet_01v8 ad=0.147 pd=1.33 as=0.147 ps=1.33 w=1.05 l=0.15
X72 a_147_462# a_200_252# a_3670_462# a_413_2408# sky130_fd_pr__nfet_01v8 ad=0.147 pd=1.33 as=0.147 ps=1.33 w=1.05 l=0.15
X73 a_147_462# a_200_1428# a_4702_1638# a_413_2408# sky130_fd_pr__nfet_01v8 ad=0.147 pd=1.33 as=0.147 ps=1.33 w=1.05 l=0.15
X74 a_1262_462# a_200_252# a_147_462# a_413_2408# sky130_fd_pr__nfet_01v8 ad=0.147 pd=1.33 as=0.147 ps=1.33 w=1.05 l=0.15
X75 a_402_1638# a_200_1428# a_2380_1638# a_413_2408# sky130_fd_pr__nfet_01v8 ad=0.147 pd=1.33 as=0.147 ps=1.33 w=1.05 l=0.15
X76 a_147_462# a_200_1428# a_4186_462# a_413_2408# sky130_fd_pr__nfet_01v8 ad=0.147 pd=1.33 as=0.147 ps=1.33 w=1.05 l=0.15
X77 a_402_1638# a_200_1428# a_4444_1638# a_413_2408# sky130_fd_pr__nfet_01v8 ad=0.147 pd=1.33 as=0.147 ps=1.33 w=1.05 l=0.15
X78 a_147_462# a_200_252# a_2122_1638# a_413_2408# sky130_fd_pr__nfet_01v8 ad=0.147 pd=1.33 as=0.147 ps=1.33 w=1.05 l=0.15
X79 a_147_462# a_200_252# a_1606_462# a_413_2408# sky130_fd_pr__nfet_01v8 ad=0.147 pd=1.33 as=0.147 ps=1.33 w=1.05 l=0.15
X80 a_147_462# a_200_252# a_4186_1638# a_413_2408# sky130_fd_pr__nfet_01v8 ad=0.147 pd=1.33 as=0.147 ps=1.33 w=1.05 l=0.15
X81 a_4702_462# a_200_252# a_4616_462# a_413_2408# sky130_fd_pr__nfet_01v8 ad=0.147 pd=1.33 as=0.147 ps=1.33 w=1.05 l=0.15
X82 a_4874_1638# a_200_252# a_147_462# a_413_2408# sky130_fd_pr__nfet_01v8 ad=0.147 pd=1.33 as=0.147 ps=1.33 w=1.05 l=0.15
X83 a_4616_1638# a_200_1428# a_402_1638# a_413_2408# sky130_fd_pr__nfet_01v8 ad=0.147 pd=1.33 as=0.147 ps=1.33 w=1.05 l=0.15
X84 a_2552_1638# a_200_1428# a_402_1638# a_413_2408# sky130_fd_pr__nfet_01v8 ad=0.147 pd=1.33 as=0.147 ps=1.33 w=1.05 l=0.15
X85 a_5132_462# a_200_1428# a_402_1638# a_413_2408# sky130_fd_pr__nfet_01v8 ad=0.147 pd=1.33 as=0.147 ps=1.33 w=1.05 l=0.15
X86 a_147_462# a_200_1428# a_2122_462# a_413_2408# sky130_fd_pr__nfet_01v8 ad=0.147 pd=1.33 as=0.147 ps=1.33 w=1.05 l=0.15
X87 a_2552_462# a_200_252# a_402_462# a_413_2408# sky130_fd_pr__nfet_01v8 ad=0.147 pd=1.33 as=0.147 ps=1.33 w=1.05 l=0.15
X88 a_574_462# a_200_252# a_488_462# a_413_2408# sky130_fd_pr__nfet_01v8 ad=0.147 pd=1.33 as=0.147 ps=1.33 w=1.05 l=0.15
X89 a_2294_1638# a_200_1428# a_147_462# a_413_2408# sky130_fd_pr__nfet_01v8 ad=0.147 pd=1.33 as=0.147 ps=1.33 w=1.05 l=0.15
X90 a_5218_462# a_200_1428# a_5132_462# a_413_2408# sky130_fd_pr__nfet_01v8 ad=0.147 pd=1.33 as=0.147 ps=1.33 w=1.05 l=0.15
X91 a_4100_1638# a_200_252# a_402_462# a_413_2408# sky130_fd_pr__nfet_01v8 ad=0.147 pd=1.33 as=0.147 ps=1.33 w=1.05 l=0.15
X92 a_1004_462# a_200_1428# a_402_1638# a_413_2408# sky130_fd_pr__nfet_01v8 ad=0.147 pd=1.33 as=0.147 ps=1.33 w=1.05 l=0.15
X93 a_2896_1638# a_200_252# a_2810_1638# a_413_2408# sky130_fd_pr__nfet_01v8 ad=0.147 pd=1.33 as=0.147 ps=1.33 w=1.05 l=0.15
X94 a_402_1638# a_200_1428# a_2896_462# a_413_2408# sky130_fd_pr__nfet_01v8 ad=0.147 pd=1.33 as=0.147 ps=1.33 w=1.05 l=0.15
X95 a_4960_1638# a_200_252# a_4874_1638# a_413_2408# sky130_fd_pr__nfet_01v8 ad=0.147 pd=1.33 as=0.147 ps=1.33 w=1.05 l=0.15
X96 a_4702_1638# a_200_1428# a_4616_1638# a_413_2408# sky130_fd_pr__nfet_01v8 ad=0.147 pd=1.33 as=0.147 ps=1.33 w=1.05 l=0.15
X97 a_3068_462# a_200_1428# a_402_1638# a_413_2408# sky130_fd_pr__nfet_01v8 ad=0.147 pd=1.33 as=0.147 ps=1.33 w=1.05 l=0.15
X98 a_2380_1638# a_200_1428# a_2294_1638# a_413_2408# sky130_fd_pr__nfet_01v8 ad=0.147 pd=1.33 as=0.147 ps=1.33 w=1.05 l=0.15
X99 a_2122_1638# a_200_252# a_2036_1638# a_413_2408# sky130_fd_pr__nfet_01v8 ad=0.147 pd=1.33 as=0.147 ps=1.33 w=1.05 l=0.15
X100 a_402_462# a_200_252# a_3412_462# a_413_2408# sky130_fd_pr__nfet_01v8 ad=0.147 pd=1.33 as=0.147 ps=1.33 w=1.05 l=0.15
X101 a_402_462# a_200_252# a_2896_1638# a_413_2408# sky130_fd_pr__nfet_01v8 ad=0.147 pd=1.33 as=0.147 ps=1.33 w=1.05 l=0.15
X102 a_3842_462# a_200_1428# a_147_462# a_413_2408# sky130_fd_pr__nfet_01v8 ad=0.147 pd=1.33 as=0.147 ps=1.33 w=1.05 l=0.15
X103 a_147_462# a_200_1428# a_2638_1638# a_413_2408# sky130_fd_pr__nfet_01v8 ad=0.147 pd=1.33 as=0.147 ps=1.33 w=1.05 l=0.15
X104 a_3928_462# a_200_1428# a_3842_462# a_413_2408# sky130_fd_pr__nfet_01v8 ad=0.147 pd=1.33 as=0.147 ps=1.33 w=1.05 l=0.15
X105 a_1348_462# a_200_252# a_1262_462# a_413_2408# sky130_fd_pr__nfet_01v8 ad=0.147 pd=1.33 as=0.147 ps=1.33 w=1.05 l=0.15
X106 a_4358_462# a_200_252# a_147_462# a_413_2408# sky130_fd_pr__nfet_01v8 ad=0.147 pd=1.33 as=0.147 ps=1.33 w=1.05 l=0.15
X107 a_402_462# a_200_252# a_4960_1638# a_413_2408# sky130_fd_pr__nfet_01v8 ad=0.147 pd=1.33 as=0.147 ps=1.33 w=1.05 l=0.15
X108 a_1778_462# a_200_1428# a_147_462# a_413_2408# sky130_fd_pr__nfet_01v8 ad=0.147 pd=1.33 as=0.147 ps=1.33 w=1.05 l=0.15
X109 a_230_462# a_200_252# a_147_462# a_413_2408# sky130_fd_pr__nfet_01v8 ad=0.147 pd=1.33 as=0.27825 ps=2.63 w=1.05 l=0.15
X110 a_2810_1638# a_200_252# a_147_462# a_413_2408# sky130_fd_pr__nfet_01v8 ad=0.147 pd=1.33 as=0.147 ps=1.33 w=1.05 l=0.15
X111 a_147_462# a_200_252# a_4702_462# a_413_2408# sky130_fd_pr__nfet_01v8 ad=0.147 pd=1.33 as=0.147 ps=1.33 w=1.05 l=0.15
X112 a_316_462# a_200_252# a_230_462# a_413_2408# sky130_fd_pr__nfet_01v8 ad=0.147 pd=1.33 as=0.147 ps=1.33 w=1.05 l=0.15
X113 a_2294_462# a_200_252# a_147_462# a_413_2408# sky130_fd_pr__nfet_01v8 ad=0.147 pd=1.33 as=0.147 ps=1.33 w=1.05 l=0.15
X114 a_147_462# a_200_252# a_574_462# a_413_2408# sky130_fd_pr__nfet_01v8 ad=0.147 pd=1.33 as=0.147 ps=1.33 w=1.05 l=0.15
X115 a_147_462# a_200_1428# a_5218_462# a_413_2408# sky130_fd_pr__nfet_01v8 ad=0.27825 pd=2.63 as=0.147 ps=1.33 w=1.05 l=0.15
X116 a_147_462# a_200_252# a_2638_462# a_413_2408# sky130_fd_pr__nfet_01v8 ad=0.147 pd=1.33 as=0.147 ps=1.33 w=1.05 l=0.15
X117 a_3068_1638# a_200_252# a_402_462# a_413_2408# sky130_fd_pr__nfet_01v8 ad=0.147 pd=1.33 as=0.147 ps=1.33 w=1.05 l=0.15
X118 a_5132_1638# a_200_252# a_402_462# a_413_2408# sky130_fd_pr__nfet_01v8 ad=0.147 pd=1.33 as=0.147 ps=1.33 w=1.05 l=0.15
X119 a_2638_462# a_200_252# a_2552_462# a_413_2408# sky130_fd_pr__nfet_01v8 ad=0.147 pd=1.33 as=0.147 ps=1.33 w=1.05 l=0.15
.ends

.subckt SCM_NMOS_20351251_X5_Y1_1792774758 a_200_252# a_918_462# a_147_462#
X0 a_3154_462# a_200_252# a_3068_462# a_147_462# sky130_fd_pr__nfet_01v8 ad=0.147 pd=1.33 as=0.147 ps=1.33 w=1.05 l=0.15
X1 a_3584_462# a_200_252# a_200_252# a_147_462# sky130_fd_pr__nfet_01v8 ad=0.147 pd=1.33 as=0.147 ps=1.33 w=1.05 l=0.15
X2 a_1090_462# a_200_252# a_1004_462# a_147_462# sky130_fd_pr__nfet_01v8 ad=0.147 pd=1.33 as=0.147 ps=1.33 w=1.05 l=0.15
X3 a_918_462# a_200_252# a_3928_462# a_147_462# sky130_fd_pr__nfet_01v8 ad=0.147 pd=1.33 as=0.147 ps=1.33 w=1.05 l=0.15
X4 a_4100_462# a_200_252# a_918_462# a_147_462# sky130_fd_pr__nfet_01v8 ad=0.147 pd=1.33 as=0.147 ps=1.33 w=1.05 l=0.15
X5 a_200_252# a_200_252# a_1348_462# a_147_462# sky130_fd_pr__nfet_01v8 ad=0.147 pd=1.33 as=0.147 ps=1.33 w=1.05 l=0.15
X6 a_1520_462# a_200_252# a_200_252# a_147_462# sky130_fd_pr__nfet_01v8 ad=0.147 pd=1.33 as=0.147 ps=1.33 w=1.05 l=0.15
X7 a_1864_462# a_200_252# a_1778_462# a_147_462# sky130_fd_pr__nfet_01v8 ad=0.147 pd=1.33 as=0.147 ps=1.33 w=1.05 l=0.15
X8 a_4444_462# a_200_252# a_4358_462# a_147_462# sky130_fd_pr__nfet_01v8 ad=0.147 pd=1.33 as=0.147 ps=1.33 w=1.05 l=0.15
X9 a_200_252# a_200_252# a_316_462# a_147_462# sky130_fd_pr__nfet_01v8 ad=0.147 pd=1.33 as=0.147 ps=1.33 w=1.05 l=0.15
X10 a_2380_462# a_200_252# a_2294_462# a_147_462# sky130_fd_pr__nfet_01v8 ad=0.147 pd=1.33 as=0.147 ps=1.33 w=1.05 l=0.15
X11 a_4874_462# a_200_252# a_147_462# a_147_462# sky130_fd_pr__nfet_01v8 ad=0.147 pd=1.33 as=0.147 ps=1.33 w=1.05 l=0.15
X12 a_746_462# a_200_252# a_147_462# a_147_462# sky130_fd_pr__nfet_01v8 ad=0.147 pd=1.33 as=0.147 ps=1.33 w=1.05 l=0.15
X13 a_2810_462# a_200_252# a_147_462# a_147_462# sky130_fd_pr__nfet_01v8 ad=0.147 pd=1.33 as=0.147 ps=1.33 w=1.05 l=0.15
X14 a_147_462# a_200_252# a_3154_462# a_147_462# sky130_fd_pr__nfet_01v8 ad=0.147 pd=1.33 as=0.147 ps=1.33 w=1.05 l=0.15
X15 a_3326_462# a_200_252# a_147_462# a_147_462# sky130_fd_pr__nfet_01v8 ad=0.147 pd=1.33 as=0.147 ps=1.33 w=1.05 l=0.15
X16 a_3670_462# a_200_252# a_3584_462# a_147_462# sky130_fd_pr__nfet_01v8 ad=0.147 pd=1.33 as=0.147 ps=1.33 w=1.05 l=0.15
X17 a_147_462# a_200_252# a_1090_462# a_147_462# sky130_fd_pr__nfet_01v8 ad=0.147 pd=1.33 as=0.147 ps=1.33 w=1.05 l=0.15
X18 a_4186_462# a_200_252# a_4100_462# a_147_462# sky130_fd_pr__nfet_01v8 ad=0.147 pd=1.33 as=0.147 ps=1.33 w=1.05 l=0.15
X19 a_1606_462# a_200_252# a_1520_462# a_147_462# sky130_fd_pr__nfet_01v8 ad=0.147 pd=1.33 as=0.147 ps=1.33 w=1.05 l=0.15
X20 a_918_462# a_200_252# a_1864_462# a_147_462# sky130_fd_pr__nfet_01v8 ad=0.147 pd=1.33 as=0.147 ps=1.33 w=1.05 l=0.15
X21 a_200_252# a_200_252# a_4444_462# a_147_462# sky130_fd_pr__nfet_01v8 ad=0.147 pd=1.33 as=0.147 ps=1.33 w=1.05 l=0.15
X22 a_4616_462# a_200_252# a_200_252# a_147_462# sky130_fd_pr__nfet_01v8 ad=0.147 pd=1.33 as=0.147 ps=1.33 w=1.05 l=0.15
X23 a_2036_462# a_200_252# a_918_462# a_147_462# sky130_fd_pr__nfet_01v8 ad=0.147 pd=1.33 as=0.147 ps=1.33 w=1.05 l=0.15
X24 a_2122_462# a_200_252# a_2036_462# a_147_462# sky130_fd_pr__nfet_01v8 ad=0.147 pd=1.33 as=0.147 ps=1.33 w=1.05 l=0.15
X25 a_4960_462# a_200_252# a_4874_462# a_147_462# sky130_fd_pr__nfet_01v8 ad=0.147 pd=1.33 as=0.147 ps=1.33 w=1.05 l=0.15
X26 a_488_462# a_200_252# a_200_252# a_147_462# sky130_fd_pr__nfet_01v8 ad=0.147 pd=1.33 as=0.147 ps=1.33 w=1.05 l=0.15
X27 a_200_252# a_200_252# a_2380_462# a_147_462# sky130_fd_pr__nfet_01v8 ad=0.147 pd=1.33 as=0.147 ps=1.33 w=1.05 l=0.15
X28 a_918_462# a_200_252# a_4960_462# a_147_462# sky130_fd_pr__nfet_01v8 ad=0.147 pd=1.33 as=0.147 ps=1.33 w=1.05 l=0.15
X29 a_832_462# a_200_252# a_746_462# a_147_462# sky130_fd_pr__nfet_01v8 ad=0.147 pd=1.33 as=0.147 ps=1.33 w=1.05 l=0.15
X30 a_918_462# a_200_252# a_832_462# a_147_462# sky130_fd_pr__nfet_01v8 ad=0.147 pd=1.33 as=0.147 ps=1.33 w=1.05 l=0.15
X31 a_2896_462# a_200_252# a_2810_462# a_147_462# sky130_fd_pr__nfet_01v8 ad=0.147 pd=1.33 as=0.147 ps=1.33 w=1.05 l=0.15
X32 a_3412_462# a_200_252# a_3326_462# a_147_462# sky130_fd_pr__nfet_01v8 ad=0.147 pd=1.33 as=0.147 ps=1.33 w=1.05 l=0.15
X33 a_147_462# a_200_252# a_3670_462# a_147_462# sky130_fd_pr__nfet_01v8 ad=0.147 pd=1.33 as=0.147 ps=1.33 w=1.05 l=0.15
X34 a_1262_462# a_200_252# a_147_462# a_147_462# sky130_fd_pr__nfet_01v8 ad=0.147 pd=1.33 as=0.147 ps=1.33 w=1.05 l=0.15
X35 a_147_462# a_200_252# a_4186_462# a_147_462# sky130_fd_pr__nfet_01v8 ad=0.147 pd=1.33 as=0.147 ps=1.33 w=1.05 l=0.15
X36 a_147_462# a_200_252# a_1606_462# a_147_462# sky130_fd_pr__nfet_01v8 ad=0.147 pd=1.33 as=0.147 ps=1.33 w=1.05 l=0.15
X37 a_4702_462# a_200_252# a_4616_462# a_147_462# sky130_fd_pr__nfet_01v8 ad=0.147 pd=1.33 as=0.147 ps=1.33 w=1.05 l=0.15
X38 a_574_462# a_200_252# a_488_462# a_147_462# sky130_fd_pr__nfet_01v8 ad=0.147 pd=1.33 as=0.147 ps=1.33 w=1.05 l=0.15
X39 a_147_462# a_200_252# a_2122_462# a_147_462# sky130_fd_pr__nfet_01v8 ad=0.147 pd=1.33 as=0.147 ps=1.33 w=1.05 l=0.15
X40 a_2552_462# a_200_252# a_200_252# a_147_462# sky130_fd_pr__nfet_01v8 ad=0.147 pd=1.33 as=0.147 ps=1.33 w=1.05 l=0.15
X41 a_5132_462# a_200_252# a_918_462# a_147_462# sky130_fd_pr__nfet_01v8 ad=0.147 pd=1.33 as=0.147 ps=1.33 w=1.05 l=0.15
X42 a_5218_462# a_200_252# a_5132_462# a_147_462# sky130_fd_pr__nfet_01v8 ad=0.147 pd=1.33 as=0.147 ps=1.33 w=1.05 l=0.15
X43 a_1004_462# a_200_252# a_918_462# a_147_462# sky130_fd_pr__nfet_01v8 ad=0.147 pd=1.33 as=0.147 ps=1.33 w=1.05 l=0.15
X44 a_918_462# a_200_252# a_2896_462# a_147_462# sky130_fd_pr__nfet_01v8 ad=0.147 pd=1.33 as=0.147 ps=1.33 w=1.05 l=0.15
X45 a_3068_462# a_200_252# a_918_462# a_147_462# sky130_fd_pr__nfet_01v8 ad=0.147 pd=1.33 as=0.147 ps=1.33 w=1.05 l=0.15
X46 a_200_252# a_200_252# a_3412_462# a_147_462# sky130_fd_pr__nfet_01v8 ad=0.147 pd=1.33 as=0.147 ps=1.33 w=1.05 l=0.15
X47 a_3842_462# a_200_252# a_147_462# a_147_462# sky130_fd_pr__nfet_01v8 ad=0.147 pd=1.33 as=0.147 ps=1.33 w=1.05 l=0.15
X48 a_3928_462# a_200_252# a_3842_462# a_147_462# sky130_fd_pr__nfet_01v8 ad=0.147 pd=1.33 as=0.147 ps=1.33 w=1.05 l=0.15
X49 a_1348_462# a_200_252# a_1262_462# a_147_462# sky130_fd_pr__nfet_01v8 ad=0.147 pd=1.33 as=0.147 ps=1.33 w=1.05 l=0.15
X50 a_4358_462# a_200_252# a_147_462# a_147_462# sky130_fd_pr__nfet_01v8 ad=0.147 pd=1.33 as=0.147 ps=1.33 w=1.05 l=0.15
X51 a_230_462# a_200_252# a_147_462# a_147_462# sky130_fd_pr__nfet_01v8 ad=0.147 pd=1.33 as=0.27825 ps=2.63 w=1.05 l=0.15
X52 a_316_462# a_200_252# a_230_462# a_147_462# sky130_fd_pr__nfet_01v8 ad=0.147 pd=1.33 as=0.147 ps=1.33 w=1.05 l=0.15
X53 a_1778_462# a_200_252# a_147_462# a_147_462# sky130_fd_pr__nfet_01v8 ad=0.147 pd=1.33 as=0.147 ps=1.33 w=1.05 l=0.15
X54 a_147_462# a_200_252# a_4702_462# a_147_462# sky130_fd_pr__nfet_01v8 ad=0.147 pd=1.33 as=0.147 ps=1.33 w=1.05 l=0.15
X55 a_147_462# a_200_252# a_574_462# a_147_462# sky130_fd_pr__nfet_01v8 ad=0.147 pd=1.33 as=0.147 ps=1.33 w=1.05 l=0.15
X56 a_2294_462# a_200_252# a_147_462# a_147_462# sky130_fd_pr__nfet_01v8 ad=0.147 pd=1.33 as=0.147 ps=1.33 w=1.05 l=0.15
X57 a_147_462# a_200_252# a_5218_462# a_147_462# sky130_fd_pr__nfet_01v8 ad=0.27825 pd=2.63 as=0.147 ps=1.33 w=1.05 l=0.15
X58 a_2638_462# a_200_252# a_2552_462# a_147_462# sky130_fd_pr__nfet_01v8 ad=0.147 pd=1.33 as=0.147 ps=1.33 w=1.05 l=0.15
X59 a_147_462# a_200_252# a_2638_462# a_147_462# sky130_fd_pr__nfet_01v8 ad=0.147 pd=1.33 as=0.147 ps=1.33 w=1.05 l=0.15
.ends

.subckt SCM_PMOS_60929072_X5_Y2_1792774759 a_200_252# w_0_0# a_402_1638#
X0 w_0_0# a_200_252# a_574_1638# w_0_0# sky130_fd_pr__pfet_01v8 ad=0.147 pd=1.33 as=0.147 ps=1.33 w=1.05 l=0.15
X1 a_1262_1638# a_200_252# w_0_0# w_0_0# sky130_fd_pr__pfet_01v8 ad=0.147 pd=1.33 as=0.147 ps=1.33 w=1.05 l=0.15
X2 a_3326_1638# a_200_252# w_0_0# w_0_0# sky130_fd_pr__pfet_01v8 ad=0.147 pd=1.33 as=0.147 ps=1.33 w=1.05 l=0.15
X3 a_402_1638# a_200_252# a_316_1638# w_0_0# sky130_fd_pr__pfet_01v8 ad=0.147 pd=1.33 as=0.147 ps=1.33 w=1.05 l=0.15
X4 a_2810_462# a_200_252# w_0_0# w_0_0# sky130_fd_pr__pfet_01v8 ad=0.147 pd=1.33 as=0.147 ps=1.33 w=1.05 l=0.15
X5 a_746_462# a_200_252# w_0_0# w_0_0# sky130_fd_pr__pfet_01v8 ad=0.147 pd=1.33 as=0.147 ps=1.33 w=1.05 l=0.15
X6 a_1864_1638# a_200_252# a_1778_1638# w_0_0# sky130_fd_pr__pfet_01v8 ad=0.147 pd=1.33 as=0.147 ps=1.33 w=1.05 l=0.15
X7 a_3928_1638# a_200_252# a_3842_1638# w_0_0# sky130_fd_pr__pfet_01v8 ad=0.147 pd=1.33 as=0.147 ps=1.33 w=1.05 l=0.15
X8 a_1004_1638# a_200_252# a_200_252# w_0_0# sky130_fd_pr__pfet_01v8 ad=0.147 pd=1.33 as=0.147 ps=1.33 w=1.05 l=0.15
X9 a_1606_1638# a_200_252# a_1520_1638# w_0_0# sky130_fd_pr__pfet_01v8 ad=0.147 pd=1.33 as=0.147 ps=1.33 w=1.05 l=0.15
X10 w_0_0# a_200_252# a_3154_462# w_0_0# sky130_fd_pr__pfet_01v8 ad=0.147 pd=1.33 as=0.147 ps=1.33 w=1.05 l=0.15
X11 a_3670_1638# a_200_252# a_3584_1638# w_0_0# sky130_fd_pr__pfet_01v8 ad=0.147 pd=1.33 as=0.147 ps=1.33 w=1.05 l=0.15
X12 a_3326_462# a_200_252# w_0_0# w_0_0# sky130_fd_pr__pfet_01v8 ad=0.147 pd=1.33 as=0.147 ps=1.33 w=1.05 l=0.15
X13 a_3412_1638# a_200_252# a_3326_1638# w_0_0# sky130_fd_pr__pfet_01v8 ad=0.147 pd=1.33 as=0.147 ps=1.33 w=1.05 l=0.15
X14 a_3670_462# a_200_252# a_3584_462# w_0_0# sky130_fd_pr__pfet_01v8 ad=0.147 pd=1.33 as=0.147 ps=1.33 w=1.05 l=0.15
X15 a_1090_1638# a_200_252# a_1004_1638# w_0_0# sky130_fd_pr__pfet_01v8 ad=0.147 pd=1.33 as=0.147 ps=1.33 w=1.05 l=0.15
X16 a_200_252# a_200_252# a_1864_1638# w_0_0# sky130_fd_pr__pfet_01v8 ad=0.147 pd=1.33 as=0.147 ps=1.33 w=1.05 l=0.15
X17 a_200_252# a_200_252# a_3928_1638# w_0_0# sky130_fd_pr__pfet_01v8 ad=0.147 pd=1.33 as=0.147 ps=1.33 w=1.05 l=0.15
X18 w_0_0# a_200_252# a_1606_1638# w_0_0# sky130_fd_pr__pfet_01v8 ad=0.147 pd=1.33 as=0.147 ps=1.33 w=1.05 l=0.15
X19 w_0_0# a_200_252# a_1090_462# w_0_0# sky130_fd_pr__pfet_01v8 ad=0.147 pd=1.33 as=0.147 ps=1.33 w=1.05 l=0.15
X20 a_4186_462# a_200_252# a_4100_462# w_0_0# sky130_fd_pr__pfet_01v8 ad=0.147 pd=1.33 as=0.147 ps=1.33 w=1.05 l=0.15
X21 a_200_252# a_200_252# a_4444_462# w_0_0# sky130_fd_pr__pfet_01v8 ad=0.147 pd=1.33 as=0.147 ps=1.33 w=1.05 l=0.15
X22 a_1606_462# a_200_252# a_1520_462# w_0_0# sky130_fd_pr__pfet_01v8 ad=0.147 pd=1.33 as=0.147 ps=1.33 w=1.05 l=0.15
X23 a_4616_462# a_200_252# a_200_252# w_0_0# sky130_fd_pr__pfet_01v8 ad=0.147 pd=1.33 as=0.147 ps=1.33 w=1.05 l=0.15
X24 a_402_1638# a_200_252# a_1864_462# w_0_0# sky130_fd_pr__pfet_01v8 ad=0.147 pd=1.33 as=0.147 ps=1.33 w=1.05 l=0.15
X25 a_4960_462# a_200_252# a_4874_462# w_0_0# sky130_fd_pr__pfet_01v8 ad=0.147 pd=1.33 as=0.147 ps=1.33 w=1.05 l=0.15
X26 a_2122_462# a_200_252# a_2036_462# w_0_0# sky130_fd_pr__pfet_01v8 ad=0.147 pd=1.33 as=0.147 ps=1.33 w=1.05 l=0.15
X27 a_2036_462# a_200_252# a_402_1638# w_0_0# sky130_fd_pr__pfet_01v8 ad=0.147 pd=1.33 as=0.147 ps=1.33 w=1.05 l=0.15
X28 a_1520_1638# a_200_252# a_402_1638# w_0_0# sky130_fd_pr__pfet_01v8 ad=0.147 pd=1.33 as=0.147 ps=1.33 w=1.05 l=0.15
X29 a_402_1638# a_200_252# a_4960_462# w_0_0# sky130_fd_pr__pfet_01v8 ad=0.147 pd=1.33 as=0.147 ps=1.33 w=1.05 l=0.15
X30 a_4358_1638# a_200_252# w_0_0# w_0_0# sky130_fd_pr__pfet_01v8 ad=0.147 pd=1.33 as=0.147 ps=1.33 w=1.05 l=0.15
X31 a_200_252# a_200_252# a_2380_462# w_0_0# sky130_fd_pr__pfet_01v8 ad=0.147 pd=1.33 as=0.147 ps=1.33 w=1.05 l=0.15
X32 a_488_462# a_200_252# a_200_252# w_0_0# sky130_fd_pr__pfet_01v8 ad=0.147 pd=1.33 as=0.147 ps=1.33 w=1.05 l=0.15
X33 a_832_462# a_200_252# a_746_462# w_0_0# sky130_fd_pr__pfet_01v8 ad=0.147 pd=1.33 as=0.147 ps=1.33 w=1.05 l=0.15
X34 a_2036_1638# a_200_252# a_200_252# w_0_0# sky130_fd_pr__pfet_01v8 ad=0.147 pd=1.33 as=0.147 ps=1.33 w=1.05 l=0.15
X35 a_402_1638# a_200_252# a_832_462# w_0_0# sky130_fd_pr__pfet_01v8 ad=0.147 pd=1.33 as=0.147 ps=1.33 w=1.05 l=0.15
X36 a_2896_462# a_200_252# a_2810_462# w_0_0# sky130_fd_pr__pfet_01v8 ad=0.147 pd=1.33 as=0.147 ps=1.33 w=1.05 l=0.15
X37 a_2638_1638# a_200_252# a_2552_1638# w_0_0# sky130_fd_pr__pfet_01v8 ad=0.147 pd=1.33 as=0.147 ps=1.33 w=1.05 l=0.15
X38 a_3412_462# a_200_252# a_3326_462# w_0_0# sky130_fd_pr__pfet_01v8 ad=0.147 pd=1.33 as=0.147 ps=1.33 w=1.05 l=0.15
X39 a_4444_1638# a_200_252# a_4358_1638# w_0_0# sky130_fd_pr__pfet_01v8 ad=0.147 pd=1.33 as=0.147 ps=1.33 w=1.05 l=0.15
X40 a_4186_1638# a_200_252# a_4100_1638# w_0_0# sky130_fd_pr__pfet_01v8 ad=0.147 pd=1.33 as=0.147 ps=1.33 w=1.05 l=0.15
X41 w_0_0# a_200_252# a_3670_462# w_0_0# sky130_fd_pr__pfet_01v8 ad=0.147 pd=1.33 as=0.147 ps=1.33 w=1.05 l=0.15
X42 w_0_0# a_200_252# a_4702_1638# w_0_0# sky130_fd_pr__pfet_01v8 ad=0.147 pd=1.33 as=0.147 ps=1.33 w=1.05 l=0.15
X43 a_1262_462# a_200_252# w_0_0# w_0_0# sky130_fd_pr__pfet_01v8 ad=0.147 pd=1.33 as=0.147 ps=1.33 w=1.05 l=0.15
X44 a_402_1638# a_200_252# a_2380_1638# w_0_0# sky130_fd_pr__pfet_01v8 ad=0.147 pd=1.33 as=0.147 ps=1.33 w=1.05 l=0.15
X45 w_0_0# a_200_252# a_4186_462# w_0_0# sky130_fd_pr__pfet_01v8 ad=0.147 pd=1.33 as=0.147 ps=1.33 w=1.05 l=0.15
X46 a_402_1638# a_200_252# a_4444_1638# w_0_0# sky130_fd_pr__pfet_01v8 ad=0.147 pd=1.33 as=0.147 ps=1.33 w=1.05 l=0.15
X47 w_0_0# a_200_252# a_2122_1638# w_0_0# sky130_fd_pr__pfet_01v8 ad=0.147 pd=1.33 as=0.147 ps=1.33 w=1.05 l=0.15
X48 w_0_0# a_200_252# a_1606_462# w_0_0# sky130_fd_pr__pfet_01v8 ad=0.147 pd=1.33 as=0.147 ps=1.33 w=1.05 l=0.15
X49 w_0_0# a_200_252# a_4186_1638# w_0_0# sky130_fd_pr__pfet_01v8 ad=0.147 pd=1.33 as=0.147 ps=1.33 w=1.05 l=0.15
X50 a_4702_462# a_200_252# a_4616_462# w_0_0# sky130_fd_pr__pfet_01v8 ad=0.147 pd=1.33 as=0.147 ps=1.33 w=1.05 l=0.15
X51 a_4874_1638# a_200_252# w_0_0# w_0_0# sky130_fd_pr__pfet_01v8 ad=0.147 pd=1.33 as=0.147 ps=1.33 w=1.05 l=0.15
X52 a_4616_1638# a_200_252# a_402_1638# w_0_0# sky130_fd_pr__pfet_01v8 ad=0.147 pd=1.33 as=0.147 ps=1.33 w=1.05 l=0.15
X53 a_2552_1638# a_200_252# a_402_1638# w_0_0# sky130_fd_pr__pfet_01v8 ad=0.147 pd=1.33 as=0.147 ps=1.33 w=1.05 l=0.15
X54 a_5132_462# a_200_252# a_402_1638# w_0_0# sky130_fd_pr__pfet_01v8 ad=0.147 pd=1.33 as=0.147 ps=1.33 w=1.05 l=0.15
X55 w_0_0# a_200_252# a_2122_462# w_0_0# sky130_fd_pr__pfet_01v8 ad=0.147 pd=1.33 as=0.147 ps=1.33 w=1.05 l=0.15
X56 a_2552_462# a_200_252# a_200_252# w_0_0# sky130_fd_pr__pfet_01v8 ad=0.147 pd=1.33 as=0.147 ps=1.33 w=1.05 l=0.15
X57 a_574_462# a_200_252# a_488_462# w_0_0# sky130_fd_pr__pfet_01v8 ad=0.147 pd=1.33 as=0.147 ps=1.33 w=1.05 l=0.15
X58 a_2294_1638# a_200_252# w_0_0# w_0_0# sky130_fd_pr__pfet_01v8 ad=0.147 pd=1.33 as=0.147 ps=1.33 w=1.05 l=0.15
X59 a_5218_462# a_200_252# a_5132_462# w_0_0# sky130_fd_pr__pfet_01v8 ad=0.147 pd=1.33 as=0.147 ps=1.33 w=1.05 l=0.15
X60 a_1004_462# a_200_252# a_402_1638# w_0_0# sky130_fd_pr__pfet_01v8 ad=0.147 pd=1.33 as=0.147 ps=1.33 w=1.05 l=0.15
X61 a_4100_1638# a_200_252# a_200_252# w_0_0# sky130_fd_pr__pfet_01v8 ad=0.147 pd=1.33 as=0.147 ps=1.33 w=1.05 l=0.15
X62 a_2896_1638# a_200_252# a_2810_1638# w_0_0# sky130_fd_pr__pfet_01v8 ad=0.147 pd=1.33 as=0.147 ps=1.33 w=1.05 l=0.15
X63 a_402_1638# a_200_252# a_2896_462# w_0_0# sky130_fd_pr__pfet_01v8 ad=0.147 pd=1.33 as=0.147 ps=1.33 w=1.05 l=0.15
X64 a_4960_1638# a_200_252# a_4874_1638# w_0_0# sky130_fd_pr__pfet_01v8 ad=0.147 pd=1.33 as=0.147 ps=1.33 w=1.05 l=0.15
X65 a_4702_1638# a_200_252# a_4616_1638# w_0_0# sky130_fd_pr__pfet_01v8 ad=0.147 pd=1.33 as=0.147 ps=1.33 w=1.05 l=0.15
X66 a_3068_462# a_200_252# a_402_1638# w_0_0# sky130_fd_pr__pfet_01v8 ad=0.147 pd=1.33 as=0.147 ps=1.33 w=1.05 l=0.15
X67 a_2380_1638# a_200_252# a_2294_1638# w_0_0# sky130_fd_pr__pfet_01v8 ad=0.147 pd=1.33 as=0.147 ps=1.33 w=1.05 l=0.15
X68 a_2122_1638# a_200_252# a_2036_1638# w_0_0# sky130_fd_pr__pfet_01v8 ad=0.147 pd=1.33 as=0.147 ps=1.33 w=1.05 l=0.15
X69 a_200_252# a_200_252# a_3412_462# w_0_0# sky130_fd_pr__pfet_01v8 ad=0.147 pd=1.33 as=0.147 ps=1.33 w=1.05 l=0.15
X70 a_200_252# a_200_252# a_2896_1638# w_0_0# sky130_fd_pr__pfet_01v8 ad=0.147 pd=1.33 as=0.147 ps=1.33 w=1.05 l=0.15
X71 a_3842_462# a_200_252# w_0_0# w_0_0# sky130_fd_pr__pfet_01v8 ad=0.147 pd=1.33 as=0.147 ps=1.33 w=1.05 l=0.15
X72 w_0_0# a_200_252# a_2638_1638# w_0_0# sky130_fd_pr__pfet_01v8 ad=0.147 pd=1.33 as=0.147 ps=1.33 w=1.05 l=0.15
X73 a_3928_462# a_200_252# a_3842_462# w_0_0# sky130_fd_pr__pfet_01v8 ad=0.147 pd=1.33 as=0.147 ps=1.33 w=1.05 l=0.15
X74 a_1348_462# a_200_252# a_1262_462# w_0_0# sky130_fd_pr__pfet_01v8 ad=0.147 pd=1.33 as=0.147 ps=1.33 w=1.05 l=0.15
X75 a_4358_462# a_200_252# w_0_0# w_0_0# sky130_fd_pr__pfet_01v8 ad=0.147 pd=1.33 as=0.147 ps=1.33 w=1.05 l=0.15
X76 a_200_252# a_200_252# a_4960_1638# w_0_0# sky130_fd_pr__pfet_01v8 ad=0.147 pd=1.33 as=0.147 ps=1.33 w=1.05 l=0.15
X77 a_1778_462# a_200_252# w_0_0# w_0_0# sky130_fd_pr__pfet_01v8 ad=0.147 pd=1.33 as=0.147 ps=1.33 w=1.05 l=0.15
X78 a_230_462# a_200_252# w_0_0# w_0_0# sky130_fd_pr__pfet_01v8 ad=0.147 pd=1.33 as=0.27825 ps=2.63 w=1.05 l=0.15
X79 a_2810_1638# a_200_252# w_0_0# w_0_0# sky130_fd_pr__pfet_01v8 ad=0.147 pd=1.33 as=0.147 ps=1.33 w=1.05 l=0.15
X80 w_0_0# a_200_252# a_4702_462# w_0_0# sky130_fd_pr__pfet_01v8 ad=0.147 pd=1.33 as=0.147 ps=1.33 w=1.05 l=0.15
X81 a_316_462# a_200_252# a_230_462# w_0_0# sky130_fd_pr__pfet_01v8 ad=0.147 pd=1.33 as=0.147 ps=1.33 w=1.05 l=0.15
X82 a_2294_462# a_200_252# w_0_0# w_0_0# sky130_fd_pr__pfet_01v8 ad=0.147 pd=1.33 as=0.147 ps=1.33 w=1.05 l=0.15
X83 w_0_0# a_200_252# a_574_462# w_0_0# sky130_fd_pr__pfet_01v8 ad=0.147 pd=1.33 as=0.147 ps=1.33 w=1.05 l=0.15
X84 w_0_0# a_200_252# a_5218_462# w_0_0# sky130_fd_pr__pfet_01v8 ad=0.27825 pd=2.63 as=0.147 ps=1.33 w=1.05 l=0.15
X85 w_0_0# a_200_252# a_2638_462# w_0_0# sky130_fd_pr__pfet_01v8 ad=0.147 pd=1.33 as=0.147 ps=1.33 w=1.05 l=0.15
X86 a_5132_1638# a_200_252# a_200_252# w_0_0# sky130_fd_pr__pfet_01v8 ad=0.147 pd=1.33 as=0.147 ps=1.33 w=1.05 l=0.15
X87 a_3068_1638# a_200_252# a_200_252# w_0_0# sky130_fd_pr__pfet_01v8 ad=0.147 pd=1.33 as=0.147 ps=1.33 w=1.05 l=0.15
X88 a_2638_462# a_200_252# a_2552_462# w_0_0# sky130_fd_pr__pfet_01v8 ad=0.147 pd=1.33 as=0.147 ps=1.33 w=1.05 l=0.15
X89 a_3154_462# a_200_252# a_3068_462# w_0_0# sky130_fd_pr__pfet_01v8 ad=0.147 pd=1.33 as=0.147 ps=1.33 w=1.05 l=0.15
X90 a_746_1638# a_200_252# w_0_0# w_0_0# sky130_fd_pr__pfet_01v8 ad=0.147 pd=1.33 as=0.147 ps=1.33 w=1.05 l=0.15
X91 a_1348_1638# a_200_252# a_1262_1638# w_0_0# sky130_fd_pr__pfet_01v8 ad=0.147 pd=1.33 as=0.147 ps=1.33 w=1.05 l=0.15
X92 a_488_1638# a_200_252# a_402_1638# w_0_0# sky130_fd_pr__pfet_01v8 ad=0.147 pd=1.33 as=0.147 ps=1.33 w=1.05 l=0.15
X93 a_3584_462# a_200_252# a_200_252# w_0_0# sky130_fd_pr__pfet_01v8 ad=0.147 pd=1.33 as=0.147 ps=1.33 w=1.05 l=0.15
X94 a_5218_1638# a_200_252# a_5132_1638# w_0_0# sky130_fd_pr__pfet_01v8 ad=0.147 pd=1.33 as=0.147 ps=1.33 w=1.05 l=0.15
X95 a_3154_1638# a_200_252# a_3068_1638# w_0_0# sky130_fd_pr__pfet_01v8 ad=0.147 pd=1.33 as=0.147 ps=1.33 w=1.05 l=0.15
X96 a_1090_462# a_200_252# a_1004_462# w_0_0# sky130_fd_pr__pfet_01v8 ad=0.147 pd=1.33 as=0.147 ps=1.33 w=1.05 l=0.15
X97 a_230_1638# a_200_252# w_0_0# w_0_0# sky130_fd_pr__pfet_01v8 ad=0.147 pd=1.33 as=0.27825 ps=2.63 w=1.05 l=0.15
X98 a_4100_462# a_200_252# a_402_1638# w_0_0# sky130_fd_pr__pfet_01v8 ad=0.147 pd=1.33 as=0.147 ps=1.33 w=1.05 l=0.15
X99 a_402_1638# a_200_252# a_3928_462# w_0_0# sky130_fd_pr__pfet_01v8 ad=0.147 pd=1.33 as=0.147 ps=1.33 w=1.05 l=0.15
X100 w_0_0# a_200_252# a_3670_1638# w_0_0# sky130_fd_pr__pfet_01v8 ad=0.147 pd=1.33 as=0.147 ps=1.33 w=1.05 l=0.15
X101 a_832_1638# a_200_252# a_746_1638# w_0_0# sky130_fd_pr__pfet_01v8 ad=0.147 pd=1.33 as=0.147 ps=1.33 w=1.05 l=0.15
X102 a_402_1638# a_200_252# a_1348_1638# w_0_0# sky130_fd_pr__pfet_01v8 ad=0.147 pd=1.33 as=0.147 ps=1.33 w=1.05 l=0.15
X103 a_1520_462# a_200_252# a_200_252# w_0_0# sky130_fd_pr__pfet_01v8 ad=0.147 pd=1.33 as=0.147 ps=1.33 w=1.05 l=0.15
X104 a_402_1638# a_200_252# a_3412_1638# w_0_0# sky130_fd_pr__pfet_01v8 ad=0.147 pd=1.33 as=0.147 ps=1.33 w=1.05 l=0.15
X105 a_574_1638# a_200_252# a_488_1638# w_0_0# sky130_fd_pr__pfet_01v8 ad=0.147 pd=1.33 as=0.147 ps=1.33 w=1.05 l=0.15
X106 a_200_252# a_200_252# a_1348_462# w_0_0# sky130_fd_pr__pfet_01v8 ad=0.147 pd=1.33 as=0.147 ps=1.33 w=1.05 l=0.15
X107 w_0_0# a_200_252# a_1090_1638# w_0_0# sky130_fd_pr__pfet_01v8 ad=0.147 pd=1.33 as=0.147 ps=1.33 w=1.05 l=0.15
X108 a_4444_462# a_200_252# a_4358_462# w_0_0# sky130_fd_pr__pfet_01v8 ad=0.147 pd=1.33 as=0.147 ps=1.33 w=1.05 l=0.15
X109 w_0_0# a_200_252# a_5218_1638# w_0_0# sky130_fd_pr__pfet_01v8 ad=0.27825 pd=2.63 as=0.147 ps=1.33 w=1.05 l=0.15
X110 w_0_0# a_200_252# a_3154_1638# w_0_0# sky130_fd_pr__pfet_01v8 ad=0.147 pd=1.33 as=0.147 ps=1.33 w=1.05 l=0.15
X111 a_316_1638# a_200_252# a_230_1638# w_0_0# sky130_fd_pr__pfet_01v8 ad=0.147 pd=1.33 as=0.147 ps=1.33 w=1.05 l=0.15
X112 a_1778_1638# a_200_252# w_0_0# w_0_0# sky130_fd_pr__pfet_01v8 ad=0.147 pd=1.33 as=0.147 ps=1.33 w=1.05 l=0.15
X113 a_1864_462# a_200_252# a_1778_462# w_0_0# sky130_fd_pr__pfet_01v8 ad=0.147 pd=1.33 as=0.147 ps=1.33 w=1.05 l=0.15
X114 a_3842_1638# a_200_252# w_0_0# w_0_0# sky130_fd_pr__pfet_01v8 ad=0.147 pd=1.33 as=0.147 ps=1.33 w=1.05 l=0.15
X115 a_200_252# a_200_252# a_832_1638# w_0_0# sky130_fd_pr__pfet_01v8 ad=0.147 pd=1.33 as=0.147 ps=1.33 w=1.05 l=0.15
X116 a_4874_462# a_200_252# w_0_0# w_0_0# sky130_fd_pr__pfet_01v8 ad=0.147 pd=1.33 as=0.147 ps=1.33 w=1.05 l=0.15
X117 a_200_252# a_200_252# a_316_462# w_0_0# sky130_fd_pr__pfet_01v8 ad=0.147 pd=1.33 as=0.147 ps=1.33 w=1.05 l=0.15
X118 a_2380_462# a_200_252# a_2294_462# w_0_0# sky130_fd_pr__pfet_01v8 ad=0.147 pd=1.33 as=0.147 ps=1.33 w=1.05 l=0.15
X119 a_3584_1638# a_200_252# a_402_1638# w_0_0# sky130_fd_pr__pfet_01v8 ad=0.147 pd=1.33 as=0.147 ps=1.33 w=1.05 l=0.15
.ends

.subckt FIVE_TRANSISTOR_OTA_0 ID VOUT VINP VINN VSS VDD
XDP_NMOS_B_8176578_X5_Y2_1792774757_0 VSS VINP VINN m2_2552_4116# m1_2892_1316# VOUT
+ DP_NMOS_B_8176578_X5_Y2_1792774757
XSCM_NMOS_20351251_X5_Y1_1792774758_0 ID m1_2892_1316# VSS SCM_NMOS_20351251_X5_Y1_1792774758
XSCM_PMOS_60929072_X5_Y2_1792774759_0 m2_2552_4116# VDD VOUT SCM_PMOS_60929072_X5_Y2_1792774759
.ends
