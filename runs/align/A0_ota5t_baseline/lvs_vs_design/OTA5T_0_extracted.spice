* NGSPICE file created from OTA5T_0.ext - technology: sky130A

.subckt SCM_PMOS_42512307_X2_Y1_1792775075 a_200_252# a_402_357# w_0_0#
X0 a_200_252# a_200_252# w_0_0# w_0_0# sky130_fd_pr__pfet_01v8 ad=0.294 pd=2.38 as=0.5565 ps=4.73 w=2.1 l=0.15
X1 w_0_0# a_200_252# a_200_252# w_0_0# sky130_fd_pr__pfet_01v8 ad=0.294 pd=2.38 as=0.294 ps=2.38 w=2.1 l=0.15
X2 w_0_0# a_200_252# a_402_357# w_0_0# sky130_fd_pr__pfet_01v8 ad=0.294 pd=2.38 as=0.294 ps=2.38 w=2.1 l=0.15
X3 a_402_357# a_200_252# w_0_0# w_0_0# sky130_fd_pr__pfet_01v8 ad=0.294 pd=2.38 as=0.294 ps=2.38 w=2.1 l=0.15
X4 a_200_252# a_200_252# w_0_0# w_0_0# sky130_fd_pr__pfet_01v8 ad=0.294 pd=2.38 as=0.294 ps=2.38 w=2.1 l=0.15
X5 w_0_0# a_200_252# a_402_357# w_0_0# sky130_fd_pr__pfet_01v8 ad=0.294 pd=2.38 as=0.294 ps=2.38 w=2.1 l=0.15
X6 w_0_0# a_200_252# a_200_252# w_0_0# sky130_fd_pr__pfet_01v8 ad=0.5565 pd=4.73 as=0.294 ps=2.38 w=2.1 l=0.15
X7 a_402_357# a_200_252# w_0_0# w_0_0# sky130_fd_pr__pfet_01v8 ad=0.294 pd=2.38 as=0.294 ps=2.38 w=2.1 l=0.15
.ends

.subckt DP_NMOS_B_42587218_X19_Y1_1792775073 a_372_252# a_147_504# a_200_252# a_230_504#
+ a_241_1232# a_402_504#
X0 a_402_504# a_372_252# a_147_504# a_241_1232# sky130_fd_pr__nfet_01v8 ad=0.0882 pd=0.91 as=0.0882 ps=0.91 w=0.63 l=0.15
X1 a_230_504# a_200_252# a_147_504# a_241_1232# sky130_fd_pr__nfet_01v8 ad=0.0882 pd=0.91 as=0.0882 ps=0.91 w=0.63 l=0.15
X2 a_402_504# a_372_252# a_147_504# a_241_1232# sky130_fd_pr__nfet_01v8 ad=0.0882 pd=0.91 as=0.0882 ps=0.91 w=0.63 l=0.15
X3 a_147_504# a_372_252# a_402_504# a_241_1232# sky130_fd_pr__nfet_01v8 ad=0.0882 pd=0.91 as=0.0882 ps=0.91 w=0.63 l=0.15
X4 a_147_504# a_200_252# a_230_504# a_241_1232# sky130_fd_pr__nfet_01v8 ad=0.0882 pd=0.91 as=0.0882 ps=0.91 w=0.63 l=0.15
X5 a_147_504# a_200_252# a_230_504# a_241_1232# sky130_fd_pr__nfet_01v8 ad=0.0882 pd=0.91 as=0.0882 ps=0.91 w=0.63 l=0.15
X6 a_230_504# a_200_252# a_147_504# a_241_1232# sky130_fd_pr__nfet_01v8 ad=0.0882 pd=0.91 as=0.16695 ps=1.79 w=0.63 l=0.15
X7 a_402_504# a_372_252# a_147_504# a_241_1232# sky130_fd_pr__nfet_01v8 ad=0.0882 pd=0.91 as=0.0882 ps=0.91 w=0.63 l=0.15
X8 a_230_504# a_200_252# a_147_504# a_241_1232# sky130_fd_pr__nfet_01v8 ad=0.0882 pd=0.91 as=0.0882 ps=0.91 w=0.63 l=0.15
X9 a_147_504# a_200_252# a_230_504# a_241_1232# sky130_fd_pr__nfet_01v8 ad=0.0882 pd=0.91 as=0.0882 ps=0.91 w=0.63 l=0.15
X10 a_230_504# a_200_252# a_147_504# a_241_1232# sky130_fd_pr__nfet_01v8 ad=0.0882 pd=0.91 as=0.0882 ps=0.91 w=0.63 l=0.15
X11 a_147_504# a_200_252# a_230_504# a_241_1232# sky130_fd_pr__nfet_01v8 ad=0.0882 pd=0.91 as=0.0882 ps=0.91 w=0.63 l=0.15
X12 a_147_504# a_200_252# a_230_504# a_241_1232# sky130_fd_pr__nfet_01v8 ad=0.0882 pd=0.91 as=0.0882 ps=0.91 w=0.63 l=0.15
X13 a_147_504# a_372_252# a_402_504# a_241_1232# sky130_fd_pr__nfet_01v8 ad=0.0882 pd=0.91 as=0.0882 ps=0.91 w=0.63 l=0.15
X14 a_230_504# a_200_252# a_147_504# a_241_1232# sky130_fd_pr__nfet_01v8 ad=0.0882 pd=0.91 as=0.0882 ps=0.91 w=0.63 l=0.15
X15 a_147_504# a_200_252# a_230_504# a_241_1232# sky130_fd_pr__nfet_01v8 ad=0.0882 pd=0.91 as=0.0882 ps=0.91 w=0.63 l=0.15
X16 a_402_504# a_372_252# a_147_504# a_241_1232# sky130_fd_pr__nfet_01v8 ad=0.0882 pd=0.91 as=0.0882 ps=0.91 w=0.63 l=0.15
X17 a_147_504# a_372_252# a_402_504# a_241_1232# sky130_fd_pr__nfet_01v8 ad=0.0882 pd=0.91 as=0.0882 ps=0.91 w=0.63 l=0.15
X18 a_147_504# a_200_252# a_230_504# a_241_1232# sky130_fd_pr__nfet_01v8 ad=0.0882 pd=0.91 as=0.0882 ps=0.91 w=0.63 l=0.15
X19 a_402_504# a_372_252# a_147_504# a_241_1232# sky130_fd_pr__nfet_01v8 ad=0.0882 pd=0.91 as=0.0882 ps=0.91 w=0.63 l=0.15
X20 a_147_504# a_372_252# a_402_504# a_241_1232# sky130_fd_pr__nfet_01v8 ad=0.0882 pd=0.91 as=0.0882 ps=0.91 w=0.63 l=0.15
X21 a_230_504# a_200_252# a_147_504# a_241_1232# sky130_fd_pr__nfet_01v8 ad=0.0882 pd=0.91 as=0.0882 ps=0.91 w=0.63 l=0.15
X22 a_147_504# a_200_252# a_230_504# a_241_1232# sky130_fd_pr__nfet_01v8 ad=0.0882 pd=0.91 as=0.0882 ps=0.91 w=0.63 l=0.15
X23 a_402_504# a_372_252# a_147_504# a_241_1232# sky130_fd_pr__nfet_01v8 ad=0.0882 pd=0.91 as=0.0882 ps=0.91 w=0.63 l=0.15
X24 a_402_504# a_372_252# a_147_504# a_241_1232# sky130_fd_pr__nfet_01v8 ad=0.0882 pd=0.91 as=0.0882 ps=0.91 w=0.63 l=0.15
X25 a_147_504# a_372_252# a_402_504# a_241_1232# sky130_fd_pr__nfet_01v8 ad=0.0882 pd=0.91 as=0.0882 ps=0.91 w=0.63 l=0.15
X26 a_147_504# a_372_252# a_402_504# a_241_1232# sky130_fd_pr__nfet_01v8 ad=0.0882 pd=0.91 as=0.0882 ps=0.91 w=0.63 l=0.15
X27 a_147_504# a_200_252# a_230_504# a_241_1232# sky130_fd_pr__nfet_01v8 ad=0.0882 pd=0.91 as=0.0882 ps=0.91 w=0.63 l=0.15
X28 a_402_504# a_372_252# a_147_504# a_241_1232# sky130_fd_pr__nfet_01v8 ad=0.0882 pd=0.91 as=0.0882 ps=0.91 w=0.63 l=0.15
X29 a_147_504# a_200_252# a_230_504# a_241_1232# sky130_fd_pr__nfet_01v8 ad=0.0882 pd=0.91 as=0.0882 ps=0.91 w=0.63 l=0.15
X30 a_402_504# a_372_252# a_147_504# a_241_1232# sky130_fd_pr__nfet_01v8 ad=0.0882 pd=0.91 as=0.0882 ps=0.91 w=0.63 l=0.15
X31 a_402_504# a_372_252# a_147_504# a_241_1232# sky130_fd_pr__nfet_01v8 ad=0.0882 pd=0.91 as=0.0882 ps=0.91 w=0.63 l=0.15
X32 a_230_504# a_200_252# a_147_504# a_241_1232# sky130_fd_pr__nfet_01v8 ad=0.0882 pd=0.91 as=0.0882 ps=0.91 w=0.63 l=0.15
X33 a_402_504# a_372_252# a_147_504# a_241_1232# sky130_fd_pr__nfet_01v8 ad=0.0882 pd=0.91 as=0.0882 ps=0.91 w=0.63 l=0.15
X34 a_230_504# a_200_252# a_147_504# a_241_1232# sky130_fd_pr__nfet_01v8 ad=0.0882 pd=0.91 as=0.0882 ps=0.91 w=0.63 l=0.15
X35 a_147_504# a_200_252# a_230_504# a_241_1232# sky130_fd_pr__nfet_01v8 ad=0.0882 pd=0.91 as=0.0882 ps=0.91 w=0.63 l=0.15
X36 a_147_504# a_372_252# a_402_504# a_241_1232# sky130_fd_pr__nfet_01v8 ad=0.0882 pd=0.91 as=0.0882 ps=0.91 w=0.63 l=0.15
X37 a_230_504# a_200_252# a_147_504# a_241_1232# sky130_fd_pr__nfet_01v8 ad=0.0882 pd=0.91 as=0.0882 ps=0.91 w=0.63 l=0.15
X38 a_402_504# a_372_252# a_147_504# a_241_1232# sky130_fd_pr__nfet_01v8 ad=0.0882 pd=0.91 as=0.0882 ps=0.91 w=0.63 l=0.15
X39 a_230_504# a_200_252# a_147_504# a_241_1232# sky130_fd_pr__nfet_01v8 ad=0.0882 pd=0.91 as=0.0882 ps=0.91 w=0.63 l=0.15
X40 a_147_504# a_372_252# a_402_504# a_241_1232# sky130_fd_pr__nfet_01v8 ad=0.16695 pd=1.79 as=0.0882 ps=0.91 w=0.63 l=0.15
X41 a_147_504# a_372_252# a_402_504# a_241_1232# sky130_fd_pr__nfet_01v8 ad=0.0882 pd=0.91 as=0.0882 ps=0.91 w=0.63 l=0.15
X42 a_402_504# a_372_252# a_147_504# a_241_1232# sky130_fd_pr__nfet_01v8 ad=0.0882 pd=0.91 as=0.0882 ps=0.91 w=0.63 l=0.15
X43 a_402_504# a_372_252# a_147_504# a_241_1232# sky130_fd_pr__nfet_01v8 ad=0.0882 pd=0.91 as=0.0882 ps=0.91 w=0.63 l=0.15
X44 a_230_504# a_200_252# a_147_504# a_241_1232# sky130_fd_pr__nfet_01v8 ad=0.0882 pd=0.91 as=0.0882 ps=0.91 w=0.63 l=0.15
X45 a_230_504# a_200_252# a_147_504# a_241_1232# sky130_fd_pr__nfet_01v8 ad=0.0882 pd=0.91 as=0.0882 ps=0.91 w=0.63 l=0.15
X46 a_147_504# a_372_252# a_402_504# a_241_1232# sky130_fd_pr__nfet_01v8 ad=0.0882 pd=0.91 as=0.0882 ps=0.91 w=0.63 l=0.15
X47 a_147_504# a_200_252# a_230_504# a_241_1232# sky130_fd_pr__nfet_01v8 ad=0.0882 pd=0.91 as=0.0882 ps=0.91 w=0.63 l=0.15
X48 a_402_504# a_372_252# a_147_504# a_241_1232# sky130_fd_pr__nfet_01v8 ad=0.0882 pd=0.91 as=0.0882 ps=0.91 w=0.63 l=0.15
X49 a_147_504# a_372_252# a_402_504# a_241_1232# sky130_fd_pr__nfet_01v8 ad=0.0882 pd=0.91 as=0.0882 ps=0.91 w=0.63 l=0.15
X50 a_147_504# a_372_252# a_402_504# a_241_1232# sky130_fd_pr__nfet_01v8 ad=0.0882 pd=0.91 as=0.0882 ps=0.91 w=0.63 l=0.15
X51 a_147_504# a_372_252# a_402_504# a_241_1232# sky130_fd_pr__nfet_01v8 ad=0.0882 pd=0.91 as=0.0882 ps=0.91 w=0.63 l=0.15
X52 a_402_504# a_372_252# a_147_504# a_241_1232# sky130_fd_pr__nfet_01v8 ad=0.0882 pd=0.91 as=0.0882 ps=0.91 w=0.63 l=0.15
X53 a_230_504# a_200_252# a_147_504# a_241_1232# sky130_fd_pr__nfet_01v8 ad=0.0882 pd=0.91 as=0.0882 ps=0.91 w=0.63 l=0.15
X54 a_230_504# a_200_252# a_147_504# a_241_1232# sky130_fd_pr__nfet_01v8 ad=0.0882 pd=0.91 as=0.0882 ps=0.91 w=0.63 l=0.15
X55 a_147_504# a_372_252# a_402_504# a_241_1232# sky130_fd_pr__nfet_01v8 ad=0.0882 pd=0.91 as=0.0882 ps=0.91 w=0.63 l=0.15
X56 a_147_504# a_200_252# a_230_504# a_241_1232# sky130_fd_pr__nfet_01v8 ad=0.0882 pd=0.91 as=0.0882 ps=0.91 w=0.63 l=0.15
X57 a_147_504# a_200_252# a_230_504# a_241_1232# sky130_fd_pr__nfet_01v8 ad=0.0882 pd=0.91 as=0.0882 ps=0.91 w=0.63 l=0.15
X58 a_402_504# a_372_252# a_147_504# a_241_1232# sky130_fd_pr__nfet_01v8 ad=0.0882 pd=0.91 as=0.0882 ps=0.91 w=0.63 l=0.15
X59 a_147_504# a_372_252# a_402_504# a_241_1232# sky130_fd_pr__nfet_01v8 ad=0.0882 pd=0.91 as=0.0882 ps=0.91 w=0.63 l=0.15
X60 a_230_504# a_200_252# a_147_504# a_241_1232# sky130_fd_pr__nfet_01v8 ad=0.0882 pd=0.91 as=0.0882 ps=0.91 w=0.63 l=0.15
X61 a_230_504# a_200_252# a_147_504# a_241_1232# sky130_fd_pr__nfet_01v8 ad=0.0882 pd=0.91 as=0.0882 ps=0.91 w=0.63 l=0.15
X62 a_147_504# a_200_252# a_230_504# a_241_1232# sky130_fd_pr__nfet_01v8 ad=0.0882 pd=0.91 as=0.0882 ps=0.91 w=0.63 l=0.15
X63 a_147_504# a_200_252# a_230_504# a_241_1232# sky130_fd_pr__nfet_01v8 ad=0.0882 pd=0.91 as=0.0882 ps=0.91 w=0.63 l=0.15
X64 a_147_504# a_372_252# a_402_504# a_241_1232# sky130_fd_pr__nfet_01v8 ad=0.0882 pd=0.91 as=0.0882 ps=0.91 w=0.63 l=0.15
X65 a_230_504# a_200_252# a_147_504# a_241_1232# sky130_fd_pr__nfet_01v8 ad=0.0882 pd=0.91 as=0.0882 ps=0.91 w=0.63 l=0.15
X66 a_147_504# a_200_252# a_230_504# a_241_1232# sky130_fd_pr__nfet_01v8 ad=0.0882 pd=0.91 as=0.0882 ps=0.91 w=0.63 l=0.15
X67 a_230_504# a_200_252# a_147_504# a_241_1232# sky130_fd_pr__nfet_01v8 ad=0.0882 pd=0.91 as=0.0882 ps=0.91 w=0.63 l=0.15
X68 a_147_504# a_372_252# a_402_504# a_241_1232# sky130_fd_pr__nfet_01v8 ad=0.0882 pd=0.91 as=0.0882 ps=0.91 w=0.63 l=0.15
X69 a_147_504# a_372_252# a_402_504# a_241_1232# sky130_fd_pr__nfet_01v8 ad=0.0882 pd=0.91 as=0.0882 ps=0.91 w=0.63 l=0.15
X70 a_402_504# a_372_252# a_147_504# a_241_1232# sky130_fd_pr__nfet_01v8 ad=0.0882 pd=0.91 as=0.0882 ps=0.91 w=0.63 l=0.15
X71 a_402_504# a_372_252# a_147_504# a_241_1232# sky130_fd_pr__nfet_01v8 ad=0.0882 pd=0.91 as=0.0882 ps=0.91 w=0.63 l=0.15
X72 a_147_504# a_200_252# a_230_504# a_241_1232# sky130_fd_pr__nfet_01v8 ad=0.0882 pd=0.91 as=0.0882 ps=0.91 w=0.63 l=0.15
X73 a_230_504# a_200_252# a_147_504# a_241_1232# sky130_fd_pr__nfet_01v8 ad=0.0882 pd=0.91 as=0.0882 ps=0.91 w=0.63 l=0.15
X74 a_147_504# a_200_252# a_230_504# a_241_1232# sky130_fd_pr__nfet_01v8 ad=0.0882 pd=0.91 as=0.0882 ps=0.91 w=0.63 l=0.15
X75 a_147_504# a_372_252# a_402_504# a_241_1232# sky130_fd_pr__nfet_01v8 ad=0.0882 pd=0.91 as=0.0882 ps=0.91 w=0.63 l=0.15
.ends

.subckt NMOS_S_83430483_X19_Y1_1792775074 a_147_504# a_200_252# a_230_504#
X0 a_147_504# a_200_252# a_230_504# a_147_504# sky130_fd_pr__nfet_01v8 ad=0.0882 pd=0.91 as=0.0882 ps=0.91 w=0.63 l=0.15
X1 a_230_504# a_200_252# a_147_504# a_147_504# sky130_fd_pr__nfet_01v8 ad=0.0882 pd=0.91 as=0.16695 ps=1.79 w=0.63 l=0.15
X2 a_230_504# a_200_252# a_147_504# a_147_504# sky130_fd_pr__nfet_01v8 ad=0.0882 pd=0.91 as=0.0882 ps=0.91 w=0.63 l=0.15
X3 a_147_504# a_200_252# a_230_504# a_147_504# sky130_fd_pr__nfet_01v8 ad=0.0882 pd=0.91 as=0.0882 ps=0.91 w=0.63 l=0.15
X4 a_230_504# a_200_252# a_147_504# a_147_504# sky130_fd_pr__nfet_01v8 ad=0.0882 pd=0.91 as=0.0882 ps=0.91 w=0.63 l=0.15
X5 a_147_504# a_200_252# a_230_504# a_147_504# sky130_fd_pr__nfet_01v8 ad=0.0882 pd=0.91 as=0.0882 ps=0.91 w=0.63 l=0.15
X6 a_230_504# a_200_252# a_147_504# a_147_504# sky130_fd_pr__nfet_01v8 ad=0.0882 pd=0.91 as=0.0882 ps=0.91 w=0.63 l=0.15
X7 a_147_504# a_200_252# a_230_504# a_147_504# sky130_fd_pr__nfet_01v8 ad=0.0882 pd=0.91 as=0.0882 ps=0.91 w=0.63 l=0.15
X8 a_230_504# a_200_252# a_147_504# a_147_504# sky130_fd_pr__nfet_01v8 ad=0.0882 pd=0.91 as=0.0882 ps=0.91 w=0.63 l=0.15
X9 a_230_504# a_200_252# a_147_504# a_147_504# sky130_fd_pr__nfet_01v8 ad=0.0882 pd=0.91 as=0.0882 ps=0.91 w=0.63 l=0.15
X10 a_230_504# a_200_252# a_147_504# a_147_504# sky130_fd_pr__nfet_01v8 ad=0.0882 pd=0.91 as=0.0882 ps=0.91 w=0.63 l=0.15
X11 a_147_504# a_200_252# a_230_504# a_147_504# sky130_fd_pr__nfet_01v8 ad=0.0882 pd=0.91 as=0.0882 ps=0.91 w=0.63 l=0.15
X12 a_147_504# a_200_252# a_230_504# a_147_504# sky130_fd_pr__nfet_01v8 ad=0.0882 pd=0.91 as=0.0882 ps=0.91 w=0.63 l=0.15
X13 a_230_504# a_200_252# a_147_504# a_147_504# sky130_fd_pr__nfet_01v8 ad=0.0882 pd=0.91 as=0.0882 ps=0.91 w=0.63 l=0.15
X14 a_147_504# a_200_252# a_230_504# a_147_504# sky130_fd_pr__nfet_01v8 ad=0.0882 pd=0.91 as=0.0882 ps=0.91 w=0.63 l=0.15
X15 a_230_504# a_200_252# a_147_504# a_147_504# sky130_fd_pr__nfet_01v8 ad=0.0882 pd=0.91 as=0.0882 ps=0.91 w=0.63 l=0.15
X16 a_230_504# a_200_252# a_147_504# a_147_504# sky130_fd_pr__nfet_01v8 ad=0.0882 pd=0.91 as=0.0882 ps=0.91 w=0.63 l=0.15
X17 a_147_504# a_200_252# a_230_504# a_147_504# sky130_fd_pr__nfet_01v8 ad=0.0882 pd=0.91 as=0.0882 ps=0.91 w=0.63 l=0.15
X18 a_230_504# a_200_252# a_147_504# a_147_504# sky130_fd_pr__nfet_01v8 ad=0.0882 pd=0.91 as=0.0882 ps=0.91 w=0.63 l=0.15
X19 a_147_504# a_200_252# a_230_504# a_147_504# sky130_fd_pr__nfet_01v8 ad=0.0882 pd=0.91 as=0.0882 ps=0.91 w=0.63 l=0.15
X20 a_230_504# a_200_252# a_147_504# a_147_504# sky130_fd_pr__nfet_01v8 ad=0.0882 pd=0.91 as=0.0882 ps=0.91 w=0.63 l=0.15
X21 a_230_504# a_200_252# a_147_504# a_147_504# sky130_fd_pr__nfet_01v8 ad=0.0882 pd=0.91 as=0.0882 ps=0.91 w=0.63 l=0.15
X22 a_147_504# a_200_252# a_230_504# a_147_504# sky130_fd_pr__nfet_01v8 ad=0.0882 pd=0.91 as=0.0882 ps=0.91 w=0.63 l=0.15
X23 a_230_504# a_200_252# a_147_504# a_147_504# sky130_fd_pr__nfet_01v8 ad=0.0882 pd=0.91 as=0.0882 ps=0.91 w=0.63 l=0.15
X24 a_147_504# a_200_252# a_230_504# a_147_504# sky130_fd_pr__nfet_01v8 ad=0.0882 pd=0.91 as=0.0882 ps=0.91 w=0.63 l=0.15
X25 a_147_504# a_200_252# a_230_504# a_147_504# sky130_fd_pr__nfet_01v8 ad=0.0882 pd=0.91 as=0.0882 ps=0.91 w=0.63 l=0.15
X26 a_230_504# a_200_252# a_147_504# a_147_504# sky130_fd_pr__nfet_01v8 ad=0.0882 pd=0.91 as=0.0882 ps=0.91 w=0.63 l=0.15
X27 a_230_504# a_200_252# a_147_504# a_147_504# sky130_fd_pr__nfet_01v8 ad=0.0882 pd=0.91 as=0.0882 ps=0.91 w=0.63 l=0.15
X28 a_147_504# a_200_252# a_230_504# a_147_504# sky130_fd_pr__nfet_01v8 ad=0.0882 pd=0.91 as=0.0882 ps=0.91 w=0.63 l=0.15
X29 a_147_504# a_200_252# a_230_504# a_147_504# sky130_fd_pr__nfet_01v8 ad=0.16695 pd=1.79 as=0.0882 ps=0.91 w=0.63 l=0.15
X30 a_230_504# a_200_252# a_147_504# a_147_504# sky130_fd_pr__nfet_01v8 ad=0.0882 pd=0.91 as=0.0882 ps=0.91 w=0.63 l=0.15
X31 a_147_504# a_200_252# a_230_504# a_147_504# sky130_fd_pr__nfet_01v8 ad=0.0882 pd=0.91 as=0.0882 ps=0.91 w=0.63 l=0.15
X32 a_230_504# a_200_252# a_147_504# a_147_504# sky130_fd_pr__nfet_01v8 ad=0.0882 pd=0.91 as=0.0882 ps=0.91 w=0.63 l=0.15
X33 a_147_504# a_200_252# a_230_504# a_147_504# sky130_fd_pr__nfet_01v8 ad=0.0882 pd=0.91 as=0.0882 ps=0.91 w=0.63 l=0.15
X34 a_147_504# a_200_252# a_230_504# a_147_504# sky130_fd_pr__nfet_01v8 ad=0.0882 pd=0.91 as=0.0882 ps=0.91 w=0.63 l=0.15
X35 a_147_504# a_200_252# a_230_504# a_147_504# sky130_fd_pr__nfet_01v8 ad=0.0882 pd=0.91 as=0.0882 ps=0.91 w=0.63 l=0.15
X36 a_230_504# a_200_252# a_147_504# a_147_504# sky130_fd_pr__nfet_01v8 ad=0.0882 pd=0.91 as=0.0882 ps=0.91 w=0.63 l=0.15
X37 a_147_504# a_200_252# a_230_504# a_147_504# sky130_fd_pr__nfet_01v8 ad=0.0882 pd=0.91 as=0.0882 ps=0.91 w=0.63 l=0.15
.ends

.subckt OTA5T_0 OUTP INP INN VBIAS VSS VDD
XSCM_PMOS_42512307_X2_Y1_1792775075_0 m1_4010_1400# OUTP VDD SCM_PMOS_42512307_X2_Y1_1792775075
XDP_NMOS_B_42587218_X19_Y1_1792775073_0 INN m1_2892_1232# INP m1_4010_1400# VSS OUTP
+ DP_NMOS_B_42587218_X19_Y1_1792775073
XNMOS_S_83430483_X19_Y1_1792775074_0 VSS VBIAS m1_2892_1232# NMOS_S_83430483_X19_Y1_1792775074
.ends
