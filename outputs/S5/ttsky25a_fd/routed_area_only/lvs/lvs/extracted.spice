* NGSPICE file created from ttsky25a_fd_routed.ext - technology: sky130A

.subckt sky130_fd_pr__nfet_01v8_lvt_YRHGMU G D S VSUBS
X0 S G D VSUBS sky130_fd_pr__nfet_01v8_lvt ad=0.29 pd=2.58 as=0.29 ps=2.58 w=1 l=20
.ends

.subckt nfet_01v8_lvt_W1_L20_m2__nf1_gboth_sdfull_ng S B G D
Xnfet_01v8_lvt_W1_L20_m2__nf1_gboth_sdfull_ng_pc G D S B sky130_fd_pr__nfet_01v8_lvt_YRHGMU
.ends

.subckt mirror_XX1_M22_XX1_M15__ABAB net4 Vss x1_net8 Vss_body x1_net7
Xnfet_01v8_lvt_W1_L20_m2__nf1_gboth_sdfull_ng_0 Vss Vss_body Vss Vss nfet_01v8_lvt_W1_L20_m2__nf1_gboth_sdfull_ng
Xnfet_01v8_lvt_W1_L20_m2__nf1_gboth_sdfull_ng_1 Vss Vss_body net4 x1_net7 nfet_01v8_lvt_W1_L20_m2__nf1_gboth_sdfull_ng
Xnfet_01v8_lvt_W1_L20_m2__nf1_gboth_sdfull_ng_2 Vss Vss_body net4 x1_net8 nfet_01v8_lvt_W1_L20_m2__nf1_gboth_sdfull_ng
Xnfet_01v8_lvt_W1_L20_m2__nf1_gboth_sdfull_ng_3 Vss Vss_body net4 x1_net7 nfet_01v8_lvt_W1_L20_m2__nf1_gboth_sdfull_ng
Xnfet_01v8_lvt_W1_L20_m2__nf1_gboth_sdfull_ng_4 Vss Vss_body net4 x1_net8 nfet_01v8_lvt_W1_L20_m2__nf1_gboth_sdfull_ng
Xnfet_01v8_lvt_W1_L20_m2__nf1_gboth_sdfull_ng_5 Vss Vss_body Vss Vss nfet_01v8_lvt_W1_L20_m2__nf1_gboth_sdfull_ng
.ends

.subckt sky130_fd_pr__pfet_01v8_lvt_26VEAH G D0 w_n1123_n200# a_1029_n100# S1
X0 a_1029_n100# G S1 w_n1123_n200# sky130_fd_pr__pfet_01v8_lvt ad=0.29 pd=2.58 as=0.145 ps=1.29 w=1 l=5
X1 S1 G D0 w_n1123_n200# sky130_fd_pr__pfet_01v8_lvt ad=0.145 pd=1.29 as=0.29 ps=2.58 w=1 l=5
.ends

.subckt pfet_01v8_lvt_W2_L5_m2__nf2_gboth_sdfull_outS_ng B D G S
Xpfet_01v8_lvt_W2_L5_m2__nf2_gboth_sdfull_outS_ng_pc G S B S D sky130_fd_pr__pfet_01v8_lvt_26VEAH
.ends

.subckt pmos_matched_cascode_pair__ABAB Vom1 Vdd_body x1_Vtest2 x1_net1 x1_Vbias Vdd
+ Vop1
Xpfet_01v8_lvt_W2_L5_m2__nf2_gboth_sdfull_outS_ng_0 Vdd_body Vdd Vdd Vdd pfet_01v8_lvt_W2_L5_m2__nf2_gboth_sdfull_outS_ng
Xpfet_01v8_lvt_W2_L5_m2__nf2_gboth_sdfull_outS_ng_1 Vdd_body Vop1 x1_Vbias x1_Vtest2
+ pfet_01v8_lvt_W2_L5_m2__nf2_gboth_sdfull_outS_ng
Xpfet_01v8_lvt_W2_L5_m2__nf2_gboth_sdfull_outS_ng_2 Vdd_body Vom1 x1_Vbias x1_net1
+ pfet_01v8_lvt_W2_L5_m2__nf2_gboth_sdfull_outS_ng
Xpfet_01v8_lvt_W2_L5_m2__nf2_gboth_sdfull_outS_ng_3 Vdd_body Vop1 x1_Vbias x1_Vtest2
+ pfet_01v8_lvt_W2_L5_m2__nf2_gboth_sdfull_outS_ng
Xpfet_01v8_lvt_W2_L5_m2__nf2_gboth_sdfull_outS_ng_4 Vdd_body Vom1 x1_Vbias x1_net1
+ pfet_01v8_lvt_W2_L5_m2__nf2_gboth_sdfull_outS_ng
Xpfet_01v8_lvt_W2_L5_m2__nf2_gboth_sdfull_outS_ng_5 Vdd_body Vdd Vdd Vdd pfet_01v8_lvt_W2_L5_m2__nf2_gboth_sdfull_outS_ng
.ends

.subckt sky130_fd_pr__nfet_01v8_lvt_MHCJX9 G D S VSUBS
X0 S G D VSUBS sky130_fd_pr__nfet_01v8_lvt ad=0.174 pd=1.78 as=0.174 ps=1.78 w=0.6 l=1
.ends

.subckt nfet_01v8_lvt_W0p6_L1_m2__nf1_gtop_sdfull_ng B G D S
Xnfet_01v8_lvt_W0p6_L1_m2__nf1_gtop_sdfull_ng_pc G D S B sky130_fd_pr__nfet_01v8_lvt_MHCJX9
.ends

.subckt nmos_current_mirror_3__ABAB net7 Vss Vss_body x2_Vbiasp
Xnfet_01v8_lvt_W0p6_L1_m2__nf1_gtop_sdfull_ng_0 Vss_body Vss Vss Vss nfet_01v8_lvt_W0p6_L1_m2__nf1_gtop_sdfull_ng
Xnfet_01v8_lvt_W0p6_L1_m2__nf1_gtop_sdfull_ng_1 Vss_body net7 net7 Vss nfet_01v8_lvt_W0p6_L1_m2__nf1_gtop_sdfull_ng
Xnfet_01v8_lvt_W0p6_L1_m2__nf1_gtop_sdfull_ng_2 Vss_body net7 x2_Vbiasp Vss nfet_01v8_lvt_W0p6_L1_m2__nf1_gtop_sdfull_ng
Xnfet_01v8_lvt_W0p6_L1_m2__nf1_gtop_sdfull_ng_3 Vss_body net7 net7 Vss nfet_01v8_lvt_W0p6_L1_m2__nf1_gtop_sdfull_ng
Xnfet_01v8_lvt_W0p6_L1_m2__nf1_gtop_sdfull_ng_4 Vss_body net7 x2_Vbiasp Vss nfet_01v8_lvt_W0p6_L1_m2__nf1_gtop_sdfull_ng
Xnfet_01v8_lvt_W0p6_L1_m2__nf1_gtop_sdfull_ng_5 Vss_body Vss Vss Vss nfet_01v8_lvt_W0p6_L1_m2__nf1_gtop_sdfull_ng
.ends

.subckt sky130_fd_pr__pfet_01v8_lvt_G794LM G w_n594_n198# D S
X0 S G D w_n594_n198# sky130_fd_pr__pfet_01v8_lvt ad=0.29 pd=2.58 as=0.29 ps=2.58 w=1 l=5
.ends

.subckt pfet_01v8_lvt_W1_L5_m2__nf1_gtop_sdfull_ng S G D B
Xpfet_01v8_lvt_W1_L5_m2__nf1_gtop_sdfull_ng_pc G B D S sky130_fd_pr__pfet_01v8_lvt_G794LM
.ends

.subckt sky130_fd_pr__pfet_01v8_lvt_KRZAMB G D w_n194_n698# S
X0 S G D w_n194_n698# sky130_fd_pr__pfet_01v8_lvt ad=1.74 pd=12.58 as=1.74 ps=12.58 w=6 l=1
.ends

.subckt pfet_01v8_lvt_W6_L1_m2__nf1_gtop_sdfull_ng D B S G
Xpfet_01v8_lvt_W6_L1_m2__nf1_gtop_sdfull_ng_pc G D B S sky130_fd_pr__pfet_01v8_lvt_KRZAMB
.ends

.subckt pmos_current_mirror_2__row x2_net1 Vdd_body Vdd x2_Vbiasp
Xpfet_01v8_lvt_W1_L5_m2__nf1_gtop_sdfull_ng_0 Vdd x2_Vbiasp x2_net1 Vdd_body pfet_01v8_lvt_W1_L5_m2__nf1_gtop_sdfull_ng
Xpfet_01v8_lvt_W1_L5_m2__nf1_gtop_sdfull_ng_1 Vdd x2_Vbiasp x2_net1 Vdd_body pfet_01v8_lvt_W1_L5_m2__nf1_gtop_sdfull_ng
Xpfet_01v8_lvt_W1_L5_m2__nf1_gtop_sdfull_ng_2 Vdd Vdd Vdd Vdd_body pfet_01v8_lvt_W1_L5_m2__nf1_gtop_sdfull_ng
Xpfet_01v8_lvt_W6_L1_m2__nf1_gtop_sdfull_ng_0 Vdd Vdd_body Vdd Vdd pfet_01v8_lvt_W6_L1_m2__nf1_gtop_sdfull_ng
Xpfet_01v8_lvt_W6_L1_m2__nf1_gtop_sdfull_ng_1 x2_Vbiasp Vdd_body Vdd x2_Vbiasp pfet_01v8_lvt_W6_L1_m2__nf1_gtop_sdfull_ng
Xpfet_01v8_lvt_W6_L1_m2__nf1_gtop_sdfull_ng_2 x2_Vbiasp Vdd_body Vdd x2_Vbiasp pfet_01v8_lvt_W6_L1_m2__nf1_gtop_sdfull_ng
.ends

.subckt sky130_fd_pr__nfet_01v8_lvt_ZCNT58 G D S VSUBS
X0 S G D VSUBS sky130_fd_pr__nfet_01v8_lvt ad=1.45 pd=10.58 as=1.45 ps=10.58 w=5 l=2
.ends

.subckt nfet_01v8_lvt_W5_L2_m2__nf1_gboth_sdfull_ng B S G D
Xnfet_01v8_lvt_W5_L2_m2__nf1_gboth_sdfull_ng_pc G D S B sky130_fd_pr__nfet_01v8_lvt_ZCNT58
.ends

.subckt nmos_single__A Vss net1 Vss_body net2
Xnfet_01v8_lvt_W5_L2_m2__nf1_gboth_sdfull_ng_0 Vss_body Vss net1 net2 nfet_01v8_lvt_W5_L2_m2__nf1_gboth_sdfull_ng
Xnfet_01v8_lvt_W5_L2_m2__nf1_gboth_sdfull_ng_1 Vss_body Vss net1 net2 nfet_01v8_lvt_W5_L2_m2__nf1_gboth_sdfull_ng
.ends

.subckt pfet_01v8_lvt_W2_L5_m4__nf2_gboth_sdfull_outS_ng G S B D
Xpfet_01v8_lvt_W2_L5_m4__nf2_gboth_sdfull_outS_ng_pc G S B S D sky130_fd_pr__pfet_01v8_lvt_26VEAH
.ends

.subckt pmos_matched_current_source_pair_4__ABAB x1_net1 x1_Vtest2 x1_Vout Vdd_body
+ Vdd
Xpfet_01v8_lvt_W2_L5_m4__nf2_gboth_sdfull_outS_ng_0 Vdd Vdd Vdd_body Vdd pfet_01v8_lvt_W2_L5_m4__nf2_gboth_sdfull_outS_ng
Xpfet_01v8_lvt_W2_L5_m4__nf2_gboth_sdfull_outS_ng_1 x1_Vout Vdd Vdd_body x1_Vtest2
+ pfet_01v8_lvt_W2_L5_m4__nf2_gboth_sdfull_outS_ng
Xpfet_01v8_lvt_W2_L5_m4__nf2_gboth_sdfull_outS_ng_2 x1_Vout Vdd Vdd_body x1_net1 pfet_01v8_lvt_W2_L5_m4__nf2_gboth_sdfull_outS_ng
Xpfet_01v8_lvt_W2_L5_m4__nf2_gboth_sdfull_outS_ng_3 x1_Vout Vdd Vdd_body x1_Vtest2
+ pfet_01v8_lvt_W2_L5_m4__nf2_gboth_sdfull_outS_ng
Xpfet_01v8_lvt_W2_L5_m4__nf2_gboth_sdfull_outS_ng_4 x1_Vout Vdd Vdd_body x1_net1 pfet_01v8_lvt_W2_L5_m4__nf2_gboth_sdfull_outS_ng
Xpfet_01v8_lvt_W2_L5_m4__nf2_gboth_sdfull_outS_ng_5 x1_Vout Vdd Vdd_body x1_Vtest2
+ pfet_01v8_lvt_W2_L5_m4__nf2_gboth_sdfull_outS_ng
Xpfet_01v8_lvt_W2_L5_m4__nf2_gboth_sdfull_outS_ng_6 x1_Vout Vdd Vdd_body x1_net1 pfet_01v8_lvt_W2_L5_m4__nf2_gboth_sdfull_outS_ng
Xpfet_01v8_lvt_W2_L5_m4__nf2_gboth_sdfull_outS_ng_7 x1_Vout Vdd Vdd_body x1_Vtest2
+ pfet_01v8_lvt_W2_L5_m4__nf2_gboth_sdfull_outS_ng
Xpfet_01v8_lvt_W2_L5_m4__nf2_gboth_sdfull_outS_ng_8 x1_Vout Vdd Vdd_body x1_net1 pfet_01v8_lvt_W2_L5_m4__nf2_gboth_sdfull_outS_ng
Xpfet_01v8_lvt_W2_L5_m4__nf2_gboth_sdfull_outS_ng_9 Vdd Vdd Vdd_body Vdd pfet_01v8_lvt_W2_L5_m4__nf2_gboth_sdfull_outS_ng
.ends

.subckt sky130_fd_pr__nfet_01v8_lvt_788GJP G D S VSUBS
X0 S G D VSUBS sky130_fd_pr__nfet_01v8_lvt ad=2.9 pd=20.58 as=2.9 ps=20.58 w=10 l=1
.ends

.subckt nfet_01v8_lvt_W10_L1_m2__nf1_gtop_sdfull_ng B S G D
Xnfet_01v8_lvt_W10_L1_m2__nf1_gtop_sdfull_ng_pc G D S B sky130_fd_pr__nfet_01v8_lvt_788GJP
.ends

.subckt nmos_diode__A Rgm Vss_body net1
Xnfet_01v8_lvt_W10_L1_m2__nf1_gtop_sdfull_ng_0 Vss_body Rgm net1 net1 nfet_01v8_lvt_W10_L1_m2__nf1_gtop_sdfull_ng
Xnfet_01v8_lvt_W10_L1_m2__nf1_gtop_sdfull_ng_1 Vss_body Rgm net1 net1 nfet_01v8_lvt_W10_L1_m2__nf1_gtop_sdfull_ng
.ends

.subckt nmos_current_mirror_2__ABBA Vss x1_Vbias net6 Vss_body
Xnfet_01v8_lvt_W0p6_L1_m2__nf1_gtop_sdfull_ng_1 Vss_body net6 net6 Vss nfet_01v8_lvt_W0p6_L1_m2__nf1_gtop_sdfull_ng
Xnfet_01v8_lvt_W0p6_L1_m2__nf1_gtop_sdfull_ng_0 Vss_body Vss Vss Vss nfet_01v8_lvt_W0p6_L1_m2__nf1_gtop_sdfull_ng
Xnfet_01v8_lvt_W0p6_L1_m2__nf1_gtop_sdfull_ng_2 Vss_body net6 x1_Vbias Vss nfet_01v8_lvt_W0p6_L1_m2__nf1_gtop_sdfull_ng
Xnfet_01v8_lvt_W0p6_L1_m2__nf1_gtop_sdfull_ng_3 Vss_body net6 x1_Vbias Vss nfet_01v8_lvt_W0p6_L1_m2__nf1_gtop_sdfull_ng
Xnfet_01v8_lvt_W0p6_L1_m2__nf1_gtop_sdfull_ng_4 Vss_body net6 net6 Vss nfet_01v8_lvt_W0p6_L1_m2__nf1_gtop_sdfull_ng
Xnfet_01v8_lvt_W0p6_L1_m2__nf1_gtop_sdfull_ng_5 Vss_body Vss Vss Vss nfet_01v8_lvt_W0p6_L1_m2__nf1_gtop_sdfull_ng
.ends

.subckt sky130_fd_pr__pfet_01v8_lvt_7Q9QDH G D S w_n194_n598#
X0 S G D w_n194_n598# sky130_fd_pr__pfet_01v8_lvt ad=1.45 pd=10.58 as=1.45 ps=10.58 w=5 l=1
.ends

.subckt pfet_01v8_lvt_W5_L1_m2__nf1_gtop_sdfull_ng G D S B
Xpfet_01v8_lvt_W5_L1_m2__nf1_gtop_sdfull_ng_pc G D S B sky130_fd_pr__pfet_01v8_lvt_7Q9QDH
.ends

.subckt pmos_current_mirror__ABAB net2 PBias Vdd_body Vdd
Xpfet_01v8_lvt_W5_L1_m2__nf1_gtop_sdfull_ng_0 Vdd Vdd Vdd Vdd_body pfet_01v8_lvt_W5_L1_m2__nf1_gtop_sdfull_ng
Xpfet_01v8_lvt_W5_L1_m2__nf1_gtop_sdfull_ng_1 net2 net2 Vdd Vdd_body pfet_01v8_lvt_W5_L1_m2__nf1_gtop_sdfull_ng
Xpfet_01v8_lvt_W5_L1_m2__nf1_gtop_sdfull_ng_2 net2 PBias Vdd Vdd_body pfet_01v8_lvt_W5_L1_m2__nf1_gtop_sdfull_ng
Xpfet_01v8_lvt_W5_L1_m2__nf1_gtop_sdfull_ng_4 net2 PBias Vdd Vdd_body pfet_01v8_lvt_W5_L1_m2__nf1_gtop_sdfull_ng
Xpfet_01v8_lvt_W5_L1_m2__nf1_gtop_sdfull_ng_3 net2 net2 Vdd Vdd_body pfet_01v8_lvt_W5_L1_m2__nf1_gtop_sdfull_ng
Xpfet_01v8_lvt_W5_L1_m2__nf1_gtop_sdfull_ng_5 Vdd Vdd Vdd Vdd_body pfet_01v8_lvt_W5_L1_m2__nf1_gtop_sdfull_ng
.ends

.subckt sky130_fd_pr__nfet_01v8_lvt_YU23CF G D S VSUBS
X0 S G D VSUBS sky130_fd_pr__nfet_01v8_lvt ad=0.29 pd=2.58 as=0.29 ps=2.58 w=1 l=1
.ends

.subckt nfet_01v8_lvt_W1_L1_m9__nf1_gboth_sdfull_ng G D B S
Xnfet_01v8_lvt_W1_L1_m9__nf1_gboth_sdfull_ng_pc G D S B sky130_fd_pr__nfet_01v8_lvt_YU23CF
.ends

.subckt nmos_matched_current_source_pair__ABAB Vss x2_Vout Vop Vom Vss_body
Xnfet_01v8_lvt_W1_L1_m9__nf1_gboth_sdfull_ng_0 Vss Vss Vss_body Vss nfet_01v8_lvt_W1_L1_m9__nf1_gboth_sdfull_ng
Xnfet_01v8_lvt_W1_L1_m9__nf1_gboth_sdfull_ng_1 x2_Vout Vop Vss_body Vss nfet_01v8_lvt_W1_L1_m9__nf1_gboth_sdfull_ng
Xnfet_01v8_lvt_W1_L1_m9__nf1_gboth_sdfull_ng_2 x2_Vout Vom Vss_body Vss nfet_01v8_lvt_W1_L1_m9__nf1_gboth_sdfull_ng
Xnfet_01v8_lvt_W1_L1_m9__nf1_gboth_sdfull_ng_3 x2_Vout Vop Vss_body Vss nfet_01v8_lvt_W1_L1_m9__nf1_gboth_sdfull_ng
Xnfet_01v8_lvt_W1_L1_m9__nf1_gboth_sdfull_ng_10 x2_Vout Vom Vss_body Vss nfet_01v8_lvt_W1_L1_m9__nf1_gboth_sdfull_ng
Xnfet_01v8_lvt_W1_L1_m9__nf1_gboth_sdfull_ng_4 x2_Vout Vom Vss_body Vss nfet_01v8_lvt_W1_L1_m9__nf1_gboth_sdfull_ng
Xnfet_01v8_lvt_W1_L1_m9__nf1_gboth_sdfull_ng_11 x2_Vout Vop Vss_body Vss nfet_01v8_lvt_W1_L1_m9__nf1_gboth_sdfull_ng
Xnfet_01v8_lvt_W1_L1_m9__nf1_gboth_sdfull_ng_5 x2_Vout Vop Vss_body Vss nfet_01v8_lvt_W1_L1_m9__nf1_gboth_sdfull_ng
Xnfet_01v8_lvt_W1_L1_m9__nf1_gboth_sdfull_ng_12 x2_Vout Vom Vss_body Vss nfet_01v8_lvt_W1_L1_m9__nf1_gboth_sdfull_ng
Xnfet_01v8_lvt_W1_L1_m9__nf1_gboth_sdfull_ng_6 x2_Vout Vom Vss_body Vss nfet_01v8_lvt_W1_L1_m9__nf1_gboth_sdfull_ng
Xnfet_01v8_lvt_W1_L1_m9__nf1_gboth_sdfull_ng_13 x2_Vout Vop Vss_body Vss nfet_01v8_lvt_W1_L1_m9__nf1_gboth_sdfull_ng
Xnfet_01v8_lvt_W1_L1_m9__nf1_gboth_sdfull_ng_7 x2_Vout Vop Vss_body Vss nfet_01v8_lvt_W1_L1_m9__nf1_gboth_sdfull_ng
Xnfet_01v8_lvt_W1_L1_m9__nf1_gboth_sdfull_ng_14 x2_Vout Vom Vss_body Vss nfet_01v8_lvt_W1_L1_m9__nf1_gboth_sdfull_ng
Xnfet_01v8_lvt_W1_L1_m9__nf1_gboth_sdfull_ng_8 x2_Vout Vom Vss_body Vss nfet_01v8_lvt_W1_L1_m9__nf1_gboth_sdfull_ng
Xnfet_01v8_lvt_W1_L1_m9__nf1_gboth_sdfull_ng_15 x2_Vout Vop Vss_body Vss nfet_01v8_lvt_W1_L1_m9__nf1_gboth_sdfull_ng
Xnfet_01v8_lvt_W1_L1_m9__nf1_gboth_sdfull_ng_9 x2_Vout Vop Vss_body Vss nfet_01v8_lvt_W1_L1_m9__nf1_gboth_sdfull_ng
Xnfet_01v8_lvt_W1_L1_m9__nf1_gboth_sdfull_ng_16 x2_Vout Vom Vss_body Vss nfet_01v8_lvt_W1_L1_m9__nf1_gboth_sdfull_ng
Xnfet_01v8_lvt_W1_L1_m9__nf1_gboth_sdfull_ng_17 x2_Vout Vop Vss_body Vss nfet_01v8_lvt_W1_L1_m9__nf1_gboth_sdfull_ng
Xnfet_01v8_lvt_W1_L1_m9__nf1_gboth_sdfull_ng_18 x2_Vout Vom Vss_body Vss nfet_01v8_lvt_W1_L1_m9__nf1_gboth_sdfull_ng
Xnfet_01v8_lvt_W1_L1_m9__nf1_gboth_sdfull_ng_19 Vss Vss Vss_body Vss nfet_01v8_lvt_W1_L1_m9__nf1_gboth_sdfull_ng
.ends

.subckt pmos_matched_current_source_pair__ABBA Vdd NBias net1 PBias Vdd_body
Xpfet_01v8_lvt_W5_L1_m2__nf1_gtop_sdfull_ng_0 Vdd Vdd Vdd Vdd_body pfet_01v8_lvt_W5_L1_m2__nf1_gtop_sdfull_ng
Xpfet_01v8_lvt_W5_L1_m2__nf1_gtop_sdfull_ng_1 PBias NBias Vdd Vdd_body pfet_01v8_lvt_W5_L1_m2__nf1_gtop_sdfull_ng
Xpfet_01v8_lvt_W5_L1_m2__nf1_gtop_sdfull_ng_2 PBias net1 Vdd Vdd_body pfet_01v8_lvt_W5_L1_m2__nf1_gtop_sdfull_ng
Xpfet_01v8_lvt_W5_L1_m2__nf1_gtop_sdfull_ng_3 PBias net1 Vdd Vdd_body pfet_01v8_lvt_W5_L1_m2__nf1_gtop_sdfull_ng
Xpfet_01v8_lvt_W5_L1_m2__nf1_gtop_sdfull_ng_4 PBias NBias Vdd Vdd_body pfet_01v8_lvt_W5_L1_m2__nf1_gtop_sdfull_ng
Xpfet_01v8_lvt_W5_L1_m2__nf1_gtop_sdfull_ng_5 Vdd Vdd Vdd Vdd_body pfet_01v8_lvt_W5_L1_m2__nf1_gtop_sdfull_ng
.ends

.subckt sky130_fd_pr__cap_mim_m3_1_DHLNXX C1_4 C1_3 C1_2 C1_1 C1_0 C2_4 C2_3 C2_2
+ C2_1 C2_0
X0 C1_0 C2_0 sky130_fd_pr__cap_mim_m3_1 l=10 w=10
X1 C1_2 C2_2 sky130_fd_pr__cap_mim_m3_1 l=10 w=10
X2 C1_3 C2_3 sky130_fd_pr__cap_mim_m3_1 l=10 w=10
X3 C1_1 C2_1 sky130_fd_pr__cap_mim_m3_1 l=10 w=10
X4 C1_4 C2_4 sky130_fd_pr__cap_mim_m3_1 l=10 w=10
.ends

.subckt XC2_mim XC2_mim_pc/C2_4 XC2_mim_pc/C2_3 XC2_mim_pc/C2_2 XC2_mim_pc/C2_1 XC2_mim_pc/C2_0
+ XC2_mim_pc/C1_4 XC2_mim_pc/C1_3 XC2_mim_pc/C1_2 XC2_mim_pc/C1_1 XC2_mim_pc/C1_0
XXC2_mim_pc XC2_mim_pc/C1_4 XC2_mim_pc/C1_3 XC2_mim_pc/C1_2 XC2_mim_pc/C1_1 XC2_mim_pc/C1_0
+ XC2_mim_pc/C2_4 XC2_mim_pc/C2_3 XC2_mim_pc/C2_2 XC2_mim_pc/C2_1 XC2_mim_pc/C2_0
+ sky130_fd_pr__cap_mim_m3_1_DHLNXX
.ends

.subckt XC2__A Vop Vom1
XXC2_mim_0 Vop Vop Vop Vop Vop Vom1 Vom1 Vom1 Vom1 Vom1 XC2_mim
.ends

.subckt sky130_fd_pr__nfet_01v8_lvt_SLTJA6 G D S VSUBS
X0 S G D VSUBS sky130_fd_pr__nfet_01v8_lvt ad=0.29 pd=2.58 as=0.29 ps=2.58 w=1 l=2
.ends

.subckt nfet_01v8_lvt_W1_L2_m2__nf1_gboth_sdfull_ng B S G D
Xnfet_01v8_lvt_W1_L2_m2__nf1_gboth_sdfull_ng_pc G D S B sky130_fd_pr__nfet_01v8_lvt_SLTJA6
.ends

.subckt nmos_current_mirror_4__A net4 Vss Vss_body
Xnfet_01v8_lvt_W1_L2_m2__nf1_gboth_sdfull_ng_0 Vss_body Vss net4 net4 nfet_01v8_lvt_W1_L2_m2__nf1_gboth_sdfull_ng
Xnfet_01v8_lvt_W1_L2_m2__nf1_gboth_sdfull_ng_1 Vss_body Vss net4 net4 nfet_01v8_lvt_W1_L2_m2__nf1_gboth_sdfull_ng
.ends

.subckt sky130_fd_pr__nfet_01v8_lvt_E98VH6 G D S VSUBS
X0 S G D VSUBS sky130_fd_pr__nfet_01v8_lvt ad=0.174 pd=1.78 as=0.174 ps=1.78 w=0.6 l=5
.ends

.subckt nfet_01v8_lvt_W0p6_L5_m2__nf1_gboth_sdfull_ng B G D S
Xnfet_01v8_lvt_W0p6_L5_m2__nf1_gboth_sdfull_ng_pc G D S B sky130_fd_pr__nfet_01v8_lvt_E98VH6
.ends

.subckt nmos_diode_2__A net5 Vss Vss_body
Xnfet_01v8_lvt_W0p6_L5_m2__nf1_gboth_sdfull_ng_0 Vss_body net5 net5 Vss nfet_01v8_lvt_W0p6_L5_m2__nf1_gboth_sdfull_ng
Xnfet_01v8_lvt_W0p6_L5_m2__nf1_gboth_sdfull_ng_1 Vss_body net5 net5 Vss nfet_01v8_lvt_W0p6_L5_m2__nf1_gboth_sdfull_ng
.ends

.subckt nfet_01v8_lvt_W1_L1_m2__nf1_gboth_sdfull_ng D B S G
Xnfet_01v8_lvt_W1_L1_m2__nf1_gboth_sdfull_ng_pc G D S B sky130_fd_pr__nfet_01v8_lvt_YU23CF
.ends

.subckt nmos_matched_cascode_pair__ABBA net5 x1_net5 Vss Vss_body x1_net3 x1_net2
+ Vop1
Xnfet_01v8_lvt_W1_L1_m2__nf1_gboth_sdfull_ng_1 x1_net2 Vss_body x1_net3 net5 nfet_01v8_lvt_W1_L1_m2__nf1_gboth_sdfull_ng
Xnfet_01v8_lvt_W1_L1_m2__nf1_gboth_sdfull_ng_0 Vss Vss_body Vss Vss nfet_01v8_lvt_W1_L1_m2__nf1_gboth_sdfull_ng
Xnfet_01v8_lvt_W1_L1_m2__nf1_gboth_sdfull_ng_2 Vop1 Vss_body x1_net5 net5 nfet_01v8_lvt_W1_L1_m2__nf1_gboth_sdfull_ng
Xnfet_01v8_lvt_W1_L1_m2__nf1_gboth_sdfull_ng_3 Vop1 Vss_body x1_net5 net5 nfet_01v8_lvt_W1_L1_m2__nf1_gboth_sdfull_ng
Xnfet_01v8_lvt_W1_L1_m2__nf1_gboth_sdfull_ng_4 x1_net2 Vss_body x1_net3 net5 nfet_01v8_lvt_W1_L1_m2__nf1_gboth_sdfull_ng
Xnfet_01v8_lvt_W1_L1_m2__nf1_gboth_sdfull_ng_5 Vss Vss_body Vss Vss nfet_01v8_lvt_W1_L1_m2__nf1_gboth_sdfull_ng
.ends

.subckt pmos_matched_current_source_pair_3__ABAB net7 Vdd_body PBias net6 Vdd
Xpfet_01v8_lvt_W5_L1_m2__nf1_gtop_sdfull_ng_0 Vdd Vdd Vdd Vdd_body pfet_01v8_lvt_W5_L1_m2__nf1_gtop_sdfull_ng
Xpfet_01v8_lvt_W5_L1_m2__nf1_gtop_sdfull_ng_1 PBias net6 Vdd Vdd_body pfet_01v8_lvt_W5_L1_m2__nf1_gtop_sdfull_ng
Xpfet_01v8_lvt_W5_L1_m2__nf1_gtop_sdfull_ng_2 PBias net7 Vdd Vdd_body pfet_01v8_lvt_W5_L1_m2__nf1_gtop_sdfull_ng
Xpfet_01v8_lvt_W5_L1_m2__nf1_gtop_sdfull_ng_4 PBias net7 Vdd Vdd_body pfet_01v8_lvt_W5_L1_m2__nf1_gtop_sdfull_ng
Xpfet_01v8_lvt_W5_L1_m2__nf1_gtop_sdfull_ng_3 PBias net6 Vdd Vdd_body pfet_01v8_lvt_W5_L1_m2__nf1_gtop_sdfull_ng
Xpfet_01v8_lvt_W5_L1_m2__nf1_gtop_sdfull_ng_5 Vdd Vdd Vdd Vdd_body pfet_01v8_lvt_W5_L1_m2__nf1_gtop_sdfull_ng
.ends

.subckt sky130_fd_pr__pfet_01v8_lvt_4N9G9U G D S w_n2094_n198#
X0 S G D w_n2094_n198# sky130_fd_pr__pfet_01v8_lvt ad=0.29 pd=2.58 as=0.29 ps=2.58 w=1 l=20
.ends

.subckt pfet_01v8_lvt_W1_L20_m2__nf1_gtop_sdfull_ng G D B S
Xpfet_01v8_lvt_W1_L20_m2__nf1_gtop_sdfull_ng_pc G D S B sky130_fd_pr__pfet_01v8_lvt_4N9G9U
.ends

.subckt pmos_diode__A Vdd_body Vdd net3
Xpfet_01v8_lvt_W1_L20_m2__nf1_gtop_sdfull_ng_0 net3 net3 Vdd_body Vdd pfet_01v8_lvt_W1_L20_m2__nf1_gtop_sdfull_ng
Xpfet_01v8_lvt_W1_L20_m2__nf1_gtop_sdfull_ng_1 net3 net3 Vdd_body Vdd pfet_01v8_lvt_W1_L20_m2__nf1_gtop_sdfull_ng
.ends

.subckt nmos_matched_cascode_pair_2__ABAB Vss net5 x1_net6 Vom1 x1_net4 Vss_body x1_net2
Xnfet_01v8_lvt_W1_L1_m2__nf1_gboth_sdfull_ng_0 Vss Vss_body Vss Vss nfet_01v8_lvt_W1_L1_m2__nf1_gboth_sdfull_ng
Xnfet_01v8_lvt_W1_L1_m2__nf1_gboth_sdfull_ng_1 x1_net2 Vss_body x1_net4 net5 nfet_01v8_lvt_W1_L1_m2__nf1_gboth_sdfull_ng
Xnfet_01v8_lvt_W1_L1_m2__nf1_gboth_sdfull_ng_2 Vom1 Vss_body x1_net6 net5 nfet_01v8_lvt_W1_L1_m2__nf1_gboth_sdfull_ng
Xnfet_01v8_lvt_W1_L1_m2__nf1_gboth_sdfull_ng_3 x1_net2 Vss_body x1_net4 net5 nfet_01v8_lvt_W1_L1_m2__nf1_gboth_sdfull_ng
Xnfet_01v8_lvt_W1_L1_m2__nf1_gboth_sdfull_ng_4 Vom1 Vss_body x1_net6 net5 nfet_01v8_lvt_W1_L1_m2__nf1_gboth_sdfull_ng
Xnfet_01v8_lvt_W1_L1_m2__nf1_gboth_sdfull_ng_5 Vss Vss_body Vss Vss nfet_01v8_lvt_W1_L1_m2__nf1_gboth_sdfull_ng
.ends

.subckt sky130_fd_pr__pfet_01v8_lvt_2HDQYB G w_n323_n200# D0 a_229_n100# S1
X0 S1 G D0 w_n323_n200# sky130_fd_pr__pfet_01v8_lvt ad=0.145 pd=1.29 as=0.29 ps=2.58 w=1 l=1
X1 a_229_n100# G S1 w_n323_n200# sky130_fd_pr__pfet_01v8_lvt ad=0.29 pd=2.58 as=0.145 ps=1.29 w=1 l=1
.ends

.subckt pfet_01v8_lvt_W2_L1_m9__nf2_gboth_sdfull_outS_ng G D S B
Xpfet_01v8_lvt_W2_L1_m9__nf2_gboth_sdfull_outS_ng_pc G B S S D sky130_fd_pr__pfet_01v8_lvt_2HDQYB
.ends

.subckt pmos_single_2__A Vom1 Vop Vdd_body Vdd
Xpfet_01v8_lvt_W2_L1_m9__nf2_gboth_sdfull_outS_ng_0 Vom1 Vop Vdd Vdd_body pfet_01v8_lvt_W2_L1_m9__nf2_gboth_sdfull_outS_ng
Xpfet_01v8_lvt_W2_L1_m9__nf2_gboth_sdfull_outS_ng_1 Vom1 Vop Vdd Vdd_body pfet_01v8_lvt_W2_L1_m9__nf2_gboth_sdfull_outS_ng
Xpfet_01v8_lvt_W2_L1_m9__nf2_gboth_sdfull_outS_ng_2 Vom1 Vop Vdd Vdd_body pfet_01v8_lvt_W2_L1_m9__nf2_gboth_sdfull_outS_ng
Xpfet_01v8_lvt_W2_L1_m9__nf2_gboth_sdfull_outS_ng_3 Vom1 Vop Vdd Vdd_body pfet_01v8_lvt_W2_L1_m9__nf2_gboth_sdfull_outS_ng
Xpfet_01v8_lvt_W2_L1_m9__nf2_gboth_sdfull_outS_ng_4 Vom1 Vop Vdd Vdd_body pfet_01v8_lvt_W2_L1_m9__nf2_gboth_sdfull_outS_ng
Xpfet_01v8_lvt_W2_L1_m9__nf2_gboth_sdfull_outS_ng_5 Vom1 Vop Vdd Vdd_body pfet_01v8_lvt_W2_L1_m9__nf2_gboth_sdfull_outS_ng
Xpfet_01v8_lvt_W2_L1_m9__nf2_gboth_sdfull_outS_ng_6 Vom1 Vop Vdd Vdd_body pfet_01v8_lvt_W2_L1_m9__nf2_gboth_sdfull_outS_ng
Xpfet_01v8_lvt_W2_L1_m9__nf2_gboth_sdfull_outS_ng_7 Vom1 Vop Vdd Vdd_body pfet_01v8_lvt_W2_L1_m9__nf2_gboth_sdfull_outS_ng
Xpfet_01v8_lvt_W2_L1_m9__nf2_gboth_sdfull_outS_ng_8 Vom1 Vop Vdd Vdd_body pfet_01v8_lvt_W2_L1_m9__nf2_gboth_sdfull_outS_ng
.ends

.subckt sky130_fd_pr__res_generic_po_5GPU7X R2 R1
X0 R1 R2 sky130_fd_pr__res_generic_po w=0.5 l=40
.ends

.subckt res_generic_po_W0p5_L40 res_generic_po_W0p5_L40_pc/R2 res_generic_po_W0p5_L40_pc/R1
Xres_generic_po_W0p5_L40_pc res_generic_po_W0p5_L40_pc/R2 res_generic_po_W0p5_L40_pc/R1
+ sky130_fd_pr__res_generic_po_5GPU7X
.ends

.subckt res_packs__interleaved Vss Vop Vom x2_Vcm
Xres_generic_po_W0p5_L40_6 x2_x2_net5 x2_x2_net6 res_generic_po_W0p5_L40
Xres_generic_po_W0p5_L40_7 x2_x2_net7 x2_x2_net6 res_generic_po_W0p5_L40
Xres_generic_po_W0p5_L40_8 x2_x1_net7 x2_x1_net6 res_generic_po_W0p5_L40
Xres_generic_po_W0p5_L40_9 x2_x1_net7 x2_x1_net1 res_generic_po_W0p5_L40
Xres_generic_po_W0p5_L40_40 x2_Vcm x2_x1_net16 res_generic_po_W0p5_L40
Xres_generic_po_W0p5_L40_30 x2_x2_net15 x2_x2_net3 res_generic_po_W0p5_L40
Xres_generic_po_W0p5_L40_41 Vss Vss res_generic_po_W0p5_L40
Xres_generic_po_W0p5_L40_20 x2_x1_net2 x2_x1_net8 res_generic_po_W0p5_L40
Xres_generic_po_W0p5_L40_31 x2_x2_net19 x2_x2_net3 res_generic_po_W0p5_L40
Xres_generic_po_W0p5_L40_10 x2_x2_net7 x2_x2_net1 res_generic_po_W0p5_L40
Xres_generic_po_W0p5_L40_21 x2_x1_net2 x2_x1_net12 res_generic_po_W0p5_L40
Xres_generic_po_W0p5_L40_32 x2_x1_net19 x2_x1_net3 res_generic_po_W0p5_L40
Xres_generic_po_W0p5_L40_11 x2_x2_net11 x2_x2_net1 res_generic_po_W0p5_L40
Xres_generic_po_W0p5_L40_22 x2_x2_net2 x2_x2_net12 res_generic_po_W0p5_L40
Xres_generic_po_W0p5_L40_33 x2_x1_net19 x2_x1_net18 res_generic_po_W0p5_L40
Xres_generic_po_W0p5_L40_12 x2_x1_net11 x2_x1_net1 res_generic_po_W0p5_L40
Xres_generic_po_W0p5_L40_23 x2_x2_net13 x2_x2_net12 res_generic_po_W0p5_L40
Xres_generic_po_W0p5_L40_34 x2_x2_net19 x2_x2_net18 res_generic_po_W0p5_L40
Xres_generic_po_W0p5_L40_13 x2_x1_net11 x2_x1_net10 res_generic_po_W0p5_L40
Xres_generic_po_W0p5_L40_24 x2_x1_net13 x2_x1_net12 res_generic_po_W0p5_L40
Xres_generic_po_W0p5_L40_35 x2_x2_net17 x2_x2_net18 res_generic_po_W0p5_L40
Xres_generic_po_W0p5_L40_14 x2_x2_net11 x2_x2_net10 res_generic_po_W0p5_L40
Xres_generic_po_W0p5_L40_25 x2_x1_net13 x2_x1_net14 res_generic_po_W0p5_L40
Xres_generic_po_W0p5_L40_36 x2_x1_net17 x2_x1_net18 res_generic_po_W0p5_L40
Xres_generic_po_W0p5_L40_15 x2_x2_net9 x2_x2_net10 res_generic_po_W0p5_L40
Xres_generic_po_W0p5_L40_16 x2_x1_net9 x2_x1_net10 res_generic_po_W0p5_L40
Xres_generic_po_W0p5_L40_26 x2_x2_net13 x2_x2_net14 res_generic_po_W0p5_L40
Xres_generic_po_W0p5_L40_27 x2_x2_net15 x2_x2_net14 res_generic_po_W0p5_L40
Xres_generic_po_W0p5_L40_37 x2_x1_net17 x2_x1_net16 res_generic_po_W0p5_L40
Xres_generic_po_W0p5_L40_38 x2_x2_net17 x2_x2_net16 res_generic_po_W0p5_L40
Xres_generic_po_W0p5_L40_17 x2_x1_net9 x2_x1_net8 res_generic_po_W0p5_L40
Xres_generic_po_W0p5_L40_28 x2_x1_net15 x2_x1_net14 res_generic_po_W0p5_L40
Xres_generic_po_W0p5_L40_39 Vom x2_x2_net16 res_generic_po_W0p5_L40
Xres_generic_po_W0p5_L40_18 x2_x2_net9 x2_x2_net8 res_generic_po_W0p5_L40
Xres_generic_po_W0p5_L40_29 x2_x1_net15 x2_x1_net3 res_generic_po_W0p5_L40
Xres_generic_po_W0p5_L40_19 x2_x2_net2 x2_x2_net8 res_generic_po_W0p5_L40
Xres_generic_po_W0p5_L40_0 Vss Vss res_generic_po_W0p5_L40
Xres_generic_po_W0p5_L40_1 Vop x2_x1_net4 res_generic_po_W0p5_L40
Xres_generic_po_W0p5_L40_2 x2_Vcm x2_x2_net4 res_generic_po_W0p5_L40
Xres_generic_po_W0p5_L40_3 x2_x2_net5 x2_x2_net4 res_generic_po_W0p5_L40
Xres_generic_po_W0p5_L40_4 x2_x1_net5 x2_x1_net4 res_generic_po_W0p5_L40
Xres_generic_po_W0p5_L40_5 x2_x1_net5 x2_x1_net6 res_generic_po_W0p5_L40
.ends

.subckt nmos_current_mirror__interdigitated NBias net3 PBias Vss Vss_body
Xnfet_01v8_lvt_W5_L2_m2__nf1_gboth_sdfull_ng_0 Vss_body Vss Vss Vss nfet_01v8_lvt_W5_L2_m2__nf1_gboth_sdfull_ng
Xnfet_01v8_lvt_W5_L2_m2__nf1_gboth_sdfull_ng_1 Vss_body Vss NBias NBias nfet_01v8_lvt_W5_L2_m2__nf1_gboth_sdfull_ng
Xnfet_01v8_lvt_W5_L2_m2__nf1_gboth_sdfull_ng_2 Vss_body Vss NBias PBias nfet_01v8_lvt_W5_L2_m2__nf1_gboth_sdfull_ng
Xnfet_01v8_lvt_W5_L2_m2__nf1_gboth_sdfull_ng_3 Vss_body Vss NBias net3 nfet_01v8_lvt_W5_L2_m2__nf1_gboth_sdfull_ng
Xnfet_01v8_lvt_W5_L2_m2__nf1_gboth_sdfull_ng_5 Vss_body Vss NBias PBias nfet_01v8_lvt_W5_L2_m2__nf1_gboth_sdfull_ng
Xnfet_01v8_lvt_W5_L2_m2__nf1_gboth_sdfull_ng_4 Vss_body Vss NBias NBias nfet_01v8_lvt_W5_L2_m2__nf1_gboth_sdfull_ng
Xnfet_01v8_lvt_W5_L2_m2__nf1_gboth_sdfull_ng_6 Vss_body Vss NBias net3 nfet_01v8_lvt_W5_L2_m2__nf1_gboth_sdfull_ng
Xnfet_01v8_lvt_W5_L2_m2__nf1_gboth_sdfull_ng_7 Vss_body Vss Vss Vss nfet_01v8_lvt_W5_L2_m2__nf1_gboth_sdfull_ng
.ends

.subckt sky130_fd_pr__nfet_01v8_lvt_SAUMT6 G D S VSUBS
X0 S G D VSUBS sky130_fd_pr__nfet_01v8_lvt ad=1.16 pd=8.58 as=1.16 ps=8.58 w=4 l=4
.ends

.subckt nfet_01v8_lvt_W4_L4_m2__nf1_gboth_sdfull_ng G D B S
Xnfet_01v8_lvt_W4_L4_m2__nf1_gboth_sdfull_ng_pc G D S B sky130_fd_pr__nfet_01v8_lvt_SAUMT6
.ends

.subckt nmos_differential_pair__ABAB x1_net1 Vm x1_Vtest2 Vss Vss_body Vp x1_net2
Xnfet_01v8_lvt_W4_L4_m2__nf1_gboth_sdfull_ng_0 Vss Vss Vss_body Vss nfet_01v8_lvt_W4_L4_m2__nf1_gboth_sdfull_ng
Xnfet_01v8_lvt_W4_L4_m2__nf1_gboth_sdfull_ng_1 Vm x1_Vtest2 Vss_body x1_net2 nfet_01v8_lvt_W4_L4_m2__nf1_gboth_sdfull_ng
Xnfet_01v8_lvt_W4_L4_m2__nf1_gboth_sdfull_ng_2 Vp x1_net1 Vss_body x1_net2 nfet_01v8_lvt_W4_L4_m2__nf1_gboth_sdfull_ng
Xnfet_01v8_lvt_W4_L4_m2__nf1_gboth_sdfull_ng_3 Vm x1_Vtest2 Vss_body x1_net2 nfet_01v8_lvt_W4_L4_m2__nf1_gboth_sdfull_ng
Xnfet_01v8_lvt_W4_L4_m2__nf1_gboth_sdfull_ng_4 Vp x1_net1 Vss_body x1_net2 nfet_01v8_lvt_W4_L4_m2__nf1_gboth_sdfull_ng
Xnfet_01v8_lvt_W4_L4_m2__nf1_gboth_sdfull_ng_5 Vss Vss Vss_body Vss nfet_01v8_lvt_W4_L4_m2__nf1_gboth_sdfull_ng
.ends

.subckt sky130_fd_pr__nfet_01v8_lvt_7VF3LY G D S VSUBS
X0 S G D VSUBS sky130_fd_pr__nfet_01v8_lvt ad=0.29 pd=2.58 as=0.29 ps=2.58 w=1 l=10
.ends

.subckt nfet_01v8_lvt_W1_L10_m2__nf1_gboth_sdfull_ng B G D S
Xnfet_01v8_lvt_W1_L10_m2__nf1_gboth_sdfull_ng_pc G D S B sky130_fd_pr__nfet_01v8_lvt_7VF3LY
.ends

.subckt mirror_XX1_M1_XX1_M2_XX1_M7_XX1_M9__centroid Vss net4 x1_net6 x1_net5 x1_net4
+ Vss_body x1_net3
Xnfet_01v8_lvt_W1_L10_m2__nf1_gboth_sdfull_ng_0 Vss_body Vss Vss Vss nfet_01v8_lvt_W1_L10_m2__nf1_gboth_sdfull_ng
Xnfet_01v8_lvt_W1_L10_m2__nf1_gboth_sdfull_ng_1 Vss_body net4 x1_net3 Vss nfet_01v8_lvt_W1_L10_m2__nf1_gboth_sdfull_ng
Xnfet_01v8_lvt_W1_L10_m2__nf1_gboth_sdfull_ng_2 Vss_body net4 x1_net4 Vss nfet_01v8_lvt_W1_L10_m2__nf1_gboth_sdfull_ng
Xnfet_01v8_lvt_W1_L10_m2__nf1_gboth_sdfull_ng_3 Vss_body net4 x1_net5 Vss nfet_01v8_lvt_W1_L10_m2__nf1_gboth_sdfull_ng
Xnfet_01v8_lvt_W1_L10_m2__nf1_gboth_sdfull_ng_4 Vss_body net4 x1_net6 Vss nfet_01v8_lvt_W1_L10_m2__nf1_gboth_sdfull_ng
Xnfet_01v8_lvt_W1_L10_m2__nf1_gboth_sdfull_ng_5 Vss_body net4 x1_net6 Vss nfet_01v8_lvt_W1_L10_m2__nf1_gboth_sdfull_ng
Xnfet_01v8_lvt_W1_L10_m2__nf1_gboth_sdfull_ng_6 Vss_body net4 x1_net5 Vss nfet_01v8_lvt_W1_L10_m2__nf1_gboth_sdfull_ng
Xnfet_01v8_lvt_W1_L10_m2__nf1_gboth_sdfull_ng_7 Vss_body net4 x1_net4 Vss nfet_01v8_lvt_W1_L10_m2__nf1_gboth_sdfull_ng
Xnfet_01v8_lvt_W1_L10_m2__nf1_gboth_sdfull_ng_8 Vss_body net4 x1_net3 Vss nfet_01v8_lvt_W1_L10_m2__nf1_gboth_sdfull_ng
Xnfet_01v8_lvt_W1_L10_m2__nf1_gboth_sdfull_ng_9 Vss_body Vss Vss Vss nfet_01v8_lvt_W1_L10_m2__nf1_gboth_sdfull_ng
.ends

.subckt XC1_mim XC1_mim_pc/C2_4 XC1_mim_pc/C2_2 XC1_mim_pc/C2_3 XC1_mim_pc/C2_1 XC1_mim_pc/C2_0
+ XC1_mim_pc/C1_4 XC1_mim_pc/C1_3 XC1_mim_pc/C1_2 XC1_mim_pc/C1_1 XC1_mim_pc/C1_0
XXC1_mim_pc XC1_mim_pc/C1_4 XC1_mim_pc/C1_3 XC1_mim_pc/C1_2 XC1_mim_pc/C1_1 XC1_mim_pc/C1_0
+ XC1_mim_pc/C2_4 XC1_mim_pc/C2_3 XC1_mim_pc/C2_2 XC1_mim_pc/C2_1 XC1_mim_pc/C2_0
+ sky130_fd_pr__cap_mim_m3_1_DHLNXX
.ends

.subckt XC1__A Vom Vop1
XXC1_mim_0 Vom Vom Vom Vom Vom Vop1 Vop1 Vop1 Vop1 Vop1 XC1_mim
.ends

.subckt sky130_fd_pr__nfet_01v8_lvt_8GTBD2 G D S VSUBS
X0 S G D VSUBS sky130_fd_pr__nfet_01v8_lvt ad=0.145 pd=1.58 as=0.145 ps=1.58 w=0.5 l=20
.ends

.subckt nfet_01v8_lvt_W0p5_L20_m2__nf1_gboth_sdfull_ng B S G D
Xnfet_01v8_lvt_W0p5_L20_m2__nf1_gboth_sdfull_ng_pc G D S B sky130_fd_pr__nfet_01v8_lvt_8GTBD2
.ends

.subckt nmos_current_mirror_load__ABBA x2_Vtest Vss x2_Vout Vss_body
Xnfet_01v8_lvt_W0p5_L20_m2__nf1_gboth_sdfull_ng_0 Vss_body Vss Vss Vss nfet_01v8_lvt_W0p5_L20_m2__nf1_gboth_sdfull_ng
Xnfet_01v8_lvt_W0p5_L20_m2__nf1_gboth_sdfull_ng_1 Vss_body Vss x2_Vtest x2_Vtest nfet_01v8_lvt_W0p5_L20_m2__nf1_gboth_sdfull_ng
Xnfet_01v8_lvt_W0p5_L20_m2__nf1_gboth_sdfull_ng_2 Vss_body Vss x2_Vtest x2_Vout nfet_01v8_lvt_W0p5_L20_m2__nf1_gboth_sdfull_ng
Xnfet_01v8_lvt_W0p5_L20_m2__nf1_gboth_sdfull_ng_3 Vss_body Vss x2_Vtest x2_Vout nfet_01v8_lvt_W0p5_L20_m2__nf1_gboth_sdfull_ng
Xnfet_01v8_lvt_W0p5_L20_m2__nf1_gboth_sdfull_ng_4 Vss_body Vss x2_Vtest x2_Vtest nfet_01v8_lvt_W0p5_L20_m2__nf1_gboth_sdfull_ng
Xnfet_01v8_lvt_W0p5_L20_m2__nf1_gboth_sdfull_ng_5 Vss_body Vss Vss Vss nfet_01v8_lvt_W0p5_L20_m2__nf1_gboth_sdfull_ng
.ends

.subckt pmos_single__A Vop1 Vdd_body Vom Vdd
Xpfet_01v8_lvt_W2_L1_m9__nf2_gboth_sdfull_outS_ng_0 Vop1 Vom Vdd Vdd_body pfet_01v8_lvt_W2_L1_m9__nf2_gboth_sdfull_outS_ng
Xpfet_01v8_lvt_W2_L1_m9__nf2_gboth_sdfull_outS_ng_1 Vop1 Vom Vdd Vdd_body pfet_01v8_lvt_W2_L1_m9__nf2_gboth_sdfull_outS_ng
Xpfet_01v8_lvt_W2_L1_m9__nf2_gboth_sdfull_outS_ng_2 Vop1 Vom Vdd Vdd_body pfet_01v8_lvt_W2_L1_m9__nf2_gboth_sdfull_outS_ng
Xpfet_01v8_lvt_W2_L1_m9__nf2_gboth_sdfull_outS_ng_3 Vop1 Vom Vdd Vdd_body pfet_01v8_lvt_W2_L1_m9__nf2_gboth_sdfull_outS_ng
Xpfet_01v8_lvt_W2_L1_m9__nf2_gboth_sdfull_outS_ng_4 Vop1 Vom Vdd Vdd_body pfet_01v8_lvt_W2_L1_m9__nf2_gboth_sdfull_outS_ng
Xpfet_01v8_lvt_W2_L1_m9__nf2_gboth_sdfull_outS_ng_5 Vop1 Vom Vdd Vdd_body pfet_01v8_lvt_W2_L1_m9__nf2_gboth_sdfull_outS_ng
Xpfet_01v8_lvt_W2_L1_m9__nf2_gboth_sdfull_outS_ng_7 Vop1 Vom Vdd Vdd_body pfet_01v8_lvt_W2_L1_m9__nf2_gboth_sdfull_outS_ng
Xpfet_01v8_lvt_W2_L1_m9__nf2_gboth_sdfull_outS_ng_6 Vop1 Vom Vdd Vdd_body pfet_01v8_lvt_W2_L1_m9__nf2_gboth_sdfull_outS_ng
Xpfet_01v8_lvt_W2_L1_m9__nf2_gboth_sdfull_outS_ng_8 Vop1 Vom Vdd Vdd_body pfet_01v8_lvt_W2_L1_m9__nf2_gboth_sdfull_outS_ng
.ends

.subckt sky130_fd_pr__nfet_01v8_lvt_KUHQTA G D S VSUBS
X0 S G D VSUBS sky130_fd_pr__nfet_01v8_lvt ad=1.45 pd=10.58 as=1.45 ps=10.58 w=5 l=20
.ends

.subckt nfet_01v8_lvt_W5_L20_m2__nf1_gboth_sdfull_ng B S G D
Xnfet_01v8_lvt_W5_L20_m2__nf1_gboth_sdfull_ng_pc G D S B sky130_fd_pr__nfet_01v8_lvt_KUHQTA
.ends

.subckt nmos_differential_pair_3__ABAB x1_net9 Vss Vref x1_net8 x1_Vout Vss_body Vop1
Xnfet_01v8_lvt_W5_L20_m2__nf1_gboth_sdfull_ng_0 Vss_body Vss Vss Vss nfet_01v8_lvt_W5_L20_m2__nf1_gboth_sdfull_ng
Xnfet_01v8_lvt_W5_L20_m2__nf1_gboth_sdfull_ng_1 Vss_body x1_net8 Vref x1_Vout nfet_01v8_lvt_W5_L20_m2__nf1_gboth_sdfull_ng
Xnfet_01v8_lvt_W5_L20_m2__nf1_gboth_sdfull_ng_3 Vss_body x1_net8 Vref x1_Vout nfet_01v8_lvt_W5_L20_m2__nf1_gboth_sdfull_ng
Xnfet_01v8_lvt_W5_L20_m2__nf1_gboth_sdfull_ng_2 Vss_body x1_net8 Vop1 x1_net9 nfet_01v8_lvt_W5_L20_m2__nf1_gboth_sdfull_ng
Xnfet_01v8_lvt_W5_L20_m2__nf1_gboth_sdfull_ng_4 Vss_body x1_net8 Vop1 x1_net9 nfet_01v8_lvt_W5_L20_m2__nf1_gboth_sdfull_ng
Xnfet_01v8_lvt_W5_L20_m2__nf1_gboth_sdfull_ng_5 Vss_body Vss Vss Vss nfet_01v8_lvt_W5_L20_m2__nf1_gboth_sdfull_ng
.ends

.subckt pmos_matched_current_source_pair_2__ABAB net5 Vdd_body PBias net4 Vdd
Xpfet_01v8_lvt_W5_L1_m2__nf1_gtop_sdfull_ng_0 Vdd Vdd Vdd Vdd_body pfet_01v8_lvt_W5_L1_m2__nf1_gtop_sdfull_ng
Xpfet_01v8_lvt_W5_L1_m2__nf1_gtop_sdfull_ng_1 PBias net4 Vdd Vdd_body pfet_01v8_lvt_W5_L1_m2__nf1_gtop_sdfull_ng
Xpfet_01v8_lvt_W5_L1_m2__nf1_gtop_sdfull_ng_2 PBias net5 Vdd Vdd_body pfet_01v8_lvt_W5_L1_m2__nf1_gtop_sdfull_ng
Xpfet_01v8_lvt_W5_L1_m2__nf1_gtop_sdfull_ng_4 PBias net5 Vdd Vdd_body pfet_01v8_lvt_W5_L1_m2__nf1_gtop_sdfull_ng
Xpfet_01v8_lvt_W5_L1_m2__nf1_gtop_sdfull_ng_3 PBias net4 Vdd Vdd_body pfet_01v8_lvt_W5_L1_m2__nf1_gtop_sdfull_ng
Xpfet_01v8_lvt_W5_L1_m2__nf1_gtop_sdfull_ng_5 Vdd Vdd Vdd Vdd_body pfet_01v8_lvt_W5_L1_m2__nf1_gtop_sdfull_ng
.ends

.subckt sky130_fd_pr__nfet_01v8_lvt_U7GK5T G D S VSUBS
X0 S G D VSUBS sky130_fd_pr__nfet_01v8_lvt ad=0.58 pd=4.58 as=0.58 ps=4.58 w=2 l=1
.ends

.subckt nfet_01v8_lvt_W2_L1_m1__nf1_gtop_sdfull_ng B G D S
Xnfet_01v8_lvt_W2_L1_m1__nf1_gtop_sdfull_ng_pc G D S B sky130_fd_pr__nfet_01v8_lvt_U7GK5T
.ends

.subckt nmos_single_2__A NBias net3 PBias Vss_body
Xnfet_01v8_lvt_W2_L1_m1__nf1_gtop_sdfull_ng_0 Vss_body net3 PBias NBias nfet_01v8_lvt_W2_L1_m1__nf1_gtop_sdfull_ng
.ends

.subckt sky130_fd_pr__pfet_01v8_lvt_BJW7CL G D S w_n1094_n250#
X0 S G D w_n1094_n250# sky130_fd_pr__pfet_01v8_lvt ad=0.435 pd=3.58 as=0.435 ps=3.58 w=1.5 l=10
.ends

.subckt pfet_01v8_lvt_W1p5_L10_m2__nf1_gboth_sdfull_ng G D S B
Xpfet_01v8_lvt_W1p5_L10_m2__nf1_gboth_sdfull_ng_pc G D S B sky130_fd_pr__pfet_01v8_lvt_BJW7CL
.ends

.subckt pmos_diode_2__A Vdd_body Vdd x1_Vbias
Xpfet_01v8_lvt_W1p5_L10_m2__nf1_gboth_sdfull_ng_0 x1_Vbias x1_Vbias Vdd Vdd_body pfet_01v8_lvt_W1p5_L10_m2__nf1_gboth_sdfull_ng
Xpfet_01v8_lvt_W1p5_L10_m2__nf1_gboth_sdfull_ng_1 x1_Vbias x1_Vbias Vdd Vdd_body pfet_01v8_lvt_W1p5_L10_m2__nf1_gboth_sdfull_ng
.ends

.subckt sky130_fd_pr__pfet_01v8_lvt_5FXXCR G D w_n1094_n200# S
X0 S G D w_n1094_n200# sky130_fd_pr__pfet_01v8_lvt ad=0.29 pd=2.58 as=0.29 ps=2.58 w=1 l=10
.ends

.subckt pfet_01v8_lvt_W1_L10_m2__nf1_gboth_sdfull_ng S G D B
Xpfet_01v8_lvt_W1_L10_m2__nf1_gboth_sdfull_ng_pc G D B S sky130_fd_pr__pfet_01v8_lvt_5FXXCR
.ends

.subckt pmos_current_mirror_load__ABAB x1_Vout Vdd_body x1_net9 Vdd
Xpfet_01v8_lvt_W1_L10_m2__nf1_gboth_sdfull_ng_0 Vdd Vdd Vdd Vdd_body pfet_01v8_lvt_W1_L10_m2__nf1_gboth_sdfull_ng
Xpfet_01v8_lvt_W1_L10_m2__nf1_gboth_sdfull_ng_1 Vdd x1_net9 x1_net9 Vdd_body pfet_01v8_lvt_W1_L10_m2__nf1_gboth_sdfull_ng
Xpfet_01v8_lvt_W1_L10_m2__nf1_gboth_sdfull_ng_2 Vdd x1_net9 x1_Vout Vdd_body pfet_01v8_lvt_W1_L10_m2__nf1_gboth_sdfull_ng
Xpfet_01v8_lvt_W1_L10_m2__nf1_gboth_sdfull_ng_3 Vdd x1_net9 x1_net9 Vdd_body pfet_01v8_lvt_W1_L10_m2__nf1_gboth_sdfull_ng
Xpfet_01v8_lvt_W1_L10_m2__nf1_gboth_sdfull_ng_4 Vdd x1_net9 x1_Vout Vdd_body pfet_01v8_lvt_W1_L10_m2__nf1_gboth_sdfull_ng
Xpfet_01v8_lvt_W1_L10_m2__nf1_gboth_sdfull_ng_5 Vdd Vdd Vdd Vdd_body pfet_01v8_lvt_W1_L10_m2__nf1_gboth_sdfull_ng
.ends

.subckt pmos_differential_pair__ABBA x2_net1 x2_Vtest x2_Vcm x2_Vout Vdd_body Vref
+ Vdd
Xpfet_01v8_lvt_W1_L10_m2__nf1_gboth_sdfull_ng_0 Vdd Vdd Vdd Vdd_body pfet_01v8_lvt_W1_L10_m2__nf1_gboth_sdfull_ng
Xpfet_01v8_lvt_W1_L10_m2__nf1_gboth_sdfull_ng_1 x2_net1 x2_Vcm x2_Vtest Vdd_body pfet_01v8_lvt_W1_L10_m2__nf1_gboth_sdfull_ng
Xpfet_01v8_lvt_W1_L10_m2__nf1_gboth_sdfull_ng_2 x2_net1 Vref x2_Vout Vdd_body pfet_01v8_lvt_W1_L10_m2__nf1_gboth_sdfull_ng
Xpfet_01v8_lvt_W1_L10_m2__nf1_gboth_sdfull_ng_3 x2_net1 Vref x2_Vout Vdd_body pfet_01v8_lvt_W1_L10_m2__nf1_gboth_sdfull_ng
Xpfet_01v8_lvt_W1_L10_m2__nf1_gboth_sdfull_ng_4 x2_net1 x2_Vcm x2_Vtest Vdd_body pfet_01v8_lvt_W1_L10_m2__nf1_gboth_sdfull_ng
Xpfet_01v8_lvt_W1_L10_m2__nf1_gboth_sdfull_ng_5 Vdd Vdd Vdd Vdd_body pfet_01v8_lvt_W1_L10_m2__nf1_gboth_sdfull_ng
.ends

.subckt nmos_differential_pair_2__ABAB x1_Vout x1_net9 Vref Vss x1_net7 Vom1 Vss_body
Xnfet_01v8_lvt_W5_L20_m2__nf1_gboth_sdfull_ng_0 Vss_body Vss Vss Vss nfet_01v8_lvt_W5_L20_m2__nf1_gboth_sdfull_ng
Xnfet_01v8_lvt_W5_L20_m2__nf1_gboth_sdfull_ng_1 Vss_body x1_net7 Vom1 x1_net9 nfet_01v8_lvt_W5_L20_m2__nf1_gboth_sdfull_ng
Xnfet_01v8_lvt_W5_L20_m2__nf1_gboth_sdfull_ng_2 Vss_body x1_net7 Vref x1_Vout nfet_01v8_lvt_W5_L20_m2__nf1_gboth_sdfull_ng
Xnfet_01v8_lvt_W5_L20_m2__nf1_gboth_sdfull_ng_3 Vss_body x1_net7 Vom1 x1_net9 nfet_01v8_lvt_W5_L20_m2__nf1_gboth_sdfull_ng
Xnfet_01v8_lvt_W5_L20_m2__nf1_gboth_sdfull_ng_4 Vss_body x1_net7 Vref x1_Vout nfet_01v8_lvt_W5_L20_m2__nf1_gboth_sdfull_ng
Xnfet_01v8_lvt_W5_L20_m2__nf1_gboth_sdfull_ng_5 Vss_body Vss Vss Vss nfet_01v8_lvt_W5_L20_m2__nf1_gboth_sdfull_ng
.ends

.subckt ttsky25a_fd_routed Vom Vop RGM VREF Vdd Vm Vp Vss
Xmirror_XX1_M22_XX1_M15__ABAB_0 nmos_current_mirror_4__A_0/net4 Vss mirror_XX1_M22_XX1_M15__ABAB_0/x1_net8
+ Vss mirror_XX1_M22_XX1_M15__ABAB_0/x1_net7 mirror_XX1_M22_XX1_M15__ABAB
Xpmos_matched_cascode_pair__ABAB_0 XC2__A_0/Vom1 Vdd nmos_differential_pair__ABAB_0/x1_Vtest2
+ nmos_differential_pair__ABAB_0/x1_net1 pmos_diode_2__A_0/x1_Vbias Vdd XC1__A_0/Vop1
+ pmos_matched_cascode_pair__ABAB
Xnmos_current_mirror_3__ABAB_0 nmos_current_mirror_3__ABAB_0/net7 Vss Vss pmos_current_mirror_2__row_0/x2_Vbiasp
+ nmos_current_mirror_3__ABAB
Xpmos_current_mirror_2__row_0 pmos_current_mirror_2__row_0/x2_net1 Vdd Vdd pmos_current_mirror_2__row_0/x2_Vbiasp
+ pmos_current_mirror_2__row
Xnmos_single__A_0 Vss nmos_diode__A_0/net1 Vss nmos_single__A_0/net2 nmos_single__A
Xpmos_matched_current_source_pair_4__ABAB_0 nmos_differential_pair__ABAB_0/x1_net1
+ nmos_differential_pair__ABAB_0/x1_Vtest2 pmos_current_mirror_load__ABAB_0/x1_Vout
+ Vdd Vdd pmos_matched_current_source_pair_4__ABAB
Xnmos_diode__A_0 RGM Vss nmos_diode__A_0/net1 nmos_diode__A
Xnmos_current_mirror_2__ABBA_0 Vss pmos_diode_2__A_0/x1_Vbias nmos_current_mirror_2__ABBA_0/net6
+ Vss nmos_current_mirror_2__ABBA
Xpmos_current_mirror__ABAB_0 nmos_single__A_0/net2 nmos_single_2__A_0/PBias Vdd Vdd
+ pmos_current_mirror__ABAB
Xnmos_matched_current_source_pair__ABAB_0 Vss pmos_differential_pair__ABBA_0/x2_Vout
+ Vop Vom Vss nmos_matched_current_source_pair__ABAB
Xpmos_matched_current_source_pair__ABBA_0 Vdd nmos_single_2__A_0/NBias nmos_diode__A_0/net1
+ nmos_single_2__A_0/PBias Vdd pmos_matched_current_source_pair__ABBA
XXC2__A_0 Vop XC2__A_0/Vom1 XC2__A
Xnmos_current_mirror_4__A_0 nmos_current_mirror_4__A_0/net4 Vss Vss nmos_current_mirror_4__A
Xnmos_diode_2__A_0 nmos_diode_2__A_0/net5 Vss Vss nmos_diode_2__A
Xnmos_matched_cascode_pair__ABBA_0 nmos_diode_2__A_0/net5 nmos_matched_cascode_pair__ABBA_0/x1_net5
+ Vss Vss nmos_matched_cascode_pair__ABBA_0/x1_net3 nmos_differential_pair__ABAB_0/x1_net2
+ XC1__A_0/Vop1 nmos_matched_cascode_pair__ABBA
Xpmos_matched_current_source_pair_3__ABAB_0 nmos_current_mirror_3__ABAB_0/net7 Vdd
+ nmos_single_2__A_0/PBias nmos_current_mirror_2__ABBA_0/net6 Vdd pmos_matched_current_source_pair_3__ABAB
Xpmos_diode__A_0 Vdd Vdd pmos_diode__A_0/net3 pmos_diode__A
Xnmos_matched_cascode_pair_2__ABAB_0 Vss nmos_diode_2__A_0/net5 nmos_matched_cascode_pair_2__ABAB_0/x1_net6
+ XC2__A_0/Vom1 nmos_matched_cascode_pair_2__ABAB_0/x1_net4 Vss nmos_differential_pair__ABAB_0/x1_net2
+ nmos_matched_cascode_pair_2__ABAB
Xpmos_single_2__A_0 XC2__A_0/Vom1 Vop Vdd Vdd pmos_single_2__A
Xres_packs__interleaved_0 Vss Vop Vom res_packs__interleaved_0/x2_Vcm res_packs__interleaved
Xnmos_current_mirror__interdigitated_0 nmos_single_2__A_0/NBias pmos_diode__A_0/net3
+ nmos_single_2__A_0/PBias Vss Vss nmos_current_mirror__interdigitated
Xnmos_differential_pair__ABAB_0 nmos_differential_pair__ABAB_0/x1_net1 Vm nmos_differential_pair__ABAB_0/x1_Vtest2
+ Vss Vss Vp nmos_differential_pair__ABAB_0/x1_net2 nmos_differential_pair__ABAB
Xmirror_XX1_M1_XX1_M2_XX1_M7_XX1_M9__centroid_0 Vss nmos_current_mirror_4__A_0/net4
+ nmos_matched_cascode_pair_2__ABAB_0/x1_net6 nmos_matched_cascode_pair__ABBA_0/x1_net5
+ nmos_matched_cascode_pair_2__ABAB_0/x1_net4 Vss nmos_matched_cascode_pair__ABBA_0/x1_net3
+ mirror_XX1_M1_XX1_M2_XX1_M7_XX1_M9__centroid
XXC1__A_0 Vom XC1__A_0/Vop1 XC1__A
Xnmos_current_mirror_load__ABBA_0 pmos_differential_pair__ABBA_0/x2_Vtest Vss pmos_differential_pair__ABBA_0/x2_Vout
+ Vss nmos_current_mirror_load__ABBA
Xpmos_single__A_0 XC1__A_0/Vop1 Vdd Vom Vdd pmos_single__A
Xnmos_differential_pair_3__ABAB_0 pmos_current_mirror_load__ABAB_0/x1_net9 Vss VREF
+ mirror_XX1_M22_XX1_M15__ABAB_0/x1_net8 pmos_current_mirror_load__ABAB_0/x1_Vout
+ Vss XC1__A_0/Vop1 nmos_differential_pair_3__ABAB
Xpmos_matched_current_source_pair_2__ABAB_0 nmos_diode_2__A_0/net5 Vdd nmos_single_2__A_0/PBias
+ nmos_current_mirror_4__A_0/net4 Vdd pmos_matched_current_source_pair_2__ABAB
Xnmos_single_2__A_0 nmos_single_2__A_0/NBias pmos_diode__A_0/net3 nmos_single_2__A_0/PBias
+ Vss nmos_single_2__A
Xpmos_diode_2__A_0 Vdd Vdd pmos_diode_2__A_0/x1_Vbias pmos_diode_2__A
Xpmos_current_mirror_load__ABAB_0 pmos_current_mirror_load__ABAB_0/x1_Vout Vdd pmos_current_mirror_load__ABAB_0/x1_net9
+ Vdd pmos_current_mirror_load__ABAB
Xpmos_differential_pair__ABBA_0 pmos_current_mirror_2__row_0/x2_net1 pmos_differential_pair__ABBA_0/x2_Vtest
+ res_packs__interleaved_0/x2_Vcm pmos_differential_pair__ABBA_0/x2_Vout Vdd VREF
+ Vdd pmos_differential_pair__ABBA
Xnmos_differential_pair_2__ABAB_0 pmos_current_mirror_load__ABAB_0/x1_Vout pmos_current_mirror_load__ABAB_0/x1_net9
+ VREF Vss mirror_XX1_M22_XX1_M15__ABAB_0/x1_net7 XC2__A_0/Vom1 Vss nmos_differential_pair_2__ABAB
.ends
