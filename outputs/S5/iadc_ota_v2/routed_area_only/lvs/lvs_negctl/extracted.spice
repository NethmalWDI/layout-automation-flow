* NGSPICE file created from iadc_ota_v2_routed.ext - technology: sky130A

.subckt sky130_fd_pr__cap_mim_m3_1_MX4MQY C1_3 C1_2 C1_1 C1_0 C2_3 C2_2 C2_1 C2_0
X0 C1_0 C2_0 sky130_fd_pr__cap_mim_m3_1 l=4.8 w=4.8
X1 C1_2 C2_2 sky130_fd_pr__cap_mim_m3_1 l=4.8 w=4.8
X2 C1_1 C2_1 sky130_fd_pr__cap_mim_m3_1 l=4.8 w=4.8
X3 C1_3 C2_3 sky130_fd_pr__cap_mim_m3_1 l=4.8 w=4.8
.ends

.subckt XC3_mim XC3_mim_pc/C2_3 XC3_mim_pc/C2_2 XC3_mim_pc/C2_1 XC3_mim_pc/C2_0 XC3_mim_pc/C1_3
+ XC3_mim_pc/C1_1 XC3_mim_pc/C1_2 XC3_mim_pc/C1_0
XXC3_mim_pc XC3_mim_pc/C1_3 XC3_mim_pc/C1_2 XC3_mim_pc/C1_1 XC3_mim_pc/C1_0 XC3_mim_pc/C2_3
+ XC3_mim_pc/C2_2 XC3_mim_pc/C2_1 XC3_mim_pc/C2_0 sky130_fd_pr__cap_mim_m3_1_MX4MQY
.ends

.subckt XC3__A op cmc
XXC3_mim_0 cmc cmc cmc cmc op op op op XC3_mim
.ends

.subckt sky130_fd_pr__nfet_01v8_RUA5M6 G D S VSUBS
X0 S G D VSUBS sky130_fd_pr__nfet_01v8 ad=0.406 pd=3.38 as=0.406 ps=3.38 w=1.4 l=0.6
.ends

.subckt nfet_01v8_W1p4_L0p6_m23__nf1_gtop_sdfull_ng B G D S
Xnfet_01v8_W1p4_L0p6_m23__nf1_gtop_sdfull_ng_pc G D S B sky130_fd_pr__nfet_01v8_RUA5M6
.ends

.subckt nmos_dummy__f1 VSS VSS_body
Xnfet_01v8_W1p4_L0p6_m23__nf1_gtop_sdfull_ng_0 VSS_body VSS VSS VSS nfet_01v8_W1p4_L0p6_m23__nf1_gtop_sdfull_ng
Xnfet_01v8_W1p4_L0p6_m23__nf1_gtop_sdfull_ng_1 VSS_body VSS VSS VSS nfet_01v8_W1p4_L0p6_m23__nf1_gtop_sdfull_ng
Xnfet_01v8_W1p4_L0p6_m23__nf1_gtop_sdfull_ng_2 VSS_body VSS VSS VSS nfet_01v8_W1p4_L0p6_m23__nf1_gtop_sdfull_ng
Xnfet_01v8_W1p4_L0p6_m23__nf1_gtop_sdfull_ng_3 VSS_body VSS VSS VSS nfet_01v8_W1p4_L0p6_m23__nf1_gtop_sdfull_ng
Xnfet_01v8_W1p4_L0p6_m23__nf1_gtop_sdfull_ng_4 VSS_body VSS VSS VSS nfet_01v8_W1p4_L0p6_m23__nf1_gtop_sdfull_ng
Xnfet_01v8_W1p4_L0p6_m23__nf1_gtop_sdfull_ng_5 VSS_body VSS VSS VSS nfet_01v8_W1p4_L0p6_m23__nf1_gtop_sdfull_ng
Xnfet_01v8_W1p4_L0p6_m23__nf1_gtop_sdfull_ng_6 VSS_body VSS VSS VSS nfet_01v8_W1p4_L0p6_m23__nf1_gtop_sdfull_ng
Xnfet_01v8_W1p4_L0p6_m23__nf1_gtop_sdfull_ng_7 VSS_body VSS VSS VSS nfet_01v8_W1p4_L0p6_m23__nf1_gtop_sdfull_ng
Xnfet_01v8_W1p4_L0p6_m23__nf1_gtop_sdfull_ng_8 VSS_body VSS VSS VSS nfet_01v8_W1p4_L0p6_m23__nf1_gtop_sdfull_ng
Xnfet_01v8_W1p4_L0p6_m23__nf1_gtop_sdfull_ng_9 VSS_body VSS VSS VSS nfet_01v8_W1p4_L0p6_m23__nf1_gtop_sdfull_ng
Xnfet_01v8_W1p4_L0p6_m23__nf1_gtop_sdfull_ng_20 VSS_body VSS VSS VSS nfet_01v8_W1p4_L0p6_m23__nf1_gtop_sdfull_ng
Xnfet_01v8_W1p4_L0p6_m23__nf1_gtop_sdfull_ng_10 VSS_body VSS VSS VSS nfet_01v8_W1p4_L0p6_m23__nf1_gtop_sdfull_ng
Xnfet_01v8_W1p4_L0p6_m23__nf1_gtop_sdfull_ng_21 VSS_body VSS VSS VSS nfet_01v8_W1p4_L0p6_m23__nf1_gtop_sdfull_ng
Xnfet_01v8_W1p4_L0p6_m23__nf1_gtop_sdfull_ng_11 VSS_body VSS VSS VSS nfet_01v8_W1p4_L0p6_m23__nf1_gtop_sdfull_ng
Xnfet_01v8_W1p4_L0p6_m23__nf1_gtop_sdfull_ng_22 VSS_body VSS VSS VSS nfet_01v8_W1p4_L0p6_m23__nf1_gtop_sdfull_ng
Xnfet_01v8_W1p4_L0p6_m23__nf1_gtop_sdfull_ng_12 VSS_body VSS VSS VSS nfet_01v8_W1p4_L0p6_m23__nf1_gtop_sdfull_ng
Xnfet_01v8_W1p4_L0p6_m23__nf1_gtop_sdfull_ng_23 VSS_body VSS VSS VSS nfet_01v8_W1p4_L0p6_m23__nf1_gtop_sdfull_ng
Xnfet_01v8_W1p4_L0p6_m23__nf1_gtop_sdfull_ng_13 VSS_body VSS VSS VSS nfet_01v8_W1p4_L0p6_m23__nf1_gtop_sdfull_ng
Xnfet_01v8_W1p4_L0p6_m23__nf1_gtop_sdfull_ng_14 VSS_body VSS VSS VSS nfet_01v8_W1p4_L0p6_m23__nf1_gtop_sdfull_ng
Xnfet_01v8_W1p4_L0p6_m23__nf1_gtop_sdfull_ng_24 VSS_body VSS VSS VSS nfet_01v8_W1p4_L0p6_m23__nf1_gtop_sdfull_ng
Xnfet_01v8_W1p4_L0p6_m23__nf1_gtop_sdfull_ng_15 VSS_body VSS VSS VSS nfet_01v8_W1p4_L0p6_m23__nf1_gtop_sdfull_ng
Xnfet_01v8_W1p4_L0p6_m23__nf1_gtop_sdfull_ng_16 VSS_body VSS VSS VSS nfet_01v8_W1p4_L0p6_m23__nf1_gtop_sdfull_ng
Xnfet_01v8_W1p4_L0p6_m23__nf1_gtop_sdfull_ng_17 VSS_body VSS VSS VSS nfet_01v8_W1p4_L0p6_m23__nf1_gtop_sdfull_ng
Xnfet_01v8_W1p4_L0p6_m23__nf1_gtop_sdfull_ng_18 VSS_body VSS VSS VSS nfet_01v8_W1p4_L0p6_m23__nf1_gtop_sdfull_ng
Xnfet_01v8_W1p4_L0p6_m23__nf1_gtop_sdfull_ng_19 VSS_body VSS VSS VSS nfet_01v8_W1p4_L0p6_m23__nf1_gtop_sdfull_ng
.ends

.subckt sky130_fd_pr__nfet_01v8_KCM6UP G D S VSUBS
X0 S G D VSUBS sky130_fd_pr__nfet_01v8 ad=0.406 pd=3.38 as=0.406 ps=3.38 w=1.4 l=0.6
.ends

.subckt nfet_01v8_W1p4_L0p6_m96__nf1_gboth_sdfull_ng D B S G
Xnfet_01v8_W1p4_L0p6_m96__nf1_gboth_sdfull_ng_pc G D S B sky130_fd_pr__nfet_01v8_KCM6UP
.ends

.subckt nfet_01v8_W1p4_L0p6_m36__nf1_gboth_sdfull_ng B S G D
Xnfet_01v8_W1p4_L0p6_m36__nf1_gboth_sdfull_ng_pc G D S B sky130_fd_pr__nfet_01v8_KCM6UP
.ends

.subckt nfet_01v8_W1p4_L0p6_m6__nf1_gtop_sdfull_ng B G D S
Xnfet_01v8_W1p4_L0p6_m6__nf1_gtop_sdfull_ng_pc G D S B sky130_fd_pr__nfet_01v8_RUA5M6
.ends

.subckt nfet_01v8_W1p4_L0p6_m2__nf1_gboth_sdfull_ng B S G D
Xnfet_01v8_W1p4_L0p6_m2__nf1_gboth_sdfull_ng_pc G D S B sky130_fd_pr__nfet_01v8_KCM6UP
.ends

.subckt nfet_01v8_W1p4_L0p6_m8__nf1_gtop_sdfull_ng B S G D
Xnfet_01v8_W1p4_L0p6_m8__nf1_gtop_sdfull_ng_pc G D S B sky130_fd_pr__nfet_01v8_RUA5M6
.ends

.subckt x2_cm_tail__id6 cmc bias_a x2_m3d x2_tail VSS x2_m4d VSS_body
Xnfet_01v8_W1p4_L0p6_m96__nf1_gboth_sdfull_ng_0 x2_tail VSS_body VSS cmc nfet_01v8_W1p4_L0p6_m96__nf1_gboth_sdfull_ng
Xnfet_01v8_W1p4_L0p6_m36__nf1_gboth_sdfull_ng_11 VSS_body VSS bias_a x2_m4d nfet_01v8_W1p4_L0p6_m36__nf1_gboth_sdfull_ng
Xnfet_01v8_W1p4_L0p6_m36__nf1_gboth_sdfull_ng_22 VSS_body VSS bias_a x2_m4d nfet_01v8_W1p4_L0p6_m36__nf1_gboth_sdfull_ng
Xnfet_01v8_W1p4_L0p6_m36__nf1_gboth_sdfull_ng_33 VSS_body VSS bias_a x2_m4d nfet_01v8_W1p4_L0p6_m36__nf1_gboth_sdfull_ng
Xnfet_01v8_W1p4_L0p6_m96__nf1_gboth_sdfull_ng_80 x2_tail VSS_body VSS cmc nfet_01v8_W1p4_L0p6_m96__nf1_gboth_sdfull_ng
Xnfet_01v8_W1p4_L0p6_m96__nf1_gboth_sdfull_ng_91 x2_tail VSS_body VSS bias_a nfet_01v8_W1p4_L0p6_m96__nf1_gboth_sdfull_ng
Xnfet_01v8_W1p4_L0p6_m36__nf1_gboth_sdfull_ng_44 VSS_body VSS bias_a x2_m4d nfet_01v8_W1p4_L0p6_m36__nf1_gboth_sdfull_ng
Xnfet_01v8_W1p4_L0p6_m36__nf1_gboth_sdfull_ng_66 VSS_body VSS bias_a x2_m4d nfet_01v8_W1p4_L0p6_m36__nf1_gboth_sdfull_ng
Xnfet_01v8_W1p4_L0p6_m36__nf1_gboth_sdfull_ng_55 VSS_body VSS bias_a x2_m4d nfet_01v8_W1p4_L0p6_m36__nf1_gboth_sdfull_ng
Xnfet_01v8_W1p4_L0p6_m96__nf1_gboth_sdfull_ng_1 x2_tail VSS_body VSS bias_a nfet_01v8_W1p4_L0p6_m96__nf1_gboth_sdfull_ng
Xnfet_01v8_W1p4_L0p6_m96__nf1_gboth_sdfull_ng_102 x2_tail VSS_body VSS bias_a nfet_01v8_W1p4_L0p6_m96__nf1_gboth_sdfull_ng
Xnfet_01v8_W1p4_L0p6_m96__nf1_gboth_sdfull_ng_113 x2_tail VSS_body VSS cmc nfet_01v8_W1p4_L0p6_m96__nf1_gboth_sdfull_ng
Xnfet_01v8_W1p4_L0p6_m96__nf1_gboth_sdfull_ng_124 x2_tail VSS_body VSS bias_a nfet_01v8_W1p4_L0p6_m96__nf1_gboth_sdfull_ng
Xnfet_01v8_W1p4_L0p6_m96__nf1_gboth_sdfull_ng_179 x2_tail VSS_body VSS cmc nfet_01v8_W1p4_L0p6_m96__nf1_gboth_sdfull_ng
Xnfet_01v8_W1p4_L0p6_m96__nf1_gboth_sdfull_ng_168 x2_tail VSS_body VSS bias_a nfet_01v8_W1p4_L0p6_m96__nf1_gboth_sdfull_ng
Xnfet_01v8_W1p4_L0p6_m96__nf1_gboth_sdfull_ng_157 x2_tail VSS_body VSS bias_a nfet_01v8_W1p4_L0p6_m96__nf1_gboth_sdfull_ng
Xnfet_01v8_W1p4_L0p6_m96__nf1_gboth_sdfull_ng_146 x2_tail VSS_body VSS cmc nfet_01v8_W1p4_L0p6_m96__nf1_gboth_sdfull_ng
Xnfet_01v8_W1p4_L0p6_m96__nf1_gboth_sdfull_ng_135 x2_tail VSS_body VSS bias_a nfet_01v8_W1p4_L0p6_m96__nf1_gboth_sdfull_ng
Xnfet_01v8_W1p4_L0p6_m96__nf1_gboth_sdfull_ng_70 x2_tail VSS_body VSS cmc nfet_01v8_W1p4_L0p6_m96__nf1_gboth_sdfull_ng
Xnfet_01v8_W1p4_L0p6_m96__nf1_gboth_sdfull_ng_81 x2_tail VSS_body VSS bias_a nfet_01v8_W1p4_L0p6_m96__nf1_gboth_sdfull_ng
Xnfet_01v8_W1p4_L0p6_m96__nf1_gboth_sdfull_ng_92 x2_tail VSS_body VSS cmc nfet_01v8_W1p4_L0p6_m96__nf1_gboth_sdfull_ng
Xnfet_01v8_W1p4_L0p6_m36__nf1_gboth_sdfull_ng_12 VSS_body VSS bias_a x2_m4d nfet_01v8_W1p4_L0p6_m36__nf1_gboth_sdfull_ng
Xnfet_01v8_W1p4_L0p6_m36__nf1_gboth_sdfull_ng_23 VSS_body VSS bias_a x2_m3d nfet_01v8_W1p4_L0p6_m36__nf1_gboth_sdfull_ng
Xnfet_01v8_W1p4_L0p6_m36__nf1_gboth_sdfull_ng_34 VSS_body VSS bias_a x2_m3d nfet_01v8_W1p4_L0p6_m36__nf1_gboth_sdfull_ng
Xnfet_01v8_W1p4_L0p6_m36__nf1_gboth_sdfull_ng_45 VSS_body VSS bias_a x2_m3d nfet_01v8_W1p4_L0p6_m36__nf1_gboth_sdfull_ng
Xnfet_01v8_W1p4_L0p6_m36__nf1_gboth_sdfull_ng_67 VSS_body VSS bias_a x2_m3d nfet_01v8_W1p4_L0p6_m36__nf1_gboth_sdfull_ng
Xnfet_01v8_W1p4_L0p6_m36__nf1_gboth_sdfull_ng_56 VSS_body VSS bias_a x2_m3d nfet_01v8_W1p4_L0p6_m36__nf1_gboth_sdfull_ng
Xnfet_01v8_W1p4_L0p6_m96__nf1_gboth_sdfull_ng_103 x2_tail VSS_body VSS cmc nfet_01v8_W1p4_L0p6_m96__nf1_gboth_sdfull_ng
Xnfet_01v8_W1p4_L0p6_m96__nf1_gboth_sdfull_ng_114 x2_tail VSS_body VSS bias_a nfet_01v8_W1p4_L0p6_m96__nf1_gboth_sdfull_ng
Xnfet_01v8_W1p4_L0p6_m96__nf1_gboth_sdfull_ng_125 x2_tail VSS_body VSS cmc nfet_01v8_W1p4_L0p6_m96__nf1_gboth_sdfull_ng
Xnfet_01v8_W1p4_L0p6_m96__nf1_gboth_sdfull_ng_169 x2_tail VSS_body VSS cmc nfet_01v8_W1p4_L0p6_m96__nf1_gboth_sdfull_ng
Xnfet_01v8_W1p4_L0p6_m96__nf1_gboth_sdfull_ng_158 x2_tail VSS_body VSS cmc nfet_01v8_W1p4_L0p6_m96__nf1_gboth_sdfull_ng
Xnfet_01v8_W1p4_L0p6_m96__nf1_gboth_sdfull_ng_147 x2_tail VSS_body VSS bias_a nfet_01v8_W1p4_L0p6_m96__nf1_gboth_sdfull_ng
Xnfet_01v8_W1p4_L0p6_m96__nf1_gboth_sdfull_ng_136 x2_tail VSS_body VSS cmc nfet_01v8_W1p4_L0p6_m96__nf1_gboth_sdfull_ng
Xnfet_01v8_W1p4_L0p6_m96__nf1_gboth_sdfull_ng_2 x2_tail VSS_body VSS cmc nfet_01v8_W1p4_L0p6_m96__nf1_gboth_sdfull_ng
Xnfet_01v8_W1p4_L0p6_m36__nf1_gboth_sdfull_ng_13 VSS_body VSS bias_a x2_m3d nfet_01v8_W1p4_L0p6_m36__nf1_gboth_sdfull_ng
Xnfet_01v8_W1p4_L0p6_m96__nf1_gboth_sdfull_ng_60 x2_tail VSS_body VSS bias_a nfet_01v8_W1p4_L0p6_m96__nf1_gboth_sdfull_ng
Xnfet_01v8_W1p4_L0p6_m36__nf1_gboth_sdfull_ng_24 VSS_body VSS bias_a x2_m3d nfet_01v8_W1p4_L0p6_m36__nf1_gboth_sdfull_ng
Xnfet_01v8_W1p4_L0p6_m96__nf1_gboth_sdfull_ng_71 x2_tail VSS_body VSS bias_a nfet_01v8_W1p4_L0p6_m96__nf1_gboth_sdfull_ng
Xnfet_01v8_W1p4_L0p6_m36__nf1_gboth_sdfull_ng_35 VSS_body VSS bias_a x2_m4d nfet_01v8_W1p4_L0p6_m36__nf1_gboth_sdfull_ng
Xnfet_01v8_W1p4_L0p6_m96__nf1_gboth_sdfull_ng_82 x2_tail VSS_body VSS cmc nfet_01v8_W1p4_L0p6_m96__nf1_gboth_sdfull_ng
Xnfet_01v8_W1p4_L0p6_m96__nf1_gboth_sdfull_ng_93 x2_tail VSS_body VSS bias_a nfet_01v8_W1p4_L0p6_m96__nf1_gboth_sdfull_ng
Xnfet_01v8_W1p4_L0p6_m36__nf1_gboth_sdfull_ng_46 VSS_body VSS bias_a x2_m4d nfet_01v8_W1p4_L0p6_m36__nf1_gboth_sdfull_ng
Xnfet_01v8_W1p4_L0p6_m36__nf1_gboth_sdfull_ng_68 VSS_body VSS bias_a x2_m4d nfet_01v8_W1p4_L0p6_m36__nf1_gboth_sdfull_ng
Xnfet_01v8_W1p4_L0p6_m36__nf1_gboth_sdfull_ng_57 VSS_body VSS bias_a x2_m4d nfet_01v8_W1p4_L0p6_m36__nf1_gboth_sdfull_ng
Xnfet_01v8_W1p4_L0p6_m96__nf1_gboth_sdfull_ng_3 x2_tail VSS_body VSS bias_a nfet_01v8_W1p4_L0p6_m96__nf1_gboth_sdfull_ng
Xnfet_01v8_W1p4_L0p6_m96__nf1_gboth_sdfull_ng_104 x2_tail VSS_body VSS bias_a nfet_01v8_W1p4_L0p6_m96__nf1_gboth_sdfull_ng
Xnfet_01v8_W1p4_L0p6_m96__nf1_gboth_sdfull_ng_115 x2_tail VSS_body VSS cmc nfet_01v8_W1p4_L0p6_m96__nf1_gboth_sdfull_ng
Xnfet_01v8_W1p4_L0p6_m96__nf1_gboth_sdfull_ng_126 x2_tail VSS_body VSS bias_a nfet_01v8_W1p4_L0p6_m96__nf1_gboth_sdfull_ng
Xnfet_01v8_W1p4_L0p6_m96__nf1_gboth_sdfull_ng_159 x2_tail VSS_body VSS bias_a nfet_01v8_W1p4_L0p6_m96__nf1_gboth_sdfull_ng
Xnfet_01v8_W1p4_L0p6_m96__nf1_gboth_sdfull_ng_148 x2_tail VSS_body VSS cmc nfet_01v8_W1p4_L0p6_m96__nf1_gboth_sdfull_ng
Xnfet_01v8_W1p4_L0p6_m96__nf1_gboth_sdfull_ng_137 x2_tail VSS_body VSS bias_a nfet_01v8_W1p4_L0p6_m96__nf1_gboth_sdfull_ng
Xnfet_01v8_W1p4_L0p6_m96__nf1_gboth_sdfull_ng_50 x2_tail VSS_body VSS bias_a nfet_01v8_W1p4_L0p6_m96__nf1_gboth_sdfull_ng
Xnfet_01v8_W1p4_L0p6_m96__nf1_gboth_sdfull_ng_61 x2_tail VSS_body VSS cmc nfet_01v8_W1p4_L0p6_m96__nf1_gboth_sdfull_ng
Xnfet_01v8_W1p4_L0p6_m96__nf1_gboth_sdfull_ng_72 x2_tail VSS_body VSS cmc nfet_01v8_W1p4_L0p6_m96__nf1_gboth_sdfull_ng
Xnfet_01v8_W1p4_L0p6_m96__nf1_gboth_sdfull_ng_83 x2_tail VSS_body VSS bias_a nfet_01v8_W1p4_L0p6_m96__nf1_gboth_sdfull_ng
Xnfet_01v8_W1p4_L0p6_m96__nf1_gboth_sdfull_ng_94 x2_tail VSS_body VSS cmc nfet_01v8_W1p4_L0p6_m96__nf1_gboth_sdfull_ng
Xnfet_01v8_W1p4_L0p6_m36__nf1_gboth_sdfull_ng_14 VSS_body VSS bias_a x2_m4d nfet_01v8_W1p4_L0p6_m36__nf1_gboth_sdfull_ng
Xnfet_01v8_W1p4_L0p6_m36__nf1_gboth_sdfull_ng_25 VSS_body VSS bias_a x2_m4d nfet_01v8_W1p4_L0p6_m36__nf1_gboth_sdfull_ng
Xnfet_01v8_W1p4_L0p6_m36__nf1_gboth_sdfull_ng_36 VSS_body VSS bias_a x2_m4d nfet_01v8_W1p4_L0p6_m36__nf1_gboth_sdfull_ng
Xnfet_01v8_W1p4_L0p6_m36__nf1_gboth_sdfull_ng_47 VSS_body VSS bias_a x2_m3d nfet_01v8_W1p4_L0p6_m36__nf1_gboth_sdfull_ng
Xnfet_01v8_W1p4_L0p6_m36__nf1_gboth_sdfull_ng_69 VSS_body VSS bias_a x2_m3d nfet_01v8_W1p4_L0p6_m36__nf1_gboth_sdfull_ng
Xnfet_01v8_W1p4_L0p6_m36__nf1_gboth_sdfull_ng_58 VSS_body VSS bias_a x2_m3d nfet_01v8_W1p4_L0p6_m36__nf1_gboth_sdfull_ng
Xnfet_01v8_W1p4_L0p6_m96__nf1_gboth_sdfull_ng_105 x2_tail VSS_body VSS cmc nfet_01v8_W1p4_L0p6_m96__nf1_gboth_sdfull_ng
Xnfet_01v8_W1p4_L0p6_m96__nf1_gboth_sdfull_ng_116 x2_tail VSS_body VSS bias_a nfet_01v8_W1p4_L0p6_m96__nf1_gboth_sdfull_ng
Xnfet_01v8_W1p4_L0p6_m96__nf1_gboth_sdfull_ng_127 x2_tail VSS_body VSS cmc nfet_01v8_W1p4_L0p6_m96__nf1_gboth_sdfull_ng
Xnfet_01v8_W1p4_L0p6_m96__nf1_gboth_sdfull_ng_149 x2_tail VSS_body VSS bias_a nfet_01v8_W1p4_L0p6_m96__nf1_gboth_sdfull_ng
Xnfet_01v8_W1p4_L0p6_m96__nf1_gboth_sdfull_ng_138 x2_tail VSS_body VSS cmc nfet_01v8_W1p4_L0p6_m96__nf1_gboth_sdfull_ng
Xnfet_01v8_W1p4_L0p6_m96__nf1_gboth_sdfull_ng_4 x2_tail VSS_body VSS cmc nfet_01v8_W1p4_L0p6_m96__nf1_gboth_sdfull_ng
Xnfet_01v8_W1p4_L0p6_m96__nf1_gboth_sdfull_ng_40 x2_tail VSS_body VSS bias_a nfet_01v8_W1p4_L0p6_m96__nf1_gboth_sdfull_ng
Xnfet_01v8_W1p4_L0p6_m96__nf1_gboth_sdfull_ng_51 x2_tail VSS_body VSS cmc nfet_01v8_W1p4_L0p6_m96__nf1_gboth_sdfull_ng
Xnfet_01v8_W1p4_L0p6_m96__nf1_gboth_sdfull_ng_62 x2_tail VSS_body VSS bias_a nfet_01v8_W1p4_L0p6_m96__nf1_gboth_sdfull_ng
Xnfet_01v8_W1p4_L0p6_m96__nf1_gboth_sdfull_ng_73 x2_tail VSS_body VSS bias_a nfet_01v8_W1p4_L0p6_m96__nf1_gboth_sdfull_ng
Xnfet_01v8_W1p4_L0p6_m96__nf1_gboth_sdfull_ng_84 x2_tail VSS_body VSS cmc nfet_01v8_W1p4_L0p6_m96__nf1_gboth_sdfull_ng
Xnfet_01v8_W1p4_L0p6_m96__nf1_gboth_sdfull_ng_95 x2_tail VSS_body VSS bias_a nfet_01v8_W1p4_L0p6_m96__nf1_gboth_sdfull_ng
Xnfet_01v8_W1p4_L0p6_m36__nf1_gboth_sdfull_ng_15 VSS_body VSS bias_a x2_m3d nfet_01v8_W1p4_L0p6_m36__nf1_gboth_sdfull_ng
Xnfet_01v8_W1p4_L0p6_m36__nf1_gboth_sdfull_ng_26 VSS_body VSS bias_a x2_m3d nfet_01v8_W1p4_L0p6_m36__nf1_gboth_sdfull_ng
Xnfet_01v8_W1p4_L0p6_m36__nf1_gboth_sdfull_ng_37 VSS_body VSS bias_a x2_m3d nfet_01v8_W1p4_L0p6_m36__nf1_gboth_sdfull_ng
Xnfet_01v8_W1p4_L0p6_m36__nf1_gboth_sdfull_ng_59 VSS_body VSS bias_a x2_m4d nfet_01v8_W1p4_L0p6_m36__nf1_gboth_sdfull_ng
Xnfet_01v8_W1p4_L0p6_m36__nf1_gboth_sdfull_ng_48 VSS_body VSS bias_a x2_m3d nfet_01v8_W1p4_L0p6_m36__nf1_gboth_sdfull_ng
Xnfet_01v8_W1p4_L0p6_m96__nf1_gboth_sdfull_ng_5 x2_tail VSS_body VSS bias_a nfet_01v8_W1p4_L0p6_m96__nf1_gboth_sdfull_ng
Xnfet_01v8_W1p4_L0p6_m96__nf1_gboth_sdfull_ng_106 x2_tail VSS_body VSS bias_a nfet_01v8_W1p4_L0p6_m96__nf1_gboth_sdfull_ng
Xnfet_01v8_W1p4_L0p6_m96__nf1_gboth_sdfull_ng_117 x2_tail VSS_body VSS cmc nfet_01v8_W1p4_L0p6_m96__nf1_gboth_sdfull_ng
Xnfet_01v8_W1p4_L0p6_m96__nf1_gboth_sdfull_ng_139 x2_tail VSS_body VSS bias_a nfet_01v8_W1p4_L0p6_m96__nf1_gboth_sdfull_ng
Xnfet_01v8_W1p4_L0p6_m96__nf1_gboth_sdfull_ng_128 x2_tail VSS_body VSS cmc nfet_01v8_W1p4_L0p6_m96__nf1_gboth_sdfull_ng
Xnfet_01v8_W1p4_L0p6_m6__nf1_gtop_sdfull_ng_0 VSS_body x2_tail x2_tail x2_tail nfet_01v8_W1p4_L0p6_m6__nf1_gtop_sdfull_ng
Xnfet_01v8_W1p4_L0p6_m96__nf1_gboth_sdfull_ng_30 x2_tail VSS_body VSS cmc nfet_01v8_W1p4_L0p6_m96__nf1_gboth_sdfull_ng
Xnfet_01v8_W1p4_L0p6_m96__nf1_gboth_sdfull_ng_41 x2_tail VSS_body VSS cmc nfet_01v8_W1p4_L0p6_m96__nf1_gboth_sdfull_ng
Xnfet_01v8_W1p4_L0p6_m96__nf1_gboth_sdfull_ng_52 x2_tail VSS_body VSS bias_a nfet_01v8_W1p4_L0p6_m96__nf1_gboth_sdfull_ng
Xnfet_01v8_W1p4_L0p6_m36__nf1_gboth_sdfull_ng_16 VSS_body VSS bias_a x2_m4d nfet_01v8_W1p4_L0p6_m36__nf1_gboth_sdfull_ng
Xnfet_01v8_W1p4_L0p6_m96__nf1_gboth_sdfull_ng_63 x2_tail VSS_body VSS cmc nfet_01v8_W1p4_L0p6_m96__nf1_gboth_sdfull_ng
Xnfet_01v8_W1p4_L0p6_m36__nf1_gboth_sdfull_ng_27 VSS_body VSS bias_a x2_m4d nfet_01v8_W1p4_L0p6_m36__nf1_gboth_sdfull_ng
Xnfet_01v8_W1p4_L0p6_m96__nf1_gboth_sdfull_ng_74 x2_tail VSS_body VSS cmc nfet_01v8_W1p4_L0p6_m96__nf1_gboth_sdfull_ng
Xnfet_01v8_W1p4_L0p6_m96__nf1_gboth_sdfull_ng_85 x2_tail VSS_body VSS bias_a nfet_01v8_W1p4_L0p6_m96__nf1_gboth_sdfull_ng
Xnfet_01v8_W1p4_L0p6_m96__nf1_gboth_sdfull_ng_96 x2_tail VSS_body VSS bias_a nfet_01v8_W1p4_L0p6_m96__nf1_gboth_sdfull_ng
Xnfet_01v8_W1p4_L0p6_m36__nf1_gboth_sdfull_ng_38 VSS_body VSS bias_a x2_m4d nfet_01v8_W1p4_L0p6_m36__nf1_gboth_sdfull_ng
Xnfet_01v8_W1p4_L0p6_m36__nf1_gboth_sdfull_ng_49 VSS_body VSS bias_a x2_m4d nfet_01v8_W1p4_L0p6_m36__nf1_gboth_sdfull_ng
Xnfet_01v8_W1p4_L0p6_m96__nf1_gboth_sdfull_ng_6 x2_tail VSS_body VSS cmc nfet_01v8_W1p4_L0p6_m96__nf1_gboth_sdfull_ng
Xnfet_01v8_W1p4_L0p6_m96__nf1_gboth_sdfull_ng_107 x2_tail VSS_body VSS cmc nfet_01v8_W1p4_L0p6_m96__nf1_gboth_sdfull_ng
Xnfet_01v8_W1p4_L0p6_m96__nf1_gboth_sdfull_ng_118 x2_tail VSS_body VSS bias_a nfet_01v8_W1p4_L0p6_m96__nf1_gboth_sdfull_ng
Xnfet_01v8_W1p4_L0p6_m96__nf1_gboth_sdfull_ng_129 x2_tail VSS_body VSS bias_a nfet_01v8_W1p4_L0p6_m96__nf1_gboth_sdfull_ng
Xnfet_01v8_W1p4_L0p6_m6__nf1_gtop_sdfull_ng_1 VSS_body VSS x2_m4d VSS nfet_01v8_W1p4_L0p6_m6__nf1_gtop_sdfull_ng
Xnfet_01v8_W1p4_L0p6_m96__nf1_gboth_sdfull_ng_20 x2_tail VSS_body VSS cmc nfet_01v8_W1p4_L0p6_m96__nf1_gboth_sdfull_ng
Xnfet_01v8_W1p4_L0p6_m96__nf1_gboth_sdfull_ng_31 x2_tail VSS_body VSS bias_a nfet_01v8_W1p4_L0p6_m96__nf1_gboth_sdfull_ng
Xnfet_01v8_W1p4_L0p6_m96__nf1_gboth_sdfull_ng_42 x2_tail VSS_body VSS bias_a nfet_01v8_W1p4_L0p6_m96__nf1_gboth_sdfull_ng
Xnfet_01v8_W1p4_L0p6_m96__nf1_gboth_sdfull_ng_53 x2_tail VSS_body VSS cmc nfet_01v8_W1p4_L0p6_m96__nf1_gboth_sdfull_ng
Xnfet_01v8_W1p4_L0p6_m96__nf1_gboth_sdfull_ng_64 x2_tail VSS_body VSS cmc nfet_01v8_W1p4_L0p6_m96__nf1_gboth_sdfull_ng
Xnfet_01v8_W1p4_L0p6_m96__nf1_gboth_sdfull_ng_75 x2_tail VSS_body VSS bias_a nfet_01v8_W1p4_L0p6_m96__nf1_gboth_sdfull_ng
Xnfet_01v8_W1p4_L0p6_m96__nf1_gboth_sdfull_ng_86 x2_tail VSS_body VSS cmc nfet_01v8_W1p4_L0p6_m96__nf1_gboth_sdfull_ng
Xnfet_01v8_W1p4_L0p6_m96__nf1_gboth_sdfull_ng_97 x2_tail VSS_body VSS cmc nfet_01v8_W1p4_L0p6_m96__nf1_gboth_sdfull_ng
Xnfet_01v8_W1p4_L0p6_m36__nf1_gboth_sdfull_ng_17 VSS_body VSS bias_a x2_m3d nfet_01v8_W1p4_L0p6_m36__nf1_gboth_sdfull_ng
Xnfet_01v8_W1p4_L0p6_m36__nf1_gboth_sdfull_ng_28 VSS_body VSS bias_a x2_m3d nfet_01v8_W1p4_L0p6_m36__nf1_gboth_sdfull_ng
Xnfet_01v8_W1p4_L0p6_m36__nf1_gboth_sdfull_ng_39 VSS_body VSS bias_a x2_m3d nfet_01v8_W1p4_L0p6_m36__nf1_gboth_sdfull_ng
Xnfet_01v8_W1p4_L0p6_m96__nf1_gboth_sdfull_ng_108 x2_tail VSS_body VSS bias_a nfet_01v8_W1p4_L0p6_m96__nf1_gboth_sdfull_ng
Xnfet_01v8_W1p4_L0p6_m96__nf1_gboth_sdfull_ng_119 x2_tail VSS_body VSS cmc nfet_01v8_W1p4_L0p6_m96__nf1_gboth_sdfull_ng
Xnfet_01v8_W1p4_L0p6_m96__nf1_gboth_sdfull_ng_7 x2_tail VSS_body VSS bias_a nfet_01v8_W1p4_L0p6_m96__nf1_gboth_sdfull_ng
Xnfet_01v8_W1p4_L0p6_m96__nf1_gboth_sdfull_ng_10 x2_tail VSS_body VSS cmc nfet_01v8_W1p4_L0p6_m96__nf1_gboth_sdfull_ng
Xnfet_01v8_W1p4_L0p6_m96__nf1_gboth_sdfull_ng_21 x2_tail VSS_body VSS bias_a nfet_01v8_W1p4_L0p6_m96__nf1_gboth_sdfull_ng
Xnfet_01v8_W1p4_L0p6_m6__nf1_gtop_sdfull_ng_2 VSS_body x2_tail x2_tail x2_tail nfet_01v8_W1p4_L0p6_m6__nf1_gtop_sdfull_ng
Xnfet_01v8_W1p4_L0p6_m96__nf1_gboth_sdfull_ng_32 x2_tail VSS_body VSS bias_a nfet_01v8_W1p4_L0p6_m96__nf1_gboth_sdfull_ng
Xnfet_01v8_W1p4_L0p6_m96__nf1_gboth_sdfull_ng_43 x2_tail VSS_body VSS cmc nfet_01v8_W1p4_L0p6_m96__nf1_gboth_sdfull_ng
Xnfet_01v8_W1p4_L0p6_m96__nf1_gboth_sdfull_ng_54 x2_tail VSS_body VSS bias_a nfet_01v8_W1p4_L0p6_m96__nf1_gboth_sdfull_ng
Xnfet_01v8_W1p4_L0p6_m36__nf1_gboth_sdfull_ng_18 VSS_body VSS bias_a x2_m4d nfet_01v8_W1p4_L0p6_m36__nf1_gboth_sdfull_ng
Xnfet_01v8_W1p4_L0p6_m96__nf1_gboth_sdfull_ng_65 x2_tail VSS_body VSS bias_a nfet_01v8_W1p4_L0p6_m96__nf1_gboth_sdfull_ng
Xnfet_01v8_W1p4_L0p6_m36__nf1_gboth_sdfull_ng_29 VSS_body VSS bias_a x2_m4d nfet_01v8_W1p4_L0p6_m36__nf1_gboth_sdfull_ng
Xnfet_01v8_W1p4_L0p6_m96__nf1_gboth_sdfull_ng_76 x2_tail VSS_body VSS cmc nfet_01v8_W1p4_L0p6_m96__nf1_gboth_sdfull_ng
Xnfet_01v8_W1p4_L0p6_m96__nf1_gboth_sdfull_ng_87 x2_tail VSS_body VSS bias_a nfet_01v8_W1p4_L0p6_m96__nf1_gboth_sdfull_ng
Xnfet_01v8_W1p4_L0p6_m96__nf1_gboth_sdfull_ng_98 x2_tail VSS_body VSS bias_a nfet_01v8_W1p4_L0p6_m96__nf1_gboth_sdfull_ng
Xnfet_01v8_W1p4_L0p6_m96__nf1_gboth_sdfull_ng_8 x2_tail VSS_body VSS cmc nfet_01v8_W1p4_L0p6_m96__nf1_gboth_sdfull_ng
Xnfet_01v8_W1p4_L0p6_m96__nf1_gboth_sdfull_ng_109 x2_tail VSS_body VSS cmc nfet_01v8_W1p4_L0p6_m96__nf1_gboth_sdfull_ng
Xnfet_01v8_W1p4_L0p6_m96__nf1_gboth_sdfull_ng_11 x2_tail VSS_body VSS bias_a nfet_01v8_W1p4_L0p6_m96__nf1_gboth_sdfull_ng
Xnfet_01v8_W1p4_L0p6_m96__nf1_gboth_sdfull_ng_22 x2_tail VSS_body VSS cmc nfet_01v8_W1p4_L0p6_m96__nf1_gboth_sdfull_ng
Xnfet_01v8_W1p4_L0p6_m6__nf1_gtop_sdfull_ng_3 VSS_body VSS x2_m4d VSS nfet_01v8_W1p4_L0p6_m6__nf1_gtop_sdfull_ng
Xnfet_01v8_W1p4_L0p6_m96__nf1_gboth_sdfull_ng_33 x2_tail VSS_body VSS cmc nfet_01v8_W1p4_L0p6_m96__nf1_gboth_sdfull_ng
Xnfet_01v8_W1p4_L0p6_m96__nf1_gboth_sdfull_ng_44 x2_tail VSS_body VSS bias_a nfet_01v8_W1p4_L0p6_m96__nf1_gboth_sdfull_ng
Xnfet_01v8_W1p4_L0p6_m96__nf1_gboth_sdfull_ng_55 x2_tail VSS_body VSS cmc nfet_01v8_W1p4_L0p6_m96__nf1_gboth_sdfull_ng
Xnfet_01v8_W1p4_L0p6_m96__nf1_gboth_sdfull_ng_66 x2_tail VSS_body VSS cmc nfet_01v8_W1p4_L0p6_m96__nf1_gboth_sdfull_ng
Xnfet_01v8_W1p4_L0p6_m96__nf1_gboth_sdfull_ng_77 x2_tail VSS_body VSS bias_a nfet_01v8_W1p4_L0p6_m96__nf1_gboth_sdfull_ng
Xnfet_01v8_W1p4_L0p6_m96__nf1_gboth_sdfull_ng_88 x2_tail VSS_body VSS cmc nfet_01v8_W1p4_L0p6_m96__nf1_gboth_sdfull_ng
Xnfet_01v8_W1p4_L0p6_m96__nf1_gboth_sdfull_ng_99 x2_tail VSS_body VSS cmc nfet_01v8_W1p4_L0p6_m96__nf1_gboth_sdfull_ng
Xnfet_01v8_W1p4_L0p6_m36__nf1_gboth_sdfull_ng_19 VSS_body VSS bias_a x2_m3d nfet_01v8_W1p4_L0p6_m36__nf1_gboth_sdfull_ng
Xnfet_01v8_W1p4_L0p6_m96__nf1_gboth_sdfull_ng_9 x2_tail VSS_body VSS bias_a nfet_01v8_W1p4_L0p6_m96__nf1_gboth_sdfull_ng
Xnfet_01v8_W1p4_L0p6_m96__nf1_gboth_sdfull_ng_12 x2_tail VSS_body VSS cmc nfet_01v8_W1p4_L0p6_m96__nf1_gboth_sdfull_ng
Xnfet_01v8_W1p4_L0p6_m96__nf1_gboth_sdfull_ng_23 x2_tail VSS_body VSS bias_a nfet_01v8_W1p4_L0p6_m96__nf1_gboth_sdfull_ng
Xnfet_01v8_W1p4_L0p6_m6__nf1_gtop_sdfull_ng_4 VSS_body x2_tail x2_tail x2_tail nfet_01v8_W1p4_L0p6_m6__nf1_gtop_sdfull_ng
Xnfet_01v8_W1p4_L0p6_m96__nf1_gboth_sdfull_ng_34 x2_tail VSS_body VSS bias_a nfet_01v8_W1p4_L0p6_m96__nf1_gboth_sdfull_ng
Xnfet_01v8_W1p4_L0p6_m96__nf1_gboth_sdfull_ng_45 x2_tail VSS_body VSS cmc nfet_01v8_W1p4_L0p6_m96__nf1_gboth_sdfull_ng
Xnfet_01v8_W1p4_L0p6_m96__nf1_gboth_sdfull_ng_56 x2_tail VSS_body VSS bias_a nfet_01v8_W1p4_L0p6_m96__nf1_gboth_sdfull_ng
Xnfet_01v8_W1p4_L0p6_m96__nf1_gboth_sdfull_ng_67 x2_tail VSS_body VSS bias_a nfet_01v8_W1p4_L0p6_m96__nf1_gboth_sdfull_ng
Xnfet_01v8_W1p4_L0p6_m96__nf1_gboth_sdfull_ng_78 x2_tail VSS_body VSS cmc nfet_01v8_W1p4_L0p6_m96__nf1_gboth_sdfull_ng
Xnfet_01v8_W1p4_L0p6_m96__nf1_gboth_sdfull_ng_89 x2_tail VSS_body VSS bias_a nfet_01v8_W1p4_L0p6_m96__nf1_gboth_sdfull_ng
Xnfet_01v8_W1p4_L0p6_m96__nf1_gboth_sdfull_ng_13 x2_tail VSS_body VSS bias_a nfet_01v8_W1p4_L0p6_m96__nf1_gboth_sdfull_ng
Xnfet_01v8_W1p4_L0p6_m96__nf1_gboth_sdfull_ng_24 x2_tail VSS_body VSS cmc nfet_01v8_W1p4_L0p6_m96__nf1_gboth_sdfull_ng
Xnfet_01v8_W1p4_L0p6_m96__nf1_gboth_sdfull_ng_35 x2_tail VSS_body VSS cmc nfet_01v8_W1p4_L0p6_m96__nf1_gboth_sdfull_ng
Xnfet_01v8_W1p4_L0p6_m96__nf1_gboth_sdfull_ng_46 x2_tail VSS_body VSS bias_a nfet_01v8_W1p4_L0p6_m96__nf1_gboth_sdfull_ng
Xnfet_01v8_W1p4_L0p6_m96__nf1_gboth_sdfull_ng_57 x2_tail VSS_body VSS cmc nfet_01v8_W1p4_L0p6_m96__nf1_gboth_sdfull_ng
Xnfet_01v8_W1p4_L0p6_m6__nf1_gtop_sdfull_ng_5 VSS_body x2_tail x2_tail x2_tail nfet_01v8_W1p4_L0p6_m6__nf1_gtop_sdfull_ng
Xnfet_01v8_W1p4_L0p6_m96__nf1_gboth_sdfull_ng_68 x2_tail VSS_body VSS cmc nfet_01v8_W1p4_L0p6_m96__nf1_gboth_sdfull_ng
Xnfet_01v8_W1p4_L0p6_m96__nf1_gboth_sdfull_ng_79 x2_tail VSS_body VSS bias_a nfet_01v8_W1p4_L0p6_m96__nf1_gboth_sdfull_ng
Xnfet_01v8_W1p4_L0p6_m96__nf1_gboth_sdfull_ng_14 x2_tail VSS_body VSS cmc nfet_01v8_W1p4_L0p6_m96__nf1_gboth_sdfull_ng
Xnfet_01v8_W1p4_L0p6_m96__nf1_gboth_sdfull_ng_25 x2_tail VSS_body VSS bias_a nfet_01v8_W1p4_L0p6_m96__nf1_gboth_sdfull_ng
Xnfet_01v8_W1p4_L0p6_m96__nf1_gboth_sdfull_ng_36 x2_tail VSS_body VSS bias_a nfet_01v8_W1p4_L0p6_m96__nf1_gboth_sdfull_ng
Xnfet_01v8_W1p4_L0p6_m96__nf1_gboth_sdfull_ng_47 x2_tail VSS_body VSS cmc nfet_01v8_W1p4_L0p6_m96__nf1_gboth_sdfull_ng
Xnfet_01v8_W1p4_L0p6_m96__nf1_gboth_sdfull_ng_58 x2_tail VSS_body VSS bias_a nfet_01v8_W1p4_L0p6_m96__nf1_gboth_sdfull_ng
Xnfet_01v8_W1p4_L0p6_m6__nf1_gtop_sdfull_ng_6 VSS_body x2_tail x2_tail x2_tail nfet_01v8_W1p4_L0p6_m6__nf1_gtop_sdfull_ng
Xnfet_01v8_W1p4_L0p6_m96__nf1_gboth_sdfull_ng_69 x2_tail VSS_body VSS bias_a nfet_01v8_W1p4_L0p6_m96__nf1_gboth_sdfull_ng
Xnfet_01v8_W1p4_L0p6_m96__nf1_gboth_sdfull_ng_15 x2_tail VSS_body VSS bias_a nfet_01v8_W1p4_L0p6_m96__nf1_gboth_sdfull_ng
Xnfet_01v8_W1p4_L0p6_m96__nf1_gboth_sdfull_ng_26 x2_tail VSS_body VSS cmc nfet_01v8_W1p4_L0p6_m96__nf1_gboth_sdfull_ng
Xnfet_01v8_W1p4_L0p6_m96__nf1_gboth_sdfull_ng_37 x2_tail VSS_body VSS cmc nfet_01v8_W1p4_L0p6_m96__nf1_gboth_sdfull_ng
Xnfet_01v8_W1p4_L0p6_m96__nf1_gboth_sdfull_ng_48 x2_tail VSS_body VSS bias_a nfet_01v8_W1p4_L0p6_m96__nf1_gboth_sdfull_ng
Xnfet_01v8_W1p4_L0p6_m96__nf1_gboth_sdfull_ng_59 x2_tail VSS_body VSS cmc nfet_01v8_W1p4_L0p6_m96__nf1_gboth_sdfull_ng
Xnfet_01v8_W1p4_L0p6_m6__nf1_gtop_sdfull_ng_7 VSS_body x2_tail x2_tail x2_tail nfet_01v8_W1p4_L0p6_m6__nf1_gtop_sdfull_ng
Xnfet_01v8_W1p4_L0p6_m96__nf1_gboth_sdfull_ng_16 x2_tail VSS_body VSS cmc nfet_01v8_W1p4_L0p6_m96__nf1_gboth_sdfull_ng
Xnfet_01v8_W1p4_L0p6_m96__nf1_gboth_sdfull_ng_27 x2_tail VSS_body VSS bias_a nfet_01v8_W1p4_L0p6_m96__nf1_gboth_sdfull_ng
Xnfet_01v8_W1p4_L0p6_m96__nf1_gboth_sdfull_ng_38 x2_tail VSS_body VSS bias_a nfet_01v8_W1p4_L0p6_m96__nf1_gboth_sdfull_ng
Xnfet_01v8_W1p4_L0p6_m96__nf1_gboth_sdfull_ng_49 x2_tail VSS_body VSS cmc nfet_01v8_W1p4_L0p6_m96__nf1_gboth_sdfull_ng
Xnfet_01v8_W1p4_L0p6_m6__nf1_gtop_sdfull_ng_8 VSS_body VSS x2_m4d VSS nfet_01v8_W1p4_L0p6_m6__nf1_gtop_sdfull_ng
Xnfet_01v8_W1p4_L0p6_m96__nf1_gboth_sdfull_ng_17 x2_tail VSS_body VSS bias_a nfet_01v8_W1p4_L0p6_m96__nf1_gboth_sdfull_ng
Xnfet_01v8_W1p4_L0p6_m96__nf1_gboth_sdfull_ng_28 x2_tail VSS_body VSS cmc nfet_01v8_W1p4_L0p6_m96__nf1_gboth_sdfull_ng
Xnfet_01v8_W1p4_L0p6_m96__nf1_gboth_sdfull_ng_39 x2_tail VSS_body VSS cmc nfet_01v8_W1p4_L0p6_m96__nf1_gboth_sdfull_ng
Xnfet_01v8_W1p4_L0p6_m6__nf1_gtop_sdfull_ng_9 VSS_body VSS x2_m4d VSS nfet_01v8_W1p4_L0p6_m6__nf1_gtop_sdfull_ng
Xnfet_01v8_W1p4_L0p6_m96__nf1_gboth_sdfull_ng_18 x2_tail VSS_body VSS cmc nfet_01v8_W1p4_L0p6_m96__nf1_gboth_sdfull_ng
Xnfet_01v8_W1p4_L0p6_m96__nf1_gboth_sdfull_ng_29 x2_tail VSS_body VSS bias_a nfet_01v8_W1p4_L0p6_m96__nf1_gboth_sdfull_ng
Xnfet_01v8_W1p4_L0p6_m96__nf1_gboth_sdfull_ng_19 x2_tail VSS_body VSS bias_a nfet_01v8_W1p4_L0p6_m96__nf1_gboth_sdfull_ng
Xnfet_01v8_W1p4_L0p6_m36__nf1_gboth_sdfull_ng_0 VSS_body VSS bias_a x2_m3d nfet_01v8_W1p4_L0p6_m36__nf1_gboth_sdfull_ng
Xnfet_01v8_W1p4_L0p6_m36__nf1_gboth_sdfull_ng_1 VSS_body VSS bias_a x2_m4d nfet_01v8_W1p4_L0p6_m36__nf1_gboth_sdfull_ng
Xnfet_01v8_W1p4_L0p6_m6__nf1_gtop_sdfull_ng_10 VSS_body VSS VSS VSS nfet_01v8_W1p4_L0p6_m6__nf1_gtop_sdfull_ng
Xnfet_01v8_W1p4_L0p6_m2__nf1_gboth_sdfull_ng_0 VSS_body VSS VSS x2_tail nfet_01v8_W1p4_L0p6_m2__nf1_gboth_sdfull_ng
Xnfet_01v8_W1p4_L0p6_m36__nf1_gboth_sdfull_ng_2 VSS_body VSS bias_a x2_m3d nfet_01v8_W1p4_L0p6_m36__nf1_gboth_sdfull_ng
Xnfet_01v8_W1p4_L0p6_m6__nf1_gtop_sdfull_ng_11 VSS_body VSS x2_m4d VSS nfet_01v8_W1p4_L0p6_m6__nf1_gtop_sdfull_ng
Xnfet_01v8_W1p4_L0p6_m36__nf1_gboth_sdfull_ng_3 VSS_body VSS bias_a x2_m4d nfet_01v8_W1p4_L0p6_m36__nf1_gboth_sdfull_ng
Xnfet_01v8_W1p4_L0p6_m2__nf1_gboth_sdfull_ng_1 VSS_body VSS VSS x2_tail nfet_01v8_W1p4_L0p6_m2__nf1_gboth_sdfull_ng
Xnfet_01v8_W1p4_L0p6_m6__nf1_gtop_sdfull_ng_12 VSS_body VSS x2_m4d VSS nfet_01v8_W1p4_L0p6_m6__nf1_gtop_sdfull_ng
Xnfet_01v8_W1p4_L0p6_m36__nf1_gboth_sdfull_ng_4 VSS_body VSS bias_a x2_m3d nfet_01v8_W1p4_L0p6_m36__nf1_gboth_sdfull_ng
Xnfet_01v8_W1p4_L0p6_m6__nf1_gtop_sdfull_ng_13 VSS_body VSS VSS VSS nfet_01v8_W1p4_L0p6_m6__nf1_gtop_sdfull_ng
Xnfet_01v8_W1p4_L0p6_m36__nf1_gboth_sdfull_ng_5 VSS_body VSS bias_a x2_m4d nfet_01v8_W1p4_L0p6_m36__nf1_gboth_sdfull_ng
Xnfet_01v8_W1p4_L0p6_m36__nf1_gboth_sdfull_ng_6 VSS_body VSS bias_a x2_m3d nfet_01v8_W1p4_L0p6_m36__nf1_gboth_sdfull_ng
Xnfet_01v8_W1p4_L0p6_m96__nf1_gboth_sdfull_ng_190 x2_tail VSS_body VSS bias_a nfet_01v8_W1p4_L0p6_m96__nf1_gboth_sdfull_ng
Xnfet_01v8_W1p4_L0p6_m36__nf1_gboth_sdfull_ng_7 VSS_body VSS bias_a x2_m4d nfet_01v8_W1p4_L0p6_m36__nf1_gboth_sdfull_ng
Xnfet_01v8_W1p4_L0p6_m96__nf1_gboth_sdfull_ng_191 x2_tail VSS_body VSS cmc nfet_01v8_W1p4_L0p6_m96__nf1_gboth_sdfull_ng
Xnfet_01v8_W1p4_L0p6_m96__nf1_gboth_sdfull_ng_180 x2_tail VSS_body VSS bias_a nfet_01v8_W1p4_L0p6_m96__nf1_gboth_sdfull_ng
Xnfet_01v8_W1p4_L0p6_m8__nf1_gtop_sdfull_ng_0 VSS_body VSS VSS x2_m3d nfet_01v8_W1p4_L0p6_m8__nf1_gtop_sdfull_ng
Xnfet_01v8_W1p4_L0p6_m36__nf1_gboth_sdfull_ng_8 VSS_body VSS bias_a x2_m3d nfet_01v8_W1p4_L0p6_m36__nf1_gboth_sdfull_ng
Xnfet_01v8_W1p4_L0p6_m96__nf1_gboth_sdfull_ng_181 x2_tail VSS_body VSS cmc nfet_01v8_W1p4_L0p6_m96__nf1_gboth_sdfull_ng
Xnfet_01v8_W1p4_L0p6_m96__nf1_gboth_sdfull_ng_170 x2_tail VSS_body VSS bias_a nfet_01v8_W1p4_L0p6_m96__nf1_gboth_sdfull_ng
Xnfet_01v8_W1p4_L0p6_m8__nf1_gtop_sdfull_ng_1 VSS_body VSS VSS x2_m3d nfet_01v8_W1p4_L0p6_m8__nf1_gtop_sdfull_ng
Xnfet_01v8_W1p4_L0p6_m36__nf1_gboth_sdfull_ng_9 VSS_body VSS bias_a x2_m4d nfet_01v8_W1p4_L0p6_m36__nf1_gboth_sdfull_ng
Xnfet_01v8_W1p4_L0p6_m96__nf1_gboth_sdfull_ng_182 x2_tail VSS_body VSS bias_a nfet_01v8_W1p4_L0p6_m96__nf1_gboth_sdfull_ng
Xnfet_01v8_W1p4_L0p6_m96__nf1_gboth_sdfull_ng_171 x2_tail VSS_body VSS cmc nfet_01v8_W1p4_L0p6_m96__nf1_gboth_sdfull_ng
Xnfet_01v8_W1p4_L0p6_m96__nf1_gboth_sdfull_ng_160 x2_tail VSS_body VSS bias_a nfet_01v8_W1p4_L0p6_m96__nf1_gboth_sdfull_ng
Xnfet_01v8_W1p4_L0p6_m36__nf1_gboth_sdfull_ng_70 VSS_body VSS bias_a x2_m4d nfet_01v8_W1p4_L0p6_m36__nf1_gboth_sdfull_ng
Xnfet_01v8_W1p4_L0p6_m8__nf1_gtop_sdfull_ng_2 VSS_body VSS VSS x2_m3d nfet_01v8_W1p4_L0p6_m8__nf1_gtop_sdfull_ng
Xnfet_01v8_W1p4_L0p6_m96__nf1_gboth_sdfull_ng_183 x2_tail VSS_body VSS cmc nfet_01v8_W1p4_L0p6_m96__nf1_gboth_sdfull_ng
Xnfet_01v8_W1p4_L0p6_m96__nf1_gboth_sdfull_ng_172 x2_tail VSS_body VSS bias_a nfet_01v8_W1p4_L0p6_m96__nf1_gboth_sdfull_ng
Xnfet_01v8_W1p4_L0p6_m96__nf1_gboth_sdfull_ng_161 x2_tail VSS_body VSS cmc nfet_01v8_W1p4_L0p6_m96__nf1_gboth_sdfull_ng
Xnfet_01v8_W1p4_L0p6_m96__nf1_gboth_sdfull_ng_150 x2_tail VSS_body VSS cmc nfet_01v8_W1p4_L0p6_m96__nf1_gboth_sdfull_ng
Xnfet_01v8_W1p4_L0p6_m8__nf1_gtop_sdfull_ng_3 VSS_body VSS VSS x2_m3d nfet_01v8_W1p4_L0p6_m8__nf1_gtop_sdfull_ng
Xnfet_01v8_W1p4_L0p6_m36__nf1_gboth_sdfull_ng_71 VSS_body VSS bias_a x2_m3d nfet_01v8_W1p4_L0p6_m36__nf1_gboth_sdfull_ng
Xnfet_01v8_W1p4_L0p6_m36__nf1_gboth_sdfull_ng_60 VSS_body VSS bias_a x2_m4d nfet_01v8_W1p4_L0p6_m36__nf1_gboth_sdfull_ng
Xnfet_01v8_W1p4_L0p6_m96__nf1_gboth_sdfull_ng_184 x2_tail VSS_body VSS bias_a nfet_01v8_W1p4_L0p6_m96__nf1_gboth_sdfull_ng
Xnfet_01v8_W1p4_L0p6_m96__nf1_gboth_sdfull_ng_173 x2_tail VSS_body VSS cmc nfet_01v8_W1p4_L0p6_m96__nf1_gboth_sdfull_ng
Xnfet_01v8_W1p4_L0p6_m96__nf1_gboth_sdfull_ng_162 x2_tail VSS_body VSS bias_a nfet_01v8_W1p4_L0p6_m96__nf1_gboth_sdfull_ng
Xnfet_01v8_W1p4_L0p6_m96__nf1_gboth_sdfull_ng_151 x2_tail VSS_body VSS bias_a nfet_01v8_W1p4_L0p6_m96__nf1_gboth_sdfull_ng
Xnfet_01v8_W1p4_L0p6_m96__nf1_gboth_sdfull_ng_140 x2_tail VSS_body VSS cmc nfet_01v8_W1p4_L0p6_m96__nf1_gboth_sdfull_ng
Xnfet_01v8_W1p4_L0p6_m8__nf1_gtop_sdfull_ng_4 VSS_body VSS VSS x2_m3d nfet_01v8_W1p4_L0p6_m8__nf1_gtop_sdfull_ng
Xnfet_01v8_W1p4_L0p6_m36__nf1_gboth_sdfull_ng_61 VSS_body VSS bias_a x2_m3d nfet_01v8_W1p4_L0p6_m36__nf1_gboth_sdfull_ng
Xnfet_01v8_W1p4_L0p6_m36__nf1_gboth_sdfull_ng_50 VSS_body VSS bias_a x2_m3d nfet_01v8_W1p4_L0p6_m36__nf1_gboth_sdfull_ng
Xnfet_01v8_W1p4_L0p6_m96__nf1_gboth_sdfull_ng_185 x2_tail VSS_body VSS cmc nfet_01v8_W1p4_L0p6_m96__nf1_gboth_sdfull_ng
Xnfet_01v8_W1p4_L0p6_m96__nf1_gboth_sdfull_ng_174 x2_tail VSS_body VSS bias_a nfet_01v8_W1p4_L0p6_m96__nf1_gboth_sdfull_ng
Xnfet_01v8_W1p4_L0p6_m96__nf1_gboth_sdfull_ng_163 x2_tail VSS_body VSS cmc nfet_01v8_W1p4_L0p6_m96__nf1_gboth_sdfull_ng
Xnfet_01v8_W1p4_L0p6_m96__nf1_gboth_sdfull_ng_152 x2_tail VSS_body VSS cmc nfet_01v8_W1p4_L0p6_m96__nf1_gboth_sdfull_ng
Xnfet_01v8_W1p4_L0p6_m96__nf1_gboth_sdfull_ng_141 x2_tail VSS_body VSS bias_a nfet_01v8_W1p4_L0p6_m96__nf1_gboth_sdfull_ng
Xnfet_01v8_W1p4_L0p6_m96__nf1_gboth_sdfull_ng_130 x2_tail VSS_body VSS cmc nfet_01v8_W1p4_L0p6_m96__nf1_gboth_sdfull_ng
Xnfet_01v8_W1p4_L0p6_m36__nf1_gboth_sdfull_ng_40 VSS_body VSS bias_a x2_m4d nfet_01v8_W1p4_L0p6_m36__nf1_gboth_sdfull_ng
Xnfet_01v8_W1p4_L0p6_m8__nf1_gtop_sdfull_ng_5 VSS_body VSS VSS x2_m3d nfet_01v8_W1p4_L0p6_m8__nf1_gtop_sdfull_ng
Xnfet_01v8_W1p4_L0p6_m36__nf1_gboth_sdfull_ng_62 VSS_body VSS bias_a x2_m4d nfet_01v8_W1p4_L0p6_m36__nf1_gboth_sdfull_ng
Xnfet_01v8_W1p4_L0p6_m36__nf1_gboth_sdfull_ng_51 VSS_body VSS bias_a x2_m4d nfet_01v8_W1p4_L0p6_m36__nf1_gboth_sdfull_ng
Xnfet_01v8_W1p4_L0p6_m96__nf1_gboth_sdfull_ng_120 x2_tail VSS_body VSS bias_a nfet_01v8_W1p4_L0p6_m96__nf1_gboth_sdfull_ng
Xnfet_01v8_W1p4_L0p6_m96__nf1_gboth_sdfull_ng_186 x2_tail VSS_body VSS bias_a nfet_01v8_W1p4_L0p6_m96__nf1_gboth_sdfull_ng
Xnfet_01v8_W1p4_L0p6_m96__nf1_gboth_sdfull_ng_175 x2_tail VSS_body VSS cmc nfet_01v8_W1p4_L0p6_m96__nf1_gboth_sdfull_ng
Xnfet_01v8_W1p4_L0p6_m96__nf1_gboth_sdfull_ng_164 x2_tail VSS_body VSS bias_a nfet_01v8_W1p4_L0p6_m96__nf1_gboth_sdfull_ng
Xnfet_01v8_W1p4_L0p6_m96__nf1_gboth_sdfull_ng_153 x2_tail VSS_body VSS bias_a nfet_01v8_W1p4_L0p6_m96__nf1_gboth_sdfull_ng
Xnfet_01v8_W1p4_L0p6_m96__nf1_gboth_sdfull_ng_142 x2_tail VSS_body VSS cmc nfet_01v8_W1p4_L0p6_m96__nf1_gboth_sdfull_ng
Xnfet_01v8_W1p4_L0p6_m96__nf1_gboth_sdfull_ng_131 x2_tail VSS_body VSS bias_a nfet_01v8_W1p4_L0p6_m96__nf1_gboth_sdfull_ng
Xnfet_01v8_W1p4_L0p6_m36__nf1_gboth_sdfull_ng_30 VSS_body VSS bias_a x2_m3d nfet_01v8_W1p4_L0p6_m36__nf1_gboth_sdfull_ng
Xnfet_01v8_W1p4_L0p6_m36__nf1_gboth_sdfull_ng_41 VSS_body VSS bias_a x2_m3d nfet_01v8_W1p4_L0p6_m36__nf1_gboth_sdfull_ng
Xnfet_01v8_W1p4_L0p6_m36__nf1_gboth_sdfull_ng_63 VSS_body VSS bias_a x2_m3d nfet_01v8_W1p4_L0p6_m36__nf1_gboth_sdfull_ng
Xnfet_01v8_W1p4_L0p6_m36__nf1_gboth_sdfull_ng_52 VSS_body VSS bias_a x2_m3d nfet_01v8_W1p4_L0p6_m36__nf1_gboth_sdfull_ng
Xnfet_01v8_W1p4_L0p6_m8__nf1_gtop_sdfull_ng_6 VSS_body VSS VSS x2_m3d nfet_01v8_W1p4_L0p6_m8__nf1_gtop_sdfull_ng
Xnfet_01v8_W1p4_L0p6_m96__nf1_gboth_sdfull_ng_110 x2_tail VSS_body VSS bias_a nfet_01v8_W1p4_L0p6_m96__nf1_gboth_sdfull_ng
Xnfet_01v8_W1p4_L0p6_m96__nf1_gboth_sdfull_ng_121 x2_tail VSS_body VSS cmc nfet_01v8_W1p4_L0p6_m96__nf1_gboth_sdfull_ng
Xnfet_01v8_W1p4_L0p6_m96__nf1_gboth_sdfull_ng_187 x2_tail VSS_body VSS cmc nfet_01v8_W1p4_L0p6_m96__nf1_gboth_sdfull_ng
Xnfet_01v8_W1p4_L0p6_m96__nf1_gboth_sdfull_ng_176 x2_tail VSS_body VSS bias_a nfet_01v8_W1p4_L0p6_m96__nf1_gboth_sdfull_ng
Xnfet_01v8_W1p4_L0p6_m96__nf1_gboth_sdfull_ng_165 x2_tail VSS_body VSS cmc nfet_01v8_W1p4_L0p6_m96__nf1_gboth_sdfull_ng
Xnfet_01v8_W1p4_L0p6_m96__nf1_gboth_sdfull_ng_154 x2_tail VSS_body VSS cmc nfet_01v8_W1p4_L0p6_m96__nf1_gboth_sdfull_ng
Xnfet_01v8_W1p4_L0p6_m96__nf1_gboth_sdfull_ng_143 x2_tail VSS_body VSS bias_a nfet_01v8_W1p4_L0p6_m96__nf1_gboth_sdfull_ng
Xnfet_01v8_W1p4_L0p6_m96__nf1_gboth_sdfull_ng_132 x2_tail VSS_body VSS cmc nfet_01v8_W1p4_L0p6_m96__nf1_gboth_sdfull_ng
Xnfet_01v8_W1p4_L0p6_m36__nf1_gboth_sdfull_ng_20 VSS_body VSS bias_a x2_m4d nfet_01v8_W1p4_L0p6_m36__nf1_gboth_sdfull_ng
Xnfet_01v8_W1p4_L0p6_m36__nf1_gboth_sdfull_ng_31 VSS_body VSS bias_a x2_m4d nfet_01v8_W1p4_L0p6_m36__nf1_gboth_sdfull_ng
Xnfet_01v8_W1p4_L0p6_m36__nf1_gboth_sdfull_ng_42 VSS_body VSS bias_a x2_m4d nfet_01v8_W1p4_L0p6_m36__nf1_gboth_sdfull_ng
Xnfet_01v8_W1p4_L0p6_m36__nf1_gboth_sdfull_ng_64 VSS_body VSS bias_a x2_m4d nfet_01v8_W1p4_L0p6_m36__nf1_gboth_sdfull_ng
Xnfet_01v8_W1p4_L0p6_m8__nf1_gtop_sdfull_ng_7 VSS_body VSS VSS x2_m3d nfet_01v8_W1p4_L0p6_m8__nf1_gtop_sdfull_ng
Xnfet_01v8_W1p4_L0p6_m36__nf1_gboth_sdfull_ng_53 VSS_body VSS bias_a x2_m4d nfet_01v8_W1p4_L0p6_m36__nf1_gboth_sdfull_ng
Xnfet_01v8_W1p4_L0p6_m96__nf1_gboth_sdfull_ng_100 x2_tail VSS_body VSS bias_a nfet_01v8_W1p4_L0p6_m96__nf1_gboth_sdfull_ng
Xnfet_01v8_W1p4_L0p6_m96__nf1_gboth_sdfull_ng_111 x2_tail VSS_body VSS cmc nfet_01v8_W1p4_L0p6_m96__nf1_gboth_sdfull_ng
Xnfet_01v8_W1p4_L0p6_m96__nf1_gboth_sdfull_ng_122 x2_tail VSS_body VSS bias_a nfet_01v8_W1p4_L0p6_m96__nf1_gboth_sdfull_ng
Xnfet_01v8_W1p4_L0p6_m96__nf1_gboth_sdfull_ng_188 x2_tail VSS_body VSS bias_a nfet_01v8_W1p4_L0p6_m96__nf1_gboth_sdfull_ng
Xnfet_01v8_W1p4_L0p6_m96__nf1_gboth_sdfull_ng_177 x2_tail VSS_body VSS cmc nfet_01v8_W1p4_L0p6_m96__nf1_gboth_sdfull_ng
Xnfet_01v8_W1p4_L0p6_m96__nf1_gboth_sdfull_ng_166 x2_tail VSS_body VSS bias_a nfet_01v8_W1p4_L0p6_m96__nf1_gboth_sdfull_ng
Xnfet_01v8_W1p4_L0p6_m96__nf1_gboth_sdfull_ng_155 x2_tail VSS_body VSS bias_a nfet_01v8_W1p4_L0p6_m96__nf1_gboth_sdfull_ng
Xnfet_01v8_W1p4_L0p6_m96__nf1_gboth_sdfull_ng_144 x2_tail VSS_body VSS cmc nfet_01v8_W1p4_L0p6_m96__nf1_gboth_sdfull_ng
Xnfet_01v8_W1p4_L0p6_m96__nf1_gboth_sdfull_ng_133 x2_tail VSS_body VSS bias_a nfet_01v8_W1p4_L0p6_m96__nf1_gboth_sdfull_ng
Xnfet_01v8_W1p4_L0p6_m96__nf1_gboth_sdfull_ng_90 x2_tail VSS_body VSS cmc nfet_01v8_W1p4_L0p6_m96__nf1_gboth_sdfull_ng
Xnfet_01v8_W1p4_L0p6_m36__nf1_gboth_sdfull_ng_10 VSS_body VSS bias_a x2_m3d nfet_01v8_W1p4_L0p6_m36__nf1_gboth_sdfull_ng
Xnfet_01v8_W1p4_L0p6_m36__nf1_gboth_sdfull_ng_21 VSS_body VSS bias_a x2_m3d nfet_01v8_W1p4_L0p6_m36__nf1_gboth_sdfull_ng
Xnfet_01v8_W1p4_L0p6_m36__nf1_gboth_sdfull_ng_32 VSS_body VSS bias_a x2_m3d nfet_01v8_W1p4_L0p6_m36__nf1_gboth_sdfull_ng
Xnfet_01v8_W1p4_L0p6_m36__nf1_gboth_sdfull_ng_43 VSS_body VSS bias_a x2_m3d nfet_01v8_W1p4_L0p6_m36__nf1_gboth_sdfull_ng
Xnfet_01v8_W1p4_L0p6_m36__nf1_gboth_sdfull_ng_65 VSS_body VSS bias_a x2_m3d nfet_01v8_W1p4_L0p6_m36__nf1_gboth_sdfull_ng
Xnfet_01v8_W1p4_L0p6_m36__nf1_gboth_sdfull_ng_54 VSS_body VSS bias_a x2_m3d nfet_01v8_W1p4_L0p6_m36__nf1_gboth_sdfull_ng
Xnfet_01v8_W1p4_L0p6_m96__nf1_gboth_sdfull_ng_101 x2_tail VSS_body VSS cmc nfet_01v8_W1p4_L0p6_m96__nf1_gboth_sdfull_ng
Xnfet_01v8_W1p4_L0p6_m96__nf1_gboth_sdfull_ng_112 x2_tail VSS_body VSS bias_a nfet_01v8_W1p4_L0p6_m96__nf1_gboth_sdfull_ng
Xnfet_01v8_W1p4_L0p6_m96__nf1_gboth_sdfull_ng_123 x2_tail VSS_body VSS cmc nfet_01v8_W1p4_L0p6_m96__nf1_gboth_sdfull_ng
Xnfet_01v8_W1p4_L0p6_m96__nf1_gboth_sdfull_ng_189 x2_tail VSS_body VSS cmc nfet_01v8_W1p4_L0p6_m96__nf1_gboth_sdfull_ng
Xnfet_01v8_W1p4_L0p6_m96__nf1_gboth_sdfull_ng_178 x2_tail VSS_body VSS bias_a nfet_01v8_W1p4_L0p6_m96__nf1_gboth_sdfull_ng
Xnfet_01v8_W1p4_L0p6_m96__nf1_gboth_sdfull_ng_167 x2_tail VSS_body VSS cmc nfet_01v8_W1p4_L0p6_m96__nf1_gboth_sdfull_ng
Xnfet_01v8_W1p4_L0p6_m96__nf1_gboth_sdfull_ng_156 x2_tail VSS_body VSS cmc nfet_01v8_W1p4_L0p6_m96__nf1_gboth_sdfull_ng
Xnfet_01v8_W1p4_L0p6_m96__nf1_gboth_sdfull_ng_145 x2_tail VSS_body VSS bias_a nfet_01v8_W1p4_L0p6_m96__nf1_gboth_sdfull_ng
Xnfet_01v8_W1p4_L0p6_m96__nf1_gboth_sdfull_ng_134 x2_tail VSS_body VSS cmc nfet_01v8_W1p4_L0p6_m96__nf1_gboth_sdfull_ng
.ends

.subckt sky130_fd_pr__pfet_01v8_RGDEC8 G D w_n154_n240# S
X0 S G D w_n154_n240# sky130_fd_pr__pfet_01v8 ad=0.406 pd=3.38 as=0.406 ps=3.38 w=1.4 l=0.6
.ends

.subckt pfet_01v8_W1p4_L0p6_m6__nf1_gboth_sdfull_ng S B G D
Xpfet_01v8_W1p4_L0p6_m6__nf1_gboth_sdfull_ng_pc G D B S sky130_fd_pr__pfet_01v8_RGDEC8
.ends

.subckt pmos_dummy_2__f2 VDD_body VDD
Xpfet_01v8_W1p4_L0p6_m6__nf1_gboth_sdfull_ng_0 VDD VDD_body VDD VDD pfet_01v8_W1p4_L0p6_m6__nf1_gboth_sdfull_ng
Xpfet_01v8_W1p4_L0p6_m6__nf1_gboth_sdfull_ng_1 VDD VDD_body VDD VDD pfet_01v8_W1p4_L0p6_m6__nf1_gboth_sdfull_ng
Xpfet_01v8_W1p4_L0p6_m6__nf1_gboth_sdfull_ng_2 VDD VDD_body VDD VDD pfet_01v8_W1p4_L0p6_m6__nf1_gboth_sdfull_ng
Xpfet_01v8_W1p4_L0p6_m6__nf1_gboth_sdfull_ng_3 VDD VDD_body VDD VDD pfet_01v8_W1p4_L0p6_m6__nf1_gboth_sdfull_ng
Xpfet_01v8_W1p4_L0p6_m6__nf1_gboth_sdfull_ng_4 VDD VDD_body VDD VDD pfet_01v8_W1p4_L0p6_m6__nf1_gboth_sdfull_ng
Xpfet_01v8_W1p4_L0p6_m6__nf1_gboth_sdfull_ng_5 VDD VDD_body VDD VDD pfet_01v8_W1p4_L0p6_m6__nf1_gboth_sdfull_ng
Xpfet_01v8_W1p4_L0p6_m6__nf1_gboth_sdfull_ng_6 VDD VDD_body VDD VDD pfet_01v8_W1p4_L0p6_m6__nf1_gboth_sdfull_ng
Xpfet_01v8_W1p4_L0p6_m6__nf1_gboth_sdfull_ng_7 VDD VDD_body VDD VDD pfet_01v8_W1p4_L0p6_m6__nf1_gboth_sdfull_ng
Xpfet_01v8_W1p4_L0p6_m6__nf1_gboth_sdfull_ng_8 VDD VDD_body VDD VDD pfet_01v8_W1p4_L0p6_m6__nf1_gboth_sdfull_ng
Xpfet_01v8_W1p4_L0p6_m6__nf1_gboth_sdfull_ng_9 VDD VDD_body VDD VDD pfet_01v8_W1p4_L0p6_m6__nf1_gboth_sdfull_ng
.ends

.subckt nfet_01v8_W1p4_L0p6_m18__nf1_gboth_sdfull_ng G B D S
Xnfet_01v8_W1p4_L0p6_m18__nf1_gboth_sdfull_ng_pc G D S B sky130_fd_pr__nfet_01v8_KCM6UP
.ends

.subckt sky130_fd_pr__nfet_01v8_lvt_RUA5M6 G D S VSUBS
X0 S G D VSUBS sky130_fd_pr__nfet_01v8_lvt ad=0.406 pd=3.38 as=0.406 ps=3.38 w=1.4 l=0.6
.ends

.subckt nfet_01v8_lvt_W1p4_L0p6_m8__nf1_gtop_sdfull_ng B G D S
Xnfet_01v8_lvt_W1p4_L0p6_m8__nf1_gtop_sdfull_ng_pc G D S B sky130_fd_pr__nfet_01v8_lvt_RUA5M6
.ends

.subckt x1_cm_iref__cc1 VSS i_bias VSS_body bias_c
Xnfet_01v8_W1p4_L0p6_m18__nf1_gboth_sdfull_ng_30 i_bias VSS_body bias_c VSS nfet_01v8_W1p4_L0p6_m18__nf1_gboth_sdfull_ng
Xnfet_01v8_W1p4_L0p6_m18__nf1_gboth_sdfull_ng_0 i_bias VSS_body i_bias VSS nfet_01v8_W1p4_L0p6_m18__nf1_gboth_sdfull_ng
Xnfet_01v8_W1p4_L0p6_m18__nf1_gboth_sdfull_ng_20 i_bias VSS_body bias_c VSS nfet_01v8_W1p4_L0p6_m18__nf1_gboth_sdfull_ng
Xnfet_01v8_W1p4_L0p6_m18__nf1_gboth_sdfull_ng_31 i_bias VSS_body i_bias VSS nfet_01v8_W1p4_L0p6_m18__nf1_gboth_sdfull_ng
Xnfet_01v8_W1p4_L0p6_m18__nf1_gboth_sdfull_ng_1 i_bias VSS_body bias_c VSS nfet_01v8_W1p4_L0p6_m18__nf1_gboth_sdfull_ng
Xnfet_01v8_W1p4_L0p6_m18__nf1_gboth_sdfull_ng_2 i_bias VSS_body i_bias VSS nfet_01v8_W1p4_L0p6_m18__nf1_gboth_sdfull_ng
Xnfet_01v8_W1p4_L0p6_m18__nf1_gboth_sdfull_ng_10 i_bias VSS_body i_bias VSS nfet_01v8_W1p4_L0p6_m18__nf1_gboth_sdfull_ng
Xnfet_01v8_W1p4_L0p6_m18__nf1_gboth_sdfull_ng_11 i_bias VSS_body bias_c VSS nfet_01v8_W1p4_L0p6_m18__nf1_gboth_sdfull_ng
Xnfet_01v8_W1p4_L0p6_m18__nf1_gboth_sdfull_ng_21 i_bias VSS_body i_bias VSS nfet_01v8_W1p4_L0p6_m18__nf1_gboth_sdfull_ng
Xnfet_01v8_W1p4_L0p6_m18__nf1_gboth_sdfull_ng_22 i_bias VSS_body bias_c VSS nfet_01v8_W1p4_L0p6_m18__nf1_gboth_sdfull_ng
Xnfet_01v8_W1p4_L0p6_m18__nf1_gboth_sdfull_ng_32 i_bias VSS_body bias_c VSS nfet_01v8_W1p4_L0p6_m18__nf1_gboth_sdfull_ng
Xnfet_01v8_W1p4_L0p6_m18__nf1_gboth_sdfull_ng_33 i_bias VSS_body i_bias VSS nfet_01v8_W1p4_L0p6_m18__nf1_gboth_sdfull_ng
Xnfet_01v8_W1p4_L0p6_m18__nf1_gboth_sdfull_ng_3 i_bias VSS_body bias_c VSS nfet_01v8_W1p4_L0p6_m18__nf1_gboth_sdfull_ng
Xnfet_01v8_W1p4_L0p6_m18__nf1_gboth_sdfull_ng_12 i_bias VSS_body i_bias VSS nfet_01v8_W1p4_L0p6_m18__nf1_gboth_sdfull_ng
Xnfet_01v8_W1p4_L0p6_m18__nf1_gboth_sdfull_ng_23 i_bias VSS_body i_bias VSS nfet_01v8_W1p4_L0p6_m18__nf1_gboth_sdfull_ng
Xnfet_01v8_W1p4_L0p6_m18__nf1_gboth_sdfull_ng_34 i_bias VSS_body bias_c VSS nfet_01v8_W1p4_L0p6_m18__nf1_gboth_sdfull_ng
Xnfet_01v8_W1p4_L0p6_m18__nf1_gboth_sdfull_ng_4 i_bias VSS_body i_bias VSS nfet_01v8_W1p4_L0p6_m18__nf1_gboth_sdfull_ng
Xnfet_01v8_W1p4_L0p6_m18__nf1_gboth_sdfull_ng_13 i_bias VSS_body bias_c VSS nfet_01v8_W1p4_L0p6_m18__nf1_gboth_sdfull_ng
Xnfet_01v8_W1p4_L0p6_m18__nf1_gboth_sdfull_ng_24 i_bias VSS_body bias_c VSS nfet_01v8_W1p4_L0p6_m18__nf1_gboth_sdfull_ng
Xnfet_01v8_W1p4_L0p6_m18__nf1_gboth_sdfull_ng_35 i_bias VSS_body i_bias VSS nfet_01v8_W1p4_L0p6_m18__nf1_gboth_sdfull_ng
Xnfet_01v8_W1p4_L0p6_m18__nf1_gboth_sdfull_ng_5 i_bias VSS_body bias_c VSS nfet_01v8_W1p4_L0p6_m18__nf1_gboth_sdfull_ng
Xnfet_01v8_W1p4_L0p6_m18__nf1_gboth_sdfull_ng_14 i_bias VSS_body i_bias VSS nfet_01v8_W1p4_L0p6_m18__nf1_gboth_sdfull_ng
Xnfet_01v8_W1p4_L0p6_m18__nf1_gboth_sdfull_ng_25 i_bias VSS_body i_bias VSS nfet_01v8_W1p4_L0p6_m18__nf1_gboth_sdfull_ng
Xnfet_01v8_W1p4_L0p6_m18__nf1_gboth_sdfull_ng_6 i_bias VSS_body i_bias VSS nfet_01v8_W1p4_L0p6_m18__nf1_gboth_sdfull_ng
Xnfet_01v8_W1p4_L0p6_m18__nf1_gboth_sdfull_ng_15 i_bias VSS_body bias_c VSS nfet_01v8_W1p4_L0p6_m18__nf1_gboth_sdfull_ng
Xnfet_01v8_W1p4_L0p6_m18__nf1_gboth_sdfull_ng_26 i_bias VSS_body bias_c VSS nfet_01v8_W1p4_L0p6_m18__nf1_gboth_sdfull_ng
Xnfet_01v8_W1p4_L0p6_m18__nf1_gboth_sdfull_ng_7 i_bias VSS_body bias_c VSS nfet_01v8_W1p4_L0p6_m18__nf1_gboth_sdfull_ng
Xnfet_01v8_W1p4_L0p6_m18__nf1_gboth_sdfull_ng_16 i_bias VSS_body i_bias VSS nfet_01v8_W1p4_L0p6_m18__nf1_gboth_sdfull_ng
Xnfet_01v8_W1p4_L0p6_m18__nf1_gboth_sdfull_ng_27 i_bias VSS_body i_bias VSS nfet_01v8_W1p4_L0p6_m18__nf1_gboth_sdfull_ng
Xnfet_01v8_W1p4_L0p6_m18__nf1_gboth_sdfull_ng_8 i_bias VSS_body i_bias VSS nfet_01v8_W1p4_L0p6_m18__nf1_gboth_sdfull_ng
Xnfet_01v8_W1p4_L0p6_m18__nf1_gboth_sdfull_ng_17 i_bias VSS_body bias_c VSS nfet_01v8_W1p4_L0p6_m18__nf1_gboth_sdfull_ng
Xnfet_01v8_W1p4_L0p6_m18__nf1_gboth_sdfull_ng_28 i_bias VSS_body bias_c VSS nfet_01v8_W1p4_L0p6_m18__nf1_gboth_sdfull_ng
Xnfet_01v8_lvt_W1p4_L0p6_m8__nf1_gtop_sdfull_ng_0 VSS_body bias_c bias_c bias_c nfet_01v8_lvt_W1p4_L0p6_m8__nf1_gtop_sdfull_ng
Xnfet_01v8_W1p4_L0p6_m18__nf1_gboth_sdfull_ng_9 i_bias VSS_body bias_c VSS nfet_01v8_W1p4_L0p6_m18__nf1_gboth_sdfull_ng
Xnfet_01v8_W1p4_L0p6_m18__nf1_gboth_sdfull_ng_18 i_bias VSS_body bias_c VSS nfet_01v8_W1p4_L0p6_m18__nf1_gboth_sdfull_ng
Xnfet_01v8_W1p4_L0p6_m18__nf1_gboth_sdfull_ng_19 i_bias VSS_body i_bias VSS nfet_01v8_W1p4_L0p6_m18__nf1_gboth_sdfull_ng
Xnfet_01v8_W1p4_L0p6_m18__nf1_gboth_sdfull_ng_29 i_bias VSS_body i_bias VSS nfet_01v8_W1p4_L0p6_m18__nf1_gboth_sdfull_ng
Xnfet_01v8_lvt_W1p4_L0p6_m8__nf1_gtop_sdfull_ng_1 VSS_body bias_c bias_c bias_c nfet_01v8_lvt_W1p4_L0p6_m8__nf1_gtop_sdfull_ng
Xnfet_01v8_lvt_W1p4_L0p6_m8__nf1_gtop_sdfull_ng_2 VSS_body bias_c bias_c bias_c nfet_01v8_lvt_W1p4_L0p6_m8__nf1_gtop_sdfull_ng
Xnfet_01v8_lvt_W1p4_L0p6_m8__nf1_gtop_sdfull_ng_3 VSS_body bias_c bias_c bias_c nfet_01v8_lvt_W1p4_L0p6_m8__nf1_gtop_sdfull_ng
Xnfet_01v8_lvt_W1p4_L0p6_m8__nf1_gtop_sdfull_ng_4 VSS_body bias_c bias_c bias_c nfet_01v8_lvt_W1p4_L0p6_m8__nf1_gtop_sdfull_ng
Xnfet_01v8_lvt_W1p4_L0p6_m8__nf1_gtop_sdfull_ng_5 VSS_body bias_c bias_c bias_c nfet_01v8_lvt_W1p4_L0p6_m8__nf1_gtop_sdfull_ng
Xnfet_01v8_lvt_W1p4_L0p6_m8__nf1_gtop_sdfull_ng_6 VSS_body bias_c bias_c bias_c nfet_01v8_lvt_W1p4_L0p6_m8__nf1_gtop_sdfull_ng
Xnfet_01v8_lvt_W1p4_L0p6_m8__nf1_gtop_sdfull_ng_7 VSS_body bias_c bias_c bias_c nfet_01v8_lvt_W1p4_L0p6_m8__nf1_gtop_sdfull_ng
Xnfet_01v8_W1p4_L0p6_m2__nf1_gboth_sdfull_ng_0 VSS_body bias_c bias_c bias_c nfet_01v8_W1p4_L0p6_m2__nf1_gboth_sdfull_ng
Xnfet_01v8_W1p4_L0p6_m2__nf1_gboth_sdfull_ng_1 VSS_body i_bias i_bias i_bias nfet_01v8_W1p4_L0p6_m2__nf1_gboth_sdfull_ng
Xnfet_01v8_W1p4_L0p6_m2__nf1_gboth_sdfull_ng_2 VSS_body bias_c bias_c bias_c nfet_01v8_W1p4_L0p6_m2__nf1_gboth_sdfull_ng
Xnfet_01v8_W1p4_L0p6_m2__nf1_gboth_sdfull_ng_3 VSS_body i_bias i_bias i_bias nfet_01v8_W1p4_L0p6_m2__nf1_gboth_sdfull_ng
.ends

.subckt x2_cm_casc__cc3 x2_m4d VSS op VSS_body x2_m3d bias_d on
Xnfet_01v8_W1p4_L0p6_m36__nf1_gboth_sdfull_ng_66 VSS_body x2_m4d bias_d op nfet_01v8_W1p4_L0p6_m36__nf1_gboth_sdfull_ng
Xnfet_01v8_W1p4_L0p6_m36__nf1_gboth_sdfull_ng_55 VSS_body x2_m4d bias_d op nfet_01v8_W1p4_L0p6_m36__nf1_gboth_sdfull_ng
Xnfet_01v8_W1p4_L0p6_m36__nf1_gboth_sdfull_ng_44 VSS_body x2_m4d bias_d op nfet_01v8_W1p4_L0p6_m36__nf1_gboth_sdfull_ng
Xnfet_01v8_W1p4_L0p6_m36__nf1_gboth_sdfull_ng_33 VSS_body x2_m4d bias_d op nfet_01v8_W1p4_L0p6_m36__nf1_gboth_sdfull_ng
Xnfet_01v8_W1p4_L0p6_m36__nf1_gboth_sdfull_ng_22 VSS_body x2_m4d bias_d op nfet_01v8_W1p4_L0p6_m36__nf1_gboth_sdfull_ng
Xnfet_01v8_W1p4_L0p6_m36__nf1_gboth_sdfull_ng_11 VSS_body x2_m4d bias_d op nfet_01v8_W1p4_L0p6_m36__nf1_gboth_sdfull_ng
Xnfet_01v8_W1p4_L0p6_m36__nf1_gboth_sdfull_ng_67 VSS_body x2_m3d bias_d on nfet_01v8_W1p4_L0p6_m36__nf1_gboth_sdfull_ng
Xnfet_01v8_W1p4_L0p6_m36__nf1_gboth_sdfull_ng_56 VSS_body x2_m3d bias_d on nfet_01v8_W1p4_L0p6_m36__nf1_gboth_sdfull_ng
Xnfet_01v8_W1p4_L0p6_m36__nf1_gboth_sdfull_ng_45 VSS_body x2_m3d bias_d on nfet_01v8_W1p4_L0p6_m36__nf1_gboth_sdfull_ng
Xnfet_01v8_W1p4_L0p6_m36__nf1_gboth_sdfull_ng_34 VSS_body x2_m3d bias_d on nfet_01v8_W1p4_L0p6_m36__nf1_gboth_sdfull_ng
Xnfet_01v8_W1p4_L0p6_m36__nf1_gboth_sdfull_ng_23 VSS_body x2_m3d bias_d on nfet_01v8_W1p4_L0p6_m36__nf1_gboth_sdfull_ng
Xnfet_01v8_W1p4_L0p6_m36__nf1_gboth_sdfull_ng_12 VSS_body x2_m4d bias_d op nfet_01v8_W1p4_L0p6_m36__nf1_gboth_sdfull_ng
Xnfet_01v8_W1p4_L0p6_m36__nf1_gboth_sdfull_ng_68 VSS_body x2_m4d bias_d op nfet_01v8_W1p4_L0p6_m36__nf1_gboth_sdfull_ng
Xnfet_01v8_W1p4_L0p6_m36__nf1_gboth_sdfull_ng_57 VSS_body x2_m4d bias_d op nfet_01v8_W1p4_L0p6_m36__nf1_gboth_sdfull_ng
Xnfet_01v8_W1p4_L0p6_m36__nf1_gboth_sdfull_ng_46 VSS_body x2_m4d bias_d op nfet_01v8_W1p4_L0p6_m36__nf1_gboth_sdfull_ng
Xnfet_01v8_W1p4_L0p6_m36__nf1_gboth_sdfull_ng_35 VSS_body x2_m4d bias_d op nfet_01v8_W1p4_L0p6_m36__nf1_gboth_sdfull_ng
Xnfet_01v8_W1p4_L0p6_m36__nf1_gboth_sdfull_ng_24 VSS_body x2_m3d bias_d on nfet_01v8_W1p4_L0p6_m36__nf1_gboth_sdfull_ng
Xnfet_01v8_W1p4_L0p6_m36__nf1_gboth_sdfull_ng_13 VSS_body x2_m3d bias_d on nfet_01v8_W1p4_L0p6_m36__nf1_gboth_sdfull_ng
Xnfet_01v8_W1p4_L0p6_m36__nf1_gboth_sdfull_ng_69 VSS_body x2_m3d bias_d on nfet_01v8_W1p4_L0p6_m36__nf1_gboth_sdfull_ng
Xnfet_01v8_W1p4_L0p6_m36__nf1_gboth_sdfull_ng_58 VSS_body x2_m3d bias_d on nfet_01v8_W1p4_L0p6_m36__nf1_gboth_sdfull_ng
Xnfet_01v8_W1p4_L0p6_m36__nf1_gboth_sdfull_ng_47 VSS_body x2_m3d bias_d on nfet_01v8_W1p4_L0p6_m36__nf1_gboth_sdfull_ng
Xnfet_01v8_W1p4_L0p6_m36__nf1_gboth_sdfull_ng_36 VSS_body x2_m4d bias_d op nfet_01v8_W1p4_L0p6_m36__nf1_gboth_sdfull_ng
Xnfet_01v8_W1p4_L0p6_m36__nf1_gboth_sdfull_ng_25 VSS_body x2_m4d bias_d op nfet_01v8_W1p4_L0p6_m36__nf1_gboth_sdfull_ng
Xnfet_01v8_W1p4_L0p6_m36__nf1_gboth_sdfull_ng_14 VSS_body x2_m4d bias_d op nfet_01v8_W1p4_L0p6_m36__nf1_gboth_sdfull_ng
Xnfet_01v8_W1p4_L0p6_m36__nf1_gboth_sdfull_ng_59 VSS_body x2_m4d bias_d op nfet_01v8_W1p4_L0p6_m36__nf1_gboth_sdfull_ng
Xnfet_01v8_W1p4_L0p6_m36__nf1_gboth_sdfull_ng_49 VSS_body x2_m4d bias_d op nfet_01v8_W1p4_L0p6_m36__nf1_gboth_sdfull_ng
Xnfet_01v8_W1p4_L0p6_m36__nf1_gboth_sdfull_ng_48 VSS_body x2_m3d bias_d on nfet_01v8_W1p4_L0p6_m36__nf1_gboth_sdfull_ng
Xnfet_01v8_W1p4_L0p6_m36__nf1_gboth_sdfull_ng_38 VSS_body x2_m4d bias_d op nfet_01v8_W1p4_L0p6_m36__nf1_gboth_sdfull_ng
Xnfet_01v8_W1p4_L0p6_m36__nf1_gboth_sdfull_ng_37 VSS_body x2_m3d bias_d on nfet_01v8_W1p4_L0p6_m36__nf1_gboth_sdfull_ng
Xnfet_01v8_W1p4_L0p6_m36__nf1_gboth_sdfull_ng_27 VSS_body x2_m4d bias_d op nfet_01v8_W1p4_L0p6_m36__nf1_gboth_sdfull_ng
Xnfet_01v8_W1p4_L0p6_m36__nf1_gboth_sdfull_ng_26 VSS_body x2_m3d bias_d on nfet_01v8_W1p4_L0p6_m36__nf1_gboth_sdfull_ng
Xnfet_01v8_W1p4_L0p6_m36__nf1_gboth_sdfull_ng_16 VSS_body x2_m4d bias_d op nfet_01v8_W1p4_L0p6_m36__nf1_gboth_sdfull_ng
Xnfet_01v8_W1p4_L0p6_m36__nf1_gboth_sdfull_ng_15 VSS_body x2_m3d bias_d on nfet_01v8_W1p4_L0p6_m36__nf1_gboth_sdfull_ng
Xnfet_01v8_W1p4_L0p6_m36__nf1_gboth_sdfull_ng_39 VSS_body x2_m3d bias_d on nfet_01v8_W1p4_L0p6_m36__nf1_gboth_sdfull_ng
Xnfet_01v8_W1p4_L0p6_m36__nf1_gboth_sdfull_ng_28 VSS_body x2_m3d bias_d on nfet_01v8_W1p4_L0p6_m36__nf1_gboth_sdfull_ng
Xnfet_01v8_W1p4_L0p6_m36__nf1_gboth_sdfull_ng_17 VSS_body x2_m3d bias_d on nfet_01v8_W1p4_L0p6_m36__nf1_gboth_sdfull_ng
Xnfet_01v8_W1p4_L0p6_m36__nf1_gboth_sdfull_ng_29 VSS_body x2_m4d bias_d op nfet_01v8_W1p4_L0p6_m36__nf1_gboth_sdfull_ng
Xnfet_01v8_W1p4_L0p6_m36__nf1_gboth_sdfull_ng_18 VSS_body x2_m4d bias_d op nfet_01v8_W1p4_L0p6_m36__nf1_gboth_sdfull_ng
Xnfet_01v8_W1p4_L0p6_m36__nf1_gboth_sdfull_ng_19 VSS_body x2_m3d bias_d on nfet_01v8_W1p4_L0p6_m36__nf1_gboth_sdfull_ng
Xnfet_01v8_W1p4_L0p6_m36__nf1_gboth_sdfull_ng_0 VSS_body x2_m3d bias_d on nfet_01v8_W1p4_L0p6_m36__nf1_gboth_sdfull_ng
Xnfet_01v8_W1p4_L0p6_m36__nf1_gboth_sdfull_ng_1 VSS_body x2_m4d bias_d op nfet_01v8_W1p4_L0p6_m36__nf1_gboth_sdfull_ng
Xnfet_01v8_W1p4_L0p6_m2__nf1_gboth_sdfull_ng_0 VSS_body op op op nfet_01v8_W1p4_L0p6_m2__nf1_gboth_sdfull_ng
Xnfet_01v8_W1p4_L0p6_m36__nf1_gboth_sdfull_ng_2 VSS_body x2_m3d bias_d on nfet_01v8_W1p4_L0p6_m36__nf1_gboth_sdfull_ng
Xnfet_01v8_W1p4_L0p6_m2__nf1_gboth_sdfull_ng_1 VSS_body VSS VSS on nfet_01v8_W1p4_L0p6_m2__nf1_gboth_sdfull_ng
Xnfet_01v8_W1p4_L0p6_m36__nf1_gboth_sdfull_ng_3 VSS_body x2_m4d bias_d op nfet_01v8_W1p4_L0p6_m36__nf1_gboth_sdfull_ng
Xnfet_01v8_W1p4_L0p6_m2__nf1_gboth_sdfull_ng_2 VSS_body op op op nfet_01v8_W1p4_L0p6_m2__nf1_gboth_sdfull_ng
Xnfet_01v8_W1p4_L0p6_m36__nf1_gboth_sdfull_ng_4 VSS_body x2_m3d bias_d on nfet_01v8_W1p4_L0p6_m36__nf1_gboth_sdfull_ng
Xnfet_01v8_W1p4_L0p6_m2__nf1_gboth_sdfull_ng_4 VSS_body VSS VSS VSS nfet_01v8_W1p4_L0p6_m2__nf1_gboth_sdfull_ng
Xnfet_01v8_W1p4_L0p6_m2__nf1_gboth_sdfull_ng_3 VSS_body VSS VSS on nfet_01v8_W1p4_L0p6_m2__nf1_gboth_sdfull_ng
Xnfet_01v8_W1p4_L0p6_m36__nf1_gboth_sdfull_ng_5 VSS_body x2_m4d bias_d op nfet_01v8_W1p4_L0p6_m36__nf1_gboth_sdfull_ng
Xnfet_01v8_W1p4_L0p6_m2__nf1_gboth_sdfull_ng_5 VSS_body on on on nfet_01v8_W1p4_L0p6_m2__nf1_gboth_sdfull_ng
Xnfet_01v8_W1p4_L0p6_m36__nf1_gboth_sdfull_ng_7 VSS_body x2_m4d bias_d op nfet_01v8_W1p4_L0p6_m36__nf1_gboth_sdfull_ng
Xnfet_01v8_W1p4_L0p6_m36__nf1_gboth_sdfull_ng_6 VSS_body x2_m3d bias_d on nfet_01v8_W1p4_L0p6_m36__nf1_gboth_sdfull_ng
Xnfet_01v8_W1p4_L0p6_m2__nf1_gboth_sdfull_ng_6 VSS_body on on on nfet_01v8_W1p4_L0p6_m2__nf1_gboth_sdfull_ng
Xnfet_01v8_W1p4_L0p6_m36__nf1_gboth_sdfull_ng_8 VSS_body x2_m3d bias_d on nfet_01v8_W1p4_L0p6_m36__nf1_gboth_sdfull_ng
Xnfet_01v8_W1p4_L0p6_m2__nf1_gboth_sdfull_ng_7 VSS_body VSS VSS VSS nfet_01v8_W1p4_L0p6_m2__nf1_gboth_sdfull_ng
Xnfet_01v8_W1p4_L0p6_m36__nf1_gboth_sdfull_ng_9 VSS_body x2_m4d bias_d op nfet_01v8_W1p4_L0p6_m36__nf1_gboth_sdfull_ng
Xnfet_01v8_W1p4_L0p6_m2__nf1_gboth_sdfull_ng_8 VSS_body VSS VSS VSS nfet_01v8_W1p4_L0p6_m2__nf1_gboth_sdfull_ng
Xnfet_01v8_W1p4_L0p6_m36__nf1_gboth_sdfull_ng_70 VSS_body x2_m4d bias_d op nfet_01v8_W1p4_L0p6_m36__nf1_gboth_sdfull_ng
Xnfet_01v8_W1p4_L0p6_m2__nf1_gboth_sdfull_ng_9 VSS_body VSS VSS op nfet_01v8_W1p4_L0p6_m2__nf1_gboth_sdfull_ng
Xnfet_01v8_W1p4_L0p6_m36__nf1_gboth_sdfull_ng_71 VSS_body x2_m3d bias_d on nfet_01v8_W1p4_L0p6_m36__nf1_gboth_sdfull_ng
Xnfet_01v8_W1p4_L0p6_m36__nf1_gboth_sdfull_ng_60 VSS_body x2_m4d bias_d op nfet_01v8_W1p4_L0p6_m36__nf1_gboth_sdfull_ng
Xnfet_01v8_W1p4_L0p6_m36__nf1_gboth_sdfull_ng_62 VSS_body x2_m4d bias_d op nfet_01v8_W1p4_L0p6_m36__nf1_gboth_sdfull_ng
Xnfet_01v8_W1p4_L0p6_m36__nf1_gboth_sdfull_ng_61 VSS_body x2_m3d bias_d on nfet_01v8_W1p4_L0p6_m36__nf1_gboth_sdfull_ng
Xnfet_01v8_W1p4_L0p6_m36__nf1_gboth_sdfull_ng_51 VSS_body x2_m4d bias_d op nfet_01v8_W1p4_L0p6_m36__nf1_gboth_sdfull_ng
Xnfet_01v8_W1p4_L0p6_m36__nf1_gboth_sdfull_ng_50 VSS_body x2_m3d bias_d on nfet_01v8_W1p4_L0p6_m36__nf1_gboth_sdfull_ng
Xnfet_01v8_W1p4_L0p6_m36__nf1_gboth_sdfull_ng_40 VSS_body x2_m4d bias_d op nfet_01v8_W1p4_L0p6_m36__nf1_gboth_sdfull_ng
Xnfet_01v8_W1p4_L0p6_m36__nf1_gboth_sdfull_ng_63 VSS_body x2_m3d bias_d on nfet_01v8_W1p4_L0p6_m36__nf1_gboth_sdfull_ng
Xnfet_01v8_W1p4_L0p6_m36__nf1_gboth_sdfull_ng_52 VSS_body x2_m3d bias_d on nfet_01v8_W1p4_L0p6_m36__nf1_gboth_sdfull_ng
Xnfet_01v8_W1p4_L0p6_m36__nf1_gboth_sdfull_ng_41 VSS_body x2_m3d bias_d on nfet_01v8_W1p4_L0p6_m36__nf1_gboth_sdfull_ng
Xnfet_01v8_W1p4_L0p6_m36__nf1_gboth_sdfull_ng_30 VSS_body x2_m3d bias_d on nfet_01v8_W1p4_L0p6_m36__nf1_gboth_sdfull_ng
Xnfet_01v8_W1p4_L0p6_m2__nf1_gboth_sdfull_ng_10 VSS_body VSS VSS op nfet_01v8_W1p4_L0p6_m2__nf1_gboth_sdfull_ng
Xnfet_01v8_W1p4_L0p6_m36__nf1_gboth_sdfull_ng_64 VSS_body x2_m4d bias_d op nfet_01v8_W1p4_L0p6_m36__nf1_gboth_sdfull_ng
Xnfet_01v8_W1p4_L0p6_m36__nf1_gboth_sdfull_ng_53 VSS_body x2_m4d bias_d op nfet_01v8_W1p4_L0p6_m36__nf1_gboth_sdfull_ng
Xnfet_01v8_W1p4_L0p6_m36__nf1_gboth_sdfull_ng_42 VSS_body x2_m4d bias_d op nfet_01v8_W1p4_L0p6_m36__nf1_gboth_sdfull_ng
Xnfet_01v8_W1p4_L0p6_m36__nf1_gboth_sdfull_ng_31 VSS_body x2_m4d bias_d op nfet_01v8_W1p4_L0p6_m36__nf1_gboth_sdfull_ng
Xnfet_01v8_W1p4_L0p6_m36__nf1_gboth_sdfull_ng_20 VSS_body x2_m4d bias_d op nfet_01v8_W1p4_L0p6_m36__nf1_gboth_sdfull_ng
Xnfet_01v8_W1p4_L0p6_m2__nf1_gboth_sdfull_ng_11 VSS_body VSS VSS VSS nfet_01v8_W1p4_L0p6_m2__nf1_gboth_sdfull_ng
Xnfet_01v8_W1p4_L0p6_m36__nf1_gboth_sdfull_ng_65 VSS_body x2_m3d bias_d on nfet_01v8_W1p4_L0p6_m36__nf1_gboth_sdfull_ng
Xnfet_01v8_W1p4_L0p6_m36__nf1_gboth_sdfull_ng_54 VSS_body x2_m3d bias_d on nfet_01v8_W1p4_L0p6_m36__nf1_gboth_sdfull_ng
Xnfet_01v8_W1p4_L0p6_m36__nf1_gboth_sdfull_ng_43 VSS_body x2_m3d bias_d on nfet_01v8_W1p4_L0p6_m36__nf1_gboth_sdfull_ng
Xnfet_01v8_W1p4_L0p6_m36__nf1_gboth_sdfull_ng_32 VSS_body x2_m3d bias_d on nfet_01v8_W1p4_L0p6_m36__nf1_gboth_sdfull_ng
Xnfet_01v8_W1p4_L0p6_m36__nf1_gboth_sdfull_ng_21 VSS_body x2_m3d bias_d on nfet_01v8_W1p4_L0p6_m36__nf1_gboth_sdfull_ng
Xnfet_01v8_W1p4_L0p6_m36__nf1_gboth_sdfull_ng_10 VSS_body x2_m3d bias_d on nfet_01v8_W1p4_L0p6_m36__nf1_gboth_sdfull_ng
.ends

.subckt sky130_fd_pr__pfet_01v8_lvt_PJ46JE G D w_n154_n240# S
X0 S G D w_n154_n240# sky130_fd_pr__pfet_01v8_lvt ad=0.406 pd=3.38 as=0.406 ps=3.38 w=1.4 l=0.6
.ends

.subckt pfet_01v8_lvt_W1p4_L0p6_m6__nf1_gboth_sdfull_ng G D S B
Xpfet_01v8_lvt_W1p4_L0p6_m6__nf1_gboth_sdfull_ng_pc G D B S sky130_fd_pr__pfet_01v8_lvt_PJ46JE
.ends

.subckt sky130_fd_pr__pfet_01v8_7A4LUF G D w_n154_n238# S
X0 S G D w_n154_n238# sky130_fd_pr__pfet_01v8 ad=0.406 pd=3.38 as=0.406 ps=3.38 w=1.4 l=0.6
.ends

.subckt pfet_01v8_W1p4_L0p6_m2__nf1_gtop_sdfull_ng S B G D
Xpfet_01v8_W1p4_L0p6_m2__nf1_gtop_sdfull_ng_pc G D B S sky130_fd_pr__pfet_01v8_7A4LUF
.ends

.subckt sky130_fd_pr__pfet_01v8_lvt_L7GY3J G D w_n154_n238# S
X0 S G D w_n154_n238# sky130_fd_pr__pfet_01v8_lvt ad=0.406 pd=3.38 as=0.406 ps=3.38 w=1.4 l=0.6
.ends

.subckt pfet_01v8_lvt_W1p4_L0p6_m2__nf1_gtop_sdfull_ng G D B S
Xpfet_01v8_lvt_W1p4_L0p6_m2__nf1_gtop_sdfull_ng_pc G D B S sky130_fd_pr__pfet_01v8_lvt_L7GY3J
.ends

.subckt x1_cm_bias_b__cc3 VDD x1_m21d x1_m25d x1_m31d VDD_body bias_b
Xpfet_01v8_lvt_W1p4_L0p6_m6__nf1_gboth_sdfull_ng_10 bias_b x1_m25d VDD VDD_body pfet_01v8_lvt_W1p4_L0p6_m6__nf1_gboth_sdfull_ng
Xpfet_01v8_lvt_W1p4_L0p6_m6__nf1_gboth_sdfull_ng_11 bias_b x1_m21d VDD VDD_body pfet_01v8_lvt_W1p4_L0p6_m6__nf1_gboth_sdfull_ng
Xpfet_01v8_lvt_W1p4_L0p6_m6__nf1_gboth_sdfull_ng_12 bias_b x1_m21d VDD VDD_body pfet_01v8_lvt_W1p4_L0p6_m6__nf1_gboth_sdfull_ng
Xpfet_01v8_lvt_W1p4_L0p6_m6__nf1_gboth_sdfull_ng_13 bias_b x1_m25d VDD VDD_body pfet_01v8_lvt_W1p4_L0p6_m6__nf1_gboth_sdfull_ng
Xpfet_01v8_lvt_W1p4_L0p6_m6__nf1_gboth_sdfull_ng_14 bias_b x1_m31d VDD VDD_body pfet_01v8_lvt_W1p4_L0p6_m6__nf1_gboth_sdfull_ng
Xpfet_01v8_lvt_W1p4_L0p6_m6__nf1_gboth_sdfull_ng_0 bias_b x1_m21d VDD VDD_body pfet_01v8_lvt_W1p4_L0p6_m6__nf1_gboth_sdfull_ng
Xpfet_01v8_lvt_W1p4_L0p6_m6__nf1_gboth_sdfull_ng_15 bias_b x1_m31d VDD VDD_body pfet_01v8_lvt_W1p4_L0p6_m6__nf1_gboth_sdfull_ng
Xpfet_01v8_lvt_W1p4_L0p6_m6__nf1_gboth_sdfull_ng_1 bias_b x1_m25d VDD VDD_body pfet_01v8_lvt_W1p4_L0p6_m6__nf1_gboth_sdfull_ng
Xpfet_01v8_lvt_W1p4_L0p6_m6__nf1_gboth_sdfull_ng_2 bias_b x1_m31d VDD VDD_body pfet_01v8_lvt_W1p4_L0p6_m6__nf1_gboth_sdfull_ng
Xpfet_01v8_lvt_W1p4_L0p6_m6__nf1_gboth_sdfull_ng_16 bias_b x1_m25d VDD VDD_body pfet_01v8_lvt_W1p4_L0p6_m6__nf1_gboth_sdfull_ng
Xpfet_01v8_lvt_W1p4_L0p6_m6__nf1_gboth_sdfull_ng_3 bias_b x1_m31d VDD VDD_body pfet_01v8_lvt_W1p4_L0p6_m6__nf1_gboth_sdfull_ng
Xpfet_01v8_lvt_W1p4_L0p6_m6__nf1_gboth_sdfull_ng_17 bias_b x1_m21d VDD VDD_body pfet_01v8_lvt_W1p4_L0p6_m6__nf1_gboth_sdfull_ng
Xpfet_01v8_lvt_W1p4_L0p6_m6__nf1_gboth_sdfull_ng_4 bias_b x1_m25d VDD VDD_body pfet_01v8_lvt_W1p4_L0p6_m6__nf1_gboth_sdfull_ng
Xpfet_01v8_lvt_W1p4_L0p6_m6__nf1_gboth_sdfull_ng_5 bias_b x1_m21d VDD VDD_body pfet_01v8_lvt_W1p4_L0p6_m6__nf1_gboth_sdfull_ng
Xpfet_01v8_lvt_W1p4_L0p6_m6__nf1_gboth_sdfull_ng_6 bias_b x1_m21d VDD VDD_body pfet_01v8_lvt_W1p4_L0p6_m6__nf1_gboth_sdfull_ng
Xpfet_01v8_lvt_W1p4_L0p6_m6__nf1_gboth_sdfull_ng_7 bias_b x1_m25d VDD VDD_body pfet_01v8_lvt_W1p4_L0p6_m6__nf1_gboth_sdfull_ng
Xpfet_01v8_W1p4_L0p6_m2__nf1_gtop_sdfull_ng_0 x1_m21d VDD_body x1_m21d x1_m21d pfet_01v8_W1p4_L0p6_m2__nf1_gtop_sdfull_ng
Xpfet_01v8_lvt_W1p4_L0p6_m6__nf1_gboth_sdfull_ng_8 bias_b x1_m31d VDD VDD_body pfet_01v8_lvt_W1p4_L0p6_m6__nf1_gboth_sdfull_ng
Xpfet_01v8_W1p4_L0p6_m2__nf1_gtop_sdfull_ng_1 x1_m21d VDD_body x1_m21d x1_m21d pfet_01v8_W1p4_L0p6_m2__nf1_gtop_sdfull_ng
Xpfet_01v8_lvt_W1p4_L0p6_m6__nf1_gboth_sdfull_ng_9 bias_b x1_m31d VDD VDD_body pfet_01v8_lvt_W1p4_L0p6_m6__nf1_gboth_sdfull_ng
Xpfet_01v8_W1p4_L0p6_m2__nf1_gtop_sdfull_ng_2 x1_m25d VDD_body x1_m25d x1_m25d pfet_01v8_W1p4_L0p6_m2__nf1_gtop_sdfull_ng
Xpfet_01v8_W1p4_L0p6_m2__nf1_gtop_sdfull_ng_4 VDD VDD_body VDD x1_m31d pfet_01v8_W1p4_L0p6_m2__nf1_gtop_sdfull_ng
Xpfet_01v8_W1p4_L0p6_m2__nf1_gtop_sdfull_ng_3 x1_m25d VDD_body x1_m25d x1_m25d pfet_01v8_W1p4_L0p6_m2__nf1_gtop_sdfull_ng
Xpfet_01v8_W1p4_L0p6_m2__nf1_gtop_sdfull_ng_5 VDD VDD_body VDD x1_m31d pfet_01v8_W1p4_L0p6_m2__nf1_gtop_sdfull_ng
Xpfet_01v8_lvt_W1p4_L0p6_m2__nf1_gtop_sdfull_ng_0 x1_m21d x1_m21d VDD_body x1_m21d
+ pfet_01v8_lvt_W1p4_L0p6_m2__nf1_gtop_sdfull_ng
Xpfet_01v8_lvt_W1p4_L0p6_m2__nf1_gtop_sdfull_ng_1 x1_m21d x1_m21d VDD_body x1_m21d
+ pfet_01v8_lvt_W1p4_L0p6_m2__nf1_gtop_sdfull_ng
Xpfet_01v8_lvt_W1p4_L0p6_m2__nf1_gtop_sdfull_ng_2 x1_m25d x1_m25d VDD_body x1_m25d
+ pfet_01v8_lvt_W1p4_L0p6_m2__nf1_gtop_sdfull_ng
Xpfet_01v8_lvt_W1p4_L0p6_m2__nf1_gtop_sdfull_ng_3 x1_m25d x1_m25d VDD_body x1_m25d
+ pfet_01v8_lvt_W1p4_L0p6_m2__nf1_gtop_sdfull_ng
Xpfet_01v8_lvt_W1p4_L0p6_m2__nf1_gtop_sdfull_ng_4 x1_m31d x1_m31d VDD_body x1_m31d
+ pfet_01v8_lvt_W1p4_L0p6_m2__nf1_gtop_sdfull_ng
Xpfet_01v8_lvt_W1p4_L0p6_m2__nf1_gtop_sdfull_ng_5 x1_m31d x1_m31d VDD_body x1_m31d
+ pfet_01v8_lvt_W1p4_L0p6_m2__nf1_gtop_sdfull_ng
.ends

.subckt sky130_fd_pr__nfet_01v8_lvt_KCM6UP G D S VSUBS
X0 S G D VSUBS sky130_fd_pr__nfet_01v8_lvt ad=0.406 pd=3.38 as=0.406 ps=3.38 w=1.4 l=0.6
.ends

.subckt nfet_01v8_lvt_W1p4_L0p6_m56__nf1_gboth_sdfull_ng B G D S
Xnfet_01v8_lvt_W1p4_L0p6_m56__nf1_gboth_sdfull_ng_pc G D S B sky130_fd_pr__nfet_01v8_lvt_KCM6UP
.ends

.subckt x1_diode_bias_b__f2 bias_b VSS_body bias_c
Xnfet_01v8_lvt_W1p4_L0p6_m56__nf1_gboth_sdfull_ng_13 VSS_body bias_b bias_b bias_c
+ nfet_01v8_lvt_W1p4_L0p6_m56__nf1_gboth_sdfull_ng
Xnfet_01v8_lvt_W1p4_L0p6_m56__nf1_gboth_sdfull_ng_24 VSS_body bias_b bias_b bias_c
+ nfet_01v8_lvt_W1p4_L0p6_m56__nf1_gboth_sdfull_ng
Xnfet_01v8_lvt_W1p4_L0p6_m56__nf1_gboth_sdfull_ng_35 VSS_body bias_b bias_b bias_c
+ nfet_01v8_lvt_W1p4_L0p6_m56__nf1_gboth_sdfull_ng
Xnfet_01v8_lvt_W1p4_L0p6_m56__nf1_gboth_sdfull_ng_46 VSS_body bias_b bias_b bias_c
+ nfet_01v8_lvt_W1p4_L0p6_m56__nf1_gboth_sdfull_ng
Xnfet_01v8_lvt_W1p4_L0p6_m56__nf1_gboth_sdfull_ng_14 VSS_body bias_b bias_b bias_c
+ nfet_01v8_lvt_W1p4_L0p6_m56__nf1_gboth_sdfull_ng
Xnfet_01v8_lvt_W1p4_L0p6_m56__nf1_gboth_sdfull_ng_25 VSS_body bias_b bias_b bias_c
+ nfet_01v8_lvt_W1p4_L0p6_m56__nf1_gboth_sdfull_ng
Xnfet_01v8_lvt_W1p4_L0p6_m56__nf1_gboth_sdfull_ng_36 VSS_body bias_b bias_b bias_c
+ nfet_01v8_lvt_W1p4_L0p6_m56__nf1_gboth_sdfull_ng
Xnfet_01v8_lvt_W1p4_L0p6_m56__nf1_gboth_sdfull_ng_47 VSS_body bias_b bias_b bias_c
+ nfet_01v8_lvt_W1p4_L0p6_m56__nf1_gboth_sdfull_ng
Xnfet_01v8_lvt_W1p4_L0p6_m56__nf1_gboth_sdfull_ng_15 VSS_body bias_b bias_b bias_c
+ nfet_01v8_lvt_W1p4_L0p6_m56__nf1_gboth_sdfull_ng
Xnfet_01v8_lvt_W1p4_L0p6_m56__nf1_gboth_sdfull_ng_26 VSS_body bias_b bias_b bias_c
+ nfet_01v8_lvt_W1p4_L0p6_m56__nf1_gboth_sdfull_ng
Xnfet_01v8_lvt_W1p4_L0p6_m56__nf1_gboth_sdfull_ng_37 VSS_body bias_b bias_b bias_c
+ nfet_01v8_lvt_W1p4_L0p6_m56__nf1_gboth_sdfull_ng
Xnfet_01v8_lvt_W1p4_L0p6_m56__nf1_gboth_sdfull_ng_48 VSS_body bias_b bias_b bias_c
+ nfet_01v8_lvt_W1p4_L0p6_m56__nf1_gboth_sdfull_ng
Xnfet_01v8_lvt_W1p4_L0p6_m56__nf1_gboth_sdfull_ng_16 VSS_body bias_b bias_b bias_c
+ nfet_01v8_lvt_W1p4_L0p6_m56__nf1_gboth_sdfull_ng
Xnfet_01v8_lvt_W1p4_L0p6_m56__nf1_gboth_sdfull_ng_17 VSS_body bias_b bias_b bias_c
+ nfet_01v8_lvt_W1p4_L0p6_m56__nf1_gboth_sdfull_ng
Xnfet_01v8_lvt_W1p4_L0p6_m56__nf1_gboth_sdfull_ng_27 VSS_body bias_b bias_b bias_c
+ nfet_01v8_lvt_W1p4_L0p6_m56__nf1_gboth_sdfull_ng
Xnfet_01v8_lvt_W1p4_L0p6_m56__nf1_gboth_sdfull_ng_28 VSS_body bias_b bias_b bias_c
+ nfet_01v8_lvt_W1p4_L0p6_m56__nf1_gboth_sdfull_ng
Xnfet_01v8_lvt_W1p4_L0p6_m56__nf1_gboth_sdfull_ng_38 VSS_body bias_b bias_b bias_c
+ nfet_01v8_lvt_W1p4_L0p6_m56__nf1_gboth_sdfull_ng
Xnfet_01v8_lvt_W1p4_L0p6_m56__nf1_gboth_sdfull_ng_39 VSS_body bias_b bias_b bias_c
+ nfet_01v8_lvt_W1p4_L0p6_m56__nf1_gboth_sdfull_ng
Xnfet_01v8_lvt_W1p4_L0p6_m56__nf1_gboth_sdfull_ng_49 VSS_body bias_b bias_b bias_c
+ nfet_01v8_lvt_W1p4_L0p6_m56__nf1_gboth_sdfull_ng
Xnfet_01v8_lvt_W1p4_L0p6_m56__nf1_gboth_sdfull_ng_18 VSS_body bias_b bias_b bias_c
+ nfet_01v8_lvt_W1p4_L0p6_m56__nf1_gboth_sdfull_ng
Xnfet_01v8_lvt_W1p4_L0p6_m56__nf1_gboth_sdfull_ng_29 VSS_body bias_b bias_b bias_c
+ nfet_01v8_lvt_W1p4_L0p6_m56__nf1_gboth_sdfull_ng
Xnfet_01v8_lvt_W1p4_L0p6_m56__nf1_gboth_sdfull_ng_19 VSS_body bias_b bias_b bias_c
+ nfet_01v8_lvt_W1p4_L0p6_m56__nf1_gboth_sdfull_ng
Xnfet_01v8_lvt_W1p4_L0p6_m56__nf1_gboth_sdfull_ng_0 VSS_body bias_b bias_b bias_c
+ nfet_01v8_lvt_W1p4_L0p6_m56__nf1_gboth_sdfull_ng
Xnfet_01v8_lvt_W1p4_L0p6_m8__nf1_gtop_sdfull_ng_0 VSS_body bias_b bias_b bias_b nfet_01v8_lvt_W1p4_L0p6_m8__nf1_gtop_sdfull_ng
Xnfet_01v8_lvt_W1p4_L0p6_m56__nf1_gboth_sdfull_ng_1 VSS_body bias_b bias_b bias_c
+ nfet_01v8_lvt_W1p4_L0p6_m56__nf1_gboth_sdfull_ng
Xnfet_01v8_lvt_W1p4_L0p6_m8__nf1_gtop_sdfull_ng_1 VSS_body bias_b bias_b bias_b nfet_01v8_lvt_W1p4_L0p6_m8__nf1_gtop_sdfull_ng
Xnfet_01v8_lvt_W1p4_L0p6_m56__nf1_gboth_sdfull_ng_2 VSS_body bias_b bias_b bias_c
+ nfet_01v8_lvt_W1p4_L0p6_m56__nf1_gboth_sdfull_ng
Xnfet_01v8_lvt_W1p4_L0p6_m8__nf1_gtop_sdfull_ng_2 VSS_body bias_b bias_b bias_b nfet_01v8_lvt_W1p4_L0p6_m8__nf1_gtop_sdfull_ng
Xnfet_01v8_lvt_W1p4_L0p6_m56__nf1_gboth_sdfull_ng_3 VSS_body bias_b bias_b bias_c
+ nfet_01v8_lvt_W1p4_L0p6_m56__nf1_gboth_sdfull_ng
Xnfet_01v8_lvt_W1p4_L0p6_m8__nf1_gtop_sdfull_ng_3 VSS_body bias_b bias_b bias_b nfet_01v8_lvt_W1p4_L0p6_m8__nf1_gtop_sdfull_ng
Xnfet_01v8_lvt_W1p4_L0p6_m56__nf1_gboth_sdfull_ng_4 VSS_body bias_b bias_b bias_c
+ nfet_01v8_lvt_W1p4_L0p6_m56__nf1_gboth_sdfull_ng
Xnfet_01v8_lvt_W1p4_L0p6_m56__nf1_gboth_sdfull_ng_5 VSS_body bias_b bias_b bias_c
+ nfet_01v8_lvt_W1p4_L0p6_m56__nf1_gboth_sdfull_ng
Xnfet_01v8_lvt_W1p4_L0p6_m8__nf1_gtop_sdfull_ng_5 VSS_body bias_b bias_b bias_b nfet_01v8_lvt_W1p4_L0p6_m8__nf1_gtop_sdfull_ng
Xnfet_01v8_lvt_W1p4_L0p6_m8__nf1_gtop_sdfull_ng_4 VSS_body bias_b bias_b bias_b nfet_01v8_lvt_W1p4_L0p6_m8__nf1_gtop_sdfull_ng
Xnfet_01v8_lvt_W1p4_L0p6_m56__nf1_gboth_sdfull_ng_6 VSS_body bias_b bias_b bias_c
+ nfet_01v8_lvt_W1p4_L0p6_m56__nf1_gboth_sdfull_ng
Xnfet_01v8_lvt_W1p4_L0p6_m8__nf1_gtop_sdfull_ng_6 VSS_body bias_b bias_b bias_b nfet_01v8_lvt_W1p4_L0p6_m8__nf1_gtop_sdfull_ng
Xnfet_01v8_lvt_W1p4_L0p6_m56__nf1_gboth_sdfull_ng_7 VSS_body bias_b bias_b bias_c
+ nfet_01v8_lvt_W1p4_L0p6_m56__nf1_gboth_sdfull_ng
Xnfet_01v8_lvt_W1p4_L0p6_m8__nf1_gtop_sdfull_ng_7 VSS_body bias_b bias_b bias_b nfet_01v8_lvt_W1p4_L0p6_m8__nf1_gtop_sdfull_ng
Xnfet_01v8_lvt_W1p4_L0p6_m56__nf1_gboth_sdfull_ng_8 VSS_body bias_b bias_b bias_c
+ nfet_01v8_lvt_W1p4_L0p6_m56__nf1_gboth_sdfull_ng
Xnfet_01v8_lvt_W1p4_L0p6_m56__nf1_gboth_sdfull_ng_9 VSS_body bias_b bias_b bias_c
+ nfet_01v8_lvt_W1p4_L0p6_m56__nf1_gboth_sdfull_ng
Xnfet_01v8_lvt_W1p4_L0p6_m56__nf1_gboth_sdfull_ng_50 VSS_body bias_b bias_b bias_c
+ nfet_01v8_lvt_W1p4_L0p6_m56__nf1_gboth_sdfull_ng
Xnfet_01v8_lvt_W1p4_L0p6_m56__nf1_gboth_sdfull_ng_30 VSS_body bias_b bias_b bias_c
+ nfet_01v8_lvt_W1p4_L0p6_m56__nf1_gboth_sdfull_ng
Xnfet_01v8_lvt_W1p4_L0p6_m56__nf1_gboth_sdfull_ng_40 VSS_body bias_b bias_b bias_c
+ nfet_01v8_lvt_W1p4_L0p6_m56__nf1_gboth_sdfull_ng
Xnfet_01v8_lvt_W1p4_L0p6_m56__nf1_gboth_sdfull_ng_41 VSS_body bias_b bias_b bias_c
+ nfet_01v8_lvt_W1p4_L0p6_m56__nf1_gboth_sdfull_ng
Xnfet_01v8_lvt_W1p4_L0p6_m56__nf1_gboth_sdfull_ng_51 VSS_body bias_b bias_b bias_c
+ nfet_01v8_lvt_W1p4_L0p6_m56__nf1_gboth_sdfull_ng
Xnfet_01v8_lvt_W1p4_L0p6_m56__nf1_gboth_sdfull_ng_52 VSS_body bias_b bias_b bias_c
+ nfet_01v8_lvt_W1p4_L0p6_m56__nf1_gboth_sdfull_ng
Xnfet_01v8_lvt_W1p4_L0p6_m56__nf1_gboth_sdfull_ng_20 VSS_body bias_b bias_b bias_c
+ nfet_01v8_lvt_W1p4_L0p6_m56__nf1_gboth_sdfull_ng
Xnfet_01v8_lvt_W1p4_L0p6_m56__nf1_gboth_sdfull_ng_31 VSS_body bias_b bias_b bias_c
+ nfet_01v8_lvt_W1p4_L0p6_m56__nf1_gboth_sdfull_ng
Xnfet_01v8_lvt_W1p4_L0p6_m56__nf1_gboth_sdfull_ng_42 VSS_body bias_b bias_b bias_c
+ nfet_01v8_lvt_W1p4_L0p6_m56__nf1_gboth_sdfull_ng
Xnfet_01v8_lvt_W1p4_L0p6_m56__nf1_gboth_sdfull_ng_53 VSS_body bias_b bias_b bias_c
+ nfet_01v8_lvt_W1p4_L0p6_m56__nf1_gboth_sdfull_ng
Xnfet_01v8_lvt_W1p4_L0p6_m56__nf1_gboth_sdfull_ng_10 VSS_body bias_b bias_b bias_c
+ nfet_01v8_lvt_W1p4_L0p6_m56__nf1_gboth_sdfull_ng
Xnfet_01v8_lvt_W1p4_L0p6_m56__nf1_gboth_sdfull_ng_21 VSS_body bias_b bias_b bias_c
+ nfet_01v8_lvt_W1p4_L0p6_m56__nf1_gboth_sdfull_ng
Xnfet_01v8_lvt_W1p4_L0p6_m56__nf1_gboth_sdfull_ng_32 VSS_body bias_b bias_b bias_c
+ nfet_01v8_lvt_W1p4_L0p6_m56__nf1_gboth_sdfull_ng
Xnfet_01v8_lvt_W1p4_L0p6_m56__nf1_gboth_sdfull_ng_43 VSS_body bias_b bias_b bias_c
+ nfet_01v8_lvt_W1p4_L0p6_m56__nf1_gboth_sdfull_ng
Xnfet_01v8_lvt_W1p4_L0p6_m56__nf1_gboth_sdfull_ng_54 VSS_body bias_b bias_b bias_c
+ nfet_01v8_lvt_W1p4_L0p6_m56__nf1_gboth_sdfull_ng
Xnfet_01v8_lvt_W1p4_L0p6_m56__nf1_gboth_sdfull_ng_11 VSS_body bias_b bias_b bias_c
+ nfet_01v8_lvt_W1p4_L0p6_m56__nf1_gboth_sdfull_ng
Xnfet_01v8_lvt_W1p4_L0p6_m56__nf1_gboth_sdfull_ng_22 VSS_body bias_b bias_b bias_c
+ nfet_01v8_lvt_W1p4_L0p6_m56__nf1_gboth_sdfull_ng
Xnfet_01v8_lvt_W1p4_L0p6_m56__nf1_gboth_sdfull_ng_33 VSS_body bias_b bias_b bias_c
+ nfet_01v8_lvt_W1p4_L0p6_m56__nf1_gboth_sdfull_ng
Xnfet_01v8_lvt_W1p4_L0p6_m56__nf1_gboth_sdfull_ng_44 VSS_body bias_b bias_b bias_c
+ nfet_01v8_lvt_W1p4_L0p6_m56__nf1_gboth_sdfull_ng
Xnfet_01v8_lvt_W1p4_L0p6_m56__nf1_gboth_sdfull_ng_55 VSS_body bias_b bias_b bias_c
+ nfet_01v8_lvt_W1p4_L0p6_m56__nf1_gboth_sdfull_ng
Xnfet_01v8_lvt_W1p4_L0p6_m56__nf1_gboth_sdfull_ng_12 VSS_body bias_b bias_b bias_c
+ nfet_01v8_lvt_W1p4_L0p6_m56__nf1_gboth_sdfull_ng
Xnfet_01v8_lvt_W1p4_L0p6_m56__nf1_gboth_sdfull_ng_23 VSS_body bias_b bias_b bias_c
+ nfet_01v8_lvt_W1p4_L0p6_m56__nf1_gboth_sdfull_ng
Xnfet_01v8_lvt_W1p4_L0p6_m56__nf1_gboth_sdfull_ng_34 VSS_body bias_b bias_b bias_c
+ nfet_01v8_lvt_W1p4_L0p6_m56__nf1_gboth_sdfull_ng
Xnfet_01v8_lvt_W1p4_L0p6_m56__nf1_gboth_sdfull_ng_45 VSS_body bias_b bias_b bias_c
+ nfet_01v8_lvt_W1p4_L0p6_m56__nf1_gboth_sdfull_ng
.ends

.subckt x1_single_m5__f3 VSS bias_a x1_m5d VSS_body
Xnfet_01v8_W1p4_L0p6_m18__nf1_gboth_sdfull_ng_0 bias_a VSS_body x1_m5d VSS nfet_01v8_W1p4_L0p6_m18__nf1_gboth_sdfull_ng
Xnfet_01v8_W1p4_L0p6_m18__nf1_gboth_sdfull_ng_11 bias_a VSS_body x1_m5d VSS nfet_01v8_W1p4_L0p6_m18__nf1_gboth_sdfull_ng
Xnfet_01v8_W1p4_L0p6_m18__nf1_gboth_sdfull_ng_10 bias_a VSS_body x1_m5d VSS nfet_01v8_W1p4_L0p6_m18__nf1_gboth_sdfull_ng
Xnfet_01v8_W1p4_L0p6_m18__nf1_gboth_sdfull_ng_2 bias_a VSS_body x1_m5d VSS nfet_01v8_W1p4_L0p6_m18__nf1_gboth_sdfull_ng
Xnfet_01v8_W1p4_L0p6_m18__nf1_gboth_sdfull_ng_1 bias_a VSS_body x1_m5d VSS nfet_01v8_W1p4_L0p6_m18__nf1_gboth_sdfull_ng
Xnfet_01v8_W1p4_L0p6_m18__nf1_gboth_sdfull_ng_12 bias_a VSS_body x1_m5d VSS nfet_01v8_W1p4_L0p6_m18__nf1_gboth_sdfull_ng
Xnfet_01v8_W1p4_L0p6_m18__nf1_gboth_sdfull_ng_3 bias_a VSS_body x1_m5d VSS nfet_01v8_W1p4_L0p6_m18__nf1_gboth_sdfull_ng
Xnfet_01v8_W1p4_L0p6_m6__nf1_gtop_sdfull_ng_0 VSS_body x1_m5d x1_m5d x1_m5d nfet_01v8_W1p4_L0p6_m6__nf1_gtop_sdfull_ng
Xnfet_01v8_W1p4_L0p6_m18__nf1_gboth_sdfull_ng_13 bias_a VSS_body x1_m5d VSS nfet_01v8_W1p4_L0p6_m18__nf1_gboth_sdfull_ng
Xnfet_01v8_W1p4_L0p6_m18__nf1_gboth_sdfull_ng_4 bias_a VSS_body x1_m5d VSS nfet_01v8_W1p4_L0p6_m18__nf1_gboth_sdfull_ng
Xnfet_01v8_W1p4_L0p6_m6__nf1_gtop_sdfull_ng_1 VSS_body VSS x1_m5d VSS nfet_01v8_W1p4_L0p6_m6__nf1_gtop_sdfull_ng
Xnfet_01v8_W1p4_L0p6_m18__nf1_gboth_sdfull_ng_14 bias_a VSS_body x1_m5d VSS nfet_01v8_W1p4_L0p6_m18__nf1_gboth_sdfull_ng
Xnfet_01v8_W1p4_L0p6_m18__nf1_gboth_sdfull_ng_5 bias_a VSS_body x1_m5d VSS nfet_01v8_W1p4_L0p6_m18__nf1_gboth_sdfull_ng
Xnfet_01v8_W1p4_L0p6_m6__nf1_gtop_sdfull_ng_2 VSS_body x1_m5d x1_m5d x1_m5d nfet_01v8_W1p4_L0p6_m6__nf1_gtop_sdfull_ng
Xnfet_01v8_W1p4_L0p6_m18__nf1_gboth_sdfull_ng_15 bias_a VSS_body x1_m5d VSS nfet_01v8_W1p4_L0p6_m18__nf1_gboth_sdfull_ng
Xnfet_01v8_W1p4_L0p6_m18__nf1_gboth_sdfull_ng_6 bias_a VSS_body x1_m5d VSS nfet_01v8_W1p4_L0p6_m18__nf1_gboth_sdfull_ng
Xnfet_01v8_W1p4_L0p6_m6__nf1_gtop_sdfull_ng_3 VSS_body VSS x1_m5d VSS nfet_01v8_W1p4_L0p6_m6__nf1_gtop_sdfull_ng
Xnfet_01v8_W1p4_L0p6_m18__nf1_gboth_sdfull_ng_16 bias_a VSS_body x1_m5d VSS nfet_01v8_W1p4_L0p6_m18__nf1_gboth_sdfull_ng
Xnfet_01v8_W1p4_L0p6_m18__nf1_gboth_sdfull_ng_7 bias_a VSS_body x1_m5d VSS nfet_01v8_W1p4_L0p6_m18__nf1_gboth_sdfull_ng
Xnfet_01v8_W1p4_L0p6_m6__nf1_gtop_sdfull_ng_4 VSS_body x1_m5d x1_m5d x1_m5d nfet_01v8_W1p4_L0p6_m6__nf1_gtop_sdfull_ng
Xnfet_01v8_W1p4_L0p6_m18__nf1_gboth_sdfull_ng_17 bias_a VSS_body x1_m5d VSS nfet_01v8_W1p4_L0p6_m18__nf1_gboth_sdfull_ng
Xnfet_01v8_W1p4_L0p6_m18__nf1_gboth_sdfull_ng_8 bias_a VSS_body x1_m5d VSS nfet_01v8_W1p4_L0p6_m18__nf1_gboth_sdfull_ng
Xnfet_01v8_W1p4_L0p6_m6__nf1_gtop_sdfull_ng_5 VSS_body VSS x1_m5d VSS nfet_01v8_W1p4_L0p6_m6__nf1_gtop_sdfull_ng
Xnfet_01v8_W1p4_L0p6_m18__nf1_gboth_sdfull_ng_9 bias_a VSS_body x1_m5d VSS nfet_01v8_W1p4_L0p6_m18__nf1_gboth_sdfull_ng
Xnfet_01v8_W1p4_L0p6_m6__nf1_gtop_sdfull_ng_6 VSS_body x1_m5d x1_m5d x1_m5d nfet_01v8_W1p4_L0p6_m6__nf1_gtop_sdfull_ng
Xnfet_01v8_W1p4_L0p6_m6__nf1_gtop_sdfull_ng_8 VSS_body x1_m5d x1_m5d x1_m5d nfet_01v8_W1p4_L0p6_m6__nf1_gtop_sdfull_ng
Xnfet_01v8_W1p4_L0p6_m6__nf1_gtop_sdfull_ng_7 VSS_body VSS x1_m5d VSS nfet_01v8_W1p4_L0p6_m6__nf1_gtop_sdfull_ng
Xnfet_01v8_W1p4_L0p6_m6__nf1_gtop_sdfull_ng_9 VSS_body VSS x1_m5d VSS nfet_01v8_W1p4_L0p6_m6__nf1_gtop_sdfull_ng
Xnfet_01v8_W1p4_L0p6_m6__nf1_gtop_sdfull_ng_10 VSS_body x1_m5d x1_m5d x1_m5d nfet_01v8_W1p4_L0p6_m6__nf1_gtop_sdfull_ng
Xnfet_01v8_W1p4_L0p6_m6__nf1_gtop_sdfull_ng_11 VSS_body VSS x1_m5d VSS nfet_01v8_W1p4_L0p6_m6__nf1_gtop_sdfull_ng
.ends

.subckt nfet_01v8_W1p4_L0p6_m1__nf1_gboth_sdfull_ng B G D S
Xnfet_01v8_W1p4_L0p6_m1__nf1_gboth_sdfull_ng_pc G D S B sky130_fd_pr__nfet_01v8_KCM6UP
.ends

.subckt x1_cc_cm__strings1 cm VSS VSS_body
Xnfet_01v8_W1p4_L0p6_m1__nf1_gboth_sdfull_ng_0 VSS_body cm cm x1_net1 nfet_01v8_W1p4_L0p6_m1__nf1_gboth_sdfull_ng
Xnfet_01v8_W1p4_L0p6_m1__nf1_gboth_sdfull_ng_1 VSS_body cm x1_net1 x1_net2 nfet_01v8_W1p4_L0p6_m1__nf1_gboth_sdfull_ng
Xnfet_01v8_W1p4_L0p6_m1__nf1_gboth_sdfull_ng_2 VSS_body cm x1_net2 x1_net3 nfet_01v8_W1p4_L0p6_m1__nf1_gboth_sdfull_ng
Xnfet_01v8_W1p4_L0p6_m1__nf1_gboth_sdfull_ng_3 VSS_body cm x1_net3 VSS nfet_01v8_W1p4_L0p6_m1__nf1_gboth_sdfull_ng
Xnfet_01v8_W1p4_L0p6_m1__nf1_gboth_sdfull_ng_10 VSS_body cm x1_net5 x1_net6 nfet_01v8_W1p4_L0p6_m1__nf1_gboth_sdfull_ng
Xnfet_01v8_W1p4_L0p6_m1__nf1_gboth_sdfull_ng_4 VSS_body cm cm x1_net13 nfet_01v8_W1p4_L0p6_m1__nf1_gboth_sdfull_ng
Xnfet_01v8_W1p4_L0p6_m1__nf1_gboth_sdfull_ng_11 VSS_body cm x1_net6 VSS nfet_01v8_W1p4_L0p6_m1__nf1_gboth_sdfull_ng
Xnfet_01v8_W1p4_L0p6_m1__nf1_gboth_sdfull_ng_5 VSS_body cm x1_net13 x1_net14 nfet_01v8_W1p4_L0p6_m1__nf1_gboth_sdfull_ng
Xnfet_01v8_W1p4_L0p6_m1__nf1_gboth_sdfull_ng_12 VSS_body cm cm x1_net7 nfet_01v8_W1p4_L0p6_m1__nf1_gboth_sdfull_ng
Xnfet_01v8_W1p4_L0p6_m1__nf1_gboth_sdfull_ng_6 VSS_body cm x1_net14 x1_net15 nfet_01v8_W1p4_L0p6_m1__nf1_gboth_sdfull_ng
Xnfet_01v8_W1p4_L0p6_m1__nf1_gboth_sdfull_ng_13 VSS_body cm x1_net7 x1_net8 nfet_01v8_W1p4_L0p6_m1__nf1_gboth_sdfull_ng
Xnfet_01v8_W1p4_L0p6_m1__nf1_gboth_sdfull_ng_7 VSS_body cm x1_net15 VSS nfet_01v8_W1p4_L0p6_m1__nf1_gboth_sdfull_ng
Xnfet_01v8_W1p4_L0p6_m1__nf1_gboth_sdfull_ng_14 VSS_body cm x1_net8 x1_net9 nfet_01v8_W1p4_L0p6_m1__nf1_gboth_sdfull_ng
Xnfet_01v8_W1p4_L0p6_m1__nf1_gboth_sdfull_ng_8 VSS_body cm cm x1_net4 nfet_01v8_W1p4_L0p6_m1__nf1_gboth_sdfull_ng
Xnfet_01v8_W1p4_L0p6_m1__nf1_gboth_sdfull_ng_9 VSS_body cm x1_net4 x1_net5 nfet_01v8_W1p4_L0p6_m1__nf1_gboth_sdfull_ng
Xnfet_01v8_W1p4_L0p6_m1__nf1_gboth_sdfull_ng_15 VSS_body cm x1_net9 VSS nfet_01v8_W1p4_L0p6_m1__nf1_gboth_sdfull_ng
Xnfet_01v8_W1p4_L0p6_m1__nf1_gboth_sdfull_ng_16 VSS_body cm cm x1_net10 nfet_01v8_W1p4_L0p6_m1__nf1_gboth_sdfull_ng
Xnfet_01v8_W1p4_L0p6_m1__nf1_gboth_sdfull_ng_17 VSS_body cm x1_net10 x1_net11 nfet_01v8_W1p4_L0p6_m1__nf1_gboth_sdfull_ng
Xnfet_01v8_W1p4_L0p6_m1__nf1_gboth_sdfull_ng_18 VSS_body cm x1_net11 x1_net12 nfet_01v8_W1p4_L0p6_m1__nf1_gboth_sdfull_ng
Xnfet_01v8_W1p4_L0p6_m1__nf1_gboth_sdfull_ng_19 VSS_body cm x1_net12 VSS nfet_01v8_W1p4_L0p6_m1__nf1_gboth_sdfull_ng
Xnfet_01v8_W1p4_L0p6_m8__nf1_gtop_sdfull_ng_0 VSS_body cm cm cm nfet_01v8_W1p4_L0p6_m8__nf1_gtop_sdfull_ng
Xnfet_01v8_W1p4_L0p6_m8__nf1_gtop_sdfull_ng_1 VSS_body cm cm cm nfet_01v8_W1p4_L0p6_m8__nf1_gtop_sdfull_ng
Xnfet_01v8_W1p4_L0p6_m8__nf1_gtop_sdfull_ng_2 VSS_body cm cm cm nfet_01v8_W1p4_L0p6_m8__nf1_gtop_sdfull_ng
Xnfet_01v8_W1p4_L0p6_m8__nf1_gtop_sdfull_ng_3 VSS_body cm cm cm nfet_01v8_W1p4_L0p6_m8__nf1_gtop_sdfull_ng
Xnfet_01v8_W1p4_L0p6_m8__nf1_gtop_sdfull_ng_5 VSS_body cm cm cm nfet_01v8_W1p4_L0p6_m8__nf1_gtop_sdfull_ng
Xnfet_01v8_W1p4_L0p6_m8__nf1_gtop_sdfull_ng_4 VSS_body cm cm cm nfet_01v8_W1p4_L0p6_m8__nf1_gtop_sdfull_ng
Xnfet_01v8_W1p4_L0p6_m8__nf1_gtop_sdfull_ng_6 VSS_body cm cm cm nfet_01v8_W1p4_L0p6_m8__nf1_gtop_sdfull_ng
Xnfet_01v8_W1p4_L0p6_m8__nf1_gtop_sdfull_ng_7 VSS_body cm cm cm nfet_01v8_W1p4_L0p6_m8__nf1_gtop_sdfull_ng
.ends

.subckt nfet_01v8_W1p4_L0p6_m4__nf1_gtop_sdfull_ng B S G D
Xnfet_01v8_W1p4_L0p6_m4__nf1_gtop_sdfull_ng_pc G D S B sky130_fd_pr__nfet_01v8_RUA5M6
.ends

.subckt x1_single_m4__f1 x1_m5d bias_a VSS_body bias_d
Xnfet_01v8_W1p4_L0p6_m18__nf1_gboth_sdfull_ng_0 bias_d VSS_body bias_a x1_m5d nfet_01v8_W1p4_L0p6_m18__nf1_gboth_sdfull_ng
Xnfet_01v8_W1p4_L0p6_m18__nf1_gboth_sdfull_ng_11 bias_d VSS_body bias_a x1_m5d nfet_01v8_W1p4_L0p6_m18__nf1_gboth_sdfull_ng
Xnfet_01v8_W1p4_L0p6_m18__nf1_gboth_sdfull_ng_10 bias_d VSS_body bias_a x1_m5d nfet_01v8_W1p4_L0p6_m18__nf1_gboth_sdfull_ng
Xnfet_01v8_W1p4_L0p6_m18__nf1_gboth_sdfull_ng_2 bias_d VSS_body bias_a x1_m5d nfet_01v8_W1p4_L0p6_m18__nf1_gboth_sdfull_ng
Xnfet_01v8_W1p4_L0p6_m18__nf1_gboth_sdfull_ng_1 bias_d VSS_body bias_a x1_m5d nfet_01v8_W1p4_L0p6_m18__nf1_gboth_sdfull_ng
Xnfet_01v8_W1p4_L0p6_m18__nf1_gboth_sdfull_ng_12 bias_d VSS_body bias_a x1_m5d nfet_01v8_W1p4_L0p6_m18__nf1_gboth_sdfull_ng
Xnfet_01v8_W1p4_L0p6_m18__nf1_gboth_sdfull_ng_3 bias_d VSS_body bias_a x1_m5d nfet_01v8_W1p4_L0p6_m18__nf1_gboth_sdfull_ng
Xnfet_01v8_W1p4_L0p6_m18__nf1_gboth_sdfull_ng_13 bias_d VSS_body bias_a x1_m5d nfet_01v8_W1p4_L0p6_m18__nf1_gboth_sdfull_ng
Xnfet_01v8_W1p4_L0p6_m18__nf1_gboth_sdfull_ng_4 bias_d VSS_body bias_a x1_m5d nfet_01v8_W1p4_L0p6_m18__nf1_gboth_sdfull_ng
Xnfet_01v8_W1p4_L0p6_m18__nf1_gboth_sdfull_ng_14 bias_d VSS_body bias_a x1_m5d nfet_01v8_W1p4_L0p6_m18__nf1_gboth_sdfull_ng
Xnfet_01v8_W1p4_L0p6_m18__nf1_gboth_sdfull_ng_5 bias_d VSS_body bias_a x1_m5d nfet_01v8_W1p4_L0p6_m18__nf1_gboth_sdfull_ng
Xnfet_01v8_W1p4_L0p6_m18__nf1_gboth_sdfull_ng_15 bias_d VSS_body bias_a x1_m5d nfet_01v8_W1p4_L0p6_m18__nf1_gboth_sdfull_ng
Xnfet_01v8_W1p4_L0p6_m18__nf1_gboth_sdfull_ng_6 bias_d VSS_body bias_a x1_m5d nfet_01v8_W1p4_L0p6_m18__nf1_gboth_sdfull_ng
Xnfet_01v8_W1p4_L0p6_m18__nf1_gboth_sdfull_ng_16 bias_d VSS_body bias_a x1_m5d nfet_01v8_W1p4_L0p6_m18__nf1_gboth_sdfull_ng
Xnfet_01v8_W1p4_L0p6_m18__nf1_gboth_sdfull_ng_7 bias_d VSS_body bias_a x1_m5d nfet_01v8_W1p4_L0p6_m18__nf1_gboth_sdfull_ng
Xnfet_01v8_W1p4_L0p6_m18__nf1_gboth_sdfull_ng_17 bias_d VSS_body bias_a x1_m5d nfet_01v8_W1p4_L0p6_m18__nf1_gboth_sdfull_ng
Xnfet_01v8_W1p4_L0p6_m18__nf1_gboth_sdfull_ng_8 bias_d VSS_body bias_a x1_m5d nfet_01v8_W1p4_L0p6_m18__nf1_gboth_sdfull_ng
Xnfet_01v8_W1p4_L0p6_m18__nf1_gboth_sdfull_ng_9 bias_d VSS_body bias_a x1_m5d nfet_01v8_W1p4_L0p6_m18__nf1_gboth_sdfull_ng
Xnfet_01v8_W1p4_L0p6_m4__nf1_gtop_sdfull_ng_0 VSS_body bias_a bias_a bias_a nfet_01v8_W1p4_L0p6_m4__nf1_gtop_sdfull_ng
Xnfet_01v8_W1p4_L0p6_m4__nf1_gtop_sdfull_ng_1 VSS_body bias_a bias_a bias_a nfet_01v8_W1p4_L0p6_m4__nf1_gtop_sdfull_ng
Xnfet_01v8_W1p4_L0p6_m4__nf1_gtop_sdfull_ng_2 VSS_body bias_a bias_a bias_a nfet_01v8_W1p4_L0p6_m4__nf1_gtop_sdfull_ng
Xnfet_01v8_W1p4_L0p6_m4__nf1_gtop_sdfull_ng_3 VSS_body bias_a bias_a bias_a nfet_01v8_W1p4_L0p6_m4__nf1_gtop_sdfull_ng
.ends

.subckt x1_single_m3__f1 bias_a x1_m2d bias_d VSS_body
Xnfet_01v8_W1p4_L0p6_m2__nf1_gboth_sdfull_ng_0 VSS_body bias_a x1_m2d bias_d nfet_01v8_W1p4_L0p6_m2__nf1_gboth_sdfull_ng
Xnfet_01v8_W1p4_L0p6_m2__nf1_gboth_sdfull_ng_1 VSS_body bias_a x1_m2d bias_d nfet_01v8_W1p4_L0p6_m2__nf1_gboth_sdfull_ng
Xnfet_01v8_W1p4_L0p6_m8__nf1_gtop_sdfull_ng_0 VSS_body bias_d bias_d bias_d nfet_01v8_W1p4_L0p6_m8__nf1_gtop_sdfull_ng
Xnfet_01v8_W1p4_L0p6_m8__nf1_gtop_sdfull_ng_1 VSS_body bias_d bias_d bias_d nfet_01v8_W1p4_L0p6_m8__nf1_gtop_sdfull_ng
Xnfet_01v8_W1p4_L0p6_m8__nf1_gtop_sdfull_ng_2 VSS_body bias_d bias_d bias_d nfet_01v8_W1p4_L0p6_m8__nf1_gtop_sdfull_ng
Xnfet_01v8_W1p4_L0p6_m8__nf1_gtop_sdfull_ng_3 VSS_body bias_d bias_d bias_d nfet_01v8_W1p4_L0p6_m8__nf1_gtop_sdfull_ng
Xnfet_01v8_W1p4_L0p6_m8__nf1_gtop_sdfull_ng_5 VSS_body bias_d bias_d bias_d nfet_01v8_W1p4_L0p6_m8__nf1_gtop_sdfull_ng
Xnfet_01v8_W1p4_L0p6_m8__nf1_gtop_sdfull_ng_4 VSS_body bias_d bias_d bias_d nfet_01v8_W1p4_L0p6_m8__nf1_gtop_sdfull_ng
Xnfet_01v8_W1p4_L0p6_m8__nf1_gtop_sdfull_ng_6 VSS_body bias_d bias_d bias_d nfet_01v8_W1p4_L0p6_m8__nf1_gtop_sdfull_ng
Xnfet_01v8_W1p4_L0p6_m8__nf1_gtop_sdfull_ng_7 VSS_body bias_d bias_d bias_d nfet_01v8_W1p4_L0p6_m8__nf1_gtop_sdfull_ng
.ends

.subckt sky130_fd_pr__nfet_01v8_lvt_A2K2V3 G D S VSUBS
X0 S G D VSUBS sky130_fd_pr__nfet_01v8_lvt ad=0.348 pd=2.98 as=0.348 ps=2.98 w=1.2 l=0.2
.ends

.subckt nfet_01v8_lvt_W1p2_L0p2_m6__nf1_gboth_sdfull_ng G B D S
Xnfet_01v8_lvt_W1p2_L0p2_m6__nf1_gboth_sdfull_ng_pc G D S B sky130_fd_pr__nfet_01v8_lvt_A2K2V3
.ends

.subckt sky130_fd_pr__nfet_01v8_lvt_CWMMG4 G D S VSUBS
X0 S G D VSUBS sky130_fd_pr__nfet_01v8_lvt ad=0.348 pd=2.98 as=0.348 ps=2.98 w=1.2 l=0.2
.ends

.subckt nfet_01v8_lvt_W1p2_L0p2_m2__nf1_gtop_sdfull_ng B G D S
Xnfet_01v8_lvt_W1p2_L0p2_m2__nf1_gtop_sdfull_ng_pc G D S B sky130_fd_pr__nfet_01v8_lvt_CWMMG4
.ends

.subckt x2_diff__cc3 VSS ip x2_tail in VSS_body x2_foldn x2_foldp
Xnfet_01v8_lvt_W1p2_L0p2_m6__nf1_gboth_sdfull_ng_10 in VSS_body x2_foldn x2_tail nfet_01v8_lvt_W1p2_L0p2_m6__nf1_gboth_sdfull_ng
Xnfet_01v8_lvt_W1p2_L0p2_m6__nf1_gboth_sdfull_ng_11 in VSS_body x2_foldn x2_tail nfet_01v8_lvt_W1p2_L0p2_m6__nf1_gboth_sdfull_ng
Xnfet_01v8_lvt_W1p2_L0p2_m6__nf1_gboth_sdfull_ng_12 ip VSS_body x2_foldp x2_tail nfet_01v8_lvt_W1p2_L0p2_m6__nf1_gboth_sdfull_ng
Xnfet_01v8_lvt_W1p2_L0p2_m6__nf1_gboth_sdfull_ng_13 VSS VSS_body VSS VSS nfet_01v8_lvt_W1p2_L0p2_m6__nf1_gboth_sdfull_ng
Xnfet_01v8_lvt_W1p2_L0p2_m6__nf1_gboth_sdfull_ng_0 ip VSS_body x2_foldp x2_tail nfet_01v8_lvt_W1p2_L0p2_m6__nf1_gboth_sdfull_ng
Xnfet_01v8_lvt_W1p2_L0p2_m6__nf1_gboth_sdfull_ng_1 in VSS_body x2_foldn x2_tail nfet_01v8_lvt_W1p2_L0p2_m6__nf1_gboth_sdfull_ng
Xnfet_01v8_lvt_W1p2_L0p2_m6__nf1_gboth_sdfull_ng_2 in VSS_body x2_foldn x2_tail nfet_01v8_lvt_W1p2_L0p2_m6__nf1_gboth_sdfull_ng
Xnfet_01v8_lvt_W1p2_L0p2_m6__nf1_gboth_sdfull_ng_3 ip VSS_body x2_foldp x2_tail nfet_01v8_lvt_W1p2_L0p2_m6__nf1_gboth_sdfull_ng
Xnfet_01v8_lvt_W1p2_L0p2_m6__nf1_gboth_sdfull_ng_4 ip VSS_body x2_foldp x2_tail nfet_01v8_lvt_W1p2_L0p2_m6__nf1_gboth_sdfull_ng
Xnfet_01v8_lvt_W1p2_L0p2_m6__nf1_gboth_sdfull_ng_5 in VSS_body x2_foldn x2_tail nfet_01v8_lvt_W1p2_L0p2_m6__nf1_gboth_sdfull_ng
Xnfet_01v8_lvt_W1p2_L0p2_m6__nf1_gboth_sdfull_ng_6 in VSS_body x2_foldn x2_tail nfet_01v8_lvt_W1p2_L0p2_m6__nf1_gboth_sdfull_ng
Xnfet_01v8_lvt_W1p2_L0p2_m2__nf1_gtop_sdfull_ng_0 VSS_body x2_foldp x2_foldp x2_foldp
+ nfet_01v8_lvt_W1p2_L0p2_m2__nf1_gtop_sdfull_ng
Xnfet_01v8_lvt_W1p2_L0p2_m6__nf1_gboth_sdfull_ng_7 ip VSS_body x2_foldp x2_tail nfet_01v8_lvt_W1p2_L0p2_m6__nf1_gboth_sdfull_ng
Xnfet_01v8_lvt_W1p2_L0p2_m2__nf1_gtop_sdfull_ng_1 VSS_body x2_foldp x2_foldp x2_foldp
+ nfet_01v8_lvt_W1p2_L0p2_m2__nf1_gtop_sdfull_ng
Xnfet_01v8_lvt_W1p2_L0p2_m6__nf1_gboth_sdfull_ng_8 VSS VSS_body VSS VSS nfet_01v8_lvt_W1p2_L0p2_m6__nf1_gboth_sdfull_ng
Xnfet_01v8_lvt_W1p2_L0p2_m2__nf1_gtop_sdfull_ng_2 VSS_body x2_foldn x2_foldn x2_foldn
+ nfet_01v8_lvt_W1p2_L0p2_m2__nf1_gtop_sdfull_ng
Xnfet_01v8_lvt_W1p2_L0p2_m6__nf1_gboth_sdfull_ng_9 ip VSS_body x2_foldp x2_tail nfet_01v8_lvt_W1p2_L0p2_m6__nf1_gboth_sdfull_ng
Xnfet_01v8_lvt_W1p2_L0p2_m2__nf1_gtop_sdfull_ng_3 VSS_body x2_foldn x2_foldn x2_foldn
+ nfet_01v8_lvt_W1p2_L0p2_m2__nf1_gtop_sdfull_ng
.ends

.subckt x1_cm_bias_c__cc1 VDD cm x1_m25d x1_m2d x1_m31d VDD_body x1_m21d bias_b bias_c
Xpfet_01v8_W1p4_L0p6_m2__nf1_gtop_sdfull_ng_0 VDD VDD_body VDD bias_b pfet_01v8_W1p4_L0p6_m2__nf1_gtop_sdfull_ng
Xpfet_01v8_W1p4_L0p6_m2__nf1_gtop_sdfull_ng_1 VDD VDD_body VDD x1_m2d pfet_01v8_W1p4_L0p6_m2__nf1_gtop_sdfull_ng
Xpfet_01v8_W1p4_L0p6_m2__nf1_gtop_sdfull_ng_2 VDD VDD_body VDD cm pfet_01v8_W1p4_L0p6_m2__nf1_gtop_sdfull_ng
Xpfet_01v8_W1p4_L0p6_m2__nf1_gtop_sdfull_ng_4 VDD VDD_body VDD x1_m2d pfet_01v8_W1p4_L0p6_m2__nf1_gtop_sdfull_ng
Xpfet_01v8_W1p4_L0p6_m2__nf1_gtop_sdfull_ng_3 VDD VDD_body VDD bias_b pfet_01v8_W1p4_L0p6_m2__nf1_gtop_sdfull_ng
Xpfet_01v8_W1p4_L0p6_m2__nf1_gtop_sdfull_ng_5 VDD VDD_body VDD cm pfet_01v8_W1p4_L0p6_m2__nf1_gtop_sdfull_ng
Xpfet_01v8_W1p4_L0p6_m6__nf1_gboth_sdfull_ng_0 x1_m21d VDD_body bias_c bias_b pfet_01v8_W1p4_L0p6_m6__nf1_gboth_sdfull_ng
Xpfet_01v8_W1p4_L0p6_m6__nf1_gboth_sdfull_ng_10 x1_m25d VDD_body bias_c x1_m2d pfet_01v8_W1p4_L0p6_m6__nf1_gboth_sdfull_ng
Xpfet_01v8_W1p4_L0p6_m6__nf1_gboth_sdfull_ng_1 x1_m25d VDD_body bias_c x1_m2d pfet_01v8_W1p4_L0p6_m6__nf1_gboth_sdfull_ng
Xpfet_01v8_W1p4_L0p6_m6__nf1_gboth_sdfull_ng_11 x1_m21d VDD_body bias_c bias_b pfet_01v8_W1p4_L0p6_m6__nf1_gboth_sdfull_ng
Xpfet_01v8_W1p4_L0p6_m6__nf1_gboth_sdfull_ng_2 x1_m31d VDD_body bias_c cm pfet_01v8_W1p4_L0p6_m6__nf1_gboth_sdfull_ng
Xpfet_01v8_W1p4_L0p6_m6__nf1_gboth_sdfull_ng_12 x1_m31d VDD_body bias_c cm pfet_01v8_W1p4_L0p6_m6__nf1_gboth_sdfull_ng
Xpfet_01v8_W1p4_L0p6_m6__nf1_gboth_sdfull_ng_3 x1_m21d VDD_body bias_c bias_b pfet_01v8_W1p4_L0p6_m6__nf1_gboth_sdfull_ng
Xpfet_01v8_W1p4_L0p6_m6__nf1_gboth_sdfull_ng_14 x1_m21d VDD_body bias_c bias_b pfet_01v8_W1p4_L0p6_m6__nf1_gboth_sdfull_ng
Xpfet_01v8_W1p4_L0p6_m6__nf1_gboth_sdfull_ng_13 x1_m25d VDD_body bias_c x1_m2d pfet_01v8_W1p4_L0p6_m6__nf1_gboth_sdfull_ng
Xpfet_01v8_W1p4_L0p6_m6__nf1_gboth_sdfull_ng_4 x1_m25d VDD_body bias_c x1_m2d pfet_01v8_W1p4_L0p6_m6__nf1_gboth_sdfull_ng
Xpfet_01v8_W1p4_L0p6_m6__nf1_gboth_sdfull_ng_15 x1_m31d VDD_body bias_c cm pfet_01v8_W1p4_L0p6_m6__nf1_gboth_sdfull_ng
Xpfet_01v8_W1p4_L0p6_m6__nf1_gboth_sdfull_ng_6 x1_m21d VDD_body bias_c bias_b pfet_01v8_W1p4_L0p6_m6__nf1_gboth_sdfull_ng
Xpfet_01v8_W1p4_L0p6_m6__nf1_gboth_sdfull_ng_5 x1_m31d VDD_body bias_c cm pfet_01v8_W1p4_L0p6_m6__nf1_gboth_sdfull_ng
Xpfet_01v8_W1p4_L0p6_m6__nf1_gboth_sdfull_ng_16 x1_m25d VDD_body bias_c x1_m2d pfet_01v8_W1p4_L0p6_m6__nf1_gboth_sdfull_ng
Xpfet_01v8_W1p4_L0p6_m6__nf1_gboth_sdfull_ng_7 x1_m25d VDD_body bias_c x1_m2d pfet_01v8_W1p4_L0p6_m6__nf1_gboth_sdfull_ng
Xpfet_01v8_W1p4_L0p6_m6__nf1_gboth_sdfull_ng_17 x1_m21d VDD_body bias_c bias_b pfet_01v8_W1p4_L0p6_m6__nf1_gboth_sdfull_ng
Xpfet_01v8_W1p4_L0p6_m6__nf1_gboth_sdfull_ng_8 x1_m31d VDD_body bias_c cm pfet_01v8_W1p4_L0p6_m6__nf1_gboth_sdfull_ng
Xpfet_01v8_W1p4_L0p6_m6__nf1_gboth_sdfull_ng_9 x1_m31d VDD_body bias_c cm pfet_01v8_W1p4_L0p6_m6__nf1_gboth_sdfull_ng
.ends

.subckt pfet_01v8_W1p4_L0p6_m20__nf1_gboth_sdfull_ng S B G D
Xpfet_01v8_W1p4_L0p6_m20__nf1_gboth_sdfull_ng_pc G D B S sky130_fd_pr__pfet_01v8_RGDEC8
.ends

.subckt sky130_fd_pr__pfet_01v8_FGX5XW G D w_n154_n238# S
X0 S G D w_n154_n238# sky130_fd_pr__pfet_01v8 ad=0.406 pd=3.38 as=0.406 ps=3.38 w=1.4 l=0.6
.ends

.subckt pfet_01v8_W1p4_L0p6_m4__nf1_gtop_sdhalf_ng G D B S
Xpfet_01v8_W1p4_L0p6_m4__nf1_gtop_sdhalf_ng_pc G D B S sky130_fd_pr__pfet_01v8_FGX5XW
.ends

.subckt x2_cl_casc__cc4 on x2_foldp VDD op x2_foldn VDD_body bias_c
Xpfet_01v8_W1p4_L0p6_m20__nf1_gboth_sdfull_ng_30 x2_foldn VDD_body bias_c op pfet_01v8_W1p4_L0p6_m20__nf1_gboth_sdfull_ng
Xpfet_01v8_W1p4_L0p6_m20__nf1_gboth_sdfull_ng_20 x2_foldp VDD_body bias_c on pfet_01v8_W1p4_L0p6_m20__nf1_gboth_sdfull_ng
Xpfet_01v8_W1p4_L0p6_m20__nf1_gboth_sdfull_ng_31 x2_foldp VDD_body bias_c on pfet_01v8_W1p4_L0p6_m20__nf1_gboth_sdfull_ng
Xpfet_01v8_W1p4_L0p6_m20__nf1_gboth_sdfull_ng_10 x2_foldn VDD_body bias_c op pfet_01v8_W1p4_L0p6_m20__nf1_gboth_sdfull_ng
Xpfet_01v8_W1p4_L0p6_m20__nf1_gboth_sdfull_ng_21 x2_foldn VDD_body bias_c op pfet_01v8_W1p4_L0p6_m20__nf1_gboth_sdfull_ng
Xpfet_01v8_W1p4_L0p6_m20__nf1_gboth_sdfull_ng_32 x2_foldn VDD_body bias_c op pfet_01v8_W1p4_L0p6_m20__nf1_gboth_sdfull_ng
Xpfet_01v8_W1p4_L0p6_m20__nf1_gboth_sdfull_ng_11 x2_foldp VDD_body bias_c on pfet_01v8_W1p4_L0p6_m20__nf1_gboth_sdfull_ng
Xpfet_01v8_W1p4_L0p6_m20__nf1_gboth_sdfull_ng_22 x2_foldp VDD_body bias_c on pfet_01v8_W1p4_L0p6_m20__nf1_gboth_sdfull_ng
Xpfet_01v8_W1p4_L0p6_m20__nf1_gboth_sdfull_ng_33 x2_foldp VDD_body bias_c on pfet_01v8_W1p4_L0p6_m20__nf1_gboth_sdfull_ng
Xpfet_01v8_W1p4_L0p6_m20__nf1_gboth_sdfull_ng_12 x2_foldn VDD_body bias_c op pfet_01v8_W1p4_L0p6_m20__nf1_gboth_sdfull_ng
Xpfet_01v8_W1p4_L0p6_m20__nf1_gboth_sdfull_ng_23 x2_foldn VDD_body bias_c op pfet_01v8_W1p4_L0p6_m20__nf1_gboth_sdfull_ng
Xpfet_01v8_W1p4_L0p6_m20__nf1_gboth_sdfull_ng_34 x2_foldn VDD_body bias_c op pfet_01v8_W1p4_L0p6_m20__nf1_gboth_sdfull_ng
Xpfet_01v8_W1p4_L0p6_m20__nf1_gboth_sdfull_ng_13 x2_foldp VDD_body bias_c on pfet_01v8_W1p4_L0p6_m20__nf1_gboth_sdfull_ng
Xpfet_01v8_W1p4_L0p6_m20__nf1_gboth_sdfull_ng_24 x2_foldp VDD_body bias_c on pfet_01v8_W1p4_L0p6_m20__nf1_gboth_sdfull_ng
Xpfet_01v8_W1p4_L0p6_m20__nf1_gboth_sdfull_ng_35 x2_foldp VDD_body bias_c on pfet_01v8_W1p4_L0p6_m20__nf1_gboth_sdfull_ng
Xpfet_01v8_W1p4_L0p6_m20__nf1_gboth_sdfull_ng_14 x2_foldn VDD_body bias_c op pfet_01v8_W1p4_L0p6_m20__nf1_gboth_sdfull_ng
Xpfet_01v8_W1p4_L0p6_m20__nf1_gboth_sdfull_ng_25 x2_foldn VDD_body bias_c op pfet_01v8_W1p4_L0p6_m20__nf1_gboth_sdfull_ng
Xpfet_01v8_W1p4_L0p6_m20__nf1_gboth_sdfull_ng_36 x2_foldn VDD_body bias_c op pfet_01v8_W1p4_L0p6_m20__nf1_gboth_sdfull_ng
Xpfet_01v8_W1p4_L0p6_m20__nf1_gboth_sdfull_ng_15 x2_foldp VDD_body bias_c on pfet_01v8_W1p4_L0p6_m20__nf1_gboth_sdfull_ng
Xpfet_01v8_W1p4_L0p6_m20__nf1_gboth_sdfull_ng_16 x2_foldn VDD_body bias_c op pfet_01v8_W1p4_L0p6_m20__nf1_gboth_sdfull_ng
Xpfet_01v8_W1p4_L0p6_m20__nf1_gboth_sdfull_ng_26 x2_foldp VDD_body bias_c on pfet_01v8_W1p4_L0p6_m20__nf1_gboth_sdfull_ng
Xpfet_01v8_W1p4_L0p6_m20__nf1_gboth_sdfull_ng_27 x2_foldn VDD_body bias_c op pfet_01v8_W1p4_L0p6_m20__nf1_gboth_sdfull_ng
Xpfet_01v8_W1p4_L0p6_m20__nf1_gboth_sdfull_ng_37 x2_foldp VDD_body bias_c on pfet_01v8_W1p4_L0p6_m20__nf1_gboth_sdfull_ng
Xpfet_01v8_W1p4_L0p6_m20__nf1_gboth_sdfull_ng_38 x2_foldn VDD_body bias_c op pfet_01v8_W1p4_L0p6_m20__nf1_gboth_sdfull_ng
Xpfet_01v8_W1p4_L0p6_m20__nf1_gboth_sdfull_ng_17 x2_foldp VDD_body bias_c on pfet_01v8_W1p4_L0p6_m20__nf1_gboth_sdfull_ng
Xpfet_01v8_W1p4_L0p6_m20__nf1_gboth_sdfull_ng_28 x2_foldp VDD_body bias_c on pfet_01v8_W1p4_L0p6_m20__nf1_gboth_sdfull_ng
Xpfet_01v8_W1p4_L0p6_m20__nf1_gboth_sdfull_ng_39 x2_foldp VDD_body bias_c on pfet_01v8_W1p4_L0p6_m20__nf1_gboth_sdfull_ng
Xpfet_01v8_W1p4_L0p6_m20__nf1_gboth_sdfull_ng_18 x2_foldn VDD_body bias_c op pfet_01v8_W1p4_L0p6_m20__nf1_gboth_sdfull_ng
Xpfet_01v8_W1p4_L0p6_m20__nf1_gboth_sdfull_ng_29 x2_foldn VDD_body bias_c op pfet_01v8_W1p4_L0p6_m20__nf1_gboth_sdfull_ng
Xpfet_01v8_W1p4_L0p6_m20__nf1_gboth_sdfull_ng_19 x2_foldp VDD_body bias_c on pfet_01v8_W1p4_L0p6_m20__nf1_gboth_sdfull_ng
Xpfet_01v8_W1p4_L0p6_m20__nf1_gboth_sdfull_ng_0 x2_foldp VDD_body bias_c on pfet_01v8_W1p4_L0p6_m20__nf1_gboth_sdfull_ng
Xpfet_01v8_W1p4_L0p6_m20__nf1_gboth_sdfull_ng_1 x2_foldn VDD_body bias_c op pfet_01v8_W1p4_L0p6_m20__nf1_gboth_sdfull_ng
Xpfet_01v8_W1p4_L0p6_m20__nf1_gboth_sdfull_ng_2 x2_foldp VDD_body bias_c on pfet_01v8_W1p4_L0p6_m20__nf1_gboth_sdfull_ng
Xpfet_01v8_W1p4_L0p6_m20__nf1_gboth_sdfull_ng_3 x2_foldn VDD_body bias_c op pfet_01v8_W1p4_L0p6_m20__nf1_gboth_sdfull_ng
Xpfet_01v8_W1p4_L0p6_m20__nf1_gboth_sdfull_ng_4 x2_foldp VDD_body bias_c on pfet_01v8_W1p4_L0p6_m20__nf1_gboth_sdfull_ng
Xpfet_01v8_W1p4_L0p6_m4__nf1_gtop_sdhalf_ng_0 VDD op VDD_body VDD pfet_01v8_W1p4_L0p6_m4__nf1_gtop_sdhalf_ng
Xpfet_01v8_W1p4_L0p6_m20__nf1_gboth_sdfull_ng_5 x2_foldn VDD_body bias_c op pfet_01v8_W1p4_L0p6_m20__nf1_gboth_sdfull_ng
Xpfet_01v8_W1p4_L0p6_m20__nf1_gboth_sdfull_ng_6 x2_foldp VDD_body bias_c on pfet_01v8_W1p4_L0p6_m20__nf1_gboth_sdfull_ng
Xpfet_01v8_W1p4_L0p6_m4__nf1_gtop_sdhalf_ng_1 VDD op VDD_body VDD pfet_01v8_W1p4_L0p6_m4__nf1_gtop_sdhalf_ng
Xpfet_01v8_W1p4_L0p6_m20__nf1_gboth_sdfull_ng_7 x2_foldn VDD_body bias_c op pfet_01v8_W1p4_L0p6_m20__nf1_gboth_sdfull_ng
Xpfet_01v8_W1p4_L0p6_m4__nf1_gtop_sdhalf_ng_2 VDD op VDD_body VDD pfet_01v8_W1p4_L0p6_m4__nf1_gtop_sdhalf_ng
Xpfet_01v8_W1p4_L0p6_m20__nf1_gboth_sdfull_ng_8 x2_foldp VDD_body bias_c on pfet_01v8_W1p4_L0p6_m20__nf1_gboth_sdfull_ng
Xpfet_01v8_W1p4_L0p6_m4__nf1_gtop_sdhalf_ng_3 VDD op VDD_body VDD pfet_01v8_W1p4_L0p6_m4__nf1_gtop_sdhalf_ng
Xpfet_01v8_W1p4_L0p6_m20__nf1_gboth_sdfull_ng_9 x2_foldn VDD_body bias_c op pfet_01v8_W1p4_L0p6_m20__nf1_gboth_sdfull_ng
Xpfet_01v8_W1p4_L0p6_m4__nf1_gtop_sdhalf_ng_4 VDD on VDD_body VDD pfet_01v8_W1p4_L0p6_m4__nf1_gtop_sdhalf_ng
Xpfet_01v8_W1p4_L0p6_m4__nf1_gtop_sdhalf_ng_5 VDD on VDD_body VDD pfet_01v8_W1p4_L0p6_m4__nf1_gtop_sdhalf_ng
Xpfet_01v8_W1p4_L0p6_m4__nf1_gtop_sdhalf_ng_6 VDD on VDD_body VDD pfet_01v8_W1p4_L0p6_m4__nf1_gtop_sdhalf_ng
Xpfet_01v8_W1p4_L0p6_m4__nf1_gtop_sdhalf_ng_7 VDD on VDD_body VDD pfet_01v8_W1p4_L0p6_m4__nf1_gtop_sdhalf_ng
.ends

.subckt XC4_mim XC4_mim_pc/C2_3 XC4_mim_pc/C2_2 XC4_mim_pc/C2_0 XC4_mim_pc/C2_1 XC4_mim_pc/C1_3
+ XC4_mim_pc/C1_2 XC4_mim_pc/C1_1 XC4_mim_pc/C1_0
XXC4_mim_pc XC4_mim_pc/C1_3 XC4_mim_pc/C1_2 XC4_mim_pc/C1_1 XC4_mim_pc/C1_0 XC4_mim_pc/C2_3
+ XC4_mim_pc/C2_2 XC4_mim_pc/C2_1 XC4_mim_pc/C2_0 sky130_fd_pr__cap_mim_m3_1_MX4MQY
.ends

.subckt XC4__A on cmc
XXC4_mim_0 cmc cmc cmc cmc on on on on XC4_mim
.ends

.subckt pfet_01v8_lvt_W1p4_L0p6_m24__nf1_gboth_sdfull_ng B S G D
Xpfet_01v8_lvt_W1p4_L0p6_m24__nf1_gboth_sdfull_ng_pc G D B S sky130_fd_pr__pfet_01v8_lvt_PJ46JE
.ends

.subckt x2_cl_src__cc4 VDD x2_foldp VDD_body bias_b x2_foldn
Xpfet_01v8_lvt_W1p4_L0p6_m24__nf1_gboth_sdfull_ng_2 VDD_body VDD bias_b x2_foldp pfet_01v8_lvt_W1p4_L0p6_m24__nf1_gboth_sdfull_ng
Xpfet_01v8_lvt_W1p4_L0p6_m24__nf1_gboth_sdfull_ng_3 VDD_body VDD bias_b x2_foldn pfet_01v8_lvt_W1p4_L0p6_m24__nf1_gboth_sdfull_ng
Xpfet_01v8_lvt_W1p4_L0p6_m24__nf1_gboth_sdfull_ng_4 VDD_body VDD bias_b x2_foldp pfet_01v8_lvt_W1p4_L0p6_m24__nf1_gboth_sdfull_ng
Xpfet_01v8_lvt_W1p4_L0p6_m24__nf1_gboth_sdfull_ng_5 VDD_body VDD bias_b x2_foldn pfet_01v8_lvt_W1p4_L0p6_m24__nf1_gboth_sdfull_ng
Xpfet_01v8_lvt_W1p4_L0p6_m24__nf1_gboth_sdfull_ng_6 VDD_body VDD bias_b x2_foldn pfet_01v8_lvt_W1p4_L0p6_m24__nf1_gboth_sdfull_ng
Xpfet_01v8_lvt_W1p4_L0p6_m24__nf1_gboth_sdfull_ng_7 VDD_body VDD bias_b x2_foldp pfet_01v8_lvt_W1p4_L0p6_m24__nf1_gboth_sdfull_ng
Xpfet_01v8_lvt_W1p4_L0p6_m24__nf1_gboth_sdfull_ng_8 VDD_body VDD bias_b x2_foldn pfet_01v8_lvt_W1p4_L0p6_m24__nf1_gboth_sdfull_ng
Xpfet_01v8_lvt_W1p4_L0p6_m24__nf1_gboth_sdfull_ng_9 VDD_body VDD bias_b x2_foldp pfet_01v8_lvt_W1p4_L0p6_m24__nf1_gboth_sdfull_ng
Xpfet_01v8_W1p4_L0p6_m2__nf1_gtop_sdfull_ng_0 VDD VDD_body VDD x2_foldn pfet_01v8_W1p4_L0p6_m2__nf1_gtop_sdfull_ng
Xpfet_01v8_W1p4_L0p6_m2__nf1_gtop_sdfull_ng_1 VDD VDD_body VDD x2_foldn pfet_01v8_W1p4_L0p6_m2__nf1_gtop_sdfull_ng
Xpfet_01v8_W1p4_L0p6_m2__nf1_gtop_sdfull_ng_2 VDD VDD_body VDD x2_foldp pfet_01v8_W1p4_L0p6_m2__nf1_gtop_sdfull_ng
Xpfet_01v8_W1p4_L0p6_m2__nf1_gtop_sdfull_ng_3 VDD VDD_body VDD x2_foldp pfet_01v8_W1p4_L0p6_m2__nf1_gtop_sdfull_ng
Xpfet_01v8_W1p4_L0p6_m2__nf1_gtop_sdfull_ng_4 x2_foldn VDD_body x2_foldn x2_foldn
+ pfet_01v8_W1p4_L0p6_m2__nf1_gtop_sdfull_ng
Xpfet_01v8_lvt_W1p4_L0p6_m24__nf1_gboth_sdfull_ng_40 VDD_body VDD bias_b x2_foldp
+ pfet_01v8_lvt_W1p4_L0p6_m24__nf1_gboth_sdfull_ng
Xpfet_01v8_lvt_W1p4_L0p6_m24__nf1_gboth_sdfull_ng_30 VDD_body VDD bias_b x2_foldn
+ pfet_01v8_lvt_W1p4_L0p6_m24__nf1_gboth_sdfull_ng
Xpfet_01v8_W1p4_L0p6_m2__nf1_gtop_sdfull_ng_5 x2_foldn VDD_body x2_foldn x2_foldn
+ pfet_01v8_W1p4_L0p6_m2__nf1_gtop_sdfull_ng
Xpfet_01v8_lvt_W1p4_L0p6_m24__nf1_gboth_sdfull_ng_41 VDD_body VDD bias_b x2_foldn
+ pfet_01v8_lvt_W1p4_L0p6_m24__nf1_gboth_sdfull_ng
Xpfet_01v8_lvt_W1p4_L0p6_m24__nf1_gboth_sdfull_ng_20 VDD_body VDD bias_b x2_foldn
+ pfet_01v8_lvt_W1p4_L0p6_m24__nf1_gboth_sdfull_ng
Xpfet_01v8_lvt_W1p4_L0p6_m24__nf1_gboth_sdfull_ng_31 VDD_body VDD bias_b x2_foldp
+ pfet_01v8_lvt_W1p4_L0p6_m24__nf1_gboth_sdfull_ng
Xpfet_01v8_W1p4_L0p6_m2__nf1_gtop_sdfull_ng_6 x2_foldp VDD_body x2_foldp x2_foldp
+ pfet_01v8_W1p4_L0p6_m2__nf1_gtop_sdfull_ng
Xpfet_01v8_lvt_W1p4_L0p6_m24__nf1_gboth_sdfull_ng_42 VDD_body VDD bias_b x2_foldn
+ pfet_01v8_lvt_W1p4_L0p6_m24__nf1_gboth_sdfull_ng
Xpfet_01v8_lvt_W1p4_L0p6_m24__nf1_gboth_sdfull_ng_10 VDD_body VDD bias_b x2_foldn
+ pfet_01v8_lvt_W1p4_L0p6_m24__nf1_gboth_sdfull_ng
Xpfet_01v8_lvt_W1p4_L0p6_m24__nf1_gboth_sdfull_ng_21 VDD_body VDD bias_b x2_foldp
+ pfet_01v8_lvt_W1p4_L0p6_m24__nf1_gboth_sdfull_ng
Xpfet_01v8_lvt_W1p4_L0p6_m24__nf1_gboth_sdfull_ng_32 VDD_body VDD bias_b x2_foldn
+ pfet_01v8_lvt_W1p4_L0p6_m24__nf1_gboth_sdfull_ng
Xpfet_01v8_lvt_W1p4_L0p6_m24__nf1_gboth_sdfull_ng_43 VDD_body VDD bias_b x2_foldp
+ pfet_01v8_lvt_W1p4_L0p6_m24__nf1_gboth_sdfull_ng
Xpfet_01v8_W1p4_L0p6_m2__nf1_gtop_sdfull_ng_7 x2_foldp VDD_body x2_foldp x2_foldp
+ pfet_01v8_W1p4_L0p6_m2__nf1_gtop_sdfull_ng
Xpfet_01v8_lvt_W1p4_L0p6_m24__nf1_gboth_sdfull_ng_11 VDD_body VDD bias_b x2_foldp
+ pfet_01v8_lvt_W1p4_L0p6_m24__nf1_gboth_sdfull_ng
Xpfet_01v8_lvt_W1p4_L0p6_m24__nf1_gboth_sdfull_ng_12 VDD_body VDD bias_b x2_foldp
+ pfet_01v8_lvt_W1p4_L0p6_m24__nf1_gboth_sdfull_ng
Xpfet_01v8_lvt_W1p4_L0p6_m24__nf1_gboth_sdfull_ng_22 VDD_body VDD bias_b x2_foldn
+ pfet_01v8_lvt_W1p4_L0p6_m24__nf1_gboth_sdfull_ng
Xpfet_01v8_lvt_W1p4_L0p6_m24__nf1_gboth_sdfull_ng_23 VDD_body VDD bias_b x2_foldp
+ pfet_01v8_lvt_W1p4_L0p6_m24__nf1_gboth_sdfull_ng
Xpfet_01v8_lvt_W1p4_L0p6_m24__nf1_gboth_sdfull_ng_33 VDD_body VDD bias_b x2_foldp
+ pfet_01v8_lvt_W1p4_L0p6_m24__nf1_gboth_sdfull_ng
Xpfet_01v8_lvt_W1p4_L0p6_m24__nf1_gboth_sdfull_ng_34 VDD_body VDD bias_b x2_foldn
+ pfet_01v8_lvt_W1p4_L0p6_m24__nf1_gboth_sdfull_ng
Xpfet_01v8_lvt_W1p4_L0p6_m24__nf1_gboth_sdfull_ng_44 VDD_body VDD bias_b x2_foldn
+ pfet_01v8_lvt_W1p4_L0p6_m24__nf1_gboth_sdfull_ng
Xpfet_01v8_lvt_W1p4_L0p6_m24__nf1_gboth_sdfull_ng_45 VDD_body VDD bias_b x2_foldp
+ pfet_01v8_lvt_W1p4_L0p6_m24__nf1_gboth_sdfull_ng
Xpfet_01v8_lvt_W1p4_L0p6_m24__nf1_gboth_sdfull_ng_13 VDD_body VDD bias_b x2_foldn
+ pfet_01v8_lvt_W1p4_L0p6_m24__nf1_gboth_sdfull_ng
Xpfet_01v8_lvt_W1p4_L0p6_m24__nf1_gboth_sdfull_ng_24 VDD_body VDD bias_b x2_foldp
+ pfet_01v8_lvt_W1p4_L0p6_m24__nf1_gboth_sdfull_ng
Xpfet_01v8_lvt_W1p4_L0p6_m24__nf1_gboth_sdfull_ng_35 VDD_body VDD bias_b x2_foldp
+ pfet_01v8_lvt_W1p4_L0p6_m24__nf1_gboth_sdfull_ng
Xpfet_01v8_lvt_W1p4_L0p6_m24__nf1_gboth_sdfull_ng_46 VDD_body VDD bias_b x2_foldn
+ pfet_01v8_lvt_W1p4_L0p6_m24__nf1_gboth_sdfull_ng
Xpfet_01v8_lvt_W1p4_L0p6_m24__nf1_gboth_sdfull_ng_14 VDD_body VDD bias_b x2_foldp
+ pfet_01v8_lvt_W1p4_L0p6_m24__nf1_gboth_sdfull_ng
Xpfet_01v8_lvt_W1p4_L0p6_m24__nf1_gboth_sdfull_ng_25 VDD_body VDD bias_b x2_foldn
+ pfet_01v8_lvt_W1p4_L0p6_m24__nf1_gboth_sdfull_ng
Xpfet_01v8_lvt_W1p4_L0p6_m24__nf1_gboth_sdfull_ng_36 VDD_body VDD bias_b x2_foldp
+ pfet_01v8_lvt_W1p4_L0p6_m24__nf1_gboth_sdfull_ng
Xpfet_01v8_lvt_W1p4_L0p6_m24__nf1_gboth_sdfull_ng_47 VDD_body VDD bias_b x2_foldp
+ pfet_01v8_lvt_W1p4_L0p6_m24__nf1_gboth_sdfull_ng
Xpfet_01v8_lvt_W1p4_L0p6_m24__nf1_gboth_sdfull_ng_15 VDD_body VDD bias_b x2_foldn
+ pfet_01v8_lvt_W1p4_L0p6_m24__nf1_gboth_sdfull_ng
Xpfet_01v8_lvt_W1p4_L0p6_m24__nf1_gboth_sdfull_ng_26 VDD_body VDD bias_b x2_foldp
+ pfet_01v8_lvt_W1p4_L0p6_m24__nf1_gboth_sdfull_ng
Xpfet_01v8_lvt_W1p4_L0p6_m24__nf1_gboth_sdfull_ng_37 VDD_body VDD bias_b x2_foldn
+ pfet_01v8_lvt_W1p4_L0p6_m24__nf1_gboth_sdfull_ng
Xpfet_01v8_lvt_W1p4_L0p6_m24__nf1_gboth_sdfull_ng_16 VDD_body VDD bias_b x2_foldp
+ pfet_01v8_lvt_W1p4_L0p6_m24__nf1_gboth_sdfull_ng
Xpfet_01v8_lvt_W1p4_L0p6_m24__nf1_gboth_sdfull_ng_27 VDD_body VDD bias_b x2_foldn
+ pfet_01v8_lvt_W1p4_L0p6_m24__nf1_gboth_sdfull_ng
Xpfet_01v8_lvt_W1p4_L0p6_m24__nf1_gboth_sdfull_ng_38 VDD_body VDD bias_b x2_foldp
+ pfet_01v8_lvt_W1p4_L0p6_m24__nf1_gboth_sdfull_ng
Xpfet_01v8_lvt_W1p4_L0p6_m24__nf1_gboth_sdfull_ng_17 VDD_body VDD bias_b x2_foldn
+ pfet_01v8_lvt_W1p4_L0p6_m24__nf1_gboth_sdfull_ng
Xpfet_01v8_lvt_W1p4_L0p6_m24__nf1_gboth_sdfull_ng_28 VDD_body VDD bias_b x2_foldp
+ pfet_01v8_lvt_W1p4_L0p6_m24__nf1_gboth_sdfull_ng
Xpfet_01v8_lvt_W1p4_L0p6_m24__nf1_gboth_sdfull_ng_39 VDD_body VDD bias_b x2_foldn
+ pfet_01v8_lvt_W1p4_L0p6_m24__nf1_gboth_sdfull_ng
Xpfet_01v8_lvt_W1p4_L0p6_m24__nf1_gboth_sdfull_ng_18 VDD_body VDD bias_b x2_foldn
+ pfet_01v8_lvt_W1p4_L0p6_m24__nf1_gboth_sdfull_ng
Xpfet_01v8_lvt_W1p4_L0p6_m24__nf1_gboth_sdfull_ng_29 VDD_body VDD bias_b x2_foldn
+ pfet_01v8_lvt_W1p4_L0p6_m24__nf1_gboth_sdfull_ng
Xpfet_01v8_lvt_W1p4_L0p6_m24__nf1_gboth_sdfull_ng_19 VDD_body VDD bias_b x2_foldp
+ pfet_01v8_lvt_W1p4_L0p6_m24__nf1_gboth_sdfull_ng
Xpfet_01v8_lvt_W1p4_L0p6_m24__nf1_gboth_sdfull_ng_0 VDD_body VDD bias_b x2_foldp pfet_01v8_lvt_W1p4_L0p6_m24__nf1_gboth_sdfull_ng
Xpfet_01v8_lvt_W1p4_L0p6_m24__nf1_gboth_sdfull_ng_1 VDD_body VDD bias_b x2_foldn pfet_01v8_lvt_W1p4_L0p6_m24__nf1_gboth_sdfull_ng
.ends

.subckt pfet_01v8_lvt_W1p4_L0p6_m8__nf1_gtop_sdfull_ng G D B S
Xpfet_01v8_lvt_W1p4_L0p6_m8__nf1_gtop_sdfull_ng_pc G D B S sky130_fd_pr__pfet_01v8_lvt_L7GY3J
.ends

.subckt pmos_dummy__f2 VDD_body VDD
Xpfet_01v8_lvt_W1p4_L0p6_m8__nf1_gtop_sdfull_ng_10 VDD VDD VDD_body VDD pfet_01v8_lvt_W1p4_L0p6_m8__nf1_gtop_sdfull_ng
Xpfet_01v8_lvt_W1p4_L0p6_m8__nf1_gtop_sdfull_ng_11 VDD VDD VDD_body VDD pfet_01v8_lvt_W1p4_L0p6_m8__nf1_gtop_sdfull_ng
Xpfet_01v8_lvt_W1p4_L0p6_m8__nf1_gtop_sdfull_ng_0 VDD VDD VDD_body VDD pfet_01v8_lvt_W1p4_L0p6_m8__nf1_gtop_sdfull_ng
Xpfet_01v8_lvt_W1p4_L0p6_m8__nf1_gtop_sdfull_ng_1 VDD VDD VDD_body VDD pfet_01v8_lvt_W1p4_L0p6_m8__nf1_gtop_sdfull_ng
Xpfet_01v8_lvt_W1p4_L0p6_m8__nf1_gtop_sdfull_ng_2 VDD VDD VDD_body VDD pfet_01v8_lvt_W1p4_L0p6_m8__nf1_gtop_sdfull_ng
Xpfet_01v8_lvt_W1p4_L0p6_m8__nf1_gtop_sdfull_ng_3 VDD VDD VDD_body VDD pfet_01v8_lvt_W1p4_L0p6_m8__nf1_gtop_sdfull_ng
Xpfet_01v8_lvt_W1p4_L0p6_m8__nf1_gtop_sdfull_ng_4 VDD VDD VDD_body VDD pfet_01v8_lvt_W1p4_L0p6_m8__nf1_gtop_sdfull_ng
Xpfet_01v8_lvt_W1p4_L0p6_m8__nf1_gtop_sdfull_ng_5 VDD VDD VDD_body VDD pfet_01v8_lvt_W1p4_L0p6_m8__nf1_gtop_sdfull_ng
Xpfet_01v8_lvt_W1p4_L0p6_m8__nf1_gtop_sdfull_ng_6 VDD VDD VDD_body VDD pfet_01v8_lvt_W1p4_L0p6_m8__nf1_gtop_sdfull_ng
Xpfet_01v8_lvt_W1p4_L0p6_m8__nf1_gtop_sdfull_ng_7 VDD VDD VDD_body VDD pfet_01v8_lvt_W1p4_L0p6_m8__nf1_gtop_sdfull_ng
Xpfet_01v8_lvt_W1p4_L0p6_m8__nf1_gtop_sdfull_ng_8 VDD VDD VDD_body VDD pfet_01v8_lvt_W1p4_L0p6_m8__nf1_gtop_sdfull_ng
Xpfet_01v8_lvt_W1p4_L0p6_m8__nf1_gtop_sdfull_ng_9 VDD VDD VDD_body VDD pfet_01v8_lvt_W1p4_L0p6_m8__nf1_gtop_sdfull_ng
.ends

.subckt nfet_01v8_W1p4_L0p6_m50__nf1_gboth_sdfull_ng B G D S
Xnfet_01v8_W1p4_L0p6_m50__nf1_gboth_sdfull_ng_pc G D S B sky130_fd_pr__nfet_01v8_KCM6UP
.ends

.subckt x1_diode_m2d__f1 bias_d x1_m2d VSS_body
Xnfet_01v8_W1p4_L0p6_m50__nf1_gboth_sdfull_ng_12 VSS_body x1_m2d x1_m2d bias_d nfet_01v8_W1p4_L0p6_m50__nf1_gboth_sdfull_ng
Xnfet_01v8_W1p4_L0p6_m50__nf1_gboth_sdfull_ng_13 VSS_body x1_m2d x1_m2d bias_d nfet_01v8_W1p4_L0p6_m50__nf1_gboth_sdfull_ng
Xnfet_01v8_W1p4_L0p6_m50__nf1_gboth_sdfull_ng_23 VSS_body x1_m2d x1_m2d bias_d nfet_01v8_W1p4_L0p6_m50__nf1_gboth_sdfull_ng
Xnfet_01v8_W1p4_L0p6_m50__nf1_gboth_sdfull_ng_24 VSS_body x1_m2d x1_m2d bias_d nfet_01v8_W1p4_L0p6_m50__nf1_gboth_sdfull_ng
Xnfet_01v8_W1p4_L0p6_m50__nf1_gboth_sdfull_ng_34 VSS_body x1_m2d x1_m2d bias_d nfet_01v8_W1p4_L0p6_m50__nf1_gboth_sdfull_ng
Xnfet_01v8_W1p4_L0p6_m50__nf1_gboth_sdfull_ng_35 VSS_body x1_m2d x1_m2d bias_d nfet_01v8_W1p4_L0p6_m50__nf1_gboth_sdfull_ng
Xnfet_01v8_W1p4_L0p6_m50__nf1_gboth_sdfull_ng_45 VSS_body x1_m2d x1_m2d bias_d nfet_01v8_W1p4_L0p6_m50__nf1_gboth_sdfull_ng
Xnfet_01v8_W1p4_L0p6_m50__nf1_gboth_sdfull_ng_46 VSS_body x1_m2d x1_m2d bias_d nfet_01v8_W1p4_L0p6_m50__nf1_gboth_sdfull_ng
Xnfet_01v8_W1p4_L0p6_m50__nf1_gboth_sdfull_ng_14 VSS_body x1_m2d x1_m2d bias_d nfet_01v8_W1p4_L0p6_m50__nf1_gboth_sdfull_ng
Xnfet_01v8_W1p4_L0p6_m50__nf1_gboth_sdfull_ng_25 VSS_body x1_m2d x1_m2d bias_d nfet_01v8_W1p4_L0p6_m50__nf1_gboth_sdfull_ng
Xnfet_01v8_W1p4_L0p6_m50__nf1_gboth_sdfull_ng_36 VSS_body x1_m2d x1_m2d bias_d nfet_01v8_W1p4_L0p6_m50__nf1_gboth_sdfull_ng
Xnfet_01v8_W1p4_L0p6_m50__nf1_gboth_sdfull_ng_47 VSS_body x1_m2d x1_m2d bias_d nfet_01v8_W1p4_L0p6_m50__nf1_gboth_sdfull_ng
Xnfet_01v8_W1p4_L0p6_m50__nf1_gboth_sdfull_ng_15 VSS_body x1_m2d x1_m2d bias_d nfet_01v8_W1p4_L0p6_m50__nf1_gboth_sdfull_ng
Xnfet_01v8_W1p4_L0p6_m50__nf1_gboth_sdfull_ng_26 VSS_body x1_m2d x1_m2d bias_d nfet_01v8_W1p4_L0p6_m50__nf1_gboth_sdfull_ng
Xnfet_01v8_W1p4_L0p6_m50__nf1_gboth_sdfull_ng_37 VSS_body x1_m2d x1_m2d bias_d nfet_01v8_W1p4_L0p6_m50__nf1_gboth_sdfull_ng
Xnfet_01v8_W1p4_L0p6_m50__nf1_gboth_sdfull_ng_48 VSS_body x1_m2d x1_m2d bias_d nfet_01v8_W1p4_L0p6_m50__nf1_gboth_sdfull_ng
Xnfet_01v8_W1p4_L0p6_m50__nf1_gboth_sdfull_ng_16 VSS_body x1_m2d x1_m2d bias_d nfet_01v8_W1p4_L0p6_m50__nf1_gboth_sdfull_ng
Xnfet_01v8_W1p4_L0p6_m50__nf1_gboth_sdfull_ng_27 VSS_body x1_m2d x1_m2d bias_d nfet_01v8_W1p4_L0p6_m50__nf1_gboth_sdfull_ng
Xnfet_01v8_W1p4_L0p6_m50__nf1_gboth_sdfull_ng_38 VSS_body x1_m2d x1_m2d bias_d nfet_01v8_W1p4_L0p6_m50__nf1_gboth_sdfull_ng
Xnfet_01v8_W1p4_L0p6_m50__nf1_gboth_sdfull_ng_49 VSS_body x1_m2d x1_m2d bias_d nfet_01v8_W1p4_L0p6_m50__nf1_gboth_sdfull_ng
Xnfet_01v8_W1p4_L0p6_m50__nf1_gboth_sdfull_ng_0 VSS_body x1_m2d x1_m2d bias_d nfet_01v8_W1p4_L0p6_m50__nf1_gboth_sdfull_ng
Xnfet_01v8_W1p4_L0p6_m50__nf1_gboth_sdfull_ng_17 VSS_body x1_m2d x1_m2d bias_d nfet_01v8_W1p4_L0p6_m50__nf1_gboth_sdfull_ng
Xnfet_01v8_W1p4_L0p6_m50__nf1_gboth_sdfull_ng_28 VSS_body x1_m2d x1_m2d bias_d nfet_01v8_W1p4_L0p6_m50__nf1_gboth_sdfull_ng
Xnfet_01v8_W1p4_L0p6_m50__nf1_gboth_sdfull_ng_39 VSS_body x1_m2d x1_m2d bias_d nfet_01v8_W1p4_L0p6_m50__nf1_gboth_sdfull_ng
Xnfet_01v8_W1p4_L0p6_m50__nf1_gboth_sdfull_ng_1 VSS_body x1_m2d x1_m2d bias_d nfet_01v8_W1p4_L0p6_m50__nf1_gboth_sdfull_ng
Xnfet_01v8_W1p4_L0p6_m50__nf1_gboth_sdfull_ng_18 VSS_body x1_m2d x1_m2d bias_d nfet_01v8_W1p4_L0p6_m50__nf1_gboth_sdfull_ng
Xnfet_01v8_W1p4_L0p6_m50__nf1_gboth_sdfull_ng_29 VSS_body x1_m2d x1_m2d bias_d nfet_01v8_W1p4_L0p6_m50__nf1_gboth_sdfull_ng
Xnfet_01v8_W1p4_L0p6_m50__nf1_gboth_sdfull_ng_2 VSS_body x1_m2d x1_m2d bias_d nfet_01v8_W1p4_L0p6_m50__nf1_gboth_sdfull_ng
Xnfet_01v8_W1p4_L0p6_m50__nf1_gboth_sdfull_ng_19 VSS_body x1_m2d x1_m2d bias_d nfet_01v8_W1p4_L0p6_m50__nf1_gboth_sdfull_ng
Xnfet_01v8_W1p4_L0p6_m50__nf1_gboth_sdfull_ng_3 VSS_body x1_m2d x1_m2d bias_d nfet_01v8_W1p4_L0p6_m50__nf1_gboth_sdfull_ng
Xnfet_01v8_W1p4_L0p6_m50__nf1_gboth_sdfull_ng_4 VSS_body x1_m2d x1_m2d bias_d nfet_01v8_W1p4_L0p6_m50__nf1_gboth_sdfull_ng
Xnfet_01v8_W1p4_L0p6_m50__nf1_gboth_sdfull_ng_5 VSS_body x1_m2d x1_m2d bias_d nfet_01v8_W1p4_L0p6_m50__nf1_gboth_sdfull_ng
Xnfet_01v8_W1p4_L0p6_m50__nf1_gboth_sdfull_ng_6 VSS_body x1_m2d x1_m2d bias_d nfet_01v8_W1p4_L0p6_m50__nf1_gboth_sdfull_ng
Xnfet_01v8_W1p4_L0p6_m50__nf1_gboth_sdfull_ng_7 VSS_body x1_m2d x1_m2d bias_d nfet_01v8_W1p4_L0p6_m50__nf1_gboth_sdfull_ng
Xnfet_01v8_W1p4_L0p6_m50__nf1_gboth_sdfull_ng_8 VSS_body x1_m2d x1_m2d bias_d nfet_01v8_W1p4_L0p6_m50__nf1_gboth_sdfull_ng
Xnfet_01v8_W1p4_L0p6_m50__nf1_gboth_sdfull_ng_9 VSS_body x1_m2d x1_m2d bias_d nfet_01v8_W1p4_L0p6_m50__nf1_gboth_sdfull_ng
Xnfet_01v8_W1p4_L0p6_m2__nf1_gboth_sdfull_ng_0 VSS_body x1_m2d x1_m2d x1_m2d nfet_01v8_W1p4_L0p6_m2__nf1_gboth_sdfull_ng
Xnfet_01v8_W1p4_L0p6_m2__nf1_gboth_sdfull_ng_1 VSS_body x1_m2d x1_m2d x1_m2d nfet_01v8_W1p4_L0p6_m2__nf1_gboth_sdfull_ng
Xnfet_01v8_W1p4_L0p6_m50__nf1_gboth_sdfull_ng_40 VSS_body x1_m2d x1_m2d bias_d nfet_01v8_W1p4_L0p6_m50__nf1_gboth_sdfull_ng
Xnfet_01v8_W1p4_L0p6_m50__nf1_gboth_sdfull_ng_30 VSS_body x1_m2d x1_m2d bias_d nfet_01v8_W1p4_L0p6_m50__nf1_gboth_sdfull_ng
Xnfet_01v8_W1p4_L0p6_m50__nf1_gboth_sdfull_ng_41 VSS_body x1_m2d x1_m2d bias_d nfet_01v8_W1p4_L0p6_m50__nf1_gboth_sdfull_ng
Xnfet_01v8_W1p4_L0p6_m50__nf1_gboth_sdfull_ng_20 VSS_body x1_m2d x1_m2d bias_d nfet_01v8_W1p4_L0p6_m50__nf1_gboth_sdfull_ng
Xnfet_01v8_W1p4_L0p6_m50__nf1_gboth_sdfull_ng_31 VSS_body x1_m2d x1_m2d bias_d nfet_01v8_W1p4_L0p6_m50__nf1_gboth_sdfull_ng
Xnfet_01v8_W1p4_L0p6_m50__nf1_gboth_sdfull_ng_42 VSS_body x1_m2d x1_m2d bias_d nfet_01v8_W1p4_L0p6_m50__nf1_gboth_sdfull_ng
Xnfet_01v8_W1p4_L0p6_m50__nf1_gboth_sdfull_ng_10 VSS_body x1_m2d x1_m2d bias_d nfet_01v8_W1p4_L0p6_m50__nf1_gboth_sdfull_ng
Xnfet_01v8_W1p4_L0p6_m50__nf1_gboth_sdfull_ng_21 VSS_body x1_m2d x1_m2d bias_d nfet_01v8_W1p4_L0p6_m50__nf1_gboth_sdfull_ng
Xnfet_01v8_W1p4_L0p6_m50__nf1_gboth_sdfull_ng_32 VSS_body x1_m2d x1_m2d bias_d nfet_01v8_W1p4_L0p6_m50__nf1_gboth_sdfull_ng
Xnfet_01v8_W1p4_L0p6_m50__nf1_gboth_sdfull_ng_43 VSS_body x1_m2d x1_m2d bias_d nfet_01v8_W1p4_L0p6_m50__nf1_gboth_sdfull_ng
Xnfet_01v8_W1p4_L0p6_m50__nf1_gboth_sdfull_ng_11 VSS_body x1_m2d x1_m2d bias_d nfet_01v8_W1p4_L0p6_m50__nf1_gboth_sdfull_ng
Xnfet_01v8_W1p4_L0p6_m50__nf1_gboth_sdfull_ng_22 VSS_body x1_m2d x1_m2d bias_d nfet_01v8_W1p4_L0p6_m50__nf1_gboth_sdfull_ng
Xnfet_01v8_W1p4_L0p6_m50__nf1_gboth_sdfull_ng_33 VSS_body x1_m2d x1_m2d bias_d nfet_01v8_W1p4_L0p6_m50__nf1_gboth_sdfull_ng
Xnfet_01v8_W1p4_L0p6_m50__nf1_gboth_sdfull_ng_44 VSS_body x1_m2d x1_m2d bias_d nfet_01v8_W1p4_L0p6_m50__nf1_gboth_sdfull_ng
.ends

.subckt iadc_ota_v2_routed on op bias_a cm IBIAS VDD VSS cmc in ip
XXC3__A_0 op cmc XC3__A
Xnmos_dummy__f1_0 VSS VSS nmos_dummy__f1
Xx2_cm_tail__id6_0 cmc bias_a x2_cm_tail__id6_0/x2_m3d x2_diff__cc3_0/x2_tail VSS
+ x2_cm_tail__id6_0/x2_m4d VSS x2_cm_tail__id6
Xpmos_dummy_2__f2_0 VDD VDD pmos_dummy_2__f2
Xx1_cm_iref__cc1_0 VSS IBIAS VSS x2_cl_casc__cc4_0/bias_c x1_cm_iref__cc1
Xx2_cm_casc__cc3_0 x2_cm_tail__id6_0/x2_m4d VSS op VSS x2_cm_tail__id6_0/x2_m3d x2_cm_casc__cc3_0/bias_d
+ on x2_cm_casc__cc3
Xx1_cm_bias_b__cc3_0 VDD x1_cm_bias_c__cc1_0/x1_m21d x1_cm_bias_c__cc1_0/x1_m25d x1_cm_bias_c__cc1_0/x1_m31d
+ VDD x2_cl_src__cc4_0/bias_b x1_cm_bias_b__cc3
Xx1_diode_bias_b__f2_0 x2_cl_src__cc4_0/bias_b VSS x2_cl_casc__cc4_0/bias_c x1_diode_bias_b__f2
Xx1_single_m5__f3_0 VSS bias_a x1_single_m5__f3_0/x1_m5d VSS x1_single_m5__f3
Xx1_cc_cm__strings1_0 cm VSS VSS x1_cc_cm__strings1
Xx1_single_m4__f1_0 x1_single_m5__f3_0/x1_m5d bias_a VSS x2_cm_casc__cc3_0/bias_d
+ x1_single_m4__f1
Xx1_single_m3__f1_0 bias_a x1_single_m3__f1_0/x1_m2d x2_cm_casc__cc3_0/bias_d VSS
+ x1_single_m3__f1
Xx2_diff__cc3_0 VSS ip x2_diff__cc3_0/x2_tail in VSS x2_diff__cc3_0/x2_foldn x2_diff__cc3_0/x2_foldp
+ x2_diff__cc3
Xx1_cm_bias_c__cc1_0 VDD cm x1_cm_bias_c__cc1_0/x1_m25d x1_single_m3__f1_0/x1_m2d
+ x1_cm_bias_c__cc1_0/x1_m31d VDD x1_cm_bias_c__cc1_0/x1_m21d x2_cl_src__cc4_0/bias_b
+ x2_cl_casc__cc4_0/bias_c x1_cm_bias_c__cc1
Xx2_cl_casc__cc4_0 on x2_diff__cc3_0/x2_foldp VDD op x2_diff__cc3_0/x2_foldn VDD x2_cl_casc__cc4_0/bias_c
+ x2_cl_casc__cc4
XXC4__A_0 on cmc XC4__A
Xx2_cl_src__cc4_0 VDD x2_diff__cc3_0/x2_foldp VDD x2_cl_src__cc4_0/bias_b x2_diff__cc3_0/x2_foldn
+ x2_cl_src__cc4
Xpmos_dummy__f2_0 VDD VDD pmos_dummy__f2
Xx1_diode_m2d__f1_0 x2_cm_casc__cc3_0/bias_d x1_single_m3__f1_0/x1_m2d VSS x1_diode_m2d__f1
.ends
