* NGSPICE file created from iadc_ota_routed.ext - technology: sky130A

.subckt sky130_fd_pr__nfet_01v8_KCM6UP G D S VSUBS
X0 S G D VSUBS sky130_fd_pr__nfet_01v8 ad=0.406 pd=3.38 as=0.406 ps=3.38 w=1.4 l=0.6
.ends

.subckt nfet_01v8_W1p4_L0p6_m1__nf1_gboth_sdfull_ng S B G D
Xnfet_01v8_W1p4_L0p6_m1__nf1_gboth_sdfull_ng_pc G D S B sky130_fd_pr__nfet_01v8_KCM6UP
.ends

.subckt nmos_matched_cascode_pair_3__AB cm VSS VSS_body x1_net2
Xnfet_01v8_W1p4_L0p6_m1__nf1_gboth_sdfull_ng_0 VSS VSS_body VSS VSS nfet_01v8_W1p4_L0p6_m1__nf1_gboth_sdfull_ng
Xnfet_01v8_W1p4_L0p6_m1__nf1_gboth_sdfull_ng_1 x1_net3 VSS_body cm x1_net2 nfet_01v8_W1p4_L0p6_m1__nf1_gboth_sdfull_ng
Xnfet_01v8_W1p4_L0p6_m1__nf1_gboth_sdfull_ng_2 VSS VSS_body cm x1_net3 nfet_01v8_W1p4_L0p6_m1__nf1_gboth_sdfull_ng
Xnfet_01v8_W1p4_L0p6_m1__nf1_gboth_sdfull_ng_3 VSS VSS_body VSS VSS nfet_01v8_W1p4_L0p6_m1__nf1_gboth_sdfull_ng
.ends

.subckt sky130_fd_pr__cap_mim_m3_1_MX4MQY C1_3 C1_2 C1_1 C1_0 C2_3 C2_2 C2_1 C2_0
X0 C1_0 C2_0 sky130_fd_pr__cap_mim_m3_1 l=4.8 w=4.8
X1 C1_2 C2_2 sky130_fd_pr__cap_mim_m3_1 l=4.8 w=4.8
X2 C1_1 C2_1 sky130_fd_pr__cap_mim_m3_1 l=4.8 w=4.8
X3 C1_3 C2_3 sky130_fd_pr__cap_mim_m3_1 l=4.8 w=4.8
.ends

.subckt XC3_mim XC3_mim_pc/C2_3 XC3_mim_pc/C2_2 XC3_mim_pc/C2_1 XC3_mim_pc/C2_0 XC3_mim_pc/C1_3
+ XC3_mim_pc/C1_1 XC3_mim_pc/C1_2 XC3_mim_pc/C1_0
XXC3_mim_pc XC3_mim_pc/C1_3 XC3_mim_pc/C1_2 XC3_mim_pc/C1_1 XC3_mim_pc/C1_0 XC3_mim_pc/C2_3
+ XC3_mim_pc/C2_2 XC3_mim_pc/C2_1 XC3_mim_pc/C2_0 sky130_fd_pr__cap_mim_m3_1_MX4MQY
.ends

.subckt XC3__A cmc op
XXC3_mim_0 cmc cmc cmc cmc op op op op XC3_mim
.ends

.subckt sky130_fd_pr__pfet_01v8_RGDEC8 G D w_n154_n240# S
X0 S G D w_n154_n240# sky130_fd_pr__pfet_01v8 ad=0.406 pd=3.38 as=0.406 ps=3.38 w=1.4 l=0.6
.ends

.subckt pfet_01v8_W1p4_L0p6_m6__nf1_gboth_sdfull_ng S B G D
Xpfet_01v8_W1p4_L0p6_m6__nf1_gboth_sdfull_ng_pc G D B S sky130_fd_pr__pfet_01v8_RGDEC8
.ends

.subckt pmos_matched_cascode_pair__ABBA x1_m21d bias_c bias_b x1_m25d VDD_body VDD
+ x1_m2d
Xpfet_01v8_W1p4_L0p6_m6__nf1_gboth_sdfull_ng_0 VDD VDD_body VDD VDD pfet_01v8_W1p4_L0p6_m6__nf1_gboth_sdfull_ng
Xpfet_01v8_W1p4_L0p6_m6__nf1_gboth_sdfull_ng_10 x1_m21d VDD_body bias_c bias_b pfet_01v8_W1p4_L0p6_m6__nf1_gboth_sdfull_ng
Xpfet_01v8_W1p4_L0p6_m6__nf1_gboth_sdfull_ng_1 x1_m21d VDD_body bias_c bias_b pfet_01v8_W1p4_L0p6_m6__nf1_gboth_sdfull_ng
Xpfet_01v8_W1p4_L0p6_m6__nf1_gboth_sdfull_ng_11 x1_m25d VDD_body bias_c x1_m2d pfet_01v8_W1p4_L0p6_m6__nf1_gboth_sdfull_ng
Xpfet_01v8_W1p4_L0p6_m6__nf1_gboth_sdfull_ng_2 x1_m25d VDD_body bias_c x1_m2d pfet_01v8_W1p4_L0p6_m6__nf1_gboth_sdfull_ng
Xpfet_01v8_W1p4_L0p6_m6__nf1_gboth_sdfull_ng_12 x1_m21d VDD_body bias_c bias_b pfet_01v8_W1p4_L0p6_m6__nf1_gboth_sdfull_ng
Xpfet_01v8_W1p4_L0p6_m6__nf1_gboth_sdfull_ng_3 x1_m21d VDD_body bias_c bias_b pfet_01v8_W1p4_L0p6_m6__nf1_gboth_sdfull_ng
Xpfet_01v8_W1p4_L0p6_m6__nf1_gboth_sdfull_ng_13 VDD VDD_body VDD VDD pfet_01v8_W1p4_L0p6_m6__nf1_gboth_sdfull_ng
Xpfet_01v8_W1p4_L0p6_m6__nf1_gboth_sdfull_ng_4 x1_m25d VDD_body bias_c x1_m2d pfet_01v8_W1p4_L0p6_m6__nf1_gboth_sdfull_ng
Xpfet_01v8_W1p4_L0p6_m6__nf1_gboth_sdfull_ng_6 x1_m25d VDD_body bias_c x1_m2d pfet_01v8_W1p4_L0p6_m6__nf1_gboth_sdfull_ng
Xpfet_01v8_W1p4_L0p6_m6__nf1_gboth_sdfull_ng_5 x1_m21d VDD_body bias_c bias_b pfet_01v8_W1p4_L0p6_m6__nf1_gboth_sdfull_ng
Xpfet_01v8_W1p4_L0p6_m6__nf1_gboth_sdfull_ng_7 x1_m25d VDD_body bias_c x1_m2d pfet_01v8_W1p4_L0p6_m6__nf1_gboth_sdfull_ng
Xpfet_01v8_W1p4_L0p6_m6__nf1_gboth_sdfull_ng_8 x1_m21d VDD_body bias_c bias_b pfet_01v8_W1p4_L0p6_m6__nf1_gboth_sdfull_ng
Xpfet_01v8_W1p4_L0p6_m6__nf1_gboth_sdfull_ng_9 x1_m25d VDD_body bias_c x1_m2d pfet_01v8_W1p4_L0p6_m6__nf1_gboth_sdfull_ng
.ends

.subckt nmos_matched_cascode_pair_2__AB cm VSS VSS_body x1_net2
Xnfet_01v8_W1p4_L0p6_m1__nf1_gboth_sdfull_ng_0 VSS VSS_body VSS VSS nfet_01v8_W1p4_L0p6_m1__nf1_gboth_sdfull_ng
Xnfet_01v8_W1p4_L0p6_m1__nf1_gboth_sdfull_ng_1 x1_net1 VSS_body cm cm nfet_01v8_W1p4_L0p6_m1__nf1_gboth_sdfull_ng
Xnfet_01v8_W1p4_L0p6_m1__nf1_gboth_sdfull_ng_2 x1_net2 VSS_body cm x1_net1 nfet_01v8_W1p4_L0p6_m1__nf1_gboth_sdfull_ng
Xnfet_01v8_W1p4_L0p6_m1__nf1_gboth_sdfull_ng_3 VSS VSS_body VSS VSS nfet_01v8_W1p4_L0p6_m1__nf1_gboth_sdfull_ng
.ends

.subckt sky130_fd_pr__nfet_01v8_RUA5M6 G D S VSUBS
X0 S G D VSUBS sky130_fd_pr__nfet_01v8 ad=0.406 pd=3.38 as=0.406 ps=3.38 w=1.4 l=0.6
.ends

.subckt nfet_01v8_W1p4_L0p6_m6__nf1_gtop_sdfull_ng B G D S
Xnfet_01v8_W1p4_L0p6_m6__nf1_gtop_sdfull_ng_pc G D S B sky130_fd_pr__nfet_01v8_RUA5M6
.ends

.subckt nmos_dummy_14__A x2_tail VSS_body
Xnfet_01v8_W1p4_L0p6_m6__nf1_gtop_sdfull_ng_0 VSS_body x2_tail x2_tail x2_tail nfet_01v8_W1p4_L0p6_m6__nf1_gtop_sdfull_ng
Xnfet_01v8_W1p4_L0p6_m6__nf1_gtop_sdfull_ng_1 VSS_body x2_tail x2_tail x2_tail nfet_01v8_W1p4_L0p6_m6__nf1_gtop_sdfull_ng
Xnfet_01v8_W1p4_L0p6_m6__nf1_gtop_sdfull_ng_2 VSS_body x2_tail x2_tail x2_tail nfet_01v8_W1p4_L0p6_m6__nf1_gtop_sdfull_ng
Xnfet_01v8_W1p4_L0p6_m6__nf1_gtop_sdfull_ng_3 VSS_body x2_tail x2_tail x2_tail nfet_01v8_W1p4_L0p6_m6__nf1_gtop_sdfull_ng
Xnfet_01v8_W1p4_L0p6_m6__nf1_gtop_sdfull_ng_4 VSS_body x2_tail x2_tail x2_tail nfet_01v8_W1p4_L0p6_m6__nf1_gtop_sdfull_ng
Xnfet_01v8_W1p4_L0p6_m6__nf1_gtop_sdfull_ng_5 VSS_body x2_tail x2_tail x2_tail nfet_01v8_W1p4_L0p6_m6__nf1_gtop_sdfull_ng
.ends

.subckt sky130_fd_pr__pfet_01v8_7A4LUF G D w_n154_n238# S
X0 S G D w_n154_n238# sky130_fd_pr__pfet_01v8 ad=0.406 pd=3.38 as=0.406 ps=3.38 w=1.4 l=0.6
.ends

.subckt pfet_01v8_W1p4_L0p6_m2__nf1_gtop_sdfull_ng B S G D
Xpfet_01v8_W1p4_L0p6_m2__nf1_gtop_sdfull_ng_pc G D B S sky130_fd_pr__pfet_01v8_7A4LUF
.ends

.subckt pmos_dummy_10__A cm VDD_body VDD
Xpfet_01v8_W1p4_L0p6_m2__nf1_gtop_sdfull_ng_0 VDD_body VDD VDD cm pfet_01v8_W1p4_L0p6_m2__nf1_gtop_sdfull_ng
Xpfet_01v8_W1p4_L0p6_m2__nf1_gtop_sdfull_ng_1 VDD_body VDD VDD cm pfet_01v8_W1p4_L0p6_m2__nf1_gtop_sdfull_ng
.ends

.subckt nfet_01v8_W1p4_L0p6_m96__nf1_gboth_sdfull_ng D B S G
Xnfet_01v8_W1p4_L0p6_m96__nf1_gboth_sdfull_ng_pc G D S B sky130_fd_pr__nfet_01v8_KCM6UP
.ends

.subckt nmos_single_4__A bias_a VSS_body x2_tail VSS
Xnfet_01v8_W1p4_L0p6_m96__nf1_gboth_sdfull_ng_91 x2_tail VSS_body VSS bias_a nfet_01v8_W1p4_L0p6_m96__nf1_gboth_sdfull_ng
Xnfet_01v8_W1p4_L0p6_m96__nf1_gboth_sdfull_ng_80 x2_tail VSS_body VSS bias_a nfet_01v8_W1p4_L0p6_m96__nf1_gboth_sdfull_ng
Xnfet_01v8_W1p4_L0p6_m96__nf1_gboth_sdfull_ng_1 x2_tail VSS_body VSS bias_a nfet_01v8_W1p4_L0p6_m96__nf1_gboth_sdfull_ng
Xnfet_01v8_W1p4_L0p6_m96__nf1_gboth_sdfull_ng_0 x2_tail VSS_body VSS bias_a nfet_01v8_W1p4_L0p6_m96__nf1_gboth_sdfull_ng
Xnfet_01v8_W1p4_L0p6_m96__nf1_gboth_sdfull_ng_92 x2_tail VSS_body VSS bias_a nfet_01v8_W1p4_L0p6_m96__nf1_gboth_sdfull_ng
Xnfet_01v8_W1p4_L0p6_m96__nf1_gboth_sdfull_ng_81 x2_tail VSS_body VSS bias_a nfet_01v8_W1p4_L0p6_m96__nf1_gboth_sdfull_ng
Xnfet_01v8_W1p4_L0p6_m96__nf1_gboth_sdfull_ng_70 x2_tail VSS_body VSS bias_a nfet_01v8_W1p4_L0p6_m96__nf1_gboth_sdfull_ng
Xnfet_01v8_W1p4_L0p6_m96__nf1_gboth_sdfull_ng_2 x2_tail VSS_body VSS bias_a nfet_01v8_W1p4_L0p6_m96__nf1_gboth_sdfull_ng
Xnfet_01v8_W1p4_L0p6_m96__nf1_gboth_sdfull_ng_94 x2_tail VSS_body VSS bias_a nfet_01v8_W1p4_L0p6_m96__nf1_gboth_sdfull_ng
Xnfet_01v8_W1p4_L0p6_m96__nf1_gboth_sdfull_ng_93 x2_tail VSS_body VSS bias_a nfet_01v8_W1p4_L0p6_m96__nf1_gboth_sdfull_ng
Xnfet_01v8_W1p4_L0p6_m96__nf1_gboth_sdfull_ng_83 x2_tail VSS_body VSS bias_a nfet_01v8_W1p4_L0p6_m96__nf1_gboth_sdfull_ng
Xnfet_01v8_W1p4_L0p6_m96__nf1_gboth_sdfull_ng_82 x2_tail VSS_body VSS bias_a nfet_01v8_W1p4_L0p6_m96__nf1_gboth_sdfull_ng
Xnfet_01v8_W1p4_L0p6_m96__nf1_gboth_sdfull_ng_72 x2_tail VSS_body VSS bias_a nfet_01v8_W1p4_L0p6_m96__nf1_gboth_sdfull_ng
Xnfet_01v8_W1p4_L0p6_m96__nf1_gboth_sdfull_ng_71 x2_tail VSS_body VSS bias_a nfet_01v8_W1p4_L0p6_m96__nf1_gboth_sdfull_ng
Xnfet_01v8_W1p4_L0p6_m96__nf1_gboth_sdfull_ng_61 x2_tail VSS_body VSS bias_a nfet_01v8_W1p4_L0p6_m96__nf1_gboth_sdfull_ng
Xnfet_01v8_W1p4_L0p6_m96__nf1_gboth_sdfull_ng_60 x2_tail VSS_body VSS bias_a nfet_01v8_W1p4_L0p6_m96__nf1_gboth_sdfull_ng
Xnfet_01v8_W1p4_L0p6_m96__nf1_gboth_sdfull_ng_50 x2_tail VSS_body VSS bias_a nfet_01v8_W1p4_L0p6_m96__nf1_gboth_sdfull_ng
Xnfet_01v8_W1p4_L0p6_m96__nf1_gboth_sdfull_ng_3 x2_tail VSS_body VSS bias_a nfet_01v8_W1p4_L0p6_m96__nf1_gboth_sdfull_ng
Xnfet_01v8_W1p4_L0p6_m96__nf1_gboth_sdfull_ng_95 x2_tail VSS_body VSS bias_a nfet_01v8_W1p4_L0p6_m96__nf1_gboth_sdfull_ng
Xnfet_01v8_W1p4_L0p6_m96__nf1_gboth_sdfull_ng_84 x2_tail VSS_body VSS bias_a nfet_01v8_W1p4_L0p6_m96__nf1_gboth_sdfull_ng
Xnfet_01v8_W1p4_L0p6_m96__nf1_gboth_sdfull_ng_73 x2_tail VSS_body VSS bias_a nfet_01v8_W1p4_L0p6_m96__nf1_gboth_sdfull_ng
Xnfet_01v8_W1p4_L0p6_m96__nf1_gboth_sdfull_ng_62 x2_tail VSS_body VSS bias_a nfet_01v8_W1p4_L0p6_m96__nf1_gboth_sdfull_ng
Xnfet_01v8_W1p4_L0p6_m96__nf1_gboth_sdfull_ng_51 x2_tail VSS_body VSS bias_a nfet_01v8_W1p4_L0p6_m96__nf1_gboth_sdfull_ng
Xnfet_01v8_W1p4_L0p6_m96__nf1_gboth_sdfull_ng_40 x2_tail VSS_body VSS bias_a nfet_01v8_W1p4_L0p6_m96__nf1_gboth_sdfull_ng
Xnfet_01v8_W1p4_L0p6_m96__nf1_gboth_sdfull_ng_4 x2_tail VSS_body VSS bias_a nfet_01v8_W1p4_L0p6_m96__nf1_gboth_sdfull_ng
Xnfet_01v8_W1p4_L0p6_m96__nf1_gboth_sdfull_ng_85 x2_tail VSS_body VSS bias_a nfet_01v8_W1p4_L0p6_m96__nf1_gboth_sdfull_ng
Xnfet_01v8_W1p4_L0p6_m96__nf1_gboth_sdfull_ng_74 x2_tail VSS_body VSS bias_a nfet_01v8_W1p4_L0p6_m96__nf1_gboth_sdfull_ng
Xnfet_01v8_W1p4_L0p6_m96__nf1_gboth_sdfull_ng_63 x2_tail VSS_body VSS bias_a nfet_01v8_W1p4_L0p6_m96__nf1_gboth_sdfull_ng
Xnfet_01v8_W1p4_L0p6_m96__nf1_gboth_sdfull_ng_52 x2_tail VSS_body VSS bias_a nfet_01v8_W1p4_L0p6_m96__nf1_gboth_sdfull_ng
Xnfet_01v8_W1p4_L0p6_m96__nf1_gboth_sdfull_ng_41 x2_tail VSS_body VSS bias_a nfet_01v8_W1p4_L0p6_m96__nf1_gboth_sdfull_ng
Xnfet_01v8_W1p4_L0p6_m96__nf1_gboth_sdfull_ng_30 x2_tail VSS_body VSS bias_a nfet_01v8_W1p4_L0p6_m96__nf1_gboth_sdfull_ng
Xnfet_01v8_W1p4_L0p6_m96__nf1_gboth_sdfull_ng_5 x2_tail VSS_body VSS bias_a nfet_01v8_W1p4_L0p6_m96__nf1_gboth_sdfull_ng
Xnfet_01v8_W1p4_L0p6_m96__nf1_gboth_sdfull_ng_86 x2_tail VSS_body VSS bias_a nfet_01v8_W1p4_L0p6_m96__nf1_gboth_sdfull_ng
Xnfet_01v8_W1p4_L0p6_m96__nf1_gboth_sdfull_ng_75 x2_tail VSS_body VSS bias_a nfet_01v8_W1p4_L0p6_m96__nf1_gboth_sdfull_ng
Xnfet_01v8_W1p4_L0p6_m96__nf1_gboth_sdfull_ng_64 x2_tail VSS_body VSS bias_a nfet_01v8_W1p4_L0p6_m96__nf1_gboth_sdfull_ng
Xnfet_01v8_W1p4_L0p6_m96__nf1_gboth_sdfull_ng_53 x2_tail VSS_body VSS bias_a nfet_01v8_W1p4_L0p6_m96__nf1_gboth_sdfull_ng
Xnfet_01v8_W1p4_L0p6_m96__nf1_gboth_sdfull_ng_42 x2_tail VSS_body VSS bias_a nfet_01v8_W1p4_L0p6_m96__nf1_gboth_sdfull_ng
Xnfet_01v8_W1p4_L0p6_m96__nf1_gboth_sdfull_ng_31 x2_tail VSS_body VSS bias_a nfet_01v8_W1p4_L0p6_m96__nf1_gboth_sdfull_ng
Xnfet_01v8_W1p4_L0p6_m96__nf1_gboth_sdfull_ng_20 x2_tail VSS_body VSS bias_a nfet_01v8_W1p4_L0p6_m96__nf1_gboth_sdfull_ng
Xnfet_01v8_W1p4_L0p6_m96__nf1_gboth_sdfull_ng_6 x2_tail VSS_body VSS bias_a nfet_01v8_W1p4_L0p6_m96__nf1_gboth_sdfull_ng
Xnfet_01v8_W1p4_L0p6_m96__nf1_gboth_sdfull_ng_87 x2_tail VSS_body VSS bias_a nfet_01v8_W1p4_L0p6_m96__nf1_gboth_sdfull_ng
Xnfet_01v8_W1p4_L0p6_m96__nf1_gboth_sdfull_ng_76 x2_tail VSS_body VSS bias_a nfet_01v8_W1p4_L0p6_m96__nf1_gboth_sdfull_ng
Xnfet_01v8_W1p4_L0p6_m96__nf1_gboth_sdfull_ng_65 x2_tail VSS_body VSS bias_a nfet_01v8_W1p4_L0p6_m96__nf1_gboth_sdfull_ng
Xnfet_01v8_W1p4_L0p6_m96__nf1_gboth_sdfull_ng_54 x2_tail VSS_body VSS bias_a nfet_01v8_W1p4_L0p6_m96__nf1_gboth_sdfull_ng
Xnfet_01v8_W1p4_L0p6_m96__nf1_gboth_sdfull_ng_43 x2_tail VSS_body VSS bias_a nfet_01v8_W1p4_L0p6_m96__nf1_gboth_sdfull_ng
Xnfet_01v8_W1p4_L0p6_m96__nf1_gboth_sdfull_ng_32 x2_tail VSS_body VSS bias_a nfet_01v8_W1p4_L0p6_m96__nf1_gboth_sdfull_ng
Xnfet_01v8_W1p4_L0p6_m96__nf1_gboth_sdfull_ng_21 x2_tail VSS_body VSS bias_a nfet_01v8_W1p4_L0p6_m96__nf1_gboth_sdfull_ng
Xnfet_01v8_W1p4_L0p6_m96__nf1_gboth_sdfull_ng_10 x2_tail VSS_body VSS bias_a nfet_01v8_W1p4_L0p6_m96__nf1_gboth_sdfull_ng
Xnfet_01v8_W1p4_L0p6_m96__nf1_gboth_sdfull_ng_7 x2_tail VSS_body VSS bias_a nfet_01v8_W1p4_L0p6_m96__nf1_gboth_sdfull_ng
Xnfet_01v8_W1p4_L0p6_m96__nf1_gboth_sdfull_ng_88 x2_tail VSS_body VSS bias_a nfet_01v8_W1p4_L0p6_m96__nf1_gboth_sdfull_ng
Xnfet_01v8_W1p4_L0p6_m96__nf1_gboth_sdfull_ng_77 x2_tail VSS_body VSS bias_a nfet_01v8_W1p4_L0p6_m96__nf1_gboth_sdfull_ng
Xnfet_01v8_W1p4_L0p6_m96__nf1_gboth_sdfull_ng_66 x2_tail VSS_body VSS bias_a nfet_01v8_W1p4_L0p6_m96__nf1_gboth_sdfull_ng
Xnfet_01v8_W1p4_L0p6_m96__nf1_gboth_sdfull_ng_55 x2_tail VSS_body VSS bias_a nfet_01v8_W1p4_L0p6_m96__nf1_gboth_sdfull_ng
Xnfet_01v8_W1p4_L0p6_m96__nf1_gboth_sdfull_ng_44 x2_tail VSS_body VSS bias_a nfet_01v8_W1p4_L0p6_m96__nf1_gboth_sdfull_ng
Xnfet_01v8_W1p4_L0p6_m96__nf1_gboth_sdfull_ng_33 x2_tail VSS_body VSS bias_a nfet_01v8_W1p4_L0p6_m96__nf1_gboth_sdfull_ng
Xnfet_01v8_W1p4_L0p6_m96__nf1_gboth_sdfull_ng_22 x2_tail VSS_body VSS bias_a nfet_01v8_W1p4_L0p6_m96__nf1_gboth_sdfull_ng
Xnfet_01v8_W1p4_L0p6_m96__nf1_gboth_sdfull_ng_11 x2_tail VSS_body VSS bias_a nfet_01v8_W1p4_L0p6_m96__nf1_gboth_sdfull_ng
Xnfet_01v8_W1p4_L0p6_m96__nf1_gboth_sdfull_ng_8 x2_tail VSS_body VSS bias_a nfet_01v8_W1p4_L0p6_m96__nf1_gboth_sdfull_ng
Xnfet_01v8_W1p4_L0p6_m96__nf1_gboth_sdfull_ng_89 x2_tail VSS_body VSS bias_a nfet_01v8_W1p4_L0p6_m96__nf1_gboth_sdfull_ng
Xnfet_01v8_W1p4_L0p6_m96__nf1_gboth_sdfull_ng_78 x2_tail VSS_body VSS bias_a nfet_01v8_W1p4_L0p6_m96__nf1_gboth_sdfull_ng
Xnfet_01v8_W1p4_L0p6_m96__nf1_gboth_sdfull_ng_67 x2_tail VSS_body VSS bias_a nfet_01v8_W1p4_L0p6_m96__nf1_gboth_sdfull_ng
Xnfet_01v8_W1p4_L0p6_m96__nf1_gboth_sdfull_ng_56 x2_tail VSS_body VSS bias_a nfet_01v8_W1p4_L0p6_m96__nf1_gboth_sdfull_ng
Xnfet_01v8_W1p4_L0p6_m96__nf1_gboth_sdfull_ng_45 x2_tail VSS_body VSS bias_a nfet_01v8_W1p4_L0p6_m96__nf1_gboth_sdfull_ng
Xnfet_01v8_W1p4_L0p6_m96__nf1_gboth_sdfull_ng_34 x2_tail VSS_body VSS bias_a nfet_01v8_W1p4_L0p6_m96__nf1_gboth_sdfull_ng
Xnfet_01v8_W1p4_L0p6_m96__nf1_gboth_sdfull_ng_23 x2_tail VSS_body VSS bias_a nfet_01v8_W1p4_L0p6_m96__nf1_gboth_sdfull_ng
Xnfet_01v8_W1p4_L0p6_m96__nf1_gboth_sdfull_ng_12 x2_tail VSS_body VSS bias_a nfet_01v8_W1p4_L0p6_m96__nf1_gboth_sdfull_ng
Xnfet_01v8_W1p4_L0p6_m96__nf1_gboth_sdfull_ng_9 x2_tail VSS_body VSS bias_a nfet_01v8_W1p4_L0p6_m96__nf1_gboth_sdfull_ng
Xnfet_01v8_W1p4_L0p6_m96__nf1_gboth_sdfull_ng_79 x2_tail VSS_body VSS bias_a nfet_01v8_W1p4_L0p6_m96__nf1_gboth_sdfull_ng
Xnfet_01v8_W1p4_L0p6_m96__nf1_gboth_sdfull_ng_68 x2_tail VSS_body VSS bias_a nfet_01v8_W1p4_L0p6_m96__nf1_gboth_sdfull_ng
Xnfet_01v8_W1p4_L0p6_m96__nf1_gboth_sdfull_ng_57 x2_tail VSS_body VSS bias_a nfet_01v8_W1p4_L0p6_m96__nf1_gboth_sdfull_ng
Xnfet_01v8_W1p4_L0p6_m96__nf1_gboth_sdfull_ng_46 x2_tail VSS_body VSS bias_a nfet_01v8_W1p4_L0p6_m96__nf1_gboth_sdfull_ng
Xnfet_01v8_W1p4_L0p6_m96__nf1_gboth_sdfull_ng_35 x2_tail VSS_body VSS bias_a nfet_01v8_W1p4_L0p6_m96__nf1_gboth_sdfull_ng
Xnfet_01v8_W1p4_L0p6_m96__nf1_gboth_sdfull_ng_24 x2_tail VSS_body VSS bias_a nfet_01v8_W1p4_L0p6_m96__nf1_gboth_sdfull_ng
Xnfet_01v8_W1p4_L0p6_m96__nf1_gboth_sdfull_ng_13 x2_tail VSS_body VSS bias_a nfet_01v8_W1p4_L0p6_m96__nf1_gboth_sdfull_ng
Xnfet_01v8_W1p4_L0p6_m96__nf1_gboth_sdfull_ng_69 x2_tail VSS_body VSS bias_a nfet_01v8_W1p4_L0p6_m96__nf1_gboth_sdfull_ng
Xnfet_01v8_W1p4_L0p6_m96__nf1_gboth_sdfull_ng_59 x2_tail VSS_body VSS bias_a nfet_01v8_W1p4_L0p6_m96__nf1_gboth_sdfull_ng
Xnfet_01v8_W1p4_L0p6_m96__nf1_gboth_sdfull_ng_58 x2_tail VSS_body VSS bias_a nfet_01v8_W1p4_L0p6_m96__nf1_gboth_sdfull_ng
Xnfet_01v8_W1p4_L0p6_m96__nf1_gboth_sdfull_ng_48 x2_tail VSS_body VSS bias_a nfet_01v8_W1p4_L0p6_m96__nf1_gboth_sdfull_ng
Xnfet_01v8_W1p4_L0p6_m96__nf1_gboth_sdfull_ng_47 x2_tail VSS_body VSS bias_a nfet_01v8_W1p4_L0p6_m96__nf1_gboth_sdfull_ng
Xnfet_01v8_W1p4_L0p6_m96__nf1_gboth_sdfull_ng_37 x2_tail VSS_body VSS bias_a nfet_01v8_W1p4_L0p6_m96__nf1_gboth_sdfull_ng
Xnfet_01v8_W1p4_L0p6_m96__nf1_gboth_sdfull_ng_36 x2_tail VSS_body VSS bias_a nfet_01v8_W1p4_L0p6_m96__nf1_gboth_sdfull_ng
Xnfet_01v8_W1p4_L0p6_m96__nf1_gboth_sdfull_ng_26 x2_tail VSS_body VSS bias_a nfet_01v8_W1p4_L0p6_m96__nf1_gboth_sdfull_ng
Xnfet_01v8_W1p4_L0p6_m96__nf1_gboth_sdfull_ng_25 x2_tail VSS_body VSS bias_a nfet_01v8_W1p4_L0p6_m96__nf1_gboth_sdfull_ng
Xnfet_01v8_W1p4_L0p6_m96__nf1_gboth_sdfull_ng_15 x2_tail VSS_body VSS bias_a nfet_01v8_W1p4_L0p6_m96__nf1_gboth_sdfull_ng
Xnfet_01v8_W1p4_L0p6_m96__nf1_gboth_sdfull_ng_14 x2_tail VSS_body VSS bias_a nfet_01v8_W1p4_L0p6_m96__nf1_gboth_sdfull_ng
Xnfet_01v8_W1p4_L0p6_m96__nf1_gboth_sdfull_ng_49 x2_tail VSS_body VSS bias_a nfet_01v8_W1p4_L0p6_m96__nf1_gboth_sdfull_ng
Xnfet_01v8_W1p4_L0p6_m96__nf1_gboth_sdfull_ng_38 x2_tail VSS_body VSS bias_a nfet_01v8_W1p4_L0p6_m96__nf1_gboth_sdfull_ng
Xnfet_01v8_W1p4_L0p6_m96__nf1_gboth_sdfull_ng_27 x2_tail VSS_body VSS bias_a nfet_01v8_W1p4_L0p6_m96__nf1_gboth_sdfull_ng
Xnfet_01v8_W1p4_L0p6_m96__nf1_gboth_sdfull_ng_16 x2_tail VSS_body VSS bias_a nfet_01v8_W1p4_L0p6_m96__nf1_gboth_sdfull_ng
Xnfet_01v8_W1p4_L0p6_m96__nf1_gboth_sdfull_ng_39 x2_tail VSS_body VSS bias_a nfet_01v8_W1p4_L0p6_m96__nf1_gboth_sdfull_ng
Xnfet_01v8_W1p4_L0p6_m96__nf1_gboth_sdfull_ng_28 x2_tail VSS_body VSS bias_a nfet_01v8_W1p4_L0p6_m96__nf1_gboth_sdfull_ng
Xnfet_01v8_W1p4_L0p6_m96__nf1_gboth_sdfull_ng_17 x2_tail VSS_body VSS bias_a nfet_01v8_W1p4_L0p6_m96__nf1_gboth_sdfull_ng
Xnfet_01v8_W1p4_L0p6_m96__nf1_gboth_sdfull_ng_29 x2_tail VSS_body VSS bias_a nfet_01v8_W1p4_L0p6_m96__nf1_gboth_sdfull_ng
Xnfet_01v8_W1p4_L0p6_m96__nf1_gboth_sdfull_ng_18 x2_tail VSS_body VSS bias_a nfet_01v8_W1p4_L0p6_m96__nf1_gboth_sdfull_ng
Xnfet_01v8_W1p4_L0p6_m96__nf1_gboth_sdfull_ng_19 x2_tail VSS_body VSS bias_a nfet_01v8_W1p4_L0p6_m96__nf1_gboth_sdfull_ng
Xnfet_01v8_W1p4_L0p6_m96__nf1_gboth_sdfull_ng_90 x2_tail VSS_body VSS bias_a nfet_01v8_W1p4_L0p6_m96__nf1_gboth_sdfull_ng
.ends

.subckt nfet_01v8_W1p4_L0p6_m2__nf1_gboth_sdfull_ng B S G D
Xnfet_01v8_W1p4_L0p6_m2__nf1_gboth_sdfull_ng_pc G D S B sky130_fd_pr__nfet_01v8_KCM6UP
.ends

.subckt nmos_dummy_17__A on VSS_body
Xnfet_01v8_W1p4_L0p6_m2__nf1_gboth_sdfull_ng_0 VSS_body on on on nfet_01v8_W1p4_L0p6_m2__nf1_gboth_sdfull_ng
Xnfet_01v8_W1p4_L0p6_m2__nf1_gboth_sdfull_ng_1 VSS_body on on on nfet_01v8_W1p4_L0p6_m2__nf1_gboth_sdfull_ng
.ends

.subckt sky130_fd_pr__nfet_01v8_lvt_RUA5M6 G D S VSUBS
X0 S G D VSUBS sky130_fd_pr__nfet_01v8_lvt ad=0.406 pd=3.38 as=0.406 ps=3.38 w=1.4 l=0.6
.ends

.subckt nfet_01v8_lvt_W1p4_L0p6_m8__nf1_gtop_sdfull_ng B G D S
Xnfet_01v8_lvt_W1p4_L0p6_m8__nf1_gtop_sdfull_ng_pc G D S B sky130_fd_pr__nfet_01v8_lvt_RUA5M6
.ends

.subckt nmos_dummy_3__A bias_b VSS_body
Xnfet_01v8_lvt_W1p4_L0p6_m8__nf1_gtop_sdfull_ng_0 VSS_body bias_b bias_b bias_b nfet_01v8_lvt_W1p4_L0p6_m8__nf1_gtop_sdfull_ng
Xnfet_01v8_lvt_W1p4_L0p6_m8__nf1_gtop_sdfull_ng_1 VSS_body bias_b bias_b bias_b nfet_01v8_lvt_W1p4_L0p6_m8__nf1_gtop_sdfull_ng
Xnfet_01v8_lvt_W1p4_L0p6_m8__nf1_gtop_sdfull_ng_2 VSS_body bias_b bias_b bias_b nfet_01v8_lvt_W1p4_L0p6_m8__nf1_gtop_sdfull_ng
Xnfet_01v8_lvt_W1p4_L0p6_m8__nf1_gtop_sdfull_ng_3 VSS_body bias_b bias_b bias_b nfet_01v8_lvt_W1p4_L0p6_m8__nf1_gtop_sdfull_ng
Xnfet_01v8_lvt_W1p4_L0p6_m8__nf1_gtop_sdfull_ng_4 VSS_body bias_b bias_b bias_b nfet_01v8_lvt_W1p4_L0p6_m8__nf1_gtop_sdfull_ng
Xnfet_01v8_lvt_W1p4_L0p6_m8__nf1_gtop_sdfull_ng_5 VSS_body bias_b bias_b bias_b nfet_01v8_lvt_W1p4_L0p6_m8__nf1_gtop_sdfull_ng
Xnfet_01v8_lvt_W1p4_L0p6_m8__nf1_gtop_sdfull_ng_6 VSS_body bias_b bias_b bias_b nfet_01v8_lvt_W1p4_L0p6_m8__nf1_gtop_sdfull_ng
Xnfet_01v8_lvt_W1p4_L0p6_m8__nf1_gtop_sdfull_ng_7 VSS_body bias_b bias_b bias_b nfet_01v8_lvt_W1p4_L0p6_m8__nf1_gtop_sdfull_ng
.ends

.subckt sky130_fd_pr__pfet_01v8_FGX5XW G D w_n154_n238# S
X0 S G D w_n154_n238# sky130_fd_pr__pfet_01v8 ad=0.406 pd=3.38 as=0.406 ps=3.38 w=1.4 l=0.6
.ends

.subckt pfet_01v8_W1p4_L0p6_m4__nf1_gtop_sdhalf_ng G D B S
Xpfet_01v8_W1p4_L0p6_m4__nf1_gtop_sdhalf_ng_pc G D B S sky130_fd_pr__pfet_01v8_FGX5XW
.ends

.subckt pmos_dummy_13__A op VDD VDD_body
Xpfet_01v8_W1p4_L0p6_m4__nf1_gtop_sdhalf_ng_0 VDD op VDD_body VDD pfet_01v8_W1p4_L0p6_m4__nf1_gtop_sdhalf_ng
Xpfet_01v8_W1p4_L0p6_m4__nf1_gtop_sdhalf_ng_1 VDD op VDD_body VDD pfet_01v8_W1p4_L0p6_m4__nf1_gtop_sdhalf_ng
Xpfet_01v8_W1p4_L0p6_m4__nf1_gtop_sdhalf_ng_2 VDD op VDD_body VDD pfet_01v8_W1p4_L0p6_m4__nf1_gtop_sdhalf_ng
Xpfet_01v8_W1p4_L0p6_m4__nf1_gtop_sdhalf_ng_3 VDD op VDD_body VDD pfet_01v8_W1p4_L0p6_m4__nf1_gtop_sdhalf_ng
.ends

.subckt sky130_fd_pr__pfet_01v8_lvt_L7GY3J G D w_n154_n238# S
X0 S G D w_n154_n238# sky130_fd_pr__pfet_01v8_lvt ad=0.406 pd=3.38 as=0.406 ps=3.38 w=1.4 l=0.6
.ends

.subckt pfet_01v8_lvt_W1p4_L0p6_m2__nf1_gtop_sdfull_ng B G D S
Xpfet_01v8_lvt_W1p4_L0p6_m2__nf1_gtop_sdfull_ng_pc G D B S sky130_fd_pr__pfet_01v8_lvt_L7GY3J
.ends

.subckt pmos_dummy_4__A x1_m25d VDD_body
Xpfet_01v8_lvt_W1p4_L0p6_m2__nf1_gtop_sdfull_ng_0 VDD_body x1_m25d x1_m25d x1_m25d
+ pfet_01v8_lvt_W1p4_L0p6_m2__nf1_gtop_sdfull_ng
Xpfet_01v8_lvt_W1p4_L0p6_m2__nf1_gtop_sdfull_ng_1 VDD_body x1_m25d x1_m25d x1_m25d
+ pfet_01v8_lvt_W1p4_L0p6_m2__nf1_gtop_sdfull_ng
.ends

.subckt nmos_single__A bias_a x1_m2d VSS_body bias_d
Xnfet_01v8_W1p4_L0p6_m2__nf1_gboth_sdfull_ng_0 VSS_body bias_a x1_m2d bias_d nfet_01v8_W1p4_L0p6_m2__nf1_gboth_sdfull_ng
Xnfet_01v8_W1p4_L0p6_m2__nf1_gboth_sdfull_ng_1 VSS_body bias_a x1_m2d bias_d nfet_01v8_W1p4_L0p6_m2__nf1_gboth_sdfull_ng
.ends

.subckt nmos_dummy_6__A x1_m2d VSS_body
Xnfet_01v8_W1p4_L0p6_m2__nf1_gboth_sdfull_ng_0 VSS_body x1_m2d x1_m2d x1_m2d nfet_01v8_W1p4_L0p6_m2__nf1_gboth_sdfull_ng
Xnfet_01v8_W1p4_L0p6_m2__nf1_gboth_sdfull_ng_1 VSS_body x1_m2d x1_m2d x1_m2d nfet_01v8_W1p4_L0p6_m2__nf1_gboth_sdfull_ng
.ends

.subckt sky130_fd_pr__nfet_01v8_lvt_KCM6UP G D S VSUBS
X0 S G D VSUBS sky130_fd_pr__nfet_01v8_lvt ad=0.406 pd=3.38 as=0.406 ps=3.38 w=1.4 l=0.6
.ends

.subckt nfet_01v8_lvt_W1p4_L0p6_m56__nf1_gboth_sdfull_ng S B G D
Xnfet_01v8_lvt_W1p4_L0p6_m56__nf1_gboth_sdfull_ng_pc G D S B sky130_fd_pr__nfet_01v8_lvt_KCM6UP
.ends

.subckt nmos_diode__A bias_b VSS_body bias_c
Xnfet_01v8_lvt_W1p4_L0p6_m56__nf1_gboth_sdfull_ng_13 bias_c VSS_body bias_b bias_b
+ nfet_01v8_lvt_W1p4_L0p6_m56__nf1_gboth_sdfull_ng
Xnfet_01v8_lvt_W1p4_L0p6_m56__nf1_gboth_sdfull_ng_24 bias_c VSS_body bias_b bias_b
+ nfet_01v8_lvt_W1p4_L0p6_m56__nf1_gboth_sdfull_ng
Xnfet_01v8_lvt_W1p4_L0p6_m56__nf1_gboth_sdfull_ng_35 bias_c VSS_body bias_b bias_b
+ nfet_01v8_lvt_W1p4_L0p6_m56__nf1_gboth_sdfull_ng
Xnfet_01v8_lvt_W1p4_L0p6_m56__nf1_gboth_sdfull_ng_46 bias_c VSS_body bias_b bias_b
+ nfet_01v8_lvt_W1p4_L0p6_m56__nf1_gboth_sdfull_ng
Xnfet_01v8_lvt_W1p4_L0p6_m56__nf1_gboth_sdfull_ng_14 bias_c VSS_body bias_b bias_b
+ nfet_01v8_lvt_W1p4_L0p6_m56__nf1_gboth_sdfull_ng
Xnfet_01v8_lvt_W1p4_L0p6_m56__nf1_gboth_sdfull_ng_25 bias_c VSS_body bias_b bias_b
+ nfet_01v8_lvt_W1p4_L0p6_m56__nf1_gboth_sdfull_ng
Xnfet_01v8_lvt_W1p4_L0p6_m56__nf1_gboth_sdfull_ng_36 bias_c VSS_body bias_b bias_b
+ nfet_01v8_lvt_W1p4_L0p6_m56__nf1_gboth_sdfull_ng
Xnfet_01v8_lvt_W1p4_L0p6_m56__nf1_gboth_sdfull_ng_47 bias_c VSS_body bias_b bias_b
+ nfet_01v8_lvt_W1p4_L0p6_m56__nf1_gboth_sdfull_ng
Xnfet_01v8_lvt_W1p4_L0p6_m56__nf1_gboth_sdfull_ng_15 bias_c VSS_body bias_b bias_b
+ nfet_01v8_lvt_W1p4_L0p6_m56__nf1_gboth_sdfull_ng
Xnfet_01v8_lvt_W1p4_L0p6_m56__nf1_gboth_sdfull_ng_26 bias_c VSS_body bias_b bias_b
+ nfet_01v8_lvt_W1p4_L0p6_m56__nf1_gboth_sdfull_ng
Xnfet_01v8_lvt_W1p4_L0p6_m56__nf1_gboth_sdfull_ng_37 bias_c VSS_body bias_b bias_b
+ nfet_01v8_lvt_W1p4_L0p6_m56__nf1_gboth_sdfull_ng
Xnfet_01v8_lvt_W1p4_L0p6_m56__nf1_gboth_sdfull_ng_48 bias_c VSS_body bias_b bias_b
+ nfet_01v8_lvt_W1p4_L0p6_m56__nf1_gboth_sdfull_ng
Xnfet_01v8_lvt_W1p4_L0p6_m56__nf1_gboth_sdfull_ng_16 bias_c VSS_body bias_b bias_b
+ nfet_01v8_lvt_W1p4_L0p6_m56__nf1_gboth_sdfull_ng
Xnfet_01v8_lvt_W1p4_L0p6_m56__nf1_gboth_sdfull_ng_17 bias_c VSS_body bias_b bias_b
+ nfet_01v8_lvt_W1p4_L0p6_m56__nf1_gboth_sdfull_ng
Xnfet_01v8_lvt_W1p4_L0p6_m56__nf1_gboth_sdfull_ng_27 bias_c VSS_body bias_b bias_b
+ nfet_01v8_lvt_W1p4_L0p6_m56__nf1_gboth_sdfull_ng
Xnfet_01v8_lvt_W1p4_L0p6_m56__nf1_gboth_sdfull_ng_28 bias_c VSS_body bias_b bias_b
+ nfet_01v8_lvt_W1p4_L0p6_m56__nf1_gboth_sdfull_ng
Xnfet_01v8_lvt_W1p4_L0p6_m56__nf1_gboth_sdfull_ng_38 bias_c VSS_body bias_b bias_b
+ nfet_01v8_lvt_W1p4_L0p6_m56__nf1_gboth_sdfull_ng
Xnfet_01v8_lvt_W1p4_L0p6_m56__nf1_gboth_sdfull_ng_39 bias_c VSS_body bias_b bias_b
+ nfet_01v8_lvt_W1p4_L0p6_m56__nf1_gboth_sdfull_ng
Xnfet_01v8_lvt_W1p4_L0p6_m56__nf1_gboth_sdfull_ng_49 bias_c VSS_body bias_b bias_b
+ nfet_01v8_lvt_W1p4_L0p6_m56__nf1_gboth_sdfull_ng
Xnfet_01v8_lvt_W1p4_L0p6_m56__nf1_gboth_sdfull_ng_18 bias_c VSS_body bias_b bias_b
+ nfet_01v8_lvt_W1p4_L0p6_m56__nf1_gboth_sdfull_ng
Xnfet_01v8_lvt_W1p4_L0p6_m56__nf1_gboth_sdfull_ng_29 bias_c VSS_body bias_b bias_b
+ nfet_01v8_lvt_W1p4_L0p6_m56__nf1_gboth_sdfull_ng
Xnfet_01v8_lvt_W1p4_L0p6_m56__nf1_gboth_sdfull_ng_19 bias_c VSS_body bias_b bias_b
+ nfet_01v8_lvt_W1p4_L0p6_m56__nf1_gboth_sdfull_ng
Xnfet_01v8_lvt_W1p4_L0p6_m56__nf1_gboth_sdfull_ng_0 bias_c VSS_body bias_b bias_b
+ nfet_01v8_lvt_W1p4_L0p6_m56__nf1_gboth_sdfull_ng
Xnfet_01v8_lvt_W1p4_L0p6_m56__nf1_gboth_sdfull_ng_1 bias_c VSS_body bias_b bias_b
+ nfet_01v8_lvt_W1p4_L0p6_m56__nf1_gboth_sdfull_ng
Xnfet_01v8_lvt_W1p4_L0p6_m56__nf1_gboth_sdfull_ng_2 bias_c VSS_body bias_b bias_b
+ nfet_01v8_lvt_W1p4_L0p6_m56__nf1_gboth_sdfull_ng
Xnfet_01v8_lvt_W1p4_L0p6_m56__nf1_gboth_sdfull_ng_3 bias_c VSS_body bias_b bias_b
+ nfet_01v8_lvt_W1p4_L0p6_m56__nf1_gboth_sdfull_ng
Xnfet_01v8_lvt_W1p4_L0p6_m56__nf1_gboth_sdfull_ng_4 bias_c VSS_body bias_b bias_b
+ nfet_01v8_lvt_W1p4_L0p6_m56__nf1_gboth_sdfull_ng
Xnfet_01v8_lvt_W1p4_L0p6_m56__nf1_gboth_sdfull_ng_5 bias_c VSS_body bias_b bias_b
+ nfet_01v8_lvt_W1p4_L0p6_m56__nf1_gboth_sdfull_ng
Xnfet_01v8_lvt_W1p4_L0p6_m56__nf1_gboth_sdfull_ng_6 bias_c VSS_body bias_b bias_b
+ nfet_01v8_lvt_W1p4_L0p6_m56__nf1_gboth_sdfull_ng
Xnfet_01v8_lvt_W1p4_L0p6_m56__nf1_gboth_sdfull_ng_7 bias_c VSS_body bias_b bias_b
+ nfet_01v8_lvt_W1p4_L0p6_m56__nf1_gboth_sdfull_ng
Xnfet_01v8_lvt_W1p4_L0p6_m56__nf1_gboth_sdfull_ng_8 bias_c VSS_body bias_b bias_b
+ nfet_01v8_lvt_W1p4_L0p6_m56__nf1_gboth_sdfull_ng
Xnfet_01v8_lvt_W1p4_L0p6_m56__nf1_gboth_sdfull_ng_9 bias_c VSS_body bias_b bias_b
+ nfet_01v8_lvt_W1p4_L0p6_m56__nf1_gboth_sdfull_ng
Xnfet_01v8_lvt_W1p4_L0p6_m56__nf1_gboth_sdfull_ng_50 bias_c VSS_body bias_b bias_b
+ nfet_01v8_lvt_W1p4_L0p6_m56__nf1_gboth_sdfull_ng
Xnfet_01v8_lvt_W1p4_L0p6_m56__nf1_gboth_sdfull_ng_30 bias_c VSS_body bias_b bias_b
+ nfet_01v8_lvt_W1p4_L0p6_m56__nf1_gboth_sdfull_ng
Xnfet_01v8_lvt_W1p4_L0p6_m56__nf1_gboth_sdfull_ng_40 bias_c VSS_body bias_b bias_b
+ nfet_01v8_lvt_W1p4_L0p6_m56__nf1_gboth_sdfull_ng
Xnfet_01v8_lvt_W1p4_L0p6_m56__nf1_gboth_sdfull_ng_41 bias_c VSS_body bias_b bias_b
+ nfet_01v8_lvt_W1p4_L0p6_m56__nf1_gboth_sdfull_ng
Xnfet_01v8_lvt_W1p4_L0p6_m56__nf1_gboth_sdfull_ng_51 bias_c VSS_body bias_b bias_b
+ nfet_01v8_lvt_W1p4_L0p6_m56__nf1_gboth_sdfull_ng
Xnfet_01v8_lvt_W1p4_L0p6_m56__nf1_gboth_sdfull_ng_52 bias_c VSS_body bias_b bias_b
+ nfet_01v8_lvt_W1p4_L0p6_m56__nf1_gboth_sdfull_ng
Xnfet_01v8_lvt_W1p4_L0p6_m56__nf1_gboth_sdfull_ng_20 bias_c VSS_body bias_b bias_b
+ nfet_01v8_lvt_W1p4_L0p6_m56__nf1_gboth_sdfull_ng
Xnfet_01v8_lvt_W1p4_L0p6_m56__nf1_gboth_sdfull_ng_31 bias_c VSS_body bias_b bias_b
+ nfet_01v8_lvt_W1p4_L0p6_m56__nf1_gboth_sdfull_ng
Xnfet_01v8_lvt_W1p4_L0p6_m56__nf1_gboth_sdfull_ng_42 bias_c VSS_body bias_b bias_b
+ nfet_01v8_lvt_W1p4_L0p6_m56__nf1_gboth_sdfull_ng
Xnfet_01v8_lvt_W1p4_L0p6_m56__nf1_gboth_sdfull_ng_53 bias_c VSS_body bias_b bias_b
+ nfet_01v8_lvt_W1p4_L0p6_m56__nf1_gboth_sdfull_ng
Xnfet_01v8_lvt_W1p4_L0p6_m56__nf1_gboth_sdfull_ng_10 bias_c VSS_body bias_b bias_b
+ nfet_01v8_lvt_W1p4_L0p6_m56__nf1_gboth_sdfull_ng
Xnfet_01v8_lvt_W1p4_L0p6_m56__nf1_gboth_sdfull_ng_21 bias_c VSS_body bias_b bias_b
+ nfet_01v8_lvt_W1p4_L0p6_m56__nf1_gboth_sdfull_ng
Xnfet_01v8_lvt_W1p4_L0p6_m56__nf1_gboth_sdfull_ng_32 bias_c VSS_body bias_b bias_b
+ nfet_01v8_lvt_W1p4_L0p6_m56__nf1_gboth_sdfull_ng
Xnfet_01v8_lvt_W1p4_L0p6_m56__nf1_gboth_sdfull_ng_43 bias_c VSS_body bias_b bias_b
+ nfet_01v8_lvt_W1p4_L0p6_m56__nf1_gboth_sdfull_ng
Xnfet_01v8_lvt_W1p4_L0p6_m56__nf1_gboth_sdfull_ng_54 bias_c VSS_body bias_b bias_b
+ nfet_01v8_lvt_W1p4_L0p6_m56__nf1_gboth_sdfull_ng
Xnfet_01v8_lvt_W1p4_L0p6_m56__nf1_gboth_sdfull_ng_11 bias_c VSS_body bias_b bias_b
+ nfet_01v8_lvt_W1p4_L0p6_m56__nf1_gboth_sdfull_ng
Xnfet_01v8_lvt_W1p4_L0p6_m56__nf1_gboth_sdfull_ng_22 bias_c VSS_body bias_b bias_b
+ nfet_01v8_lvt_W1p4_L0p6_m56__nf1_gboth_sdfull_ng
Xnfet_01v8_lvt_W1p4_L0p6_m56__nf1_gboth_sdfull_ng_33 bias_c VSS_body bias_b bias_b
+ nfet_01v8_lvt_W1p4_L0p6_m56__nf1_gboth_sdfull_ng
Xnfet_01v8_lvt_W1p4_L0p6_m56__nf1_gboth_sdfull_ng_44 bias_c VSS_body bias_b bias_b
+ nfet_01v8_lvt_W1p4_L0p6_m56__nf1_gboth_sdfull_ng
Xnfet_01v8_lvt_W1p4_L0p6_m56__nf1_gboth_sdfull_ng_55 bias_c VSS_body bias_b bias_b
+ nfet_01v8_lvt_W1p4_L0p6_m56__nf1_gboth_sdfull_ng
Xnfet_01v8_lvt_W1p4_L0p6_m56__nf1_gboth_sdfull_ng_12 bias_c VSS_body bias_b bias_b
+ nfet_01v8_lvt_W1p4_L0p6_m56__nf1_gboth_sdfull_ng
Xnfet_01v8_lvt_W1p4_L0p6_m56__nf1_gboth_sdfull_ng_23 bias_c VSS_body bias_b bias_b
+ nfet_01v8_lvt_W1p4_L0p6_m56__nf1_gboth_sdfull_ng
Xnfet_01v8_lvt_W1p4_L0p6_m56__nf1_gboth_sdfull_ng_34 bias_c VSS_body bias_b bias_b
+ nfet_01v8_lvt_W1p4_L0p6_m56__nf1_gboth_sdfull_ng
Xnfet_01v8_lvt_W1p4_L0p6_m56__nf1_gboth_sdfull_ng_45 bias_c VSS_body bias_b bias_b
+ nfet_01v8_lvt_W1p4_L0p6_m56__nf1_gboth_sdfull_ng
.ends

.subckt pmos_dummy_16__A VDD_body x2_foldn
Xpfet_01v8_W1p4_L0p6_m2__nf1_gtop_sdfull_ng_0 VDD_body x2_foldn x2_foldn x2_foldn
+ pfet_01v8_W1p4_L0p6_m2__nf1_gtop_sdfull_ng
Xpfet_01v8_W1p4_L0p6_m2__nf1_gtop_sdfull_ng_1 VDD_body x2_foldn x2_foldn x2_foldn
+ pfet_01v8_W1p4_L0p6_m2__nf1_gtop_sdfull_ng
.ends

.subckt nmos_dummy_20__A VSS op VSS_body
Xnfet_01v8_W1p4_L0p6_m2__nf1_gboth_sdfull_ng_0 VSS_body VSS VSS op nfet_01v8_W1p4_L0p6_m2__nf1_gboth_sdfull_ng
Xnfet_01v8_W1p4_L0p6_m2__nf1_gboth_sdfull_ng_1 VSS_body VSS VSS op nfet_01v8_W1p4_L0p6_m2__nf1_gboth_sdfull_ng
.ends

.subckt nfet_01v8_W1p4_L0p6_m36__nf1_gboth_sdfull_ng B S G D
Xnfet_01v8_W1p4_L0p6_m36__nf1_gboth_sdfull_ng_pc G D S B sky130_fd_pr__nfet_01v8_KCM6UP
.ends

.subckt nmos_matched_current_source_pair__ABAB x2_m3d VSS x2_m4d bias_a VSS_body
Xnfet_01v8_W1p4_L0p6_m36__nf1_gboth_sdfull_ng_11 VSS_body VSS bias_a x2_m3d nfet_01v8_W1p4_L0p6_m36__nf1_gboth_sdfull_ng
Xnfet_01v8_W1p4_L0p6_m36__nf1_gboth_sdfull_ng_22 VSS_body VSS bias_a x2_m4d nfet_01v8_W1p4_L0p6_m36__nf1_gboth_sdfull_ng
Xnfet_01v8_W1p4_L0p6_m36__nf1_gboth_sdfull_ng_33 VSS_body VSS bias_a x2_m3d nfet_01v8_W1p4_L0p6_m36__nf1_gboth_sdfull_ng
Xnfet_01v8_W1p4_L0p6_m36__nf1_gboth_sdfull_ng_44 VSS_body VSS bias_a x2_m4d nfet_01v8_W1p4_L0p6_m36__nf1_gboth_sdfull_ng
Xnfet_01v8_W1p4_L0p6_m36__nf1_gboth_sdfull_ng_55 VSS_body VSS bias_a x2_m3d nfet_01v8_W1p4_L0p6_m36__nf1_gboth_sdfull_ng
Xnfet_01v8_W1p4_L0p6_m36__nf1_gboth_sdfull_ng_66 VSS_body VSS bias_a x2_m4d nfet_01v8_W1p4_L0p6_m36__nf1_gboth_sdfull_ng
Xnfet_01v8_W1p4_L0p6_m36__nf1_gboth_sdfull_ng_12 VSS_body VSS bias_a x2_m4d nfet_01v8_W1p4_L0p6_m36__nf1_gboth_sdfull_ng
Xnfet_01v8_W1p4_L0p6_m36__nf1_gboth_sdfull_ng_23 VSS_body VSS bias_a x2_m3d nfet_01v8_W1p4_L0p6_m36__nf1_gboth_sdfull_ng
Xnfet_01v8_W1p4_L0p6_m36__nf1_gboth_sdfull_ng_34 VSS_body VSS bias_a x2_m4d nfet_01v8_W1p4_L0p6_m36__nf1_gboth_sdfull_ng
Xnfet_01v8_W1p4_L0p6_m36__nf1_gboth_sdfull_ng_45 VSS_body VSS bias_a x2_m3d nfet_01v8_W1p4_L0p6_m36__nf1_gboth_sdfull_ng
Xnfet_01v8_W1p4_L0p6_m36__nf1_gboth_sdfull_ng_56 VSS_body VSS bias_a x2_m4d nfet_01v8_W1p4_L0p6_m36__nf1_gboth_sdfull_ng
Xnfet_01v8_W1p4_L0p6_m36__nf1_gboth_sdfull_ng_67 VSS_body VSS bias_a x2_m3d nfet_01v8_W1p4_L0p6_m36__nf1_gboth_sdfull_ng
Xnfet_01v8_W1p4_L0p6_m36__nf1_gboth_sdfull_ng_13 VSS_body VSS bias_a x2_m3d nfet_01v8_W1p4_L0p6_m36__nf1_gboth_sdfull_ng
Xnfet_01v8_W1p4_L0p6_m36__nf1_gboth_sdfull_ng_24 VSS_body VSS bias_a x2_m4d nfet_01v8_W1p4_L0p6_m36__nf1_gboth_sdfull_ng
Xnfet_01v8_W1p4_L0p6_m36__nf1_gboth_sdfull_ng_35 VSS_body VSS bias_a x2_m3d nfet_01v8_W1p4_L0p6_m36__nf1_gboth_sdfull_ng
Xnfet_01v8_W1p4_L0p6_m36__nf1_gboth_sdfull_ng_46 VSS_body VSS bias_a x2_m4d nfet_01v8_W1p4_L0p6_m36__nf1_gboth_sdfull_ng
Xnfet_01v8_W1p4_L0p6_m36__nf1_gboth_sdfull_ng_57 VSS_body VSS bias_a x2_m3d nfet_01v8_W1p4_L0p6_m36__nf1_gboth_sdfull_ng
Xnfet_01v8_W1p4_L0p6_m36__nf1_gboth_sdfull_ng_68 VSS_body VSS bias_a x2_m4d nfet_01v8_W1p4_L0p6_m36__nf1_gboth_sdfull_ng
Xnfet_01v8_W1p4_L0p6_m36__nf1_gboth_sdfull_ng_14 VSS_body VSS bias_a x2_m4d nfet_01v8_W1p4_L0p6_m36__nf1_gboth_sdfull_ng
Xnfet_01v8_W1p4_L0p6_m36__nf1_gboth_sdfull_ng_25 VSS_body VSS bias_a x2_m3d nfet_01v8_W1p4_L0p6_m36__nf1_gboth_sdfull_ng
Xnfet_01v8_W1p4_L0p6_m36__nf1_gboth_sdfull_ng_36 VSS_body VSS bias_a x2_m4d nfet_01v8_W1p4_L0p6_m36__nf1_gboth_sdfull_ng
Xnfet_01v8_W1p4_L0p6_m36__nf1_gboth_sdfull_ng_47 VSS_body VSS bias_a x2_m3d nfet_01v8_W1p4_L0p6_m36__nf1_gboth_sdfull_ng
Xnfet_01v8_W1p4_L0p6_m36__nf1_gboth_sdfull_ng_58 VSS_body VSS bias_a x2_m4d nfet_01v8_W1p4_L0p6_m36__nf1_gboth_sdfull_ng
Xnfet_01v8_W1p4_L0p6_m36__nf1_gboth_sdfull_ng_69 VSS_body VSS bias_a x2_m3d nfet_01v8_W1p4_L0p6_m36__nf1_gboth_sdfull_ng
Xnfet_01v8_W1p4_L0p6_m36__nf1_gboth_sdfull_ng_15 VSS_body VSS bias_a x2_m3d nfet_01v8_W1p4_L0p6_m36__nf1_gboth_sdfull_ng
Xnfet_01v8_W1p4_L0p6_m36__nf1_gboth_sdfull_ng_16 VSS_body VSS bias_a x2_m4d nfet_01v8_W1p4_L0p6_m36__nf1_gboth_sdfull_ng
Xnfet_01v8_W1p4_L0p6_m36__nf1_gboth_sdfull_ng_26 VSS_body VSS bias_a x2_m4d nfet_01v8_W1p4_L0p6_m36__nf1_gboth_sdfull_ng
Xnfet_01v8_W1p4_L0p6_m36__nf1_gboth_sdfull_ng_27 VSS_body VSS bias_a x2_m3d nfet_01v8_W1p4_L0p6_m36__nf1_gboth_sdfull_ng
Xnfet_01v8_W1p4_L0p6_m36__nf1_gboth_sdfull_ng_37 VSS_body VSS bias_a x2_m3d nfet_01v8_W1p4_L0p6_m36__nf1_gboth_sdfull_ng
Xnfet_01v8_W1p4_L0p6_m36__nf1_gboth_sdfull_ng_38 VSS_body VSS bias_a x2_m4d nfet_01v8_W1p4_L0p6_m36__nf1_gboth_sdfull_ng
Xnfet_01v8_W1p4_L0p6_m36__nf1_gboth_sdfull_ng_48 VSS_body VSS bias_a x2_m4d nfet_01v8_W1p4_L0p6_m36__nf1_gboth_sdfull_ng
Xnfet_01v8_W1p4_L0p6_m36__nf1_gboth_sdfull_ng_49 VSS_body VSS bias_a x2_m3d nfet_01v8_W1p4_L0p6_m36__nf1_gboth_sdfull_ng
Xnfet_01v8_W1p4_L0p6_m36__nf1_gboth_sdfull_ng_59 VSS_body VSS bias_a x2_m3d nfet_01v8_W1p4_L0p6_m36__nf1_gboth_sdfull_ng
Xnfet_01v8_W1p4_L0p6_m36__nf1_gboth_sdfull_ng_17 VSS_body VSS bias_a x2_m3d nfet_01v8_W1p4_L0p6_m36__nf1_gboth_sdfull_ng
Xnfet_01v8_W1p4_L0p6_m36__nf1_gboth_sdfull_ng_28 VSS_body VSS bias_a x2_m4d nfet_01v8_W1p4_L0p6_m36__nf1_gboth_sdfull_ng
Xnfet_01v8_W1p4_L0p6_m36__nf1_gboth_sdfull_ng_39 VSS_body VSS bias_a x2_m3d nfet_01v8_W1p4_L0p6_m36__nf1_gboth_sdfull_ng
Xnfet_01v8_W1p4_L0p6_m36__nf1_gboth_sdfull_ng_18 VSS_body VSS bias_a x2_m4d nfet_01v8_W1p4_L0p6_m36__nf1_gboth_sdfull_ng
Xnfet_01v8_W1p4_L0p6_m36__nf1_gboth_sdfull_ng_29 VSS_body VSS bias_a x2_m3d nfet_01v8_W1p4_L0p6_m36__nf1_gboth_sdfull_ng
Xnfet_01v8_W1p4_L0p6_m36__nf1_gboth_sdfull_ng_19 VSS_body VSS bias_a x2_m3d nfet_01v8_W1p4_L0p6_m36__nf1_gboth_sdfull_ng
Xnfet_01v8_W1p4_L0p6_m36__nf1_gboth_sdfull_ng_0 VSS_body VSS VSS VSS nfet_01v8_W1p4_L0p6_m36__nf1_gboth_sdfull_ng
Xnfet_01v8_W1p4_L0p6_m36__nf1_gboth_sdfull_ng_1 VSS_body VSS bias_a x2_m3d nfet_01v8_W1p4_L0p6_m36__nf1_gboth_sdfull_ng
Xnfet_01v8_W1p4_L0p6_m36__nf1_gboth_sdfull_ng_2 VSS_body VSS bias_a x2_m4d nfet_01v8_W1p4_L0p6_m36__nf1_gboth_sdfull_ng
Xnfet_01v8_W1p4_L0p6_m36__nf1_gboth_sdfull_ng_3 VSS_body VSS bias_a x2_m3d nfet_01v8_W1p4_L0p6_m36__nf1_gboth_sdfull_ng
Xnfet_01v8_W1p4_L0p6_m36__nf1_gboth_sdfull_ng_4 VSS_body VSS bias_a x2_m4d nfet_01v8_W1p4_L0p6_m36__nf1_gboth_sdfull_ng
Xnfet_01v8_W1p4_L0p6_m36__nf1_gboth_sdfull_ng_5 VSS_body VSS bias_a x2_m3d nfet_01v8_W1p4_L0p6_m36__nf1_gboth_sdfull_ng
Xnfet_01v8_W1p4_L0p6_m36__nf1_gboth_sdfull_ng_6 VSS_body VSS bias_a x2_m4d nfet_01v8_W1p4_L0p6_m36__nf1_gboth_sdfull_ng
Xnfet_01v8_W1p4_L0p6_m36__nf1_gboth_sdfull_ng_7 VSS_body VSS bias_a x2_m3d nfet_01v8_W1p4_L0p6_m36__nf1_gboth_sdfull_ng
Xnfet_01v8_W1p4_L0p6_m36__nf1_gboth_sdfull_ng_8 VSS_body VSS bias_a x2_m4d nfet_01v8_W1p4_L0p6_m36__nf1_gboth_sdfull_ng
Xnfet_01v8_W1p4_L0p6_m36__nf1_gboth_sdfull_ng_9 VSS_body VSS bias_a x2_m3d nfet_01v8_W1p4_L0p6_m36__nf1_gboth_sdfull_ng
Xnfet_01v8_W1p4_L0p6_m36__nf1_gboth_sdfull_ng_70 VSS_body VSS bias_a x2_m4d nfet_01v8_W1p4_L0p6_m36__nf1_gboth_sdfull_ng
Xnfet_01v8_W1p4_L0p6_m36__nf1_gboth_sdfull_ng_60 VSS_body VSS bias_a x2_m4d nfet_01v8_W1p4_L0p6_m36__nf1_gboth_sdfull_ng
Xnfet_01v8_W1p4_L0p6_m36__nf1_gboth_sdfull_ng_71 VSS_body VSS bias_a x2_m3d nfet_01v8_W1p4_L0p6_m36__nf1_gboth_sdfull_ng
Xnfet_01v8_W1p4_L0p6_m36__nf1_gboth_sdfull_ng_40 VSS_body VSS bias_a x2_m4d nfet_01v8_W1p4_L0p6_m36__nf1_gboth_sdfull_ng
Xnfet_01v8_W1p4_L0p6_m36__nf1_gboth_sdfull_ng_50 VSS_body VSS bias_a x2_m4d nfet_01v8_W1p4_L0p6_m36__nf1_gboth_sdfull_ng
Xnfet_01v8_W1p4_L0p6_m36__nf1_gboth_sdfull_ng_51 VSS_body VSS bias_a x2_m3d nfet_01v8_W1p4_L0p6_m36__nf1_gboth_sdfull_ng
Xnfet_01v8_W1p4_L0p6_m36__nf1_gboth_sdfull_ng_61 VSS_body VSS bias_a x2_m3d nfet_01v8_W1p4_L0p6_m36__nf1_gboth_sdfull_ng
Xnfet_01v8_W1p4_L0p6_m36__nf1_gboth_sdfull_ng_62 VSS_body VSS bias_a x2_m4d nfet_01v8_W1p4_L0p6_m36__nf1_gboth_sdfull_ng
Xnfet_01v8_W1p4_L0p6_m36__nf1_gboth_sdfull_ng_72 VSS_body VSS bias_a x2_m4d nfet_01v8_W1p4_L0p6_m36__nf1_gboth_sdfull_ng
Xnfet_01v8_W1p4_L0p6_m36__nf1_gboth_sdfull_ng_73 VSS_body VSS VSS VSS nfet_01v8_W1p4_L0p6_m36__nf1_gboth_sdfull_ng
Xnfet_01v8_W1p4_L0p6_m36__nf1_gboth_sdfull_ng_30 VSS_body VSS bias_a x2_m4d nfet_01v8_W1p4_L0p6_m36__nf1_gboth_sdfull_ng
Xnfet_01v8_W1p4_L0p6_m36__nf1_gboth_sdfull_ng_41 VSS_body VSS bias_a x2_m3d nfet_01v8_W1p4_L0p6_m36__nf1_gboth_sdfull_ng
Xnfet_01v8_W1p4_L0p6_m36__nf1_gboth_sdfull_ng_52 VSS_body VSS bias_a x2_m4d nfet_01v8_W1p4_L0p6_m36__nf1_gboth_sdfull_ng
Xnfet_01v8_W1p4_L0p6_m36__nf1_gboth_sdfull_ng_63 VSS_body VSS bias_a x2_m3d nfet_01v8_W1p4_L0p6_m36__nf1_gboth_sdfull_ng
Xnfet_01v8_W1p4_L0p6_m36__nf1_gboth_sdfull_ng_20 VSS_body VSS bias_a x2_m4d nfet_01v8_W1p4_L0p6_m36__nf1_gboth_sdfull_ng
Xnfet_01v8_W1p4_L0p6_m36__nf1_gboth_sdfull_ng_31 VSS_body VSS bias_a x2_m3d nfet_01v8_W1p4_L0p6_m36__nf1_gboth_sdfull_ng
Xnfet_01v8_W1p4_L0p6_m36__nf1_gboth_sdfull_ng_42 VSS_body VSS bias_a x2_m4d nfet_01v8_W1p4_L0p6_m36__nf1_gboth_sdfull_ng
Xnfet_01v8_W1p4_L0p6_m36__nf1_gboth_sdfull_ng_53 VSS_body VSS bias_a x2_m3d nfet_01v8_W1p4_L0p6_m36__nf1_gboth_sdfull_ng
Xnfet_01v8_W1p4_L0p6_m36__nf1_gboth_sdfull_ng_64 VSS_body VSS bias_a x2_m4d nfet_01v8_W1p4_L0p6_m36__nf1_gboth_sdfull_ng
Xnfet_01v8_W1p4_L0p6_m36__nf1_gboth_sdfull_ng_10 VSS_body VSS bias_a x2_m4d nfet_01v8_W1p4_L0p6_m36__nf1_gboth_sdfull_ng
Xnfet_01v8_W1p4_L0p6_m36__nf1_gboth_sdfull_ng_21 VSS_body VSS bias_a x2_m3d nfet_01v8_W1p4_L0p6_m36__nf1_gboth_sdfull_ng
Xnfet_01v8_W1p4_L0p6_m36__nf1_gboth_sdfull_ng_32 VSS_body VSS bias_a x2_m4d nfet_01v8_W1p4_L0p6_m36__nf1_gboth_sdfull_ng
Xnfet_01v8_W1p4_L0p6_m36__nf1_gboth_sdfull_ng_43 VSS_body VSS bias_a x2_m3d nfet_01v8_W1p4_L0p6_m36__nf1_gboth_sdfull_ng
Xnfet_01v8_W1p4_L0p6_m36__nf1_gboth_sdfull_ng_54 VSS_body VSS bias_a x2_m4d nfet_01v8_W1p4_L0p6_m36__nf1_gboth_sdfull_ng
Xnfet_01v8_W1p4_L0p6_m36__nf1_gboth_sdfull_ng_65 VSS_body VSS bias_a x2_m3d nfet_01v8_W1p4_L0p6_m36__nf1_gboth_sdfull_ng
.ends

.subckt sky130_fd_pr__pfet_01v8_lvt_PJ46JE G D w_n154_n240# S
X0 S G D w_n154_n240# sky130_fd_pr__pfet_01v8_lvt ad=0.406 pd=3.38 as=0.406 ps=3.38 w=1.4 l=0.6
.ends

.subckt pfet_01v8_lvt_W1p4_L0p6_m6__nf1_gboth_sdfull_ng G D S B
Xpfet_01v8_lvt_W1p4_L0p6_m6__nf1_gboth_sdfull_ng_pc G D B S sky130_fd_pr__pfet_01v8_lvt_PJ46JE
.ends

.subckt pmos_matched_current_source_pair__ABBA x1_m25d VDD x1_m21d VDD_body bias_b
Xpfet_01v8_lvt_W1p4_L0p6_m6__nf1_gboth_sdfull_ng_10 bias_b x1_m21d VDD VDD_body pfet_01v8_lvt_W1p4_L0p6_m6__nf1_gboth_sdfull_ng
Xpfet_01v8_lvt_W1p4_L0p6_m6__nf1_gboth_sdfull_ng_11 bias_b x1_m25d VDD VDD_body pfet_01v8_lvt_W1p4_L0p6_m6__nf1_gboth_sdfull_ng
Xpfet_01v8_lvt_W1p4_L0p6_m6__nf1_gboth_sdfull_ng_12 bias_b x1_m21d VDD VDD_body pfet_01v8_lvt_W1p4_L0p6_m6__nf1_gboth_sdfull_ng
Xpfet_01v8_lvt_W1p4_L0p6_m6__nf1_gboth_sdfull_ng_13 VDD VDD VDD VDD_body pfet_01v8_lvt_W1p4_L0p6_m6__nf1_gboth_sdfull_ng
Xpfet_01v8_lvt_W1p4_L0p6_m6__nf1_gboth_sdfull_ng_0 VDD VDD VDD VDD_body pfet_01v8_lvt_W1p4_L0p6_m6__nf1_gboth_sdfull_ng
Xpfet_01v8_lvt_W1p4_L0p6_m6__nf1_gboth_sdfull_ng_2 bias_b x1_m25d VDD VDD_body pfet_01v8_lvt_W1p4_L0p6_m6__nf1_gboth_sdfull_ng
Xpfet_01v8_lvt_W1p4_L0p6_m6__nf1_gboth_sdfull_ng_1 bias_b x1_m21d VDD VDD_body pfet_01v8_lvt_W1p4_L0p6_m6__nf1_gboth_sdfull_ng
Xpfet_01v8_lvt_W1p4_L0p6_m6__nf1_gboth_sdfull_ng_3 bias_b x1_m21d VDD VDD_body pfet_01v8_lvt_W1p4_L0p6_m6__nf1_gboth_sdfull_ng
Xpfet_01v8_lvt_W1p4_L0p6_m6__nf1_gboth_sdfull_ng_4 bias_b x1_m25d VDD VDD_body pfet_01v8_lvt_W1p4_L0p6_m6__nf1_gboth_sdfull_ng
Xpfet_01v8_lvt_W1p4_L0p6_m6__nf1_gboth_sdfull_ng_5 bias_b x1_m21d VDD VDD_body pfet_01v8_lvt_W1p4_L0p6_m6__nf1_gboth_sdfull_ng
Xpfet_01v8_lvt_W1p4_L0p6_m6__nf1_gboth_sdfull_ng_6 bias_b x1_m25d VDD VDD_body pfet_01v8_lvt_W1p4_L0p6_m6__nf1_gboth_sdfull_ng
Xpfet_01v8_lvt_W1p4_L0p6_m6__nf1_gboth_sdfull_ng_7 bias_b x1_m25d VDD VDD_body pfet_01v8_lvt_W1p4_L0p6_m6__nf1_gboth_sdfull_ng
Xpfet_01v8_lvt_W1p4_L0p6_m6__nf1_gboth_sdfull_ng_8 bias_b x1_m21d VDD VDD_body pfet_01v8_lvt_W1p4_L0p6_m6__nf1_gboth_sdfull_ng
Xpfet_01v8_lvt_W1p4_L0p6_m6__nf1_gboth_sdfull_ng_9 bias_b x1_m25d VDD VDD_body pfet_01v8_lvt_W1p4_L0p6_m6__nf1_gboth_sdfull_ng
.ends

.subckt pmos_dummy_7__A VDD_body x1_m25d
Xpfet_01v8_W1p4_L0p6_m2__nf1_gtop_sdfull_ng_0 VDD_body x1_m25d x1_m25d x1_m25d pfet_01v8_W1p4_L0p6_m2__nf1_gtop_sdfull_ng
Xpfet_01v8_W1p4_L0p6_m2__nf1_gtop_sdfull_ng_1 VDD_body x1_m25d x1_m25d x1_m25d pfet_01v8_W1p4_L0p6_m2__nf1_gtop_sdfull_ng
.ends

.subckt nfet_01v8_W1p4_L0p6_m23__nf1_gtop_sdfull_ng B G D S
Xnfet_01v8_W1p4_L0p6_m23__nf1_gtop_sdfull_ng_pc G D S B sky130_fd_pr__nfet_01v8_RUA5M6
.ends

.subckt nmos_dummy__A VSS VSS_body
Xnfet_01v8_W1p4_L0p6_m23__nf1_gtop_sdfull_ng_0 VSS_body VSS VSS VSS nfet_01v8_W1p4_L0p6_m23__nf1_gtop_sdfull_ng
Xnfet_01v8_W1p4_L0p6_m23__nf1_gtop_sdfull_ng_1 VSS_body VSS VSS VSS nfet_01v8_W1p4_L0p6_m23__nf1_gtop_sdfull_ng
Xnfet_01v8_W1p4_L0p6_m23__nf1_gtop_sdfull_ng_2 VSS_body VSS VSS VSS nfet_01v8_W1p4_L0p6_m23__nf1_gtop_sdfull_ng
Xnfet_01v8_W1p4_L0p6_m23__nf1_gtop_sdfull_ng_3 VSS_body VSS VSS VSS nfet_01v8_W1p4_L0p6_m23__nf1_gtop_sdfull_ng
Xnfet_01v8_W1p4_L0p6_m23__nf1_gtop_sdfull_ng_4 VSS_body VSS VSS VSS nfet_01v8_W1p4_L0p6_m23__nf1_gtop_sdfull_ng
Xnfet_01v8_W1p4_L0p6_m23__nf1_gtop_sdfull_ng_5 VSS_body VSS VSS VSS nfet_01v8_W1p4_L0p6_m23__nf1_gtop_sdfull_ng
Xnfet_01v8_W1p4_L0p6_m23__nf1_gtop_sdfull_ng_6 VSS_body VSS VSS VSS nfet_01v8_W1p4_L0p6_m23__nf1_gtop_sdfull_ng
Xnfet_01v8_W1p4_L0p6_m23__nf1_gtop_sdfull_ng_7 VSS_body VSS VSS VSS nfet_01v8_W1p4_L0p6_m23__nf1_gtop_sdfull_ng
Xnfet_01v8_W1p4_L0p6_m23__nf1_gtop_sdfull_ng_8 VSS_body VSS VSS VSS nfet_01v8_W1p4_L0p6_m23__nf1_gtop_sdfull_ng
Xnfet_01v8_W1p4_L0p6_m23__nf1_gtop_sdfull_ng_9 VSS_body VSS VSS VSS nfet_01v8_W1p4_L0p6_m23__nf1_gtop_sdfull_ng
Xnfet_01v8_W1p4_L0p6_m23__nf1_gtop_sdfull_ng_20 VSS_body VSS VSS VSS nfet_01v8_W1p4_L0p6_m23__nf1_gtop_sdfull_ng
Xnfet_01v8_W1p4_L0p6_m23__nf1_gtop_sdfull_ng_10 VSS_body VSS VSS VSS nfet_01v8_W1p4_L0p6_m23__nf1_gtop_sdfull_ng
Xnfet_01v8_W1p4_L0p6_m23__nf1_gtop_sdfull_ng_21 VSS_body VSS VSS VSS nfet_01v8_W1p4_L0p6_m23__nf1_gtop_sdfull_ng
Xnfet_01v8_W1p4_L0p6_m23__nf1_gtop_sdfull_ng_11 VSS_body VSS VSS VSS nfet_01v8_W1p4_L0p6_m23__nf1_gtop_sdfull_ng
Xnfet_01v8_W1p4_L0p6_m23__nf1_gtop_sdfull_ng_22 VSS_body VSS VSS VSS nfet_01v8_W1p4_L0p6_m23__nf1_gtop_sdfull_ng
Xnfet_01v8_W1p4_L0p6_m23__nf1_gtop_sdfull_ng_12 VSS_body VSS VSS VSS nfet_01v8_W1p4_L0p6_m23__nf1_gtop_sdfull_ng
Xnfet_01v8_W1p4_L0p6_m23__nf1_gtop_sdfull_ng_13 VSS_body VSS VSS VSS nfet_01v8_W1p4_L0p6_m23__nf1_gtop_sdfull_ng
Xnfet_01v8_W1p4_L0p6_m23__nf1_gtop_sdfull_ng_14 VSS_body VSS VSS VSS nfet_01v8_W1p4_L0p6_m23__nf1_gtop_sdfull_ng
Xnfet_01v8_W1p4_L0p6_m23__nf1_gtop_sdfull_ng_15 VSS_body VSS VSS VSS nfet_01v8_W1p4_L0p6_m23__nf1_gtop_sdfull_ng
Xnfet_01v8_W1p4_L0p6_m23__nf1_gtop_sdfull_ng_16 VSS_body VSS VSS VSS nfet_01v8_W1p4_L0p6_m23__nf1_gtop_sdfull_ng
Xnfet_01v8_W1p4_L0p6_m23__nf1_gtop_sdfull_ng_17 VSS_body VSS VSS VSS nfet_01v8_W1p4_L0p6_m23__nf1_gtop_sdfull_ng
Xnfet_01v8_W1p4_L0p6_m23__nf1_gtop_sdfull_ng_18 VSS_body VSS VSS VSS nfet_01v8_W1p4_L0p6_m23__nf1_gtop_sdfull_ng
Xnfet_01v8_W1p4_L0p6_m23__nf1_gtop_sdfull_ng_19 VSS_body VSS VSS VSS nfet_01v8_W1p4_L0p6_m23__nf1_gtop_sdfull_ng
.ends

.subckt nmos_dummy_10__A bias_c VSS_body
Xnfet_01v8_W1p4_L0p6_m2__nf1_gboth_sdfull_ng_0 VSS_body bias_c bias_c bias_c nfet_01v8_W1p4_L0p6_m2__nf1_gboth_sdfull_ng
Xnfet_01v8_W1p4_L0p6_m2__nf1_gboth_sdfull_ng_1 VSS_body bias_c bias_c bias_c nfet_01v8_W1p4_L0p6_m2__nf1_gboth_sdfull_ng
.ends

.subckt nmos_dummy_9__A VSS x1_m5d VSS_body
Xnfet_01v8_W1p4_L0p6_m6__nf1_gtop_sdfull_ng_0 VSS_body VSS x1_m5d VSS nfet_01v8_W1p4_L0p6_m6__nf1_gtop_sdfull_ng
Xnfet_01v8_W1p4_L0p6_m6__nf1_gtop_sdfull_ng_1 VSS_body VSS x1_m5d VSS nfet_01v8_W1p4_L0p6_m6__nf1_gtop_sdfull_ng
Xnfet_01v8_W1p4_L0p6_m6__nf1_gtop_sdfull_ng_2 VSS_body VSS x1_m5d VSS nfet_01v8_W1p4_L0p6_m6__nf1_gtop_sdfull_ng
Xnfet_01v8_W1p4_L0p6_m6__nf1_gtop_sdfull_ng_3 VSS_body VSS x1_m5d VSS nfet_01v8_W1p4_L0p6_m6__nf1_gtop_sdfull_ng
Xnfet_01v8_W1p4_L0p6_m6__nf1_gtop_sdfull_ng_4 VSS_body VSS x1_m5d VSS nfet_01v8_W1p4_L0p6_m6__nf1_gtop_sdfull_ng
Xnfet_01v8_W1p4_L0p6_m6__nf1_gtop_sdfull_ng_5 VSS_body VSS x1_m5d VSS nfet_01v8_W1p4_L0p6_m6__nf1_gtop_sdfull_ng
.ends

.subckt sky130_fd_pr__nfet_01v8_lvt_CWMMG4 G D S VSUBS
X0 S G D VSUBS sky130_fd_pr__nfet_01v8_lvt ad=0.348 pd=2.98 as=0.348 ps=2.98 w=1.2 l=0.2
.ends

.subckt nfet_01v8_lvt_W1p2_L0p2_m2__nf1_gtop_sdfull_ng B G D S
Xnfet_01v8_lvt_W1p2_L0p2_m2__nf1_gtop_sdfull_ng_pc G D S B sky130_fd_pr__nfet_01v8_lvt_CWMMG4
.ends

.subckt nmos_dummy_13__A x2_foldn VSS_body
Xnfet_01v8_lvt_W1p2_L0p2_m2__nf1_gtop_sdfull_ng_0 VSS_body x2_foldn x2_foldn x2_foldn
+ nfet_01v8_lvt_W1p2_L0p2_m2__nf1_gtop_sdfull_ng
Xnfet_01v8_lvt_W1p2_L0p2_m2__nf1_gtop_sdfull_ng_1 VSS_body x2_foldn x2_foldn x2_foldn
+ nfet_01v8_lvt_W1p2_L0p2_m2__nf1_gtop_sdfull_ng
.ends

.subckt nmos_dummy_16__A VSS_body op
Xnfet_01v8_W1p4_L0p6_m2__nf1_gboth_sdfull_ng_0 VSS_body op op op nfet_01v8_W1p4_L0p6_m2__nf1_gboth_sdfull_ng
Xnfet_01v8_W1p4_L0p6_m2__nf1_gboth_sdfull_ng_1 VSS_body op op op nfet_01v8_W1p4_L0p6_m2__nf1_gboth_sdfull_ng
.ends

.subckt nfet_01v8_W1p4_L0p6_m18__nf1_gboth_sdfull_ng G B D S
Xnfet_01v8_W1p4_L0p6_m18__nf1_gboth_sdfull_ng_pc G D S B sky130_fd_pr__nfet_01v8_KCM6UP
.ends

.subckt nmos_single_3__A bias_a VSS x1_m5d VSS_body
Xnfet_01v8_W1p4_L0p6_m18__nf1_gboth_sdfull_ng_0 bias_a VSS_body x1_m5d VSS nfet_01v8_W1p4_L0p6_m18__nf1_gboth_sdfull_ng
Xnfet_01v8_W1p4_L0p6_m18__nf1_gboth_sdfull_ng_1 bias_a VSS_body x1_m5d VSS nfet_01v8_W1p4_L0p6_m18__nf1_gboth_sdfull_ng
Xnfet_01v8_W1p4_L0p6_m18__nf1_gboth_sdfull_ng_2 bias_a VSS_body x1_m5d VSS nfet_01v8_W1p4_L0p6_m18__nf1_gboth_sdfull_ng
Xnfet_01v8_W1p4_L0p6_m18__nf1_gboth_sdfull_ng_10 bias_a VSS_body x1_m5d VSS nfet_01v8_W1p4_L0p6_m18__nf1_gboth_sdfull_ng
Xnfet_01v8_W1p4_L0p6_m18__nf1_gboth_sdfull_ng_11 bias_a VSS_body x1_m5d VSS nfet_01v8_W1p4_L0p6_m18__nf1_gboth_sdfull_ng
Xnfet_01v8_W1p4_L0p6_m18__nf1_gboth_sdfull_ng_3 bias_a VSS_body x1_m5d VSS nfet_01v8_W1p4_L0p6_m18__nf1_gboth_sdfull_ng
Xnfet_01v8_W1p4_L0p6_m18__nf1_gboth_sdfull_ng_12 bias_a VSS_body x1_m5d VSS nfet_01v8_W1p4_L0p6_m18__nf1_gboth_sdfull_ng
Xnfet_01v8_W1p4_L0p6_m18__nf1_gboth_sdfull_ng_4 bias_a VSS_body x1_m5d VSS nfet_01v8_W1p4_L0p6_m18__nf1_gboth_sdfull_ng
Xnfet_01v8_W1p4_L0p6_m18__nf1_gboth_sdfull_ng_13 bias_a VSS_body x1_m5d VSS nfet_01v8_W1p4_L0p6_m18__nf1_gboth_sdfull_ng
Xnfet_01v8_W1p4_L0p6_m18__nf1_gboth_sdfull_ng_5 bias_a VSS_body x1_m5d VSS nfet_01v8_W1p4_L0p6_m18__nf1_gboth_sdfull_ng
Xnfet_01v8_W1p4_L0p6_m18__nf1_gboth_sdfull_ng_14 bias_a VSS_body x1_m5d VSS nfet_01v8_W1p4_L0p6_m18__nf1_gboth_sdfull_ng
Xnfet_01v8_W1p4_L0p6_m18__nf1_gboth_sdfull_ng_6 bias_a VSS_body x1_m5d VSS nfet_01v8_W1p4_L0p6_m18__nf1_gboth_sdfull_ng
Xnfet_01v8_W1p4_L0p6_m18__nf1_gboth_sdfull_ng_15 bias_a VSS_body x1_m5d VSS nfet_01v8_W1p4_L0p6_m18__nf1_gboth_sdfull_ng
Xnfet_01v8_W1p4_L0p6_m18__nf1_gboth_sdfull_ng_7 bias_a VSS_body x1_m5d VSS nfet_01v8_W1p4_L0p6_m18__nf1_gboth_sdfull_ng
Xnfet_01v8_W1p4_L0p6_m18__nf1_gboth_sdfull_ng_16 bias_a VSS_body x1_m5d VSS nfet_01v8_W1p4_L0p6_m18__nf1_gboth_sdfull_ng
Xnfet_01v8_W1p4_L0p6_m18__nf1_gboth_sdfull_ng_8 bias_a VSS_body x1_m5d VSS nfet_01v8_W1p4_L0p6_m18__nf1_gboth_sdfull_ng
Xnfet_01v8_W1p4_L0p6_m18__nf1_gboth_sdfull_ng_17 bias_a VSS_body x1_m5d VSS nfet_01v8_W1p4_L0p6_m18__nf1_gboth_sdfull_ng
Xnfet_01v8_W1p4_L0p6_m18__nf1_gboth_sdfull_ng_9 bias_a VSS_body x1_m5d VSS nfet_01v8_W1p4_L0p6_m18__nf1_gboth_sdfull_ng
.ends

.subckt nmos_dummy_2__A VSS_body bias_c
Xnfet_01v8_lvt_W1p4_L0p6_m8__nf1_gtop_sdfull_ng_0 VSS_body bias_c bias_c bias_c nfet_01v8_lvt_W1p4_L0p6_m8__nf1_gtop_sdfull_ng
Xnfet_01v8_lvt_W1p4_L0p6_m8__nf1_gtop_sdfull_ng_1 VSS_body bias_c bias_c bias_c nfet_01v8_lvt_W1p4_L0p6_m8__nf1_gtop_sdfull_ng
Xnfet_01v8_lvt_W1p4_L0p6_m8__nf1_gtop_sdfull_ng_2 VSS_body bias_c bias_c bias_c nfet_01v8_lvt_W1p4_L0p6_m8__nf1_gtop_sdfull_ng
Xnfet_01v8_lvt_W1p4_L0p6_m8__nf1_gtop_sdfull_ng_3 VSS_body bias_c bias_c bias_c nfet_01v8_lvt_W1p4_L0p6_m8__nf1_gtop_sdfull_ng
Xnfet_01v8_lvt_W1p4_L0p6_m8__nf1_gtop_sdfull_ng_5 VSS_body bias_c bias_c bias_c nfet_01v8_lvt_W1p4_L0p6_m8__nf1_gtop_sdfull_ng
Xnfet_01v8_lvt_W1p4_L0p6_m8__nf1_gtop_sdfull_ng_4 VSS_body bias_c bias_c bias_c nfet_01v8_lvt_W1p4_L0p6_m8__nf1_gtop_sdfull_ng
Xnfet_01v8_lvt_W1p4_L0p6_m8__nf1_gtop_sdfull_ng_6 VSS_body bias_c bias_c bias_c nfet_01v8_lvt_W1p4_L0p6_m8__nf1_gtop_sdfull_ng
Xnfet_01v8_lvt_W1p4_L0p6_m8__nf1_gtop_sdfull_ng_7 VSS_body bias_c bias_c bias_c nfet_01v8_lvt_W1p4_L0p6_m8__nf1_gtop_sdfull_ng
.ends

.subckt pmos_dummy_12__A VDD_body VDD x2_foldn
Xpfet_01v8_W1p4_L0p6_m2__nf1_gtop_sdfull_ng_0 VDD_body VDD VDD x2_foldn pfet_01v8_W1p4_L0p6_m2__nf1_gtop_sdfull_ng
Xpfet_01v8_W1p4_L0p6_m2__nf1_gtop_sdfull_ng_1 VDD_body VDD VDD x2_foldn pfet_01v8_W1p4_L0p6_m2__nf1_gtop_sdfull_ng
.ends

.subckt nmos_matched_cascode_pair__ABBA VSS x2_m3d bias_d on x2_m4d VSS_body op
Xnfet_01v8_W1p4_L0p6_m36__nf1_gboth_sdfull_ng_66 VSS_body x2_m3d bias_d on nfet_01v8_W1p4_L0p6_m36__nf1_gboth_sdfull_ng
Xnfet_01v8_W1p4_L0p6_m36__nf1_gboth_sdfull_ng_55 VSS_body x2_m4d bias_d op nfet_01v8_W1p4_L0p6_m36__nf1_gboth_sdfull_ng
Xnfet_01v8_W1p4_L0p6_m36__nf1_gboth_sdfull_ng_44 VSS_body x2_m3d bias_d on nfet_01v8_W1p4_L0p6_m36__nf1_gboth_sdfull_ng
Xnfet_01v8_W1p4_L0p6_m36__nf1_gboth_sdfull_ng_33 VSS_body x2_m3d bias_d on nfet_01v8_W1p4_L0p6_m36__nf1_gboth_sdfull_ng
Xnfet_01v8_W1p4_L0p6_m36__nf1_gboth_sdfull_ng_22 VSS_body x2_m4d bias_d op nfet_01v8_W1p4_L0p6_m36__nf1_gboth_sdfull_ng
Xnfet_01v8_W1p4_L0p6_m36__nf1_gboth_sdfull_ng_11 VSS_body x2_m3d bias_d on nfet_01v8_W1p4_L0p6_m36__nf1_gboth_sdfull_ng
Xnfet_01v8_W1p4_L0p6_m36__nf1_gboth_sdfull_ng_67 VSS_body x2_m4d bias_d op nfet_01v8_W1p4_L0p6_m36__nf1_gboth_sdfull_ng
Xnfet_01v8_W1p4_L0p6_m36__nf1_gboth_sdfull_ng_56 VSS_body x2_m3d bias_d on nfet_01v8_W1p4_L0p6_m36__nf1_gboth_sdfull_ng
Xnfet_01v8_W1p4_L0p6_m36__nf1_gboth_sdfull_ng_45 VSS_body x2_m4d bias_d op nfet_01v8_W1p4_L0p6_m36__nf1_gboth_sdfull_ng
Xnfet_01v8_W1p4_L0p6_m36__nf1_gboth_sdfull_ng_34 VSS_body x2_m4d bias_d op nfet_01v8_W1p4_L0p6_m36__nf1_gboth_sdfull_ng
Xnfet_01v8_W1p4_L0p6_m36__nf1_gboth_sdfull_ng_23 VSS_body x2_m3d bias_d on nfet_01v8_W1p4_L0p6_m36__nf1_gboth_sdfull_ng
Xnfet_01v8_W1p4_L0p6_m36__nf1_gboth_sdfull_ng_12 VSS_body x2_m4d bias_d op nfet_01v8_W1p4_L0p6_m36__nf1_gboth_sdfull_ng
Xnfet_01v8_W1p4_L0p6_m36__nf1_gboth_sdfull_ng_68 VSS_body x2_m3d bias_d on nfet_01v8_W1p4_L0p6_m36__nf1_gboth_sdfull_ng
Xnfet_01v8_W1p4_L0p6_m36__nf1_gboth_sdfull_ng_57 VSS_body x2_m4d bias_d op nfet_01v8_W1p4_L0p6_m36__nf1_gboth_sdfull_ng
Xnfet_01v8_W1p4_L0p6_m36__nf1_gboth_sdfull_ng_46 VSS_body x2_m3d bias_d on nfet_01v8_W1p4_L0p6_m36__nf1_gboth_sdfull_ng
Xnfet_01v8_W1p4_L0p6_m36__nf1_gboth_sdfull_ng_35 VSS_body x2_m3d bias_d on nfet_01v8_W1p4_L0p6_m36__nf1_gboth_sdfull_ng
Xnfet_01v8_W1p4_L0p6_m36__nf1_gboth_sdfull_ng_24 VSS_body x2_m4d bias_d op nfet_01v8_W1p4_L0p6_m36__nf1_gboth_sdfull_ng
Xnfet_01v8_W1p4_L0p6_m36__nf1_gboth_sdfull_ng_13 VSS_body x2_m3d bias_d on nfet_01v8_W1p4_L0p6_m36__nf1_gboth_sdfull_ng
Xnfet_01v8_W1p4_L0p6_m36__nf1_gboth_sdfull_ng_69 VSS_body x2_m4d bias_d op nfet_01v8_W1p4_L0p6_m36__nf1_gboth_sdfull_ng
Xnfet_01v8_W1p4_L0p6_m36__nf1_gboth_sdfull_ng_58 VSS_body x2_m3d bias_d on nfet_01v8_W1p4_L0p6_m36__nf1_gboth_sdfull_ng
Xnfet_01v8_W1p4_L0p6_m36__nf1_gboth_sdfull_ng_47 VSS_body x2_m4d bias_d op nfet_01v8_W1p4_L0p6_m36__nf1_gboth_sdfull_ng
Xnfet_01v8_W1p4_L0p6_m36__nf1_gboth_sdfull_ng_36 VSS_body x2_m4d bias_d op nfet_01v8_W1p4_L0p6_m36__nf1_gboth_sdfull_ng
Xnfet_01v8_W1p4_L0p6_m36__nf1_gboth_sdfull_ng_25 VSS_body x2_m3d bias_d on nfet_01v8_W1p4_L0p6_m36__nf1_gboth_sdfull_ng
Xnfet_01v8_W1p4_L0p6_m36__nf1_gboth_sdfull_ng_14 VSS_body x2_m4d bias_d op nfet_01v8_W1p4_L0p6_m36__nf1_gboth_sdfull_ng
Xnfet_01v8_W1p4_L0p6_m36__nf1_gboth_sdfull_ng_59 VSS_body x2_m4d bias_d op nfet_01v8_W1p4_L0p6_m36__nf1_gboth_sdfull_ng
Xnfet_01v8_W1p4_L0p6_m36__nf1_gboth_sdfull_ng_49 VSS_body x2_m4d bias_d op nfet_01v8_W1p4_L0p6_m36__nf1_gboth_sdfull_ng
Xnfet_01v8_W1p4_L0p6_m36__nf1_gboth_sdfull_ng_48 VSS_body x2_m3d bias_d on nfet_01v8_W1p4_L0p6_m36__nf1_gboth_sdfull_ng
Xnfet_01v8_W1p4_L0p6_m36__nf1_gboth_sdfull_ng_38 VSS_body x2_m3d bias_d on nfet_01v8_W1p4_L0p6_m36__nf1_gboth_sdfull_ng
Xnfet_01v8_W1p4_L0p6_m36__nf1_gboth_sdfull_ng_37 VSS_body x2_m4d bias_d op nfet_01v8_W1p4_L0p6_m36__nf1_gboth_sdfull_ng
Xnfet_01v8_W1p4_L0p6_m36__nf1_gboth_sdfull_ng_27 VSS_body x2_m3d bias_d on nfet_01v8_W1p4_L0p6_m36__nf1_gboth_sdfull_ng
Xnfet_01v8_W1p4_L0p6_m36__nf1_gboth_sdfull_ng_26 VSS_body x2_m4d bias_d op nfet_01v8_W1p4_L0p6_m36__nf1_gboth_sdfull_ng
Xnfet_01v8_W1p4_L0p6_m36__nf1_gboth_sdfull_ng_16 VSS_body x2_m4d bias_d op nfet_01v8_W1p4_L0p6_m36__nf1_gboth_sdfull_ng
Xnfet_01v8_W1p4_L0p6_m36__nf1_gboth_sdfull_ng_15 VSS_body x2_m3d bias_d on nfet_01v8_W1p4_L0p6_m36__nf1_gboth_sdfull_ng
Xnfet_01v8_W1p4_L0p6_m36__nf1_gboth_sdfull_ng_39 VSS_body x2_m4d bias_d op nfet_01v8_W1p4_L0p6_m36__nf1_gboth_sdfull_ng
Xnfet_01v8_W1p4_L0p6_m36__nf1_gboth_sdfull_ng_28 VSS_body x2_m4d bias_d op nfet_01v8_W1p4_L0p6_m36__nf1_gboth_sdfull_ng
Xnfet_01v8_W1p4_L0p6_m36__nf1_gboth_sdfull_ng_17 VSS_body x2_m3d bias_d on nfet_01v8_W1p4_L0p6_m36__nf1_gboth_sdfull_ng
Xnfet_01v8_W1p4_L0p6_m36__nf1_gboth_sdfull_ng_29 VSS_body x2_m3d bias_d on nfet_01v8_W1p4_L0p6_m36__nf1_gboth_sdfull_ng
Xnfet_01v8_W1p4_L0p6_m36__nf1_gboth_sdfull_ng_18 VSS_body x2_m4d bias_d op nfet_01v8_W1p4_L0p6_m36__nf1_gboth_sdfull_ng
Xnfet_01v8_W1p4_L0p6_m36__nf1_gboth_sdfull_ng_19 VSS_body x2_m3d bias_d on nfet_01v8_W1p4_L0p6_m36__nf1_gboth_sdfull_ng
Xnfet_01v8_W1p4_L0p6_m36__nf1_gboth_sdfull_ng_0 VSS_body VSS VSS VSS nfet_01v8_W1p4_L0p6_m36__nf1_gboth_sdfull_ng
Xnfet_01v8_W1p4_L0p6_m36__nf1_gboth_sdfull_ng_1 VSS_body x2_m3d bias_d on nfet_01v8_W1p4_L0p6_m36__nf1_gboth_sdfull_ng
Xnfet_01v8_W1p4_L0p6_m36__nf1_gboth_sdfull_ng_2 VSS_body x2_m4d bias_d op nfet_01v8_W1p4_L0p6_m36__nf1_gboth_sdfull_ng
Xnfet_01v8_W1p4_L0p6_m36__nf1_gboth_sdfull_ng_3 VSS_body x2_m3d bias_d on nfet_01v8_W1p4_L0p6_m36__nf1_gboth_sdfull_ng
Xnfet_01v8_W1p4_L0p6_m36__nf1_gboth_sdfull_ng_4 VSS_body x2_m4d bias_d op nfet_01v8_W1p4_L0p6_m36__nf1_gboth_sdfull_ng
Xnfet_01v8_W1p4_L0p6_m36__nf1_gboth_sdfull_ng_5 VSS_body x2_m3d bias_d on nfet_01v8_W1p4_L0p6_m36__nf1_gboth_sdfull_ng
Xnfet_01v8_W1p4_L0p6_m36__nf1_gboth_sdfull_ng_7 VSS_body x2_m3d bias_d on nfet_01v8_W1p4_L0p6_m36__nf1_gboth_sdfull_ng
Xnfet_01v8_W1p4_L0p6_m36__nf1_gboth_sdfull_ng_6 VSS_body x2_m4d bias_d op nfet_01v8_W1p4_L0p6_m36__nf1_gboth_sdfull_ng
Xnfet_01v8_W1p4_L0p6_m36__nf1_gboth_sdfull_ng_8 VSS_body x2_m4d bias_d op nfet_01v8_W1p4_L0p6_m36__nf1_gboth_sdfull_ng
Xnfet_01v8_W1p4_L0p6_m36__nf1_gboth_sdfull_ng_9 VSS_body x2_m3d bias_d on nfet_01v8_W1p4_L0p6_m36__nf1_gboth_sdfull_ng
Xnfet_01v8_W1p4_L0p6_m36__nf1_gboth_sdfull_ng_70 VSS_body x2_m3d bias_d on nfet_01v8_W1p4_L0p6_m36__nf1_gboth_sdfull_ng
Xnfet_01v8_W1p4_L0p6_m36__nf1_gboth_sdfull_ng_71 VSS_body x2_m4d bias_d op nfet_01v8_W1p4_L0p6_m36__nf1_gboth_sdfull_ng
Xnfet_01v8_W1p4_L0p6_m36__nf1_gboth_sdfull_ng_60 VSS_body x2_m3d bias_d on nfet_01v8_W1p4_L0p6_m36__nf1_gboth_sdfull_ng
Xnfet_01v8_W1p4_L0p6_m36__nf1_gboth_sdfull_ng_73 VSS_body VSS VSS VSS nfet_01v8_W1p4_L0p6_m36__nf1_gboth_sdfull_ng
Xnfet_01v8_W1p4_L0p6_m36__nf1_gboth_sdfull_ng_72 VSS_body x2_m3d bias_d on nfet_01v8_W1p4_L0p6_m36__nf1_gboth_sdfull_ng
Xnfet_01v8_W1p4_L0p6_m36__nf1_gboth_sdfull_ng_62 VSS_body x2_m3d bias_d on nfet_01v8_W1p4_L0p6_m36__nf1_gboth_sdfull_ng
Xnfet_01v8_W1p4_L0p6_m36__nf1_gboth_sdfull_ng_61 VSS_body x2_m4d bias_d op nfet_01v8_W1p4_L0p6_m36__nf1_gboth_sdfull_ng
Xnfet_01v8_W1p4_L0p6_m36__nf1_gboth_sdfull_ng_51 VSS_body x2_m4d bias_d op nfet_01v8_W1p4_L0p6_m36__nf1_gboth_sdfull_ng
Xnfet_01v8_W1p4_L0p6_m36__nf1_gboth_sdfull_ng_50 VSS_body x2_m3d bias_d on nfet_01v8_W1p4_L0p6_m36__nf1_gboth_sdfull_ng
Xnfet_01v8_W1p4_L0p6_m36__nf1_gboth_sdfull_ng_40 VSS_body x2_m3d bias_d on nfet_01v8_W1p4_L0p6_m36__nf1_gboth_sdfull_ng
Xnfet_01v8_W1p4_L0p6_m36__nf1_gboth_sdfull_ng_63 VSS_body x2_m4d bias_d op nfet_01v8_W1p4_L0p6_m36__nf1_gboth_sdfull_ng
Xnfet_01v8_W1p4_L0p6_m36__nf1_gboth_sdfull_ng_52 VSS_body x2_m3d bias_d on nfet_01v8_W1p4_L0p6_m36__nf1_gboth_sdfull_ng
Xnfet_01v8_W1p4_L0p6_m36__nf1_gboth_sdfull_ng_41 VSS_body x2_m4d bias_d op nfet_01v8_W1p4_L0p6_m36__nf1_gboth_sdfull_ng
Xnfet_01v8_W1p4_L0p6_m36__nf1_gboth_sdfull_ng_30 VSS_body x2_m4d bias_d op nfet_01v8_W1p4_L0p6_m36__nf1_gboth_sdfull_ng
Xnfet_01v8_W1p4_L0p6_m36__nf1_gboth_sdfull_ng_64 VSS_body x2_m3d bias_d on nfet_01v8_W1p4_L0p6_m36__nf1_gboth_sdfull_ng
Xnfet_01v8_W1p4_L0p6_m36__nf1_gboth_sdfull_ng_53 VSS_body x2_m4d bias_d op nfet_01v8_W1p4_L0p6_m36__nf1_gboth_sdfull_ng
Xnfet_01v8_W1p4_L0p6_m36__nf1_gboth_sdfull_ng_42 VSS_body x2_m3d bias_d on nfet_01v8_W1p4_L0p6_m36__nf1_gboth_sdfull_ng
Xnfet_01v8_W1p4_L0p6_m36__nf1_gboth_sdfull_ng_31 VSS_body x2_m3d bias_d on nfet_01v8_W1p4_L0p6_m36__nf1_gboth_sdfull_ng
Xnfet_01v8_W1p4_L0p6_m36__nf1_gboth_sdfull_ng_20 VSS_body x2_m4d bias_d op nfet_01v8_W1p4_L0p6_m36__nf1_gboth_sdfull_ng
Xnfet_01v8_W1p4_L0p6_m36__nf1_gboth_sdfull_ng_65 VSS_body x2_m4d bias_d op nfet_01v8_W1p4_L0p6_m36__nf1_gboth_sdfull_ng
Xnfet_01v8_W1p4_L0p6_m36__nf1_gboth_sdfull_ng_54 VSS_body x2_m3d bias_d on nfet_01v8_W1p4_L0p6_m36__nf1_gboth_sdfull_ng
Xnfet_01v8_W1p4_L0p6_m36__nf1_gboth_sdfull_ng_43 VSS_body x2_m4d bias_d op nfet_01v8_W1p4_L0p6_m36__nf1_gboth_sdfull_ng
Xnfet_01v8_W1p4_L0p6_m36__nf1_gboth_sdfull_ng_32 VSS_body x2_m4d bias_d op nfet_01v8_W1p4_L0p6_m36__nf1_gboth_sdfull_ng
Xnfet_01v8_W1p4_L0p6_m36__nf1_gboth_sdfull_ng_21 VSS_body x2_m3d bias_d on nfet_01v8_W1p4_L0p6_m36__nf1_gboth_sdfull_ng
Xnfet_01v8_W1p4_L0p6_m36__nf1_gboth_sdfull_ng_10 VSS_body x2_m4d bias_d op nfet_01v8_W1p4_L0p6_m36__nf1_gboth_sdfull_ng
.ends

.subckt nfet_01v8_W1p4_L0p6_m50__nf1_gboth_sdfull_ng S B G D
Xnfet_01v8_W1p4_L0p6_m50__nf1_gboth_sdfull_ng_pc G D S B sky130_fd_pr__nfet_01v8_KCM6UP
.ends

.subckt nmos_diode_2__A bias_d x1_m2d VSS_body
Xnfet_01v8_W1p4_L0p6_m50__nf1_gboth_sdfull_ng_12 bias_d VSS_body x1_m2d x1_m2d nfet_01v8_W1p4_L0p6_m50__nf1_gboth_sdfull_ng
Xnfet_01v8_W1p4_L0p6_m50__nf1_gboth_sdfull_ng_13 bias_d VSS_body x1_m2d x1_m2d nfet_01v8_W1p4_L0p6_m50__nf1_gboth_sdfull_ng
Xnfet_01v8_W1p4_L0p6_m50__nf1_gboth_sdfull_ng_23 bias_d VSS_body x1_m2d x1_m2d nfet_01v8_W1p4_L0p6_m50__nf1_gboth_sdfull_ng
Xnfet_01v8_W1p4_L0p6_m50__nf1_gboth_sdfull_ng_24 bias_d VSS_body x1_m2d x1_m2d nfet_01v8_W1p4_L0p6_m50__nf1_gboth_sdfull_ng
Xnfet_01v8_W1p4_L0p6_m50__nf1_gboth_sdfull_ng_34 bias_d VSS_body x1_m2d x1_m2d nfet_01v8_W1p4_L0p6_m50__nf1_gboth_sdfull_ng
Xnfet_01v8_W1p4_L0p6_m50__nf1_gboth_sdfull_ng_35 bias_d VSS_body x1_m2d x1_m2d nfet_01v8_W1p4_L0p6_m50__nf1_gboth_sdfull_ng
Xnfet_01v8_W1p4_L0p6_m50__nf1_gboth_sdfull_ng_45 bias_d VSS_body x1_m2d x1_m2d nfet_01v8_W1p4_L0p6_m50__nf1_gboth_sdfull_ng
Xnfet_01v8_W1p4_L0p6_m50__nf1_gboth_sdfull_ng_46 bias_d VSS_body x1_m2d x1_m2d nfet_01v8_W1p4_L0p6_m50__nf1_gboth_sdfull_ng
Xnfet_01v8_W1p4_L0p6_m50__nf1_gboth_sdfull_ng_14 bias_d VSS_body x1_m2d x1_m2d nfet_01v8_W1p4_L0p6_m50__nf1_gboth_sdfull_ng
Xnfet_01v8_W1p4_L0p6_m50__nf1_gboth_sdfull_ng_25 bias_d VSS_body x1_m2d x1_m2d nfet_01v8_W1p4_L0p6_m50__nf1_gboth_sdfull_ng
Xnfet_01v8_W1p4_L0p6_m50__nf1_gboth_sdfull_ng_36 bias_d VSS_body x1_m2d x1_m2d nfet_01v8_W1p4_L0p6_m50__nf1_gboth_sdfull_ng
Xnfet_01v8_W1p4_L0p6_m50__nf1_gboth_sdfull_ng_47 bias_d VSS_body x1_m2d x1_m2d nfet_01v8_W1p4_L0p6_m50__nf1_gboth_sdfull_ng
Xnfet_01v8_W1p4_L0p6_m50__nf1_gboth_sdfull_ng_15 bias_d VSS_body x1_m2d x1_m2d nfet_01v8_W1p4_L0p6_m50__nf1_gboth_sdfull_ng
Xnfet_01v8_W1p4_L0p6_m50__nf1_gboth_sdfull_ng_26 bias_d VSS_body x1_m2d x1_m2d nfet_01v8_W1p4_L0p6_m50__nf1_gboth_sdfull_ng
Xnfet_01v8_W1p4_L0p6_m50__nf1_gboth_sdfull_ng_37 bias_d VSS_body x1_m2d x1_m2d nfet_01v8_W1p4_L0p6_m50__nf1_gboth_sdfull_ng
Xnfet_01v8_W1p4_L0p6_m50__nf1_gboth_sdfull_ng_48 bias_d VSS_body x1_m2d x1_m2d nfet_01v8_W1p4_L0p6_m50__nf1_gboth_sdfull_ng
Xnfet_01v8_W1p4_L0p6_m50__nf1_gboth_sdfull_ng_16 bias_d VSS_body x1_m2d x1_m2d nfet_01v8_W1p4_L0p6_m50__nf1_gboth_sdfull_ng
Xnfet_01v8_W1p4_L0p6_m50__nf1_gboth_sdfull_ng_27 bias_d VSS_body x1_m2d x1_m2d nfet_01v8_W1p4_L0p6_m50__nf1_gboth_sdfull_ng
Xnfet_01v8_W1p4_L0p6_m50__nf1_gboth_sdfull_ng_38 bias_d VSS_body x1_m2d x1_m2d nfet_01v8_W1p4_L0p6_m50__nf1_gboth_sdfull_ng
Xnfet_01v8_W1p4_L0p6_m50__nf1_gboth_sdfull_ng_49 bias_d VSS_body x1_m2d x1_m2d nfet_01v8_W1p4_L0p6_m50__nf1_gboth_sdfull_ng
Xnfet_01v8_W1p4_L0p6_m50__nf1_gboth_sdfull_ng_0 bias_d VSS_body x1_m2d x1_m2d nfet_01v8_W1p4_L0p6_m50__nf1_gboth_sdfull_ng
Xnfet_01v8_W1p4_L0p6_m50__nf1_gboth_sdfull_ng_17 bias_d VSS_body x1_m2d x1_m2d nfet_01v8_W1p4_L0p6_m50__nf1_gboth_sdfull_ng
Xnfet_01v8_W1p4_L0p6_m50__nf1_gboth_sdfull_ng_28 bias_d VSS_body x1_m2d x1_m2d nfet_01v8_W1p4_L0p6_m50__nf1_gboth_sdfull_ng
Xnfet_01v8_W1p4_L0p6_m50__nf1_gboth_sdfull_ng_39 bias_d VSS_body x1_m2d x1_m2d nfet_01v8_W1p4_L0p6_m50__nf1_gboth_sdfull_ng
Xnfet_01v8_W1p4_L0p6_m50__nf1_gboth_sdfull_ng_1 bias_d VSS_body x1_m2d x1_m2d nfet_01v8_W1p4_L0p6_m50__nf1_gboth_sdfull_ng
Xnfet_01v8_W1p4_L0p6_m50__nf1_gboth_sdfull_ng_18 bias_d VSS_body x1_m2d x1_m2d nfet_01v8_W1p4_L0p6_m50__nf1_gboth_sdfull_ng
Xnfet_01v8_W1p4_L0p6_m50__nf1_gboth_sdfull_ng_29 bias_d VSS_body x1_m2d x1_m2d nfet_01v8_W1p4_L0p6_m50__nf1_gboth_sdfull_ng
Xnfet_01v8_W1p4_L0p6_m50__nf1_gboth_sdfull_ng_2 bias_d VSS_body x1_m2d x1_m2d nfet_01v8_W1p4_L0p6_m50__nf1_gboth_sdfull_ng
Xnfet_01v8_W1p4_L0p6_m50__nf1_gboth_sdfull_ng_19 bias_d VSS_body x1_m2d x1_m2d nfet_01v8_W1p4_L0p6_m50__nf1_gboth_sdfull_ng
Xnfet_01v8_W1p4_L0p6_m50__nf1_gboth_sdfull_ng_3 bias_d VSS_body x1_m2d x1_m2d nfet_01v8_W1p4_L0p6_m50__nf1_gboth_sdfull_ng
Xnfet_01v8_W1p4_L0p6_m50__nf1_gboth_sdfull_ng_4 bias_d VSS_body x1_m2d x1_m2d nfet_01v8_W1p4_L0p6_m50__nf1_gboth_sdfull_ng
Xnfet_01v8_W1p4_L0p6_m50__nf1_gboth_sdfull_ng_5 bias_d VSS_body x1_m2d x1_m2d nfet_01v8_W1p4_L0p6_m50__nf1_gboth_sdfull_ng
Xnfet_01v8_W1p4_L0p6_m50__nf1_gboth_sdfull_ng_6 bias_d VSS_body x1_m2d x1_m2d nfet_01v8_W1p4_L0p6_m50__nf1_gboth_sdfull_ng
Xnfet_01v8_W1p4_L0p6_m50__nf1_gboth_sdfull_ng_7 bias_d VSS_body x1_m2d x1_m2d nfet_01v8_W1p4_L0p6_m50__nf1_gboth_sdfull_ng
Xnfet_01v8_W1p4_L0p6_m50__nf1_gboth_sdfull_ng_8 bias_d VSS_body x1_m2d x1_m2d nfet_01v8_W1p4_L0p6_m50__nf1_gboth_sdfull_ng
Xnfet_01v8_W1p4_L0p6_m50__nf1_gboth_sdfull_ng_9 bias_d VSS_body x1_m2d x1_m2d nfet_01v8_W1p4_L0p6_m50__nf1_gboth_sdfull_ng
Xnfet_01v8_W1p4_L0p6_m50__nf1_gboth_sdfull_ng_40 bias_d VSS_body x1_m2d x1_m2d nfet_01v8_W1p4_L0p6_m50__nf1_gboth_sdfull_ng
Xnfet_01v8_W1p4_L0p6_m50__nf1_gboth_sdfull_ng_30 bias_d VSS_body x1_m2d x1_m2d nfet_01v8_W1p4_L0p6_m50__nf1_gboth_sdfull_ng
Xnfet_01v8_W1p4_L0p6_m50__nf1_gboth_sdfull_ng_41 bias_d VSS_body x1_m2d x1_m2d nfet_01v8_W1p4_L0p6_m50__nf1_gboth_sdfull_ng
Xnfet_01v8_W1p4_L0p6_m50__nf1_gboth_sdfull_ng_20 bias_d VSS_body x1_m2d x1_m2d nfet_01v8_W1p4_L0p6_m50__nf1_gboth_sdfull_ng
Xnfet_01v8_W1p4_L0p6_m50__nf1_gboth_sdfull_ng_31 bias_d VSS_body x1_m2d x1_m2d nfet_01v8_W1p4_L0p6_m50__nf1_gboth_sdfull_ng
Xnfet_01v8_W1p4_L0p6_m50__nf1_gboth_sdfull_ng_42 bias_d VSS_body x1_m2d x1_m2d nfet_01v8_W1p4_L0p6_m50__nf1_gboth_sdfull_ng
Xnfet_01v8_W1p4_L0p6_m50__nf1_gboth_sdfull_ng_10 bias_d VSS_body x1_m2d x1_m2d nfet_01v8_W1p4_L0p6_m50__nf1_gboth_sdfull_ng
Xnfet_01v8_W1p4_L0p6_m50__nf1_gboth_sdfull_ng_21 bias_d VSS_body x1_m2d x1_m2d nfet_01v8_W1p4_L0p6_m50__nf1_gboth_sdfull_ng
Xnfet_01v8_W1p4_L0p6_m50__nf1_gboth_sdfull_ng_32 bias_d VSS_body x1_m2d x1_m2d nfet_01v8_W1p4_L0p6_m50__nf1_gboth_sdfull_ng
Xnfet_01v8_W1p4_L0p6_m50__nf1_gboth_sdfull_ng_43 bias_d VSS_body x1_m2d x1_m2d nfet_01v8_W1p4_L0p6_m50__nf1_gboth_sdfull_ng
Xnfet_01v8_W1p4_L0p6_m50__nf1_gboth_sdfull_ng_11 bias_d VSS_body x1_m2d x1_m2d nfet_01v8_W1p4_L0p6_m50__nf1_gboth_sdfull_ng
Xnfet_01v8_W1p4_L0p6_m50__nf1_gboth_sdfull_ng_22 bias_d VSS_body x1_m2d x1_m2d nfet_01v8_W1p4_L0p6_m50__nf1_gboth_sdfull_ng
Xnfet_01v8_W1p4_L0p6_m50__nf1_gboth_sdfull_ng_33 bias_d VSS_body x1_m2d x1_m2d nfet_01v8_W1p4_L0p6_m50__nf1_gboth_sdfull_ng
Xnfet_01v8_W1p4_L0p6_m50__nf1_gboth_sdfull_ng_44 bias_d VSS_body x1_m2d x1_m2d nfet_01v8_W1p4_L0p6_m50__nf1_gboth_sdfull_ng
.ends

.subckt nfet_01v8_W1p4_L0p6_m8__nf1_gtop_sdfull_ng B S G D
Xnfet_01v8_W1p4_L0p6_m8__nf1_gtop_sdfull_ng_pc G D S B sky130_fd_pr__nfet_01v8_RUA5M6
.ends

.subckt nmos_dummy_19__A x2_m3d VSS VSS_body
Xnfet_01v8_W1p4_L0p6_m8__nf1_gtop_sdfull_ng_0 VSS_body VSS VSS x2_m3d nfet_01v8_W1p4_L0p6_m8__nf1_gtop_sdfull_ng
Xnfet_01v8_W1p4_L0p6_m8__nf1_gtop_sdfull_ng_1 VSS_body VSS VSS x2_m3d nfet_01v8_W1p4_L0p6_m8__nf1_gtop_sdfull_ng
Xnfet_01v8_W1p4_L0p6_m8__nf1_gtop_sdfull_ng_2 VSS_body VSS VSS x2_m3d nfet_01v8_W1p4_L0p6_m8__nf1_gtop_sdfull_ng
Xnfet_01v8_W1p4_L0p6_m8__nf1_gtop_sdfull_ng_3 VSS_body VSS VSS x2_m3d nfet_01v8_W1p4_L0p6_m8__nf1_gtop_sdfull_ng
Xnfet_01v8_W1p4_L0p6_m8__nf1_gtop_sdfull_ng_5 VSS_body VSS VSS x2_m3d nfet_01v8_W1p4_L0p6_m8__nf1_gtop_sdfull_ng
Xnfet_01v8_W1p4_L0p6_m8__nf1_gtop_sdfull_ng_4 VSS_body VSS VSS x2_m3d nfet_01v8_W1p4_L0p6_m8__nf1_gtop_sdfull_ng
Xnfet_01v8_W1p4_L0p6_m8__nf1_gtop_sdfull_ng_6 VSS_body VSS VSS x2_m3d nfet_01v8_W1p4_L0p6_m8__nf1_gtop_sdfull_ng
Xnfet_01v8_W1p4_L0p6_m8__nf1_gtop_sdfull_ng_7 VSS_body VSS VSS x2_m3d nfet_01v8_W1p4_L0p6_m8__nf1_gtop_sdfull_ng
.ends

.subckt pmos_dummy_3__A x1_m21d VDD_body
Xpfet_01v8_lvt_W1p4_L0p6_m2__nf1_gtop_sdfull_ng_0 VDD_body x1_m21d x1_m21d x1_m21d
+ pfet_01v8_lvt_W1p4_L0p6_m2__nf1_gtop_sdfull_ng
Xpfet_01v8_lvt_W1p4_L0p6_m2__nf1_gtop_sdfull_ng_1 VDD_body x1_m21d x1_m21d x1_m21d
+ pfet_01v8_lvt_W1p4_L0p6_m2__nf1_gtop_sdfull_ng
.ends

.subckt nmos_dummy_5__A VSS_body bias_d
Xnfet_01v8_W1p4_L0p6_m8__nf1_gtop_sdfull_ng_0 VSS_body bias_d bias_d bias_d nfet_01v8_W1p4_L0p6_m8__nf1_gtop_sdfull_ng
Xnfet_01v8_W1p4_L0p6_m8__nf1_gtop_sdfull_ng_1 VSS_body bias_d bias_d bias_d nfet_01v8_W1p4_L0p6_m8__nf1_gtop_sdfull_ng
Xnfet_01v8_W1p4_L0p6_m8__nf1_gtop_sdfull_ng_2 VSS_body bias_d bias_d bias_d nfet_01v8_W1p4_L0p6_m8__nf1_gtop_sdfull_ng
Xnfet_01v8_W1p4_L0p6_m8__nf1_gtop_sdfull_ng_3 VSS_body bias_d bias_d bias_d nfet_01v8_W1p4_L0p6_m8__nf1_gtop_sdfull_ng
Xnfet_01v8_W1p4_L0p6_m8__nf1_gtop_sdfull_ng_5 VSS_body bias_d bias_d bias_d nfet_01v8_W1p4_L0p6_m8__nf1_gtop_sdfull_ng
Xnfet_01v8_W1p4_L0p6_m8__nf1_gtop_sdfull_ng_4 VSS_body bias_d bias_d bias_d nfet_01v8_W1p4_L0p6_m8__nf1_gtop_sdfull_ng
Xnfet_01v8_W1p4_L0p6_m8__nf1_gtop_sdfull_ng_6 VSS_body bias_d bias_d bias_d nfet_01v8_W1p4_L0p6_m8__nf1_gtop_sdfull_ng
Xnfet_01v8_W1p4_L0p6_m8__nf1_gtop_sdfull_ng_7 VSS_body bias_d bias_d bias_d nfet_01v8_W1p4_L0p6_m8__nf1_gtop_sdfull_ng
.ends

.subckt pmos_single_2__A x1_m31d VDD_body bias_c cm
Xpfet_01v8_W1p4_L0p6_m6__nf1_gboth_sdfull_ng_0 x1_m31d VDD_body bias_c cm pfet_01v8_W1p4_L0p6_m6__nf1_gboth_sdfull_ng
Xpfet_01v8_W1p4_L0p6_m6__nf1_gboth_sdfull_ng_1 x1_m31d VDD_body bias_c cm pfet_01v8_W1p4_L0p6_m6__nf1_gboth_sdfull_ng
Xpfet_01v8_W1p4_L0p6_m6__nf1_gboth_sdfull_ng_2 x1_m31d VDD_body bias_c cm pfet_01v8_W1p4_L0p6_m6__nf1_gboth_sdfull_ng
Xpfet_01v8_W1p4_L0p6_m6__nf1_gboth_sdfull_ng_3 x1_m31d VDD_body bias_c cm pfet_01v8_W1p4_L0p6_m6__nf1_gboth_sdfull_ng
Xpfet_01v8_W1p4_L0p6_m6__nf1_gboth_sdfull_ng_4 x1_m31d VDD_body bias_c cm pfet_01v8_W1p4_L0p6_m6__nf1_gboth_sdfull_ng
Xpfet_01v8_W1p4_L0p6_m6__nf1_gboth_sdfull_ng_5 x1_m31d VDD_body bias_c cm pfet_01v8_W1p4_L0p6_m6__nf1_gboth_sdfull_ng
.ends

.subckt pmos_dummy_15__A VDD on VDD_body
Xpfet_01v8_W1p4_L0p6_m4__nf1_gtop_sdhalf_ng_0 VDD on VDD_body VDD pfet_01v8_W1p4_L0p6_m4__nf1_gtop_sdhalf_ng
Xpfet_01v8_W1p4_L0p6_m4__nf1_gtop_sdhalf_ng_1 VDD on VDD_body VDD pfet_01v8_W1p4_L0p6_m4__nf1_gtop_sdhalf_ng
Xpfet_01v8_W1p4_L0p6_m4__nf1_gtop_sdhalf_ng_2 VDD on VDD_body VDD pfet_01v8_W1p4_L0p6_m4__nf1_gtop_sdhalf_ng
Xpfet_01v8_W1p4_L0p6_m4__nf1_gtop_sdhalf_ng_3 VDD on VDD_body VDD pfet_01v8_W1p4_L0p6_m4__nf1_gtop_sdhalf_ng
.ends

.subckt sky130_fd_pr__nfet_01v8_lvt_A2K2V3 G D S VSUBS
X0 S G D VSUBS sky130_fd_pr__nfet_01v8_lvt ad=0.348 pd=2.98 as=0.348 ps=2.98 w=1.2 l=0.2
.ends

.subckt nfet_01v8_lvt_W1p2_L0p2_m6__nf1_gboth_sdfull_ng G B D S
Xnfet_01v8_lvt_W1p2_L0p2_m6__nf1_gboth_sdfull_ng_pc G D S B sky130_fd_pr__nfet_01v8_lvt_A2K2V3
.ends

.subckt nmos_differential_pair__ABAB x2_foldp x2_tail VSS_body VSS in x2_foldn ip
Xnfet_01v8_lvt_W1p2_L0p2_m6__nf1_gboth_sdfull_ng_10 in VSS_body x2_foldn x2_tail nfet_01v8_lvt_W1p2_L0p2_m6__nf1_gboth_sdfull_ng
Xnfet_01v8_lvt_W1p2_L0p2_m6__nf1_gboth_sdfull_ng_11 ip VSS_body x2_foldp x2_tail nfet_01v8_lvt_W1p2_L0p2_m6__nf1_gboth_sdfull_ng
Xnfet_01v8_lvt_W1p2_L0p2_m6__nf1_gboth_sdfull_ng_12 in VSS_body x2_foldn x2_tail nfet_01v8_lvt_W1p2_L0p2_m6__nf1_gboth_sdfull_ng
Xnfet_01v8_lvt_W1p2_L0p2_m6__nf1_gboth_sdfull_ng_13 VSS VSS_body VSS VSS nfet_01v8_lvt_W1p2_L0p2_m6__nf1_gboth_sdfull_ng
Xnfet_01v8_lvt_W1p2_L0p2_m6__nf1_gboth_sdfull_ng_0 VSS VSS_body VSS VSS nfet_01v8_lvt_W1p2_L0p2_m6__nf1_gboth_sdfull_ng
Xnfet_01v8_lvt_W1p2_L0p2_m6__nf1_gboth_sdfull_ng_1 ip VSS_body x2_foldp x2_tail nfet_01v8_lvt_W1p2_L0p2_m6__nf1_gboth_sdfull_ng
Xnfet_01v8_lvt_W1p2_L0p2_m6__nf1_gboth_sdfull_ng_2 in VSS_body x2_foldn x2_tail nfet_01v8_lvt_W1p2_L0p2_m6__nf1_gboth_sdfull_ng
Xnfet_01v8_lvt_W1p2_L0p2_m6__nf1_gboth_sdfull_ng_3 ip VSS_body x2_foldp x2_tail nfet_01v8_lvt_W1p2_L0p2_m6__nf1_gboth_sdfull_ng
Xnfet_01v8_lvt_W1p2_L0p2_m6__nf1_gboth_sdfull_ng_4 in VSS_body x2_foldn x2_tail nfet_01v8_lvt_W1p2_L0p2_m6__nf1_gboth_sdfull_ng
Xnfet_01v8_lvt_W1p2_L0p2_m6__nf1_gboth_sdfull_ng_5 ip VSS_body x2_foldp x2_tail nfet_01v8_lvt_W1p2_L0p2_m6__nf1_gboth_sdfull_ng
Xnfet_01v8_lvt_W1p2_L0p2_m6__nf1_gboth_sdfull_ng_6 in VSS_body x2_foldn x2_tail nfet_01v8_lvt_W1p2_L0p2_m6__nf1_gboth_sdfull_ng
Xnfet_01v8_lvt_W1p2_L0p2_m6__nf1_gboth_sdfull_ng_7 ip VSS_body x2_foldp x2_tail nfet_01v8_lvt_W1p2_L0p2_m6__nf1_gboth_sdfull_ng
Xnfet_01v8_lvt_W1p2_L0p2_m6__nf1_gboth_sdfull_ng_8 in VSS_body x2_foldn x2_tail nfet_01v8_lvt_W1p2_L0p2_m6__nf1_gboth_sdfull_ng
Xnfet_01v8_lvt_W1p2_L0p2_m6__nf1_gboth_sdfull_ng_9 ip VSS_body x2_foldp x2_tail nfet_01v8_lvt_W1p2_L0p2_m6__nf1_gboth_sdfull_ng
.ends

.subckt pmos_dummy_6__A VDD_body x1_m21d
Xpfet_01v8_W1p4_L0p6_m2__nf1_gtop_sdfull_ng_0 VDD_body x1_m21d x1_m21d x1_m21d pfet_01v8_W1p4_L0p6_m2__nf1_gtop_sdfull_ng
Xpfet_01v8_W1p4_L0p6_m2__nf1_gtop_sdfull_ng_1 VDD_body x1_m21d x1_m21d x1_m21d pfet_01v8_W1p4_L0p6_m2__nf1_gtop_sdfull_ng
.ends

.subckt pfet_01v8_lvt_W1p4_L0p6_m8__nf1_gtop_sdfull_ng G D B S
Xpfet_01v8_lvt_W1p4_L0p6_m8__nf1_gtop_sdfull_ng_pc G D B S sky130_fd_pr__pfet_01v8_lvt_L7GY3J
.ends

.subckt pmos_dummy__A VDD_body VDD
Xpfet_01v8_lvt_W1p4_L0p6_m8__nf1_gtop_sdfull_ng_0 VDD VDD VDD_body VDD pfet_01v8_lvt_W1p4_L0p6_m8__nf1_gtop_sdfull_ng
Xpfet_01v8_lvt_W1p4_L0p6_m8__nf1_gtop_sdfull_ng_1 VDD VDD VDD_body VDD pfet_01v8_lvt_W1p4_L0p6_m8__nf1_gtop_sdfull_ng
Xpfet_01v8_lvt_W1p4_L0p6_m8__nf1_gtop_sdfull_ng_2 VDD VDD VDD_body VDD pfet_01v8_lvt_W1p4_L0p6_m8__nf1_gtop_sdfull_ng
Xpfet_01v8_lvt_W1p4_L0p6_m8__nf1_gtop_sdfull_ng_3 VDD VDD VDD_body VDD pfet_01v8_lvt_W1p4_L0p6_m8__nf1_gtop_sdfull_ng
Xpfet_01v8_lvt_W1p4_L0p6_m8__nf1_gtop_sdfull_ng_4 VDD VDD VDD_body VDD pfet_01v8_lvt_W1p4_L0p6_m8__nf1_gtop_sdfull_ng
Xpfet_01v8_lvt_W1p4_L0p6_m8__nf1_gtop_sdfull_ng_5 VDD VDD VDD_body VDD pfet_01v8_lvt_W1p4_L0p6_m8__nf1_gtop_sdfull_ng
Xpfet_01v8_lvt_W1p4_L0p6_m8__nf1_gtop_sdfull_ng_6 VDD VDD VDD_body VDD pfet_01v8_lvt_W1p4_L0p6_m8__nf1_gtop_sdfull_ng
Xpfet_01v8_lvt_W1p4_L0p6_m8__nf1_gtop_sdfull_ng_7 VDD VDD VDD_body VDD pfet_01v8_lvt_W1p4_L0p6_m8__nf1_gtop_sdfull_ng
.ends

.subckt nmos_dummy_8__A cm VSS_body
Xnfet_01v8_W1p4_L0p6_m8__nf1_gtop_sdfull_ng_0 VSS_body cm cm cm nfet_01v8_W1p4_L0p6_m8__nf1_gtop_sdfull_ng
Xnfet_01v8_W1p4_L0p6_m8__nf1_gtop_sdfull_ng_1 VSS_body cm cm cm nfet_01v8_W1p4_L0p6_m8__nf1_gtop_sdfull_ng
Xnfet_01v8_W1p4_L0p6_m8__nf1_gtop_sdfull_ng_2 VSS_body cm cm cm nfet_01v8_W1p4_L0p6_m8__nf1_gtop_sdfull_ng
Xnfet_01v8_W1p4_L0p6_m8__nf1_gtop_sdfull_ng_3 VSS_body cm cm cm nfet_01v8_W1p4_L0p6_m8__nf1_gtop_sdfull_ng
Xnfet_01v8_W1p4_L0p6_m8__nf1_gtop_sdfull_ng_4 VSS_body cm cm cm nfet_01v8_W1p4_L0p6_m8__nf1_gtop_sdfull_ng
Xnfet_01v8_W1p4_L0p6_m8__nf1_gtop_sdfull_ng_5 VSS_body cm cm cm nfet_01v8_W1p4_L0p6_m8__nf1_gtop_sdfull_ng
Xnfet_01v8_W1p4_L0p6_m8__nf1_gtop_sdfull_ng_6 VSS_body cm cm cm nfet_01v8_W1p4_L0p6_m8__nf1_gtop_sdfull_ng
Xnfet_01v8_W1p4_L0p6_m8__nf1_gtop_sdfull_ng_7 VSS_body cm cm cm nfet_01v8_W1p4_L0p6_m8__nf1_gtop_sdfull_ng
.ends

.subckt nmos_dummy_12__A x2_foldp VSS_body
Xnfet_01v8_lvt_W1p2_L0p2_m2__nf1_gtop_sdfull_ng_0 VSS_body x2_foldp x2_foldp x2_foldp
+ nfet_01v8_lvt_W1p2_L0p2_m2__nf1_gtop_sdfull_ng
Xnfet_01v8_lvt_W1p2_L0p2_m2__nf1_gtop_sdfull_ng_1 VSS_body x2_foldp x2_foldp x2_foldp
+ nfet_01v8_lvt_W1p2_L0p2_m2__nf1_gtop_sdfull_ng
.ends

.subckt pmos_single__A VDD bias_b VDD_body x1_m31d
Xpfet_01v8_lvt_W1p4_L0p6_m6__nf1_gboth_sdfull_ng_0 bias_b x1_m31d VDD VDD_body pfet_01v8_lvt_W1p4_L0p6_m6__nf1_gboth_sdfull_ng
Xpfet_01v8_lvt_W1p4_L0p6_m6__nf1_gboth_sdfull_ng_1 bias_b x1_m31d VDD VDD_body pfet_01v8_lvt_W1p4_L0p6_m6__nf1_gboth_sdfull_ng
Xpfet_01v8_lvt_W1p4_L0p6_m6__nf1_gboth_sdfull_ng_2 bias_b x1_m31d VDD VDD_body pfet_01v8_lvt_W1p4_L0p6_m6__nf1_gboth_sdfull_ng
Xpfet_01v8_lvt_W1p4_L0p6_m6__nf1_gboth_sdfull_ng_3 bias_b x1_m31d VDD VDD_body pfet_01v8_lvt_W1p4_L0p6_m6__nf1_gboth_sdfull_ng
Xpfet_01v8_lvt_W1p4_L0p6_m6__nf1_gboth_sdfull_ng_4 bias_b x1_m31d VDD VDD_body pfet_01v8_lvt_W1p4_L0p6_m6__nf1_gboth_sdfull_ng
Xpfet_01v8_lvt_W1p4_L0p6_m6__nf1_gboth_sdfull_ng_5 bias_b x1_m31d VDD VDD_body pfet_01v8_lvt_W1p4_L0p6_m6__nf1_gboth_sdfull_ng
.ends

.subckt pmos_dummy_9__A VDD_body x1_m2d VDD
Xpfet_01v8_W1p4_L0p6_m2__nf1_gtop_sdfull_ng_0 VDD_body VDD VDD x1_m2d pfet_01v8_W1p4_L0p6_m2__nf1_gtop_sdfull_ng
Xpfet_01v8_W1p4_L0p6_m2__nf1_gtop_sdfull_ng_1 VDD_body VDD VDD x1_m2d pfet_01v8_W1p4_L0p6_m2__nf1_gtop_sdfull_ng
.ends

.subckt XC4_mim XC4_mim_pc/C2_3 XC4_mim_pc/C2_2 XC4_mim_pc/C2_0 XC4_mim_pc/C2_1 XC4_mim_pc/C1_3
+ XC4_mim_pc/C1_2 XC4_mim_pc/C1_1 XC4_mim_pc/C1_0
XXC4_mim_pc XC4_mim_pc/C1_3 XC4_mim_pc/C1_2 XC4_mim_pc/C1_1 XC4_mim_pc/C1_0 XC4_mim_pc/C2_3
+ XC4_mim_pc/C2_2 XC4_mim_pc/C2_1 XC4_mim_pc/C2_0 sky130_fd_pr__cap_mim_m3_1_MX4MQY
.ends

.subckt XC4__A on cmc
XXC4_mim_0 cmc cmc cmc cmc on on on on XC4_mim
.ends

.subckt pfet_01v8_lvt_W1p4_L0p6_m24__nf1_gboth_sdfull_ng B S G D
Xpfet_01v8_lvt_W1p4_L0p6_m24__nf1_gboth_sdfull_ng_pc G D B S sky130_fd_pr__pfet_01v8_lvt_PJ46JE
.ends

.subckt pmos_matched_current_source_pair_2__ABAB bias_b VDD_body x2_foldp x2_foldn
+ VDD
Xpfet_01v8_lvt_W1p4_L0p6_m24__nf1_gboth_sdfull_ng_2 VDD_body VDD bias_b x2_foldn pfet_01v8_lvt_W1p4_L0p6_m24__nf1_gboth_sdfull_ng
Xpfet_01v8_lvt_W1p4_L0p6_m24__nf1_gboth_sdfull_ng_3 VDD_body VDD bias_b x2_foldp pfet_01v8_lvt_W1p4_L0p6_m24__nf1_gboth_sdfull_ng
Xpfet_01v8_lvt_W1p4_L0p6_m24__nf1_gboth_sdfull_ng_4 VDD_body VDD bias_b x2_foldn pfet_01v8_lvt_W1p4_L0p6_m24__nf1_gboth_sdfull_ng
Xpfet_01v8_lvt_W1p4_L0p6_m24__nf1_gboth_sdfull_ng_5 VDD_body VDD bias_b x2_foldp pfet_01v8_lvt_W1p4_L0p6_m24__nf1_gboth_sdfull_ng
Xpfet_01v8_lvt_W1p4_L0p6_m24__nf1_gboth_sdfull_ng_6 VDD_body VDD bias_b x2_foldn pfet_01v8_lvt_W1p4_L0p6_m24__nf1_gboth_sdfull_ng
Xpfet_01v8_lvt_W1p4_L0p6_m24__nf1_gboth_sdfull_ng_7 VDD_body VDD bias_b x2_foldp pfet_01v8_lvt_W1p4_L0p6_m24__nf1_gboth_sdfull_ng
Xpfet_01v8_lvt_W1p4_L0p6_m24__nf1_gboth_sdfull_ng_8 VDD_body VDD bias_b x2_foldn pfet_01v8_lvt_W1p4_L0p6_m24__nf1_gboth_sdfull_ng
Xpfet_01v8_lvt_W1p4_L0p6_m24__nf1_gboth_sdfull_ng_9 VDD_body VDD bias_b x2_foldp pfet_01v8_lvt_W1p4_L0p6_m24__nf1_gboth_sdfull_ng
Xpfet_01v8_lvt_W1p4_L0p6_m24__nf1_gboth_sdfull_ng_40 VDD_body VDD bias_b x2_foldn
+ pfet_01v8_lvt_W1p4_L0p6_m24__nf1_gboth_sdfull_ng
Xpfet_01v8_lvt_W1p4_L0p6_m24__nf1_gboth_sdfull_ng_30 VDD_body VDD bias_b x2_foldn
+ pfet_01v8_lvt_W1p4_L0p6_m24__nf1_gboth_sdfull_ng
Xpfet_01v8_lvt_W1p4_L0p6_m24__nf1_gboth_sdfull_ng_41 VDD_body VDD bias_b x2_foldp
+ pfet_01v8_lvt_W1p4_L0p6_m24__nf1_gboth_sdfull_ng
Xpfet_01v8_lvt_W1p4_L0p6_m24__nf1_gboth_sdfull_ng_20 VDD_body VDD bias_b x2_foldn
+ pfet_01v8_lvt_W1p4_L0p6_m24__nf1_gboth_sdfull_ng
Xpfet_01v8_lvt_W1p4_L0p6_m24__nf1_gboth_sdfull_ng_31 VDD_body VDD bias_b x2_foldp
+ pfet_01v8_lvt_W1p4_L0p6_m24__nf1_gboth_sdfull_ng
Xpfet_01v8_lvt_W1p4_L0p6_m24__nf1_gboth_sdfull_ng_42 VDD_body VDD bias_b x2_foldn
+ pfet_01v8_lvt_W1p4_L0p6_m24__nf1_gboth_sdfull_ng
Xpfet_01v8_lvt_W1p4_L0p6_m24__nf1_gboth_sdfull_ng_10 VDD_body VDD bias_b x2_foldn
+ pfet_01v8_lvt_W1p4_L0p6_m24__nf1_gboth_sdfull_ng
Xpfet_01v8_lvt_W1p4_L0p6_m24__nf1_gboth_sdfull_ng_21 VDD_body VDD bias_b x2_foldp
+ pfet_01v8_lvt_W1p4_L0p6_m24__nf1_gboth_sdfull_ng
Xpfet_01v8_lvt_W1p4_L0p6_m24__nf1_gboth_sdfull_ng_32 VDD_body VDD bias_b x2_foldn
+ pfet_01v8_lvt_W1p4_L0p6_m24__nf1_gboth_sdfull_ng
Xpfet_01v8_lvt_W1p4_L0p6_m24__nf1_gboth_sdfull_ng_43 VDD_body VDD bias_b x2_foldp
+ pfet_01v8_lvt_W1p4_L0p6_m24__nf1_gboth_sdfull_ng
Xpfet_01v8_lvt_W1p4_L0p6_m24__nf1_gboth_sdfull_ng_11 VDD_body VDD bias_b x2_foldp
+ pfet_01v8_lvt_W1p4_L0p6_m24__nf1_gboth_sdfull_ng
Xpfet_01v8_lvt_W1p4_L0p6_m24__nf1_gboth_sdfull_ng_12 VDD_body VDD bias_b x2_foldn
+ pfet_01v8_lvt_W1p4_L0p6_m24__nf1_gboth_sdfull_ng
Xpfet_01v8_lvt_W1p4_L0p6_m24__nf1_gboth_sdfull_ng_22 VDD_body VDD bias_b x2_foldn
+ pfet_01v8_lvt_W1p4_L0p6_m24__nf1_gboth_sdfull_ng
Xpfet_01v8_lvt_W1p4_L0p6_m24__nf1_gboth_sdfull_ng_23 VDD_body VDD bias_b x2_foldp
+ pfet_01v8_lvt_W1p4_L0p6_m24__nf1_gboth_sdfull_ng
Xpfet_01v8_lvt_W1p4_L0p6_m24__nf1_gboth_sdfull_ng_33 VDD_body VDD bias_b x2_foldp
+ pfet_01v8_lvt_W1p4_L0p6_m24__nf1_gboth_sdfull_ng
Xpfet_01v8_lvt_W1p4_L0p6_m24__nf1_gboth_sdfull_ng_34 VDD_body VDD bias_b x2_foldn
+ pfet_01v8_lvt_W1p4_L0p6_m24__nf1_gboth_sdfull_ng
Xpfet_01v8_lvt_W1p4_L0p6_m24__nf1_gboth_sdfull_ng_44 VDD_body VDD bias_b x2_foldn
+ pfet_01v8_lvt_W1p4_L0p6_m24__nf1_gboth_sdfull_ng
Xpfet_01v8_lvt_W1p4_L0p6_m24__nf1_gboth_sdfull_ng_45 VDD_body VDD bias_b x2_foldp
+ pfet_01v8_lvt_W1p4_L0p6_m24__nf1_gboth_sdfull_ng
Xpfet_01v8_lvt_W1p4_L0p6_m24__nf1_gboth_sdfull_ng_13 VDD_body VDD bias_b x2_foldp
+ pfet_01v8_lvt_W1p4_L0p6_m24__nf1_gboth_sdfull_ng
Xpfet_01v8_lvt_W1p4_L0p6_m24__nf1_gboth_sdfull_ng_24 VDD_body VDD bias_b x2_foldn
+ pfet_01v8_lvt_W1p4_L0p6_m24__nf1_gboth_sdfull_ng
Xpfet_01v8_lvt_W1p4_L0p6_m24__nf1_gboth_sdfull_ng_35 VDD_body VDD bias_b x2_foldp
+ pfet_01v8_lvt_W1p4_L0p6_m24__nf1_gboth_sdfull_ng
Xpfet_01v8_lvt_W1p4_L0p6_m24__nf1_gboth_sdfull_ng_46 VDD_body VDD bias_b x2_foldn
+ pfet_01v8_lvt_W1p4_L0p6_m24__nf1_gboth_sdfull_ng
Xpfet_01v8_lvt_W1p4_L0p6_m24__nf1_gboth_sdfull_ng_14 VDD_body VDD bias_b x2_foldn
+ pfet_01v8_lvt_W1p4_L0p6_m24__nf1_gboth_sdfull_ng
Xpfet_01v8_lvt_W1p4_L0p6_m24__nf1_gboth_sdfull_ng_25 VDD_body VDD bias_b x2_foldp
+ pfet_01v8_lvt_W1p4_L0p6_m24__nf1_gboth_sdfull_ng
Xpfet_01v8_lvt_W1p4_L0p6_m24__nf1_gboth_sdfull_ng_36 VDD_body VDD bias_b x2_foldn
+ pfet_01v8_lvt_W1p4_L0p6_m24__nf1_gboth_sdfull_ng
Xpfet_01v8_lvt_W1p4_L0p6_m24__nf1_gboth_sdfull_ng_47 VDD_body VDD bias_b x2_foldp
+ pfet_01v8_lvt_W1p4_L0p6_m24__nf1_gboth_sdfull_ng
Xpfet_01v8_lvt_W1p4_L0p6_m24__nf1_gboth_sdfull_ng_15 VDD_body VDD bias_b x2_foldp
+ pfet_01v8_lvt_W1p4_L0p6_m24__nf1_gboth_sdfull_ng
Xpfet_01v8_lvt_W1p4_L0p6_m24__nf1_gboth_sdfull_ng_26 VDD_body VDD bias_b x2_foldn
+ pfet_01v8_lvt_W1p4_L0p6_m24__nf1_gboth_sdfull_ng
Xpfet_01v8_lvt_W1p4_L0p6_m24__nf1_gboth_sdfull_ng_37 VDD_body VDD bias_b x2_foldp
+ pfet_01v8_lvt_W1p4_L0p6_m24__nf1_gboth_sdfull_ng
Xpfet_01v8_lvt_W1p4_L0p6_m24__nf1_gboth_sdfull_ng_48 VDD_body VDD bias_b x2_foldn
+ pfet_01v8_lvt_W1p4_L0p6_m24__nf1_gboth_sdfull_ng
Xpfet_01v8_lvt_W1p4_L0p6_m24__nf1_gboth_sdfull_ng_16 VDD_body VDD bias_b x2_foldn
+ pfet_01v8_lvt_W1p4_L0p6_m24__nf1_gboth_sdfull_ng
Xpfet_01v8_lvt_W1p4_L0p6_m24__nf1_gboth_sdfull_ng_27 VDD_body VDD bias_b x2_foldp
+ pfet_01v8_lvt_W1p4_L0p6_m24__nf1_gboth_sdfull_ng
Xpfet_01v8_lvt_W1p4_L0p6_m24__nf1_gboth_sdfull_ng_38 VDD_body VDD bias_b x2_foldn
+ pfet_01v8_lvt_W1p4_L0p6_m24__nf1_gboth_sdfull_ng
Xpfet_01v8_lvt_W1p4_L0p6_m24__nf1_gboth_sdfull_ng_49 VDD_body VDD VDD VDD pfet_01v8_lvt_W1p4_L0p6_m24__nf1_gboth_sdfull_ng
Xpfet_01v8_lvt_W1p4_L0p6_m24__nf1_gboth_sdfull_ng_17 VDD_body VDD bias_b x2_foldp
+ pfet_01v8_lvt_W1p4_L0p6_m24__nf1_gboth_sdfull_ng
Xpfet_01v8_lvt_W1p4_L0p6_m24__nf1_gboth_sdfull_ng_28 VDD_body VDD bias_b x2_foldn
+ pfet_01v8_lvt_W1p4_L0p6_m24__nf1_gboth_sdfull_ng
Xpfet_01v8_lvt_W1p4_L0p6_m24__nf1_gboth_sdfull_ng_39 VDD_body VDD bias_b x2_foldp
+ pfet_01v8_lvt_W1p4_L0p6_m24__nf1_gboth_sdfull_ng
Xpfet_01v8_lvt_W1p4_L0p6_m24__nf1_gboth_sdfull_ng_18 VDD_body VDD bias_b x2_foldn
+ pfet_01v8_lvt_W1p4_L0p6_m24__nf1_gboth_sdfull_ng
Xpfet_01v8_lvt_W1p4_L0p6_m24__nf1_gboth_sdfull_ng_29 VDD_body VDD bias_b x2_foldp
+ pfet_01v8_lvt_W1p4_L0p6_m24__nf1_gboth_sdfull_ng
Xpfet_01v8_lvt_W1p4_L0p6_m24__nf1_gboth_sdfull_ng_19 VDD_body VDD bias_b x2_foldp
+ pfet_01v8_lvt_W1p4_L0p6_m24__nf1_gboth_sdfull_ng
Xpfet_01v8_lvt_W1p4_L0p6_m24__nf1_gboth_sdfull_ng_0 VDD_body VDD VDD VDD pfet_01v8_lvt_W1p4_L0p6_m24__nf1_gboth_sdfull_ng
Xpfet_01v8_lvt_W1p4_L0p6_m24__nf1_gboth_sdfull_ng_1 VDD_body VDD bias_b x2_foldp pfet_01v8_lvt_W1p4_L0p6_m24__nf1_gboth_sdfull_ng
.ends

.subckt nmos_matched_cascode_pair_11__AB cm x1_net14 VSS VSS_body
Xnfet_01v8_W1p4_L0p6_m1__nf1_gboth_sdfull_ng_0 VSS VSS_body VSS VSS nfet_01v8_W1p4_L0p6_m1__nf1_gboth_sdfull_ng
Xnfet_01v8_W1p4_L0p6_m1__nf1_gboth_sdfull_ng_1 x1_net15 VSS_body cm x1_net14 nfet_01v8_W1p4_L0p6_m1__nf1_gboth_sdfull_ng
Xnfet_01v8_W1p4_L0p6_m1__nf1_gboth_sdfull_ng_2 VSS VSS_body cm x1_net15 nfet_01v8_W1p4_L0p6_m1__nf1_gboth_sdfull_ng
Xnfet_01v8_W1p4_L0p6_m1__nf1_gboth_sdfull_ng_3 VSS VSS_body VSS VSS nfet_01v8_W1p4_L0p6_m1__nf1_gboth_sdfull_ng
.ends

.subckt nmos_current_mirror__ABBA VSS i_bias VSS_body bias_c
Xnfet_01v8_W1p4_L0p6_m18__nf1_gboth_sdfull_ng_30 i_bias VSS_body i_bias VSS nfet_01v8_W1p4_L0p6_m18__nf1_gboth_sdfull_ng
Xnfet_01v8_W1p4_L0p6_m18__nf1_gboth_sdfull_ng_31 i_bias VSS_body bias_c VSS nfet_01v8_W1p4_L0p6_m18__nf1_gboth_sdfull_ng
Xnfet_01v8_W1p4_L0p6_m18__nf1_gboth_sdfull_ng_20 i_bias VSS_body i_bias VSS nfet_01v8_W1p4_L0p6_m18__nf1_gboth_sdfull_ng
Xnfet_01v8_W1p4_L0p6_m18__nf1_gboth_sdfull_ng_0 VSS VSS_body VSS VSS nfet_01v8_W1p4_L0p6_m18__nf1_gboth_sdfull_ng
Xnfet_01v8_W1p4_L0p6_m18__nf1_gboth_sdfull_ng_33 i_bias VSS_body bias_c VSS nfet_01v8_W1p4_L0p6_m18__nf1_gboth_sdfull_ng
Xnfet_01v8_W1p4_L0p6_m18__nf1_gboth_sdfull_ng_32 i_bias VSS_body i_bias VSS nfet_01v8_W1p4_L0p6_m18__nf1_gboth_sdfull_ng
Xnfet_01v8_W1p4_L0p6_m18__nf1_gboth_sdfull_ng_22 i_bias VSS_body i_bias VSS nfet_01v8_W1p4_L0p6_m18__nf1_gboth_sdfull_ng
Xnfet_01v8_W1p4_L0p6_m18__nf1_gboth_sdfull_ng_21 i_bias VSS_body bias_c VSS nfet_01v8_W1p4_L0p6_m18__nf1_gboth_sdfull_ng
Xnfet_01v8_W1p4_L0p6_m18__nf1_gboth_sdfull_ng_11 i_bias VSS_body i_bias VSS nfet_01v8_W1p4_L0p6_m18__nf1_gboth_sdfull_ng
Xnfet_01v8_W1p4_L0p6_m18__nf1_gboth_sdfull_ng_10 i_bias VSS_body bias_c VSS nfet_01v8_W1p4_L0p6_m18__nf1_gboth_sdfull_ng
Xnfet_01v8_W1p4_L0p6_m18__nf1_gboth_sdfull_ng_2 i_bias VSS_body bias_c VSS nfet_01v8_W1p4_L0p6_m18__nf1_gboth_sdfull_ng
Xnfet_01v8_W1p4_L0p6_m18__nf1_gboth_sdfull_ng_1 i_bias VSS_body i_bias VSS nfet_01v8_W1p4_L0p6_m18__nf1_gboth_sdfull_ng
Xnfet_01v8_W1p4_L0p6_m18__nf1_gboth_sdfull_ng_34 i_bias VSS_body i_bias VSS nfet_01v8_W1p4_L0p6_m18__nf1_gboth_sdfull_ng
Xnfet_01v8_W1p4_L0p6_m18__nf1_gboth_sdfull_ng_23 i_bias VSS_body bias_c VSS nfet_01v8_W1p4_L0p6_m18__nf1_gboth_sdfull_ng
Xnfet_01v8_W1p4_L0p6_m18__nf1_gboth_sdfull_ng_12 i_bias VSS_body bias_c VSS nfet_01v8_W1p4_L0p6_m18__nf1_gboth_sdfull_ng
Xnfet_01v8_W1p4_L0p6_m18__nf1_gboth_sdfull_ng_3 i_bias VSS_body i_bias VSS nfet_01v8_W1p4_L0p6_m18__nf1_gboth_sdfull_ng
Xnfet_01v8_W1p4_L0p6_m18__nf1_gboth_sdfull_ng_35 i_bias VSS_body bias_c VSS nfet_01v8_W1p4_L0p6_m18__nf1_gboth_sdfull_ng
Xnfet_01v8_W1p4_L0p6_m18__nf1_gboth_sdfull_ng_24 i_bias VSS_body i_bias VSS nfet_01v8_W1p4_L0p6_m18__nf1_gboth_sdfull_ng
Xnfet_01v8_W1p4_L0p6_m18__nf1_gboth_sdfull_ng_13 i_bias VSS_body i_bias VSS nfet_01v8_W1p4_L0p6_m18__nf1_gboth_sdfull_ng
Xnfet_01v8_W1p4_L0p6_m18__nf1_gboth_sdfull_ng_4 i_bias VSS_body bias_c VSS nfet_01v8_W1p4_L0p6_m18__nf1_gboth_sdfull_ng
Xnfet_01v8_W1p4_L0p6_m18__nf1_gboth_sdfull_ng_36 i_bias VSS_body i_bias VSS nfet_01v8_W1p4_L0p6_m18__nf1_gboth_sdfull_ng
Xnfet_01v8_W1p4_L0p6_m18__nf1_gboth_sdfull_ng_25 i_bias VSS_body bias_c VSS nfet_01v8_W1p4_L0p6_m18__nf1_gboth_sdfull_ng
Xnfet_01v8_W1p4_L0p6_m18__nf1_gboth_sdfull_ng_14 i_bias VSS_body bias_c VSS nfet_01v8_W1p4_L0p6_m18__nf1_gboth_sdfull_ng
Xnfet_01v8_W1p4_L0p6_m18__nf1_gboth_sdfull_ng_5 i_bias VSS_body i_bias VSS nfet_01v8_W1p4_L0p6_m18__nf1_gboth_sdfull_ng
Xnfet_01v8_W1p4_L0p6_m18__nf1_gboth_sdfull_ng_37 VSS VSS_body VSS VSS nfet_01v8_W1p4_L0p6_m18__nf1_gboth_sdfull_ng
Xnfet_01v8_W1p4_L0p6_m18__nf1_gboth_sdfull_ng_26 i_bias VSS_body i_bias VSS nfet_01v8_W1p4_L0p6_m18__nf1_gboth_sdfull_ng
Xnfet_01v8_W1p4_L0p6_m18__nf1_gboth_sdfull_ng_15 i_bias VSS_body i_bias VSS nfet_01v8_W1p4_L0p6_m18__nf1_gboth_sdfull_ng
Xnfet_01v8_W1p4_L0p6_m18__nf1_gboth_sdfull_ng_6 i_bias VSS_body bias_c VSS nfet_01v8_W1p4_L0p6_m18__nf1_gboth_sdfull_ng
Xnfet_01v8_W1p4_L0p6_m18__nf1_gboth_sdfull_ng_27 i_bias VSS_body bias_c VSS nfet_01v8_W1p4_L0p6_m18__nf1_gboth_sdfull_ng
Xnfet_01v8_W1p4_L0p6_m18__nf1_gboth_sdfull_ng_16 i_bias VSS_body bias_c VSS nfet_01v8_W1p4_L0p6_m18__nf1_gboth_sdfull_ng
Xnfet_01v8_W1p4_L0p6_m18__nf1_gboth_sdfull_ng_7 i_bias VSS_body i_bias VSS nfet_01v8_W1p4_L0p6_m18__nf1_gboth_sdfull_ng
Xnfet_01v8_W1p4_L0p6_m18__nf1_gboth_sdfull_ng_28 i_bias VSS_body i_bias VSS nfet_01v8_W1p4_L0p6_m18__nf1_gboth_sdfull_ng
Xnfet_01v8_W1p4_L0p6_m18__nf1_gboth_sdfull_ng_17 i_bias VSS_body i_bias VSS nfet_01v8_W1p4_L0p6_m18__nf1_gboth_sdfull_ng
Xnfet_01v8_W1p4_L0p6_m18__nf1_gboth_sdfull_ng_8 i_bias VSS_body bias_c VSS nfet_01v8_W1p4_L0p6_m18__nf1_gboth_sdfull_ng
Xnfet_01v8_W1p4_L0p6_m18__nf1_gboth_sdfull_ng_29 i_bias VSS_body bias_c VSS nfet_01v8_W1p4_L0p6_m18__nf1_gboth_sdfull_ng
Xnfet_01v8_W1p4_L0p6_m18__nf1_gboth_sdfull_ng_19 i_bias VSS_body bias_c VSS nfet_01v8_W1p4_L0p6_m18__nf1_gboth_sdfull_ng
Xnfet_01v8_W1p4_L0p6_m18__nf1_gboth_sdfull_ng_18 i_bias VSS_body bias_c VSS nfet_01v8_W1p4_L0p6_m18__nf1_gboth_sdfull_ng
Xnfet_01v8_W1p4_L0p6_m18__nf1_gboth_sdfull_ng_9 i_bias VSS_body i_bias VSS nfet_01v8_W1p4_L0p6_m18__nf1_gboth_sdfull_ng
.ends

.subckt pfet_01v8_W1p4_L0p6_m20__nf1_gboth_sdfull_ng B G D S
Xpfet_01v8_W1p4_L0p6_m20__nf1_gboth_sdfull_ng_pc G D B S sky130_fd_pr__pfet_01v8_RGDEC8
.ends

.subckt pmos_matched_cascode_pair_2__ABAB on x2_foldp VDD_body VDD op bias_c x2_foldn
Xpfet_01v8_W1p4_L0p6_m20__nf1_gboth_sdfull_ng_40 VDD_body bias_c op x2_foldn pfet_01v8_W1p4_L0p6_m20__nf1_gboth_sdfull_ng
Xpfet_01v8_W1p4_L0p6_m20__nf1_gboth_sdfull_ng_30 VDD_body bias_c op x2_foldn pfet_01v8_W1p4_L0p6_m20__nf1_gboth_sdfull_ng
Xpfet_01v8_W1p4_L0p6_m20__nf1_gboth_sdfull_ng_41 VDD_body VDD VDD VDD pfet_01v8_W1p4_L0p6_m20__nf1_gboth_sdfull_ng
Xpfet_01v8_W1p4_L0p6_m20__nf1_gboth_sdfull_ng_20 VDD_body bias_c op x2_foldn pfet_01v8_W1p4_L0p6_m20__nf1_gboth_sdfull_ng
Xpfet_01v8_W1p4_L0p6_m20__nf1_gboth_sdfull_ng_31 VDD_body bias_c on x2_foldp pfet_01v8_W1p4_L0p6_m20__nf1_gboth_sdfull_ng
Xpfet_01v8_W1p4_L0p6_m20__nf1_gboth_sdfull_ng_10 VDD_body bias_c op x2_foldn pfet_01v8_W1p4_L0p6_m20__nf1_gboth_sdfull_ng
Xpfet_01v8_W1p4_L0p6_m20__nf1_gboth_sdfull_ng_21 VDD_body bias_c on x2_foldp pfet_01v8_W1p4_L0p6_m20__nf1_gboth_sdfull_ng
Xpfet_01v8_W1p4_L0p6_m20__nf1_gboth_sdfull_ng_32 VDD_body bias_c op x2_foldn pfet_01v8_W1p4_L0p6_m20__nf1_gboth_sdfull_ng
Xpfet_01v8_W1p4_L0p6_m20__nf1_gboth_sdfull_ng_11 VDD_body bias_c on x2_foldp pfet_01v8_W1p4_L0p6_m20__nf1_gboth_sdfull_ng
Xpfet_01v8_W1p4_L0p6_m20__nf1_gboth_sdfull_ng_22 VDD_body bias_c op x2_foldn pfet_01v8_W1p4_L0p6_m20__nf1_gboth_sdfull_ng
Xpfet_01v8_W1p4_L0p6_m20__nf1_gboth_sdfull_ng_33 VDD_body bias_c on x2_foldp pfet_01v8_W1p4_L0p6_m20__nf1_gboth_sdfull_ng
Xpfet_01v8_W1p4_L0p6_m20__nf1_gboth_sdfull_ng_12 VDD_body bias_c op x2_foldn pfet_01v8_W1p4_L0p6_m20__nf1_gboth_sdfull_ng
Xpfet_01v8_W1p4_L0p6_m20__nf1_gboth_sdfull_ng_23 VDD_body bias_c on x2_foldp pfet_01v8_W1p4_L0p6_m20__nf1_gboth_sdfull_ng
Xpfet_01v8_W1p4_L0p6_m20__nf1_gboth_sdfull_ng_34 VDD_body bias_c op x2_foldn pfet_01v8_W1p4_L0p6_m20__nf1_gboth_sdfull_ng
Xpfet_01v8_W1p4_L0p6_m20__nf1_gboth_sdfull_ng_13 VDD_body bias_c on x2_foldp pfet_01v8_W1p4_L0p6_m20__nf1_gboth_sdfull_ng
Xpfet_01v8_W1p4_L0p6_m20__nf1_gboth_sdfull_ng_24 VDD_body bias_c op x2_foldn pfet_01v8_W1p4_L0p6_m20__nf1_gboth_sdfull_ng
Xpfet_01v8_W1p4_L0p6_m20__nf1_gboth_sdfull_ng_35 VDD_body bias_c on x2_foldp pfet_01v8_W1p4_L0p6_m20__nf1_gboth_sdfull_ng
Xpfet_01v8_W1p4_L0p6_m20__nf1_gboth_sdfull_ng_14 VDD_body bias_c op x2_foldn pfet_01v8_W1p4_L0p6_m20__nf1_gboth_sdfull_ng
Xpfet_01v8_W1p4_L0p6_m20__nf1_gboth_sdfull_ng_25 VDD_body bias_c on x2_foldp pfet_01v8_W1p4_L0p6_m20__nf1_gboth_sdfull_ng
Xpfet_01v8_W1p4_L0p6_m20__nf1_gboth_sdfull_ng_36 VDD_body bias_c op x2_foldn pfet_01v8_W1p4_L0p6_m20__nf1_gboth_sdfull_ng
Xpfet_01v8_W1p4_L0p6_m20__nf1_gboth_sdfull_ng_15 VDD_body bias_c on x2_foldp pfet_01v8_W1p4_L0p6_m20__nf1_gboth_sdfull_ng
Xpfet_01v8_W1p4_L0p6_m20__nf1_gboth_sdfull_ng_16 VDD_body bias_c op x2_foldn pfet_01v8_W1p4_L0p6_m20__nf1_gboth_sdfull_ng
Xpfet_01v8_W1p4_L0p6_m20__nf1_gboth_sdfull_ng_26 VDD_body bias_c op x2_foldn pfet_01v8_W1p4_L0p6_m20__nf1_gboth_sdfull_ng
Xpfet_01v8_W1p4_L0p6_m20__nf1_gboth_sdfull_ng_27 VDD_body bias_c on x2_foldp pfet_01v8_W1p4_L0p6_m20__nf1_gboth_sdfull_ng
Xpfet_01v8_W1p4_L0p6_m20__nf1_gboth_sdfull_ng_37 VDD_body bias_c on x2_foldp pfet_01v8_W1p4_L0p6_m20__nf1_gboth_sdfull_ng
Xpfet_01v8_W1p4_L0p6_m20__nf1_gboth_sdfull_ng_38 VDD_body bias_c op x2_foldn pfet_01v8_W1p4_L0p6_m20__nf1_gboth_sdfull_ng
Xpfet_01v8_W1p4_L0p6_m20__nf1_gboth_sdfull_ng_17 VDD_body bias_c on x2_foldp pfet_01v8_W1p4_L0p6_m20__nf1_gboth_sdfull_ng
Xpfet_01v8_W1p4_L0p6_m20__nf1_gboth_sdfull_ng_28 VDD_body bias_c op x2_foldn pfet_01v8_W1p4_L0p6_m20__nf1_gboth_sdfull_ng
Xpfet_01v8_W1p4_L0p6_m20__nf1_gboth_sdfull_ng_39 VDD_body bias_c on x2_foldp pfet_01v8_W1p4_L0p6_m20__nf1_gboth_sdfull_ng
Xpfet_01v8_W1p4_L0p6_m20__nf1_gboth_sdfull_ng_18 VDD_body bias_c op x2_foldn pfet_01v8_W1p4_L0p6_m20__nf1_gboth_sdfull_ng
Xpfet_01v8_W1p4_L0p6_m20__nf1_gboth_sdfull_ng_29 VDD_body bias_c on x2_foldp pfet_01v8_W1p4_L0p6_m20__nf1_gboth_sdfull_ng
Xpfet_01v8_W1p4_L0p6_m20__nf1_gboth_sdfull_ng_19 VDD_body bias_c on x2_foldp pfet_01v8_W1p4_L0p6_m20__nf1_gboth_sdfull_ng
Xpfet_01v8_W1p4_L0p6_m20__nf1_gboth_sdfull_ng_0 VDD_body VDD VDD VDD pfet_01v8_W1p4_L0p6_m20__nf1_gboth_sdfull_ng
Xpfet_01v8_W1p4_L0p6_m20__nf1_gboth_sdfull_ng_1 VDD_body bias_c on x2_foldp pfet_01v8_W1p4_L0p6_m20__nf1_gboth_sdfull_ng
Xpfet_01v8_W1p4_L0p6_m20__nf1_gboth_sdfull_ng_2 VDD_body bias_c op x2_foldn pfet_01v8_W1p4_L0p6_m20__nf1_gboth_sdfull_ng
Xpfet_01v8_W1p4_L0p6_m20__nf1_gboth_sdfull_ng_3 VDD_body bias_c on x2_foldp pfet_01v8_W1p4_L0p6_m20__nf1_gboth_sdfull_ng
Xpfet_01v8_W1p4_L0p6_m20__nf1_gboth_sdfull_ng_4 VDD_body bias_c op x2_foldn pfet_01v8_W1p4_L0p6_m20__nf1_gboth_sdfull_ng
Xpfet_01v8_W1p4_L0p6_m20__nf1_gboth_sdfull_ng_5 VDD_body bias_c on x2_foldp pfet_01v8_W1p4_L0p6_m20__nf1_gboth_sdfull_ng
Xpfet_01v8_W1p4_L0p6_m20__nf1_gboth_sdfull_ng_6 VDD_body bias_c op x2_foldn pfet_01v8_W1p4_L0p6_m20__nf1_gboth_sdfull_ng
Xpfet_01v8_W1p4_L0p6_m20__nf1_gboth_sdfull_ng_7 VDD_body bias_c on x2_foldp pfet_01v8_W1p4_L0p6_m20__nf1_gboth_sdfull_ng
Xpfet_01v8_W1p4_L0p6_m20__nf1_gboth_sdfull_ng_8 VDD_body bias_c op x2_foldn pfet_01v8_W1p4_L0p6_m20__nf1_gboth_sdfull_ng
Xpfet_01v8_W1p4_L0p6_m20__nf1_gboth_sdfull_ng_9 VDD_body bias_c on x2_foldp pfet_01v8_W1p4_L0p6_m20__nf1_gboth_sdfull_ng
.ends

.subckt nmos_dummy_15__A VSS x2_tail VSS_body
Xnfet_01v8_W1p4_L0p6_m2__nf1_gboth_sdfull_ng_0 VSS_body VSS VSS x2_tail nfet_01v8_W1p4_L0p6_m2__nf1_gboth_sdfull_ng
Xnfet_01v8_W1p4_L0p6_m2__nf1_gboth_sdfull_ng_1 VSS_body VSS VSS x2_tail nfet_01v8_W1p4_L0p6_m2__nf1_gboth_sdfull_ng
.ends

.subckt nmos_matched_cascode_pair_10__AB cm VSS VSS_body x1_net14
Xnfet_01v8_W1p4_L0p6_m1__nf1_gboth_sdfull_ng_0 VSS VSS_body VSS VSS nfet_01v8_W1p4_L0p6_m1__nf1_gboth_sdfull_ng
Xnfet_01v8_W1p4_L0p6_m1__nf1_gboth_sdfull_ng_1 x1_net13 VSS_body cm cm nfet_01v8_W1p4_L0p6_m1__nf1_gboth_sdfull_ng
Xnfet_01v8_W1p4_L0p6_m1__nf1_gboth_sdfull_ng_2 x1_net14 VSS_body cm x1_net13 nfet_01v8_W1p4_L0p6_m1__nf1_gboth_sdfull_ng
Xnfet_01v8_W1p4_L0p6_m1__nf1_gboth_sdfull_ng_3 VSS VSS_body VSS VSS nfet_01v8_W1p4_L0p6_m1__nf1_gboth_sdfull_ng
.ends

.subckt nmos_single_2__A x1_m5d VSS_body bias_d bias_a
Xnfet_01v8_W1p4_L0p6_m18__nf1_gboth_sdfull_ng_0 bias_d VSS_body bias_a x1_m5d nfet_01v8_W1p4_L0p6_m18__nf1_gboth_sdfull_ng
Xnfet_01v8_W1p4_L0p6_m18__nf1_gboth_sdfull_ng_11 bias_d VSS_body bias_a x1_m5d nfet_01v8_W1p4_L0p6_m18__nf1_gboth_sdfull_ng
Xnfet_01v8_W1p4_L0p6_m18__nf1_gboth_sdfull_ng_10 bias_d VSS_body bias_a x1_m5d nfet_01v8_W1p4_L0p6_m18__nf1_gboth_sdfull_ng
Xnfet_01v8_W1p4_L0p6_m18__nf1_gboth_sdfull_ng_2 bias_d VSS_body bias_a x1_m5d nfet_01v8_W1p4_L0p6_m18__nf1_gboth_sdfull_ng
Xnfet_01v8_W1p4_L0p6_m18__nf1_gboth_sdfull_ng_1 bias_d VSS_body bias_a x1_m5d nfet_01v8_W1p4_L0p6_m18__nf1_gboth_sdfull_ng
Xnfet_01v8_W1p4_L0p6_m18__nf1_gboth_sdfull_ng_12 bias_d VSS_body bias_a x1_m5d nfet_01v8_W1p4_L0p6_m18__nf1_gboth_sdfull_ng
Xnfet_01v8_W1p4_L0p6_m18__nf1_gboth_sdfull_ng_3 bias_d VSS_body bias_a x1_m5d nfet_01v8_W1p4_L0p6_m18__nf1_gboth_sdfull_ng
Xnfet_01v8_W1p4_L0p6_m18__nf1_gboth_sdfull_ng_13 bias_d VSS_body bias_a x1_m5d nfet_01v8_W1p4_L0p6_m18__nf1_gboth_sdfull_ng
Xnfet_01v8_W1p4_L0p6_m18__nf1_gboth_sdfull_ng_4 bias_d VSS_body bias_a x1_m5d nfet_01v8_W1p4_L0p6_m18__nf1_gboth_sdfull_ng
Xnfet_01v8_W1p4_L0p6_m18__nf1_gboth_sdfull_ng_14 bias_d VSS_body bias_a x1_m5d nfet_01v8_W1p4_L0p6_m18__nf1_gboth_sdfull_ng
Xnfet_01v8_W1p4_L0p6_m18__nf1_gboth_sdfull_ng_5 bias_d VSS_body bias_a x1_m5d nfet_01v8_W1p4_L0p6_m18__nf1_gboth_sdfull_ng
Xnfet_01v8_W1p4_L0p6_m18__nf1_gboth_sdfull_ng_15 bias_d VSS_body bias_a x1_m5d nfet_01v8_W1p4_L0p6_m18__nf1_gboth_sdfull_ng
Xnfet_01v8_W1p4_L0p6_m18__nf1_gboth_sdfull_ng_6 bias_d VSS_body bias_a x1_m5d nfet_01v8_W1p4_L0p6_m18__nf1_gboth_sdfull_ng
Xnfet_01v8_W1p4_L0p6_m18__nf1_gboth_sdfull_ng_16 bias_d VSS_body bias_a x1_m5d nfet_01v8_W1p4_L0p6_m18__nf1_gboth_sdfull_ng
Xnfet_01v8_W1p4_L0p6_m18__nf1_gboth_sdfull_ng_7 bias_d VSS_body bias_a x1_m5d nfet_01v8_W1p4_L0p6_m18__nf1_gboth_sdfull_ng
Xnfet_01v8_W1p4_L0p6_m18__nf1_gboth_sdfull_ng_17 bias_d VSS_body bias_a x1_m5d nfet_01v8_W1p4_L0p6_m18__nf1_gboth_sdfull_ng
Xnfet_01v8_W1p4_L0p6_m18__nf1_gboth_sdfull_ng_8 bias_d VSS_body bias_a x1_m5d nfet_01v8_W1p4_L0p6_m18__nf1_gboth_sdfull_ng
Xnfet_01v8_W1p4_L0p6_m18__nf1_gboth_sdfull_ng_9 bias_d VSS_body bias_a x1_m5d nfet_01v8_W1p4_L0p6_m18__nf1_gboth_sdfull_ng
.ends

.subckt pmos_dummy_11__A VDD_body VDD x1_m31d
Xpfet_01v8_W1p4_L0p6_m2__nf1_gtop_sdfull_ng_0 VDD_body VDD VDD x1_m31d pfet_01v8_W1p4_L0p6_m2__nf1_gtop_sdfull_ng
Xpfet_01v8_W1p4_L0p6_m2__nf1_gtop_sdfull_ng_1 VDD_body VDD VDD x1_m31d pfet_01v8_W1p4_L0p6_m2__nf1_gtop_sdfull_ng
.ends

.subckt nmos_matched_cascode_pair_9__AB VSS cm x1_net11 VSS_body
Xnfet_01v8_W1p4_L0p6_m1__nf1_gboth_sdfull_ng_0 VSS VSS_body VSS VSS nfet_01v8_W1p4_L0p6_m1__nf1_gboth_sdfull_ng
Xnfet_01v8_W1p4_L0p6_m1__nf1_gboth_sdfull_ng_1 x1_net12 VSS_body cm x1_net11 nfet_01v8_W1p4_L0p6_m1__nf1_gboth_sdfull_ng
Xnfet_01v8_W1p4_L0p6_m1__nf1_gboth_sdfull_ng_2 VSS VSS_body cm x1_net12 nfet_01v8_W1p4_L0p6_m1__nf1_gboth_sdfull_ng
Xnfet_01v8_W1p4_L0p6_m1__nf1_gboth_sdfull_ng_3 VSS VSS_body VSS VSS nfet_01v8_W1p4_L0p6_m1__nf1_gboth_sdfull_ng
.ends

.subckt nmos_dummy_18__A VSS x2_m4d VSS_body
Xnfet_01v8_W1p4_L0p6_m6__nf1_gtop_sdfull_ng_0 VSS_body VSS x2_m4d VSS nfet_01v8_W1p4_L0p6_m6__nf1_gtop_sdfull_ng
Xnfet_01v8_W1p4_L0p6_m6__nf1_gtop_sdfull_ng_1 VSS_body VSS x2_m4d VSS nfet_01v8_W1p4_L0p6_m6__nf1_gtop_sdfull_ng
Xnfet_01v8_W1p4_L0p6_m6__nf1_gtop_sdfull_ng_2 VSS_body VSS x2_m4d VSS nfet_01v8_W1p4_L0p6_m6__nf1_gtop_sdfull_ng
Xnfet_01v8_W1p4_L0p6_m6__nf1_gtop_sdfull_ng_3 VSS_body VSS x2_m4d VSS nfet_01v8_W1p4_L0p6_m6__nf1_gtop_sdfull_ng
Xnfet_01v8_W1p4_L0p6_m6__nf1_gtop_sdfull_ng_4 VSS_body VSS x2_m4d VSS nfet_01v8_W1p4_L0p6_m6__nf1_gtop_sdfull_ng
Xnfet_01v8_W1p4_L0p6_m6__nf1_gtop_sdfull_ng_5 VSS_body VSS x2_m4d VSS nfet_01v8_W1p4_L0p6_m6__nf1_gtop_sdfull_ng
.ends

.subckt nmos_single_5__A cmc VSS VSS_body x2_tail
Xnfet_01v8_W1p4_L0p6_m96__nf1_gboth_sdfull_ng_0 x2_tail VSS_body VSS cmc nfet_01v8_W1p4_L0p6_m96__nf1_gboth_sdfull_ng
Xnfet_01v8_W1p4_L0p6_m96__nf1_gboth_sdfull_ng_1 x2_tail VSS_body VSS cmc nfet_01v8_W1p4_L0p6_m96__nf1_gboth_sdfull_ng
Xnfet_01v8_W1p4_L0p6_m96__nf1_gboth_sdfull_ng_80 x2_tail VSS_body VSS cmc nfet_01v8_W1p4_L0p6_m96__nf1_gboth_sdfull_ng
Xnfet_01v8_W1p4_L0p6_m96__nf1_gboth_sdfull_ng_91 x2_tail VSS_body VSS cmc nfet_01v8_W1p4_L0p6_m96__nf1_gboth_sdfull_ng
Xnfet_01v8_W1p4_L0p6_m96__nf1_gboth_sdfull_ng_2 x2_tail VSS_body VSS cmc nfet_01v8_W1p4_L0p6_m96__nf1_gboth_sdfull_ng
Xnfet_01v8_W1p4_L0p6_m96__nf1_gboth_sdfull_ng_70 x2_tail VSS_body VSS cmc nfet_01v8_W1p4_L0p6_m96__nf1_gboth_sdfull_ng
Xnfet_01v8_W1p4_L0p6_m96__nf1_gboth_sdfull_ng_81 x2_tail VSS_body VSS cmc nfet_01v8_W1p4_L0p6_m96__nf1_gboth_sdfull_ng
Xnfet_01v8_W1p4_L0p6_m96__nf1_gboth_sdfull_ng_92 x2_tail VSS_body VSS cmc nfet_01v8_W1p4_L0p6_m96__nf1_gboth_sdfull_ng
Xnfet_01v8_W1p4_L0p6_m96__nf1_gboth_sdfull_ng_3 x2_tail VSS_body VSS cmc nfet_01v8_W1p4_L0p6_m96__nf1_gboth_sdfull_ng
Xnfet_01v8_W1p4_L0p6_m96__nf1_gboth_sdfull_ng_50 x2_tail VSS_body VSS cmc nfet_01v8_W1p4_L0p6_m96__nf1_gboth_sdfull_ng
Xnfet_01v8_W1p4_L0p6_m96__nf1_gboth_sdfull_ng_60 x2_tail VSS_body VSS cmc nfet_01v8_W1p4_L0p6_m96__nf1_gboth_sdfull_ng
Xnfet_01v8_W1p4_L0p6_m96__nf1_gboth_sdfull_ng_61 x2_tail VSS_body VSS cmc nfet_01v8_W1p4_L0p6_m96__nf1_gboth_sdfull_ng
Xnfet_01v8_W1p4_L0p6_m96__nf1_gboth_sdfull_ng_71 x2_tail VSS_body VSS cmc nfet_01v8_W1p4_L0p6_m96__nf1_gboth_sdfull_ng
Xnfet_01v8_W1p4_L0p6_m96__nf1_gboth_sdfull_ng_72 x2_tail VSS_body VSS cmc nfet_01v8_W1p4_L0p6_m96__nf1_gboth_sdfull_ng
Xnfet_01v8_W1p4_L0p6_m96__nf1_gboth_sdfull_ng_82 x2_tail VSS_body VSS cmc nfet_01v8_W1p4_L0p6_m96__nf1_gboth_sdfull_ng
Xnfet_01v8_W1p4_L0p6_m96__nf1_gboth_sdfull_ng_83 x2_tail VSS_body VSS cmc nfet_01v8_W1p4_L0p6_m96__nf1_gboth_sdfull_ng
Xnfet_01v8_W1p4_L0p6_m96__nf1_gboth_sdfull_ng_93 x2_tail VSS_body VSS cmc nfet_01v8_W1p4_L0p6_m96__nf1_gboth_sdfull_ng
Xnfet_01v8_W1p4_L0p6_m96__nf1_gboth_sdfull_ng_94 x2_tail VSS_body VSS cmc nfet_01v8_W1p4_L0p6_m96__nf1_gboth_sdfull_ng
Xnfet_01v8_W1p4_L0p6_m96__nf1_gboth_sdfull_ng_4 x2_tail VSS_body VSS cmc nfet_01v8_W1p4_L0p6_m96__nf1_gboth_sdfull_ng
Xnfet_01v8_W1p4_L0p6_m96__nf1_gboth_sdfull_ng_40 x2_tail VSS_body VSS cmc nfet_01v8_W1p4_L0p6_m96__nf1_gboth_sdfull_ng
Xnfet_01v8_W1p4_L0p6_m96__nf1_gboth_sdfull_ng_51 x2_tail VSS_body VSS cmc nfet_01v8_W1p4_L0p6_m96__nf1_gboth_sdfull_ng
Xnfet_01v8_W1p4_L0p6_m96__nf1_gboth_sdfull_ng_62 x2_tail VSS_body VSS cmc nfet_01v8_W1p4_L0p6_m96__nf1_gboth_sdfull_ng
Xnfet_01v8_W1p4_L0p6_m96__nf1_gboth_sdfull_ng_73 x2_tail VSS_body VSS cmc nfet_01v8_W1p4_L0p6_m96__nf1_gboth_sdfull_ng
Xnfet_01v8_W1p4_L0p6_m96__nf1_gboth_sdfull_ng_84 x2_tail VSS_body VSS cmc nfet_01v8_W1p4_L0p6_m96__nf1_gboth_sdfull_ng
Xnfet_01v8_W1p4_L0p6_m96__nf1_gboth_sdfull_ng_95 x2_tail VSS_body VSS cmc nfet_01v8_W1p4_L0p6_m96__nf1_gboth_sdfull_ng
Xnfet_01v8_W1p4_L0p6_m96__nf1_gboth_sdfull_ng_5 x2_tail VSS_body VSS cmc nfet_01v8_W1p4_L0p6_m96__nf1_gboth_sdfull_ng
Xnfet_01v8_W1p4_L0p6_m96__nf1_gboth_sdfull_ng_30 x2_tail VSS_body VSS cmc nfet_01v8_W1p4_L0p6_m96__nf1_gboth_sdfull_ng
Xnfet_01v8_W1p4_L0p6_m96__nf1_gboth_sdfull_ng_41 x2_tail VSS_body VSS cmc nfet_01v8_W1p4_L0p6_m96__nf1_gboth_sdfull_ng
Xnfet_01v8_W1p4_L0p6_m96__nf1_gboth_sdfull_ng_52 x2_tail VSS_body VSS cmc nfet_01v8_W1p4_L0p6_m96__nf1_gboth_sdfull_ng
Xnfet_01v8_W1p4_L0p6_m96__nf1_gboth_sdfull_ng_63 x2_tail VSS_body VSS cmc nfet_01v8_W1p4_L0p6_m96__nf1_gboth_sdfull_ng
Xnfet_01v8_W1p4_L0p6_m96__nf1_gboth_sdfull_ng_74 x2_tail VSS_body VSS cmc nfet_01v8_W1p4_L0p6_m96__nf1_gboth_sdfull_ng
Xnfet_01v8_W1p4_L0p6_m96__nf1_gboth_sdfull_ng_85 x2_tail VSS_body VSS cmc nfet_01v8_W1p4_L0p6_m96__nf1_gboth_sdfull_ng
Xnfet_01v8_W1p4_L0p6_m96__nf1_gboth_sdfull_ng_6 x2_tail VSS_body VSS cmc nfet_01v8_W1p4_L0p6_m96__nf1_gboth_sdfull_ng
Xnfet_01v8_W1p4_L0p6_m96__nf1_gboth_sdfull_ng_20 x2_tail VSS_body VSS cmc nfet_01v8_W1p4_L0p6_m96__nf1_gboth_sdfull_ng
Xnfet_01v8_W1p4_L0p6_m96__nf1_gboth_sdfull_ng_31 x2_tail VSS_body VSS cmc nfet_01v8_W1p4_L0p6_m96__nf1_gboth_sdfull_ng
Xnfet_01v8_W1p4_L0p6_m96__nf1_gboth_sdfull_ng_42 x2_tail VSS_body VSS cmc nfet_01v8_W1p4_L0p6_m96__nf1_gboth_sdfull_ng
Xnfet_01v8_W1p4_L0p6_m96__nf1_gboth_sdfull_ng_53 x2_tail VSS_body VSS cmc nfet_01v8_W1p4_L0p6_m96__nf1_gboth_sdfull_ng
Xnfet_01v8_W1p4_L0p6_m96__nf1_gboth_sdfull_ng_64 x2_tail VSS_body VSS cmc nfet_01v8_W1p4_L0p6_m96__nf1_gboth_sdfull_ng
Xnfet_01v8_W1p4_L0p6_m96__nf1_gboth_sdfull_ng_75 x2_tail VSS_body VSS cmc nfet_01v8_W1p4_L0p6_m96__nf1_gboth_sdfull_ng
Xnfet_01v8_W1p4_L0p6_m96__nf1_gboth_sdfull_ng_86 x2_tail VSS_body VSS cmc nfet_01v8_W1p4_L0p6_m96__nf1_gboth_sdfull_ng
Xnfet_01v8_W1p4_L0p6_m96__nf1_gboth_sdfull_ng_7 x2_tail VSS_body VSS cmc nfet_01v8_W1p4_L0p6_m96__nf1_gboth_sdfull_ng
Xnfet_01v8_W1p4_L0p6_m96__nf1_gboth_sdfull_ng_10 x2_tail VSS_body VSS cmc nfet_01v8_W1p4_L0p6_m96__nf1_gboth_sdfull_ng
Xnfet_01v8_W1p4_L0p6_m96__nf1_gboth_sdfull_ng_21 x2_tail VSS_body VSS cmc nfet_01v8_W1p4_L0p6_m96__nf1_gboth_sdfull_ng
Xnfet_01v8_W1p4_L0p6_m96__nf1_gboth_sdfull_ng_32 x2_tail VSS_body VSS cmc nfet_01v8_W1p4_L0p6_m96__nf1_gboth_sdfull_ng
Xnfet_01v8_W1p4_L0p6_m96__nf1_gboth_sdfull_ng_43 x2_tail VSS_body VSS cmc nfet_01v8_W1p4_L0p6_m96__nf1_gboth_sdfull_ng
Xnfet_01v8_W1p4_L0p6_m96__nf1_gboth_sdfull_ng_54 x2_tail VSS_body VSS cmc nfet_01v8_W1p4_L0p6_m96__nf1_gboth_sdfull_ng
Xnfet_01v8_W1p4_L0p6_m96__nf1_gboth_sdfull_ng_65 x2_tail VSS_body VSS cmc nfet_01v8_W1p4_L0p6_m96__nf1_gboth_sdfull_ng
Xnfet_01v8_W1p4_L0p6_m96__nf1_gboth_sdfull_ng_76 x2_tail VSS_body VSS cmc nfet_01v8_W1p4_L0p6_m96__nf1_gboth_sdfull_ng
Xnfet_01v8_W1p4_L0p6_m96__nf1_gboth_sdfull_ng_87 x2_tail VSS_body VSS cmc nfet_01v8_W1p4_L0p6_m96__nf1_gboth_sdfull_ng
Xnfet_01v8_W1p4_L0p6_m96__nf1_gboth_sdfull_ng_8 x2_tail VSS_body VSS cmc nfet_01v8_W1p4_L0p6_m96__nf1_gboth_sdfull_ng
Xnfet_01v8_W1p4_L0p6_m96__nf1_gboth_sdfull_ng_11 x2_tail VSS_body VSS cmc nfet_01v8_W1p4_L0p6_m96__nf1_gboth_sdfull_ng
Xnfet_01v8_W1p4_L0p6_m96__nf1_gboth_sdfull_ng_22 x2_tail VSS_body VSS cmc nfet_01v8_W1p4_L0p6_m96__nf1_gboth_sdfull_ng
Xnfet_01v8_W1p4_L0p6_m96__nf1_gboth_sdfull_ng_33 x2_tail VSS_body VSS cmc nfet_01v8_W1p4_L0p6_m96__nf1_gboth_sdfull_ng
Xnfet_01v8_W1p4_L0p6_m96__nf1_gboth_sdfull_ng_44 x2_tail VSS_body VSS cmc nfet_01v8_W1p4_L0p6_m96__nf1_gboth_sdfull_ng
Xnfet_01v8_W1p4_L0p6_m96__nf1_gboth_sdfull_ng_55 x2_tail VSS_body VSS cmc nfet_01v8_W1p4_L0p6_m96__nf1_gboth_sdfull_ng
Xnfet_01v8_W1p4_L0p6_m96__nf1_gboth_sdfull_ng_66 x2_tail VSS_body VSS cmc nfet_01v8_W1p4_L0p6_m96__nf1_gboth_sdfull_ng
Xnfet_01v8_W1p4_L0p6_m96__nf1_gboth_sdfull_ng_77 x2_tail VSS_body VSS cmc nfet_01v8_W1p4_L0p6_m96__nf1_gboth_sdfull_ng
Xnfet_01v8_W1p4_L0p6_m96__nf1_gboth_sdfull_ng_88 x2_tail VSS_body VSS cmc nfet_01v8_W1p4_L0p6_m96__nf1_gboth_sdfull_ng
Xnfet_01v8_W1p4_L0p6_m96__nf1_gboth_sdfull_ng_9 x2_tail VSS_body VSS cmc nfet_01v8_W1p4_L0p6_m96__nf1_gboth_sdfull_ng
Xnfet_01v8_W1p4_L0p6_m96__nf1_gboth_sdfull_ng_12 x2_tail VSS_body VSS cmc nfet_01v8_W1p4_L0p6_m96__nf1_gboth_sdfull_ng
Xnfet_01v8_W1p4_L0p6_m96__nf1_gboth_sdfull_ng_23 x2_tail VSS_body VSS cmc nfet_01v8_W1p4_L0p6_m96__nf1_gboth_sdfull_ng
Xnfet_01v8_W1p4_L0p6_m96__nf1_gboth_sdfull_ng_34 x2_tail VSS_body VSS cmc nfet_01v8_W1p4_L0p6_m96__nf1_gboth_sdfull_ng
Xnfet_01v8_W1p4_L0p6_m96__nf1_gboth_sdfull_ng_45 x2_tail VSS_body VSS cmc nfet_01v8_W1p4_L0p6_m96__nf1_gboth_sdfull_ng
Xnfet_01v8_W1p4_L0p6_m96__nf1_gboth_sdfull_ng_56 x2_tail VSS_body VSS cmc nfet_01v8_W1p4_L0p6_m96__nf1_gboth_sdfull_ng
Xnfet_01v8_W1p4_L0p6_m96__nf1_gboth_sdfull_ng_67 x2_tail VSS_body VSS cmc nfet_01v8_W1p4_L0p6_m96__nf1_gboth_sdfull_ng
Xnfet_01v8_W1p4_L0p6_m96__nf1_gboth_sdfull_ng_78 x2_tail VSS_body VSS cmc nfet_01v8_W1p4_L0p6_m96__nf1_gboth_sdfull_ng
Xnfet_01v8_W1p4_L0p6_m96__nf1_gboth_sdfull_ng_89 x2_tail VSS_body VSS cmc nfet_01v8_W1p4_L0p6_m96__nf1_gboth_sdfull_ng
Xnfet_01v8_W1p4_L0p6_m96__nf1_gboth_sdfull_ng_13 x2_tail VSS_body VSS cmc nfet_01v8_W1p4_L0p6_m96__nf1_gboth_sdfull_ng
Xnfet_01v8_W1p4_L0p6_m96__nf1_gboth_sdfull_ng_24 x2_tail VSS_body VSS cmc nfet_01v8_W1p4_L0p6_m96__nf1_gboth_sdfull_ng
Xnfet_01v8_W1p4_L0p6_m96__nf1_gboth_sdfull_ng_35 x2_tail VSS_body VSS cmc nfet_01v8_W1p4_L0p6_m96__nf1_gboth_sdfull_ng
Xnfet_01v8_W1p4_L0p6_m96__nf1_gboth_sdfull_ng_46 x2_tail VSS_body VSS cmc nfet_01v8_W1p4_L0p6_m96__nf1_gboth_sdfull_ng
Xnfet_01v8_W1p4_L0p6_m96__nf1_gboth_sdfull_ng_57 x2_tail VSS_body VSS cmc nfet_01v8_W1p4_L0p6_m96__nf1_gboth_sdfull_ng
Xnfet_01v8_W1p4_L0p6_m96__nf1_gboth_sdfull_ng_68 x2_tail VSS_body VSS cmc nfet_01v8_W1p4_L0p6_m96__nf1_gboth_sdfull_ng
Xnfet_01v8_W1p4_L0p6_m96__nf1_gboth_sdfull_ng_79 x2_tail VSS_body VSS cmc nfet_01v8_W1p4_L0p6_m96__nf1_gboth_sdfull_ng
Xnfet_01v8_W1p4_L0p6_m96__nf1_gboth_sdfull_ng_14 x2_tail VSS_body VSS cmc nfet_01v8_W1p4_L0p6_m96__nf1_gboth_sdfull_ng
Xnfet_01v8_W1p4_L0p6_m96__nf1_gboth_sdfull_ng_15 x2_tail VSS_body VSS cmc nfet_01v8_W1p4_L0p6_m96__nf1_gboth_sdfull_ng
Xnfet_01v8_W1p4_L0p6_m96__nf1_gboth_sdfull_ng_25 x2_tail VSS_body VSS cmc nfet_01v8_W1p4_L0p6_m96__nf1_gboth_sdfull_ng
Xnfet_01v8_W1p4_L0p6_m96__nf1_gboth_sdfull_ng_26 x2_tail VSS_body VSS cmc nfet_01v8_W1p4_L0p6_m96__nf1_gboth_sdfull_ng
Xnfet_01v8_W1p4_L0p6_m96__nf1_gboth_sdfull_ng_36 x2_tail VSS_body VSS cmc nfet_01v8_W1p4_L0p6_m96__nf1_gboth_sdfull_ng
Xnfet_01v8_W1p4_L0p6_m96__nf1_gboth_sdfull_ng_37 x2_tail VSS_body VSS cmc nfet_01v8_W1p4_L0p6_m96__nf1_gboth_sdfull_ng
Xnfet_01v8_W1p4_L0p6_m96__nf1_gboth_sdfull_ng_47 x2_tail VSS_body VSS cmc nfet_01v8_W1p4_L0p6_m96__nf1_gboth_sdfull_ng
Xnfet_01v8_W1p4_L0p6_m96__nf1_gboth_sdfull_ng_48 x2_tail VSS_body VSS cmc nfet_01v8_W1p4_L0p6_m96__nf1_gboth_sdfull_ng
Xnfet_01v8_W1p4_L0p6_m96__nf1_gboth_sdfull_ng_58 x2_tail VSS_body VSS cmc nfet_01v8_W1p4_L0p6_m96__nf1_gboth_sdfull_ng
Xnfet_01v8_W1p4_L0p6_m96__nf1_gboth_sdfull_ng_59 x2_tail VSS_body VSS cmc nfet_01v8_W1p4_L0p6_m96__nf1_gboth_sdfull_ng
Xnfet_01v8_W1p4_L0p6_m96__nf1_gboth_sdfull_ng_69 x2_tail VSS_body VSS cmc nfet_01v8_W1p4_L0p6_m96__nf1_gboth_sdfull_ng
Xnfet_01v8_W1p4_L0p6_m96__nf1_gboth_sdfull_ng_16 x2_tail VSS_body VSS cmc nfet_01v8_W1p4_L0p6_m96__nf1_gboth_sdfull_ng
Xnfet_01v8_W1p4_L0p6_m96__nf1_gboth_sdfull_ng_27 x2_tail VSS_body VSS cmc nfet_01v8_W1p4_L0p6_m96__nf1_gboth_sdfull_ng
Xnfet_01v8_W1p4_L0p6_m96__nf1_gboth_sdfull_ng_38 x2_tail VSS_body VSS cmc nfet_01v8_W1p4_L0p6_m96__nf1_gboth_sdfull_ng
Xnfet_01v8_W1p4_L0p6_m96__nf1_gboth_sdfull_ng_49 x2_tail VSS_body VSS cmc nfet_01v8_W1p4_L0p6_m96__nf1_gboth_sdfull_ng
Xnfet_01v8_W1p4_L0p6_m96__nf1_gboth_sdfull_ng_17 x2_tail VSS_body VSS cmc nfet_01v8_W1p4_L0p6_m96__nf1_gboth_sdfull_ng
Xnfet_01v8_W1p4_L0p6_m96__nf1_gboth_sdfull_ng_28 x2_tail VSS_body VSS cmc nfet_01v8_W1p4_L0p6_m96__nf1_gboth_sdfull_ng
Xnfet_01v8_W1p4_L0p6_m96__nf1_gboth_sdfull_ng_39 x2_tail VSS_body VSS cmc nfet_01v8_W1p4_L0p6_m96__nf1_gboth_sdfull_ng
Xnfet_01v8_W1p4_L0p6_m96__nf1_gboth_sdfull_ng_18 x2_tail VSS_body VSS cmc nfet_01v8_W1p4_L0p6_m96__nf1_gboth_sdfull_ng
Xnfet_01v8_W1p4_L0p6_m96__nf1_gboth_sdfull_ng_29 x2_tail VSS_body VSS cmc nfet_01v8_W1p4_L0p6_m96__nf1_gboth_sdfull_ng
Xnfet_01v8_W1p4_L0p6_m96__nf1_gboth_sdfull_ng_19 x2_tail VSS_body VSS cmc nfet_01v8_W1p4_L0p6_m96__nf1_gboth_sdfull_ng
Xnfet_01v8_W1p4_L0p6_m96__nf1_gboth_sdfull_ng_90 x2_tail VSS_body VSS cmc nfet_01v8_W1p4_L0p6_m96__nf1_gboth_sdfull_ng
.ends

.subckt nmos_matched_cascode_pair_8__AB cm VSS VSS_body x1_net11
Xnfet_01v8_W1p4_L0p6_m1__nf1_gboth_sdfull_ng_0 VSS VSS_body VSS VSS nfet_01v8_W1p4_L0p6_m1__nf1_gboth_sdfull_ng
Xnfet_01v8_W1p4_L0p6_m1__nf1_gboth_sdfull_ng_1 x1_net10 VSS_body cm cm nfet_01v8_W1p4_L0p6_m1__nf1_gboth_sdfull_ng
Xnfet_01v8_W1p4_L0p6_m1__nf1_gboth_sdfull_ng_2 x1_net11 VSS_body cm x1_net10 nfet_01v8_W1p4_L0p6_m1__nf1_gboth_sdfull_ng
Xnfet_01v8_W1p4_L0p6_m1__nf1_gboth_sdfull_ng_3 VSS VSS_body VSS VSS nfet_01v8_W1p4_L0p6_m1__nf1_gboth_sdfull_ng
.ends

.subckt pmos_dummy_2__A VDD_body VDD
Xpfet_01v8_W1p4_L0p6_m6__nf1_gboth_sdfull_ng_0 VDD VDD_body VDD VDD pfet_01v8_W1p4_L0p6_m6__nf1_gboth_sdfull_ng
Xpfet_01v8_W1p4_L0p6_m6__nf1_gboth_sdfull_ng_1 VDD VDD_body VDD VDD pfet_01v8_W1p4_L0p6_m6__nf1_gboth_sdfull_ng
Xpfet_01v8_W1p4_L0p6_m6__nf1_gboth_sdfull_ng_2 VDD VDD_body VDD VDD pfet_01v8_W1p4_L0p6_m6__nf1_gboth_sdfull_ng
Xpfet_01v8_W1p4_L0p6_m6__nf1_gboth_sdfull_ng_3 VDD VDD_body VDD VDD pfet_01v8_W1p4_L0p6_m6__nf1_gboth_sdfull_ng
Xpfet_01v8_W1p4_L0p6_m6__nf1_gboth_sdfull_ng_4 VDD VDD_body VDD VDD pfet_01v8_W1p4_L0p6_m6__nf1_gboth_sdfull_ng
Xpfet_01v8_W1p4_L0p6_m6__nf1_gboth_sdfull_ng_5 VDD VDD_body VDD VDD pfet_01v8_W1p4_L0p6_m6__nf1_gboth_sdfull_ng
.ends

.subckt nmos_dummy_4__A x1_m5d VSS_body
Xnfet_01v8_W1p4_L0p6_m6__nf1_gtop_sdfull_ng_0 VSS_body x1_m5d x1_m5d x1_m5d nfet_01v8_W1p4_L0p6_m6__nf1_gtop_sdfull_ng
Xnfet_01v8_W1p4_L0p6_m6__nf1_gtop_sdfull_ng_1 VSS_body x1_m5d x1_m5d x1_m5d nfet_01v8_W1p4_L0p6_m6__nf1_gtop_sdfull_ng
Xnfet_01v8_W1p4_L0p6_m6__nf1_gtop_sdfull_ng_2 VSS_body x1_m5d x1_m5d x1_m5d nfet_01v8_W1p4_L0p6_m6__nf1_gtop_sdfull_ng
Xnfet_01v8_W1p4_L0p6_m6__nf1_gtop_sdfull_ng_3 VSS_body x1_m5d x1_m5d x1_m5d nfet_01v8_W1p4_L0p6_m6__nf1_gtop_sdfull_ng
Xnfet_01v8_W1p4_L0p6_m6__nf1_gtop_sdfull_ng_4 VSS_body x1_m5d x1_m5d x1_m5d nfet_01v8_W1p4_L0p6_m6__nf1_gtop_sdfull_ng
Xnfet_01v8_W1p4_L0p6_m6__nf1_gtop_sdfull_ng_5 VSS_body x1_m5d x1_m5d x1_m5d nfet_01v8_W1p4_L0p6_m6__nf1_gtop_sdfull_ng
.ends

.subckt pmos_dummy_14__A VDD VDD_body x2_foldp
Xpfet_01v8_W1p4_L0p6_m2__nf1_gtop_sdfull_ng_0 VDD_body VDD VDD x2_foldp pfet_01v8_W1p4_L0p6_m2__nf1_gtop_sdfull_ng
Xpfet_01v8_W1p4_L0p6_m2__nf1_gtop_sdfull_ng_1 VDD_body VDD VDD x2_foldp pfet_01v8_W1p4_L0p6_m2__nf1_gtop_sdfull_ng
.ends

.subckt pmos_dummy_5__A VDD_body x1_m31d
Xpfet_01v8_lvt_W1p4_L0p6_m2__nf1_gtop_sdfull_ng_0 VDD_body x1_m31d x1_m31d x1_m31d
+ pfet_01v8_lvt_W1p4_L0p6_m2__nf1_gtop_sdfull_ng
Xpfet_01v8_lvt_W1p4_L0p6_m2__nf1_gtop_sdfull_ng_1 VDD_body x1_m31d x1_m31d x1_m31d
+ pfet_01v8_lvt_W1p4_L0p6_m2__nf1_gtop_sdfull_ng
.ends

.subckt nmos_matched_cascode_pair_7__AB cm VSS x1_net8 VSS_body
Xnfet_01v8_W1p4_L0p6_m1__nf1_gboth_sdfull_ng_0 VSS VSS_body VSS VSS nfet_01v8_W1p4_L0p6_m1__nf1_gboth_sdfull_ng
Xnfet_01v8_W1p4_L0p6_m1__nf1_gboth_sdfull_ng_1 x1_net9 VSS_body cm x1_net8 nfet_01v8_W1p4_L0p6_m1__nf1_gboth_sdfull_ng
Xnfet_01v8_W1p4_L0p6_m1__nf1_gboth_sdfull_ng_2 VSS VSS_body cm x1_net9 nfet_01v8_W1p4_L0p6_m1__nf1_gboth_sdfull_ng
Xnfet_01v8_W1p4_L0p6_m1__nf1_gboth_sdfull_ng_3 VSS VSS_body VSS VSS nfet_01v8_W1p4_L0p6_m1__nf1_gboth_sdfull_ng
.ends

.subckt nfet_01v8_W1p4_L0p6_m4__nf1_gtop_sdfull_ng B S G D
Xnfet_01v8_W1p4_L0p6_m4__nf1_gtop_sdfull_ng_pc G D S B sky130_fd_pr__nfet_01v8_RUA5M6
.ends

.subckt nmos_dummy_7__A bias_a VSS_body
Xnfet_01v8_W1p4_L0p6_m4__nf1_gtop_sdfull_ng_0 VSS_body bias_a bias_a bias_a nfet_01v8_W1p4_L0p6_m4__nf1_gtop_sdfull_ng
Xnfet_01v8_W1p4_L0p6_m4__nf1_gtop_sdfull_ng_1 VSS_body bias_a bias_a bias_a nfet_01v8_W1p4_L0p6_m4__nf1_gtop_sdfull_ng
Xnfet_01v8_W1p4_L0p6_m4__nf1_gtop_sdfull_ng_2 VSS_body bias_a bias_a bias_a nfet_01v8_W1p4_L0p6_m4__nf1_gtop_sdfull_ng
Xnfet_01v8_W1p4_L0p6_m4__nf1_gtop_sdfull_ng_3 VSS_body bias_a bias_a bias_a nfet_01v8_W1p4_L0p6_m4__nf1_gtop_sdfull_ng
.ends

.subckt nmos_matched_cascode_pair_6__AB cm VSS VSS_body x1_net8
Xnfet_01v8_W1p4_L0p6_m1__nf1_gboth_sdfull_ng_0 VSS VSS_body VSS VSS nfet_01v8_W1p4_L0p6_m1__nf1_gboth_sdfull_ng
Xnfet_01v8_W1p4_L0p6_m1__nf1_gboth_sdfull_ng_1 x1_net7 VSS_body cm cm nfet_01v8_W1p4_L0p6_m1__nf1_gboth_sdfull_ng
Xnfet_01v8_W1p4_L0p6_m1__nf1_gboth_sdfull_ng_2 x1_net8 VSS_body cm x1_net7 nfet_01v8_W1p4_L0p6_m1__nf1_gboth_sdfull_ng
Xnfet_01v8_W1p4_L0p6_m1__nf1_gboth_sdfull_ng_3 VSS VSS_body VSS VSS nfet_01v8_W1p4_L0p6_m1__nf1_gboth_sdfull_ng
.ends

.subckt pmos_dummy_17__A VDD_body x2_foldp
Xpfet_01v8_W1p4_L0p6_m2__nf1_gtop_sdfull_ng_0 VDD_body x2_foldp x2_foldp x2_foldp
+ pfet_01v8_W1p4_L0p6_m2__nf1_gtop_sdfull_ng
Xpfet_01v8_W1p4_L0p6_m2__nf1_gtop_sdfull_ng_1 VDD_body x2_foldp x2_foldp x2_foldp
+ pfet_01v8_W1p4_L0p6_m2__nf1_gtop_sdfull_ng
.ends

.subckt nmos_dummy_21__A on VSS VSS_body
Xnfet_01v8_W1p4_L0p6_m2__nf1_gboth_sdfull_ng_0 VSS_body VSS VSS on nfet_01v8_W1p4_L0p6_m2__nf1_gboth_sdfull_ng
Xnfet_01v8_W1p4_L0p6_m2__nf1_gboth_sdfull_ng_1 VSS_body VSS VSS on nfet_01v8_W1p4_L0p6_m2__nf1_gboth_sdfull_ng
.ends

.subckt nmos_matched_cascode_pair_5__AB cm VSS x1_net5 VSS_body
Xnfet_01v8_W1p4_L0p6_m1__nf1_gboth_sdfull_ng_0 VSS VSS_body VSS VSS nfet_01v8_W1p4_L0p6_m1__nf1_gboth_sdfull_ng
Xnfet_01v8_W1p4_L0p6_m1__nf1_gboth_sdfull_ng_1 x1_net6 VSS_body cm x1_net5 nfet_01v8_W1p4_L0p6_m1__nf1_gboth_sdfull_ng
Xnfet_01v8_W1p4_L0p6_m1__nf1_gboth_sdfull_ng_2 VSS VSS_body cm x1_net6 nfet_01v8_W1p4_L0p6_m1__nf1_gboth_sdfull_ng
Xnfet_01v8_W1p4_L0p6_m1__nf1_gboth_sdfull_ng_3 VSS VSS_body VSS VSS nfet_01v8_W1p4_L0p6_m1__nf1_gboth_sdfull_ng
.ends

.subckt pmos_dummy_8__A VDD VDD_body bias_b
Xpfet_01v8_W1p4_L0p6_m2__nf1_gtop_sdfull_ng_0 VDD_body VDD VDD bias_b pfet_01v8_W1p4_L0p6_m2__nf1_gtop_sdfull_ng
Xpfet_01v8_W1p4_L0p6_m2__nf1_gtop_sdfull_ng_1 VDD_body VDD VDD bias_b pfet_01v8_W1p4_L0p6_m2__nf1_gtop_sdfull_ng
.ends

.subckt nmos_matched_cascode_pair_4__AB cm VSS VSS_body x1_net5
Xnfet_01v8_W1p4_L0p6_m1__nf1_gboth_sdfull_ng_0 VSS VSS_body VSS VSS nfet_01v8_W1p4_L0p6_m1__nf1_gboth_sdfull_ng
Xnfet_01v8_W1p4_L0p6_m1__nf1_gboth_sdfull_ng_1 x1_net4 VSS_body cm cm nfet_01v8_W1p4_L0p6_m1__nf1_gboth_sdfull_ng
Xnfet_01v8_W1p4_L0p6_m1__nf1_gboth_sdfull_ng_2 x1_net5 VSS_body cm x1_net4 nfet_01v8_W1p4_L0p6_m1__nf1_gboth_sdfull_ng
Xnfet_01v8_W1p4_L0p6_m1__nf1_gboth_sdfull_ng_3 VSS VSS_body VSS VSS nfet_01v8_W1p4_L0p6_m1__nf1_gboth_sdfull_ng
.ends

.subckt nmos_dummy_11__A i_bias VSS_body
Xnfet_01v8_W1p4_L0p6_m2__nf1_gboth_sdfull_ng_0 VSS_body i_bias i_bias i_bias nfet_01v8_W1p4_L0p6_m2__nf1_gboth_sdfull_ng
Xnfet_01v8_W1p4_L0p6_m2__nf1_gboth_sdfull_ng_1 VSS_body i_bias i_bias i_bias nfet_01v8_W1p4_L0p6_m2__nf1_gboth_sdfull_ng
.ends

.subckt iadc_ota_routed on op bias_a cm IBIAS VDD VSS cmc in ip
Xnmos_matched_cascode_pair_3__AB_0 cm VSS VSS nmos_matched_cascode_pair_3__AB_0/x1_net2
+ nmos_matched_cascode_pair_3__AB
XXC3__A_0 cmc op XC3__A
Xpmos_matched_cascode_pair__ABBA_0 pmos_dummy_6__A_0/x1_m21d nmos_diode__A_0/bias_c
+ nmos_diode__A_0/bias_b pmos_dummy_7__A_0/x1_m25d VDD VDD nmos_single__A_0/x1_m2d
+ pmos_matched_cascode_pair__ABBA
Xnmos_matched_cascode_pair_2__AB_0 cm VSS VSS nmos_matched_cascode_pair_3__AB_0/x1_net2
+ nmos_matched_cascode_pair_2__AB
Xnmos_dummy_14__A_0 nmos_single_5__A_0/x2_tail VSS nmos_dummy_14__A
Xpmos_dummy_10__A_0 cm VDD VDD pmos_dummy_10__A
Xnmos_single_4__A_0 bias_a VSS nmos_single_5__A_0/x2_tail VSS nmos_single_4__A
Xnmos_dummy_17__A_0 on VSS nmos_dummy_17__A
Xnmos_dummy_3__A_0 nmos_diode__A_0/bias_b VSS nmos_dummy_3__A
Xpmos_dummy_13__A_0 op VDD VDD pmos_dummy_13__A
Xpmos_dummy_4__A_0 pmos_dummy_7__A_0/x1_m25d VDD pmos_dummy_4__A
Xnmos_single__A_0 bias_a nmos_single__A_0/x1_m2d VSS nmos_single__A_0/bias_d nmos_single__A
Xnmos_dummy_6__A_0 nmos_single__A_0/x1_m2d VSS nmos_dummy_6__A
Xnmos_diode__A_0 nmos_diode__A_0/bias_b VSS nmos_diode__A_0/bias_c nmos_diode__A
Xpmos_dummy_16__A_0 VDD pmos_dummy_16__A_0/x2_foldn pmos_dummy_16__A
Xnmos_dummy_20__A_0 VSS op VSS nmos_dummy_20__A
Xnmos_matched_current_source_pair__ABAB_0 nmos_dummy_19__A_0/x2_m3d VSS nmos_dummy_18__A_0/x2_m4d
+ bias_a VSS nmos_matched_current_source_pair__ABAB
Xpmos_matched_current_source_pair__ABBA_0 pmos_dummy_7__A_0/x1_m25d VDD pmos_dummy_6__A_0/x1_m21d
+ VDD nmos_diode__A_0/bias_b pmos_matched_current_source_pair__ABBA
Xpmos_dummy_7__A_0 VDD pmos_dummy_7__A_0/x1_m25d pmos_dummy_7__A
Xnmos_dummy__A_0 VSS VSS nmos_dummy__A
Xnmos_dummy_10__A_0 nmos_diode__A_0/bias_c VSS nmos_dummy_10__A
Xnmos_dummy_9__A_0 VSS nmos_dummy_9__A_0/x1_m5d VSS nmos_dummy_9__A
Xnmos_dummy_13__A_0 pmos_dummy_16__A_0/x2_foldn VSS nmos_dummy_13__A
Xnmos_dummy_16__A_0 VSS op nmos_dummy_16__A
Xnmos_single_3__A_0 bias_a VSS nmos_dummy_9__A_0/x1_m5d VSS nmos_single_3__A
Xnmos_dummy_2__A_0 VSS nmos_diode__A_0/bias_c nmos_dummy_2__A
Xpmos_dummy_12__A_0 VDD VDD pmos_dummy_16__A_0/x2_foldn pmos_dummy_12__A
Xnmos_matched_cascode_pair__ABBA_0 VSS nmos_dummy_19__A_0/x2_m3d nmos_single__A_0/bias_d
+ on nmos_dummy_18__A_0/x2_m4d VSS op nmos_matched_cascode_pair__ABBA
Xnmos_diode_2__A_0 nmos_single__A_0/bias_d nmos_single__A_0/x1_m2d VSS nmos_diode_2__A
Xnmos_dummy_19__A_0 nmos_dummy_19__A_0/x2_m3d VSS VSS nmos_dummy_19__A
Xpmos_dummy_3__A_0 pmos_dummy_6__A_0/x1_m21d VDD pmos_dummy_3__A
Xnmos_dummy_5__A_0 VSS nmos_single__A_0/bias_d nmos_dummy_5__A
Xpmos_single_2__A_0 pmos_single__A_0/x1_m31d VDD nmos_diode__A_0/bias_c cm pmos_single_2__A
Xpmos_dummy_15__A_0 VDD on VDD pmos_dummy_15__A
Xnmos_differential_pair__ABAB_0 pmos_dummy_17__A_0/x2_foldp nmos_single_5__A_0/x2_tail
+ VSS VSS in pmos_dummy_16__A_0/x2_foldn ip nmos_differential_pair__ABAB
Xpmos_dummy_6__A_0 VDD pmos_dummy_6__A_0/x1_m21d pmos_dummy_6__A
Xpmos_dummy__A_0 VDD VDD pmos_dummy__A
Xnmos_dummy_8__A_0 cm VSS nmos_dummy_8__A
Xnmos_dummy_12__A_0 pmos_dummy_17__A_0/x2_foldp VSS nmos_dummy_12__A
Xpmos_single__A_0 VDD nmos_diode__A_0/bias_b VDD pmos_single__A_0/x1_m31d pmos_single__A
Xpmos_dummy_9__A_0 VDD nmos_single__A_0/x1_m2d VDD pmos_dummy_9__A
XXC4__A_0 on cmc XC4__A
Xpmos_matched_current_source_pair_2__ABAB_0 nmos_diode__A_0/bias_b VDD pmos_dummy_17__A_0/x2_foldp
+ pmos_dummy_16__A_0/x2_foldn VDD pmos_matched_current_source_pair_2__ABAB
Xnmos_matched_cascode_pair_11__AB_0 cm nmos_matched_cascode_pair_11__AB_0/x1_net14
+ VSS VSS nmos_matched_cascode_pair_11__AB
Xnmos_current_mirror__ABBA_0 VSS IBIAS VSS nmos_diode__A_0/bias_c nmos_current_mirror__ABBA
Xpmos_matched_cascode_pair_2__ABAB_0 on pmos_dummy_17__A_0/x2_foldp VDD VDD op nmos_diode__A_0/bias_c
+ pmos_dummy_16__A_0/x2_foldn pmos_matched_cascode_pair_2__ABAB
Xnmos_dummy_15__A_0 VSS nmos_single_5__A_0/x2_tail VSS nmos_dummy_15__A
Xnmos_matched_cascode_pair_10__AB_0 cm VSS VSS nmos_matched_cascode_pair_11__AB_0/x1_net14
+ nmos_matched_cascode_pair_10__AB
Xnmos_single_2__A_0 nmos_dummy_9__A_0/x1_m5d VSS nmos_single__A_0/bias_d bias_a nmos_single_2__A
Xpmos_dummy_11__A_0 VDD VDD pmos_single__A_0/x1_m31d pmos_dummy_11__A
Xnmos_matched_cascode_pair_9__AB_0 VSS cm nmos_matched_cascode_pair_9__AB_0/x1_net11
+ VSS nmos_matched_cascode_pair_9__AB
Xnmos_dummy_18__A_0 VSS nmos_dummy_18__A_0/x2_m4d VSS nmos_dummy_18__A
Xnmos_single_5__A_0 cmc VSS VSS nmos_single_5__A_0/x2_tail nmos_single_5__A
Xnmos_matched_cascode_pair_8__AB_0 cm VSS VSS nmos_matched_cascode_pair_9__AB_0/x1_net11
+ nmos_matched_cascode_pair_8__AB
Xpmos_dummy_2__A_0 VDD VDD pmos_dummy_2__A
Xnmos_dummy_4__A_0 nmos_dummy_9__A_0/x1_m5d VSS nmos_dummy_4__A
Xpmos_dummy_14__A_0 VDD VDD pmos_dummy_17__A_0/x2_foldp pmos_dummy_14__A
Xpmos_dummy_5__A_0 VDD pmos_single__A_0/x1_m31d pmos_dummy_5__A
Xnmos_matched_cascode_pair_7__AB_0 cm VSS nmos_matched_cascode_pair_7__AB_0/x1_net8
+ VSS nmos_matched_cascode_pair_7__AB
Xnmos_dummy_7__A_0 bias_a VSS nmos_dummy_7__A
Xnmos_matched_cascode_pair_6__AB_0 cm VSS VSS nmos_matched_cascode_pair_7__AB_0/x1_net8
+ nmos_matched_cascode_pair_6__AB
Xpmos_dummy_17__A_0 VDD pmos_dummy_17__A_0/x2_foldp pmos_dummy_17__A
Xnmos_dummy_21__A_0 on VSS VSS nmos_dummy_21__A
Xnmos_matched_cascode_pair_5__AB_0 cm VSS nmos_matched_cascode_pair_5__AB_0/x1_net5
+ VSS nmos_matched_cascode_pair_5__AB
Xpmos_dummy_8__A_0 VDD VDD nmos_diode__A_0/bias_b pmos_dummy_8__A
Xnmos_matched_cascode_pair_4__AB_0 cm VSS VSS nmos_matched_cascode_pair_5__AB_0/x1_net5
+ nmos_matched_cascode_pair_4__AB
Xnmos_dummy_11__A_0 IBIAS VSS nmos_dummy_11__A
.ends
