* NGSPICE file created from loadbench_miller_routed.ext - technology: sky130A

.subckt sky130_fd_pr__nfet_01v8_lvt_2FVR8Y a_1667_n1544# S27 D22 S17 D10 D20 S15 G
+ D30 S25 S13 S23 S11 S21 S31 D8 D6 D4 D2 D0 S9 S7 D18 D28 S5 D16 D26 S3 D14 D24 S19
+ S1 S29 D12 VSUBS
X0 D4 G S3 VSUBS sky130_fd_pr__nfet_01v8_lvt ad=2.19385 pd=15.42 as=2.19385 ps=15.42 w=15.13 l=0.24
X1 D6 G S5 VSUBS sky130_fd_pr__nfet_01v8_lvt ad=2.19385 pd=15.42 as=2.19385 ps=15.42 w=15.13 l=0.24
X2 D30 G S29 VSUBS sky130_fd_pr__nfet_01v8_lvt ad=2.19385 pd=15.42 as=2.19385 ps=15.42 w=15.13 l=0.24
X3 a_1667_n1544# G S31 VSUBS sky130_fd_pr__nfet_01v8_lvt ad=4.3877 pd=30.84 as=2.19385 ps=15.42 w=15.13 l=0.24
X4 D14 G S13 VSUBS sky130_fd_pr__nfet_01v8_lvt ad=2.19385 pd=15.42 as=2.19385 ps=15.42 w=15.13 l=0.24
X5 S25 G D24 VSUBS sky130_fd_pr__nfet_01v8_lvt ad=2.19385 pd=15.42 as=2.19385 ps=15.42 w=15.13 l=0.24
X6 D8 G S7 VSUBS sky130_fd_pr__nfet_01v8_lvt ad=2.19385 pd=15.42 as=2.19385 ps=15.42 w=15.13 l=0.24
X7 S23 G D22 VSUBS sky130_fd_pr__nfet_01v8_lvt ad=2.19385 pd=15.42 as=2.19385 ps=15.42 w=15.13 l=0.24
X8 D10 G S9 VSUBS sky130_fd_pr__nfet_01v8_lvt ad=2.19385 pd=15.42 as=2.19385 ps=15.42 w=15.13 l=0.24
X9 D12 G S11 VSUBS sky130_fd_pr__nfet_01v8_lvt ad=2.19385 pd=15.42 as=2.19385 ps=15.42 w=15.13 l=0.24
X10 S21 G D20 VSUBS sky130_fd_pr__nfet_01v8_lvt ad=2.19385 pd=15.42 as=2.19385 ps=15.42 w=15.13 l=0.24
X11 S19 G D18 VSUBS sky130_fd_pr__nfet_01v8_lvt ad=2.19385 pd=15.42 as=2.19385 ps=15.42 w=15.13 l=0.24
X12 S9 G D8 VSUBS sky130_fd_pr__nfet_01v8_lvt ad=2.19385 pd=15.42 as=2.19385 ps=15.42 w=15.13 l=0.24
X13 S11 G D10 VSUBS sky130_fd_pr__nfet_01v8_lvt ad=2.19385 pd=15.42 as=2.19385 ps=15.42 w=15.13 l=0.24
X14 D20 G S19 VSUBS sky130_fd_pr__nfet_01v8_lvt ad=2.19385 pd=15.42 as=2.19385 ps=15.42 w=15.13 l=0.24
X15 D22 G S21 VSUBS sky130_fd_pr__nfet_01v8_lvt ad=2.19385 pd=15.42 as=2.19385 ps=15.42 w=15.13 l=0.24
X16 D18 G S17 VSUBS sky130_fd_pr__nfet_01v8_lvt ad=2.19385 pd=15.42 as=2.19385 ps=15.42 w=15.13 l=0.24
X17 D16 G S15 VSUBS sky130_fd_pr__nfet_01v8_lvt ad=2.19385 pd=15.42 as=2.19385 ps=15.42 w=15.13 l=0.24
X18 D28 G S27 VSUBS sky130_fd_pr__nfet_01v8_lvt ad=2.19385 pd=15.42 as=2.19385 ps=15.42 w=15.13 l=0.24
X19 D2 G S1 VSUBS sky130_fd_pr__nfet_01v8_lvt ad=2.19385 pd=15.42 as=2.19385 ps=15.42 w=15.13 l=0.24
X20 S17 G D16 VSUBS sky130_fd_pr__nfet_01v8_lvt ad=2.19385 pd=15.42 as=2.19385 ps=15.42 w=15.13 l=0.24
X21 S1 G D0 VSUBS sky130_fd_pr__nfet_01v8_lvt ad=2.19385 pd=15.42 as=4.3877 ps=30.84 w=15.13 l=0.24
X22 S3 G D2 VSUBS sky130_fd_pr__nfet_01v8_lvt ad=2.19385 pd=15.42 as=2.19385 ps=15.42 w=15.13 l=0.24
X23 S27 G D26 VSUBS sky130_fd_pr__nfet_01v8_lvt ad=2.19385 pd=15.42 as=2.19385 ps=15.42 w=15.13 l=0.24
X24 S5 G D4 VSUBS sky130_fd_pr__nfet_01v8_lvt ad=2.19385 pd=15.42 as=2.19385 ps=15.42 w=15.13 l=0.24
X25 S31 G D30 VSUBS sky130_fd_pr__nfet_01v8_lvt ad=2.19385 pd=15.42 as=2.19385 ps=15.42 w=15.13 l=0.24
X26 S7 G D6 VSUBS sky130_fd_pr__nfet_01v8_lvt ad=2.19385 pd=15.42 as=2.19385 ps=15.42 w=15.13 l=0.24
X27 S13 G D12 VSUBS sky130_fd_pr__nfet_01v8_lvt ad=2.19385 pd=15.42 as=2.19385 ps=15.42 w=15.13 l=0.24
X28 D26 G S25 VSUBS sky130_fd_pr__nfet_01v8_lvt ad=2.19385 pd=15.42 as=2.19385 ps=15.42 w=15.13 l=0.24
X29 S29 G D28 VSUBS sky130_fd_pr__nfet_01v8_lvt ad=2.19385 pd=15.42 as=2.19385 ps=15.42 w=15.13 l=0.24
X30 S15 G D14 VSUBS sky130_fd_pr__nfet_01v8_lvt ad=2.19385 pd=15.42 as=2.19385 ps=15.42 w=15.13 l=0.24
X31 D24 G S23 VSUBS sky130_fd_pr__nfet_01v8_lvt ad=2.19385 pd=15.42 as=2.19385 ps=15.42 w=15.13 l=0.24
.ends

.subckt nfet_01v8_lvt_W484p2_L0p24_m1__nf32_gtop_sdhalf_outS_ng G B S D
Xnfet_01v8_lvt_W484p2_L0p24_m1__nf32_gtop_sdhalf_outS_ng_pc S D S D S S D G S D D
+ D D D D S S S S S D D S S D S S D S S D D D S B sky130_fd_pr__nfet_01v8_lvt_2FVR8Y
.ends

.subckt cs_stage__A out sourceNmos sourceNmos_body outFirstStage
Xnfet_01v8_lvt_W484p2_L0p24_m1__nf32_gtop_sdhalf_outS_ng_0 outFirstStage sourceNmos_body
+ sourceNmos out nfet_01v8_lvt_W484p2_L0p24_m1__nf32_gtop_sdhalf_outS_ng
.ends

.subckt sky130_fd_pr__pfet_01v8_lvt_CBAHUX G D6 a_795_n1133# D4 D2 w_n889_n1233# D0
+ S7 S5 S3 S1
X0 S7 G D6 w_n889_n1233# sky130_fd_pr__pfet_01v8_lvt ad=1.64285 pd=11.62 as=1.64285 ps=11.62 w=11.33 l=0.74
X1 a_795_n1133# G S7 w_n889_n1233# sky130_fd_pr__pfet_01v8_lvt ad=3.2857 pd=23.24 as=1.64285 ps=11.62 w=11.33 l=0.74
X2 D4 G S3 w_n889_n1233# sky130_fd_pr__pfet_01v8_lvt ad=1.64285 pd=11.62 as=1.64285 ps=11.62 w=11.33 l=0.74
X3 D6 G S5 w_n889_n1233# sky130_fd_pr__pfet_01v8_lvt ad=1.64285 pd=11.62 as=1.64285 ps=11.62 w=11.33 l=0.74
X4 S1 G D0 w_n889_n1233# sky130_fd_pr__pfet_01v8_lvt ad=1.64285 pd=11.62 as=3.2857 ps=23.24 w=11.33 l=0.74
X5 D2 G S1 w_n889_n1233# sky130_fd_pr__pfet_01v8_lvt ad=1.64285 pd=11.62 as=1.64285 ps=11.62 w=11.33 l=0.74
X6 S3 G D2 w_n889_n1233# sky130_fd_pr__pfet_01v8_lvt ad=1.64285 pd=11.62 as=1.64285 ps=11.62 w=11.33 l=0.74
X7 S5 G D4 w_n889_n1233# sky130_fd_pr__pfet_01v8_lvt ad=1.64285 pd=11.62 as=1.64285 ps=11.62 w=11.33 l=0.74
.ends

.subckt pfet_01v8_lvt_W90p63_L0p74_m1__nf8_gboth_sdfull_outS_ng D G S B
Xpfet_01v8_lvt_W90p63_L0p74_m1__nf8_gboth_sdfull_outS_ng_pc G S S S S B S D D D D
+ sky130_fd_pr__pfet_01v8_lvt_CBAHUX
.ends

.subckt sky130_fd_pr__pfet_01v8_lvt_7S7S4Q G D w_n168_n3830# S
X0 S G D w_n168_n3830# sky130_fd_pr__pfet_01v8_lvt ad=10.817 pd=75.18 as=10.817 ps=75.18 w=37.3 l=0.74
.ends

.subckt pfet_01v8_lvt_W37p3_L0p74_m1__nf1_gboth_sdhalf_ng B G D S
Xpfet_01v8_lvt_W37p3_L0p74_m1__nf1_gboth_sdhalf_ng_pc G D B S sky130_fd_pr__pfet_01v8_lvt_7S7S4Q
.ends

.subckt sky130_fd_pr__pfet_01v8_lvt_2BKEHH D10 S15 G S13 S11 D8 D6 D4 D2 D0 a_1619_n5544#
+ S9 w_n1713_n5644# S7 S5 S3 D14 S1 D12
X0 S15 G D14 w_n1713_n5644# sky130_fd_pr__pfet_01v8_lvt ad=8.0388 pd=55.73 as=8.0388 ps=55.73 w=55.44 l=0.74
X1 D2 G S1 w_n1713_n5644# sky130_fd_pr__pfet_01v8_lvt ad=8.0388 pd=55.73 as=8.0388 ps=55.73 w=55.44 l=0.74
X2 S1 G D0 w_n1713_n5644# sky130_fd_pr__pfet_01v8_lvt ad=8.0388 pd=55.73 as=16.0776 ps=111.46 w=55.44 l=0.74
X3 S5 G D4 w_n1713_n5644# sky130_fd_pr__pfet_01v8_lvt ad=8.0388 pd=55.73 as=8.0388 ps=55.73 w=55.44 l=0.74
X4 D14 G S13 w_n1713_n5644# sky130_fd_pr__pfet_01v8_lvt ad=8.0388 pd=55.73 as=8.0388 ps=55.73 w=55.44 l=0.74
X5 D4 G S3 w_n1713_n5644# sky130_fd_pr__pfet_01v8_lvt ad=8.0388 pd=55.73 as=8.0388 ps=55.73 w=55.44 l=0.74
X6 S3 G D2 w_n1713_n5644# sky130_fd_pr__pfet_01v8_lvt ad=8.0388 pd=55.73 as=8.0388 ps=55.73 w=55.44 l=0.74
X7 S13 G D12 w_n1713_n5644# sky130_fd_pr__pfet_01v8_lvt ad=8.0388 pd=55.73 as=8.0388 ps=55.73 w=55.44 l=0.74
X8 D6 G S5 w_n1713_n5644# sky130_fd_pr__pfet_01v8_lvt ad=8.0388 pd=55.73 as=8.0388 ps=55.73 w=55.44 l=0.74
X9 S7 G D6 w_n1713_n5644# sky130_fd_pr__pfet_01v8_lvt ad=8.0388 pd=55.73 as=8.0388 ps=55.73 w=55.44 l=0.74
X10 S9 G D8 w_n1713_n5644# sky130_fd_pr__pfet_01v8_lvt ad=8.0388 pd=55.73 as=8.0388 ps=55.73 w=55.44 l=0.74
X11 S11 G D10 w_n1713_n5644# sky130_fd_pr__pfet_01v8_lvt ad=8.0388 pd=55.73 as=8.0388 ps=55.73 w=55.44 l=0.74
X12 D12 G S11 w_n1713_n5644# sky130_fd_pr__pfet_01v8_lvt ad=8.0388 pd=55.73 as=8.0388 ps=55.73 w=55.44 l=0.74
X13 D8 G S7 w_n1713_n5644# sky130_fd_pr__pfet_01v8_lvt ad=8.0388 pd=55.73 as=8.0388 ps=55.73 w=55.44 l=0.74
X14 a_1619_n5544# G S15 w_n1713_n5644# sky130_fd_pr__pfet_01v8_lvt ad=16.0776 pd=111.46 as=8.0388 ps=55.73 w=55.44 l=0.74
X15 D10 G S9 w_n1713_n5644# sky130_fd_pr__pfet_01v8_lvt ad=8.0388 pd=55.73 as=8.0388 ps=55.73 w=55.44 l=0.74
.ends

.subckt pfet_01v8_lvt_W887p03_L0p74_m1__nf16_gboth_sdhalf_outS_ng B G D S
Xpfet_01v8_lvt_W887p03_L0p74_m1__nf16_gboth_sdhalf_outS_ng_pc S D G D D S S S S S
+ S D B D D D S D S sky130_fd_pr__pfet_01v8_lvt_2BKEHH
.ends

.subckt pmos_bias_bank__row ibias sourcePmos_body out sourcePmos FirstStageYsourceTransconductance
Xpfet_01v8_lvt_W90p63_L0p74_m1__nf8_gboth_sdfull_outS_ng_0 FirstStageYsourceTransconductance
+ ibias sourcePmos sourcePmos_body pfet_01v8_lvt_W90p63_L0p74_m1__nf8_gboth_sdfull_outS_ng
Xpfet_01v8_lvt_W37p3_L0p74_m1__nf1_gboth_sdhalf_ng_0 sourcePmos_body ibias ibias sourcePmos
+ pfet_01v8_lvt_W37p3_L0p74_m1__nf1_gboth_sdhalf_ng
Xpfet_01v8_lvt_W887p03_L0p74_m1__nf16_gboth_sdhalf_outS_ng_0 sourcePmos_body ibias
+ out sourcePmos pfet_01v8_lvt_W887p03_L0p74_m1__nf16_gboth_sdhalf_outS_ng
.ends

.subckt sky130_fd_pr__cap_mim_m3_1_84GA9G C1 C2
X0 C1 C2 sky130_fd_pr__cap_mim_m3_1 l=15.66 w=15.66
.ends

.subckt Capacitor2_mim Capacitor2_mim_pc/C2 Capacitor2_mim_pc/C1
XCapacitor2_mim_pc Capacitor2_mim_pc/C1 Capacitor2_mim_pc/C2 sky130_fd_pr__cap_mim_m3_1_84GA9G
.ends

.subckt Capacitor2__A out outFirstStage
XCapacitor2_mim_0 out outFirstStage Capacitor2_mim
.ends

.subckt sky130_fd_pr__nfet_01v8_lvt_4LZ4RL G D6 D4 D2 D0 a_1827_n827# S7 S5 S3 S1
+ VSUBS
X0 S1 G D0 VSUBS sky130_fd_pr__nfet_01v8_lvt ad=1.19915 pd=8.56 as=2.3983 ps=17.12 w=8.27 l=2.03
X1 D2 G S1 VSUBS sky130_fd_pr__nfet_01v8_lvt ad=1.19915 pd=8.56 as=1.19915 ps=8.56 w=8.27 l=2.03
X2 S7 G D6 VSUBS sky130_fd_pr__nfet_01v8_lvt ad=1.19915 pd=8.56 as=1.19915 ps=8.56 w=8.27 l=2.03
X3 D6 G S5 VSUBS sky130_fd_pr__nfet_01v8_lvt ad=1.19915 pd=8.56 as=1.19915 ps=8.56 w=8.27 l=2.03
X4 a_1827_n827# G S7 VSUBS sky130_fd_pr__nfet_01v8_lvt ad=2.3983 pd=17.12 as=1.19915 ps=8.56 w=8.27 l=2.03
X5 S5 G D4 VSUBS sky130_fd_pr__nfet_01v8_lvt ad=1.19915 pd=8.56 as=1.19915 ps=8.56 w=8.27 l=2.03
X6 D4 G S3 VSUBS sky130_fd_pr__nfet_01v8_lvt ad=1.19915 pd=8.56 as=1.19915 ps=8.56 w=8.27 l=2.03
X7 S3 G D2 VSUBS sky130_fd_pr__nfet_01v8_lvt ad=1.19915 pd=8.56 as=1.19915 ps=8.56 w=8.27 l=2.03
.ends

.subckt nfet_01v8_lvt_W66p13_L2p03_m1__nf8_gboth_sdfull_outS_ng B G S D
Xnfet_01v8_lvt_W66p13_L2p03_m1__nf8_gboth_sdfull_outS_ng_pc G S S S S S D D D D B
+ sky130_fd_pr__nfet_01v8_lvt_4LZ4RL
.ends

.subckt nmos_mirror_load__AB FirstStageYout1 sourceNmos_body sourceNmos outFirstStage
Xnfet_01v8_lvt_W66p13_L2p03_m1__nf8_gboth_sdfull_outS_ng_0 sourceNmos_body FirstStageYout1
+ sourceNmos FirstStageYout1 nfet_01v8_lvt_W66p13_L2p03_m1__nf8_gboth_sdfull_outS_ng
Xnfet_01v8_lvt_W66p13_L2p03_m1__nf8_gboth_sdfull_outS_ng_1 sourceNmos_body FirstStageYout1
+ sourceNmos outFirstStage nfet_01v8_lvt_W66p13_L2p03_m1__nf8_gboth_sdfull_outS_ng
.ends

.subckt sky130_fd_pr__pfet_01v8_lvt_ZLA3LR G w_n301_n811# D0 a_207_n711# S1
X0 a_207_n711# G S1 w_n301_n811# sky130_fd_pr__pfet_01v8_lvt ad=2.0619 pd=14.8 as=1.03095 ps=7.4 w=7.11 l=0.89
X1 S1 G D0 w_n301_n811# sky130_fd_pr__pfet_01v8_lvt ad=1.03095 pd=7.4 as=2.0619 ps=14.8 w=7.11 l=0.89
.ends

.subckt pfet_01v8_lvt_W14p21_L0p89_m1__nf2_gboth_sdfull_outS_ng D B S G
Xpfet_01v8_lvt_W14p21_L0p89_m1__nf2_gboth_sdfull_outS_ng_pc G B S S D sky130_fd_pr__pfet_01v8_lvt_ZLA3LR
.ends

.subckt input_pair__AB FirstStageYsourceTransconductance outFirstStage FirstStageYsourceTransconductance_body
+ in2 FirstStageYout1 in1
Xpfet_01v8_lvt_W14p21_L0p89_m1__nf2_gboth_sdfull_outS_ng_0 FirstStageYout1 FirstStageYsourceTransconductance_body
+ FirstStageYsourceTransconductance in1 pfet_01v8_lvt_W14p21_L0p89_m1__nf2_gboth_sdfull_outS_ng
Xpfet_01v8_lvt_W14p21_L0p89_m1__nf2_gboth_sdfull_outS_ng_1 outFirstStage FirstStageYsourceTransconductance_body
+ FirstStageYsourceTransconductance in2 pfet_01v8_lvt_W14p21_L0p89_m1__nf2_gboth_sdfull_outS_ng
.ends

.subckt loadbench_miller_routed out IBIAS in1 in2 sourceNmos sourcePmos
Xcs_stage__A_0 out sourceNmos sourceNmos cs_stage__A_0/outFirstStage cs_stage__A
Xpmos_bias_bank__row_0 IBIAS sourcePmos out sourcePmos input_pair__AB_0/FirstStageYsourceTransconductance
+ pmos_bias_bank__row
XCapacitor2__A_0 out cs_stage__A_0/outFirstStage Capacitor2__A
Xnmos_mirror_load__AB_0 input_pair__AB_0/FirstStageYout1 sourceNmos sourceNmos cs_stage__A_0/outFirstStage
+ nmos_mirror_load__AB
Xinput_pair__AB_0 input_pair__AB_0/FirstStageYsourceTransconductance cs_stage__A_0/outFirstStage
+ input_pair__AB_0/FirstStageYsourceTransconductance in2 input_pair__AB_0/FirstStageYout1
+ in1 input_pair__AB
.ends
