* ttsky25a_fd on dido_amp_AC
.lib $PDK_ROOT/sky130A/libs.tech/combined/sky130.lib.spice tt
.option rshunt=1e12
.param VDD_V=1.8 VCM_V=0.9 CL_F=529f
.temp 27

**.subckt dido_amp_AC
x1 INP INN OUTN VDD 0 OUTP dut_amp
Vsup VDD 0 'VDD_V'
* AC drive through 1 F couplers; DC set by unity feedback through 1 GH chokes (OUTP->INN, OUTN->INP)
Vacp ACP 0 dc 0 ac 0.5
Vacn ACN 0 dc 0 ac -0.5
Cinp ACP INP 1
Cinn ACN INN 1
Lfbp OUTP INN 1G
Lfbn OUTN INP 1G
Cloadp OUTP 0 'CL_F'
Cloadn OUTN 0 'CL_F'
.control
  save all
  ac dec 40 1 1G
  let hsig = v(OUTP) - v(OUTN)
  let hdb = db(hsig)
  let gph_deg = 180/pi * cph(hsig)
  meas ac gain_db find hdb at=1
  meas ac gbw_hz  when hdb=0
  meas ac ph_dc   find gph_deg at=1
  meas ac ph_ugb  find gph_deg when hdb=0
  let gbw_mhz = gbw_hz / 1e6
  let pm_deg  = 180 + (ph_ugb - ph_dc)
  echo MEAS gain_db $&gain_db
  echo MEAS gbw_mhz $&gbw_mhz
  echo MEAS pm_deg $&pm_deg
  write
  quit 0
.endc
**.ends

.subckt dut_amp INP INN OUTN VDD VSS OUTP
XDUT OUTN OUTP N_RGM N_VREF VDD INN INP VSS N_net3 N_Vop1 N_Vom1 N_net1 N_PBias N_NBias N_net2 N_x2_x1_net4 N_x2_x2_net4 N_x2_x1_net6 N_x2_x2_net6 N_x2_x1_net1 N_x2_x2_net1 N_x2_x1_net10 N_x2_x2_net10 N_x2_x1_net8 N_x2_x2_net8 N_x2_x1_net12 N_x2_x2_net12 N_x2_x1_net14 N_x2_x2_net14 N_x2_x1_net3 N_x2_x2_net3 N_x2_x1_net18 N_x2_x2_net18 N_x2_x1_net16 N_x2_x2_net16 N_x2_Vcm N_x2_x2_net5 N_x2_x1_net5 N_x2_x2_net7 N_x2_x1_net7 N_x2_x2_net11 N_x2_x1_net11 N_x2_x2_net9 N_x2_x1_net9 N_x2_x2_net2 N_x2_x1_net2 N_x2_x2_net13 N_x2_x1_net13 N_x2_x2_net15 N_x2_x1_net15 N_x2_x2_net19 N_x2_x1_net19 N_x2_x2_net17 N_x2_x1_net17 N_x1_Vtest2 N_x1_net2 N_x1_net1 N_x2_Vtest N_x2_Vout N_x2_Vbiasp N_x2_net1 N_net7 N_net6 N_x1_net3 N_x1_net5 N_net5 N_x1_net7 N_x1_net8 N_x1_net4 N_x1_net6 N_net4 N_x1_net9 N_x1_Vout N_x1_Vbias ttsky25a_fd_routed_flat
VVref_ext_layout N_VREF VSS 0.9
RRgm_ext_layout N_RGM VSS 12000.0
.ends
.subckt ttsky25a_fd Vop Vm Vdd Vss Vom Vp
XM32 NBias PBias Vdd Vdd sky130_fd_pr__pfet_01v8_lvt L=1 W=5 NF=1 AD=1.45 AS=1.45 PD=10.58 PS=10.58 NRD=0.058 NRS=0.058 SA=0 SB=0 SD=0 MULT=2 M=2
XM33 NBias NBias Vss Vss sky130_fd_pr__nfet_01v8_lvt L=2 W=5 NF=1 AD=1.45 AS=1.45 PD=10.58 PS=10.58 NRD=0.058 NRS=0.058 SA=0 SB=0 SD=0 MULT=2 M=2
XM34 net1 PBias Vdd Vdd sky130_fd_pr__pfet_01v8_lvt L=1 W=5 NF=1 AD=1.45 AS=1.45 PD=10.58 PS=10.58 NRD=0.058 NRS=0.058 SA=0 SB=0 SD=0 MULT=2 M=2
XM35 net1 net1 Rgm Vss sky130_fd_pr__nfet_01v8_lvt L=1 W=10 NF=1 AD=2.9 AS=2.9 PD=20.58 PS=20.58 NRD=0.029 NRS=0.029 SA=0 SB=0 SD=0 MULT=2 M=2
XM36 net2 net1 Vss Vss sky130_fd_pr__nfet_01v8_lvt L=2 W=5 NF=1 AD=1.45 AS=1.45 PD=10.58 PS=10.58 NRD=0.058 NRS=0.058 SA=0 SB=0 SD=0 MULT=2 M=2
XM37 PBias NBias Vss Vss sky130_fd_pr__nfet_01v8_lvt L=2 W=5 NF=1 AD=1.45 AS=1.45 PD=10.58 PS=10.58 NRD=0.058 NRS=0.058 SA=0 SB=0 SD=0 MULT=2 M=2
XM38 PBias net2 Vdd Vdd sky130_fd_pr__pfet_01v8_lvt L=1 W=5 NF=1 AD=1.45 AS=1.45 PD=10.58 PS=10.58 NRD=0.058 NRS=0.058 SA=0 SB=0 SD=0 MULT=2 M=2
XM39 net2 net2 Vdd Vdd sky130_fd_pr__pfet_01v8_lvt L=1 W=5 NF=1 AD=1.45 AS=1.45 PD=10.58 PS=10.58 NRD=0.058 NRS=0.058 SA=0 SB=0 SD=0 MULT=2 M=2
XM40 PBias net3 NBias Vss sky130_fd_pr__nfet_01v8_lvt L=1 W=2 NF=1 AD=0.58 AS=0.58 PD=4.58 PS=4.58 NRD=0.145 NRS=0.145 SA=0 SB=0 SD=0 MULT=1
XM41 net3 NBias Vss Vss sky130_fd_pr__nfet_01v8_lvt L=2 W=5 NF=1 AD=1.45 AS=1.45 PD=10.58 PS=10.58 NRD=0.058 NRS=0.058 SA=0 SB=0 SD=0 MULT=2 M=2
XM42 net3 net3 Vdd Vdd sky130_fd_pr__pfet_01v8_lvt L=20 W=1 NF=1 AD=0.29 AS=0.29 PD=2.58 PS=2.58 NRD=0.29 NRS=0.29 SA=0 SB=0 SD=0 MULT=2 M=2
XM43 net4 PBias Vdd Vdd sky130_fd_pr__pfet_01v8_lvt L=1 W=5 NF=1 AD=1.45 AS=1.45 PD=10.58 PS=10.58 NRD=0.058 NRS=0.058 SA=0 SB=0 SD=0 MULT=2 M=2
XM44 net5 PBias Vdd Vdd sky130_fd_pr__pfet_01v8_lvt L=1 W=5 NF=1 AD=1.45 AS=1.45 PD=10.58 PS=10.58 NRD=0.058 NRS=0.058 SA=0 SB=0 SD=0 MULT=2 M=2
XM45 net6 PBias Vdd Vdd sky130_fd_pr__pfet_01v8_lvt L=1 W=5 NF=1 AD=1.45 AS=1.45 PD=10.58 PS=10.58 NRD=0.058 NRS=0.058 SA=0 SB=0 SD=0 MULT=2 M=2
XM54 net7 PBias Vdd Vdd sky130_fd_pr__pfet_01v8_lvt L=1 W=5 NF=1 AD=1.45 AS=1.45 PD=10.58 PS=10.58 NRD=0.058 NRS=0.058 SA=0 SB=0 SD=0 MULT=2 M=2
XX1_M5 x1_Vtest2 Vm x1_net2 Vss sky130_fd_pr__nfet_01v8_lvt L=4 W=4 NF=1 AD=1.16 AS=1.16 PD=8.58 PS=8.58 NRD=0.0725 NRS=0.0725 SA=0 SB=0 SD=0 MULT=2 M=2
XX1_M6 x1_net1 Vp x1_net2 Vss sky130_fd_pr__nfet_01v8_lvt L=4 W=4 NF=1 AD=1.16 AS=1.16 PD=8.58 PS=8.58 NRD=0.0725 NRS=0.0725 SA=0 SB=0 SD=0 MULT=2 M=2
XX1_M11 Vop1 x1_Vbias x1_Vtest2 Vdd sky130_fd_pr__pfet_01v8_lvt L=5 W=2 NF=1 AD=0.58 AS=0.58 PD=4.58 PS=4.58 NRD=0.145 NRS=0.145 SA=0 SB=0 SD=0 MULT=2 M=2
XX1_M12 Vom1 x1_Vbias x1_net1 Vdd sky130_fd_pr__pfet_01v8_lvt L=5 W=2 NF=1 AD=0.58 AS=0.58 PD=4.58 PS=4.58 NRD=0.145 NRS=0.145 SA=0 SB=0 SD=0 MULT=2 M=2
XX1_M13 x1_Vtest2 x1_Vout Vdd Vdd sky130_fd_pr__pfet_01v8_lvt L=5 W=2 NF=1 AD=0.58 AS=0.58 PD=4.58 PS=4.58 NRD=0.145 NRS=0.145 SA=0 SB=0 SD=0 MULT=4 M=4
XX1_M14 x1_net1 x1_Vout Vdd Vdd sky130_fd_pr__pfet_01v8_lvt L=5 W=2 NF=1 AD=0.58 AS=0.58 PD=4.58 PS=4.58 NRD=0.145 NRS=0.145 SA=0 SB=0 SD=0 MULT=4 M=4
XX1_M19 x1_net2 net5 x1_net3 Vss sky130_fd_pr__nfet_01v8_lvt L=1 W=1 NF=1 AD=0.29 AS=0.29 PD=2.58 PS=2.58 NRD=0.29 NRS=0.29 SA=0 SB=0 SD=0 MULT=2 M=2
XX1_M1 x1_net3 net4 Vss Vss sky130_fd_pr__nfet_01v8_lvt L=10 W=1 NF=1 AD=0.29 AS=0.29 PD=2.58 PS=2.58 NRD=0.29 NRS=0.29 SA=0 SB=0 SD=0 MULT=2 M=2
XX1_M2 x1_net4 net4 Vss Vss sky130_fd_pr__nfet_01v8_lvt L=10 W=1 NF=1 AD=0.29 AS=0.29 PD=2.58 PS=2.58 NRD=0.29 NRS=0.29 SA=0 SB=0 SD=0 MULT=2 M=2
XX1_M3 x1_net2 net5 x1_net4 Vss sky130_fd_pr__nfet_01v8_lvt L=1 W=1 NF=1 AD=0.29 AS=0.29 PD=2.58 PS=2.58 NRD=0.29 NRS=0.29 SA=0 SB=0 SD=0 MULT=2 M=2
XX1_M4 Vop1 net5 x1_net5 Vss sky130_fd_pr__nfet_01v8_lvt L=1 W=1 NF=1 AD=0.29 AS=0.29 PD=2.58 PS=2.58 NRD=0.29 NRS=0.29 SA=0 SB=0 SD=0 MULT=2 M=2
XX1_M7 x1_net5 net4 Vss Vss sky130_fd_pr__nfet_01v8_lvt L=10 W=1 NF=1 AD=0.29 AS=0.29 PD=2.58 PS=2.58 NRD=0.29 NRS=0.29 SA=0 SB=0 SD=0 MULT=2 M=2
XX1_M8 Vom1 net5 x1_net6 Vss sky130_fd_pr__nfet_01v8_lvt L=1 W=1 NF=1 AD=0.29 AS=0.29 PD=2.58 PS=2.58 NRD=0.29 NRS=0.29 SA=0 SB=0 SD=0 MULT=2 M=2
XX1_M9 x1_net6 net4 Vss Vss sky130_fd_pr__nfet_01v8_lvt L=10 W=1 NF=1 AD=0.29 AS=0.29 PD=2.58 PS=2.58 NRD=0.29 NRS=0.29 SA=0 SB=0 SD=0 MULT=2 M=2
XX1_M10 x1_Vout Vref x1_net8 Vss sky130_fd_pr__nfet_01v8_lvt L=20 W=5 NF=1 AD=1.45 AS=1.45 PD=10.58 PS=10.58 NRD=0.058 NRS=0.058 SA=0 SB=0 SD=0 MULT=2 M=2
XX1_M17 x1_net9 Vop1 x1_net8 Vss sky130_fd_pr__nfet_01v8_lvt L=20 W=5 NF=1 AD=1.45 AS=1.45 PD=10.58 PS=10.58 NRD=0.058 NRS=0.058 SA=0 SB=0 SD=0 MULT=2 M=2
XX1_M18 x1_net9 Vom1 x1_net7 Vss sky130_fd_pr__nfet_01v8_lvt L=20 W=5 NF=1 AD=1.45 AS=1.45 PD=10.58 PS=10.58 NRD=0.058 NRS=0.058 SA=0 SB=0 SD=0 MULT=2 M=2
XX1_M22 x1_net7 net4 Vss Vss sky130_fd_pr__nfet_01v8_lvt L=20 W=1 NF=1 AD=0.29 AS=0.29 PD=2.58 PS=2.58 NRD=0.29 NRS=0.29 SA=0 SB=0 SD=0 MULT=2 M=2
XX1_M20 x1_net9 x1_net9 Vdd Vdd sky130_fd_pr__pfet_01v8_lvt L=10 W=1 NF=1 AD=0.29 AS=0.29 PD=2.58 PS=2.58 NRD=0.29 NRS=0.29 SA=0 SB=0 SD=0 MULT=2 M=2
XX1_M21 x1_Vout x1_net9 Vdd Vdd sky130_fd_pr__pfet_01v8_lvt L=10 W=1 NF=1 AD=0.29 AS=0.29 PD=2.58 PS=2.58 NRD=0.29 NRS=0.29 SA=0 SB=0 SD=0 MULT=2 M=2
XX1_M15 x1_net8 net4 Vss Vss sky130_fd_pr__nfet_01v8_lvt L=20 W=1 NF=1 AD=0.29 AS=0.29 PD=2.58 PS=2.58 NRD=0.29 NRS=0.29 SA=0 SB=0 SD=0 MULT=2 M=2
XX1_M16 x1_Vout Vref x1_net7 Vss sky130_fd_pr__nfet_01v8_lvt L=20 W=5 NF=1 AD=1.45 AS=1.45 PD=10.58 PS=10.58 NRD=0.058 NRS=0.058 SA=0 SB=0 SD=0 MULT=2 M=2
XX1_M46 net4 net4 Vss Vss sky130_fd_pr__nfet_01v8_lvt L=2 W=1 NF=1 AD=0.29 AS=0.29 PD=2.58 PS=2.58 NRD=0.29 NRS=0.29 SA=0 SB=0 SD=0 MULT=2 M=2
XX1_M47 net5 net5 Vss Vss sky130_fd_pr__nfet_01v8_lvt L=5 W=0.6 NF=1 AD=0.174 AS=0.174 PD=1.78 PS=1.78 NRD=0.483333 NRS=0.483333 SA=0 SB=0 SD=0 MULT=2 M=2
XX1_M23 net6 net6 Vss Vss sky130_fd_pr__nfet_01v8_lvt L=1 W=0.6 NF=1 AD=0.174 AS=0.174 PD=1.78 PS=1.78 NRD=0.483333 NRS=0.483333 SA=0 SB=0 SD=0 MULT=2 M=2
XX1_M24 x1_Vbias net6 Vss Vss sky130_fd_pr__nfet_01v8_lvt L=1 W=0.6 NF=1 AD=0.174 AS=0.174 PD=1.78 PS=1.78 NRD=0.483333 NRS=0.483333 SA=0 SB=0 SD=0 MULT=2 M=2
XX1_M25 x1_Vbias x1_Vbias Vdd Vdd sky130_fd_pr__pfet_01v8_lvt L=10 W=1.5 NF=1 AD=0.435 AS=0.435 PD=3.58 PS=3.58 NRD=0.193333 NRS=0.193333 SA=0 SB=0 SD=0 MULT=2 M=2
XX2_M9 Vop Vom1 Vdd Vdd sky130_fd_pr__pfet_01v8_lvt L=1 W=2 NF=1 AD=0.58 AS=0.58 PD=4.58 PS=4.58 NRD=0.145 NRS=0.145 SA=0 SB=0 SD=0 MULT=9 M=9
XX2_M4 Vom Vop1 Vdd Vdd sky130_fd_pr__pfet_01v8_lvt L=1 W=2 NF=1 AD=0.58 AS=0.58 PD=4.58 PS=4.58 NRD=0.145 NRS=0.145 SA=0 SB=0 SD=0 MULT=9 M=9
XX2_M2 Vop x2_Vout Vss Vss sky130_fd_pr__nfet_01v8_lvt L=1 W=1 NF=1 AD=0.29 AS=0.29 PD=2.58 PS=2.58 NRD=0.29 NRS=0.29 SA=0 SB=0 SD=0 MULT=9 M=9
XX2_M1 Vom x2_Vout Vss Vss sky130_fd_pr__nfet_01v8_lvt L=1 W=1 NF=1 AD=0.29 AS=0.29 PD=2.58 PS=2.58 NRD=0.29 NRS=0.29 SA=0 SB=0 SD=0 MULT=9 M=9
XX2_M3 x2_net1 x2_Vbiasp Vdd Vdd sky130_fd_pr__pfet_01v8_lvt L=5 W=1 NF=1 AD=0.29 AS=0.29 PD=2.58 PS=2.58 NRD=0.29 NRS=0.29 SA=0 SB=0 SD=0 MULT=2 M=2
XX2_M7 x2_Vtest x2_Vcm x2_net1 Vdd sky130_fd_pr__pfet_01v8_lvt L=10 W=1 NF=1 AD=0.29 AS=0.29 PD=2.58 PS=2.58 NRD=0.29 NRS=0.29 SA=0 SB=0 SD=0 MULT=2 M=2
XX2_M8 x2_Vout Vref x2_net1 Vdd sky130_fd_pr__pfet_01v8_lvt L=10 W=1 NF=1 AD=0.29 AS=0.29 PD=2.58 PS=2.58 NRD=0.29 NRS=0.29 SA=0 SB=0 SD=0 MULT=2 M=2
XX2_M5 x2_Vtest x2_Vtest Vss Vss sky130_fd_pr__nfet_01v8_lvt L=20 W=0.5 NF=1 AD=0.145 AS=0.145 PD=1.58 PS=1.58 NRD=0.58 NRS=0.58 SA=0 SB=0 SD=0 MULT=2 M=2
XX2_M6 x2_Vout x2_Vtest Vss Vss sky130_fd_pr__nfet_01v8_lvt L=20 W=0.5 NF=1 AD=0.145 AS=0.145 PD=1.58 PS=1.58 NRD=0.58 NRS=0.58 SA=0 SB=0 SD=0 MULT=2 M=2
XX2_M10 net7 net7 Vss Vss sky130_fd_pr__nfet_01v8_lvt L=1 W=0.6 NF=1 AD=0.174 AS=0.174 PD=1.78 PS=1.78 NRD=0.483333 NRS=0.483333 SA=0 SB=0 SD=0 MULT=2 M=2
XX2_M11 x2_Vbiasp net7 Vss Vss sky130_fd_pr__nfet_01v8_lvt L=1 W=0.6 NF=1 AD=0.174 AS=0.174 PD=1.78 PS=1.78 NRD=0.483333 NRS=0.483333 SA=0 SB=0 SD=0 MULT=2 M=2
XX2_M12 x2_Vbiasp x2_Vbiasp Vdd Vdd sky130_fd_pr__pfet_01v8_lvt L=1 W=6 NF=1 AD=1.74 AS=1.74 PD=12.58 PS=12.58 NRD=0.0483333 NRS=0.0483333 SA=0 SB=0 SD=0 MULT=2 M=2
Vref_ext Vref Vss 0.9
XC1 Vop1 Vom sky130_fd_pr__cap_mim_m3_1 W=10 L=10 MF=5 M=5
XC2 Vom1 Vop sky130_fd_pr__cap_mim_m3_1 W=10 L=10 MF=5 M=5
XX2_X1_R1 x2_x1_net4 Vop sky130_fd_pr__res_generic_po W=0.5 L=40
XX2_X1_R2 x2_x1_net5 x2_x1_net4 sky130_fd_pr__res_generic_po W=0.5 L=40
XX2_X1_R3 x2_x1_net6 x2_x1_net5 sky130_fd_pr__res_generic_po W=0.5 L=40
XX2_X1_R4 x2_x1_net7 x2_x1_net6 sky130_fd_pr__res_generic_po W=0.5 L=40
XX2_X1_R5 x2_x1_net1 x2_x1_net7 sky130_fd_pr__res_generic_po W=0.5 L=40
XX2_X1_R6 x2_x1_net8 x2_x1_net2 sky130_fd_pr__res_generic_po W=0.5 L=40
XX2_X1_R7 x2_x1_net9 x2_x1_net8 sky130_fd_pr__res_generic_po W=0.5 L=40
XX2_X1_R8 x2_x1_net10 x2_x1_net9 sky130_fd_pr__res_generic_po W=0.5 L=40
XX2_X1_R9 x2_x1_net11 x2_x1_net10 sky130_fd_pr__res_generic_po W=0.5 L=40
XX2_X1_R10 x2_x1_net1 x2_x1_net11 sky130_fd_pr__res_generic_po W=0.5 L=40
XX2_X1_R11 x2_x1_net12 x2_x1_net2 sky130_fd_pr__res_generic_po W=0.5 L=40
XX2_X1_R12 x2_x1_net13 x2_x1_net12 sky130_fd_pr__res_generic_po W=0.5 L=40
XX2_X1_R13 x2_x1_net14 x2_x1_net13 sky130_fd_pr__res_generic_po W=0.5 L=40
XX2_X1_R14 x2_x1_net15 x2_x1_net14 sky130_fd_pr__res_generic_po W=0.5 L=40
XX2_X1_R16 x2_x1_net16 x2_Vcm sky130_fd_pr__res_generic_po W=0.5 L=40
XX2_X1_R17 x2_x1_net17 x2_x1_net16 sky130_fd_pr__res_generic_po W=0.5 L=40
XX2_X1_R18 x2_x1_net18 x2_x1_net17 sky130_fd_pr__res_generic_po W=0.5 L=40
XX2_X1_R19 x2_x1_net19 x2_x1_net18 sky130_fd_pr__res_generic_po W=0.5 L=40
XX2_X1_R20 x2_x1_net3 x2_x1_net19 sky130_fd_pr__res_generic_po W=0.5 L=40
XX2_X1_R15 x2_x1_net3 x2_x1_net15 sky130_fd_pr__res_generic_po W=0.5 L=40
XX2_X2_R1 x2_x2_net4 x2_Vcm sky130_fd_pr__res_generic_po W=0.5 L=40
XX2_X2_R2 x2_x2_net5 x2_x2_net4 sky130_fd_pr__res_generic_po W=0.5 L=40
XX2_X2_R3 x2_x2_net6 x2_x2_net5 sky130_fd_pr__res_generic_po W=0.5 L=40
XX2_X2_R4 x2_x2_net7 x2_x2_net6 sky130_fd_pr__res_generic_po W=0.5 L=40
XX2_X2_R5 x2_x2_net1 x2_x2_net7 sky130_fd_pr__res_generic_po W=0.5 L=40
XX2_X2_R6 x2_x2_net8 x2_x2_net2 sky130_fd_pr__res_generic_po W=0.5 L=40
XX2_X2_R7 x2_x2_net9 x2_x2_net8 sky130_fd_pr__res_generic_po W=0.5 L=40
XX2_X2_R8 x2_x2_net10 x2_x2_net9 sky130_fd_pr__res_generic_po W=0.5 L=40
XX2_X2_R9 x2_x2_net11 x2_x2_net10 sky130_fd_pr__res_generic_po W=0.5 L=40
XX2_X2_R10 x2_x2_net1 x2_x2_net11 sky130_fd_pr__res_generic_po W=0.5 L=40
XX2_X2_R11 x2_x2_net12 x2_x2_net2 sky130_fd_pr__res_generic_po W=0.5 L=40
XX2_X2_R12 x2_x2_net13 x2_x2_net12 sky130_fd_pr__res_generic_po W=0.5 L=40
XX2_X2_R13 x2_x2_net14 x2_x2_net13 sky130_fd_pr__res_generic_po W=0.5 L=40
XX2_X2_R14 x2_x2_net15 x2_x2_net14 sky130_fd_pr__res_generic_po W=0.5 L=40
XX2_X2_R16 x2_x2_net16 Vom sky130_fd_pr__res_generic_po W=0.5 L=40
XX2_X2_R17 x2_x2_net17 x2_x2_net16 sky130_fd_pr__res_generic_po W=0.5 L=40
XX2_X2_R18 x2_x2_net18 x2_x2_net17 sky130_fd_pr__res_generic_po W=0.5 L=40
XX2_X2_R19 x2_x2_net19 x2_x2_net18 sky130_fd_pr__res_generic_po W=0.5 L=40
XX2_X2_R20 x2_x2_net3 x2_x2_net19 sky130_fd_pr__res_generic_po W=0.5 L=40
XX2_X2_R15 x2_x2_net3 x2_x2_net15 sky130_fd_pr__res_generic_po W=0.5 L=40
Rgm_ext Rgm Vss 12000
.ends ttsky25a_fd
* NGSPICE file created from ttsky25a_fd_routed_flat.ext - technology: sky130A

.subckt ttsky25a_fd_routed_flat Vom Vop RGM VREF Vdd Vm Vp Vss pmos_diode__A_0.net3
+ XC1__A_0.Vop1 XC2__A_0.Vom1 nmos_diode__A_0.net1 nmos_single_2__A_0.PBias nmos_single_2__A_0.NBias
+ nmos_single__A_0.net2 res_packs__interleaved_0.x2_x1_net4 res_packs__interleaved_0.x2_x2_net4
+ res_packs__interleaved_0.x2_x1_net6 res_packs__interleaved_0.x2_x2_net6 res_packs__interleaved_0.x2_x1_net1
+ res_packs__interleaved_0.x2_x2_net1 res_packs__interleaved_0.x2_x1_net10 res_packs__interleaved_0.x2_x2_net10
+ res_packs__interleaved_0.x2_x1_net8 res_packs__interleaved_0.x2_x2_net8 res_packs__interleaved_0.x2_x1_net12
+ res_packs__interleaved_0.x2_x2_net12 res_packs__interleaved_0.x2_x1_net14 res_packs__interleaved_0.x2_x2_net14
+ res_packs__interleaved_0.x2_x1_net3 res_packs__interleaved_0.x2_x2_net3 res_packs__interleaved_0.x2_x1_net18
+ res_packs__interleaved_0.x2_x2_net18 res_packs__interleaved_0.x2_x1_net16 res_packs__interleaved_0.x2_x2_net16
+ res_packs__interleaved_0.x2_Vcm res_packs__interleaved_0.x2_x2_net5 res_packs__interleaved_0.x2_x1_net5
+ res_packs__interleaved_0.x2_x2_net7 res_packs__interleaved_0.x2_x1_net7 res_packs__interleaved_0.x2_x2_net11
+ res_packs__interleaved_0.x2_x1_net11 res_packs__interleaved_0.x2_x2_net9 res_packs__interleaved_0.x2_x1_net9
+ res_packs__interleaved_0.x2_x2_net2 res_packs__interleaved_0.x2_x1_net2 res_packs__interleaved_0.x2_x2_net13
+ res_packs__interleaved_0.x2_x1_net13 res_packs__interleaved_0.x2_x2_net15 res_packs__interleaved_0.x2_x1_net15
+ res_packs__interleaved_0.x2_x2_net19 res_packs__interleaved_0.x2_x1_net19 res_packs__interleaved_0.x2_x2_net17
+ res_packs__interleaved_0.x2_x1_net17 nmos_differential_pair__ABAB_0.x1_Vtest2 nmos_differential_pair__ABAB_0.x1_net2
+ nmos_differential_pair__ABAB_0.x1_net1 pmos_differential_pair__ABBA_0.x2_Vtest pmos_differential_pair__ABBA_0.x2_Vout
+ pmos_current_mirror_2__row_0.x2_Vbiasp pmos_current_mirror_2__row_0.x2_net1 nmos_current_mirror_3__ABAB_0.net7
+ nmos_current_mirror_2__ABBA_0.net6 nmos_matched_cascode_pair__ABBA_0.x1_net3 nmos_matched_cascode_pair__ABBA_0.x1_net5
+ nmos_diode_2__A_0.net5 mirror_XX1_M22_XX1_M15__ABAB_0.x1_net7 mirror_XX1_M22_XX1_M15__ABAB_0.x1_net8
+ nmos_matched_cascode_pair_2__ABAB_0.x1_net4 nmos_matched_cascode_pair_2__ABAB_0.x1_net6
+ nmos_current_mirror_4__A_0.net4 pmos_current_mirror_load__ABAB_0.x1_net9 pmos_current_mirror_load__ABAB_0.x1_Vout
+ pmos_diode_2__A_0.x1_Vbias
X0 nmos_differential_pair__ABAB_0.x1_net1 pmos_current_mirror_load__ABAB_0.x1_Vout Vdd Vdd sky130_fd_pr__pfet_01v8_lvt ad=0.145 pd=1.29 as=0.29 ps=2.58 w=1 l=5
X1 nmos_current_mirror_2__ABBA_0.net6 nmos_current_mirror_2__ABBA_0.net6 Vss Vss sky130_fd_pr__nfet_01v8_lvt ad=0.174 pd=1.78 as=0.174 ps=1.78 w=0.6 l=1
X2 Vss Vss Vss Vss sky130_fd_pr__nfet_01v8_lvt ad=0.29 pd=2.58 as=53.012 ps=424.76001 w=1 l=10
X3 Vss pmos_differential_pair__ABBA_0.x2_Vout Vom Vss sky130_fd_pr__nfet_01v8_lvt ad=0.29 pd=2.58 as=0.29 ps=2.58 w=1 l=1
X4 Vdd XC2__A_0.Vom1 Vop Vdd sky130_fd_pr__pfet_01v8_lvt ad=0.29 pd=2.58 as=0.145 ps=1.29 w=1 l=1
X5 Vdd Vdd Vdd Vdd sky130_fd_pr__pfet_01v8_lvt ad=0.145 pd=1.29 as=78.01 ps=607.59998 w=1 l=5
X6 mirror_XX1_M22_XX1_M15__ABAB_0.x1_net7 XC2__A_0.Vom1 pmos_current_mirror_load__ABAB_0.x1_net9 Vss sky130_fd_pr__nfet_01v8_lvt ad=1.45 pd=10.58 as=1.45 ps=10.58 w=5 l=20
X7 res_packs__interleaved_0.x2_x1_net1 res_packs__interleaved_0.x2_x1_net7 sky130_fd_pr__res_generic_po w=0.5 l=40
X8 Vss nmos_single_2__A_0.NBias pmos_diode__A_0.net3 Vss sky130_fd_pr__nfet_01v8_lvt ad=1.45 pd=10.58 as=1.45 ps=10.58 w=5 l=2
X9 nmos_differential_pair__ABAB_0.x1_Vtest2 pmos_current_mirror_load__ABAB_0.x1_Vout Vdd Vdd sky130_fd_pr__pfet_01v8_lvt ad=0.145 pd=1.29 as=0.29 ps=2.58 w=1 l=5
X10 XC1__A_0.Vop1 Vom sky130_fd_pr__cap_mim_m3_1 l=10 w=10
Cmimself0 XC1__A_0.Vop1 Vom -9.7061f
X11 Vdd XC2__A_0.Vom1 Vop Vdd sky130_fd_pr__pfet_01v8_lvt ad=0.29 pd=2.58 as=0.145 ps=1.29 w=1 l=1
X12 XC2__A_0.Vom1 Vop sky130_fd_pr__cap_mim_m3_1 l=10 w=10
Cmimself1 XC2__A_0.Vom1 Vop -9.7061f
X13 Vss nmos_current_mirror_4__A_0.net4 nmos_matched_cascode_pair_2__ABAB_0.x1_net6 Vss sky130_fd_pr__nfet_01v8_lvt ad=0.29 pd=2.58 as=0.29 ps=2.58 w=1 l=10
X14 Vss pmos_differential_pair__ABBA_0.x2_Vout Vop Vss sky130_fd_pr__nfet_01v8_lvt ad=0.29 pd=2.58 as=0.29 ps=2.58 w=1 l=1
X15 Vdd Vdd Vdd Vdd sky130_fd_pr__pfet_01v8_lvt ad=0.145 pd=1.29 as=0 ps=0 w=1 l=5
X16 Vdd pmos_current_mirror_load__ABAB_0.x1_Vout nmos_differential_pair__ABAB_0.x1_Vtest2 Vdd sky130_fd_pr__pfet_01v8_lvt ad=0.29 pd=2.58 as=0.145 ps=1.29 w=1 l=5
X17 Vop XC2__A_0.Vom1 Vdd Vdd sky130_fd_pr__pfet_01v8_lvt ad=0.145 pd=1.29 as=0.29 ps=2.58 w=1 l=1
X18 Vdd pmos_current_mirror_2__row_0.x2_Vbiasp pmos_current_mirror_2__row_0.x2_Vbiasp Vdd sky130_fd_pr__pfet_01v8_lvt ad=1.74 pd=12.58 as=1.74 ps=12.58 w=6 l=1
X19 Vdd pmos_current_mirror_load__ABAB_0.x1_Vout nmos_differential_pair__ABAB_0.x1_Vtest2 Vdd sky130_fd_pr__pfet_01v8_lvt ad=0.29 pd=2.58 as=0.145 ps=1.29 w=1 l=5
X20 Vss Vss Vss Vss sky130_fd_pr__nfet_01v8_lvt ad=0.29 pd=2.58 as=0 ps=0 w=1 l=10
X21 Vss nmos_current_mirror_3__ABAB_0.net7 pmos_current_mirror_2__row_0.x2_Vbiasp Vss sky130_fd_pr__nfet_01v8_lvt ad=0.174 pd=1.78 as=0.174 ps=1.78 w=0.6 l=1
X22 Vss Vss sky130_fd_pr__res_generic_po w=0.5 l=40
X23 Vss nmos_current_mirror_3__ABAB_0.net7 pmos_current_mirror_2__row_0.x2_Vbiasp Vss sky130_fd_pr__nfet_01v8_lvt ad=0.174 pd=1.78 as=0.174 ps=1.78 w=0.6 l=1
X24 res_packs__interleaved_0.x2_x2_net16 Vom sky130_fd_pr__res_generic_po w=0.5 l=40
X25 Vdd Vdd Vdd Vdd sky130_fd_pr__pfet_01v8_lvt ad=0.29 pd=2.58 as=0 ps=0 w=1 l=5
X26 Vdd pmos_current_mirror_load__ABAB_0.x1_Vout nmos_differential_pair__ABAB_0.x1_Vtest2 Vdd sky130_fd_pr__pfet_01v8_lvt ad=0.29 pd=2.58 as=0.145 ps=1.29 w=1 l=5
X27 nmos_matched_cascode_pair_2__ABAB_0.x1_net4 nmos_diode_2__A_0.net5 nmos_differential_pair__ABAB_0.x1_net2 Vss sky130_fd_pr__nfet_01v8_lvt ad=0.29 pd=2.58 as=0.29 ps=2.58 w=1 l=1
X28 res_packs__interleaved_0.x2_x2_net14 res_packs__interleaved_0.x2_x2_net13 sky130_fd_pr__res_generic_po w=0.5 l=40
X29 Vss Vss Vss Vss sky130_fd_pr__nfet_01v8_lvt ad=0.174 pd=1.78 as=0 ps=0 w=0.6 l=1
X30 Vss pmos_differential_pair__ABBA_0.x2_Vout Vom Vss sky130_fd_pr__nfet_01v8_lvt ad=0.29 pd=2.58 as=0.29 ps=2.58 w=1 l=1
X31 res_packs__interleaved_0.x2_x2_net4 res_packs__interleaved_0.x2_Vcm sky130_fd_pr__res_generic_po w=0.5 l=40
X32 nmos_differential_pair__ABAB_0.x1_net1 pmos_current_mirror_load__ABAB_0.x1_Vout Vdd Vdd sky130_fd_pr__pfet_01v8_lvt ad=0.145 pd=1.29 as=0.29 ps=2.58 w=1 l=5
X33 Vss Vss Vss Vss sky130_fd_pr__nfet_01v8_lvt ad=0.29 pd=2.58 as=0 ps=0 w=1 l=20
X34 Vss pmos_differential_pair__ABBA_0.x2_Vout Vom Vss sky130_fd_pr__nfet_01v8_lvt ad=0.29 pd=2.58 as=0.29 ps=2.58 w=1 l=1
X35 Vss pmos_differential_pair__ABBA_0.x2_Vout Vom Vss sky130_fd_pr__nfet_01v8_lvt ad=0.29 pd=2.58 as=0.29 ps=2.58 w=1 l=1
X36 res_packs__interleaved_0.x2_x2_net12 res_packs__interleaved_0.x2_x2_net2 sky130_fd_pr__res_generic_po w=0.5 l=40
X37 Vdd nmos_single__A_0.net2 nmos_single__A_0.net2 Vdd sky130_fd_pr__pfet_01v8_lvt ad=1.45 pd=10.58 as=1.45 ps=10.58 w=5 l=1
X38 Vdd Vdd Vdd Vdd sky130_fd_pr__pfet_01v8_lvt ad=0.29 pd=2.58 as=0 ps=0 w=1 l=10
X39 Vdd nmos_single__A_0.net2 nmos_single__A_0.net2 Vdd sky130_fd_pr__pfet_01v8_lvt ad=1.45 pd=10.58 as=1.45 ps=10.58 w=5 l=1
X40 res_packs__interleaved_0.x2_x1_net18 res_packs__interleaved_0.x2_x1_net19 sky130_fd_pr__res_generic_po w=0.5 l=40
X41 nmos_differential_pair__ABAB_0.x1_net2 Vm nmos_differential_pair__ABAB_0.x1_Vtest2 Vss sky130_fd_pr__nfet_01v8_lvt ad=1.16 pd=8.58 as=1.16 ps=8.58 w=4 l=4
X42 pmos_current_mirror_2__row_0.x2_net1 res_packs__interleaved_0.x2_Vcm pmos_differential_pair__ABBA_0.x2_Vtest Vdd sky130_fd_pr__pfet_01v8_lvt ad=0.29 pd=2.58 as=0.29 ps=2.58 w=1 l=10
X43 res_packs__interleaved_0.x2_x1_net8 res_packs__interleaved_0.x2_x1_net2 sky130_fd_pr__res_generic_po w=0.5 l=40
X44 res_packs__interleaved_0.x2_x2_net6 res_packs__interleaved_0.x2_x2_net7 sky130_fd_pr__res_generic_po w=0.5 l=40
X45 nmos_differential_pair__ABAB_0.x1_net1 pmos_current_mirror_load__ABAB_0.x1_Vout Vdd Vdd sky130_fd_pr__pfet_01v8_lvt ad=0.145 pd=1.29 as=0.29 ps=2.58 w=1 l=5
X46 Vss nmos_current_mirror_4__A_0.net4 nmos_matched_cascode_pair__ABBA_0.x1_net5 Vss sky130_fd_pr__nfet_01v8_lvt ad=0.29 pd=2.58 as=0.29 ps=2.58 w=1 l=10
X47 Vss pmos_differential_pair__ABBA_0.x2_Vout Vop Vss sky130_fd_pr__nfet_01v8_lvt ad=0.29 pd=2.58 as=0.29 ps=2.58 w=1 l=1
X48 Vss pmos_differential_pair__ABBA_0.x2_Vtest pmos_differential_pair__ABBA_0.x2_Vout Vss sky130_fd_pr__nfet_01v8_lvt ad=0.145 pd=1.58 as=0.145 ps=1.58 w=0.5 l=20
X49 Vdd pmos_current_mirror_load__ABAB_0.x1_net9 pmos_current_mirror_load__ABAB_0.x1_net9 Vdd sky130_fd_pr__pfet_01v8_lvt ad=0.29 pd=2.58 as=0.29 ps=2.58 w=1 l=10
X50 Vdd pmos_current_mirror_2__row_0.x2_Vbiasp pmos_current_mirror_2__row_0.x2_net1 Vdd sky130_fd_pr__pfet_01v8_lvt ad=0.29 pd=2.58 as=0.29 ps=2.58 w=1 l=5
X51 res_packs__interleaved_0.x2_x2_net10 res_packs__interleaved_0.x2_x2_net11 sky130_fd_pr__res_generic_po w=0.5 l=40
X52 Vss nmos_diode__A_0.net1 nmos_single__A_0.net2 Vss sky130_fd_pr__nfet_01v8_lvt ad=1.45 pd=10.58 as=1.45 ps=10.58 w=5 l=2
X53 Vss nmos_current_mirror_4__A_0.net4 mirror_XX1_M22_XX1_M15__ABAB_0.x1_net7 Vss sky130_fd_pr__nfet_01v8_lvt ad=0.29 pd=2.58 as=0.29 ps=2.58 w=1 l=20
X54 Vss Vss Vss Vss sky130_fd_pr__nfet_01v8_lvt ad=0.29 pd=2.58 as=0 ps=0 w=1 l=1
X55 Vdd pmos_current_mirror_load__ABAB_0.x1_Vout nmos_differential_pair__ABAB_0.x1_Vtest2 Vdd sky130_fd_pr__pfet_01v8_lvt ad=0.29 pd=2.58 as=0.145 ps=1.29 w=1 l=5
X56 Vss nmos_diode_2__A_0.net5 nmos_diode_2__A_0.net5 Vss sky130_fd_pr__nfet_01v8_lvt ad=0.174 pd=1.78 as=0.174 ps=1.78 w=0.6 l=5
X57 res_packs__interleaved_0.x2_x1_net6 res_packs__interleaved_0.x2_x1_net7 sky130_fd_pr__res_generic_po w=0.5 l=40
X58 Vdd XC2__A_0.Vom1 Vop Vdd sky130_fd_pr__pfet_01v8_lvt ad=0.29 pd=2.58 as=0.145 ps=1.29 w=1 l=1
X59 Vss Vss Vss Vss sky130_fd_pr__nfet_01v8_lvt ad=1.45 pd=10.58 as=0 ps=0 w=5 l=2
X60 Vdd Vdd Vdd Vdd sky130_fd_pr__pfet_01v8_lvt ad=1.45 pd=10.58 as=0 ps=0 w=5 l=1
X61 Vdd nmos_single_2__A_0.PBias nmos_diode_2__A_0.net5 Vdd sky130_fd_pr__pfet_01v8_lvt ad=1.45 pd=10.58 as=1.45 ps=10.58 w=5 l=1
X62 Vdd nmos_single_2__A_0.PBias nmos_current_mirror_3__ABAB_0.net7 Vdd sky130_fd_pr__pfet_01v8_lvt ad=1.45 pd=10.58 as=1.45 ps=10.58 w=5 l=1
X63 Vdd Vdd Vdd Vdd sky130_fd_pr__pfet_01v8_lvt ad=1.45 pd=10.58 as=0 ps=0 w=5 l=1
X64 Vss nmos_diode_2__A_0.net5 nmos_diode_2__A_0.net5 Vss sky130_fd_pr__nfet_01v8_lvt ad=0.174 pd=1.78 as=0.174 ps=1.78 w=0.6 l=5
X65 Vdd nmos_single_2__A_0.PBias nmos_diode_2__A_0.net5 Vdd sky130_fd_pr__pfet_01v8_lvt ad=1.45 pd=10.58 as=1.45 ps=10.58 w=5 l=1
X66 Vom XC1__A_0.Vop1 Vdd Vdd sky130_fd_pr__pfet_01v8_lvt ad=0.145 pd=1.29 as=0.29 ps=2.58 w=1 l=1
X67 Vdd Vdd Vdd Vdd sky130_fd_pr__pfet_01v8_lvt ad=1.45 pd=10.58 as=0 ps=0 w=5 l=1
X68 nmos_diode__A_0.net1 nmos_single_2__A_0.PBias Vdd Vdd sky130_fd_pr__pfet_01v8_lvt ad=1.45 pd=10.58 as=1.45 ps=10.58 w=5 l=1
X69 Vdd pmos_diode__A_0.net3 pmos_diode__A_0.net3 Vdd sky130_fd_pr__pfet_01v8_lvt ad=0.29 pd=2.58 as=0.29 ps=2.58 w=1 l=20
X70 nmos_differential_pair__ABAB_0.x1_net1 pmos_current_mirror_load__ABAB_0.x1_Vout Vdd Vdd sky130_fd_pr__pfet_01v8_lvt ad=0.145 pd=1.29 as=0.29 ps=2.58 w=1 l=5
X71 Vss nmos_current_mirror_4__A_0.net4 nmos_current_mirror_4__A_0.net4 Vss sky130_fd_pr__nfet_01v8_lvt ad=0.29 pd=2.58 as=0.29 ps=2.58 w=1 l=2
X72 Vop XC2__A_0.Vom1 Vdd Vdd sky130_fd_pr__pfet_01v8_lvt ad=0.145 pd=1.29 as=0.29 ps=2.58 w=1 l=1
X73 Vss nmos_diode__A_0.net1 nmos_single__A_0.net2 Vss sky130_fd_pr__nfet_01v8_lvt ad=1.45 pd=10.58 as=1.45 ps=10.58 w=5 l=2
X74 Vdd nmos_single_2__A_0.PBias nmos_single_2__A_0.NBias Vdd sky130_fd_pr__pfet_01v8_lvt ad=1.45 pd=10.58 as=1.45 ps=10.58 w=5 l=1
X75 Vss pmos_differential_pair__ABBA_0.x2_Vout Vom Vss sky130_fd_pr__nfet_01v8_lvt ad=0.29 pd=2.58 as=0.29 ps=2.58 w=1 l=1
X76 res_packs__interleaved_0.x2_x1_net16 res_packs__interleaved_0.x2_Vcm sky130_fd_pr__res_generic_po w=0.5 l=40
X77 Vdd XC1__A_0.Vop1 Vom Vdd sky130_fd_pr__pfet_01v8_lvt ad=0.29 pd=2.58 as=0.145 ps=1.29 w=1 l=1
X78 res_packs__interleaved_0.x2_x2_net14 res_packs__interleaved_0.x2_x2_net15 sky130_fd_pr__res_generic_po w=0.5 l=40
X79 Vdd nmos_single_2__A_0.PBias nmos_current_mirror_2__ABBA_0.net6 Vdd sky130_fd_pr__pfet_01v8_lvt ad=1.45 pd=10.58 as=1.45 ps=10.58 w=5 l=1
X80 Vdd nmos_single_2__A_0.PBias nmos_current_mirror_4__A_0.net4 Vdd sky130_fd_pr__pfet_01v8_lvt ad=1.45 pd=10.58 as=1.45 ps=10.58 w=5 l=1
X81 Vdd Vdd Vdd Vdd sky130_fd_pr__pfet_01v8_lvt ad=1.45 pd=10.58 as=0 ps=0 w=5 l=1
X82 Vdd Vdd Vdd Vdd sky130_fd_pr__pfet_01v8_lvt ad=0.29 pd=2.58 as=0 ps=0 w=1 l=5
X83 pmos_current_mirror_2__row_0.x2_net1 VREF pmos_differential_pair__ABBA_0.x2_Vout Vdd sky130_fd_pr__pfet_01v8_lvt ad=0.29 pd=2.58 as=0.29 ps=2.58 w=1 l=10
X84 res_packs__interleaved_0.x2_x2_net16 res_packs__interleaved_0.x2_x2_net17 sky130_fd_pr__res_generic_po w=0.5 l=40
X85 res_packs__interleaved_0.x2_x1_net14 res_packs__interleaved_0.x2_x1_net13 sky130_fd_pr__res_generic_po w=0.5 l=40
X86 res_packs__interleaved_0.x2_x1_net1 res_packs__interleaved_0.x2_x1_net11 sky130_fd_pr__res_generic_po w=0.5 l=40
X87 Vss Vss Vss Vss sky130_fd_pr__nfet_01v8_lvt ad=1.45 pd=10.58 as=0 ps=0 w=5 l=2
X88 XC1__A_0.Vop1 pmos_diode_2__A_0.x1_Vbias nmos_differential_pair__ABAB_0.x1_Vtest2 Vdd sky130_fd_pr__pfet_01v8_lvt ad=0.145 pd=1.29 as=0.29 ps=2.58 w=1 l=5
X89 Vdd XC2__A_0.Vom1 Vop Vdd sky130_fd_pr__pfet_01v8_lvt ad=0.29 pd=2.58 as=0.145 ps=1.29 w=1 l=1
X90 res_packs__interleaved_0.x2_x1_net4 Vop sky130_fd_pr__res_generic_po w=0.5 l=40
X91 mirror_XX1_M22_XX1_M15__ABAB_0.x1_net8 XC1__A_0.Vop1 pmos_current_mirror_load__ABAB_0.x1_net9 Vss sky130_fd_pr__nfet_01v8_lvt ad=1.45 pd=10.58 as=1.45 ps=10.58 w=5 l=20
X92 Vom XC1__A_0.Vop1 Vdd Vdd sky130_fd_pr__pfet_01v8_lvt ad=0.145 pd=1.29 as=0.29 ps=2.58 w=1 l=1
X93 Vss pmos_differential_pair__ABBA_0.x2_Vout Vop Vss sky130_fd_pr__nfet_01v8_lvt ad=0.29 pd=2.58 as=0.29 ps=2.58 w=1 l=1
X94 Vss pmos_differential_pair__ABBA_0.x2_Vout Vop Vss sky130_fd_pr__nfet_01v8_lvt ad=0.29 pd=2.58 as=0.29 ps=2.58 w=1 l=1
X95 RGM nmos_diode__A_0.net1 nmos_diode__A_0.net1 Vss sky130_fd_pr__nfet_01v8_lvt ad=2.9 pd=20.58 as=2.9 ps=20.58 w=10 l=1
X96 Vom XC1__A_0.Vop1 Vdd Vdd sky130_fd_pr__pfet_01v8_lvt ad=0.145 pd=1.29 as=0.29 ps=2.58 w=1 l=1
X97 Vss pmos_differential_pair__ABBA_0.x2_Vout Vop Vss sky130_fd_pr__nfet_01v8_lvt ad=0.29 pd=2.58 as=0.29 ps=2.58 w=1 l=1
X98 res_packs__interleaved_0.x2_x2_net8 res_packs__interleaved_0.x2_x2_net2 sky130_fd_pr__res_generic_po w=0.5 l=40
X99 res_packs__interleaved_0.x2_x2_net6 res_packs__interleaved_0.x2_x2_net5 sky130_fd_pr__res_generic_po w=0.5 l=40
X100 Vdd pmos_current_mirror_load__ABAB_0.x1_net9 pmos_current_mirror_load__ABAB_0.x1_net9 Vdd sky130_fd_pr__pfet_01v8_lvt ad=0.29 pd=2.58 as=0.29 ps=2.58 w=1 l=10
X101 Vdd Vdd Vdd Vdd sky130_fd_pr__pfet_01v8_lvt ad=1.74 pd=12.58 as=0 ps=0 w=6 l=1
X102 nmos_differential_pair__ABAB_0.x1_net1 pmos_diode_2__A_0.x1_Vbias XC2__A_0.Vom1 Vdd sky130_fd_pr__pfet_01v8_lvt ad=0.29 pd=2.58 as=0.145 ps=1.29 w=1 l=5
X103 Vss Vss Vss Vss sky130_fd_pr__nfet_01v8_lvt ad=0.174 pd=1.78 as=0 ps=0 w=0.6 l=1
X104 Vss pmos_differential_pair__ABBA_0.x2_Vtest pmos_differential_pair__ABBA_0.x2_Vtest Vss sky130_fd_pr__nfet_01v8_lvt ad=0.145 pd=1.58 as=0.145 ps=1.58 w=0.5 l=20
X105 Vdd pmos_current_mirror_load__ABAB_0.x1_Vout nmos_differential_pair__ABAB_0.x1_net1 Vdd sky130_fd_pr__pfet_01v8_lvt ad=0.29 pd=2.58 as=0.145 ps=1.29 w=1 l=5
X106 Vdd XC1__A_0.Vop1 Vom Vdd sky130_fd_pr__pfet_01v8_lvt ad=0.29 pd=2.58 as=0.145 ps=1.29 w=1 l=1
X107 Vss pmos_differential_pair__ABBA_0.x2_Vout Vom Vss sky130_fd_pr__nfet_01v8_lvt ad=0.29 pd=2.58 as=0.29 ps=2.58 w=1 l=1
X108 Vss nmos_current_mirror_4__A_0.net4 nmos_matched_cascode_pair_2__ABAB_0.x1_net4 Vss sky130_fd_pr__nfet_01v8_lvt ad=0.29 pd=2.58 as=0.29 ps=2.58 w=1 l=10
X109 Vss nmos_current_mirror_4__A_0.net4 mirror_XX1_M22_XX1_M15__ABAB_0.x1_net8 Vss sky130_fd_pr__nfet_01v8_lvt ad=0.29 pd=2.58 as=0.29 ps=2.58 w=1 l=20
X110 pmos_differential_pair__ABBA_0.x2_Vtest res_packs__interleaved_0.x2_Vcm pmos_current_mirror_2__row_0.x2_net1 Vdd sky130_fd_pr__pfet_01v8_lvt ad=0.29 pd=2.58 as=0.29 ps=2.58 w=1 l=10
X111 res_packs__interleaved_0.x2_x1_net10 res_packs__interleaved_0.x2_x1_net11 sky130_fd_pr__res_generic_po w=0.5 l=40
X112 nmos_matched_cascode_pair_2__ABAB_0.x1_net4 nmos_diode_2__A_0.net5 nmos_differential_pair__ABAB_0.x1_net2 Vss sky130_fd_pr__nfet_01v8_lvt ad=0.29 pd=2.58 as=0.29 ps=2.58 w=1 l=1
X113 Vop XC2__A_0.Vom1 Vdd Vdd sky130_fd_pr__pfet_01v8_lvt ad=0.145 pd=1.29 as=0.29 ps=2.58 w=1 l=1
X114 Vss nmos_current_mirror_3__ABAB_0.net7 nmos_current_mirror_3__ABAB_0.net7 Vss sky130_fd_pr__nfet_01v8_lvt ad=0.174 pd=1.78 as=0.174 ps=1.78 w=0.6 l=1
X115 Vss Vss Vss Vss sky130_fd_pr__nfet_01v8_lvt ad=0.29 pd=2.58 as=0 ps=0 w=1 l=1
X116 Vss nmos_current_mirror_3__ABAB_0.net7 nmos_current_mirror_3__ABAB_0.net7 Vss sky130_fd_pr__nfet_01v8_lvt ad=0.174 pd=1.78 as=0.174 ps=1.78 w=0.6 l=1
X117 Vss pmos_differential_pair__ABBA_0.x2_Vout Vop Vss sky130_fd_pr__nfet_01v8_lvt ad=0.29 pd=2.58 as=0.29 ps=2.58 w=1 l=1
X118 Vdd pmos_current_mirror_load__ABAB_0.x1_net9 pmos_current_mirror_load__ABAB_0.x1_Vout Vdd sky130_fd_pr__pfet_01v8_lvt ad=0.29 pd=2.58 as=0.29 ps=2.58 w=1 l=10
X119 Vdd pmos_current_mirror_load__ABAB_0.x1_Vout nmos_differential_pair__ABAB_0.x1_net1 Vdd sky130_fd_pr__pfet_01v8_lvt ad=0.29 pd=2.58 as=0.145 ps=1.29 w=1 l=5
X120 Vop XC2__A_0.Vom1 Vdd Vdd sky130_fd_pr__pfet_01v8_lvt ad=0.145 pd=1.29 as=0.29 ps=2.58 w=1 l=1
X121 Vss Vss Vss Vss sky130_fd_pr__nfet_01v8_lvt ad=0.174 pd=1.78 as=0 ps=0 w=0.6 l=1
X122 XC2__A_0.Vom1 Vop sky130_fd_pr__cap_mim_m3_1 l=10 w=10
Cmimself2 XC2__A_0.Vom1 Vop -9.7061f
X123 nmos_matched_cascode_pair__ABBA_0.x1_net5 nmos_current_mirror_4__A_0.net4 Vss Vss sky130_fd_pr__nfet_01v8_lvt ad=0.29 pd=2.58 as=0.29 ps=2.58 w=1 l=10
X124 nmos_matched_cascode_pair_2__ABAB_0.x1_net6 nmos_diode_2__A_0.net5 XC2__A_0.Vom1 Vss sky130_fd_pr__nfet_01v8_lvt ad=0.29 pd=2.58 as=0.29 ps=2.58 w=1 l=1
X125 res_packs__interleaved_0.x2_x1_net3 res_packs__interleaved_0.x2_x1_net19 sky130_fd_pr__res_generic_po w=0.5 l=40
X126 nmos_matched_cascode_pair_2__ABAB_0.x1_net4 nmos_current_mirror_4__A_0.net4 Vss Vss sky130_fd_pr__nfet_01v8_lvt ad=0.29 pd=2.58 as=0.29 ps=2.58 w=1 l=10
X127 Vss nmos_current_mirror_4__A_0.net4 mirror_XX1_M22_XX1_M15__ABAB_0.x1_net7 Vss sky130_fd_pr__nfet_01v8_lvt ad=0.29 pd=2.58 as=0.29 ps=2.58 w=1 l=20
X128 Vss Vss Vss Vss sky130_fd_pr__nfet_01v8_lvt ad=0.29 pd=2.58 as=0 ps=0 w=1 l=1
X129 nmos_differential_pair__ABAB_0.x1_Vtest2 pmos_current_mirror_load__ABAB_0.x1_Vout Vdd Vdd sky130_fd_pr__pfet_01v8_lvt ad=0.145 pd=1.29 as=0.29 ps=2.58 w=1 l=5
X130 Vdd XC2__A_0.Vom1 Vop Vdd sky130_fd_pr__pfet_01v8_lvt ad=0.29 pd=2.58 as=0.145 ps=1.29 w=1 l=1
X131 Vdd Vdd Vdd Vdd sky130_fd_pr__pfet_01v8_lvt ad=1.45 pd=10.58 as=0 ps=0 w=5 l=1
X132 Vdd Vdd Vdd Vdd sky130_fd_pr__pfet_01v8_lvt ad=0.29 pd=2.58 as=0 ps=0 w=1 l=5
X133 mirror_XX1_M22_XX1_M15__ABAB_0.x1_net8 VREF pmos_current_mirror_load__ABAB_0.x1_Vout Vss sky130_fd_pr__nfet_01v8_lvt ad=1.45 pd=10.58 as=1.45 ps=10.58 w=5 l=20
X134 nmos_differential_pair__ABAB_0.x1_net2 Vp nmos_differential_pair__ABAB_0.x1_net1 Vss sky130_fd_pr__nfet_01v8_lvt ad=1.16 pd=8.58 as=1.16 ps=8.58 w=4 l=4
X135 Vdd XC2__A_0.Vom1 Vop Vdd sky130_fd_pr__pfet_01v8_lvt ad=0.29 pd=2.58 as=0.145 ps=1.29 w=1 l=1
X136 res_packs__interleaved_0.x2_x2_net3 res_packs__interleaved_0.x2_x2_net15 sky130_fd_pr__res_generic_po w=0.5 l=40
X137 Vom XC1__A_0.Vop1 Vdd Vdd sky130_fd_pr__pfet_01v8_lvt ad=0.145 pd=1.29 as=0.29 ps=2.58 w=1 l=1
X138 res_packs__interleaved_0.x2_x1_net8 res_packs__interleaved_0.x2_x1_net9 sky130_fd_pr__res_generic_po w=0.5 l=40
X139 nmos_differential_pair__ABAB_0.x1_Vtest2 pmos_current_mirror_load__ABAB_0.x1_Vout Vdd Vdd sky130_fd_pr__pfet_01v8_lvt ad=0.145 pd=1.29 as=0.29 ps=2.58 w=1 l=5
X140 Vss nmos_current_mirror_4__A_0.net4 nmos_matched_cascode_pair__ABBA_0.x1_net3 Vss sky130_fd_pr__nfet_01v8_lvt ad=0.29 pd=2.58 as=0.29 ps=2.58 w=1 l=10
X141 Vss Vss Vss Vss sky130_fd_pr__nfet_01v8_lvt ad=0.29 pd=2.58 as=0 ps=0 w=1 l=1
X142 nmos_matched_cascode_pair__ABBA_0.x1_net5 nmos_diode_2__A_0.net5 XC1__A_0.Vop1 Vss sky130_fd_pr__nfet_01v8_lvt ad=0.29 pd=2.58 as=0.29 ps=2.58 w=1 l=1
X143 XC1__A_0.Vop1 Vom sky130_fd_pr__cap_mim_m3_1 l=10 w=10
Cmimself3 XC1__A_0.Vop1 Vom -9.7061f
X144 nmos_differential_pair__ABAB_0.x1_Vtest2 pmos_current_mirror_load__ABAB_0.x1_Vout Vdd Vdd sky130_fd_pr__pfet_01v8_lvt ad=0.145 pd=1.29 as=0.29 ps=2.58 w=1 l=5
X145 Vdd Vdd Vdd Vdd sky130_fd_pr__pfet_01v8_lvt ad=0.29 pd=2.58 as=0 ps=0 w=1 l=5
X146 XC1__A_0.Vop1 Vom sky130_fd_pr__cap_mim_m3_1 l=10 w=10
Cmimself4 XC1__A_0.Vop1 Vom -9.7061f
X147 res_packs__interleaved_0.x2_x1_net12 res_packs__interleaved_0.x2_x1_net13 sky130_fd_pr__res_generic_po w=0.5 l=40
X148 res_packs__interleaved_0.x2_x2_net1 res_packs__interleaved_0.x2_x2_net11 sky130_fd_pr__res_generic_po w=0.5 l=40
X149 nmos_differential_pair__ABAB_0.x1_net1 pmos_diode_2__A_0.x1_Vbias XC2__A_0.Vom1 Vdd sky130_fd_pr__pfet_01v8_lvt ad=0.29 pd=2.58 as=0.145 ps=1.29 w=1 l=5
X150 Vdd XC1__A_0.Vop1 Vom Vdd sky130_fd_pr__pfet_01v8_lvt ad=0.29 pd=2.58 as=0.145 ps=1.29 w=1 l=1
X151 XC1__A_0.Vop1 Vom sky130_fd_pr__cap_mim_m3_1 l=10 w=10
Cmimself5 XC1__A_0.Vop1 Vom -9.7061f
X152 Vss Vss sky130_fd_pr__res_generic_po w=0.5 l=40
X153 Vss nmos_single_2__A_0.NBias nmos_single_2__A_0.PBias Vss sky130_fd_pr__nfet_01v8_lvt ad=1.45 pd=10.58 as=1.45 ps=10.58 w=5 l=2
X154 nmos_single_2__A_0.NBias nmos_single_2__A_0.PBias Vdd Vdd sky130_fd_pr__pfet_01v8_lvt ad=1.45 pd=10.58 as=1.45 ps=10.58 w=5 l=1
X155 Vss Vss Vss Vss sky130_fd_pr__nfet_01v8_lvt ad=1.45 pd=10.58 as=0 ps=0 w=5 l=20
X156 Vss Vss Vss Vss sky130_fd_pr__nfet_01v8_lvt ad=1.16 pd=8.58 as=0 ps=0 w=4 l=4
X157 Vdd nmos_single_2__A_0.PBias nmos_diode__A_0.net1 Vdd sky130_fd_pr__pfet_01v8_lvt ad=1.45 pd=10.58 as=1.45 ps=10.58 w=5 l=1
X158 nmos_differential_pair__ABAB_0.x1_Vtest2 pmos_diode_2__A_0.x1_Vbias XC1__A_0.Vop1 Vdd sky130_fd_pr__pfet_01v8_lvt ad=0.29 pd=2.58 as=0.145 ps=1.29 w=1 l=5
X159 Vss Vss Vss Vss sky130_fd_pr__nfet_01v8_lvt ad=1.45 pd=10.58 as=0 ps=0 w=5 l=20
X160 Vdd XC1__A_0.Vop1 Vom Vdd sky130_fd_pr__pfet_01v8_lvt ad=0.29 pd=2.58 as=0.145 ps=1.29 w=1 l=1
X161 Vdd Vdd Vdd Vdd sky130_fd_pr__pfet_01v8_lvt ad=0.29 pd=2.58 as=0 ps=0 w=1 l=10
X162 Vss nmos_single_2__A_0.NBias nmos_single_2__A_0.PBias Vss sky130_fd_pr__nfet_01v8_lvt ad=1.45 pd=10.58 as=1.45 ps=10.58 w=5 l=2
X163 nmos_matched_cascode_pair_2__ABAB_0.x1_net6 nmos_diode_2__A_0.net5 XC2__A_0.Vom1 Vss sky130_fd_pr__nfet_01v8_lvt ad=0.29 pd=2.58 as=0.29 ps=2.58 w=1 l=1
X164 Vdd nmos_single_2__A_0.PBias nmos_current_mirror_3__ABAB_0.net7 Vdd sky130_fd_pr__pfet_01v8_lvt ad=1.45 pd=10.58 as=1.45 ps=10.58 w=5 l=1
X165 Vdd pmos_current_mirror_load__ABAB_0.x1_Vout nmos_differential_pair__ABAB_0.x1_net1 Vdd sky130_fd_pr__pfet_01v8_lvt ad=0.29 pd=2.58 as=0.145 ps=1.29 w=1 l=5
X166 pmos_differential_pair__ABBA_0.x2_Vout VREF pmos_current_mirror_2__row_0.x2_net1 Vdd sky130_fd_pr__pfet_01v8_lvt ad=0.29 pd=2.58 as=0.29 ps=2.58 w=1 l=10
X167 res_packs__interleaved_0.x2_x2_net8 res_packs__interleaved_0.x2_x2_net9 sky130_fd_pr__res_generic_po w=0.5 l=40
X168 res_packs__interleaved_0.x2_x1_net6 res_packs__interleaved_0.x2_x1_net5 sky130_fd_pr__res_generic_po w=0.5 l=40
X169 XC2__A_0.Vom1 Vop sky130_fd_pr__cap_mim_m3_1 l=10 w=10
Cmimself6 XC2__A_0.Vom1 Vop -9.7061f
X170 Vdd pmos_current_mirror_load__ABAB_0.x1_net9 pmos_current_mirror_load__ABAB_0.x1_Vout Vdd sky130_fd_pr__pfet_01v8_lvt ad=0.29 pd=2.58 as=0.29 ps=2.58 w=1 l=10
X171 Vdd pmos_current_mirror_load__ABAB_0.x1_Vout nmos_differential_pair__ABAB_0.x1_net1 Vdd sky130_fd_pr__pfet_01v8_lvt ad=0.29 pd=2.58 as=0.145 ps=1.29 w=1 l=5
X172 Vss nmos_current_mirror_4__A_0.net4 nmos_current_mirror_4__A_0.net4 Vss sky130_fd_pr__nfet_01v8_lvt ad=0.29 pd=2.58 as=0.29 ps=2.58 w=1 l=2
X173 Vdd XC1__A_0.Vop1 Vom Vdd sky130_fd_pr__pfet_01v8_lvt ad=0.29 pd=2.58 as=0.145 ps=1.29 w=1 l=1
X174 Vdd Vdd Vdd Vdd sky130_fd_pr__pfet_01v8_lvt ad=0.145 pd=1.29 as=0 ps=0 w=1 l=5
X175 Vss Vss Vss Vss sky130_fd_pr__nfet_01v8_lvt ad=1.45 pd=10.58 as=0 ps=0 w=5 l=20
X176 Vdd XC2__A_0.Vom1 Vop Vdd sky130_fd_pr__pfet_01v8_lvt ad=0.29 pd=2.58 as=0.145 ps=1.29 w=1 l=1
X177 Vdd Vdd Vdd Vdd sky130_fd_pr__pfet_01v8_lvt ad=0.29 pd=2.58 as=0 ps=0 w=1 l=10
X178 nmos_differential_pair__ABAB_0.x1_net2 nmos_diode_2__A_0.net5 nmos_matched_cascode_pair__ABBA_0.x1_net3 Vss sky130_fd_pr__nfet_01v8_lvt ad=0.29 pd=2.58 as=0.29 ps=2.58 w=1 l=1
X179 Vss Vss Vss Vss sky130_fd_pr__nfet_01v8_lvt ad=1.16 pd=8.58 as=0 ps=0 w=4 l=4
X180 res_packs__interleaved_0.x2_x1_net16 res_packs__interleaved_0.x2_x1_net17 sky130_fd_pr__res_generic_po w=0.5 l=40
X181 Vss nmos_single_2__A_0.NBias pmos_diode__A_0.net3 Vss sky130_fd_pr__nfet_01v8_lvt ad=1.45 pd=10.58 as=1.45 ps=10.58 w=5 l=2
X182 Vss nmos_single_2__A_0.NBias nmos_single_2__A_0.NBias Vss sky130_fd_pr__nfet_01v8_lvt ad=1.45 pd=10.58 as=1.45 ps=10.58 w=5 l=2
X183 nmos_matched_cascode_pair__ABBA_0.x1_net3 nmos_diode_2__A_0.net5 nmos_differential_pair__ABAB_0.x1_net2 Vss sky130_fd_pr__nfet_01v8_lvt ad=0.29 pd=2.58 as=0.29 ps=2.58 w=1 l=1
X184 Vom XC1__A_0.Vop1 Vdd Vdd sky130_fd_pr__pfet_01v8_lvt ad=0.145 pd=1.29 as=0.29 ps=2.58 w=1 l=1
X185 Vss Vss Vss Vss sky130_fd_pr__nfet_01v8_lvt ad=0.145 pd=1.58 as=0 ps=0 w=0.5 l=20
X186 res_packs__interleaved_0.x2_x2_net18 res_packs__interleaved_0.x2_x2_net17 sky130_fd_pr__res_generic_po w=0.5 l=40
X187 XC1__A_0.Vop1 pmos_diode_2__A_0.x1_Vbias nmos_differential_pair__ABAB_0.x1_Vtest2 Vdd sky130_fd_pr__pfet_01v8_lvt ad=0.145 pd=1.29 as=0.29 ps=2.58 w=1 l=5
X188 Vss Vss Vss Vss sky130_fd_pr__nfet_01v8_lvt ad=0.29 pd=2.58 as=0 ps=0 w=1 l=1
X189 Vom XC1__A_0.Vop1 Vdd Vdd sky130_fd_pr__pfet_01v8_lvt ad=0.145 pd=1.29 as=0.29 ps=2.58 w=1 l=1
X190 Vdd Vdd Vdd Vdd sky130_fd_pr__pfet_01v8_lvt ad=0.29 pd=2.58 as=0 ps=0 w=1 l=5
X191 res_packs__interleaved_0.x2_x2_net3 res_packs__interleaved_0.x2_x2_net19 sky130_fd_pr__res_generic_po w=0.5 l=40
X192 nmos_single_2__A_0.NBias pmos_diode__A_0.net3 nmos_single_2__A_0.PBias Vss sky130_fd_pr__nfet_01v8_lvt ad=0.58 pd=4.58 as=0.58 ps=4.58 w=2 l=1
X193 pmos_differential_pair__ABBA_0.x2_Vout pmos_differential_pair__ABBA_0.x2_Vtest Vss Vss sky130_fd_pr__nfet_01v8_lvt ad=0.145 pd=1.58 as=0.145 ps=1.58 w=0.5 l=20
X194 mirror_XX1_M22_XX1_M15__ABAB_0.x1_net7 XC2__A_0.Vom1 pmos_current_mirror_load__ABAB_0.x1_net9 Vss sky130_fd_pr__nfet_01v8_lvt ad=1.45 pd=10.58 as=1.45 ps=10.58 w=5 l=20
X195 Vss nmos_current_mirror_2__ABBA_0.net6 nmos_current_mirror_2__ABBA_0.net6 Vss sky130_fd_pr__nfet_01v8_lvt ad=0.174 pd=1.78 as=0.174 ps=1.78 w=0.6 l=1
X196 Vss pmos_differential_pair__ABBA_0.x2_Vout Vop Vss sky130_fd_pr__nfet_01v8_lvt ad=0.29 pd=2.58 as=0.29 ps=2.58 w=1 l=1
X197 res_packs__interleaved_0.x2_x1_net3 res_packs__interleaved_0.x2_x1_net15 sky130_fd_pr__res_generic_po w=0.5 l=40
X198 mirror_XX1_M22_XX1_M15__ABAB_0.x1_net8 XC1__A_0.Vop1 pmos_current_mirror_load__ABAB_0.x1_net9 Vss sky130_fd_pr__nfet_01v8_lvt ad=1.45 pd=10.58 as=1.45 ps=10.58 w=5 l=20
X199 res_packs__interleaved_0.x2_x1_net10 res_packs__interleaved_0.x2_x1_net9 sky130_fd_pr__res_generic_po w=0.5 l=40
X200 Vss nmos_current_mirror_2__ABBA_0.net6 pmos_diode_2__A_0.x1_Vbias Vss sky130_fd_pr__nfet_01v8_lvt ad=0.174 pd=1.78 as=0.174 ps=1.78 w=0.6 l=1
X201 nmos_differential_pair__ABAB_0.x1_net2 Vm nmos_differential_pair__ABAB_0.x1_Vtest2 Vss sky130_fd_pr__nfet_01v8_lvt ad=1.16 pd=8.58 as=1.16 ps=8.58 w=4 l=4
X202 Vdd XC2__A_0.Vom1 Vop Vdd sky130_fd_pr__pfet_01v8_lvt ad=0.29 pd=2.58 as=0.145 ps=1.29 w=1 l=1
X203 XC2__A_0.Vom1 Vop sky130_fd_pr__cap_mim_m3_1 l=10 w=10
Cmimself7 XC2__A_0.Vom1 Vop -9.7061f
X204 mirror_XX1_M22_XX1_M15__ABAB_0.x1_net8 VREF pmos_current_mirror_load__ABAB_0.x1_Vout Vss sky130_fd_pr__nfet_01v8_lvt ad=1.45 pd=10.58 as=1.45 ps=10.58 w=5 l=20
X205 Vdd pmos_current_mirror_2__row_0.x2_Vbiasp pmos_current_mirror_2__row_0.x2_Vbiasp Vdd sky130_fd_pr__pfet_01v8_lvt ad=1.74 pd=12.58 as=1.74 ps=12.58 w=6 l=1
X206 Vss pmos_differential_pair__ABBA_0.x2_Vout Vop Vss sky130_fd_pr__nfet_01v8_lvt ad=0.29 pd=2.58 as=0.29 ps=2.58 w=1 l=1
X207 Vss Vss Vss Vss sky130_fd_pr__nfet_01v8_lvt ad=0.145 pd=1.58 as=0 ps=0 w=0.5 l=20
X208 mirror_XX1_M22_XX1_M15__ABAB_0.x1_net7 VREF pmos_current_mirror_load__ABAB_0.x1_Vout Vss sky130_fd_pr__nfet_01v8_lvt ad=1.45 pd=10.58 as=1.45 ps=10.58 w=5 l=20
X209 res_packs__interleaved_0.x2_x2_net4 res_packs__interleaved_0.x2_x2_net5 sky130_fd_pr__res_generic_po w=0.5 l=40
X210 nmos_matched_cascode_pair_2__ABAB_0.x1_net6 nmos_current_mirror_4__A_0.net4 Vss Vss sky130_fd_pr__nfet_01v8_lvt ad=0.29 pd=2.58 as=0.29 ps=2.58 w=1 l=10
X211 res_packs__interleaved_0.x2_x2_net12 res_packs__interleaved_0.x2_x2_net13 sky130_fd_pr__res_generic_po w=0.5 l=40
X212 res_packs__interleaved_0.x2_x2_net1 res_packs__interleaved_0.x2_x2_net7 sky130_fd_pr__res_generic_po w=0.5 l=40
X213 pmos_differential_pair__ABBA_0.x2_Vtest pmos_differential_pair__ABBA_0.x2_Vtest Vss Vss sky130_fd_pr__nfet_01v8_lvt ad=0.145 pd=1.58 as=0.145 ps=1.58 w=0.5 l=20
X214 XC1__A_0.Vop1 nmos_diode_2__A_0.net5 nmos_matched_cascode_pair__ABBA_0.x1_net5 Vss sky130_fd_pr__nfet_01v8_lvt ad=0.29 pd=2.58 as=0.29 ps=2.58 w=1 l=1
X215 Vdd pmos_current_mirror_2__row_0.x2_Vbiasp pmos_current_mirror_2__row_0.x2_net1 Vdd sky130_fd_pr__pfet_01v8_lvt ad=0.29 pd=2.58 as=0.29 ps=2.58 w=1 l=5
X216 Vop XC2__A_0.Vom1 Vdd Vdd sky130_fd_pr__pfet_01v8_lvt ad=0.145 pd=1.29 as=0.29 ps=2.58 w=1 l=1
X217 Vdd XC1__A_0.Vop1 Vom Vdd sky130_fd_pr__pfet_01v8_lvt ad=0.29 pd=2.58 as=0.145 ps=1.29 w=1 l=1
X218 Vss pmos_differential_pair__ABBA_0.x2_Vout Vom Vss sky130_fd_pr__nfet_01v8_lvt ad=0.29 pd=2.58 as=0.29 ps=2.58 w=1 l=1
X219 Vdd pmos_diode_2__A_0.x1_Vbias pmos_diode_2__A_0.x1_Vbias Vdd sky130_fd_pr__pfet_01v8_lvt ad=0.435 pd=3.58 as=0.435 ps=3.58 w=1.5 l=10
X220 nmos_differential_pair__ABAB_0.x1_net2 Vp nmos_differential_pair__ABAB_0.x1_net1 Vss sky130_fd_pr__nfet_01v8_lvt ad=1.16 pd=8.58 as=1.16 ps=8.58 w=4 l=4
X221 mirror_XX1_M22_XX1_M15__ABAB_0.x1_net7 VREF pmos_current_mirror_load__ABAB_0.x1_Vout Vss sky130_fd_pr__nfet_01v8_lvt ad=1.45 pd=10.58 as=1.45 ps=10.58 w=5 l=20
X222 Vdd XC1__A_0.Vop1 Vom Vdd sky130_fd_pr__pfet_01v8_lvt ad=0.29 pd=2.58 as=0.145 ps=1.29 w=1 l=1
X223 Vdd XC2__A_0.Vom1 Vop Vdd sky130_fd_pr__pfet_01v8_lvt ad=0.29 pd=2.58 as=0.145 ps=1.29 w=1 l=1
X224 XC1__A_0.Vop1 Vom sky130_fd_pr__cap_mim_m3_1 l=10 w=10
Cmimself8 XC1__A_0.Vop1 Vom -9.7061f
X225 res_packs__interleaved_0.x2_x1_net4 res_packs__interleaved_0.x2_x1_net5 sky130_fd_pr__res_generic_po w=0.5 l=40
X226 Vdd Vdd Vdd Vdd sky130_fd_pr__pfet_01v8_lvt ad=1.45 pd=10.58 as=0 ps=0 w=5 l=1
X227 Vss Vss Vss Vss sky130_fd_pr__nfet_01v8_lvt ad=0.29 pd=2.58 as=0 ps=0 w=1 l=20
X228 Vss pmos_differential_pair__ABBA_0.x2_Vout Vop Vss sky130_fd_pr__nfet_01v8_lvt ad=0.29 pd=2.58 as=0.29 ps=2.58 w=1 l=1
X229 Vdd nmos_single__A_0.net2 nmos_single_2__A_0.PBias Vdd sky130_fd_pr__pfet_01v8_lvt ad=1.45 pd=10.58 as=1.45 ps=10.58 w=5 l=1
X230 Vom XC1__A_0.Vop1 Vdd Vdd sky130_fd_pr__pfet_01v8_lvt ad=0.145 pd=1.29 as=0.29 ps=2.58 w=1 l=1
X231 XC2__A_0.Vom1 pmos_diode_2__A_0.x1_Vbias nmos_differential_pair__ABAB_0.x1_net1 Vdd sky130_fd_pr__pfet_01v8_lvt ad=0.145 pd=1.29 as=0.29 ps=2.58 w=1 l=5
X232 Vdd Vdd Vdd Vdd sky130_fd_pr__pfet_01v8_lvt ad=0.145 pd=1.29 as=0 ps=0 w=1 l=5
X233 Vss Vss Vss Vss sky130_fd_pr__nfet_01v8_lvt ad=0.174 pd=1.78 as=0 ps=0 w=0.6 l=1
X234 nmos_matched_cascode_pair__ABBA_0.x1_net3 nmos_current_mirror_4__A_0.net4 Vss Vss sky130_fd_pr__nfet_01v8_lvt ad=0.29 pd=2.58 as=0.29 ps=2.58 w=1 l=10
X235 Vss nmos_current_mirror_4__A_0.net4 mirror_XX1_M22_XX1_M15__ABAB_0.x1_net8 Vss sky130_fd_pr__nfet_01v8_lvt ad=0.29 pd=2.58 as=0.29 ps=2.58 w=1 l=20
X236 Vop XC2__A_0.Vom1 Vdd Vdd sky130_fd_pr__pfet_01v8_lvt ad=0.145 pd=1.29 as=0.29 ps=2.58 w=1 l=1
X237 Vom XC1__A_0.Vop1 Vdd Vdd sky130_fd_pr__pfet_01v8_lvt ad=0.145 pd=1.29 as=0.29 ps=2.58 w=1 l=1
X238 nmos_differential_pair__ABAB_0.x1_Vtest2 pmos_diode_2__A_0.x1_Vbias XC1__A_0.Vop1 Vdd sky130_fd_pr__pfet_01v8_lvt ad=0.29 pd=2.58 as=0.145 ps=1.29 w=1 l=5
X239 pmos_diode_2__A_0.x1_Vbias nmos_current_mirror_2__ABBA_0.net6 Vss Vss sky130_fd_pr__nfet_01v8_lvt ad=0.174 pd=1.78 as=0.174 ps=1.78 w=0.6 l=1
X240 Vdd Vdd Vdd Vdd sky130_fd_pr__pfet_01v8_lvt ad=0.29 pd=2.58 as=0 ps=0 w=1 l=10
X241 Vss Vss Vss Vss sky130_fd_pr__nfet_01v8_lvt ad=0.29 pd=2.58 as=0 ps=0 w=1 l=1
X242 Vdd XC1__A_0.Vop1 Vom Vdd sky130_fd_pr__pfet_01v8_lvt ad=0.29 pd=2.58 as=0.145 ps=1.29 w=1 l=1
X243 XC2__A_0.Vom1 Vop sky130_fd_pr__cap_mim_m3_1 l=10 w=10
Cmimself9 XC2__A_0.Vom1 Vop -9.7061f
X244 res_packs__interleaved_0.x2_x1_net18 res_packs__interleaved_0.x2_x1_net17 sky130_fd_pr__res_generic_po w=0.5 l=40
X245 Vdd pmos_diode_2__A_0.x1_Vbias pmos_diode_2__A_0.x1_Vbias Vdd sky130_fd_pr__pfet_01v8_lvt ad=0.435 pd=3.58 as=0.435 ps=3.58 w=1.5 l=10
X246 Vss nmos_single_2__A_0.NBias nmos_single_2__A_0.NBias Vss sky130_fd_pr__nfet_01v8_lvt ad=1.45 pd=10.58 as=1.45 ps=10.58 w=5 l=2
X247 res_packs__interleaved_0.x2_x2_net18 res_packs__interleaved_0.x2_x2_net19 sky130_fd_pr__res_generic_po w=0.5 l=40
X248 Vdd Vdd Vdd Vdd sky130_fd_pr__pfet_01v8_lvt ad=1.45 pd=10.58 as=0 ps=0 w=5 l=1
X249 Vss Vss Vss Vss sky130_fd_pr__nfet_01v8_lvt ad=1.45 pd=10.58 as=0 ps=0 w=5 l=20
X250 res_packs__interleaved_0.x2_x1_net12 res_packs__interleaved_0.x2_x1_net2 sky130_fd_pr__res_generic_po w=0.5 l=40
X251 Vop XC2__A_0.Vom1 Vdd Vdd sky130_fd_pr__pfet_01v8_lvt ad=0.145 pd=1.29 as=0.29 ps=2.58 w=1 l=1
X252 XC2__A_0.Vom1 pmos_diode_2__A_0.x1_Vbias nmos_differential_pair__ABAB_0.x1_net1 Vdd sky130_fd_pr__pfet_01v8_lvt ad=0.145 pd=1.29 as=0.29 ps=2.58 w=1 l=5
X253 Vom XC1__A_0.Vop1 Vdd Vdd sky130_fd_pr__pfet_01v8_lvt ad=0.145 pd=1.29 as=0.29 ps=2.58 w=1 l=1
X254 Vop XC2__A_0.Vom1 Vdd Vdd sky130_fd_pr__pfet_01v8_lvt ad=0.145 pd=1.29 as=0.29 ps=2.58 w=1 l=1
X255 Vdd nmos_single_2__A_0.PBias nmos_current_mirror_2__ABBA_0.net6 Vdd sky130_fd_pr__pfet_01v8_lvt ad=1.45 pd=10.58 as=1.45 ps=10.58 w=5 l=1
X256 res_packs__interleaved_0.x2_x1_net14 res_packs__interleaved_0.x2_x1_net15 sky130_fd_pr__res_generic_po w=0.5 l=40
X257 Vdd Vdd Vdd Vdd sky130_fd_pr__pfet_01v8_lvt ad=1.45 pd=10.58 as=0 ps=0 w=5 l=1
X258 Vdd nmos_single__A_0.net2 nmos_single_2__A_0.PBias Vdd sky130_fd_pr__pfet_01v8_lvt ad=1.45 pd=10.58 as=1.45 ps=10.58 w=5 l=1
X259 Vop XC2__A_0.Vom1 Vdd Vdd sky130_fd_pr__pfet_01v8_lvt ad=0.145 pd=1.29 as=0.29 ps=2.58 w=1 l=1
X260 Vss pmos_differential_pair__ABBA_0.x2_Vout Vom Vss sky130_fd_pr__nfet_01v8_lvt ad=0.29 pd=2.58 as=0.29 ps=2.58 w=1 l=1
X261 res_packs__interleaved_0.x2_x2_net10 res_packs__interleaved_0.x2_x2_net9 sky130_fd_pr__res_generic_po w=0.5 l=40
X262 RGM nmos_diode__A_0.net1 nmos_diode__A_0.net1 Vss sky130_fd_pr__nfet_01v8_lvt ad=2.9 pd=20.58 as=2.9 ps=20.58 w=10 l=1
X263 Vdd nmos_single_2__A_0.PBias nmos_current_mirror_4__A_0.net4 Vdd sky130_fd_pr__pfet_01v8_lvt ad=1.45 pd=10.58 as=1.45 ps=10.58 w=5 l=1
X264 Vdd pmos_diode__A_0.net3 pmos_diode__A_0.net3 Vdd sky130_fd_pr__pfet_01v8_lvt ad=0.29 pd=2.58 as=0.29 ps=2.58 w=1 l=20
X265 Vdd XC1__A_0.Vop1 Vom Vdd sky130_fd_pr__pfet_01v8_lvt ad=0.29 pd=2.58 as=0.145 ps=1.29 w=1 l=1
X266 Vss pmos_differential_pair__ABBA_0.x2_Vout Vom Vss sky130_fd_pr__nfet_01v8_lvt ad=0.29 pd=2.58 as=0.29 ps=2.58 w=1 l=1
C0 res_packs__interleaved_0.x2_x1_net7 res_packs__interleaved_0.x2_x2_net7 0.41644f
C1 nmos_differential_pair__ABAB_0.x1_Vtest2 XC1__A_0.Vop1 1.40342f
C2 XC2__A_0.Vom1 nmos_matched_cascode_pair_2__ABAB_0.x1_net6 1.21262f
C3 res_packs__interleaved_0.x2_x2_net19 res_packs__interleaved_0.x2_Vcm 0.00171f
C4 Vdd Vop 6.61791f
C5 mirror_XX1_M22_XX1_M15__ABAB_0.x1_net7 pmos_current_mirror_load__ABAB_0.x1_net9 6.1294f
C6 res_packs__interleaved_0.x2_x2_net1 pmos_differential_pair__ABBA_0.x2_Vtest 0
C7 nmos_diode_2__A_0.net5 Vop 0.23099f
C8 pmos_diode__A_0.net3 Vop 0.17352f
C9 pmos_differential_pair__ABBA_0.x2_Vtest nmos_current_mirror_4__A_0.net4 0.27064f
C10 res_packs__interleaved_0.x2_x2_net4 res_packs__interleaved_0.x2_Vcm 0.00365f
C11 nmos_matched_cascode_pair_2__ABAB_0.x1_net4 nmos_matched_cascode_pair_2__ABAB_0.x1_net6 1.4073f
C12 Vom Vop 6.73851f
C13 pmos_differential_pair__ABBA_0.x2_Vout pmos_current_mirror_2__row_0.x2_net1 3.34297f
C14 pmos_current_mirror_2__row_0.x2_Vbiasp pmos_differential_pair__ABBA_0.x2_Vtest 0.0696f
C15 Vm Vp 1.76344f
C16 nmos_current_mirror_4__A_0.net4 XC1__A_0.Vop1 0.20528f
C17 nmos_current_mirror_3__ABAB_0.net7 pmos_current_mirror_2__row_0.x2_Vbiasp 1.03823f
C18 mirror_XX1_M22_XX1_M15__ABAB_0.x1_net7 nmos_current_mirror_2__ABBA_0.net6 0.16565f
C19 nmos_current_mirror_2__ABBA_0.net6 nmos_single_2__A_0.PBias 0.56574f
C20 pmos_current_mirror_2__row_0.x2_Vbiasp XC1__A_0.Vop1 0.05962f
C21 res_packs__interleaved_0.x2_x2_net17 res_packs__interleaved_0.x2_x1_net19 0.00925f
C22 pmos_current_mirror_load__ABAB_0.x1_net9 XC1__A_0.Vop1 2.08221f
C23 res_packs__interleaved_0.x2_x2_net15 res_packs__interleaved_0.x2_x2_net19 0.16037f
C24 res_packs__interleaved_0.x2_x2_net7 res_packs__interleaved_0.x2_Vcm 0.00171f
C25 res_packs__interleaved_0.x2_x1_net7 Vop 0.00207f
C26 XC2__A_0.Vom1 nmos_differential_pair__ABAB_0.x1_net1 1.48623f
C27 nmos_differential_pair__ABAB_0.x1_net2 Vm 0.8788f
C28 res_packs__interleaved_0.x2_x2_net3 res_packs__interleaved_0.x2_x1_net18 0.00925f
C29 RGM pmos_diode__A_0.net3 0.00126f
C30 nmos_diode__A_0.net1 nmos_single_2__A_0.NBias 1.15249f
C31 pmos_differential_pair__ABBA_0.x2_Vtest nmos_current_mirror_2__ABBA_0.net6 0.28046f
C32 nmos_matched_cascode_pair_2__ABAB_0.x1_net4 nmos_differential_pair__ABAB_0.x1_net1 0.00736f
C33 Vdd nmos_single_2__A_0.PBias 17.8326f
C34 mirror_XX1_M22_XX1_M15__ABAB_0.x1_net7 Vdd 0.15895f
C35 nmos_current_mirror_3__ABAB_0.net7 nmos_current_mirror_2__ABBA_0.net6 2.26954f
C36 res_packs__interleaved_0.x2_x1_net10 res_packs__interleaved_0.x2_x1_net1 0.16069f
C37 nmos_diode_2__A_0.net5 mirror_XX1_M22_XX1_M15__ABAB_0.x1_net7 0.22274f
C38 nmos_diode_2__A_0.net5 nmos_single_2__A_0.PBias 0.58734f
C39 RGM Vom 0
C40 pmos_diode__A_0.net3 nmos_single_2__A_0.PBias 3.69624f
C41 nmos_single_2__A_0.NBias nmos_single__A_0.net2 0.55134f
C42 res_packs__interleaved_0.x2_x2_net11 res_packs__interleaved_0.x2_x1_net9 0.00925f
C43 nmos_matched_cascode_pair_2__ABAB_0.x1_net6 nmos_matched_cascode_pair__ABBA_0.x1_net5 5.08594f
C44 mirror_XX1_M22_XX1_M15__ABAB_0.x1_net8 nmos_matched_cascode_pair_2__ABAB_0.x1_net6 0.59379f
C45 Vm VREF 0
C46 nmos_current_mirror_2__ABBA_0.net6 XC1__A_0.Vop1 0.71702f
C47 XC2__A_0.Vom1 Vop 54.062f
C48 Vom nmos_single_2__A_0.PBias 0.6797f
C49 mirror_XX1_M22_XX1_M15__ABAB_0.x1_net7 Vom 0.00302f
C50 nmos_differential_pair__ABAB_0.x1_Vtest2 Vp 0.21412f
C51 res_packs__interleaved_0.x2_x1_net11 res_packs__interleaved_0.x2_x2_net9 0.02074f
C52 pmos_diode_2__A_0.x1_Vbias XC1__A_0.Vop1 2.71315f
C53 res_packs__interleaved_0.x2_x1_net17 res_packs__interleaved_0.x2_x2_net17 0.51022f
C54 Vdd pmos_differential_pair__ABBA_0.x2_Vtest 5.0674f
C55 Vom res_packs__interleaved_0.x2_x2_net2 0
C56 pmos_current_mirror_load__ABAB_0.x1_Vout nmos_matched_cascode_pair_2__ABAB_0.x1_net6 0.04859f
C57 res_packs__interleaved_0.x2_Vcm Vop 3.02123f
C58 nmos_diode_2__A_0.net5 pmos_differential_pair__ABBA_0.x2_Vtest 0.33529f
C59 nmos_current_mirror_3__ABAB_0.net7 Vdd 3.17664f
C60 res_packs__interleaved_0.x2_x1_net10 res_packs__interleaved_0.x2_x2_net1 0.02074f
C61 nmos_current_mirror_3__ABAB_0.net7 nmos_diode_2__A_0.net5 0.00435f
C62 nmos_current_mirror_3__ABAB_0.net7 pmos_diode__A_0.net3 0
C63 res_packs__interleaved_0.x2_x1_net13 res_packs__interleaved_0.x2_x2_net13 0.41644f
C64 Vdd XC1__A_0.Vop1 23.0787f
C65 nmos_differential_pair__ABAB_0.x1_Vtest2 nmos_differential_pair__ABAB_0.x1_net2 2.1041f
C66 Vom pmos_differential_pair__ABBA_0.x2_Vtest 0.24116f
C67 nmos_differential_pair__ABAB_0.x1_Vtest2 nmos_matched_cascode_pair__ABBA_0.x1_net3 0.00133f
C68 nmos_diode_2__A_0.net5 XC1__A_0.Vop1 4.03584f
C69 res_packs__interleaved_0.x2_x2_net4 pmos_differential_pair__ABBA_0.x2_Vout 0
C70 pmos_diode__A_0.net3 XC1__A_0.Vop1 1.1397f
C71 nmos_current_mirror_3__ABAB_0.net7 Vom 0.07073f
C72 nmos_differential_pair__ABAB_0.x1_net1 nmos_matched_cascode_pair__ABBA_0.x1_net5 0.00736f
C73 res_packs__interleaved_0.x2_x2_net14 res_packs__interleaved_0.x2_x1_net14 0.51069f
C74 mirror_XX1_M22_XX1_M15__ABAB_0.x1_net8 nmos_differential_pair__ABAB_0.x1_net1 0.107f
C75 Vom XC1__A_0.Vop1 51.7103f
C76 RGM XC2__A_0.Vom1 0.01605f
C77 pmos_current_mirror_load__ABAB_0.x1_net9 Vp 0
C78 nmos_differential_pair__ABAB_0.x1_Vtest2 VREF 0.11957f
C79 Vom res_packs__interleaved_0.x2_x2_net9 0.00112f
C80 res_packs__interleaved_0.x2_x2_net3 res_packs__interleaved_0.x2_x1_net3 0.41702f
C81 nmos_differential_pair__ABAB_0.x1_net2 nmos_current_mirror_4__A_0.net4 0.54895f
C82 res_packs__interleaved_0.x2_x2_net15 Vop 0.00207f
C83 nmos_single_2__A_0.NBias nmos_current_mirror_4__A_0.net4 0
C84 nmos_matched_cascode_pair__ABBA_0.x1_net3 nmos_current_mirror_4__A_0.net4 0.54882f
C85 pmos_current_mirror_load__ABAB_0.x1_Vout nmos_differential_pair__ABAB_0.x1_net1 5.49964f
C86 pmos_differential_pair__ABBA_0.x2_Vtest res_packs__interleaved_0.x2_x2_net10 0
C87 XC2__A_0.Vom1 nmos_single_2__A_0.PBias 0.20275f
C88 mirror_XX1_M22_XX1_M15__ABAB_0.x1_net7 XC2__A_0.Vom1 1.68422f
C89 res_packs__interleaved_0.x2_x1_net12 res_packs__interleaved_0.x2_x2_net12 0.41702f
C90 nmos_differential_pair__ABAB_0.x1_net2 pmos_current_mirror_load__ABAB_0.x1_net9 0.13913f
C91 res_packs__interleaved_0.x2_Vcm nmos_single_2__A_0.PBias 0
C92 nmos_matched_cascode_pair__ABBA_0.x1_net3 pmos_current_mirror_load__ABAB_0.x1_net9 0.08237f
C93 mirror_XX1_M22_XX1_M15__ABAB_0.x1_net7 nmos_matched_cascode_pair_2__ABAB_0.x1_net4 0.06639f
C94 nmos_current_mirror_4__A_0.net4 VREF 0.83742f
C95 res_packs__interleaved_0.x2_Vcm res_packs__interleaved_0.x2_x2_net2 0.00135f
C96 Vop res_packs__interleaved_0.x2_x1_net2 0.0031f
C97 nmos_diode__A_0.net1 nmos_single__A_0.net2 1.33455f
C98 res_packs__interleaved_0.x2_x1_net8 res_packs__interleaved_0.x2_x2_net8 0.51069f
C99 XC2__A_0.Vom1 pmos_differential_pair__ABBA_0.x2_Vtest 0.2451f
C100 res_packs__interleaved_0.x2_x2_net7 res_packs__interleaved_0.x2_x2_net11 0.16037f
C101 pmos_current_mirror_2__row_0.x2_Vbiasp VREF 0.0084f
C102 pmos_current_mirror_load__ABAB_0.x1_Vout Vop 0.26266f
C103 nmos_current_mirror_3__ABAB_0.net7 XC2__A_0.Vom1 0.00328f
C104 pmos_current_mirror_load__ABAB_0.x1_net9 VREF 0.83455f
C105 pmos_differential_pair__ABBA_0.x2_Vtest res_packs__interleaved_0.x2_Vcm 0.50221f
C106 pmos_current_mirror_2__row_0.x2_net1 Vop 0.08385f
C107 nmos_differential_pair__ABAB_0.x1_net2 nmos_current_mirror_2__ABBA_0.net6 0.09495f
C108 nmos_matched_cascode_pair__ABBA_0.x1_net3 nmos_current_mirror_2__ABBA_0.net6 0.00112f
C109 nmos_single_2__A_0.NBias nmos_current_mirror_2__ABBA_0.net6 0
C110 XC2__A_0.Vom1 XC1__A_0.Vop1 4.30324f
C111 pmos_differential_pair__ABBA_0.x2_Vout Vop 1.81112f
C112 nmos_diode_2__A_0.net5 Vp 0.16698f
C113 nmos_differential_pair__ABAB_0.x1_Vtest2 Vm 0.85164f
C114 res_packs__interleaved_0.x2_Vcm XC1__A_0.Vop1 0.00981f
C115 res_packs__interleaved_0.x2_x1_net12 res_packs__interleaved_0.x2_x1_net8 0.16069f
C116 nmos_matched_cascode_pair_2__ABAB_0.x1_net4 XC1__A_0.Vop1 0.09536f
C117 res_packs__interleaved_0.x2_x1_net9 Vop 0.00207f
C118 res_packs__interleaved_0.x2_x2_net9 res_packs__interleaved_0.x2_Vcm 0.00171f
C119 nmos_current_mirror_2__ABBA_0.net6 VREF 0.28182f
C120 res_packs__interleaved_0.x2_x1_net15 res_packs__interleaved_0.x2_x2_net13 0.02074f
C121 mirror_XX1_M22_XX1_M15__ABAB_0.x1_net7 nmos_matched_cascode_pair__ABBA_0.x1_net5 0
C122 nmos_differential_pair__ABAB_0.x1_net2 Vdd 0.09109f
C123 res_packs__interleaved_0.x2_x2_net11 Vop 0.00207f
C124 Vom res_packs__interleaved_0.x2_x1_net19 0
C125 Vdd nmos_matched_cascode_pair__ABBA_0.x1_net3 0.08476f
C126 res_packs__interleaved_0.x2_x1_net4 res_packs__interleaved_0.x2_x1_net6 0.16069f
C127 res_packs__interleaved_0.x2_x1_net6 res_packs__interleaved_0.x2_x1_net1 0.16069f
C128 nmos_single_2__A_0.NBias Vdd 3.55199f
C129 nmos_differential_pair__ABAB_0.x1_net2 nmos_diode_2__A_0.net5 0.99588f
C130 mirror_XX1_M22_XX1_M15__ABAB_0.x1_net8 mirror_XX1_M22_XX1_M15__ABAB_0.x1_net7 5.70829f
C131 nmos_diode_2__A_0.net5 nmos_single_2__A_0.NBias 0
C132 nmos_diode_2__A_0.net5 nmos_matched_cascode_pair__ABBA_0.x1_net3 0.31391f
C133 Vom res_packs__interleaved_0.x2_x2_net5 0.00114f
C134 nmos_single_2__A_0.NBias pmos_diode__A_0.net3 5.46423f
C135 res_packs__interleaved_0.x2_x1_net2 res_packs__interleaved_0.x2_x2_net2 0.51022f
C136 res_packs__interleaved_0.x2_x1_net10 res_packs__interleaved_0.x2_x2_net10 0.41702f
C137 mirror_XX1_M22_XX1_M15__ABAB_0.x1_net7 pmos_current_mirror_load__ABAB_0.x1_Vout 7.59307f
C138 nmos_single_2__A_0.NBias Vom 0.387f
C139 nmos_matched_cascode_pair_2__ABAB_0.x1_net6 nmos_differential_pair__ABAB_0.x1_net1 0.00736f
C140 Vdd VREF 12.9234f
C141 Vm pmos_current_mirror_load__ABAB_0.x1_net9 0
C142 nmos_diode_2__A_0.net5 VREF 1.80718f
C143 res_packs__interleaved_0.x2_x1_net7 res_packs__interleaved_0.x2_x2_net5 0.00925f
C144 res_packs__interleaved_0.x2_x1_net6 res_packs__interleaved_0.x2_x2_net1 0.02074f
C145 Vom res_packs__interleaved_0.x2_x1_net5 0.00123f
C146 XC1__A_0.Vop1 nmos_matched_cascode_pair__ABBA_0.x1_net5 1.44103f
C147 Vom VREF 0.19856f
C148 res_packs__interleaved_0.x2_x2_net19 Vop 0.0031f
C149 mirror_XX1_M22_XX1_M15__ABAB_0.x1_net8 XC1__A_0.Vop1 1.60392f
C150 Vom res_packs__interleaved_0.x2_x1_net17 0.01232f
C151 res_packs__interleaved_0.x2_x1_net13 Vom 0
C152 res_packs__interleaved_0.x2_x2_net6 pmos_differential_pair__ABBA_0.x2_Vout 0
C153 res_packs__interleaved_0.x2_x2_net1 res_packs__interleaved_0.x2_x1_net1 0.51069f
C154 pmos_current_mirror_2__row_0.x2_net1 pmos_differential_pair__ABBA_0.x2_Vtest 3.3464f
C155 XC2__A_0.Vom1 Vp 0.00332f
C156 res_packs__interleaved_0.x2_x1_net16 res_packs__interleaved_0.x2_x1_net18 0.16069f
C157 nmos_current_mirror_3__ABAB_0.net7 pmos_current_mirror_2__row_0.x2_net1 0
C158 res_packs__interleaved_0.x2_x1_net9 res_packs__interleaved_0.x2_x2_net2 0.00925f
C159 res_packs__interleaved_0.x2_x2_net9 res_packs__interleaved_0.x2_x1_net2 0.02074f
C160 pmos_current_mirror_load__ABAB_0.x1_Vout XC1__A_0.Vop1 0.71078f
C161 pmos_differential_pair__ABBA_0.x2_Vout pmos_differential_pair__ABBA_0.x2_Vtest 6.69504f
C162 nmos_differential_pair__ABAB_0.x1_Vtest2 nmos_current_mirror_4__A_0.net4 0.07393f
C163 nmos_current_mirror_3__ABAB_0.net7 pmos_differential_pair__ABBA_0.x2_Vout 0.06695f
C164 pmos_current_mirror_2__row_0.x2_net1 XC1__A_0.Vop1 0.00673f
C165 res_packs__interleaved_0.x2_Vcm res_packs__interleaved_0.x2_x1_net19 0.00135f
C166 res_packs__interleaved_0.x2_Vcm res_packs__interleaved_0.x2_x2_net5 0.16229f
C167 nmos_differential_pair__ABAB_0.x1_net2 XC2__A_0.Vom1 0.38109f
C168 XC2__A_0.Vom1 nmos_single_2__A_0.NBias 0.08005f
C169 XC2__A_0.Vom1 nmos_matched_cascode_pair__ABBA_0.x1_net3 0.09242f
C170 pmos_differential_pair__ABBA_0.x2_Vout XC1__A_0.Vop1 0.09776f
C171 nmos_differential_pair__ABAB_0.x1_Vtest2 pmos_current_mirror_load__ABAB_0.x1_net9 0.172f
C172 res_packs__interleaved_0.x2_x2_net7 Vop 0.0031f
C173 nmos_single_2__A_0.NBias res_packs__interleaved_0.x2_Vcm 0
C174 nmos_diode_2__A_0.net5 Vm 0.00138f
C175 nmos_differential_pair__ABAB_0.x1_net2 nmos_matched_cascode_pair_2__ABAB_0.x1_net4 1.11859f
C176 res_packs__interleaved_0.x2_x1_net3 res_packs__interleaved_0.x2_x1_net18 0.16069f
C177 nmos_diode__A_0.net1 Vdd 2.1182f
C178 nmos_matched_cascode_pair_2__ABAB_0.x1_net4 nmos_matched_cascode_pair__ABBA_0.x1_net3 4.99404f
C179 nmos_diode__A_0.net1 pmos_diode__A_0.net3 0.30202f
C180 XC2__A_0.Vom1 VREF 6.27323f
C181 res_packs__interleaved_0.x2_x1_net9 res_packs__interleaved_0.x2_x2_net9 0.41644f
C182 pmos_current_mirror_2__row_0.x2_Vbiasp nmos_current_mirror_4__A_0.net4 0.07932f
C183 res_packs__interleaved_0.x2_x1_net5 res_packs__interleaved_0.x2_Vcm 0.01316f
C184 Vdd nmos_single__A_0.net2 8.01634f
C185 nmos_diode__A_0.net1 Vom 0.51034f
C186 nmos_current_mirror_4__A_0.net4 pmos_current_mirror_load__ABAB_0.x1_net9 1.49847f
C187 pmos_diode__A_0.net3 nmos_single__A_0.net2 0.86187f
C188 res_packs__interleaved_0.x2_x2_net11 res_packs__interleaved_0.x2_x2_net9 0.16037f
C189 res_packs__interleaved_0.x2_Vcm VREF 3.26539f
C190 nmos_differential_pair__ABAB_0.x1_Vtest2 nmos_current_mirror_2__ABBA_0.net6 0.1364f
C191 res_packs__interleaved_0.x2_x2_net15 res_packs__interleaved_0.x2_x1_net19 0.00925f
C192 nmos_matched_cascode_pair_2__ABAB_0.x1_net4 VREF 0
C193 Vom res_packs__interleaved_0.x2_x2_net17 0.16133f
C194 mirror_XX1_M22_XX1_M15__ABAB_0.x1_net7 nmos_matched_cascode_pair_2__ABAB_0.x1_net6 0.06497f
C195 res_packs__interleaved_0.x2_x1_net13 res_packs__interleaved_0.x2_Vcm 0.00135f
C196 res_packs__interleaved_0.x2_x1_net17 res_packs__interleaved_0.x2_Vcm 0.00196f
C197 Vom nmos_single__A_0.net2 2.78793f
C198 nmos_differential_pair__ABAB_0.x1_Vtest2 pmos_diode_2__A_0.x1_Vbias 5.13285f
C199 Vom res_packs__interleaved_0.x2_x2_net13 0.00112f
C200 res_packs__interleaved_0.x2_x2_net16 res_packs__interleaved_0.x2_x1_net18 0.00925f
C201 res_packs__interleaved_0.x2_x1_net10 res_packs__interleaved_0.x2_x1_net8 0.16069f
C202 nmos_current_mirror_2__ABBA_0.net6 nmos_current_mirror_4__A_0.net4 0.28415f
C203 res_packs__interleaved_0.x2_x2_net4 pmos_differential_pair__ABBA_0.x2_Vtest 0
C204 res_packs__interleaved_0.x2_x2_net3 res_packs__interleaved_0.x2_x1_net14 0.00925f
C205 pmos_current_mirror_load__ABAB_0.x1_Vout Vp 0
C206 nmos_differential_pair__ABAB_0.x1_Vtest2 Vdd 17.5949f
C207 res_packs__interleaved_0.x2_x1_net12 res_packs__interleaved_0.x2_x2_net8 0.02074f
C208 nmos_differential_pair__ABAB_0.x1_net2 nmos_matched_cascode_pair__ABBA_0.x1_net5 0.18635f
C209 nmos_differential_pair__ABAB_0.x1_Vtest2 nmos_diode_2__A_0.net5 0.07805f
C210 nmos_differential_pair__ABAB_0.x1_net2 mirror_XX1_M22_XX1_M15__ABAB_0.x1_net8 0.19085f
C211 nmos_matched_cascode_pair__ABBA_0.x1_net3 nmos_matched_cascode_pair__ABBA_0.x1_net5 0.23673f
C212 Vom res_packs__interleaved_0.x2_x1_net15 0.00112f
C213 mirror_XX1_M22_XX1_M15__ABAB_0.x1_net8 nmos_matched_cascode_pair__ABBA_0.x1_net3 0
C214 res_packs__interleaved_0.x2_x2_net12 res_packs__interleaved_0.x2_x1_net14 0.00925f
C215 nmos_current_mirror_4__A_0.net4 pmos_diode_2__A_0.x1_Vbias 0
C216 pmos_current_mirror_2__row_0.x2_Vbiasp nmos_current_mirror_2__ABBA_0.net6 0.30703f
C217 res_packs__interleaved_0.x2_x1_net10 pmos_differential_pair__ABBA_0.x2_Vout 0
C218 nmos_matched_cascode_pair_2__ABAB_0.x1_net6 XC1__A_0.Vop1 0.44232f
C219 nmos_current_mirror_2__ABBA_0.net6 pmos_current_mirror_load__ABAB_0.x1_net9 0.22733f
C220 mirror_XX1_M22_XX1_M15__ABAB_0.x1_net7 nmos_differential_pair__ABAB_0.x1_net1 0.04988f
C221 res_packs__interleaved_0.x2_x1_net13 res_packs__interleaved_0.x2_x2_net15 0.00925f
C222 nmos_differential_pair__ABAB_0.x1_net2 pmos_current_mirror_load__ABAB_0.x1_Vout 0.08979f
C223 nmos_matched_cascode_pair__ABBA_0.x1_net3 pmos_current_mirror_load__ABAB_0.x1_Vout 0.04304f
C224 nmos_diode__A_0.net1 XC2__A_0.Vom1 0.18653f
C225 Vdd nmos_current_mirror_4__A_0.net4 5.03482f
C226 pmos_diode_2__A_0.x1_Vbias pmos_current_mirror_load__ABAB_0.x1_net9 0.0056f
C227 mirror_XX1_M22_XX1_M15__ABAB_0.x1_net8 VREF 1.10627f
C228 res_packs__interleaved_0.x2_x2_net18 res_packs__interleaved_0.x2_x1_net18 0.51069f
C229 nmos_diode_2__A_0.net5 nmos_current_mirror_4__A_0.net4 1.63744f
C230 pmos_diode__A_0.net3 nmos_current_mirror_4__A_0.net4 0
C231 RGM Vop 0.06837f
C232 nmos_diode__A_0.net1 res_packs__interleaved_0.x2_Vcm 0
C233 XC2__A_0.Vom1 nmos_single__A_0.net2 0.10455f
C234 res_packs__interleaved_0.x2_x2_net16 res_packs__interleaved_0.x2_x1_net16 0.41702f
C235 Vdd pmos_current_mirror_2__row_0.x2_Vbiasp 13.1087f
C236 res_packs__interleaved_0.x2_x2_net10 res_packs__interleaved_0.x2_x1_net1 0.00925f
C237 res_packs__interleaved_0.x2_Vcm res_packs__interleaved_0.x2_x2_net17 0.00199f
C238 nmos_diode_2__A_0.net5 pmos_current_mirror_2__row_0.x2_Vbiasp 0.09557f
C239 Vdd pmos_current_mirror_load__ABAB_0.x1_net9 29.1247f
C240 Vom nmos_current_mirror_4__A_0.net4 0.08056f
C241 pmos_current_mirror_load__ABAB_0.x1_Vout VREF 2.31538f
C242 nmos_diode_2__A_0.net5 pmos_current_mirror_load__ABAB_0.x1_net9 0.24259f
C243 Vop nmos_single_2__A_0.PBias 0.25157f
C244 mirror_XX1_M22_XX1_M15__ABAB_0.x1_net7 Vop 0.00475f
C245 pmos_current_mirror_2__row_0.x2_net1 VREF 0.30975f
C246 Vom pmos_current_mirror_2__row_0.x2_Vbiasp 0.72379f
C247 Vop res_packs__interleaved_0.x2_x2_net2 0.00207f
C248 nmos_current_mirror_2__ABBA_0.net6 pmos_diode_2__A_0.x1_Vbias 1.01467f
C249 res_packs__interleaved_0.x2_Vcm res_packs__interleaved_0.x2_x2_net13 0.00171f
C250 nmos_differential_pair__ABAB_0.x1_net1 XC1__A_0.Vop1 0.13042f
C251 Vom pmos_current_mirror_load__ABAB_0.x1_net9 0
C252 pmos_differential_pair__ABBA_0.x2_Vout VREF 0.29043f
C253 Vdd nmos_current_mirror_2__ABBA_0.net6 3.88109f
C254 res_packs__interleaved_0.x2_x1_net15 res_packs__interleaved_0.x2_Vcm 0.00171f
C255 pmos_differential_pair__ABBA_0.x2_Vtest Vop 0.20647f
C256 res_packs__interleaved_0.x2_x2_net18 res_packs__interleaved_0.x2_x1_net16 0.02074f
C257 nmos_differential_pair__ABAB_0.x1_Vtest2 XC2__A_0.Vom1 0.20419f
C258 nmos_diode_2__A_0.net5 nmos_current_mirror_2__ABBA_0.net6 0.15672f
C259 res_packs__interleaved_0.x2_x1_net4 res_packs__interleaved_0.x2_Vcm 0.06768f
C260 nmos_current_mirror_3__ABAB_0.net7 Vop 0.09157f
C261 pmos_diode__A_0.net3 nmos_current_mirror_2__ABBA_0.net6 0
C262 Vdd pmos_diode_2__A_0.x1_Vbias 30.7852f
C263 res_packs__interleaved_0.x2_x2_net19 res_packs__interleaved_0.x2_x1_net19 0.41644f
C264 nmos_differential_pair__ABAB_0.x1_Vtest2 nmos_matched_cascode_pair_2__ABAB_0.x1_net4 0.00133f
C265 Vop XC1__A_0.Vop1 0.29406f
C266 Vom nmos_current_mirror_2__ABBA_0.net6 0.52706f
C267 res_packs__interleaved_0.x2_x1_net11 Vom 0.00112f
C268 RGM nmos_single_2__A_0.PBias 0.00563f
C269 res_packs__interleaved_0.x2_x2_net9 Vop 0.0031f
C270 res_packs__interleaved_0.x2_x2_net15 res_packs__interleaved_0.x2_x2_net13 0.16037f
C271 XC2__A_0.Vom1 nmos_current_mirror_4__A_0.net4 4.07285f
C272 nmos_diode_2__A_0.net5 Vdd 3.07187f
C273 pmos_current_mirror_load__ABAB_0.x1_Vout Vm 0
C274 pmos_diode__A_0.net3 Vdd 16.1487f
C275 res_packs__interleaved_0.x2_x1_net3 res_packs__interleaved_0.x2_x2_net18 0.02074f
C276 nmos_diode_2__A_0.net5 pmos_diode__A_0.net3 0
C277 res_packs__interleaved_0.x2_Vcm nmos_current_mirror_4__A_0.net4 0.04988f
C278 XC2__A_0.Vom1 pmos_current_mirror_2__row_0.x2_Vbiasp 0.06307f
C279 nmos_matched_cascode_pair_2__ABAB_0.x1_net4 nmos_current_mirror_4__A_0.net4 0.52901f
C280 res_packs__interleaved_0.x2_x2_net15 res_packs__interleaved_0.x2_x1_net15 0.51022f
C281 nmos_differential_pair__ABAB_0.x1_net2 nmos_matched_cascode_pair_2__ABAB_0.x1_net6 0.29803f
C282 nmos_matched_cascode_pair__ABBA_0.x1_net3 nmos_matched_cascode_pair_2__ABAB_0.x1_net6 0.11011f
C283 XC2__A_0.Vom1 pmos_current_mirror_load__ABAB_0.x1_net9 1.60034f
C284 Vdd Vom 7.74627f
C285 res_packs__interleaved_0.x2_x1_net2 res_packs__interleaved_0.x2_x2_net13 0.02074f
C286 nmos_diode_2__A_0.net5 Vom 0.10996f
C287 pmos_current_mirror_2__row_0.x2_Vbiasp res_packs__interleaved_0.x2_Vcm 0.41478f
C288 pmos_diode__A_0.net3 Vom 0.18432f
C289 nmos_matched_cascode_pair_2__ABAB_0.x1_net4 pmos_current_mirror_load__ABAB_0.x1_net9 0.08251f
C290 res_packs__interleaved_0.x2_x1_net17 res_packs__interleaved_0.x2_x2_net19 0.02074f
C291 RGM XC1__A_0.Vop1 0
C292 res_packs__interleaved_0.x2_x2_net7 res_packs__interleaved_0.x2_x2_net5 0.16037f
C293 nmos_current_mirror_3__ABAB_0.net7 nmos_single_2__A_0.PBias 0.56349f
C294 nmos_differential_pair__ABAB_0.x1_net1 Vp 0.88064f
C295 nmos_matched_cascode_pair_2__ABAB_0.x1_net6 VREF 0
C296 res_packs__interleaved_0.x2_x2_net6 pmos_differential_pair__ABBA_0.x2_Vtest 0
C297 nmos_differential_pair__ABAB_0.x1_Vtest2 nmos_matched_cascode_pair__ABBA_0.x1_net5 0.00133f
C298 nmos_differential_pair__ABAB_0.x1_Vtest2 mirror_XX1_M22_XX1_M15__ABAB_0.x1_net8 0.15193f
C299 mirror_XX1_M22_XX1_M15__ABAB_0.x1_net7 XC1__A_0.Vop1 0.22478f
C300 XC2__A_0.Vom1 nmos_current_mirror_2__ABBA_0.net6 0.32496f
C301 nmos_single_2__A_0.PBias XC1__A_0.Vop1 1.32223f
C302 res_packs__interleaved_0.x2_x1_net10 res_packs__interleaved_0.x2_x2_net8 0.02074f
C303 res_packs__interleaved_0.x2_x1_net6 pmos_differential_pair__ABBA_0.x2_Vout 0
C304 nmos_current_mirror_2__ABBA_0.net6 res_packs__interleaved_0.x2_Vcm 0.17891f
C305 nmos_differential_pair__ABAB_0.x1_net2 nmos_differential_pair__ABAB_0.x1_net1 2.26884f
C306 res_packs__interleaved_0.x2_x1_net11 res_packs__interleaved_0.x2_Vcm 0.00171f
C307 XC2__A_0.Vom1 pmos_diode_2__A_0.x1_Vbias 1.82549f
C308 nmos_matched_cascode_pair__ABBA_0.x1_net3 nmos_differential_pair__ABAB_0.x1_net1 0.00736f
C309 nmos_matched_cascode_pair_2__ABAB_0.x1_net4 nmos_current_mirror_2__ABBA_0.net6 0.00134f
C310 nmos_differential_pair__ABAB_0.x1_Vtest2 pmos_current_mirror_load__ABAB_0.x1_Vout 3.63807f
C311 nmos_current_mirror_3__ABAB_0.net7 pmos_differential_pair__ABBA_0.x2_Vtest 0.4511f
C312 res_packs__interleaved_0.x2_x1_net7 Vom 0
C313 res_packs__interleaved_0.x2_x2_net9 res_packs__interleaved_0.x2_x2_net2 0.16037f
C314 res_packs__interleaved_0.x2_x2_net7 res_packs__interleaved_0.x2_x1_net5 0.02074f
C315 nmos_current_mirror_4__A_0.net4 nmos_matched_cascode_pair__ABBA_0.x1_net5 0.40646f
C316 mirror_XX1_M22_XX1_M15__ABAB_0.x1_net8 nmos_current_mirror_4__A_0.net4 0.65695f
C317 pmos_differential_pair__ABBA_0.x2_Vout res_packs__interleaved_0.x2_x1_net1 0
C318 pmos_differential_pair__ABBA_0.x2_Vtest XC1__A_0.Vop1 0.51136f
C319 res_packs__interleaved_0.x2_x1_net4 pmos_differential_pair__ABBA_0.x2_Vout 0
C320 Vop res_packs__interleaved_0.x2_x1_net19 0.00207f
C321 XC2__A_0.Vom1 Vdd 20.2691f
C322 nmos_current_mirror_3__ABAB_0.net7 XC1__A_0.Vop1 0.10105f
C323 Vop res_packs__interleaved_0.x2_x2_net5 0.00301f
C324 nmos_diode_2__A_0.net5 XC2__A_0.Vom1 0.68948f
C325 XC2__A_0.Vom1 pmos_diode__A_0.net3 0.09082f
C326 nmos_differential_pair__ABAB_0.x1_net1 VREF 0.27621f
C327 pmos_current_mirror_load__ABAB_0.x1_net9 nmos_matched_cascode_pair__ABBA_0.x1_net5 0.08237f
C328 pmos_current_mirror_load__ABAB_0.x1_Vout nmos_current_mirror_4__A_0.net4 2.21341f
C329 Vdd res_packs__interleaved_0.x2_Vcm 14.6433f
C330 mirror_XX1_M22_XX1_M15__ABAB_0.x1_net8 pmos_current_mirror_load__ABAB_0.x1_net9 6.33075f
C331 Vdd nmos_matched_cascode_pair_2__ABAB_0.x1_net4 0.08397f
C332 nmos_diode_2__A_0.net5 res_packs__interleaved_0.x2_Vcm 0.17127f
C333 nmos_single_2__A_0.NBias Vop 0.15195f
C334 nmos_diode_2__A_0.net5 nmos_matched_cascode_pair_2__ABAB_0.x1_net4 0.29782f
C335 XC2__A_0.Vom1 Vom 0.69736f
C336 pmos_current_mirror_2__row_0.x2_net1 nmos_current_mirror_4__A_0.net4 0.06963f
C337 res_packs__interleaved_0.x2_x2_net19 res_packs__interleaved_0.x2_x2_net17 0.16037f
C338 res_packs__interleaved_0.x2_x2_net1 pmos_differential_pair__ABBA_0.x2_Vout 0
C339 pmos_current_mirror_load__ABAB_0.x1_Vout pmos_current_mirror_load__ABAB_0.x1_net9 4.77486f
C340 Vom res_packs__interleaved_0.x2_Vcm 2.74449f
C341 pmos_differential_pair__ABBA_0.x2_Vout nmos_current_mirror_4__A_0.net4 0.25937f
C342 res_packs__interleaved_0.x2_x1_net5 Vop 0.00351f
C343 pmos_current_mirror_2__row_0.x2_Vbiasp pmos_current_mirror_2__row_0.x2_net1 1.74532f
C344 nmos_current_mirror_2__ABBA_0.net6 nmos_matched_cascode_pair__ABBA_0.x1_net5 0.00124f
C345 Vop VREF 0.1467f
C346 mirror_XX1_M22_XX1_M15__ABAB_0.x1_net8 nmos_current_mirror_2__ABBA_0.net6 0.65346f
C347 pmos_current_mirror_2__row_0.x2_Vbiasp pmos_differential_pair__ABBA_0.x2_Vout 1.08039f
C348 res_packs__interleaved_0.x2_x1_net17 Vop 0.0031f
C349 res_packs__interleaved_0.x2_x1_net13 Vop 0.00207f
C350 res_packs__interleaved_0.x2_x1_net6 res_packs__interleaved_0.x2_x2_net4 0.02074f
C351 mirror_XX1_M22_XX1_M15__ABAB_0.x1_net7 Vp 0
C352 res_packs__interleaved_0.x2_x1_net7 res_packs__interleaved_0.x2_Vcm 0.00135f
C353 res_packs__interleaved_0.x2_x1_net15 res_packs__interleaved_0.x2_x2_net19 0.02074f
C354 pmos_current_mirror_load__ABAB_0.x1_Vout nmos_current_mirror_2__ABBA_0.net6 0.24054f
C355 RGM nmos_single_2__A_0.NBias 0.00503f
C356 pmos_current_mirror_2__row_0.x2_net1 nmos_current_mirror_2__ABBA_0.net6 0.08151f
C357 Vm nmos_differential_pair__ABAB_0.x1_net1 0.0798f
C358 Vdd nmos_matched_cascode_pair__ABBA_0.x1_net5 0.08216f
C359 res_packs__interleaved_0.x2_x1_net3 res_packs__interleaved_0.x2_x1_net14 0.16069f
C360 res_packs__interleaved_0.x2_x1_net10 pmos_differential_pair__ABBA_0.x2_Vtest 0
C361 res_packs__interleaved_0.x2_x1_net4 res_packs__interleaved_0.x2_x2_net4 0.51069f
C362 pmos_current_mirror_load__ABAB_0.x1_Vout pmos_diode_2__A_0.x1_Vbias 0.00521f
C363 nmos_diode_2__A_0.net5 nmos_matched_cascode_pair__ABBA_0.x1_net5 0.27787f
C364 mirror_XX1_M22_XX1_M15__ABAB_0.x1_net8 Vdd 0.21801f
C365 res_packs__interleaved_0.x2_x2_net15 Vom 0
C366 res_packs__interleaved_0.x2_x1_net12 res_packs__interleaved_0.x2_x1_net14 0.16069f
C367 nmos_diode_2__A_0.net5 mirror_XX1_M22_XX1_M15__ABAB_0.x1_net8 0.21391f
C368 nmos_differential_pair__ABAB_0.x1_net2 mirror_XX1_M22_XX1_M15__ABAB_0.x1_net7 0.35231f
C369 nmos_single_2__A_0.NBias nmos_single_2__A_0.PBias 5.74953f
C370 mirror_XX1_M22_XX1_M15__ABAB_0.x1_net7 nmos_matched_cascode_pair__ABBA_0.x1_net3 0
C371 pmos_differential_pair__ABBA_0.x2_Vout nmos_current_mirror_2__ABBA_0.net6 0.16764f
C372 nmos_differential_pair__ABAB_0.x1_Vtest2 nmos_matched_cascode_pair_2__ABAB_0.x1_net6 0.00133f
C373 XC2__A_0.Vom1 res_packs__interleaved_0.x2_Vcm 0.04988f
C374 Vdd pmos_current_mirror_load__ABAB_0.x1_Vout 52.4008f
C375 XC2__A_0.Vom1 nmos_matched_cascode_pair_2__ABAB_0.x1_net4 1.35001f
C376 nmos_diode_2__A_0.net5 pmos_current_mirror_load__ABAB_0.x1_Vout 0.23352f
C377 XC1__A_0.Vop1 Vp 0.08629f
C378 Vom res_packs__interleaved_0.x2_x1_net2 0.00112f
C379 Vdd pmos_current_mirror_2__row_0.x2_net1 4.4503f
C380 mirror_XX1_M22_XX1_M15__ABAB_0.x1_net7 VREF 1.48057f
C381 nmos_diode_2__A_0.net5 pmos_current_mirror_2__row_0.x2_net1 0.08237f
C382 res_packs__interleaved_0.x2_x2_net11 res_packs__interleaved_0.x2_x1_net11 0.51022f
C383 nmos_current_mirror_4__A_0.net4 nmos_matched_cascode_pair_2__ABAB_0.x1_net6 0.55398f
C384 nmos_diode__A_0.net1 Vop 0.79748f
C385 nmos_current_mirror_3__ABAB_0.net7 nmos_single_2__A_0.NBias 0
C386 Vom pmos_current_mirror_load__ABAB_0.x1_Vout 0.25438f
C387 Vdd pmos_differential_pair__ABBA_0.x2_Vout 2.29672f
C388 Vop res_packs__interleaved_0.x2_x2_net17 0.00207f
C389 nmos_diode_2__A_0.net5 pmos_differential_pair__ABBA_0.x2_Vout 0.37044f
C390 res_packs__interleaved_0.x2_x1_net13 res_packs__interleaved_0.x2_x2_net2 0.00925f
C391 Vom pmos_current_mirror_2__row_0.x2_net1 0.08157f
C392 nmos_differential_pair__ABAB_0.x1_net2 XC1__A_0.Vop1 3.47657f
C393 nmos_single_2__A_0.NBias XC1__A_0.Vop1 0.65274f
C394 nmos_matched_cascode_pair__ABBA_0.x1_net3 XC1__A_0.Vop1 1.10759f
C395 Vop nmos_single__A_0.net2 0.89951f
C396 nmos_matched_cascode_pair_2__ABAB_0.x1_net6 pmos_current_mirror_load__ABAB_0.x1_net9 0.09339f
C397 pmos_differential_pair__ABBA_0.x2_Vtest VREF 0.06687f
C398 nmos_differential_pair__ABAB_0.x1_Vtest2 nmos_differential_pair__ABAB_0.x1_net1 9.48056f
C399 Vom pmos_differential_pair__ABBA_0.x2_Vout 1.13189f
C400 Vop res_packs__interleaved_0.x2_x2_net13 0.0031f
C401 Vom res_packs__interleaved_0.x2_x1_net9 0
C402 res_packs__interleaved_0.x2_x1_net8 res_packs__interleaved_0.x2_x2_net10 0.00925f
C403 VREF XC1__A_0.Vop1 6.53237f
C404 res_packs__interleaved_0.x2_x2_net15 res_packs__interleaved_0.x2_Vcm 0.00135f
C405 res_packs__interleaved_0.x2_x1_net15 Vop 0.0031f
C406 XC2__A_0.Vom1 nmos_matched_cascode_pair__ABBA_0.x1_net5 0.08076f
C407 mirror_XX1_M22_XX1_M15__ABAB_0.x1_net8 XC2__A_0.Vom1 0.16244f
C408 res_packs__interleaved_0.x2_x2_net11 Vom 0
C409 nmos_current_mirror_4__A_0.net4 nmos_differential_pair__ABAB_0.x1_net1 0.06535f
C410 RGM nmos_diode__A_0.net1 2.80202f
C411 res_packs__interleaved_0.x2_x1_net3 res_packs__interleaved_0.x2_x2_net14 0.02074f
C412 nmos_current_mirror_2__ABBA_0.net6 nmos_matched_cascode_pair_2__ABAB_0.x1_net6 0.74915f
C413 res_packs__interleaved_0.x2_x1_net12 res_packs__interleaved_0.x2_x2_net14 0.02074f
C414 pmos_differential_pair__ABBA_0.x2_Vout res_packs__interleaved_0.x2_x2_net10 0
C415 nmos_matched_cascode_pair_2__ABAB_0.x1_net4 nmos_matched_cascode_pair__ABBA_0.x1_net5 5.08787f
C416 mirror_XX1_M22_XX1_M15__ABAB_0.x1_net7 Vm 0
C417 mirror_XX1_M22_XX1_M15__ABAB_0.x1_net8 nmos_matched_cascode_pair_2__ABAB_0.x1_net4 0.07293f
C418 XC2__A_0.Vom1 pmos_current_mirror_load__ABAB_0.x1_Vout 1.28357f
C419 RGM nmos_single__A_0.net2 0
C420 nmos_diode__A_0.net1 nmos_single_2__A_0.PBias 0.70973f
C421 res_packs__interleaved_0.x2_Vcm res_packs__interleaved_0.x2_x1_net2 0.00171f
C422 pmos_current_mirror_load__ABAB_0.x1_net9 nmos_differential_pair__ABAB_0.x1_net1 0.13257f
C423 res_packs__interleaved_0.x2_x1_net7 res_packs__interleaved_0.x2_x2_net11 0.00925f
C424 XC2__A_0.Vom1 pmos_current_mirror_2__row_0.x2_net1 0.05455f
C425 nmos_matched_cascode_pair_2__ABAB_0.x1_net4 pmos_current_mirror_load__ABAB_0.x1_Vout 0.04318f
C426 nmos_single_2__A_0.PBias nmos_single__A_0.net2 2.02417f
C427 Vdd nmos_matched_cascode_pair_2__ABAB_0.x1_net6 0.08713f
C428 Vop nmos_current_mirror_4__A_0.net4 0.18069f
C429 pmos_current_mirror_2__row_0.x2_net1 res_packs__interleaved_0.x2_Vcm 0.7069f
C430 XC2__A_0.Vom1 pmos_differential_pair__ABBA_0.x2_Vout 0.2416f
C431 nmos_diode_2__A_0.net5 nmos_matched_cascode_pair_2__ABAB_0.x1_net6 0.30671f
C432 res_packs__interleaved_0.x2_x2_net7 res_packs__interleaved_0.x2_x1_net11 0.02074f
C433 Vom res_packs__interleaved_0.x2_x2_net19 0.00112f
C434 res_packs__interleaved_0.x2_x2_net2 res_packs__interleaved_0.x2_x2_net13 0.16037f
C435 pmos_differential_pair__ABBA_0.x2_Vout res_packs__interleaved_0.x2_Vcm 0.12549f
C436 pmos_current_mirror_2__row_0.x2_Vbiasp Vop 0.08452f
C437 nmos_differential_pair__ABAB_0.x1_net2 Vp 0.89037f
C438 res_packs__interleaved_0.x2_x2_net6 res_packs__interleaved_0.x2_x1_net6 0.41702f
C439 nmos_current_mirror_2__ABBA_0.net6 nmos_differential_pair__ABAB_0.x1_net1 0.06976f
C440 Vop pmos_current_mirror_load__ABAB_0.x1_net9 0
C441 Vm XC1__A_0.Vop1 0
C442 res_packs__interleaved_0.x2_x1_net8 res_packs__interleaved_0.x2_x2_net12 0.00925f
C443 nmos_diode__A_0.net1 XC1__A_0.Vop1 0.13325f
C444 res_packs__interleaved_0.x2_x1_net9 res_packs__interleaved_0.x2_Vcm 0.00135f
C445 pmos_diode_2__A_0.x1_Vbias nmos_differential_pair__ABAB_0.x1_net1 4.96191f
C446 res_packs__interleaved_0.x2_x1_net6 pmos_differential_pair__ABBA_0.x2_Vtest 0
C447 mirror_XX1_M22_XX1_M15__ABAB_0.x1_net8 nmos_matched_cascode_pair__ABBA_0.x1_net5 0.00647f
C448 res_packs__interleaved_0.x2_x2_net11 res_packs__interleaved_0.x2_Vcm 0.00135f
C449 nmos_differential_pair__ABAB_0.x1_Vtest2 mirror_XX1_M22_XX1_M15__ABAB_0.x1_net7 0.06491f
C450 res_packs__interleaved_0.x2_x1_net4 res_packs__interleaved_0.x2_x2_net6 0.00925f
C451 res_packs__interleaved_0.x2_x2_net6 res_packs__interleaved_0.x2_x1_net1 0.00925f
C452 nmos_single__A_0.net2 XC1__A_0.Vop1 0.06247f
C453 VREF Vp 0
C454 nmos_differential_pair__ABAB_0.x1_net2 nmos_matched_cascode_pair__ABBA_0.x1_net3 1.25806f
C455 res_packs__interleaved_0.x2_x1_net5 res_packs__interleaved_0.x2_x2_net5 0.51022f
C456 Vdd nmos_differential_pair__ABAB_0.x1_net1 11.9201f
C457 nmos_current_mirror_2__ABBA_0.net6 Vop 0.11118f
C458 nmos_diode_2__A_0.net5 nmos_differential_pair__ABAB_0.x1_net1 0.07805f
C459 pmos_current_mirror_load__ABAB_0.x1_Vout nmos_matched_cascode_pair__ABBA_0.x1_net5 0.04304f
C460 res_packs__interleaved_0.x2_x1_net11 Vop 0.0031f
C461 pmos_differential_pair__ABBA_0.x2_Vtest res_packs__interleaved_0.x2_x1_net1 0
C462 res_packs__interleaved_0.x2_x1_net4 pmos_differential_pair__ABBA_0.x2_Vtest 0
C463 res_packs__interleaved_0.x2_x2_net7 Vom 0.00112f
C464 mirror_XX1_M22_XX1_M15__ABAB_0.x1_net8 pmos_current_mirror_load__ABAB_0.x1_Vout 6.03388f
C465 nmos_current_mirror_4__A_0.net4 nmos_single_2__A_0.PBias 0.5688f
C466 mirror_XX1_M22_XX1_M15__ABAB_0.x1_net7 nmos_current_mirror_4__A_0.net4 0.71587f
C467 nmos_differential_pair__ABAB_0.x1_net2 VREF 2.337f
C468 res_packs__interleaved_0.x2_x2_net16 Vss 1.01524f
C469 res_packs__interleaved_0.x2_x1_net16 Vss 1.48257f
C470 res_packs__interleaved_0.x2_x1_net17 Vss 1.10261f
C471 res_packs__interleaved_0.x2_x2_net17 Vss 1.16246f
C472 res_packs__interleaved_0.x2_x2_net18 Vss 1.09142f
C473 res_packs__interleaved_0.x2_x1_net18 Vss 1.15006f
C474 res_packs__interleaved_0.x2_x1_net19 Vss 0.99661f
C475 res_packs__interleaved_0.x2_x2_net19 Vss 1.28412f
C476 res_packs__interleaved_0.x2_x2_net3 Vss 0.99757f
C477 res_packs__interleaved_0.x2_x1_net3 Vss 1.28865f
C478 res_packs__interleaved_0.x2_x1_net15 Vss 1.08817f
C479 res_packs__interleaved_0.x2_x2_net15 Vss 1.14752f
C480 res_packs__interleaved_0.x2_x2_net14 Vss 1.09105f
C481 res_packs__interleaved_0.x2_x1_net14 Vss 1.1493f
C482 res_packs__interleaved_0.x2_x1_net13 Vss 0.99662f
C483 res_packs__interleaved_0.x2_x2_net13 Vss 1.28412f
C484 res_packs__interleaved_0.x2_x2_net12 Vss 0.99757f
C485 res_packs__interleaved_0.x2_x1_net12 Vss 1.28865f
C486 res_packs__interleaved_0.x2_x1_net2 Vss 1.08817f
C487 res_packs__interleaved_0.x2_x2_net2 Vss 1.14752f
C488 res_packs__interleaved_0.x2_x2_net8 Vss 1.09106f
C489 res_packs__interleaved_0.x2_x1_net8 Vss 1.14929f
C490 res_packs__interleaved_0.x2_x1_net9 Vss 0.99662f
C491 res_packs__interleaved_0.x2_x2_net9 Vss 1.28412f
C492 res_packs__interleaved_0.x2_x2_net10 Vss 0.99714f
C493 res_packs__interleaved_0.x2_x1_net10 Vss 1.28692f
C494 res_packs__interleaved_0.x2_x1_net11 Vss 1.08818f
C495 res_packs__interleaved_0.x2_x2_net11 Vss 1.14751f
C496 res_packs__interleaved_0.x2_x2_net1 Vss 1.09103f
C497 res_packs__interleaved_0.x2_x1_net1 Vss 1.14944f
C498 res_packs__interleaved_0.x2_x1_net7 Vss 0.99894f
C499 res_packs__interleaved_0.x2_x2_net7 Vss 1.2874f
C500 res_packs__interleaved_0.x2_x2_net6 Vss 1.00397f
C501 res_packs__interleaved_0.x2_x1_net6 Vss 1.29797f
C502 res_packs__interleaved_0.x2_x1_net5 Vss 1.11573f
C503 res_packs__interleaved_0.x2_x2_net5 Vss 1.18142f
C504 res_packs__interleaved_0.x2_x2_net4 Vss 1.17839f
C505 res_packs__interleaved_0.x2_x1_net4 Vss 1.42727f
C506 RGM Vss 1.66314f
C507 pmos_current_mirror_2__row_0.x2_net1 Vss 34.67397f
C508 Vop Vss 69.60223f
C509 Vom Vss 96.11126f
C510 mirror_XX1_M22_XX1_M15__ABAB_0.x1_net8 Vss 11.30834f
C511 mirror_XX1_M22_XX1_M15__ABAB_0.x1_net7 Vss 13.5879f
C512 nmos_differential_pair__ABAB_0.x1_net2 Vss 34.46498f
C513 nmos_matched_cascode_pair_2__ABAB_0.x1_net6 Vss 56.10862f
C514 nmos_matched_cascode_pair__ABBA_0.x1_net5 Vss 4.6487f
C515 nmos_matched_cascode_pair_2__ABAB_0.x1_net4 Vss 18.95115f
C516 nmos_matched_cascode_pair__ABBA_0.x1_net3 Vss 8.97656f
C517 nmos_current_mirror_2__ABBA_0.net6 Vss 1.3729f
C518 nmos_differential_pair__ABAB_0.x1_net1 Vss 22.23467f
C519 nmos_differential_pair__ABAB_0.x1_Vtest2 Vss 12.28684f
.ends

.end
