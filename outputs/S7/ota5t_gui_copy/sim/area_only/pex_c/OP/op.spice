* example_ota_5t on diso_amp_OP
.lib $PDK_ROOT/sky130A/libs.tech/combined/sky130.lib.spice tt
.option rshunt=1e12
.param VDD_V=1.8 VCM_V=0.9 CL_F=1p
.temp 27

** sch_path: /foss/designs/PROJECTS/llm-analog-sizing/testbenches/diso_amp_OP.sch
**.subckt diso_amp_OP
x1 INP INN net1 VDD 0 OUT dut_amp
Vinp INP 0 'VCM_V'
Vinn INN 0 'VCM_V'
Cload OUT 0 'CL_F'
* noconn #net1
Vsup VDD 0 'VDD_V'
**** begin user architecture code

.control
  save all
  op

  * supply current [uA], supply power [uW], output operating point [V]
  let isup    = abs(i(vsup))
  let isup_ua = isup * 1e6
  let power_uw = isup * v(VDD) * 1e6
  let vout_v  = v(OUT)

  echo MEAS isup_ua $&isup_ua
  echo MEAS power_uw $&power_uw
  echo MEAS vout_v $&vout_v

  write
  quit 0
.endc

**** end user architecture code
**.ends

* expanding   symbol:  dut_amp.sym # of pins=6
** sym_path: /foss/designs/PROJECTS/llm-analog-sizing/testbenches/dut_amp.sym
** sch_path: /foss/designs/PROJECTS/llm-analog-sizing/testbenches/dut_amp.sch
.subckt dut_amp INP INN OUTN VDD VSS OUTP
XDUT OUTP INN INP N_VBIAS VDD VSS N_net3 N_net1 ota5t_gui_copy_routed_flat
VV1_layout N_VBIAS VSS 0.75
.ends
.subckt example_ota_5t_sized VDD OUTP INP INN VSS
XM3 net3 net3 VDD VDD sky130_fd_pr__pfet_01v8 L=1 W=8 NF=1 AD=2.32 AS=2.32 PD=16.58 PS=16.58 NRD=0.03625 NRS=0.03625 SA=0 SB=0 SD=0 MULT=1
XM4 OUTP net3 VDD VDD sky130_fd_pr__pfet_01v8 L=1 W=8 NF=1 AD=2.32 AS=2.32 PD=16.58 PS=16.58 NRD=0.03625 NRS=0.03625 SA=0 SB=0 SD=0 MULT=1
XM1 net3 INP net1 VSS sky130_fd_pr__nfet_01v8 L=0.5 W=24 NF=1 AD=6.96 AS=6.96 PD=48.58 PS=48.58 NRD=0.0120833333333333 NRS=0.0120833333333333 SA=0 SB=0 SD=0 MULT=1
XM2 OUTP INN net1 VSS sky130_fd_pr__nfet_01v8 L=0.5 W=24 NF=1 AD=6.96 AS=6.96 PD=48.58 PS=48.58 NRD=0.0120833333333333 NRS=0.0120833333333333 SA=0 SB=0 SD=0 MULT=1
XM5 net1 net2 VSS VSS sky130_fd_pr__nfet_01v8 L=1 W=24 NF=1 AD=6.96 AS=6.96 PD=48.58 PS=48.58 NRD=0.0120833333333333 NRS=0.0120833333333333 SA=0 SB=0 SD=0 MULT=1
V1 net2 VSS 0.75
.ends example_ota_5t_sized
* NGSPICE file created from ota5t_gui_copy_routed_flat.ext - technology: sky130A

.subckt ota5t_gui_copy_routed_flat OUTP INN INP VBIAS VDD VSS pmos_current_mirror_load__AB_0.net3
+ nmos_current_mirror_bias__A_0.net1
X0 nmos_current_mirror_bias__A_0.net1 INN OUTP VSS sky130_fd_pr__nfet_01v8 ad=3.48 pd=24.58 as=3.48 ps=24.58 w=12 l=0.5
X1 VDD VDD VDD VDD sky130_fd_pr__pfet_01v8 ad=2.32 pd=16.58 as=13.92 ps=99.48 w=8 l=1
X2 nmos_current_mirror_bias__A_0.net1 VBIAS VSS VSS sky130_fd_pr__nfet_01v8 ad=3.48 pd=24.58 as=1.74 ps=12.29 w=12 l=1
X3 OUTP INN nmos_current_mirror_bias__A_0.net1 VSS sky130_fd_pr__nfet_01v8 ad=3.48 pd=24.58 as=3.48 ps=24.58 w=12 l=0.5
X4 OUTP pmos_current_mirror_load__AB_0.net3 VDD VDD sky130_fd_pr__pfet_01v8 ad=2.32 pd=16.58 as=2.32 ps=16.58 w=8 l=1
X5 VDD VDD VDD VDD sky130_fd_pr__pfet_01v8 ad=2.32 pd=16.58 as=0 ps=0 w=8 l=1
X6 pmos_current_mirror_load__AB_0.net3 INP nmos_current_mirror_bias__A_0.net1 VSS sky130_fd_pr__nfet_01v8 ad=3.48 pd=24.58 as=3.48 ps=24.58 w=12 l=0.5
X7 nmos_current_mirror_bias__A_0.net1 INP pmos_current_mirror_load__AB_0.net3 VSS sky130_fd_pr__nfet_01v8 ad=3.48 pd=24.58 as=3.48 ps=24.58 w=12 l=0.5
X8 VDD pmos_current_mirror_load__AB_0.net3 pmos_current_mirror_load__AB_0.net3 VDD sky130_fd_pr__pfet_01v8 ad=2.32 pd=16.58 as=2.32 ps=16.58 w=8 l=1
X9 VSS VSS VSS VSS sky130_fd_pr__nfet_01v8 ad=3.48 pd=24.58 as=17.4 ps=122.9 w=12 l=0.5
X10 VSS VBIAS nmos_current_mirror_bias__A_0.net1 VSS sky130_fd_pr__nfet_01v8 ad=1.74 pd=12.29 as=3.48 ps=24.58 w=12 l=1
X11 VSS VSS VSS VSS sky130_fd_pr__nfet_01v8 ad=3.48 pd=24.58 as=0 ps=0 w=12 l=0.5
C0 nmos_current_mirror_bias__A_0.net1 INP 0.88853f
C1 VDD nmos_current_mirror_bias__A_0.net1 0
C2 VBIAS pmos_current_mirror_load__AB_0.net3 0.00298f
C3 INN OUTP 1.13125f
C4 INN INP 0.84135f
C5 pmos_current_mirror_load__AB_0.net3 OUTP 2.50139f
C6 VDD INN 0.05988f
C7 pmos_current_mirror_load__AB_0.net3 INP 0.96605f
C8 VDD pmos_current_mirror_load__AB_0.net3 5.98787f
C9 VBIAS OUTP 0.04543f
C10 INN nmos_current_mirror_bias__A_0.net1 0.88814f
C11 pmos_current_mirror_load__AB_0.net3 nmos_current_mirror_bias__A_0.net1 2.26656f
C12 OUTP INP 0.0982f
C13 VDD OUTP 1.55191f
C14 VDD INP 0.00911f
C15 INN pmos_current_mirror_load__AB_0.net3 0.11948f
C16 VBIAS nmos_current_mirror_bias__A_0.net1 1.70149f
C17 nmos_current_mirror_bias__A_0.net1 OUTP 3.37569f
C18 nmos_current_mirror_bias__A_0.net1 VSS 10.38823f
C19 OUTP VSS 6.12552f
C20 VDD VSS 0.45818f
.ends

.end
