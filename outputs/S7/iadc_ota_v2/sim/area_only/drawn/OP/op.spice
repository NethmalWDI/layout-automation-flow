* iadc_ota on dido_amp_OP
.lib $PDK_ROOT/sky130A/libs.tech/combined/sky130.lib.spice tt
.option rshunt=1e12
.param VDD_V=1.8 VCM_V=0.9 CL_F=0.3p
.temp 27

**.subckt dido_amp_OP
x1 INP INN OUTN VDD 0 OUTP dut_amp
Vsup VDD 0 'VDD_V'
* AC drive through 1 F couplers; DC set by unity feedback through 1 GH chokes (OUTP->INN, OUTN->INP)
Vacp ACP 0 dc 0 ac 0
Vacn ACN 0 dc 0 ac 0
Cinp ACP INP 1
Cinn ACN INN 1
Lfbp OUTP INN 1G
Lfbn OUTN INP 1G
Cloadp OUTP 0 'CL_F'
Cloadn OUTN 0 'CL_F'
.control
  save all
  op
  let isup    = abs(i(vsup))
  let isup_ua = isup * 1e6
  let power_uw = isup * v(VDD) * 1e6
  let vout_v  = v(OUTP) - v(OUTN)
  echo MEAS isup_ua $&isup_ua
  echo MEAS power_uw $&power_uw
  echo MEAS vout_v $&vout_v
  let voutcm_v = (v(OUTP) + v(OUTN)) / 2
  echo MEAS voutcm_v $&voutcm_v
  write
  quit 0
.endc
**.ends

.subckt dut_amp INP INN OUTN VDD VSS OUTP
XDUT OUTN OUTP bias_a_w cm_w N_IBIAS VDD VSS cmc_w INN INP N_x2_m4d N_x2_m3d N_x1_net1 N_x1_net2 N_x1_net3 N_x1_net13 N_x1_net14 N_x1_net15 N_x1_net4 N_x1_net5 N_x1_net6 N_x1_net7 N_x1_net8 N_x1_net9 N_x1_net10 N_x1_net11 N_x1_net12 N_bias_d N_x1_m5d N_x2_foldp N_x2_tail N_x2_foldn N_x1_m2d N_bias_b N_bias_c N_x1_m21d N_x1_m25d N_x1_m31d iadc_ota_v2_routed_flat
* ideal CMFB: the steady-state law of the upstream switched-capacitor CMFB (ASSUMPTION)
Bcmfb cmc_w VSS V = v(bias_a_w) + (v(OUTP) + v(OUTN))/2 - v(cm_w)
IIbias_ext_layout VDD N_IBIAS 3e-05
.ends
.subckt iadc_ota ip in op on VDD VSS cmc cm bias_a
XX1_M22 bias_b bias_c x1_m21d VDD sky130_fd_pr__pfet_01v8 L=0.6 W=1.4 NF=1 AD=0.406 AS=0.406 PD=3.38 PS=3.38 NRD=0.207143 NRS=0.207143 SA=0 SB=0 SD=0 MULT=6 M=6
XX1_M26 x1_m2d bias_c x1_m25d VDD sky130_fd_pr__pfet_01v8 L=0.6 W=1.4 NF=1 AD=0.406 AS=0.406 PD=3.38 PS=3.38 NRD=0.207143 NRS=0.207143 SA=0 SB=0 SD=0 MULT=6 M=6
XX1_M32 cm bias_c x1_m31d VDD sky130_fd_pr__pfet_01v8 L=0.6 W=1.4 NF=1 AD=0.406 AS=0.406 PD=3.38 PS=3.38 NRD=0.207143 NRS=0.207143 SA=0 SB=0 SD=0 MULT=6 M=6
XX1_M21 x1_m21d bias_b VDD VDD sky130_fd_pr__pfet_01v8_lvt L=0.6 W=1.4 NF=1 AD=0.406 AS=0.406 PD=3.38 PS=3.38 NRD=0.207143 NRS=0.207143 SA=0 SB=0 SD=0 MULT=6 M=6
XX1_M25 x1_m25d bias_b VDD VDD sky130_fd_pr__pfet_01v8_lvt L=0.6 W=1.4 NF=1 AD=0.406 AS=0.406 PD=3.38 PS=3.38 NRD=0.207143 NRS=0.207143 SA=0 SB=0 SD=0 MULT=6 M=6
XX1_M31 x1_m31d bias_b VDD VDD sky130_fd_pr__pfet_01v8_lvt L=0.6 W=1.4 NF=1 AD=0.406 AS=0.406 PD=3.38 PS=3.38 NRD=0.207143 NRS=0.207143 SA=0 SB=0 SD=0 MULT=6 M=6
XX1_M1 bias_b bias_b bias_c VSS sky130_fd_pr__nfet_01v8_lvt L=0.6 W=1.4 NF=1 AD=0.406 AS=0.406 PD=3.38 PS=3.38 NRD=0.207143 NRS=0.207143 SA=0 SB=0 SD=0 MULT=56 M=56
XX1_M2 x1_m2d x1_m2d bias_d VSS sky130_fd_pr__nfet_01v8 L=0.6 W=1.4 NF=1 AD=0.406 AS=0.406 PD=3.38 PS=3.38 NRD=0.207143 NRS=0.207143 SA=0 SB=0 SD=0 MULT=50 M=50
XX1_M3 bias_d x1_m2d bias_a VSS sky130_fd_pr__nfet_01v8 L=0.6 W=1.4 NF=1 AD=0.406 AS=0.406 PD=3.38 PS=3.38 NRD=0.207143 NRS=0.207143 SA=0 SB=0 SD=0 MULT=2 M=2
XX1_M4 bias_a bias_d x1_m5d VSS sky130_fd_pr__nfet_01v8 L=0.6 W=1.4 NF=1 AD=0.406 AS=0.406 PD=3.38 PS=3.38 NRD=0.207143 NRS=0.207143 SA=0 SB=0 SD=0 MULT=18 M=18
XX1_M5 x1_m5d bias_a VSS VSS sky130_fd_pr__nfet_01v8 L=0.6 W=1.4 NF=1 AD=0.406 AS=0.406 PD=3.38 PS=3.38 NRD=0.207143 NRS=0.207143 SA=0 SB=0 SD=0 MULT=18 M=18
XX1_M6 bias_c i_bias VSS VSS sky130_fd_pr__nfet_01v8 L=0.6 W=1.4 NF=1 AD=0.406 AS=0.406 PD=3.38 PS=3.38 NRD=0.207143 NRS=0.207143 SA=0 SB=0 SD=0 MULT=18 M=18
XX1_M7 i_bias i_bias VSS VSS sky130_fd_pr__nfet_01v8 L=0.6 W=1.4 NF=1 AD=0.406 AS=0.406 PD=3.38 PS=3.38 NRD=0.207143 NRS=0.207143 SA=0 SB=0 SD=0 MULT=18 M=18
XX1_M33 cm cm x1_net1 VSS sky130_fd_pr__nfet_01v8 L=0.6 W=1.4 NF=1 AD=0.406 AS=0.406 PD=3.38 PS=3.38 NRD=0.207143 NRS=0.207143 SA=0 SB=0 SD=0 MULT=1 M=1
XX1_M49 x1_net1 cm x1_net2 VSS sky130_fd_pr__nfet_01v8 L=0.6 W=1.4 NF=1 AD=0.406 AS=0.406 PD=3.38 PS=3.38 NRD=0.207143 NRS=0.207143 SA=0 SB=0 SD=0 MULT=1 M=1
XX1_M50 x1_net2 cm x1_net3 VSS sky130_fd_pr__nfet_01v8 L=0.6 W=1.4 NF=1 AD=0.406 AS=0.406 PD=3.38 PS=3.38 NRD=0.207143 NRS=0.207143 SA=0 SB=0 SD=0 MULT=1 M=1
XX1_M63 x1_net3 cm VSS VSS sky130_fd_pr__nfet_01v8 L=0.6 W=1.4 NF=1 AD=0.406 AS=0.406 PD=3.38 PS=3.38 NRD=0.207143 NRS=0.207143 SA=0 SB=0 SD=0 MULT=1 M=1
XX1_M68 cm cm x1_net4 VSS sky130_fd_pr__nfet_01v8 L=0.6 W=1.4 NF=1 AD=0.406 AS=0.406 PD=3.38 PS=3.38 NRD=0.207143 NRS=0.207143 SA=0 SB=0 SD=0 MULT=1 M=1
XX1_M69 x1_net4 cm x1_net5 VSS sky130_fd_pr__nfet_01v8 L=0.6 W=1.4 NF=1 AD=0.406 AS=0.406 PD=3.38 PS=3.38 NRD=0.207143 NRS=0.207143 SA=0 SB=0 SD=0 MULT=1 M=1
XX1_M70 x1_net5 cm x1_net6 VSS sky130_fd_pr__nfet_01v8 L=0.6 W=1.4 NF=1 AD=0.406 AS=0.406 PD=3.38 PS=3.38 NRD=0.207143 NRS=0.207143 SA=0 SB=0 SD=0 MULT=1 M=1
XX1_M71 x1_net6 cm VSS VSS sky130_fd_pr__nfet_01v8 L=0.6 W=1.4 NF=1 AD=0.406 AS=0.406 PD=3.38 PS=3.38 NRD=0.207143 NRS=0.207143 SA=0 SB=0 SD=0 MULT=1 M=1
XX1_M72 cm cm x1_net7 VSS sky130_fd_pr__nfet_01v8 L=0.6 W=1.4 NF=1 AD=0.406 AS=0.406 PD=3.38 PS=3.38 NRD=0.207143 NRS=0.207143 SA=0 SB=0 SD=0 MULT=1 M=1
XX1_M73 x1_net7 cm x1_net8 VSS sky130_fd_pr__nfet_01v8 L=0.6 W=1.4 NF=1 AD=0.406 AS=0.406 PD=3.38 PS=3.38 NRD=0.207143 NRS=0.207143 SA=0 SB=0 SD=0 MULT=1 M=1
XX1_M74 x1_net8 cm x1_net9 VSS sky130_fd_pr__nfet_01v8 L=0.6 W=1.4 NF=1 AD=0.406 AS=0.406 PD=3.38 PS=3.38 NRD=0.207143 NRS=0.207143 SA=0 SB=0 SD=0 MULT=1 M=1
XX1_M75 x1_net9 cm VSS VSS sky130_fd_pr__nfet_01v8 L=0.6 W=1.4 NF=1 AD=0.406 AS=0.406 PD=3.38 PS=3.38 NRD=0.207143 NRS=0.207143 SA=0 SB=0 SD=0 MULT=1 M=1
XX1_M76 cm cm x1_net10 VSS sky130_fd_pr__nfet_01v8 L=0.6 W=1.4 NF=1 AD=0.406 AS=0.406 PD=3.38 PS=3.38 NRD=0.207143 NRS=0.207143 SA=0 SB=0 SD=0 MULT=1 M=1
XX1_M77 x1_net10 cm x1_net11 VSS sky130_fd_pr__nfet_01v8 L=0.6 W=1.4 NF=1 AD=0.406 AS=0.406 PD=3.38 PS=3.38 NRD=0.207143 NRS=0.207143 SA=0 SB=0 SD=0 MULT=1 M=1
XX1_M78 x1_net11 cm x1_net12 VSS sky130_fd_pr__nfet_01v8 L=0.6 W=1.4 NF=1 AD=0.406 AS=0.406 PD=3.38 PS=3.38 NRD=0.207143 NRS=0.207143 SA=0 SB=0 SD=0 MULT=1 M=1
XX1_M79 x1_net12 cm VSS VSS sky130_fd_pr__nfet_01v8 L=0.6 W=1.4 NF=1 AD=0.406 AS=0.406 PD=3.38 PS=3.38 NRD=0.207143 NRS=0.207143 SA=0 SB=0 SD=0 MULT=1 M=1
XX1_M64 cm cm x1_net13 VSS sky130_fd_pr__nfet_01v8 L=0.6 W=1.4 NF=1 AD=0.406 AS=0.406 PD=3.38 PS=3.38 NRD=0.207143 NRS=0.207143 SA=0 SB=0 SD=0 MULT=1 M=1
XX1_M65 x1_net13 cm x1_net14 VSS sky130_fd_pr__nfet_01v8 L=0.6 W=1.4 NF=1 AD=0.406 AS=0.406 PD=3.38 PS=3.38 NRD=0.207143 NRS=0.207143 SA=0 SB=0 SD=0 MULT=1 M=1
XX1_M66 x1_net14 cm x1_net15 VSS sky130_fd_pr__nfet_01v8 L=0.6 W=1.4 NF=1 AD=0.406 AS=0.406 PD=3.38 PS=3.38 NRD=0.207143 NRS=0.207143 SA=0 SB=0 SD=0 MULT=1 M=1
XX1_M67 x1_net15 cm VSS VSS sky130_fd_pr__nfet_01v8 L=0.6 W=1.4 NF=1 AD=0.406 AS=0.406 PD=3.38 PS=3.38 NRD=0.207143 NRS=0.207143 SA=0 SB=0 SD=0 MULT=1 M=1
XX1_M57 bias_b VDD VDD VDD sky130_fd_pr__pfet_01v8 L=0.6 W=1.4 NF=1 AD=0.406 AS=0.406 PD=3.38 PS=3.38 NRD=0.207143 NRS=0.207143 SA=0 SB=0 SD=0 MULT=2 M=2
XX1_M58 x1_m2d VDD VDD VDD sky130_fd_pr__pfet_01v8 L=0.6 W=1.4 NF=1 AD=0.406 AS=0.406 PD=3.38 PS=3.38 NRD=0.207143 NRS=0.207143 SA=0 SB=0 SD=0 MULT=2 M=2
XX1_M59 cm VDD VDD VDD sky130_fd_pr__pfet_01v8 L=0.6 W=1.4 NF=1 AD=0.406 AS=0.406 PD=3.38 PS=3.38 NRD=0.207143 NRS=0.207143 SA=0 SB=0 SD=0 MULT=2 M=2
XX1_M60 x1_m31d VDD VDD VDD sky130_fd_pr__pfet_01v8 L=0.6 W=1.4 NF=1 AD=0.406 AS=0.406 PD=3.38 PS=3.38 NRD=0.207143 NRS=0.207143 SA=0 SB=0 SD=0 MULT=2 M=2
XX1_M42 x1_m5d VSS VSS VSS sky130_fd_pr__nfet_01v8 L=0.6 W=1.4 NF=1 AD=0.406 AS=0.406 PD=3.38 PS=3.38 NRD=0.207143 NRS=0.207143 SA=0 SB=0 SD=0 MULT=6 M=6
XX1_M44 bias_c bias_c bias_c VSS sky130_fd_pr__nfet_01v8 L=0.6 W=1.4 NF=1 AD=0.406 AS=0.406 PD=3.38 PS=3.38 NRD=0.207143 NRS=0.207143 SA=0 SB=0 SD=0 MULT=2 M=2
XX1_M34 bias_d bias_d bias_d VSS sky130_fd_pr__nfet_01v8 L=0.6 W=1.4 NF=1 AD=0.406 AS=0.406 PD=3.38 PS=3.38 NRD=0.207143 NRS=0.207143 SA=0 SB=0 SD=0 MULT=8 M=8
XX1_M35 x1_m2d x1_m2d x1_m2d VSS sky130_fd_pr__nfet_01v8 L=0.6 W=1.4 NF=1 AD=0.406 AS=0.406 PD=3.38 PS=3.38 NRD=0.207143 NRS=0.207143 SA=0 SB=0 SD=0 MULT=2 M=2
XX1_M36 bias_a bias_a bias_a VSS sky130_fd_pr__nfet_01v8 L=0.6 W=1.4 NF=1 AD=0.406 AS=0.406 PD=3.38 PS=3.38 NRD=0.207143 NRS=0.207143 SA=0 SB=0 SD=0 MULT=4 M=4
XX1_M37 cm cm cm VSS sky130_fd_pr__nfet_01v8 L=0.6 W=1.4 NF=1 AD=0.406 AS=0.406 PD=3.38 PS=3.38 NRD=0.207143 NRS=0.207143 SA=0 SB=0 SD=0 MULT=8 M=8
XX1_M54 x1_m25d x1_m25d x1_m25d VDD sky130_fd_pr__pfet_01v8 L=0.6 W=1.4 NF=1 AD=0.406 AS=0.406 PD=3.38 PS=3.38 NRD=0.207143 NRS=0.207143 SA=0 SB=0 SD=0 MULT=2 M=2
XX1_M29 x1_m5d x1_m5d x1_m5d VSS sky130_fd_pr__nfet_01v8 L=0.6 W=1.4 NF=1 AD=0.406 AS=0.406 PD=3.38 PS=3.38 NRD=0.207143 NRS=0.207143 SA=0 SB=0 SD=0 MULT=6 M=6
XX1_M8 i_bias i_bias i_bias VSS sky130_fd_pr__nfet_01v8 L=0.6 W=1.4 NF=1 AD=0.406 AS=0.406 PD=3.38 PS=3.38 NRD=0.207143 NRS=0.207143 SA=0 SB=0 SD=0 MULT=2 M=2
XX1_M10 bias_c bias_c bias_c VSS sky130_fd_pr__nfet_01v8_lvt L=0.6 W=1.4 NF=1 AD=0.406 AS=0.406 PD=3.38 PS=3.38 NRD=0.207143 NRS=0.207143 SA=0 SB=0 SD=0 MULT=8 M=8
XX1_M27 bias_b bias_b bias_b VSS sky130_fd_pr__nfet_01v8_lvt L=0.6 W=1.4 NF=1 AD=0.406 AS=0.406 PD=3.38 PS=3.38 NRD=0.207143 NRS=0.207143 SA=0 SB=0 SD=0 MULT=8 M=8
XX1_M46 x1_m21d x1_m21d x1_m21d VDD sky130_fd_pr__pfet_01v8_lvt L=0.6 W=1.4 NF=1 AD=0.406 AS=0.406 PD=3.38 PS=3.38 NRD=0.207143 NRS=0.207143 SA=0 SB=0 SD=0 MULT=2 M=2
XX1_M47 x1_m25d x1_m25d x1_m25d VDD sky130_fd_pr__pfet_01v8_lvt L=0.6 W=1.4 NF=1 AD=0.406 AS=0.406 PD=3.38 PS=3.38 NRD=0.207143 NRS=0.207143 SA=0 SB=0 SD=0 MULT=2 M=2
XX1_M48 x1_m31d x1_m31d x1_m31d VDD sky130_fd_pr__pfet_01v8_lvt L=0.6 W=1.4 NF=1 AD=0.406 AS=0.406 PD=3.38 PS=3.38 NRD=0.207143 NRS=0.207143 SA=0 SB=0 SD=0 MULT=2 M=2
XX1_M51 x1_m21d x1_m21d x1_m21d VDD sky130_fd_pr__pfet_01v8 L=0.6 W=1.4 NF=1 AD=0.406 AS=0.406 PD=3.38 PS=3.38 NRD=0.207143 NRS=0.207143 SA=0 SB=0 SD=0 MULT=2 M=2
XX2_M1 x2_foldp ip x2_tail VSS sky130_fd_pr__nfet_01v8_lvt L=0.2 W=1.2 NF=1 AD=0.348 AS=0.348 PD=2.98 PS=2.98 NRD=0.241667 NRS=0.241667 SA=0 SB=0 SD=0 MULT=6 M=6
XX2_M2 x2_foldn in x2_tail VSS sky130_fd_pr__nfet_01v8_lvt L=0.2 W=1.2 NF=1 AD=0.348 AS=0.348 PD=2.98 PS=2.98 NRD=0.241667 NRS=0.241667 SA=0 SB=0 SD=0 MULT=6 M=6
XX2_M6 x2_tail cmc VSS VSS sky130_fd_pr__nfet_01v8 L=0.6 W=1.4 NF=1 AD=0.406 AS=0.406 PD=3.38 PS=3.38 NRD=0.207143 NRS=0.207143 SA=0 SB=0 SD=0 MULT=96 M=96
XX2_M5 x2_tail bias_a VSS VSS sky130_fd_pr__nfet_01v8 L=0.6 W=1.4 NF=1 AD=0.406 AS=0.406 PD=3.38 PS=3.38 NRD=0.207143 NRS=0.207143 SA=0 SB=0 SD=0 MULT=96 M=96
XX2_M11 x2_foldp bias_b VDD VDD sky130_fd_pr__pfet_01v8_lvt L=0.6 W=1.4 NF=1 AD=0.406 AS=0.406 PD=3.38 PS=3.38 NRD=0.207143 NRS=0.207143 SA=0 SB=0 SD=0 MULT=24 M=24
XX2_M12 x2_foldn bias_b VDD VDD sky130_fd_pr__pfet_01v8_lvt L=0.6 W=1.4 NF=1 AD=0.406 AS=0.406 PD=3.38 PS=3.38 NRD=0.207143 NRS=0.207143 SA=0 SB=0 SD=0 MULT=24 M=24
XX2_M1A on bias_c x2_foldp VDD sky130_fd_pr__pfet_01v8 L=0.6 W=1.4 NF=1 AD=0.406 AS=0.406 PD=3.38 PS=3.38 NRD=0.207143 NRS=0.207143 SA=0 SB=0 SD=0 MULT=20 M=20
XX2_M8 op bias_c x2_foldn VDD sky130_fd_pr__pfet_01v8 L=0.6 W=1.4 NF=1 AD=0.406 AS=0.406 PD=3.38 PS=3.38 NRD=0.207143 NRS=0.207143 SA=0 SB=0 SD=0 MULT=20 M=20
XX2_M3A on bias_d x2_m3d VSS sky130_fd_pr__nfet_01v8 L=0.6 W=1.4 NF=1 AD=0.406 AS=0.406 PD=3.38 PS=3.38 NRD=0.207143 NRS=0.207143 SA=0 SB=0 SD=0 MULT=36 M=36
XX2_M7 op bias_d x2_m4d VSS sky130_fd_pr__nfet_01v8 L=0.6 W=1.4 NF=1 AD=0.406 AS=0.406 PD=3.38 PS=3.38 NRD=0.207143 NRS=0.207143 SA=0 SB=0 SD=0 MULT=36 M=36
XX2_M3 x2_m3d bias_a VSS VSS sky130_fd_pr__nfet_01v8 L=0.6 W=1.4 NF=1 AD=0.406 AS=0.406 PD=3.38 PS=3.38 NRD=0.207143 NRS=0.207143 SA=0 SB=0 SD=0 MULT=36 M=36
XX2_M4 x2_m4d bias_a VSS VSS sky130_fd_pr__nfet_01v8 L=0.6 W=1.4 NF=1 AD=0.406 AS=0.406 PD=3.38 PS=3.38 NRD=0.207143 NRS=0.207143 SA=0 SB=0 SD=0 MULT=36 M=36
XX2_M82 x2_foldn x2_foldn x2_foldn VDD sky130_fd_pr__pfet_01v8 L=0.6 W=1.4 NF=1 AD=0.406 AS=0.406 PD=3.38 PS=3.38 NRD=0.207143 NRS=0.207143 SA=0 SB=0 SD=0 MULT=2 M=2
XX2_M83 x2_foldp x2_foldp x2_foldp VDD sky130_fd_pr__pfet_01v8 L=0.6 W=1.4 NF=1 AD=0.406 AS=0.406 PD=3.38 PS=3.38 NRD=0.207143 NRS=0.207143 SA=0 SB=0 SD=0 MULT=2 M=2
XX2_M55 x2_foldn VDD VDD VDD sky130_fd_pr__pfet_01v8 L=0.6 W=1.4 NF=1 AD=0.406 AS=0.406 PD=3.38 PS=3.38 NRD=0.207143 NRS=0.207143 SA=0 SB=0 SD=0 MULT=2 M=2
XX2_M56 op VDD VDD VDD sky130_fd_pr__pfet_01v8 L=0.6 W=1.4 NF=1 AD=0.406 AS=0.406 PD=3.38 PS=3.38 NRD=0.207143 NRS=0.207143 SA=0 SB=0 SD=0 MULT=4 M=4
XX2_M61 x2_foldp VDD VDD VDD sky130_fd_pr__pfet_01v8 L=0.6 W=1.4 NF=1 AD=0.406 AS=0.406 PD=3.38 PS=3.38 NRD=0.207143 NRS=0.207143 SA=0 SB=0 SD=0 MULT=2 M=2
XX2_M62 on VDD VDD VDD sky130_fd_pr__pfet_01v8 L=0.6 W=1.4 NF=1 AD=0.406 AS=0.406 PD=3.38 PS=3.38 NRD=0.207143 NRS=0.207143 SA=0 SB=0 SD=0 MULT=4 M=4
XX2_M40 x2_m4d VSS VSS VSS sky130_fd_pr__nfet_01v8 L=0.6 W=1.4 NF=1 AD=0.406 AS=0.406 PD=3.38 PS=3.38 NRD=0.207143 NRS=0.207143 SA=0 SB=0 SD=0 MULT=6 M=6
XX2_M41 x2_m3d VSS VSS VSS sky130_fd_pr__nfet_01v8 L=0.6 W=1.4 NF=1 AD=0.406 AS=0.406 PD=3.38 PS=3.38 NRD=0.207143 NRS=0.207143 SA=0 SB=0 SD=0 MULT=8 M=8
XX2_M38 op op op VSS sky130_fd_pr__nfet_01v8 L=0.6 W=1.4 NF=1 AD=0.406 AS=0.406 PD=3.38 PS=3.38 NRD=0.207143 NRS=0.207143 SA=0 SB=0 SD=0 MULT=2 M=2
XX2_M39 on on on VSS sky130_fd_pr__nfet_01v8 L=0.6 W=1.4 NF=1 AD=0.406 AS=0.406 PD=3.38 PS=3.38 NRD=0.207143 NRS=0.207143 SA=0 SB=0 SD=0 MULT=2 M=2
XX2_M30 x2_tail VSS VSS VSS sky130_fd_pr__nfet_01v8 L=0.6 W=1.4 NF=1 AD=0.406 AS=0.406 PD=3.38 PS=3.38 NRD=0.207143 NRS=0.207143 SA=0 SB=0 SD=0 MULT=2 M=2
XX2_M23 x2_foldp x2_foldp x2_foldp VSS sky130_fd_pr__nfet_01v8_lvt L=0.2 W=1.2 NF=1 AD=0.348 AS=0.348 PD=2.98 PS=2.98 NRD=0.241667 NRS=0.241667 SA=0 SB=0 SD=0 MULT=2 M=2
XX2_M24 x2_foldn x2_foldn x2_foldn VSS sky130_fd_pr__nfet_01v8_lvt L=0.2 W=1.2 NF=1 AD=0.348 AS=0.348 PD=2.98 PS=2.98 NRD=0.241667 NRS=0.241667 SA=0 SB=0 SD=0 MULT=2 M=2
XX2_M80 op VSS VSS VSS sky130_fd_pr__nfet_01v8 L=0.6 W=1.4 NF=1 AD=0.406 AS=0.406 PD=3.38 PS=3.38 NRD=0.207143 NRS=0.207143 SA=0 SB=0 SD=0 MULT=2 M=2
XX2_M81 on VSS VSS VSS sky130_fd_pr__nfet_01v8 L=0.6 W=1.4 NF=1 AD=0.406 AS=0.406 PD=3.38 PS=3.38 NRD=0.207143 NRS=0.207143 SA=0 SB=0 SD=0 MULT=2 M=2
XX2_M28 x2_tail x2_tail x2_tail VSS sky130_fd_pr__nfet_01v8 L=0.6 W=1.4 NF=1 AD=0.406 AS=0.406 PD=3.38 PS=3.38 NRD=0.207143 NRS=0.207143 SA=0 SB=0 SD=0 MULT=6 M=6
XM43 VDD VDD VDD VDD sky130_fd_pr__pfet_01v8_lvt L=0.6 W=1.4 NF=1 AD=0.406 AS=0.406 PD=3.38 PS=3.38 NRD=0.207143 NRS=0.207143 SA=0 SB=0 SD=0 MULT=8 M=8
XM45 VDD VDD VDD VDD sky130_fd_pr__pfet_01v8 L=0.6 W=1.4 NF=1 AD=0.406 AS=0.406 PD=3.38 PS=3.38 NRD=0.207143 NRS=0.207143 SA=0 SB=0 SD=0 MULT=6 M=6
XM9 VSS VSS VSS VSS sky130_fd_pr__nfet_01v8 L=0.6 W=1.4 NF=1 AD=0.406 AS=0.406 PD=3.38 PS=3.38 NRD=0.207143 NRS=0.207143 SA=0 SB=0 SD=0 MULT=23 M=23
Ibias_ext VDD i_bias 3e-05
XC3 op cmc sky130_fd_pr__cap_mim_m3_1 W=4.8 L=4.8 MF=4 M=4
XC4 on cmc sky130_fd_pr__cap_mim_m3_1 W=4.8 L=4.8 MF=4 M=4
.ends iadc_ota
* NGSPICE file created from iadc_ota_v2_routed_flat.ext - technology: sky130A

.subckt iadc_ota_v2_routed_flat on op bias_a cm IBIAS VDD VSS cmc in ip x2_cm_tail__id6_0.x2_m4d
+ x2_cm_tail__id6_0.x2_m3d x1_cc_cm__strings1_0.x1_net1 x1_cc_cm__strings1_0.x1_net2
+ x1_cc_cm__strings1_0.x1_net3 x1_cc_cm__strings1_0.x1_net13 x1_cc_cm__strings1_0.x1_net14
+ x1_cc_cm__strings1_0.x1_net15 x1_cc_cm__strings1_0.x1_net4 x1_cc_cm__strings1_0.x1_net5
+ x1_cc_cm__strings1_0.x1_net6 x1_cc_cm__strings1_0.x1_net7 x1_cc_cm__strings1_0.x1_net8
+ x1_cc_cm__strings1_0.x1_net9 x1_cc_cm__strings1_0.x1_net10 x1_cc_cm__strings1_0.x1_net11
+ x1_cc_cm__strings1_0.x1_net12 x2_cm_casc__cc3_0.bias_d x1_single_m5__f3_0.x1_m5d
+ x2_diff__cc3_0.x2_foldp x2_diff__cc3_0.x2_tail x2_diff__cc3_0.x2_foldn x1_single_m3__f1_0.x1_m2d
+ x2_cl_src__cc4_0.bias_b x2_cl_casc__cc4_0.bias_c x1_cm_bias_c__cc1_0.x1_m21d x1_cm_bias_c__cc1_0.x1_m25d
+ x1_cm_bias_c__cc1_0.x1_m31d
X0 x1_single_m5__f3_0.x1_m5d x1_single_m5__f3_0.x1_m5d x1_single_m5__f3_0.x1_m5d VSS sky130_fd_pr__nfet_01v8 ad=0.406 pd=3.38 as=21.924 ps=182.52 w=1.4 l=0.6
X1 VDD x2_cl_src__cc4_0.bias_b x2_diff__cc3_0.x2_foldn VDD sky130_fd_pr__pfet_01v8_lvt ad=0.406 pd=3.38 as=0.406 ps=3.38 w=1.4 l=0.6
X2 VSS VSS VSS VSS sky130_fd_pr__nfet_01v8 ad=0.406 pd=3.38 as=168.258 ps=1.4011k w=1.4 l=0.6
X3 x1_single_m5__f3_0.x1_m5d x2_cm_casc__cc3_0.bias_d bias_a VSS sky130_fd_pr__nfet_01v8 ad=0.406 pd=3.38 as=0.406 ps=3.38 w=1.4 l=0.6
X4 VSS bias_a x2_cm_tail__id6_0.x2_m4d VSS sky130_fd_pr__nfet_01v8 ad=0.406 pd=3.38 as=0.406 ps=3.38 w=1.4 l=0.6
X5 VSS bias_a x2_diff__cc3_0.x2_tail VSS sky130_fd_pr__nfet_01v8 ad=0.406 pd=3.38 as=0.406 ps=3.38 w=1.4 l=0.6
X6 VSS cmc x2_diff__cc3_0.x2_tail VSS sky130_fd_pr__nfet_01v8 ad=0.406 pd=3.38 as=0.406 ps=3.38 w=1.4 l=0.6
X7 x2_cm_casc__cc3_0.bias_d x2_cm_casc__cc3_0.bias_d x2_cm_casc__cc3_0.bias_d VSS sky130_fd_pr__nfet_01v8 ad=0.406 pd=3.38 as=27.608 ps=229.84 w=1.4 l=0.6
X8 x2_cl_casc__cc4_0.bias_c x2_cl_src__cc4_0.bias_b x2_cl_src__cc4_0.bias_b VSS sky130_fd_pr__nfet_01v8_lvt ad=0.406 pd=3.38 as=0.406 ps=3.38 w=1.4 l=0.6
X9 VSS bias_a x2_cm_tail__id6_0.x2_m3d VSS sky130_fd_pr__nfet_01v8 ad=0.406 pd=3.38 as=0.406 ps=3.38 w=1.4 l=0.6
X10 op x2_cl_casc__cc4_0.bias_c x2_diff__cc3_0.x2_foldn VDD sky130_fd_pr__pfet_01v8 ad=0.406 pd=3.38 as=0.406 ps=3.38 w=1.4 l=0.6
X11 VSS cmc x2_diff__cc3_0.x2_tail VSS sky130_fd_pr__nfet_01v8 ad=0.406 pd=3.38 as=0.406 ps=3.38 w=1.4 l=0.6
X12 on x2_cm_casc__cc3_0.bias_d x2_cm_tail__id6_0.x2_m3d VSS sky130_fd_pr__nfet_01v8 ad=0.406 pd=3.38 as=0.406 ps=3.38 w=1.4 l=0.6
X13 VSS bias_a x2_diff__cc3_0.x2_tail VSS sky130_fd_pr__nfet_01v8 ad=0.406 pd=3.38 as=0.406 ps=3.38 w=1.4 l=0.6
X14 x2_cm_tail__id6_0.x2_m3d bias_a VSS VSS sky130_fd_pr__nfet_01v8 ad=0.406 pd=3.38 as=0.406 ps=3.38 w=1.4 l=0.6
X15 VSS bias_a x2_diff__cc3_0.x2_tail VSS sky130_fd_pr__nfet_01v8 ad=0.406 pd=3.38 as=0.406 ps=3.38 w=1.4 l=0.6
X16 VSS bias_a x2_diff__cc3_0.x2_tail VSS sky130_fd_pr__nfet_01v8 ad=0.406 pd=3.38 as=0.406 ps=3.38 w=1.4 l=0.6
X17 x1_cm_bias_c__cc1_0.x1_m31d x2_cl_casc__cc4_0.bias_c cm VDD sky130_fd_pr__pfet_01v8 ad=0.406 pd=3.38 as=0.406 ps=3.38 w=1.4 l=0.6
X18 on x2_cl_casc__cc4_0.bias_c x2_diff__cc3_0.x2_foldp VDD sky130_fd_pr__pfet_01v8 ad=0.406 pd=3.38 as=0.406 ps=3.38 w=1.4 l=0.6
X19 x2_diff__cc3_0.x2_tail bias_a VSS VSS sky130_fd_pr__nfet_01v8 ad=0.406 pd=3.38 as=0.406 ps=3.38 w=1.4 l=0.6
X20 x2_diff__cc3_0.x2_tail bias_a VSS VSS sky130_fd_pr__nfet_01v8 ad=0.406 pd=3.38 as=0.406 ps=3.38 w=1.4 l=0.6
X21 x2_cm_tail__id6_0.x2_m3d x2_cm_casc__cc3_0.bias_d on VSS sky130_fd_pr__nfet_01v8 ad=0.406 pd=3.38 as=0.406 ps=3.38 w=1.4 l=0.6
X22 x2_diff__cc3_0.x2_tail cmc VSS VSS sky130_fd_pr__nfet_01v8 ad=0.406 pd=3.38 as=0.406 ps=3.38 w=1.4 l=0.6
X23 x2_diff__cc3_0.x2_foldp x2_cl_src__cc4_0.bias_b VDD VDD sky130_fd_pr__pfet_01v8_lvt ad=0.406 pd=3.38 as=0.406 ps=3.38 w=1.4 l=0.6
X24 x1_single_m3__f1_0.x1_m2d x1_single_m3__f1_0.x1_m2d x2_cm_casc__cc3_0.bias_d VSS sky130_fd_pr__nfet_01v8 ad=0.406 pd=3.38 as=0.406 ps=3.38 w=1.4 l=0.6
X25 x2_diff__cc3_0.x2_foldp x2_diff__cc3_0.x2_foldp x2_diff__cc3_0.x2_foldp VSS sky130_fd_pr__nfet_01v8_lvt ad=0.348 pd=2.98 as=3.48 ps=29.8 w=1.2 l=0.2
X26 VSS VSS x2_cm_tail__id6_0.x2_m4d VSS sky130_fd_pr__nfet_01v8 ad=0.406 pd=3.38 as=0.406 ps=3.38 w=1.4 l=0.6
X27 on x2_cm_casc__cc3_0.bias_d x2_cm_tail__id6_0.x2_m3d VSS sky130_fd_pr__nfet_01v8 ad=0.406 pd=3.38 as=0.406 ps=3.38 w=1.4 l=0.6
X28 VSS cmc x2_diff__cc3_0.x2_tail VSS sky130_fd_pr__nfet_01v8 ad=0.406 pd=3.38 as=0.406 ps=3.38 w=1.4 l=0.6
X29 VDD x2_cl_src__cc4_0.bias_b x1_cm_bias_c__cc1_0.x1_m25d VDD sky130_fd_pr__pfet_01v8_lvt ad=0.406 pd=3.38 as=0.406 ps=3.38 w=1.4 l=0.6
X30 IBIAS IBIAS VSS VSS sky130_fd_pr__nfet_01v8 ad=0.406 pd=3.38 as=0.406 ps=3.38 w=1.4 l=0.6
X31 VDD VDD x2_cl_src__cc4_0.bias_b VDD sky130_fd_pr__pfet_01v8 ad=0.406 pd=3.38 as=0.406 ps=3.38 w=1.4 l=0.6
X32 VDD VDD on VDD sky130_fd_pr__pfet_01v8 ad=0.406 pd=3.38 as=0.406 ps=3.38 w=1.4 l=0.6
X33 VSS cmc x2_diff__cc3_0.x2_tail VSS sky130_fd_pr__nfet_01v8 ad=0.406 pd=3.38 as=0.406 ps=3.38 w=1.4 l=0.6
X34 x1_single_m3__f1_0.x1_m2d x1_single_m3__f1_0.x1_m2d x2_cm_casc__cc3_0.bias_d VSS sky130_fd_pr__nfet_01v8 ad=0.406 pd=3.38 as=0.406 ps=3.38 w=1.4 l=0.6
X35 on x2_cl_casc__cc4_0.bias_c x2_diff__cc3_0.x2_foldp VDD sky130_fd_pr__pfet_01v8 ad=0.406 pd=3.38 as=0.406 ps=3.38 w=1.4 l=0.6
X36 VSS bias_a x2_diff__cc3_0.x2_tail VSS sky130_fd_pr__nfet_01v8 ad=0.406 pd=3.38 as=0.406 ps=3.38 w=1.4 l=0.6
X37 VSS bias_a x2_diff__cc3_0.x2_tail VSS sky130_fd_pr__nfet_01v8 ad=0.406 pd=3.38 as=0.406 ps=3.38 w=1.4 l=0.6
X38 VSS VSS VSS VSS sky130_fd_pr__nfet_01v8 ad=0.406 pd=3.38 as=0 ps=0 w=1.4 l=0.6
X39 x2_diff__cc3_0.x2_tail bias_a VSS VSS sky130_fd_pr__nfet_01v8 ad=0.406 pd=3.38 as=0.406 ps=3.38 w=1.4 l=0.6
X40 x1_single_m5__f3_0.x1_m5d bias_a VSS VSS sky130_fd_pr__nfet_01v8 ad=0.406 pd=3.38 as=0.406 ps=3.38 w=1.4 l=0.6
X41 x2_cl_src__cc4_0.bias_b x2_cl_src__cc4_0.bias_b x2_cl_casc__cc4_0.bias_c VSS sky130_fd_pr__nfet_01v8_lvt ad=0.406 pd=3.38 as=0.406 ps=3.38 w=1.4 l=0.6
X42 x2_cm_tail__id6_0.x2_m4d bias_a VSS VSS sky130_fd_pr__nfet_01v8 ad=0.406 pd=3.38 as=0.406 ps=3.38 w=1.4 l=0.6
X43 x2_cl_casc__cc4_0.bias_c x2_cl_casc__cc4_0.bias_c x2_cl_casc__cc4_0.bias_c VSS sky130_fd_pr__nfet_01v8 ad=0.406 pd=3.38 as=38.164 ps=317.72 w=1.4 l=0.6
X44 x1_single_m3__f1_0.x1_m2d x1_single_m3__f1_0.x1_m2d x2_cm_casc__cc3_0.bias_d VSS sky130_fd_pr__nfet_01v8 ad=0.406 pd=3.38 as=0.406 ps=3.38 w=1.4 l=0.6
X45 x2_cl_src__cc4_0.bias_b x2_cl_src__cc4_0.bias_b x2_cl_casc__cc4_0.bias_c VSS sky130_fd_pr__nfet_01v8_lvt ad=0.406 pd=3.38 as=0.406 ps=3.38 w=1.4 l=0.6
X46 cm cm x1_cc_cm__strings1_0.x1_net7 VSS sky130_fd_pr__nfet_01v8 ad=0.406 pd=3.38 as=0.406 ps=3.38 w=1.4 l=0.6
X47 x2_cm_casc__cc3_0.bias_d x1_single_m3__f1_0.x1_m2d x1_single_m3__f1_0.x1_m2d VSS sky130_fd_pr__nfet_01v8 ad=0.406 pd=3.38 as=0.406 ps=3.38 w=1.4 l=0.6
X48 x2_diff__cc3_0.x2_tail cmc VSS VSS sky130_fd_pr__nfet_01v8 ad=0.406 pd=3.38 as=0.406 ps=3.38 w=1.4 l=0.6
X49 x2_cm_tail__id6_0.x2_m4d x2_cm_casc__cc3_0.bias_d op VSS sky130_fd_pr__nfet_01v8 ad=0.406 pd=3.38 as=0.406 ps=3.38 w=1.4 l=0.6
X50 x2_cl_casc__cc4_0.bias_c x2_cl_src__cc4_0.bias_b x2_cl_src__cc4_0.bias_b VSS sky130_fd_pr__nfet_01v8_lvt ad=0.406 pd=3.38 as=0.406 ps=3.38 w=1.4 l=0.6
X51 x2_diff__cc3_0.x2_tail bias_a VSS VSS sky130_fd_pr__nfet_01v8 ad=0.406 pd=3.38 as=0.406 ps=3.38 w=1.4 l=0.6
X52 x2_cm_tail__id6_0.x2_m3d x2_cm_casc__cc3_0.bias_d on VSS sky130_fd_pr__nfet_01v8 ad=0.406 pd=3.38 as=0.406 ps=3.38 w=1.4 l=0.6
X53 x2_cm_tail__id6_0.x2_m3d x2_cm_casc__cc3_0.bias_d on VSS sky130_fd_pr__nfet_01v8 ad=0.406 pd=3.38 as=0.406 ps=3.38 w=1.4 l=0.6
X54 x2_cm_casc__cc3_0.bias_d x1_single_m3__f1_0.x1_m2d x1_single_m3__f1_0.x1_m2d VSS sky130_fd_pr__nfet_01v8 ad=0.406 pd=3.38 as=0.406 ps=3.38 w=1.4 l=0.6
X55 x2_diff__cc3_0.x2_tail in x2_diff__cc3_0.x2_foldn VSS sky130_fd_pr__nfet_01v8_lvt ad=0.348 pd=2.98 as=0.348 ps=2.98 w=1.2 l=0.2
X56 VDD VDD VDD VDD sky130_fd_pr__pfet_01v8 ad=0.406 pd=3.38 as=52.78 ps=439.39999 w=1.4 l=0.6
X57 x2_cm_casc__cc3_0.bias_d x1_single_m3__f1_0.x1_m2d x1_single_m3__f1_0.x1_m2d VSS sky130_fd_pr__nfet_01v8 ad=0.406 pd=3.38 as=0.406 ps=3.38 w=1.4 l=0.6
X58 x2_diff__cc3_0.x2_foldp x2_cl_src__cc4_0.bias_b VDD VDD sky130_fd_pr__pfet_01v8_lvt ad=0.406 pd=3.38 as=0.406 ps=3.38 w=1.4 l=0.6
X59 VSS IBIAS IBIAS VSS sky130_fd_pr__nfet_01v8 ad=0.406 pd=3.38 as=0.406 ps=3.38 w=1.4 l=0.6
X60 x2_diff__cc3_0.x2_foldp x2_cl_casc__cc4_0.bias_c on VDD sky130_fd_pr__pfet_01v8 ad=0.406 pd=3.38 as=0.406 ps=3.38 w=1.4 l=0.6
X61 x2_diff__cc3_0.x2_tail bias_a VSS VSS sky130_fd_pr__nfet_01v8 ad=0.406 pd=3.38 as=0.406 ps=3.38 w=1.4 l=0.6
X62 x1_cc_cm__strings1_0.x1_net3 cm x1_cc_cm__strings1_0.x1_net2 VSS sky130_fd_pr__nfet_01v8 ad=0.406 pd=3.38 as=0.406 ps=3.38 w=1.4 l=0.6
X63 VSS bias_a x2_diff__cc3_0.x2_tail VSS sky130_fd_pr__nfet_01v8 ad=0.406 pd=3.38 as=0.406 ps=3.38 w=1.4 l=0.6
X64 x2_cm_tail__id6_0.x2_m3d bias_a VSS VSS sky130_fd_pr__nfet_01v8 ad=0.406 pd=3.38 as=0.406 ps=3.38 w=1.4 l=0.6
X65 on x2_cm_casc__cc3_0.bias_d x2_cm_tail__id6_0.x2_m3d VSS sky130_fd_pr__nfet_01v8 ad=0.406 pd=3.38 as=0.406 ps=3.38 w=1.4 l=0.6
X66 x2_diff__cc3_0.x2_tail bias_a VSS VSS sky130_fd_pr__nfet_01v8 ad=0.406 pd=3.38 as=0.406 ps=3.38 w=1.4 l=0.6
X67 x2_diff__cc3_0.x2_tail cmc VSS VSS sky130_fd_pr__nfet_01v8 ad=0.406 pd=3.38 as=0.406 ps=3.38 w=1.4 l=0.6
X68 x2_diff__cc3_0.x2_tail cmc VSS VSS sky130_fd_pr__nfet_01v8 ad=0.406 pd=3.38 as=0.406 ps=3.38 w=1.4 l=0.6
X69 x2_diff__cc3_0.x2_tail cmc VSS VSS sky130_fd_pr__nfet_01v8 ad=0.406 pd=3.38 as=0.406 ps=3.38 w=1.4 l=0.6
X70 x2_cl_casc__cc4_0.bias_c x2_cl_casc__cc4_0.bias_c x2_cl_casc__cc4_0.bias_c VSS sky130_fd_pr__nfet_01v8_lvt ad=0.406 pd=3.38 as=0 ps=0 w=1.4 l=0.6
X71 VSS bias_a x2_diff__cc3_0.x2_tail VSS sky130_fd_pr__nfet_01v8 ad=0.406 pd=3.38 as=0.406 ps=3.38 w=1.4 l=0.6
X72 on x2_cl_casc__cc4_0.bias_c x2_diff__cc3_0.x2_foldp VDD sky130_fd_pr__pfet_01v8 ad=0.406 pd=3.38 as=0.406 ps=3.38 w=1.4 l=0.6
X73 VDD x2_cl_src__cc4_0.bias_b x1_cm_bias_c__cc1_0.x1_m21d VDD sky130_fd_pr__pfet_01v8_lvt ad=0.406 pd=3.38 as=0.406 ps=3.38 w=1.4 l=0.6
X74 x2_diff__cc3_0.x2_foldp ip x2_diff__cc3_0.x2_tail VSS sky130_fd_pr__nfet_01v8_lvt ad=0.348 pd=2.98 as=0.348 ps=2.98 w=1.2 l=0.2
X75 VSS VSS x1_single_m5__f3_0.x1_m5d VSS sky130_fd_pr__nfet_01v8 ad=0.406 pd=3.38 as=0.406 ps=3.38 w=1.4 l=0.6
X76 x2_diff__cc3_0.x2_tail cmc VSS VSS sky130_fd_pr__nfet_01v8 ad=0.406 pd=3.38 as=0.406 ps=3.38 w=1.4 l=0.6
X77 x2_cl_casc__cc4_0.bias_c IBIAS VSS VSS sky130_fd_pr__nfet_01v8 ad=0.406 pd=3.38 as=0.406 ps=3.38 w=1.4 l=0.6
X78 VSS VSS VSS VSS sky130_fd_pr__nfet_01v8 ad=0.406 pd=3.38 as=0 ps=0 w=1.4 l=0.6
X79 x2_cl_src__cc4_0.bias_b x2_cl_src__cc4_0.bias_b x2_cl_casc__cc4_0.bias_c VSS sky130_fd_pr__nfet_01v8_lvt ad=0.406 pd=3.38 as=0.406 ps=3.38 w=1.4 l=0.6
X80 x2_diff__cc3_0.x2_tail x2_diff__cc3_0.x2_tail x2_diff__cc3_0.x2_tail VSS sky130_fd_pr__nfet_01v8 ad=0.406 pd=3.38 as=87.812 ps=732.03998 w=1.4 l=0.6
X81 x2_cm_tail__id6_0.x2_m3d bias_a VSS VSS sky130_fd_pr__nfet_01v8 ad=0.406 pd=3.38 as=0.406 ps=3.38 w=1.4 l=0.6
X82 VSS bias_a x2_diff__cc3_0.x2_tail VSS sky130_fd_pr__nfet_01v8 ad=0.406 pd=3.38 as=0.406 ps=3.38 w=1.4 l=0.6
X83 x2_diff__cc3_0.x2_foldn x2_cl_casc__cc4_0.bias_c op VDD sky130_fd_pr__pfet_01v8 ad=0.406 pd=3.38 as=0.406 ps=3.38 w=1.4 l=0.6
X84 op x2_cm_casc__cc3_0.bias_d x2_cm_tail__id6_0.x2_m4d VSS sky130_fd_pr__nfet_01v8 ad=0.406 pd=3.38 as=0.406 ps=3.38 w=1.4 l=0.6
X85 VSS bias_a x2_cm_tail__id6_0.x2_m4d VSS sky130_fd_pr__nfet_01v8 ad=0.406 pd=3.38 as=0.406 ps=3.38 w=1.4 l=0.6
X86 x2_cm_tail__id6_0.x2_m3d bias_a VSS VSS sky130_fd_pr__nfet_01v8 ad=0.406 pd=3.38 as=0.406 ps=3.38 w=1.4 l=0.6
X87 VSS cmc x2_diff__cc3_0.x2_tail VSS sky130_fd_pr__nfet_01v8 ad=0.406 pd=3.38 as=0.406 ps=3.38 w=1.4 l=0.6
X88 x2_cl_src__cc4_0.bias_b x2_cl_src__cc4_0.bias_b x2_cl_src__cc4_0.bias_b VSS sky130_fd_pr__nfet_01v8_lvt ad=0.406 pd=3.38 as=29.232 ps=243.36 w=1.4 l=0.6
X89 VSS bias_a x1_single_m5__f3_0.x1_m5d VSS sky130_fd_pr__nfet_01v8 ad=0.406 pd=3.38 as=0.406 ps=3.38 w=1.4 l=0.6
X90 x2_diff__cc3_0.x2_tail cmc VSS VSS sky130_fd_pr__nfet_01v8 ad=0.406 pd=3.38 as=0.406 ps=3.38 w=1.4 l=0.6
X91 on x2_cm_casc__cc3_0.bias_d x2_cm_tail__id6_0.x2_m3d VSS sky130_fd_pr__nfet_01v8 ad=0.406 pd=3.38 as=0.406 ps=3.38 w=1.4 l=0.6
X92 x2_cm_tail__id6_0.x2_m4d x2_cm_casc__cc3_0.bias_d op VSS sky130_fd_pr__nfet_01v8 ad=0.406 pd=3.38 as=0.406 ps=3.38 w=1.4 l=0.6
X93 VSS bias_a x2_diff__cc3_0.x2_tail VSS sky130_fd_pr__nfet_01v8 ad=0.406 pd=3.38 as=0.406 ps=3.38 w=1.4 l=0.6
X94 VSS bias_a x2_cm_tail__id6_0.x2_m3d VSS sky130_fd_pr__nfet_01v8 ad=0.406 pd=3.38 as=0.406 ps=3.38 w=1.4 l=0.6
X95 VSS bias_a x2_cm_tail__id6_0.x2_m4d VSS sky130_fd_pr__nfet_01v8 ad=0.406 pd=3.38 as=0.406 ps=3.38 w=1.4 l=0.6
X96 x2_cm_tail__id6_0.x2_m4d bias_a VSS VSS sky130_fd_pr__nfet_01v8 ad=0.406 pd=3.38 as=0.406 ps=3.38 w=1.4 l=0.6
X97 x2_cl_src__cc4_0.bias_b x2_cl_src__cc4_0.bias_b x2_cl_src__cc4_0.bias_b VSS sky130_fd_pr__nfet_01v8_lvt ad=0.406 pd=3.38 as=0 ps=0 w=1.4 l=0.6
X98 VSS VSS VSS VSS sky130_fd_pr__nfet_01v8 ad=0.406 pd=3.38 as=0 ps=0 w=1.4 l=0.6
X99 x2_cm_tail__id6_0.x2_m4d bias_a VSS VSS sky130_fd_pr__nfet_01v8 ad=0.406 pd=3.38 as=0.406 ps=3.38 w=1.4 l=0.6
X100 VDD VDD VDD VDD sky130_fd_pr__pfet_01v8 ad=0.406 pd=3.38 as=0 ps=0 w=1.4 l=0.6
X101 VSS bias_a x1_single_m5__f3_0.x1_m5d VSS sky130_fd_pr__nfet_01v8 ad=0.406 pd=3.38 as=0.406 ps=3.38 w=1.4 l=0.6
X102 op x2_cm_casc__cc3_0.bias_d x2_cm_tail__id6_0.x2_m4d VSS sky130_fd_pr__nfet_01v8 ad=0.406 pd=3.38 as=0.406 ps=3.38 w=1.4 l=0.6
X103 VSS bias_a x2_diff__cc3_0.x2_tail VSS sky130_fd_pr__nfet_01v8 ad=0.406 pd=3.38 as=0.406 ps=3.38 w=1.4 l=0.6
X104 x1_single_m3__f1_0.x1_m2d x1_single_m3__f1_0.x1_m2d x2_cm_casc__cc3_0.bias_d VSS sky130_fd_pr__nfet_01v8 ad=0.406 pd=3.38 as=0.406 ps=3.38 w=1.4 l=0.6
X105 x1_cm_bias_c__cc1_0.x1_m25d x1_cm_bias_c__cc1_0.x1_m25d x1_cm_bias_c__cc1_0.x1_m25d VDD sky130_fd_pr__pfet_01v8 ad=0.406 pd=3.38 as=8.12 ps=67.6 w=1.4 l=0.6
X106 VDD x2_cl_src__cc4_0.bias_b x2_diff__cc3_0.x2_foldp VDD sky130_fd_pr__pfet_01v8_lvt ad=0.406 pd=3.38 as=0.406 ps=3.38 w=1.4 l=0.6
X107 x2_cl_casc__cc4_0.bias_c x2_cl_src__cc4_0.bias_b x2_cl_src__cc4_0.bias_b VSS sky130_fd_pr__nfet_01v8_lvt ad=0.406 pd=3.38 as=0.406 ps=3.38 w=1.4 l=0.6
X108 x2_cl_casc__cc4_0.bias_c IBIAS VSS VSS sky130_fd_pr__nfet_01v8 ad=0.406 pd=3.38 as=0.406 ps=3.38 w=1.4 l=0.6
X109 x1_single_m3__f1_0.x1_m2d x1_single_m3__f1_0.x1_m2d x1_single_m3__f1_0.x1_m2d VSS sky130_fd_pr__nfet_01v8 ad=0.406 pd=3.38 as=21.924 ps=182.52 w=1.4 l=0.6
X110 VSS bias_a x2_diff__cc3_0.x2_tail VSS sky130_fd_pr__nfet_01v8 ad=0.406 pd=3.38 as=0.406 ps=3.38 w=1.4 l=0.6
X111 x1_single_m3__f1_0.x1_m2d x1_single_m3__f1_0.x1_m2d x2_cm_casc__cc3_0.bias_d VSS sky130_fd_pr__nfet_01v8 ad=0.406 pd=3.38 as=0.406 ps=3.38 w=1.4 l=0.6
X112 VSS cmc x2_diff__cc3_0.x2_tail VSS sky130_fd_pr__nfet_01v8 ad=0.406 pd=3.38 as=0.406 ps=3.38 w=1.4 l=0.6
X113 VSS VSS VSS VSS sky130_fd_pr__nfet_01v8 ad=0.406 pd=3.38 as=0 ps=0 w=1.4 l=0.6
X114 x2_diff__cc3_0.x2_foldp x2_cl_src__cc4_0.bias_b VDD VDD sky130_fd_pr__pfet_01v8_lvt ad=0.406 pd=3.38 as=0.406 ps=3.38 w=1.4 l=0.6
X115 x2_cl_casc__cc4_0.bias_c x2_cl_src__cc4_0.bias_b x2_cl_src__cc4_0.bias_b VSS sky130_fd_pr__nfet_01v8_lvt ad=0.406 pd=3.38 as=0.406 ps=3.38 w=1.4 l=0.6
X116 x2_cl_src__cc4_0.bias_b x2_cl_src__cc4_0.bias_b x2_cl_casc__cc4_0.bias_c VSS sky130_fd_pr__nfet_01v8_lvt ad=0.406 pd=3.38 as=0.406 ps=3.38 w=1.4 l=0.6
X117 x2_diff__cc3_0.x2_tail bias_a VSS VSS sky130_fd_pr__nfet_01v8 ad=0.406 pd=3.38 as=0.406 ps=3.38 w=1.4 l=0.6
X118 VDD VDD VDD VDD sky130_fd_pr__pfet_01v8 ad=0.406 pd=3.38 as=0 ps=0 w=1.4 l=0.6
X119 x1_cc_cm__strings1_0.x1_net5 cm x1_cc_cm__strings1_0.x1_net6 VSS sky130_fd_pr__nfet_01v8 ad=0.406 pd=3.38 as=0.406 ps=3.38 w=1.4 l=0.6
X120 x2_diff__cc3_0.x2_tail cmc VSS VSS sky130_fd_pr__nfet_01v8 ad=0.406 pd=3.38 as=0.406 ps=3.38 w=1.4 l=0.6
X121 x2_cl_src__cc4_0.bias_b x2_cl_src__cc4_0.bias_b x2_cl_src__cc4_0.bias_b VSS sky130_fd_pr__nfet_01v8_lvt ad=0.406 pd=3.38 as=0 ps=0 w=1.4 l=0.6
X122 x2_cm_tail__id6_0.x2_m4d x2_cm_casc__cc3_0.bias_d op VSS sky130_fd_pr__nfet_01v8 ad=0.406 pd=3.38 as=0.406 ps=3.38 w=1.4 l=0.6
X123 x2_cm_casc__cc3_0.bias_d x1_single_m3__f1_0.x1_m2d x1_single_m3__f1_0.x1_m2d VSS sky130_fd_pr__nfet_01v8 ad=0.406 pd=3.38 as=0.406 ps=3.38 w=1.4 l=0.6
X124 x1_cm_bias_c__cc1_0.x1_m21d x2_cl_casc__cc4_0.bias_c x2_cl_src__cc4_0.bias_b VDD sky130_fd_pr__pfet_01v8 ad=0.406 pd=3.38 as=0.406 ps=3.38 w=1.4 l=0.6
X125 VSS VSS VSS VSS sky130_fd_pr__nfet_01v8 ad=0.406 pd=3.38 as=0 ps=0 w=1.4 l=0.6
X126 x2_diff__cc3_0.x2_foldn x2_cl_casc__cc4_0.bias_c op VDD sky130_fd_pr__pfet_01v8 ad=0.406 pd=3.38 as=0.406 ps=3.38 w=1.4 l=0.6
X127 x2_diff__cc3_0.x2_tail bias_a VSS VSS sky130_fd_pr__nfet_01v8 ad=0.406 pd=3.38 as=0.406 ps=3.38 w=1.4 l=0.6
X128 x2_cl_src__cc4_0.bias_b x2_cl_src__cc4_0.bias_b x2_cl_src__cc4_0.bias_b VSS sky130_fd_pr__nfet_01v8_lvt ad=0.406 pd=3.38 as=0 ps=0 w=1.4 l=0.6
X129 x2_diff__cc3_0.x2_tail bias_a VSS VSS sky130_fd_pr__nfet_01v8 ad=0.406 pd=3.38 as=0.406 ps=3.38 w=1.4 l=0.6
X130 on x2_cl_casc__cc4_0.bias_c x2_diff__cc3_0.x2_foldp VDD sky130_fd_pr__pfet_01v8 ad=0.406 pd=3.38 as=0.406 ps=3.38 w=1.4 l=0.6
X131 x2_cm_casc__cc3_0.bias_d x1_single_m3__f1_0.x1_m2d x1_single_m3__f1_0.x1_m2d VSS sky130_fd_pr__nfet_01v8 ad=0.406 pd=3.38 as=0.406 ps=3.38 w=1.4 l=0.6
X132 x1_cm_bias_c__cc1_0.x1_m21d x1_cm_bias_c__cc1_0.x1_m21d x1_cm_bias_c__cc1_0.x1_m21d VDD sky130_fd_pr__pfet_01v8 ad=0.406 pd=3.38 as=8.12 ps=67.6 w=1.4 l=0.6
X133 cm cm cm VSS sky130_fd_pr__nfet_01v8 ad=0.406 pd=3.38 as=8.526 ps=70.98 w=1.4 l=0.6
X134 VSS VSS x1_single_m5__f3_0.x1_m5d VSS sky130_fd_pr__nfet_01v8 ad=0.406 pd=3.38 as=0.406 ps=3.38 w=1.4 l=0.6
X135 x2_diff__cc3_0.x2_foldn x2_cl_src__cc4_0.bias_b VDD VDD sky130_fd_pr__pfet_01v8_lvt ad=0.406 pd=3.38 as=0.406 ps=3.38 w=1.4 l=0.6
X136 x2_diff__cc3_0.x2_tail ip x2_diff__cc3_0.x2_foldp VSS sky130_fd_pr__nfet_01v8_lvt ad=0.348 pd=2.98 as=0.348 ps=2.98 w=1.2 l=0.2
X137 cm x2_cl_casc__cc4_0.bias_c x1_cm_bias_c__cc1_0.x1_m31d VDD sky130_fd_pr__pfet_01v8 ad=0.406 pd=3.38 as=0.406 ps=3.38 w=1.4 l=0.6
X138 op x2_cl_casc__cc4_0.bias_c x2_diff__cc3_0.x2_foldn VDD sky130_fd_pr__pfet_01v8 ad=0.406 pd=3.38 as=0.406 ps=3.38 w=1.4 l=0.6
X139 x1_cm_bias_c__cc1_0.x1_m31d x2_cl_src__cc4_0.bias_b VDD VDD sky130_fd_pr__pfet_01v8_lvt ad=0.406 pd=3.38 as=0.406 ps=3.38 w=1.4 l=0.6
X140 x2_diff__cc3_0.x2_tail bias_a VSS VSS sky130_fd_pr__nfet_01v8 ad=0.406 pd=3.38 as=0.406 ps=3.38 w=1.4 l=0.6
X141 VDD x2_cl_src__cc4_0.bias_b x2_diff__cc3_0.x2_foldp VDD sky130_fd_pr__pfet_01v8_lvt ad=0.406 pd=3.38 as=0.406 ps=3.38 w=1.4 l=0.6
X142 x2_cm_tail__id6_0.x2_m4d x2_cm_casc__cc3_0.bias_d op VSS sky130_fd_pr__nfet_01v8 ad=0.406 pd=3.38 as=0.406 ps=3.38 w=1.4 l=0.6
X143 on cmc sky130_fd_pr__cap_mim_m3_1 l=4.8 w=4.8
X144 VSS bias_a x2_cm_tail__id6_0.x2_m4d VSS sky130_fd_pr__nfet_01v8 ad=0.406 pd=3.38 as=0.406 ps=3.38 w=1.4 l=0.6
X145 VSS bias_a x2_diff__cc3_0.x2_tail VSS sky130_fd_pr__nfet_01v8 ad=0.406 pd=3.38 as=0.406 ps=3.38 w=1.4 l=0.6
X146 x2_cl_casc__cc4_0.bias_c x2_cl_casc__cc4_0.bias_c x2_cl_casc__cc4_0.bias_c VSS sky130_fd_pr__nfet_01v8_lvt ad=0.406 pd=3.38 as=0 ps=0 w=1.4 l=0.6
X147 x2_diff__cc3_0.x2_foldn x2_diff__cc3_0.x2_foldn x2_diff__cc3_0.x2_foldn VDD sky130_fd_pr__pfet_01v8 ad=0.406 pd=3.38 as=20.3 ps=169 w=1.4 l=0.6
X148 VSS cmc x2_diff__cc3_0.x2_tail VSS sky130_fd_pr__nfet_01v8 ad=0.406 pd=3.38 as=0.406 ps=3.38 w=1.4 l=0.6
X149 VDD x2_cl_src__cc4_0.bias_b x2_diff__cc3_0.x2_foldn VDD sky130_fd_pr__pfet_01v8_lvt ad=0.406 pd=3.38 as=0.406 ps=3.38 w=1.4 l=0.6
X150 VSS bias_a x2_cm_tail__id6_0.x2_m3d VSS sky130_fd_pr__nfet_01v8 ad=0.406 pd=3.38 as=0.406 ps=3.38 w=1.4 l=0.6
X151 x1_single_m3__f1_0.x1_m2d x2_cl_casc__cc4_0.bias_c x1_cm_bias_c__cc1_0.x1_m25d VDD sky130_fd_pr__pfet_01v8 ad=0.406 pd=3.38 as=0.406 ps=3.38 w=1.4 l=0.6
X152 x2_diff__cc3_0.x2_tail bias_a VSS VSS sky130_fd_pr__nfet_01v8 ad=0.406 pd=3.38 as=0.406 ps=3.38 w=1.4 l=0.6
X153 IBIAS IBIAS VSS VSS sky130_fd_pr__nfet_01v8 ad=0.406 pd=3.38 as=0.406 ps=3.38 w=1.4 l=0.6
X154 VDD VDD on VDD sky130_fd_pr__pfet_01v8 ad=0.406 pd=3.38 as=0.406 ps=3.38 w=1.4 l=0.6
X155 x2_cl_casc__cc4_0.bias_c x2_cl_src__cc4_0.bias_b x2_cl_src__cc4_0.bias_b VSS sky130_fd_pr__nfet_01v8_lvt ad=0.406 pd=3.38 as=0.406 ps=3.38 w=1.4 l=0.6
X156 x1_single_m5__f3_0.x1_m5d x2_cm_casc__cc3_0.bias_d bias_a VSS sky130_fd_pr__nfet_01v8 ad=0.406 pd=3.38 as=0.406 ps=3.38 w=1.4 l=0.6
X157 x2_diff__cc3_0.x2_tail bias_a VSS VSS sky130_fd_pr__nfet_01v8 ad=0.406 pd=3.38 as=0.406 ps=3.38 w=1.4 l=0.6
X158 VSS bias_a x2_diff__cc3_0.x2_tail VSS sky130_fd_pr__nfet_01v8 ad=0.406 pd=3.38 as=0.406 ps=3.38 w=1.4 l=0.6
X159 x2_diff__cc3_0.x2_tail bias_a VSS VSS sky130_fd_pr__nfet_01v8 ad=0.406 pd=3.38 as=0.406 ps=3.38 w=1.4 l=0.6
X160 VSS VSS x2_cm_tail__id6_0.x2_m3d VSS sky130_fd_pr__nfet_01v8 ad=0.406 pd=3.38 as=0.406 ps=3.38 w=1.4 l=0.6
X161 x2_cl_casc__cc4_0.bias_c x2_cl_src__cc4_0.bias_b x2_cl_src__cc4_0.bias_b VSS sky130_fd_pr__nfet_01v8_lvt ad=0.406 pd=3.38 as=0.406 ps=3.38 w=1.4 l=0.6
X162 bias_a x2_cm_casc__cc3_0.bias_d x1_single_m5__f3_0.x1_m5d VSS sky130_fd_pr__nfet_01v8 ad=0.406 pd=3.38 as=0.406 ps=3.38 w=1.4 l=0.6
X163 VDD VDD VDD VDD sky130_fd_pr__pfet_01v8_lvt ad=0.406 pd=3.38 as=0 ps=0 w=1.4 l=0.6
X164 x2_cm_casc__cc3_0.bias_d x2_cm_casc__cc3_0.bias_d x2_cm_casc__cc3_0.bias_d VSS sky130_fd_pr__nfet_01v8 ad=0.406 pd=3.38 as=0 ps=0 w=1.4 l=0.6
X165 VSS VSS op VSS sky130_fd_pr__nfet_01v8 ad=0.406 pd=3.38 as=0.406 ps=3.38 w=1.4 l=0.6
X166 x2_cl_casc__cc4_0.bias_c IBIAS VSS VSS sky130_fd_pr__nfet_01v8 ad=0.406 pd=3.38 as=0.406 ps=3.38 w=1.4 l=0.6
X167 VSS bias_a x2_diff__cc3_0.x2_tail VSS sky130_fd_pr__nfet_01v8 ad=0.406 pd=3.38 as=0.406 ps=3.38 w=1.4 l=0.6
X168 VDD VDD VDD VDD sky130_fd_pr__pfet_01v8 ad=0.406 pd=3.38 as=0 ps=0 w=1.4 l=0.6
X169 cm cm cm VSS sky130_fd_pr__nfet_01v8 ad=0.406 pd=3.38 as=0 ps=0 w=1.4 l=0.6
X170 VSS VSS VSS VSS sky130_fd_pr__nfet_01v8 ad=0.406 pd=3.38 as=0 ps=0 w=1.4 l=0.6
X171 VDD x2_cl_src__cc4_0.bias_b x2_diff__cc3_0.x2_foldn VDD sky130_fd_pr__pfet_01v8_lvt ad=0.406 pd=3.38 as=0.406 ps=3.38 w=1.4 l=0.6
X172 op x2_cm_casc__cc3_0.bias_d x2_cm_tail__id6_0.x2_m4d VSS sky130_fd_pr__nfet_01v8 ad=0.406 pd=3.38 as=0.406 ps=3.38 w=1.4 l=0.6
X173 op x2_cm_casc__cc3_0.bias_d x2_cm_tail__id6_0.x2_m4d VSS sky130_fd_pr__nfet_01v8 ad=0.406 pd=3.38 as=0.406 ps=3.38 w=1.4 l=0.6
X174 VSS bias_a x2_diff__cc3_0.x2_tail VSS sky130_fd_pr__nfet_01v8 ad=0.406 pd=3.38 as=0.406 ps=3.38 w=1.4 l=0.6
X175 VSS cmc x2_diff__cc3_0.x2_tail VSS sky130_fd_pr__nfet_01v8 ad=0.406 pd=3.38 as=0.406 ps=3.38 w=1.4 l=0.6
X176 x2_diff__cc3_0.x2_tail cmc VSS VSS sky130_fd_pr__nfet_01v8 ad=0.406 pd=3.38 as=0.406 ps=3.38 w=1.4 l=0.6
X177 VSS cmc x2_diff__cc3_0.x2_tail VSS sky130_fd_pr__nfet_01v8 ad=0.406 pd=3.38 as=0.406 ps=3.38 w=1.4 l=0.6
X178 VSS bias_a x2_cm_tail__id6_0.x2_m4d VSS sky130_fd_pr__nfet_01v8 ad=0.406 pd=3.38 as=0.406 ps=3.38 w=1.4 l=0.6
X179 VSS IBIAS IBIAS VSS sky130_fd_pr__nfet_01v8 ad=0.406 pd=3.38 as=0.406 ps=3.38 w=1.4 l=0.6
X180 x1_single_m5__f3_0.x1_m5d bias_a VSS VSS sky130_fd_pr__nfet_01v8 ad=0.406 pd=3.38 as=0.406 ps=3.38 w=1.4 l=0.6
X181 x2_diff__cc3_0.x2_tail cmc VSS VSS sky130_fd_pr__nfet_01v8 ad=0.406 pd=3.38 as=0.406 ps=3.38 w=1.4 l=0.6
X182 on x2_cl_casc__cc4_0.bias_c x2_diff__cc3_0.x2_foldp VDD sky130_fd_pr__pfet_01v8 ad=0.406 pd=3.38 as=0.406 ps=3.38 w=1.4 l=0.6
X183 VDD x2_cl_src__cc4_0.bias_b x2_diff__cc3_0.x2_foldp VDD sky130_fd_pr__pfet_01v8_lvt ad=0.406 pd=3.38 as=0.406 ps=3.38 w=1.4 l=0.6
X184 on x2_cm_casc__cc3_0.bias_d x2_cm_tail__id6_0.x2_m3d VSS sky130_fd_pr__nfet_01v8 ad=0.406 pd=3.38 as=0.406 ps=3.38 w=1.4 l=0.6
X185 VSS bias_a x2_diff__cc3_0.x2_tail VSS sky130_fd_pr__nfet_01v8 ad=0.406 pd=3.38 as=0.406 ps=3.38 w=1.4 l=0.6
X186 x1_single_m3__f1_0.x1_m2d x1_single_m3__f1_0.x1_m2d x2_cm_casc__cc3_0.bias_d VSS sky130_fd_pr__nfet_01v8 ad=0.406 pd=3.38 as=0.406 ps=3.38 w=1.4 l=0.6
X187 VDD VDD VDD VDD sky130_fd_pr__pfet_01v8 ad=0.406 pd=3.38 as=0 ps=0 w=1.4 l=0.6
X188 x2_cm_tail__id6_0.x2_m3d bias_a VSS VSS sky130_fd_pr__nfet_01v8 ad=0.406 pd=3.38 as=0.406 ps=3.38 w=1.4 l=0.6
X189 x2_diff__cc3_0.x2_foldn x2_cl_src__cc4_0.bias_b VDD VDD sky130_fd_pr__pfet_01v8_lvt ad=0.406 pd=3.38 as=0.406 ps=3.38 w=1.4 l=0.6
X190 x2_cl_casc__cc4_0.bias_c x2_cl_src__cc4_0.bias_b x2_cl_src__cc4_0.bias_b VSS sky130_fd_pr__nfet_01v8_lvt ad=0.406 pd=3.38 as=0.406 ps=3.38 w=1.4 l=0.6
X191 x1_single_m5__f3_0.x1_m5d bias_a VSS VSS sky130_fd_pr__nfet_01v8 ad=0.406 pd=3.38 as=0.406 ps=3.38 w=1.4 l=0.6
X192 op x2_cm_casc__cc3_0.bias_d x2_cm_tail__id6_0.x2_m4d VSS sky130_fd_pr__nfet_01v8 ad=0.406 pd=3.38 as=0.406 ps=3.38 w=1.4 l=0.6
X193 x1_cc_cm__strings1_0.x1_net12 cm VSS VSS sky130_fd_pr__nfet_01v8 ad=0.406 pd=3.38 as=0.406 ps=3.38 w=1.4 l=0.6
X194 x2_cm_casc__cc3_0.bias_d x1_single_m3__f1_0.x1_m2d x1_single_m3__f1_0.x1_m2d VSS sky130_fd_pr__nfet_01v8 ad=0.406 pd=3.38 as=0.406 ps=3.38 w=1.4 l=0.6
X195 x2_cl_casc__cc4_0.bias_c x2_cl_src__cc4_0.bias_b x2_cl_src__cc4_0.bias_b VSS sky130_fd_pr__nfet_01v8_lvt ad=0.406 pd=3.38 as=0.406 ps=3.38 w=1.4 l=0.6
X196 x1_single_m3__f1_0.x1_m2d x1_single_m3__f1_0.x1_m2d x2_cm_casc__cc3_0.bias_d VSS sky130_fd_pr__nfet_01v8 ad=0.406 pd=3.38 as=0.406 ps=3.38 w=1.4 l=0.6
X197 x2_cl_casc__cc4_0.bias_c IBIAS VSS VSS sky130_fd_pr__nfet_01v8 ad=0.406 pd=3.38 as=0.406 ps=3.38 w=1.4 l=0.6
X198 x2_diff__cc3_0.x2_foldn in x2_diff__cc3_0.x2_tail VSS sky130_fd_pr__nfet_01v8_lvt ad=0.348 pd=2.98 as=0.348 ps=2.98 w=1.2 l=0.2
X199 x1_cc_cm__strings1_0.x1_net11 cm x1_cc_cm__strings1_0.x1_net12 VSS sky130_fd_pr__nfet_01v8 ad=0.406 pd=3.38 as=0.406 ps=3.38 w=1.4 l=0.6
X200 VSS bias_a x2_diff__cc3_0.x2_tail VSS sky130_fd_pr__nfet_01v8 ad=0.406 pd=3.38 as=0.406 ps=3.38 w=1.4 l=0.6
X201 x1_single_m3__f1_0.x1_m2d x2_cl_casc__cc4_0.bias_c x1_cm_bias_c__cc1_0.x1_m25d VDD sky130_fd_pr__pfet_01v8 ad=0.406 pd=3.38 as=0.406 ps=3.38 w=1.4 l=0.6
X202 x2_diff__cc3_0.x2_foldn x2_cl_casc__cc4_0.bias_c op VDD sky130_fd_pr__pfet_01v8 ad=0.406 pd=3.38 as=0.406 ps=3.38 w=1.4 l=0.6
X203 VDD VDD x2_diff__cc3_0.x2_foldn VDD sky130_fd_pr__pfet_01v8 ad=0.406 pd=3.38 as=0.406 ps=3.38 w=1.4 l=0.6
X204 x1_single_m3__f1_0.x1_m2d x1_single_m3__f1_0.x1_m2d x2_cm_casc__cc3_0.bias_d VSS sky130_fd_pr__nfet_01v8 ad=0.406 pd=3.38 as=0.406 ps=3.38 w=1.4 l=0.6
X205 VSS bias_a x2_cm_tail__id6_0.x2_m4d VSS sky130_fd_pr__nfet_01v8 ad=0.406 pd=3.38 as=0.406 ps=3.38 w=1.4 l=0.6
X206 x2_diff__cc3_0.x2_foldn x2_cl_casc__cc4_0.bias_c op VDD sky130_fd_pr__pfet_01v8 ad=0.406 pd=3.38 as=0.406 ps=3.38 w=1.4 l=0.6
X207 VSS cmc x2_diff__cc3_0.x2_tail VSS sky130_fd_pr__nfet_01v8 ad=0.406 pd=3.38 as=0.406 ps=3.38 w=1.4 l=0.6
X208 VSS IBIAS IBIAS VSS sky130_fd_pr__nfet_01v8 ad=0.406 pd=3.38 as=0.406 ps=3.38 w=1.4 l=0.6
X209 x2_cm_tail__id6_0.x2_m3d x2_cm_casc__cc3_0.bias_d on VSS sky130_fd_pr__nfet_01v8 ad=0.406 pd=3.38 as=0.406 ps=3.38 w=1.4 l=0.6
X210 x2_diff__cc3_0.x2_foldn x2_diff__cc3_0.x2_foldn x2_diff__cc3_0.x2_foldn VSS sky130_fd_pr__nfet_01v8_lvt ad=0.348 pd=2.98 as=3.48 ps=29.8 w=1.2 l=0.2
X211 VSS IBIAS IBIAS VSS sky130_fd_pr__nfet_01v8 ad=0.406 pd=3.38 as=0.406 ps=3.38 w=1.4 l=0.6
X212 x2_cl_casc__cc4_0.bias_c x2_cl_src__cc4_0.bias_b x2_cl_src__cc4_0.bias_b VSS sky130_fd_pr__nfet_01v8_lvt ad=0.406 pd=3.38 as=0.406 ps=3.38 w=1.4 l=0.6
X213 op x2_cm_casc__cc3_0.bias_d x2_cm_tail__id6_0.x2_m4d VSS sky130_fd_pr__nfet_01v8 ad=0.406 pd=3.38 as=0.406 ps=3.38 w=1.4 l=0.6
X214 op x2_cl_casc__cc4_0.bias_c x2_diff__cc3_0.x2_foldn VDD sky130_fd_pr__pfet_01v8 ad=0.406 pd=3.38 as=0.406 ps=3.38 w=1.4 l=0.6
X215 x1_cm_bias_c__cc1_0.x1_m21d x1_cm_bias_c__cc1_0.x1_m21d x1_cm_bias_c__cc1_0.x1_m21d VDD sky130_fd_pr__pfet_01v8_lvt ad=0.406 pd=3.38 as=0 ps=0 w=1.4 l=0.6
X216 x2_cl_src__cc4_0.bias_b x2_cl_src__cc4_0.bias_b x2_cl_casc__cc4_0.bias_c VSS sky130_fd_pr__nfet_01v8_lvt ad=0.406 pd=3.38 as=0.406 ps=3.38 w=1.4 l=0.6
X217 x1_single_m5__f3_0.x1_m5d x1_single_m5__f3_0.x1_m5d x1_single_m5__f3_0.x1_m5d VSS sky130_fd_pr__nfet_01v8 ad=0.406 pd=3.38 as=0 ps=0 w=1.4 l=0.6
X218 x1_cc_cm__strings1_0.x1_net5 cm x1_cc_cm__strings1_0.x1_net4 VSS sky130_fd_pr__nfet_01v8 ad=0.406 pd=3.38 as=0.406 ps=3.38 w=1.4 l=0.6
X219 x2_cm_casc__cc3_0.bias_d x1_single_m3__f1_0.x1_m2d x1_single_m3__f1_0.x1_m2d VSS sky130_fd_pr__nfet_01v8 ad=0.406 pd=3.38 as=0.406 ps=3.38 w=1.4 l=0.6
X220 VSS cmc x2_diff__cc3_0.x2_tail VSS sky130_fd_pr__nfet_01v8 ad=0.406 pd=3.38 as=0.406 ps=3.38 w=1.4 l=0.6
X221 VDD VDD x1_cm_bias_c__cc1_0.x1_m31d VDD sky130_fd_pr__pfet_01v8 ad=0.406 pd=3.38 as=0.406 ps=3.38 w=1.4 l=0.6
X222 x2_cm_tail__id6_0.x2_m3d x2_cm_casc__cc3_0.bias_d on VSS sky130_fd_pr__nfet_01v8 ad=0.406 pd=3.38 as=0.406 ps=3.38 w=1.4 l=0.6
X223 VSS VSS op VSS sky130_fd_pr__nfet_01v8 ad=0.406 pd=3.38 as=0.406 ps=3.38 w=1.4 l=0.6
X224 VDD VDD VDD VDD sky130_fd_pr__pfet_01v8_lvt ad=0.406 pd=3.38 as=0 ps=0 w=1.4 l=0.6
X225 x2_diff__cc3_0.x2_tail cmc VSS VSS sky130_fd_pr__nfet_01v8 ad=0.406 pd=3.38 as=0.406 ps=3.38 w=1.4 l=0.6
X226 VSS bias_a x2_diff__cc3_0.x2_tail VSS sky130_fd_pr__nfet_01v8 ad=0.406 pd=3.38 as=0.406 ps=3.38 w=1.4 l=0.6
X227 VDD x2_cl_src__cc4_0.bias_b x1_cm_bias_c__cc1_0.x1_m31d VDD sky130_fd_pr__pfet_01v8_lvt ad=0.406 pd=3.38 as=0.406 ps=3.38 w=1.4 l=0.6
X228 x1_single_m5__f3_0.x1_m5d x1_single_m5__f3_0.x1_m5d x1_single_m5__f3_0.x1_m5d VSS sky130_fd_pr__nfet_01v8 ad=0.406 pd=3.38 as=0 ps=0 w=1.4 l=0.6
X229 x1_cc_cm__strings1_0.x1_net4 cm cm VSS sky130_fd_pr__nfet_01v8 ad=0.406 pd=3.38 as=0.406 ps=3.38 w=1.4 l=0.6
X230 x2_diff__cc3_0.x2_tail bias_a VSS VSS sky130_fd_pr__nfet_01v8 ad=0.406 pd=3.38 as=0.406 ps=3.38 w=1.4 l=0.6
X231 cm cm cm VSS sky130_fd_pr__nfet_01v8 ad=0.406 pd=3.38 as=0 ps=0 w=1.4 l=0.6
X232 bias_a x1_single_m3__f1_0.x1_m2d x2_cm_casc__cc3_0.bias_d VSS sky130_fd_pr__nfet_01v8 ad=0.406 pd=3.38 as=0.406 ps=3.38 w=1.4 l=0.6
X233 x2_cl_casc__cc4_0.bias_c x2_cl_casc__cc4_0.bias_c x2_cl_casc__cc4_0.bias_c VSS sky130_fd_pr__nfet_01v8_lvt ad=0.406 pd=3.38 as=0 ps=0 w=1.4 l=0.6
X234 x2_diff__cc3_0.x2_foldp x2_cl_casc__cc4_0.bias_c on VDD sky130_fd_pr__pfet_01v8 ad=0.406 pd=3.38 as=0.406 ps=3.38 w=1.4 l=0.6
X235 VSS VSS x2_cm_tail__id6_0.x2_m3d VSS sky130_fd_pr__nfet_01v8 ad=0.406 pd=3.38 as=0.406 ps=3.38 w=1.4 l=0.6
X236 VDD VDD VDD VDD sky130_fd_pr__pfet_01v8_lvt ad=0.406 pd=3.38 as=0 ps=0 w=1.4 l=0.6
X237 x2_diff__cc3_0.x2_foldn x2_cl_src__cc4_0.bias_b VDD VDD sky130_fd_pr__pfet_01v8_lvt ad=0.406 pd=3.38 as=0.406 ps=3.38 w=1.4 l=0.6
X238 x2_cm_casc__cc3_0.bias_d x1_single_m3__f1_0.x1_m2d bias_a VSS sky130_fd_pr__nfet_01v8 ad=0.406 pd=3.38 as=0.406 ps=3.38 w=1.4 l=0.6
X239 x2_cm_tail__id6_0.x2_m4d bias_a VSS VSS sky130_fd_pr__nfet_01v8 ad=0.406 pd=3.38 as=0.406 ps=3.38 w=1.4 l=0.6
X240 VDD VDD x1_single_m3__f1_0.x1_m2d VDD sky130_fd_pr__pfet_01v8 ad=0.406 pd=3.38 as=0.406 ps=3.38 w=1.4 l=0.6
X241 x2_diff__cc3_0.x2_tail cmc VSS VSS sky130_fd_pr__nfet_01v8 ad=0.406 pd=3.38 as=0.406 ps=3.38 w=1.4 l=0.6
X242 x2_cm_tail__id6_0.x2_m3d x2_cm_casc__cc3_0.bias_d on VSS sky130_fd_pr__nfet_01v8 ad=0.406 pd=3.38 as=0.406 ps=3.38 w=1.4 l=0.6
X243 VSS cmc x2_diff__cc3_0.x2_tail VSS sky130_fd_pr__nfet_01v8 ad=0.406 pd=3.38 as=0.406 ps=3.38 w=1.4 l=0.6
X244 x2_diff__cc3_0.x2_tail x2_diff__cc3_0.x2_tail x2_diff__cc3_0.x2_tail VSS sky130_fd_pr__nfet_01v8 ad=0.406 pd=3.38 as=0 ps=0 w=1.4 l=0.6
X245 x2_diff__cc3_0.x2_tail bias_a VSS VSS sky130_fd_pr__nfet_01v8 ad=0.406 pd=3.38 as=0.406 ps=3.38 w=1.4 l=0.6
X246 VDD x2_cl_src__cc4_0.bias_b x2_diff__cc3_0.x2_foldn VDD sky130_fd_pr__pfet_01v8_lvt ad=0.406 pd=3.38 as=0.406 ps=3.38 w=1.4 l=0.6
X247 x2_diff__cc3_0.x2_tail bias_a VSS VSS sky130_fd_pr__nfet_01v8 ad=0.406 pd=3.38 as=0.406 ps=3.38 w=1.4 l=0.6
X248 x2_cm_casc__cc3_0.bias_d x1_single_m3__f1_0.x1_m2d x1_single_m3__f1_0.x1_m2d VSS sky130_fd_pr__nfet_01v8 ad=0.406 pd=3.38 as=0.406 ps=3.38 w=1.4 l=0.6
X249 VSS bias_a x2_diff__cc3_0.x2_tail VSS sky130_fd_pr__nfet_01v8 ad=0.406 pd=3.38 as=0.406 ps=3.38 w=1.4 l=0.6
X250 VDD VDD VDD VDD sky130_fd_pr__pfet_01v8_lvt ad=0.406 pd=3.38 as=0 ps=0 w=1.4 l=0.6
X251 x2_cl_src__cc4_0.bias_b x2_cl_src__cc4_0.bias_b x2_cl_casc__cc4_0.bias_c VSS sky130_fd_pr__nfet_01v8_lvt ad=0.406 pd=3.38 as=0.406 ps=3.38 w=1.4 l=0.6
X252 x2_diff__cc3_0.x2_tail x2_diff__cc3_0.x2_tail x2_diff__cc3_0.x2_tail VSS sky130_fd_pr__nfet_01v8 ad=0.406 pd=3.38 as=0 ps=0 w=1.4 l=0.6
X253 VSS cmc x2_diff__cc3_0.x2_tail VSS sky130_fd_pr__nfet_01v8 ad=0.406 pd=3.38 as=0.406 ps=3.38 w=1.4 l=0.6
X254 x1_single_m5__f3_0.x1_m5d x2_cm_casc__cc3_0.bias_d bias_a VSS sky130_fd_pr__nfet_01v8 ad=0.406 pd=3.38 as=0.406 ps=3.38 w=1.4 l=0.6
X255 x2_cm_tail__id6_0.x2_m3d bias_a VSS VSS sky130_fd_pr__nfet_01v8 ad=0.406 pd=3.38 as=0.406 ps=3.38 w=1.4 l=0.6
X256 VSS cmc x2_diff__cc3_0.x2_tail VSS sky130_fd_pr__nfet_01v8 ad=0.406 pd=3.38 as=0.406 ps=3.38 w=1.4 l=0.6
X257 x2_diff__cc3_0.x2_tail cmc VSS VSS sky130_fd_pr__nfet_01v8 ad=0.406 pd=3.38 as=0.406 ps=3.38 w=1.4 l=0.6
X258 cm cm cm VSS sky130_fd_pr__nfet_01v8 ad=0.406 pd=3.38 as=0 ps=0 w=1.4 l=0.6
X259 on cmc sky130_fd_pr__cap_mim_m3_1 l=4.8 w=4.8
X260 VSS VSS VSS VSS sky130_fd_pr__nfet_01v8 ad=0.406 pd=3.38 as=0 ps=0 w=1.4 l=0.6
X261 x2_cl_casc__cc4_0.bias_c x2_cl_src__cc4_0.bias_b x2_cl_src__cc4_0.bias_b VSS sky130_fd_pr__nfet_01v8_lvt ad=0.406 pd=3.38 as=0.406 ps=3.38 w=1.4 l=0.6
X262 x2_cm_tail__id6_0.x2_m4d x2_cm_casc__cc3_0.bias_d op VSS sky130_fd_pr__nfet_01v8 ad=0.406 pd=3.38 as=0.406 ps=3.38 w=1.4 l=0.6
X263 x2_cm_tail__id6_0.x2_m4d bias_a VSS VSS sky130_fd_pr__nfet_01v8 ad=0.406 pd=3.38 as=0.406 ps=3.38 w=1.4 l=0.6
X264 x1_single_m3__f1_0.x1_m2d x1_single_m3__f1_0.x1_m2d x2_cm_casc__cc3_0.bias_d VSS sky130_fd_pr__nfet_01v8 ad=0.406 pd=3.38 as=0.406 ps=3.38 w=1.4 l=0.6
X265 op x2_cl_casc__cc4_0.bias_c x2_diff__cc3_0.x2_foldn VDD sky130_fd_pr__pfet_01v8 ad=0.406 pd=3.38 as=0.406 ps=3.38 w=1.4 l=0.6
X266 VDD VDD VDD VDD sky130_fd_pr__pfet_01v8_lvt ad=0.406 pd=3.38 as=0 ps=0 w=1.4 l=0.6
X267 x1_cm_bias_c__cc1_0.x1_m21d x2_cl_src__cc4_0.bias_b VDD VDD sky130_fd_pr__pfet_01v8_lvt ad=0.406 pd=3.38 as=0.406 ps=3.38 w=1.4 l=0.6
X268 on x2_cm_casc__cc3_0.bias_d x2_cm_tail__id6_0.x2_m3d VSS sky130_fd_pr__nfet_01v8 ad=0.406 pd=3.38 as=0.406 ps=3.38 w=1.4 l=0.6
X269 cm cm cm VSS sky130_fd_pr__nfet_01v8 ad=0.406 pd=3.38 as=0 ps=0 w=1.4 l=0.6
X270 x2_diff__cc3_0.x2_foldp x2_cl_src__cc4_0.bias_b VDD VDD sky130_fd_pr__pfet_01v8_lvt ad=0.406 pd=3.38 as=0.406 ps=3.38 w=1.4 l=0.6
X271 VSS bias_a x2_cm_tail__id6_0.x2_m3d VSS sky130_fd_pr__nfet_01v8 ad=0.406 pd=3.38 as=0.406 ps=3.38 w=1.4 l=0.6
X272 x2_diff__cc3_0.x2_tail bias_a VSS VSS sky130_fd_pr__nfet_01v8 ad=0.406 pd=3.38 as=0.406 ps=3.38 w=1.4 l=0.6
X273 x2_diff__cc3_0.x2_tail bias_a VSS VSS sky130_fd_pr__nfet_01v8 ad=0.406 pd=3.38 as=0.406 ps=3.38 w=1.4 l=0.6
X274 VSS bias_a x2_diff__cc3_0.x2_tail VSS sky130_fd_pr__nfet_01v8 ad=0.406 pd=3.38 as=0.406 ps=3.38 w=1.4 l=0.6
X275 x1_single_m5__f3_0.x1_m5d bias_a VSS VSS sky130_fd_pr__nfet_01v8 ad=0.406 pd=3.38 as=0.406 ps=3.38 w=1.4 l=0.6
X276 VSS cmc x2_diff__cc3_0.x2_tail VSS sky130_fd_pr__nfet_01v8 ad=0.406 pd=3.38 as=0.406 ps=3.38 w=1.4 l=0.6
X277 x2_diff__cc3_0.x2_tail bias_a VSS VSS sky130_fd_pr__nfet_01v8 ad=0.406 pd=3.38 as=0.406 ps=3.38 w=1.4 l=0.6
X278 VSS IBIAS IBIAS VSS sky130_fd_pr__nfet_01v8 ad=0.406 pd=3.38 as=0.406 ps=3.38 w=1.4 l=0.6
X279 x2_cm_tail__id6_0.x2_m3d bias_a VSS VSS sky130_fd_pr__nfet_01v8 ad=0.406 pd=3.38 as=0.406 ps=3.38 w=1.4 l=0.6
X280 VSS bias_a x2_cm_tail__id6_0.x2_m4d VSS sky130_fd_pr__nfet_01v8 ad=0.406 pd=3.38 as=0.406 ps=3.38 w=1.4 l=0.6
X281 x2_diff__cc3_0.x2_foldp x2_cl_casc__cc4_0.bias_c on VDD sky130_fd_pr__pfet_01v8 ad=0.406 pd=3.38 as=0.406 ps=3.38 w=1.4 l=0.6
X282 VSS bias_a x1_single_m5__f3_0.x1_m5d VSS sky130_fd_pr__nfet_01v8 ad=0.406 pd=3.38 as=0.406 ps=3.38 w=1.4 l=0.6
X283 x1_single_m5__f3_0.x1_m5d bias_a VSS VSS sky130_fd_pr__nfet_01v8 ad=0.406 pd=3.38 as=0.406 ps=3.38 w=1.4 l=0.6
X284 x2_diff__cc3_0.x2_foldp x2_cl_casc__cc4_0.bias_c on VDD sky130_fd_pr__pfet_01v8 ad=0.406 pd=3.38 as=0.406 ps=3.38 w=1.4 l=0.6
X285 on x2_cm_casc__cc3_0.bias_d x2_cm_tail__id6_0.x2_m3d VSS sky130_fd_pr__nfet_01v8 ad=0.406 pd=3.38 as=0.406 ps=3.38 w=1.4 l=0.6
X286 on x2_cm_casc__cc3_0.bias_d x2_cm_tail__id6_0.x2_m3d VSS sky130_fd_pr__nfet_01v8 ad=0.406 pd=3.38 as=0.406 ps=3.38 w=1.4 l=0.6
X287 op x2_cl_casc__cc4_0.bias_c x2_diff__cc3_0.x2_foldn VDD sky130_fd_pr__pfet_01v8 ad=0.406 pd=3.38 as=0.406 ps=3.38 w=1.4 l=0.6
X288 x1_single_m3__f1_0.x1_m2d x1_single_m3__f1_0.x1_m2d x2_cm_casc__cc3_0.bias_d VSS sky130_fd_pr__nfet_01v8 ad=0.406 pd=3.38 as=0.406 ps=3.38 w=1.4 l=0.6
X289 x1_cc_cm__strings1_0.x1_net10 cm x1_cc_cm__strings1_0.x1_net11 VSS sky130_fd_pr__nfet_01v8 ad=0.406 pd=3.38 as=0.406 ps=3.38 w=1.4 l=0.6
X290 x2_cm_casc__cc3_0.bias_d x1_single_m3__f1_0.x1_m2d x1_single_m3__f1_0.x1_m2d VSS sky130_fd_pr__nfet_01v8 ad=0.406 pd=3.38 as=0.406 ps=3.38 w=1.4 l=0.6
X291 x1_single_m3__f1_0.x1_m2d x1_single_m3__f1_0.x1_m2d x2_cm_casc__cc3_0.bias_d VSS sky130_fd_pr__nfet_01v8 ad=0.406 pd=3.38 as=0.406 ps=3.38 w=1.4 l=0.6
X292 VSS cmc x2_diff__cc3_0.x2_tail VSS sky130_fd_pr__nfet_01v8 ad=0.406 pd=3.38 as=0.406 ps=3.38 w=1.4 l=0.6
X293 VSS bias_a x2_diff__cc3_0.x2_tail VSS sky130_fd_pr__nfet_01v8 ad=0.406 pd=3.38 as=0.406 ps=3.38 w=1.4 l=0.6
X294 VSS bias_a x2_diff__cc3_0.x2_tail VSS sky130_fd_pr__nfet_01v8 ad=0.406 pd=3.38 as=0.406 ps=3.38 w=1.4 l=0.6
X295 x2_cm_tail__id6_0.x2_m4d x2_cm_casc__cc3_0.bias_d op VSS sky130_fd_pr__nfet_01v8 ad=0.406 pd=3.38 as=0.406 ps=3.38 w=1.4 l=0.6
X296 on cmc sky130_fd_pr__cap_mim_m3_1 l=4.8 w=4.8
X297 x2_cl_casc__cc4_0.bias_c x2_cl_src__cc4_0.bias_b x2_cl_src__cc4_0.bias_b VSS sky130_fd_pr__nfet_01v8_lvt ad=0.406 pd=3.38 as=0.406 ps=3.38 w=1.4 l=0.6
X298 VSS IBIAS x2_cl_casc__cc4_0.bias_c VSS sky130_fd_pr__nfet_01v8 ad=0.406 pd=3.38 as=0.406 ps=3.38 w=1.4 l=0.6
X299 x2_cm_tail__id6_0.x2_m3d bias_a VSS VSS sky130_fd_pr__nfet_01v8 ad=0.406 pd=3.38 as=0.406 ps=3.38 w=1.4 l=0.6
X300 VSS bias_a x2_diff__cc3_0.x2_tail VSS sky130_fd_pr__nfet_01v8 ad=0.406 pd=3.38 as=0.406 ps=3.38 w=1.4 l=0.6
X301 x2_cl_src__cc4_0.bias_b x2_cl_src__cc4_0.bias_b x2_cl_casc__cc4_0.bias_c VSS sky130_fd_pr__nfet_01v8_lvt ad=0.406 pd=3.38 as=0.406 ps=3.38 w=1.4 l=0.6
X302 VSS VSS x1_single_m5__f3_0.x1_m5d VSS sky130_fd_pr__nfet_01v8 ad=0.406 pd=3.38 as=0.406 ps=3.38 w=1.4 l=0.6
X303 x2_cl_src__cc4_0.bias_b x2_cl_src__cc4_0.bias_b x2_cl_casc__cc4_0.bias_c VSS sky130_fd_pr__nfet_01v8_lvt ad=0.406 pd=3.38 as=0.406 ps=3.38 w=1.4 l=0.6
X304 x2_diff__cc3_0.x2_foldp x2_cl_src__cc4_0.bias_b VDD VDD sky130_fd_pr__pfet_01v8_lvt ad=0.406 pd=3.38 as=0.406 ps=3.38 w=1.4 l=0.6
X305 VSS cm x1_cc_cm__strings1_0.x1_net15 VSS sky130_fd_pr__nfet_01v8 ad=0.406 pd=3.38 as=0.406 ps=3.38 w=1.4 l=0.6
X306 x2_cm_tail__id6_0.x2_m3d bias_a VSS VSS sky130_fd_pr__nfet_01v8 ad=0.406 pd=3.38 as=0.406 ps=3.38 w=1.4 l=0.6
X307 VSS cmc x2_diff__cc3_0.x2_tail VSS sky130_fd_pr__nfet_01v8 ad=0.406 pd=3.38 as=0.406 ps=3.38 w=1.4 l=0.6
X308 VSS VSS x1_single_m5__f3_0.x1_m5d VSS sky130_fd_pr__nfet_01v8 ad=0.406 pd=3.38 as=0.406 ps=3.38 w=1.4 l=0.6
X309 x2_cm_tail__id6_0.x2_m3d x2_cm_casc__cc3_0.bias_d on VSS sky130_fd_pr__nfet_01v8 ad=0.406 pd=3.38 as=0.406 ps=3.38 w=1.4 l=0.6
X310 x2_cm_casc__cc3_0.bias_d x1_single_m3__f1_0.x1_m2d x1_single_m3__f1_0.x1_m2d VSS sky130_fd_pr__nfet_01v8 ad=0.406 pd=3.38 as=0.406 ps=3.38 w=1.4 l=0.6
X311 VSS bias_a x2_diff__cc3_0.x2_tail VSS sky130_fd_pr__nfet_01v8 ad=0.406 pd=3.38 as=0.406 ps=3.38 w=1.4 l=0.6
X312 x2_cm_tail__id6_0.x2_m4d bias_a VSS VSS sky130_fd_pr__nfet_01v8 ad=0.406 pd=3.38 as=0.406 ps=3.38 w=1.4 l=0.6
X313 VSS cmc x2_diff__cc3_0.x2_tail VSS sky130_fd_pr__nfet_01v8 ad=0.406 pd=3.38 as=0.406 ps=3.38 w=1.4 l=0.6
X314 x2_cl_casc__cc4_0.bias_c IBIAS VSS VSS sky130_fd_pr__nfet_01v8 ad=0.406 pd=3.38 as=0.406 ps=3.38 w=1.4 l=0.6
X315 x2_diff__cc3_0.x2_tail cmc VSS VSS sky130_fd_pr__nfet_01v8 ad=0.406 pd=3.38 as=0.406 ps=3.38 w=1.4 l=0.6
X316 x2_cl_casc__cc4_0.bias_c x2_cl_casc__cc4_0.bias_c x2_cl_casc__cc4_0.bias_c VSS sky130_fd_pr__nfet_01v8_lvt ad=0.406 pd=3.38 as=0 ps=0 w=1.4 l=0.6
X317 VDD VDD VDD VDD sky130_fd_pr__pfet_01v8_lvt ad=0.406 pd=3.38 as=0 ps=0 w=1.4 l=0.6
X318 x2_diff__cc3_0.x2_tail bias_a VSS VSS sky130_fd_pr__nfet_01v8 ad=0.406 pd=3.38 as=0.406 ps=3.38 w=1.4 l=0.6
X319 VSS VSS x2_cm_tail__id6_0.x2_m4d VSS sky130_fd_pr__nfet_01v8 ad=0.406 pd=3.38 as=0.406 ps=3.38 w=1.4 l=0.6
X320 VDD VDD on VDD sky130_fd_pr__pfet_01v8 ad=0.406 pd=3.38 as=0.406 ps=3.38 w=1.4 l=0.6
X321 x2_diff__cc3_0.x2_foldp x2_cl_src__cc4_0.bias_b VDD VDD sky130_fd_pr__pfet_01v8_lvt ad=0.406 pd=3.38 as=0.406 ps=3.38 w=1.4 l=0.6
X322 VSS VSS VSS VSS sky130_fd_pr__nfet_01v8 ad=0.406 pd=3.38 as=0 ps=0 w=1.4 l=0.6
X323 op x2_cl_casc__cc4_0.bias_c x2_diff__cc3_0.x2_foldn VDD sky130_fd_pr__pfet_01v8 ad=0.406 pd=3.38 as=0.406 ps=3.38 w=1.4 l=0.6
X324 x1_cm_bias_c__cc1_0.x1_m25d x2_cl_src__cc4_0.bias_b VDD VDD sky130_fd_pr__pfet_01v8_lvt ad=0.406 pd=3.38 as=0.406 ps=3.38 w=1.4 l=0.6
X325 x2_cl_casc__cc4_0.bias_c x2_cl_src__cc4_0.bias_b x2_cl_src__cc4_0.bias_b VSS sky130_fd_pr__nfet_01v8_lvt ad=0.406 pd=3.38 as=0.406 ps=3.38 w=1.4 l=0.6
X326 x2_diff__cc3_0.x2_tail cmc VSS VSS sky130_fd_pr__nfet_01v8 ad=0.406 pd=3.38 as=0.406 ps=3.38 w=1.4 l=0.6
X327 x2_cm_tail__id6_0.x2_m3d x2_cm_casc__cc3_0.bias_d on VSS sky130_fd_pr__nfet_01v8 ad=0.406 pd=3.38 as=0.406 ps=3.38 w=1.4 l=0.6
X328 VSS cmc x2_diff__cc3_0.x2_tail VSS sky130_fd_pr__nfet_01v8 ad=0.406 pd=3.38 as=0.406 ps=3.38 w=1.4 l=0.6
X329 x2_cl_src__cc4_0.bias_b x2_cl_src__cc4_0.bias_b x2_cl_casc__cc4_0.bias_c VSS sky130_fd_pr__nfet_01v8_lvt ad=0.406 pd=3.38 as=0.406 ps=3.38 w=1.4 l=0.6
X330 VSS VSS VSS VSS sky130_fd_pr__nfet_01v8 ad=0.406 pd=3.38 as=0 ps=0 w=1.4 l=0.6
X331 VSS bias_a x2_diff__cc3_0.x2_tail VSS sky130_fd_pr__nfet_01v8 ad=0.406 pd=3.38 as=0.406 ps=3.38 w=1.4 l=0.6
X332 on x2_cl_casc__cc4_0.bias_c x2_diff__cc3_0.x2_foldp VDD sky130_fd_pr__pfet_01v8 ad=0.406 pd=3.38 as=0.406 ps=3.38 w=1.4 l=0.6
X333 VSS bias_a x2_diff__cc3_0.x2_tail VSS sky130_fd_pr__nfet_01v8 ad=0.406 pd=3.38 as=0.406 ps=3.38 w=1.4 l=0.6
X334 x2_diff__cc3_0.x2_tail bias_a VSS VSS sky130_fd_pr__nfet_01v8 ad=0.406 pd=3.38 as=0.406 ps=3.38 w=1.4 l=0.6
X335 VSS VSS x2_cm_tail__id6_0.x2_m4d VSS sky130_fd_pr__nfet_01v8 ad=0.406 pd=3.38 as=0.406 ps=3.38 w=1.4 l=0.6
X336 x2_cl_src__cc4_0.bias_b x2_cl_src__cc4_0.bias_b x2_cl_src__cc4_0.bias_b VSS sky130_fd_pr__nfet_01v8_lvt ad=0.406 pd=3.38 as=0 ps=0 w=1.4 l=0.6
X337 x2_diff__cc3_0.x2_tail cmc VSS VSS sky130_fd_pr__nfet_01v8 ad=0.406 pd=3.38 as=0.406 ps=3.38 w=1.4 l=0.6
X338 VDD x2_cl_src__cc4_0.bias_b x2_diff__cc3_0.x2_foldn VDD sky130_fd_pr__pfet_01v8_lvt ad=0.406 pd=3.38 as=0.406 ps=3.38 w=1.4 l=0.6
X339 x1_single_m3__f1_0.x1_m2d x1_single_m3__f1_0.x1_m2d x2_cm_casc__cc3_0.bias_d VSS sky130_fd_pr__nfet_01v8 ad=0.406 pd=3.38 as=0.406 ps=3.38 w=1.4 l=0.6
X340 VSS bias_a x2_cm_tail__id6_0.x2_m3d VSS sky130_fd_pr__nfet_01v8 ad=0.406 pd=3.38 as=0.406 ps=3.38 w=1.4 l=0.6
X341 x2_cl_casc__cc4_0.bias_c x2_cl_src__cc4_0.bias_b x2_cl_src__cc4_0.bias_b VSS sky130_fd_pr__nfet_01v8_lvt ad=0.406 pd=3.38 as=0.406 ps=3.38 w=1.4 l=0.6
X342 x2_diff__cc3_0.x2_foldp x2_cl_casc__cc4_0.bias_c on VDD sky130_fd_pr__pfet_01v8 ad=0.406 pd=3.38 as=0.406 ps=3.38 w=1.4 l=0.6
X343 x2_cl_src__cc4_0.bias_b x2_cl_src__cc4_0.bias_b x2_cl_src__cc4_0.bias_b VSS sky130_fd_pr__nfet_01v8_lvt ad=0.406 pd=3.38 as=0 ps=0 w=1.4 l=0.6
X344 VDD VDD op VDD sky130_fd_pr__pfet_01v8 ad=0.406 pd=3.38 as=0.406 ps=3.38 w=1.4 l=0.6
X345 op x2_cm_casc__cc3_0.bias_d x2_cm_tail__id6_0.x2_m4d VSS sky130_fd_pr__nfet_01v8 ad=0.406 pd=3.38 as=0.406 ps=3.38 w=1.4 l=0.6
X346 x2_cm_casc__cc3_0.bias_d x2_cm_casc__cc3_0.bias_d x2_cm_casc__cc3_0.bias_d VSS sky130_fd_pr__nfet_01v8 ad=0.406 pd=3.38 as=0 ps=0 w=1.4 l=0.6
X347 x2_cm_casc__cc3_0.bias_d x1_single_m3__f1_0.x1_m2d x1_single_m3__f1_0.x1_m2d VSS sky130_fd_pr__nfet_01v8 ad=0.406 pd=3.38 as=0.406 ps=3.38 w=1.4 l=0.6
X348 IBIAS IBIAS VSS VSS sky130_fd_pr__nfet_01v8 ad=0.406 pd=3.38 as=0.406 ps=3.38 w=1.4 l=0.6
X349 x2_diff__cc3_0.x2_foldn x2_cl_src__cc4_0.bias_b VDD VDD sky130_fd_pr__pfet_01v8_lvt ad=0.406 pd=3.38 as=0.406 ps=3.38 w=1.4 l=0.6
X350 x1_single_m5__f3_0.x1_m5d bias_a VSS VSS sky130_fd_pr__nfet_01v8 ad=0.406 pd=3.38 as=0.406 ps=3.38 w=1.4 l=0.6
X351 on x2_cl_casc__cc4_0.bias_c x2_diff__cc3_0.x2_foldp VDD sky130_fd_pr__pfet_01v8 ad=0.406 pd=3.38 as=0.406 ps=3.38 w=1.4 l=0.6
X352 on x2_cm_casc__cc3_0.bias_d x2_cm_tail__id6_0.x2_m3d VSS sky130_fd_pr__nfet_01v8 ad=0.406 pd=3.38 as=0.406 ps=3.38 w=1.4 l=0.6
X353 VSS cmc x2_diff__cc3_0.x2_tail VSS sky130_fd_pr__nfet_01v8 ad=0.406 pd=3.38 as=0.406 ps=3.38 w=1.4 l=0.6
X354 VSS bias_a x2_diff__cc3_0.x2_tail VSS sky130_fd_pr__nfet_01v8 ad=0.406 pd=3.38 as=0.406 ps=3.38 w=1.4 l=0.6
X355 x2_cm_tail__id6_0.x2_m4d bias_a VSS VSS sky130_fd_pr__nfet_01v8 ad=0.406 pd=3.38 as=0.406 ps=3.38 w=1.4 l=0.6
X356 VSS IBIAS x2_cl_casc__cc4_0.bias_c VSS sky130_fd_pr__nfet_01v8 ad=0.406 pd=3.38 as=0.406 ps=3.38 w=1.4 l=0.6
X357 VDD x2_cl_src__cc4_0.bias_b x2_diff__cc3_0.x2_foldp VDD sky130_fd_pr__pfet_01v8_lvt ad=0.406 pd=3.38 as=0.406 ps=3.38 w=1.4 l=0.6
X358 x2_cm_tail__id6_0.x2_m4d x2_cm_casc__cc3_0.bias_d op VSS sky130_fd_pr__nfet_01v8 ad=0.406 pd=3.38 as=0.406 ps=3.38 w=1.4 l=0.6
X359 op op op VSS sky130_fd_pr__nfet_01v8 ad=0.406 pd=3.38 as=17.052 ps=141.96001 w=1.4 l=0.6
X360 x1_cc_cm__strings1_0.x1_net1 cm cm VSS sky130_fd_pr__nfet_01v8 ad=0.406 pd=3.38 as=0.406 ps=3.38 w=1.4 l=0.6
X361 VDD VDD x2_diff__cc3_0.x2_foldp VDD sky130_fd_pr__pfet_01v8 ad=0.406 pd=3.38 as=0.406 ps=3.38 w=1.4 l=0.6
X362 x1_single_m5__f3_0.x1_m5d bias_a VSS VSS sky130_fd_pr__nfet_01v8 ad=0.406 pd=3.38 as=0.406 ps=3.38 w=1.4 l=0.6
X363 op x2_cm_casc__cc3_0.bias_d x2_cm_tail__id6_0.x2_m4d VSS sky130_fd_pr__nfet_01v8 ad=0.406 pd=3.38 as=0.406 ps=3.38 w=1.4 l=0.6
X364 x2_diff__cc3_0.x2_tail ip x2_diff__cc3_0.x2_foldp VSS sky130_fd_pr__nfet_01v8_lvt ad=0.348 pd=2.98 as=0.348 ps=2.98 w=1.2 l=0.2
X365 VSS bias_a x2_diff__cc3_0.x2_tail VSS sky130_fd_pr__nfet_01v8 ad=0.406 pd=3.38 as=0.406 ps=3.38 w=1.4 l=0.6
X366 x1_single_m3__f1_0.x1_m2d x1_single_m3__f1_0.x1_m2d x2_cm_casc__cc3_0.bias_d VSS sky130_fd_pr__nfet_01v8 ad=0.406 pd=3.38 as=0.406 ps=3.38 w=1.4 l=0.6
X367 x2_diff__cc3_0.x2_tail cmc VSS VSS sky130_fd_pr__nfet_01v8 ad=0.406 pd=3.38 as=0.406 ps=3.38 w=1.4 l=0.6
X368 x2_cl_casc__cc4_0.bias_c x2_cl_casc__cc4_0.bias_c x2_cl_casc__cc4_0.bias_c VSS sky130_fd_pr__nfet_01v8_lvt ad=0.406 pd=3.38 as=0 ps=0 w=1.4 l=0.6
X369 VDD x2_cl_src__cc4_0.bias_b x2_diff__cc3_0.x2_foldp VDD sky130_fd_pr__pfet_01v8_lvt ad=0.406 pd=3.38 as=0.406 ps=3.38 w=1.4 l=0.6
X370 x2_cl_src__cc4_0.bias_b x2_cl_src__cc4_0.bias_b x2_cl_casc__cc4_0.bias_c VSS sky130_fd_pr__nfet_01v8_lvt ad=0.406 pd=3.38 as=0.406 ps=3.38 w=1.4 l=0.6
X371 x2_cm_tail__id6_0.x2_m3d x2_cm_casc__cc3_0.bias_d on VSS sky130_fd_pr__nfet_01v8 ad=0.406 pd=3.38 as=0.406 ps=3.38 w=1.4 l=0.6
X372 VSS bias_a x1_single_m5__f3_0.x1_m5d VSS sky130_fd_pr__nfet_01v8 ad=0.406 pd=3.38 as=0.406 ps=3.38 w=1.4 l=0.6
X373 VSS VSS x1_single_m5__f3_0.x1_m5d VSS sky130_fd_pr__nfet_01v8 ad=0.406 pd=3.38 as=0.406 ps=3.38 w=1.4 l=0.6
X374 cm cm x1_cc_cm__strings1_0.x1_net10 VSS sky130_fd_pr__nfet_01v8 ad=0.406 pd=3.38 as=0.406 ps=3.38 w=1.4 l=0.6
X375 VSS VSS VSS VSS sky130_fd_pr__nfet_01v8 ad=0.406 pd=3.38 as=0 ps=0 w=1.4 l=0.6
X376 x1_cm_bias_c__cc1_0.x1_m25d x2_cl_casc__cc4_0.bias_c x1_single_m3__f1_0.x1_m2d VDD sky130_fd_pr__pfet_01v8 ad=0.406 pd=3.38 as=0.406 ps=3.38 w=1.4 l=0.6
X377 x2_cm_tail__id6_0.x2_m3d bias_a VSS VSS sky130_fd_pr__nfet_01v8 ad=0.406 pd=3.38 as=0.406 ps=3.38 w=1.4 l=0.6
X378 VSS VSS x2_cm_tail__id6_0.x2_m4d VSS sky130_fd_pr__nfet_01v8 ad=0.406 pd=3.38 as=0.406 ps=3.38 w=1.4 l=0.6
X379 x2_diff__cc3_0.x2_tail in x2_diff__cc3_0.x2_foldn VSS sky130_fd_pr__nfet_01v8_lvt ad=0.348 pd=2.98 as=0.348 ps=2.98 w=1.2 l=0.2
X380 VSS VSS VSS VSS sky130_fd_pr__nfet_01v8 ad=0.406 pd=3.38 as=0 ps=0 w=1.4 l=0.6
X381 VSS VSS x1_single_m5__f3_0.x1_m5d VSS sky130_fd_pr__nfet_01v8 ad=0.406 pd=3.38 as=0.406 ps=3.38 w=1.4 l=0.6
X382 bias_a bias_a bias_a VSS sky130_fd_pr__nfet_01v8 ad=0.406 pd=3.38 as=11.368 ps=94.64 w=1.4 l=0.6
X383 x1_single_m3__f1_0.x1_m2d x1_single_m3__f1_0.x1_m2d x2_cm_casc__cc3_0.bias_d VSS sky130_fd_pr__nfet_01v8 ad=0.406 pd=3.38 as=0.406 ps=3.38 w=1.4 l=0.6
X384 x2_cm_tail__id6_0.x2_m4d bias_a VSS VSS sky130_fd_pr__nfet_01v8 ad=0.406 pd=3.38 as=0.406 ps=3.38 w=1.4 l=0.6
X385 x2_diff__cc3_0.x2_foldp x2_diff__cc3_0.x2_foldp x2_diff__cc3_0.x2_foldp VDD sky130_fd_pr__pfet_01v8 ad=0.406 pd=3.38 as=20.3 ps=169 w=1.4 l=0.6
X386 bias_a x2_cm_casc__cc3_0.bias_d x1_single_m5__f3_0.x1_m5d VSS sky130_fd_pr__nfet_01v8 ad=0.406 pd=3.38 as=0.406 ps=3.38 w=1.4 l=0.6
X387 x2_cm_casc__cc3_0.bias_d x1_single_m3__f1_0.x1_m2d x1_single_m3__f1_0.x1_m2d VSS sky130_fd_pr__nfet_01v8 ad=0.406 pd=3.38 as=0.406 ps=3.38 w=1.4 l=0.6
X388 on x2_cm_casc__cc3_0.bias_d x2_cm_tail__id6_0.x2_m3d VSS sky130_fd_pr__nfet_01v8 ad=0.406 pd=3.38 as=0.406 ps=3.38 w=1.4 l=0.6
X389 VSS VSS VSS VSS sky130_fd_pr__nfet_01v8_lvt ad=0.348 pd=2.98 as=0 ps=0 w=1.2 l=0.2
X390 VSS VSS x2_cm_tail__id6_0.x2_m4d VSS sky130_fd_pr__nfet_01v8 ad=0.406 pd=3.38 as=0.406 ps=3.38 w=1.4 l=0.6
X391 VSS bias_a x2_diff__cc3_0.x2_tail VSS sky130_fd_pr__nfet_01v8 ad=0.406 pd=3.38 as=0.406 ps=3.38 w=1.4 l=0.6
X392 VSS bias_a x2_cm_tail__id6_0.x2_m4d VSS sky130_fd_pr__nfet_01v8 ad=0.406 pd=3.38 as=0.406 ps=3.38 w=1.4 l=0.6
X393 x2_diff__cc3_0.x2_tail cmc VSS VSS sky130_fd_pr__nfet_01v8 ad=0.406 pd=3.38 as=0.406 ps=3.38 w=1.4 l=0.6
X394 x2_cl_src__cc4_0.bias_b x2_cl_src__cc4_0.bias_b x2_cl_casc__cc4_0.bias_c VSS sky130_fd_pr__nfet_01v8_lvt ad=0.406 pd=3.38 as=0.406 ps=3.38 w=1.4 l=0.6
X395 x1_cc_cm__strings1_0.x1_net15 cm x1_cc_cm__strings1_0.x1_net14 VSS sky130_fd_pr__nfet_01v8 ad=0.406 pd=3.38 as=0.406 ps=3.38 w=1.4 l=0.6
X396 VSS bias_a x2_diff__cc3_0.x2_tail VSS sky130_fd_pr__nfet_01v8 ad=0.406 pd=3.38 as=0.406 ps=3.38 w=1.4 l=0.6
X397 x2_cm_tail__id6_0.x2_m4d x2_cm_casc__cc3_0.bias_d op VSS sky130_fd_pr__nfet_01v8 ad=0.406 pd=3.38 as=0.406 ps=3.38 w=1.4 l=0.6
X398 x2_cm_tail__id6_0.x2_m4d bias_a VSS VSS sky130_fd_pr__nfet_01v8 ad=0.406 pd=3.38 as=0.406 ps=3.38 w=1.4 l=0.6
X399 x1_cm_bias_c__cc1_0.x1_m31d x2_cl_casc__cc4_0.bias_c cm VDD sky130_fd_pr__pfet_01v8 ad=0.406 pd=3.38 as=0.406 ps=3.38 w=1.4 l=0.6
X400 VDD VDD VDD VDD sky130_fd_pr__pfet_01v8 ad=0.406 pd=3.38 as=0 ps=0 w=1.4 l=0.6
X401 x2_diff__cc3_0.x2_foldn x2_cl_src__cc4_0.bias_b VDD VDD sky130_fd_pr__pfet_01v8_lvt ad=0.406 pd=3.38 as=0.406 ps=3.38 w=1.4 l=0.6
X402 VSS VSS VSS VSS sky130_fd_pr__nfet_01v8 ad=0.406 pd=3.38 as=0 ps=0 w=1.4 l=0.6
X403 x2_diff__cc3_0.x2_tail cmc VSS VSS sky130_fd_pr__nfet_01v8 ad=0.406 pd=3.38 as=0.406 ps=3.38 w=1.4 l=0.6
X404 on x2_cl_casc__cc4_0.bias_c x2_diff__cc3_0.x2_foldp VDD sky130_fd_pr__pfet_01v8 ad=0.406 pd=3.38 as=0.406 ps=3.38 w=1.4 l=0.6
X405 x2_cl_casc__cc4_0.bias_c x2_cl_src__cc4_0.bias_b x2_cl_src__cc4_0.bias_b VSS sky130_fd_pr__nfet_01v8_lvt ad=0.406 pd=3.38 as=0.406 ps=3.38 w=1.4 l=0.6
X406 x2_diff__cc3_0.x2_tail bias_a VSS VSS sky130_fd_pr__nfet_01v8 ad=0.406 pd=3.38 as=0.406 ps=3.38 w=1.4 l=0.6
X407 VSS bias_a x2_diff__cc3_0.x2_tail VSS sky130_fd_pr__nfet_01v8 ad=0.406 pd=3.38 as=0.406 ps=3.38 w=1.4 l=0.6
X408 VDD x2_cl_src__cc4_0.bias_b x2_diff__cc3_0.x2_foldp VDD sky130_fd_pr__pfet_01v8_lvt ad=0.406 pd=3.38 as=0.406 ps=3.38 w=1.4 l=0.6
X409 x2_cl_casc__cc4_0.bias_c x2_cl_casc__cc4_0.bias_c x2_cl_casc__cc4_0.bias_c VSS sky130_fd_pr__nfet_01v8_lvt ad=0.406 pd=3.38 as=0 ps=0 w=1.4 l=0.6
X410 x1_cm_bias_c__cc1_0.x1_m25d x2_cl_casc__cc4_0.bias_c x1_single_m3__f1_0.x1_m2d VDD sky130_fd_pr__pfet_01v8 ad=0.406 pd=3.38 as=0.406 ps=3.38 w=1.4 l=0.6
X411 x2_diff__cc3_0.x2_tail cmc VSS VSS sky130_fd_pr__nfet_01v8 ad=0.406 pd=3.38 as=0.406 ps=3.38 w=1.4 l=0.6
X412 x2_diff__cc3_0.x2_foldn x2_cl_src__cc4_0.bias_b VDD VDD sky130_fd_pr__pfet_01v8_lvt ad=0.406 pd=3.38 as=0.406 ps=3.38 w=1.4 l=0.6
X413 x2_cm_tail__id6_0.x2_m4d x2_cm_casc__cc3_0.bias_d op VSS sky130_fd_pr__nfet_01v8 ad=0.406 pd=3.38 as=0.406 ps=3.38 w=1.4 l=0.6
X414 VSS bias_a x2_diff__cc3_0.x2_tail VSS sky130_fd_pr__nfet_01v8 ad=0.406 pd=3.38 as=0.406 ps=3.38 w=1.4 l=0.6
X415 VSS bias_a x2_diff__cc3_0.x2_tail VSS sky130_fd_pr__nfet_01v8 ad=0.406 pd=3.38 as=0.406 ps=3.38 w=1.4 l=0.6
X416 VSS VSS VSS VSS sky130_fd_pr__nfet_01v8 ad=0.406 pd=3.38 as=0 ps=0 w=1.4 l=0.6
X417 x2_cl_casc__cc4_0.bias_c x2_cl_src__cc4_0.bias_b x2_cl_src__cc4_0.bias_b VSS sky130_fd_pr__nfet_01v8_lvt ad=0.406 pd=3.38 as=0.406 ps=3.38 w=1.4 l=0.6
X418 op cmc sky130_fd_pr__cap_mim_m3_1 l=4.8 w=4.8
X419 x2_diff__cc3_0.x2_foldn x2_cl_casc__cc4_0.bias_c op VDD sky130_fd_pr__pfet_01v8 ad=0.406 pd=3.38 as=0.406 ps=3.38 w=1.4 l=0.6
X420 x1_cm_bias_c__cc1_0.x1_m21d x1_cm_bias_c__cc1_0.x1_m21d x1_cm_bias_c__cc1_0.x1_m21d VDD sky130_fd_pr__pfet_01v8_lvt ad=0.406 pd=3.38 as=0 ps=0 w=1.4 l=0.6
X421 x2_diff__cc3_0.x2_tail cmc VSS VSS sky130_fd_pr__nfet_01v8 ad=0.406 pd=3.38 as=0.406 ps=3.38 w=1.4 l=0.6
X422 x1_cm_bias_c__cc1_0.x1_m25d x1_cm_bias_c__cc1_0.x1_m25d x1_cm_bias_c__cc1_0.x1_m25d VDD sky130_fd_pr__pfet_01v8 ad=0.406 pd=3.38 as=0 ps=0 w=1.4 l=0.6
X423 VSS VSS VSS VSS sky130_fd_pr__nfet_01v8 ad=0.406 pd=3.38 as=0 ps=0 w=1.4 l=0.6
X424 x2_cl_src__cc4_0.bias_b x2_cl_src__cc4_0.bias_b x2_cl_casc__cc4_0.bias_c VSS sky130_fd_pr__nfet_01v8_lvt ad=0.406 pd=3.38 as=0.406 ps=3.38 w=1.4 l=0.6
X425 VSS cmc x2_diff__cc3_0.x2_tail VSS sky130_fd_pr__nfet_01v8 ad=0.406 pd=3.38 as=0.406 ps=3.38 w=1.4 l=0.6
X426 x2_diff__cc3_0.x2_tail cmc VSS VSS sky130_fd_pr__nfet_01v8 ad=0.406 pd=3.38 as=0.406 ps=3.38 w=1.4 l=0.6
X427 VSS bias_a x2_diff__cc3_0.x2_tail VSS sky130_fd_pr__nfet_01v8 ad=0.406 pd=3.38 as=0.406 ps=3.38 w=1.4 l=0.6
X428 x2_diff__cc3_0.x2_tail bias_a VSS VSS sky130_fd_pr__nfet_01v8 ad=0.406 pd=3.38 as=0.406 ps=3.38 w=1.4 l=0.6
X429 VSS bias_a x2_cm_tail__id6_0.x2_m4d VSS sky130_fd_pr__nfet_01v8 ad=0.406 pd=3.38 as=0.406 ps=3.38 w=1.4 l=0.6
X430 IBIAS IBIAS IBIAS VSS sky130_fd_pr__nfet_01v8 ad=0.406 pd=3.38 as=8.932 ps=74.36 w=1.4 l=0.6
X431 x2_diff__cc3_0.x2_foldp ip x2_diff__cc3_0.x2_tail VSS sky130_fd_pr__nfet_01v8_lvt ad=0.348 pd=2.98 as=0.348 ps=2.98 w=1.2 l=0.2
X432 x2_diff__cc3_0.x2_tail bias_a VSS VSS sky130_fd_pr__nfet_01v8 ad=0.406 pd=3.38 as=0.406 ps=3.38 w=1.4 l=0.6
X433 x2_cl_casc__cc4_0.bias_c x2_cl_src__cc4_0.bias_b x2_cl_src__cc4_0.bias_b VSS sky130_fd_pr__nfet_01v8_lvt ad=0.406 pd=3.38 as=0.406 ps=3.38 w=1.4 l=0.6
X434 IBIAS IBIAS IBIAS VSS sky130_fd_pr__nfet_01v8 ad=0.406 pd=3.38 as=0 ps=0 w=1.4 l=0.6
X435 x1_cm_bias_c__cc1_0.x1_m31d x2_cl_src__cc4_0.bias_b VDD VDD sky130_fd_pr__pfet_01v8_lvt ad=0.406 pd=3.38 as=0.406 ps=3.38 w=1.4 l=0.6
X436 x2_cm_tail__id6_0.x2_m3d bias_a VSS VSS sky130_fd_pr__nfet_01v8 ad=0.406 pd=3.38 as=0.406 ps=3.38 w=1.4 l=0.6
X437 VDD x2_cl_src__cc4_0.bias_b x2_diff__cc3_0.x2_foldn VDD sky130_fd_pr__pfet_01v8_lvt ad=0.406 pd=3.38 as=0.406 ps=3.38 w=1.4 l=0.6
X438 bias_a bias_a bias_a VSS sky130_fd_pr__nfet_01v8 ad=0.406 pd=3.38 as=0 ps=0 w=1.4 l=0.6
X439 x1_single_m5__f3_0.x1_m5d x1_single_m5__f3_0.x1_m5d x1_single_m5__f3_0.x1_m5d VSS sky130_fd_pr__nfet_01v8 ad=0.406 pd=3.38 as=0 ps=0 w=1.4 l=0.6
X440 op x2_cm_casc__cc3_0.bias_d x2_cm_tail__id6_0.x2_m4d VSS sky130_fd_pr__nfet_01v8 ad=0.406 pd=3.38 as=0.406 ps=3.38 w=1.4 l=0.6
X441 VSS bias_a x2_diff__cc3_0.x2_tail VSS sky130_fd_pr__nfet_01v8 ad=0.406 pd=3.38 as=0.406 ps=3.38 w=1.4 l=0.6
X442 VSS cmc x2_diff__cc3_0.x2_tail VSS sky130_fd_pr__nfet_01v8 ad=0.406 pd=3.38 as=0.406 ps=3.38 w=1.4 l=0.6
X443 VSS VSS VSS VSS sky130_fd_pr__nfet_01v8 ad=0.406 pd=3.38 as=0 ps=0 w=1.4 l=0.6
X444 VSS bias_a x2_cm_tail__id6_0.x2_m3d VSS sky130_fd_pr__nfet_01v8 ad=0.406 pd=3.38 as=0.406 ps=3.38 w=1.4 l=0.6
X445 VSS bias_a x2_diff__cc3_0.x2_tail VSS sky130_fd_pr__nfet_01v8 ad=0.406 pd=3.38 as=0.406 ps=3.38 w=1.4 l=0.6
X446 VSS IBIAS x2_cl_casc__cc4_0.bias_c VSS sky130_fd_pr__nfet_01v8 ad=0.406 pd=3.38 as=0.406 ps=3.38 w=1.4 l=0.6
X447 VSS VSS x2_diff__cc3_0.x2_tail VSS sky130_fd_pr__nfet_01v8 ad=0.406 pd=3.38 as=0.406 ps=3.38 w=1.4 l=0.6
X448 VSS bias_a x2_cm_tail__id6_0.x2_m3d VSS sky130_fd_pr__nfet_01v8 ad=0.406 pd=3.38 as=0.406 ps=3.38 w=1.4 l=0.6
X449 VDD VDD VDD VDD sky130_fd_pr__pfet_01v8 ad=0.406 pd=3.38 as=0 ps=0 w=1.4 l=0.6
X450 VDD x2_cl_src__cc4_0.bias_b x2_diff__cc3_0.x2_foldn VDD sky130_fd_pr__pfet_01v8_lvt ad=0.406 pd=3.38 as=0.406 ps=3.38 w=1.4 l=0.6
X451 x2_cl_src__cc4_0.bias_b x2_cl_src__cc4_0.bias_b x2_cl_casc__cc4_0.bias_c VSS sky130_fd_pr__nfet_01v8_lvt ad=0.406 pd=3.38 as=0.406 ps=3.38 w=1.4 l=0.6
X452 x2_diff__cc3_0.x2_tail bias_a VSS VSS sky130_fd_pr__nfet_01v8 ad=0.406 pd=3.38 as=0.406 ps=3.38 w=1.4 l=0.6
X453 x2_cm_tail__id6_0.x2_m4d bias_a VSS VSS sky130_fd_pr__nfet_01v8 ad=0.406 pd=3.38 as=0.406 ps=3.38 w=1.4 l=0.6
X454 op x2_cm_casc__cc3_0.bias_d x2_cm_tail__id6_0.x2_m4d VSS sky130_fd_pr__nfet_01v8 ad=0.406 pd=3.38 as=0.406 ps=3.38 w=1.4 l=0.6
X455 x2_cm_tail__id6_0.x2_m3d bias_a VSS VSS sky130_fd_pr__nfet_01v8 ad=0.406 pd=3.38 as=0.406 ps=3.38 w=1.4 l=0.6
X456 x2_diff__cc3_0.x2_tail bias_a VSS VSS sky130_fd_pr__nfet_01v8 ad=0.406 pd=3.38 as=0.406 ps=3.38 w=1.4 l=0.6
X457 op cmc sky130_fd_pr__cap_mim_m3_1 l=4.8 w=4.8
X458 x1_single_m3__f1_0.x1_m2d x1_single_m3__f1_0.x1_m2d x2_cm_casc__cc3_0.bias_d VSS sky130_fd_pr__nfet_01v8 ad=0.406 pd=3.38 as=0.406 ps=3.38 w=1.4 l=0.6
X459 x2_cl_src__cc4_0.bias_b x2_cl_src__cc4_0.bias_b x2_cl_casc__cc4_0.bias_c VSS sky130_fd_pr__nfet_01v8_lvt ad=0.406 pd=3.38 as=0.406 ps=3.38 w=1.4 l=0.6
X460 VSS VSS x2_cm_tail__id6_0.x2_m3d VSS sky130_fd_pr__nfet_01v8 ad=0.406 pd=3.38 as=0.406 ps=3.38 w=1.4 l=0.6
X461 x1_cc_cm__strings1_0.x1_net8 cm x1_cc_cm__strings1_0.x1_net9 VSS sky130_fd_pr__nfet_01v8 ad=0.406 pd=3.38 as=0.406 ps=3.38 w=1.4 l=0.6
X462 x2_cm_casc__cc3_0.bias_d x1_single_m3__f1_0.x1_m2d x1_single_m3__f1_0.x1_m2d VSS sky130_fd_pr__nfet_01v8 ad=0.406 pd=3.38 as=0.406 ps=3.38 w=1.4 l=0.6
X463 VDD VDD on VDD sky130_fd_pr__pfet_01v8 ad=0.406 pd=3.38 as=0.406 ps=3.38 w=1.4 l=0.6
X464 x2_cl_src__cc4_0.bias_b x2_cl_src__cc4_0.bias_b x2_cl_casc__cc4_0.bias_c VSS sky130_fd_pr__nfet_01v8_lvt ad=0.406 pd=3.38 as=0.406 ps=3.38 w=1.4 l=0.6
X465 x2_cm_tail__id6_0.x2_m4d x2_cm_casc__cc3_0.bias_d op VSS sky130_fd_pr__nfet_01v8 ad=0.406 pd=3.38 as=0.406 ps=3.38 w=1.4 l=0.6
X466 x2_cm_tail__id6_0.x2_m3d x2_cm_casc__cc3_0.bias_d on VSS sky130_fd_pr__nfet_01v8 ad=0.406 pd=3.38 as=0.406 ps=3.38 w=1.4 l=0.6
X467 bias_a x2_cm_casc__cc3_0.bias_d x1_single_m5__f3_0.x1_m5d VSS sky130_fd_pr__nfet_01v8 ad=0.406 pd=3.38 as=0.406 ps=3.38 w=1.4 l=0.6
X468 IBIAS IBIAS VSS VSS sky130_fd_pr__nfet_01v8 ad=0.406 pd=3.38 as=0.406 ps=3.38 w=1.4 l=0.6
X469 VDD VDD VDD VDD sky130_fd_pr__pfet_01v8 ad=0.406 pd=3.38 as=0 ps=0 w=1.4 l=0.6
X470 x2_diff__cc3_0.x2_foldp x2_cl_src__cc4_0.bias_b VDD VDD sky130_fd_pr__pfet_01v8_lvt ad=0.406 pd=3.38 as=0.406 ps=3.38 w=1.4 l=0.6
X471 VSS cmc x2_diff__cc3_0.x2_tail VSS sky130_fd_pr__nfet_01v8 ad=0.406 pd=3.38 as=0.406 ps=3.38 w=1.4 l=0.6
X472 VSS cmc x2_diff__cc3_0.x2_tail VSS sky130_fd_pr__nfet_01v8 ad=0.406 pd=3.38 as=0.406 ps=3.38 w=1.4 l=0.6
X473 op x2_cl_casc__cc4_0.bias_c x2_diff__cc3_0.x2_foldn VDD sky130_fd_pr__pfet_01v8 ad=0.406 pd=3.38 as=0.406 ps=3.38 w=1.4 l=0.6
X474 x2_cl_src__cc4_0.bias_b x2_cl_src__cc4_0.bias_b x2_cl_casc__cc4_0.bias_c VSS sky130_fd_pr__nfet_01v8_lvt ad=0.406 pd=3.38 as=0.406 ps=3.38 w=1.4 l=0.6
X475 x2_cm_tail__id6_0.x2_m3d x2_cm_casc__cc3_0.bias_d on VSS sky130_fd_pr__nfet_01v8 ad=0.406 pd=3.38 as=0.406 ps=3.38 w=1.4 l=0.6
X476 x2_diff__cc3_0.x2_foldp x2_diff__cc3_0.x2_foldp x2_diff__cc3_0.x2_foldp VSS sky130_fd_pr__nfet_01v8_lvt ad=0.348 pd=2.98 as=0 ps=0 w=1.2 l=0.2
X477 cm cm cm VSS sky130_fd_pr__nfet_01v8 ad=0.406 pd=3.38 as=0 ps=0 w=1.4 l=0.6
X478 x1_cc_cm__strings1_0.x1_net13 cm cm VSS sky130_fd_pr__nfet_01v8 ad=0.406 pd=3.38 as=0.406 ps=3.38 w=1.4 l=0.6
X479 x2_diff__cc3_0.x2_tail bias_a VSS VSS sky130_fd_pr__nfet_01v8 ad=0.406 pd=3.38 as=0.406 ps=3.38 w=1.4 l=0.6
X480 VSS bias_a x2_diff__cc3_0.x2_tail VSS sky130_fd_pr__nfet_01v8 ad=0.406 pd=3.38 as=0.406 ps=3.38 w=1.4 l=0.6
X481 VDD VDD x1_single_m3__f1_0.x1_m2d VDD sky130_fd_pr__pfet_01v8 ad=0.406 pd=3.38 as=0.406 ps=3.38 w=1.4 l=0.6
X482 on on on VSS sky130_fd_pr__nfet_01v8 ad=0.406 pd=3.38 as=17.052 ps=141.96001 w=1.4 l=0.6
X483 x2_diff__cc3_0.x2_foldp x2_cl_src__cc4_0.bias_b VDD VDD sky130_fd_pr__pfet_01v8_lvt ad=0.406 pd=3.38 as=0.406 ps=3.38 w=1.4 l=0.6
X484 VSS bias_a x2_cm_tail__id6_0.x2_m3d VSS sky130_fd_pr__nfet_01v8 ad=0.406 pd=3.38 as=0.406 ps=3.38 w=1.4 l=0.6
X485 VDD VDD op VDD sky130_fd_pr__pfet_01v8 ad=0.406 pd=3.38 as=0.406 ps=3.38 w=1.4 l=0.6
X486 x2_cm_tail__id6_0.x2_m3d bias_a VSS VSS sky130_fd_pr__nfet_01v8 ad=0.406 pd=3.38 as=0.406 ps=3.38 w=1.4 l=0.6
X487 VSS bias_a x2_cm_tail__id6_0.x2_m4d VSS sky130_fd_pr__nfet_01v8 ad=0.406 pd=3.38 as=0.406 ps=3.38 w=1.4 l=0.6
X488 IBIAS IBIAS VSS VSS sky130_fd_pr__nfet_01v8 ad=0.406 pd=3.38 as=0.406 ps=3.38 w=1.4 l=0.6
X489 x2_diff__cc3_0.x2_tail bias_a VSS VSS sky130_fd_pr__nfet_01v8 ad=0.406 pd=3.38 as=0.406 ps=3.38 w=1.4 l=0.6
X490 x1_cm_bias_c__cc1_0.x1_m25d x1_cm_bias_c__cc1_0.x1_m25d x1_cm_bias_c__cc1_0.x1_m25d VDD sky130_fd_pr__pfet_01v8_lvt ad=0.406 pd=3.38 as=0 ps=0 w=1.4 l=0.6
X491 op x2_cm_casc__cc3_0.bias_d x2_cm_tail__id6_0.x2_m4d VSS sky130_fd_pr__nfet_01v8 ad=0.406 pd=3.38 as=0.406 ps=3.38 w=1.4 l=0.6
X492 x1_single_m3__f1_0.x1_m2d x1_single_m3__f1_0.x1_m2d x2_cm_casc__cc3_0.bias_d VSS sky130_fd_pr__nfet_01v8 ad=0.406 pd=3.38 as=0.406 ps=3.38 w=1.4 l=0.6
X493 VSS VSS VSS VSS sky130_fd_pr__nfet_01v8 ad=0.406 pd=3.38 as=0 ps=0 w=1.4 l=0.6
X494 VDD x2_cl_src__cc4_0.bias_b x1_cm_bias_c__cc1_0.x1_m31d VDD sky130_fd_pr__pfet_01v8_lvt ad=0.406 pd=3.38 as=0.406 ps=3.38 w=1.4 l=0.6
X495 x2_cl_casc__cc4_0.bias_c x2_cl_src__cc4_0.bias_b x2_cl_src__cc4_0.bias_b VSS sky130_fd_pr__nfet_01v8_lvt ad=0.406 pd=3.38 as=0.406 ps=3.38 w=1.4 l=0.6
X496 VSS bias_a x2_diff__cc3_0.x2_tail VSS sky130_fd_pr__nfet_01v8 ad=0.406 pd=3.38 as=0.406 ps=3.38 w=1.4 l=0.6
X497 x2_cl_casc__cc4_0.bias_c x2_cl_src__cc4_0.bias_b x2_cl_src__cc4_0.bias_b VSS sky130_fd_pr__nfet_01v8_lvt ad=0.406 pd=3.38 as=0.406 ps=3.38 w=1.4 l=0.6
X498 x2_cl_src__cc4_0.bias_b x2_cl_src__cc4_0.bias_b x2_cl_casc__cc4_0.bias_c VSS sky130_fd_pr__nfet_01v8_lvt ad=0.406 pd=3.38 as=0.406 ps=3.38 w=1.4 l=0.6
X499 on x2_cm_casc__cc3_0.bias_d x2_cm_tail__id6_0.x2_m3d VSS sky130_fd_pr__nfet_01v8 ad=0.406 pd=3.38 as=0.406 ps=3.38 w=1.4 l=0.6
X500 VSS VSS VSS VSS sky130_fd_pr__nfet_01v8 ad=0.406 pd=3.38 as=0 ps=0 w=1.4 l=0.6
X501 VSS bias_a x2_diff__cc3_0.x2_tail VSS sky130_fd_pr__nfet_01v8 ad=0.406 pd=3.38 as=0.406 ps=3.38 w=1.4 l=0.6
X502 x2_diff__cc3_0.x2_tail bias_a VSS VSS sky130_fd_pr__nfet_01v8 ad=0.406 pd=3.38 as=0.406 ps=3.38 w=1.4 l=0.6
X503 VSS IBIAS IBIAS VSS sky130_fd_pr__nfet_01v8 ad=0.406 pd=3.38 as=0.406 ps=3.38 w=1.4 l=0.6
X504 VSS cmc x2_diff__cc3_0.x2_tail VSS sky130_fd_pr__nfet_01v8 ad=0.406 pd=3.38 as=0.406 ps=3.38 w=1.4 l=0.6
X505 x2_diff__cc3_0.x2_tail cmc VSS VSS sky130_fd_pr__nfet_01v8 ad=0.406 pd=3.38 as=0.406 ps=3.38 w=1.4 l=0.6
X506 x2_cm_tail__id6_0.x2_m3d bias_a VSS VSS sky130_fd_pr__nfet_01v8 ad=0.406 pd=3.38 as=0.406 ps=3.38 w=1.4 l=0.6
X507 x2_cl_src__cc4_0.bias_b x2_cl_src__cc4_0.bias_b x2_cl_casc__cc4_0.bias_c VSS sky130_fd_pr__nfet_01v8_lvt ad=0.406 pd=3.38 as=0.406 ps=3.38 w=1.4 l=0.6
X508 x2_cm_tail__id6_0.x2_m4d x2_cm_casc__cc3_0.bias_d op VSS sky130_fd_pr__nfet_01v8 ad=0.406 pd=3.38 as=0.406 ps=3.38 w=1.4 l=0.6
X509 x2_diff__cc3_0.x2_tail cmc VSS VSS sky130_fd_pr__nfet_01v8 ad=0.406 pd=3.38 as=0.406 ps=3.38 w=1.4 l=0.6
X510 x2_cm_tail__id6_0.x2_m4d bias_a VSS VSS sky130_fd_pr__nfet_01v8 ad=0.406 pd=3.38 as=0.406 ps=3.38 w=1.4 l=0.6
X511 VSS IBIAS x2_cl_casc__cc4_0.bias_c VSS sky130_fd_pr__nfet_01v8 ad=0.406 pd=3.38 as=0.406 ps=3.38 w=1.4 l=0.6
X512 VDD x2_cl_src__cc4_0.bias_b x1_cm_bias_c__cc1_0.x1_m25d VDD sky130_fd_pr__pfet_01v8_lvt ad=0.406 pd=3.38 as=0.406 ps=3.38 w=1.4 l=0.6
X513 VSS VSS x2_cm_tail__id6_0.x2_m3d VSS sky130_fd_pr__nfet_01v8 ad=0.406 pd=3.38 as=0.406 ps=3.38 w=1.4 l=0.6
X514 x2_diff__cc3_0.x2_foldn in x2_diff__cc3_0.x2_tail VSS sky130_fd_pr__nfet_01v8_lvt ad=0.348 pd=2.98 as=0.348 ps=2.98 w=1.2 l=0.2
X515 op x2_cm_casc__cc3_0.bias_d x2_cm_tail__id6_0.x2_m4d VSS sky130_fd_pr__nfet_01v8 ad=0.406 pd=3.38 as=0.406 ps=3.38 w=1.4 l=0.6
X516 x2_cm_casc__cc3_0.bias_d x1_single_m3__f1_0.x1_m2d x1_single_m3__f1_0.x1_m2d VSS sky130_fd_pr__nfet_01v8 ad=0.406 pd=3.38 as=0.406 ps=3.38 w=1.4 l=0.6
X517 on cmc sky130_fd_pr__cap_mim_m3_1 l=4.8 w=4.8
X518 x2_diff__cc3_0.x2_foldn x2_cl_casc__cc4_0.bias_c op VDD sky130_fd_pr__pfet_01v8 ad=0.406 pd=3.38 as=0.406 ps=3.38 w=1.4 l=0.6
X519 on on on VSS sky130_fd_pr__nfet_01v8 ad=0.406 pd=3.38 as=0 ps=0 w=1.4 l=0.6
X520 VSS bias_a x2_cm_tail__id6_0.x2_m4d VSS sky130_fd_pr__nfet_01v8 ad=0.406 pd=3.38 as=0.406 ps=3.38 w=1.4 l=0.6
X521 VDD VDD x1_cm_bias_c__cc1_0.x1_m31d VDD sky130_fd_pr__pfet_01v8 ad=0.406 pd=3.38 as=0.406 ps=3.38 w=1.4 l=0.6
X522 VSS IBIAS IBIAS VSS sky130_fd_pr__nfet_01v8 ad=0.406 pd=3.38 as=0.406 ps=3.38 w=1.4 l=0.6
X523 x2_diff__cc3_0.x2_tail cmc VSS VSS sky130_fd_pr__nfet_01v8 ad=0.406 pd=3.38 as=0.406 ps=3.38 w=1.4 l=0.6
X524 x1_single_m5__f3_0.x1_m5d x2_cm_casc__cc3_0.bias_d bias_a VSS sky130_fd_pr__nfet_01v8 ad=0.406 pd=3.38 as=0.406 ps=3.38 w=1.4 l=0.6
X525 on x2_cm_casc__cc3_0.bias_d x2_cm_tail__id6_0.x2_m3d VSS sky130_fd_pr__nfet_01v8 ad=0.406 pd=3.38 as=0.406 ps=3.38 w=1.4 l=0.6
X526 x2_cm_tail__id6_0.x2_m4d bias_a VSS VSS sky130_fd_pr__nfet_01v8 ad=0.406 pd=3.38 as=0.406 ps=3.38 w=1.4 l=0.6
X527 VSS IBIAS x2_cl_casc__cc4_0.bias_c VSS sky130_fd_pr__nfet_01v8 ad=0.406 pd=3.38 as=0.406 ps=3.38 w=1.4 l=0.6
X528 VDD x2_cl_src__cc4_0.bias_b x2_diff__cc3_0.x2_foldp VDD sky130_fd_pr__pfet_01v8_lvt ad=0.406 pd=3.38 as=0.406 ps=3.38 w=1.4 l=0.6
X529 x2_diff__cc3_0.x2_tail bias_a VSS VSS sky130_fd_pr__nfet_01v8 ad=0.406 pd=3.38 as=0.406 ps=3.38 w=1.4 l=0.6
X530 VSS cmc x2_diff__cc3_0.x2_tail VSS sky130_fd_pr__nfet_01v8 ad=0.406 pd=3.38 as=0.406 ps=3.38 w=1.4 l=0.6
X531 x1_cm_bias_c__cc1_0.x1_m31d x2_cl_src__cc4_0.bias_b VDD VDD sky130_fd_pr__pfet_01v8_lvt ad=0.406 pd=3.38 as=0.406 ps=3.38 w=1.4 l=0.6
X532 x1_cm_bias_c__cc1_0.x1_m21d x2_cl_src__cc4_0.bias_b VDD VDD sky130_fd_pr__pfet_01v8_lvt ad=0.406 pd=3.38 as=0.406 ps=3.38 w=1.4 l=0.6
X533 x2_cl_src__cc4_0.bias_b x2_cl_src__cc4_0.bias_b x2_cl_casc__cc4_0.bias_c VSS sky130_fd_pr__nfet_01v8_lvt ad=0.406 pd=3.38 as=0.406 ps=3.38 w=1.4 l=0.6
X534 VSS bias_a x2_diff__cc3_0.x2_tail VSS sky130_fd_pr__nfet_01v8 ad=0.406 pd=3.38 as=0.406 ps=3.38 w=1.4 l=0.6
X535 x2_diff__cc3_0.x2_tail cmc VSS VSS sky130_fd_pr__nfet_01v8 ad=0.406 pd=3.38 as=0.406 ps=3.38 w=1.4 l=0.6
X536 x2_diff__cc3_0.x2_tail cmc VSS VSS sky130_fd_pr__nfet_01v8 ad=0.406 pd=3.38 as=0.406 ps=3.38 w=1.4 l=0.6
X537 x2_cm_tail__id6_0.x2_m3d x2_cm_casc__cc3_0.bias_d on VSS sky130_fd_pr__nfet_01v8 ad=0.406 pd=3.38 as=0.406 ps=3.38 w=1.4 l=0.6
X538 x2_cl_casc__cc4_0.bias_c x2_cl_src__cc4_0.bias_b x2_cl_src__cc4_0.bias_b VSS sky130_fd_pr__nfet_01v8_lvt ad=0.406 pd=3.38 as=0.406 ps=3.38 w=1.4 l=0.6
X539 x2_cm_tail__id6_0.x2_m4d x2_cm_casc__cc3_0.bias_d op VSS sky130_fd_pr__nfet_01v8 ad=0.406 pd=3.38 as=0.406 ps=3.38 w=1.4 l=0.6
X540 op cmc sky130_fd_pr__cap_mim_m3_1 l=4.8 w=4.8
X541 bias_a x2_cm_casc__cc3_0.bias_d x1_single_m5__f3_0.x1_m5d VSS sky130_fd_pr__nfet_01v8 ad=0.406 pd=3.38 as=0.406 ps=3.38 w=1.4 l=0.6
X542 IBIAS IBIAS VSS VSS sky130_fd_pr__nfet_01v8 ad=0.406 pd=3.38 as=0.406 ps=3.38 w=1.4 l=0.6
X543 x2_cm_casc__cc3_0.bias_d x2_cm_casc__cc3_0.bias_d x2_cm_casc__cc3_0.bias_d VSS sky130_fd_pr__nfet_01v8 ad=0.406 pd=3.38 as=0 ps=0 w=1.4 l=0.6
X544 VSS cmc x2_diff__cc3_0.x2_tail VSS sky130_fd_pr__nfet_01v8 ad=0.406 pd=3.38 as=0.406 ps=3.38 w=1.4 l=0.6
X545 x1_cm_bias_c__cc1_0.x1_m31d x2_cl_casc__cc4_0.bias_c cm VDD sky130_fd_pr__pfet_01v8 ad=0.406 pd=3.38 as=0.406 ps=3.38 w=1.4 l=0.6
X546 VDD x2_cl_src__cc4_0.bias_b x1_cm_bias_c__cc1_0.x1_m21d VDD sky130_fd_pr__pfet_01v8_lvt ad=0.406 pd=3.38 as=0.406 ps=3.38 w=1.4 l=0.6
X547 x2_cl_src__cc4_0.bias_b x2_cl_src__cc4_0.bias_b x2_cl_casc__cc4_0.bias_c VSS sky130_fd_pr__nfet_01v8_lvt ad=0.406 pd=3.38 as=0.406 ps=3.38 w=1.4 l=0.6
X548 x2_cm_tail__id6_0.x2_m4d bias_a VSS VSS sky130_fd_pr__nfet_01v8 ad=0.406 pd=3.38 as=0.406 ps=3.38 w=1.4 l=0.6
X549 x2_diff__cc3_0.x2_foldp x2_cl_src__cc4_0.bias_b VDD VDD sky130_fd_pr__pfet_01v8_lvt ad=0.406 pd=3.38 as=0.406 ps=3.38 w=1.4 l=0.6
X550 x1_single_m3__f1_0.x1_m2d x2_cl_casc__cc4_0.bias_c x1_cm_bias_c__cc1_0.x1_m25d VDD sky130_fd_pr__pfet_01v8 ad=0.406 pd=3.38 as=0.406 ps=3.38 w=1.4 l=0.6
X551 x2_diff__cc3_0.x2_tail cmc VSS VSS sky130_fd_pr__nfet_01v8 ad=0.406 pd=3.38 as=0.406 ps=3.38 w=1.4 l=0.6
X552 VSS cmc x2_diff__cc3_0.x2_tail VSS sky130_fd_pr__nfet_01v8 ad=0.406 pd=3.38 as=0.406 ps=3.38 w=1.4 l=0.6
X553 VSS bias_a x2_cm_tail__id6_0.x2_m3d VSS sky130_fd_pr__nfet_01v8 ad=0.406 pd=3.38 as=0.406 ps=3.38 w=1.4 l=0.6
X554 VSS VSS x2_cm_tail__id6_0.x2_m3d VSS sky130_fd_pr__nfet_01v8 ad=0.406 pd=3.38 as=0.406 ps=3.38 w=1.4 l=0.6
X555 IBIAS IBIAS VSS VSS sky130_fd_pr__nfet_01v8 ad=0.406 pd=3.38 as=0.406 ps=3.38 w=1.4 l=0.6
X556 x2_cm_casc__cc3_0.bias_d x1_single_m3__f1_0.x1_m2d x1_single_m3__f1_0.x1_m2d VSS sky130_fd_pr__nfet_01v8 ad=0.406 pd=3.38 as=0.406 ps=3.38 w=1.4 l=0.6
X557 on x2_cm_casc__cc3_0.bias_d x2_cm_tail__id6_0.x2_m3d VSS sky130_fd_pr__nfet_01v8 ad=0.406 pd=3.38 as=0.406 ps=3.38 w=1.4 l=0.6
X558 x2_diff__cc3_0.x2_tail bias_a VSS VSS sky130_fd_pr__nfet_01v8 ad=0.406 pd=3.38 as=0.406 ps=3.38 w=1.4 l=0.6
X559 VSS cmc x2_diff__cc3_0.x2_tail VSS sky130_fd_pr__nfet_01v8 ad=0.406 pd=3.38 as=0.406 ps=3.38 w=1.4 l=0.6
X560 IBIAS IBIAS VSS VSS sky130_fd_pr__nfet_01v8 ad=0.406 pd=3.38 as=0.406 ps=3.38 w=1.4 l=0.6
X561 VDD x2_cl_src__cc4_0.bias_b x2_diff__cc3_0.x2_foldp VDD sky130_fd_pr__pfet_01v8_lvt ad=0.406 pd=3.38 as=0.406 ps=3.38 w=1.4 l=0.6
X562 VSS VSS VSS VSS sky130_fd_pr__nfet_01v8 ad=0.406 pd=3.38 as=0 ps=0 w=1.4 l=0.6
X563 x2_cl_src__cc4_0.bias_b x2_cl_casc__cc4_0.bias_c x1_cm_bias_c__cc1_0.x1_m21d VDD sky130_fd_pr__pfet_01v8 ad=0.406 pd=3.38 as=0.406 ps=3.38 w=1.4 l=0.6
X564 x2_diff__cc3_0.x2_tail in x2_diff__cc3_0.x2_foldn VSS sky130_fd_pr__nfet_01v8_lvt ad=0.348 pd=2.98 as=0.348 ps=2.98 w=1.2 l=0.2
X565 cm cm cm VSS sky130_fd_pr__nfet_01v8 ad=0.406 pd=3.38 as=0 ps=0 w=1.4 l=0.6
X566 VDD x2_cl_src__cc4_0.bias_b x2_diff__cc3_0.x2_foldn VDD sky130_fd_pr__pfet_01v8_lvt ad=0.406 pd=3.38 as=0.406 ps=3.38 w=1.4 l=0.6
X567 VSS VSS VSS VSS sky130_fd_pr__nfet_01v8 ad=0.406 pd=3.38 as=0 ps=0 w=1.4 l=0.6
X568 x2_cm_casc__cc3_0.bias_d x1_single_m3__f1_0.x1_m2d x1_single_m3__f1_0.x1_m2d VSS sky130_fd_pr__nfet_01v8 ad=0.406 pd=3.38 as=0.406 ps=3.38 w=1.4 l=0.6
X569 VSS bias_a x2_cm_tail__id6_0.x2_m3d VSS sky130_fd_pr__nfet_01v8 ad=0.406 pd=3.38 as=0.406 ps=3.38 w=1.4 l=0.6
X570 VSS bias_a x1_single_m5__f3_0.x1_m5d VSS sky130_fd_pr__nfet_01v8 ad=0.406 pd=3.38 as=0.406 ps=3.38 w=1.4 l=0.6
X571 on x2_cm_casc__cc3_0.bias_d x2_cm_tail__id6_0.x2_m3d VSS sky130_fd_pr__nfet_01v8 ad=0.406 pd=3.38 as=0.406 ps=3.38 w=1.4 l=0.6
X572 VSS VSS VSS VSS sky130_fd_pr__nfet_01v8 ad=0.406 pd=3.38 as=0 ps=0 w=1.4 l=0.6
X573 x2_cm_tail__id6_0.x2_m4d bias_a VSS VSS sky130_fd_pr__nfet_01v8 ad=0.406 pd=3.38 as=0.406 ps=3.38 w=1.4 l=0.6
X574 x2_cl_src__cc4_0.bias_b x2_cl_src__cc4_0.bias_b x2_cl_casc__cc4_0.bias_c VSS sky130_fd_pr__nfet_01v8_lvt ad=0.406 pd=3.38 as=0.406 ps=3.38 w=1.4 l=0.6
X575 x2_diff__cc3_0.x2_tail bias_a VSS VSS sky130_fd_pr__nfet_01v8 ad=0.406 pd=3.38 as=0.406 ps=3.38 w=1.4 l=0.6
X576 VSS cmc x2_diff__cc3_0.x2_tail VSS sky130_fd_pr__nfet_01v8 ad=0.406 pd=3.38 as=0.406 ps=3.38 w=1.4 l=0.6
X577 VSS bias_a x2_cm_tail__id6_0.x2_m3d VSS sky130_fd_pr__nfet_01v8 ad=0.406 pd=3.38 as=0.406 ps=3.38 w=1.4 l=0.6
X578 VSS bias_a x2_diff__cc3_0.x2_tail VSS sky130_fd_pr__nfet_01v8 ad=0.406 pd=3.38 as=0.406 ps=3.38 w=1.4 l=0.6
X579 VSS IBIAS IBIAS VSS sky130_fd_pr__nfet_01v8 ad=0.406 pd=3.38 as=0.406 ps=3.38 w=1.4 l=0.6
X580 VSS bias_a x2_diff__cc3_0.x2_tail VSS sky130_fd_pr__nfet_01v8 ad=0.406 pd=3.38 as=0.406 ps=3.38 w=1.4 l=0.6
X581 x2_diff__cc3_0.x2_foldp x2_cl_casc__cc4_0.bias_c on VDD sky130_fd_pr__pfet_01v8 ad=0.406 pd=3.38 as=0.406 ps=3.38 w=1.4 l=0.6
X582 x2_diff__cc3_0.x2_foldn x2_cl_src__cc4_0.bias_b VDD VDD sky130_fd_pr__pfet_01v8_lvt ad=0.406 pd=3.38 as=0.406 ps=3.38 w=1.4 l=0.6
X583 x2_cm_casc__cc3_0.bias_d x1_single_m3__f1_0.x1_m2d x1_single_m3__f1_0.x1_m2d VSS sky130_fd_pr__nfet_01v8 ad=0.406 pd=3.38 as=0.406 ps=3.38 w=1.4 l=0.6
X584 x2_diff__cc3_0.x2_tail cmc VSS VSS sky130_fd_pr__nfet_01v8 ad=0.406 pd=3.38 as=0.406 ps=3.38 w=1.4 l=0.6
X585 VSS bias_a x1_single_m5__f3_0.x1_m5d VSS sky130_fd_pr__nfet_01v8 ad=0.406 pd=3.38 as=0.406 ps=3.38 w=1.4 l=0.6
X586 x2_diff__cc3_0.x2_tail x2_diff__cc3_0.x2_tail x2_diff__cc3_0.x2_tail VSS sky130_fd_pr__nfet_01v8 ad=0.406 pd=3.38 as=0 ps=0 w=1.4 l=0.6
X587 x1_cm_bias_c__cc1_0.x1_m31d x1_cm_bias_c__cc1_0.x1_m31d x1_cm_bias_c__cc1_0.x1_m31d VDD sky130_fd_pr__pfet_01v8_lvt ad=0.406 pd=3.38 as=7.308 ps=60.84 w=1.4 l=0.6
X588 x1_cm_bias_c__cc1_0.x1_m25d x2_cl_src__cc4_0.bias_b VDD VDD sky130_fd_pr__pfet_01v8_lvt ad=0.406 pd=3.38 as=0.406 ps=3.38 w=1.4 l=0.6
X589 x2_diff__cc3_0.x2_tail bias_a VSS VSS sky130_fd_pr__nfet_01v8 ad=0.406 pd=3.38 as=0.406 ps=3.38 w=1.4 l=0.6
X590 x2_diff__cc3_0.x2_tail cmc VSS VSS sky130_fd_pr__nfet_01v8 ad=0.406 pd=3.38 as=0.406 ps=3.38 w=1.4 l=0.6
X591 VSS cmc x2_diff__cc3_0.x2_tail VSS sky130_fd_pr__nfet_01v8 ad=0.406 pd=3.38 as=0.406 ps=3.38 w=1.4 l=0.6
X592 x1_single_m3__f1_0.x1_m2d x1_single_m3__f1_0.x1_m2d x2_cm_casc__cc3_0.bias_d VSS sky130_fd_pr__nfet_01v8 ad=0.406 pd=3.38 as=0.406 ps=3.38 w=1.4 l=0.6
X593 VDD VDD VDD VDD sky130_fd_pr__pfet_01v8 ad=0.406 pd=3.38 as=0 ps=0 w=1.4 l=0.6
X594 x2_cl_casc__cc4_0.bias_c x2_cl_src__cc4_0.bias_b x2_cl_src__cc4_0.bias_b VSS sky130_fd_pr__nfet_01v8_lvt ad=0.406 pd=3.38 as=0.406 ps=3.38 w=1.4 l=0.6
X595 x2_diff__cc3_0.x2_tail cmc VSS VSS sky130_fd_pr__nfet_01v8 ad=0.406 pd=3.38 as=0.406 ps=3.38 w=1.4 l=0.6
X596 VDD VDD x2_diff__cc3_0.x2_foldn VDD sky130_fd_pr__pfet_01v8 ad=0.406 pd=3.38 as=0.406 ps=3.38 w=1.4 l=0.6
X597 VDD x2_cl_src__cc4_0.bias_b x2_diff__cc3_0.x2_foldn VDD sky130_fd_pr__pfet_01v8_lvt ad=0.406 pd=3.38 as=0.406 ps=3.38 w=1.4 l=0.6
X598 VDD x2_cl_src__cc4_0.bias_b x1_cm_bias_c__cc1_0.x1_m31d VDD sky130_fd_pr__pfet_01v8_lvt ad=0.406 pd=3.38 as=0.406 ps=3.38 w=1.4 l=0.6
X599 x2_cl_casc__cc4_0.bias_c IBIAS VSS VSS sky130_fd_pr__nfet_01v8 ad=0.406 pd=3.38 as=0.406 ps=3.38 w=1.4 l=0.6
X600 VSS cmc x2_diff__cc3_0.x2_tail VSS sky130_fd_pr__nfet_01v8 ad=0.406 pd=3.38 as=0.406 ps=3.38 w=1.4 l=0.6
X601 x2_diff__cc3_0.x2_tail x2_diff__cc3_0.x2_tail x2_diff__cc3_0.x2_tail VSS sky130_fd_pr__nfet_01v8 ad=0.406 pd=3.38 as=0 ps=0 w=1.4 l=0.6
X602 cm x2_cl_casc__cc4_0.bias_c x1_cm_bias_c__cc1_0.x1_m31d VDD sky130_fd_pr__pfet_01v8 ad=0.406 pd=3.38 as=0.406 ps=3.38 w=1.4 l=0.6
X603 VDD x2_cl_src__cc4_0.bias_b x2_diff__cc3_0.x2_foldp VDD sky130_fd_pr__pfet_01v8_lvt ad=0.406 pd=3.38 as=0.406 ps=3.38 w=1.4 l=0.6
X604 x1_single_m5__f3_0.x1_m5d x2_cm_casc__cc3_0.bias_d bias_a VSS sky130_fd_pr__nfet_01v8 ad=0.406 pd=3.38 as=0.406 ps=3.38 w=1.4 l=0.6
X605 VSS IBIAS IBIAS VSS sky130_fd_pr__nfet_01v8 ad=0.406 pd=3.38 as=0.406 ps=3.38 w=1.4 l=0.6
X606 VDD VDD x2_cl_src__cc4_0.bias_b VDD sky130_fd_pr__pfet_01v8 ad=0.406 pd=3.38 as=0.406 ps=3.38 w=1.4 l=0.6
X607 x2_cm_tail__id6_0.x2_m3d bias_a VSS VSS sky130_fd_pr__nfet_01v8 ad=0.406 pd=3.38 as=0.406 ps=3.38 w=1.4 l=0.6
X608 VSS bias_a x2_diff__cc3_0.x2_tail VSS sky130_fd_pr__nfet_01v8 ad=0.406 pd=3.38 as=0.406 ps=3.38 w=1.4 l=0.6
X609 x2_diff__cc3_0.x2_foldp x2_cl_casc__cc4_0.bias_c on VDD sky130_fd_pr__pfet_01v8 ad=0.406 pd=3.38 as=0.406 ps=3.38 w=1.4 l=0.6
X610 x2_cm_tail__id6_0.x2_m3d x2_cm_casc__cc3_0.bias_d on VSS sky130_fd_pr__nfet_01v8 ad=0.406 pd=3.38 as=0.406 ps=3.38 w=1.4 l=0.6
X611 x1_single_m5__f3_0.x1_m5d x2_cm_casc__cc3_0.bias_d bias_a VSS sky130_fd_pr__nfet_01v8 ad=0.406 pd=3.38 as=0.406 ps=3.38 w=1.4 l=0.6
X612 VSS cmc x2_diff__cc3_0.x2_tail VSS sky130_fd_pr__nfet_01v8 ad=0.406 pd=3.38 as=0.406 ps=3.38 w=1.4 l=0.6
X613 VSS bias_a x2_cm_tail__id6_0.x2_m3d VSS sky130_fd_pr__nfet_01v8 ad=0.406 pd=3.38 as=0.406 ps=3.38 w=1.4 l=0.6
X614 x1_single_m3__f1_0.x1_m2d x1_single_m3__f1_0.x1_m2d x2_cm_casc__cc3_0.bias_d VSS sky130_fd_pr__nfet_01v8 ad=0.406 pd=3.38 as=0.406 ps=3.38 w=1.4 l=0.6
X615 x2_cl_src__cc4_0.bias_b x2_cl_casc__cc4_0.bias_c x1_cm_bias_c__cc1_0.x1_m21d VDD sky130_fd_pr__pfet_01v8 ad=0.406 pd=3.38 as=0.406 ps=3.38 w=1.4 l=0.6
X616 x2_diff__cc3_0.x2_foldn x2_diff__cc3_0.x2_foldn x2_diff__cc3_0.x2_foldn VSS sky130_fd_pr__nfet_01v8_lvt ad=0.348 pd=2.98 as=0 ps=0 w=1.2 l=0.2
X617 x2_cm_casc__cc3_0.bias_d x1_single_m3__f1_0.x1_m2d x1_single_m3__f1_0.x1_m2d VSS sky130_fd_pr__nfet_01v8 ad=0.406 pd=3.38 as=0.406 ps=3.38 w=1.4 l=0.6
X618 x2_diff__cc3_0.x2_foldn x2_diff__cc3_0.x2_foldn x2_diff__cc3_0.x2_foldn VDD sky130_fd_pr__pfet_01v8 ad=0.406 pd=3.38 as=0 ps=0 w=1.4 l=0.6
X619 x2_cl_casc__cc4_0.bias_c x2_cl_src__cc4_0.bias_b x2_cl_src__cc4_0.bias_b VSS sky130_fd_pr__nfet_01v8_lvt ad=0.406 pd=3.38 as=0.406 ps=3.38 w=1.4 l=0.6
X620 x1_cc_cm__strings1_0.x1_net6 cm VSS VSS sky130_fd_pr__nfet_01v8 ad=0.406 pd=3.38 as=0.406 ps=3.38 w=1.4 l=0.6
X621 VSS VSS x2_cm_tail__id6_0.x2_m3d VSS sky130_fd_pr__nfet_01v8 ad=0.406 pd=3.38 as=0.406 ps=3.38 w=1.4 l=0.6
X622 x2_cm_tail__id6_0.x2_m3d x2_cm_casc__cc3_0.bias_d on VSS sky130_fd_pr__nfet_01v8 ad=0.406 pd=3.38 as=0.406 ps=3.38 w=1.4 l=0.6
X623 bias_a x2_cm_casc__cc3_0.bias_d x1_single_m5__f3_0.x1_m5d VSS sky130_fd_pr__nfet_01v8 ad=0.406 pd=3.38 as=0.406 ps=3.38 w=1.4 l=0.6
X624 x2_cl_casc__cc4_0.bias_c IBIAS VSS VSS sky130_fd_pr__nfet_01v8 ad=0.406 pd=3.38 as=0.406 ps=3.38 w=1.4 l=0.6
X625 x2_cm_casc__cc3_0.bias_d x2_cm_casc__cc3_0.bias_d x2_cm_casc__cc3_0.bias_d VSS sky130_fd_pr__nfet_01v8 ad=0.406 pd=3.38 as=0 ps=0 w=1.4 l=0.6
X626 x2_diff__cc3_0.x2_foldn x2_cl_src__cc4_0.bias_b VDD VDD sky130_fd_pr__pfet_01v8_lvt ad=0.406 pd=3.38 as=0.406 ps=3.38 w=1.4 l=0.6
X627 bias_a x2_cm_casc__cc3_0.bias_d x1_single_m5__f3_0.x1_m5d VSS sky130_fd_pr__nfet_01v8 ad=0.406 pd=3.38 as=0.406 ps=3.38 w=1.4 l=0.6
X628 VSS bias_a x2_cm_tail__id6_0.x2_m4d VSS sky130_fd_pr__nfet_01v8 ad=0.406 pd=3.38 as=0.406 ps=3.38 w=1.4 l=0.6
X629 VDD VDD VDD VDD sky130_fd_pr__pfet_01v8_lvt ad=0.406 pd=3.38 as=0 ps=0 w=1.4 l=0.6
X630 VDD VDD VDD VDD sky130_fd_pr__pfet_01v8 ad=0.406 pd=3.38 as=0 ps=0 w=1.4 l=0.6
X631 VDD VDD op VDD sky130_fd_pr__pfet_01v8 ad=0.406 pd=3.38 as=0.406 ps=3.38 w=1.4 l=0.6
X632 x2_diff__cc3_0.x2_tail cmc VSS VSS sky130_fd_pr__nfet_01v8 ad=0.406 pd=3.38 as=0.406 ps=3.38 w=1.4 l=0.6
X633 VSS cmc x2_diff__cc3_0.x2_tail VSS sky130_fd_pr__nfet_01v8 ad=0.406 pd=3.38 as=0.406 ps=3.38 w=1.4 l=0.6
X634 x2_diff__cc3_0.x2_foldn x2_cl_casc__cc4_0.bias_c op VDD sky130_fd_pr__pfet_01v8 ad=0.406 pd=3.38 as=0.406 ps=3.38 w=1.4 l=0.6
X635 x1_cm_bias_c__cc1_0.x1_m21d x2_cl_src__cc4_0.bias_b VDD VDD sky130_fd_pr__pfet_01v8_lvt ad=0.406 pd=3.38 as=0.406 ps=3.38 w=1.4 l=0.6
X636 VSS VSS VSS VSS sky130_fd_pr__nfet_01v8 ad=0.406 pd=3.38 as=0 ps=0 w=1.4 l=0.6
X637 x2_diff__cc3_0.x2_tail bias_a VSS VSS sky130_fd_pr__nfet_01v8 ad=0.406 pd=3.38 as=0.406 ps=3.38 w=1.4 l=0.6
X638 VSS cmc x2_diff__cc3_0.x2_tail VSS sky130_fd_pr__nfet_01v8 ad=0.406 pd=3.38 as=0.406 ps=3.38 w=1.4 l=0.6
X639 x2_cl_src__cc4_0.bias_b x2_cl_src__cc4_0.bias_b x2_cl_casc__cc4_0.bias_c VSS sky130_fd_pr__nfet_01v8_lvt ad=0.406 pd=3.38 as=0.406 ps=3.38 w=1.4 l=0.6
X640 cm x2_cl_casc__cc4_0.bias_c x1_cm_bias_c__cc1_0.x1_m31d VDD sky130_fd_pr__pfet_01v8 ad=0.406 pd=3.38 as=0.406 ps=3.38 w=1.4 l=0.6
X641 VSS bias_a x1_single_m5__f3_0.x1_m5d VSS sky130_fd_pr__nfet_01v8 ad=0.406 pd=3.38 as=0.406 ps=3.38 w=1.4 l=0.6
X642 x1_single_m5__f3_0.x1_m5d x1_single_m5__f3_0.x1_m5d x1_single_m5__f3_0.x1_m5d VSS sky130_fd_pr__nfet_01v8 ad=0.406 pd=3.38 as=0 ps=0 w=1.4 l=0.6
X643 x2_diff__cc3_0.x2_tail bias_a VSS VSS sky130_fd_pr__nfet_01v8 ad=0.406 pd=3.38 as=0.406 ps=3.38 w=1.4 l=0.6
X644 x2_diff__cc3_0.x2_foldn x2_cl_src__cc4_0.bias_b VDD VDD sky130_fd_pr__pfet_01v8_lvt ad=0.406 pd=3.38 as=0.406 ps=3.38 w=1.4 l=0.6
X645 VDD VDD cm VDD sky130_fd_pr__pfet_01v8 ad=0.406 pd=3.38 as=0.406 ps=3.38 w=1.4 l=0.6
X646 x2_cl_src__cc4_0.bias_b x2_cl_src__cc4_0.bias_b x2_cl_casc__cc4_0.bias_c VSS sky130_fd_pr__nfet_01v8_lvt ad=0.406 pd=3.38 as=0.406 ps=3.38 w=1.4 l=0.6
X647 op x2_cm_casc__cc3_0.bias_d x2_cm_tail__id6_0.x2_m4d VSS sky130_fd_pr__nfet_01v8 ad=0.406 pd=3.38 as=0.406 ps=3.38 w=1.4 l=0.6
X648 x2_cl_casc__cc4_0.bias_c IBIAS VSS VSS sky130_fd_pr__nfet_01v8 ad=0.406 pd=3.38 as=0.406 ps=3.38 w=1.4 l=0.6
X649 x2_diff__cc3_0.x2_tail cmc VSS VSS sky130_fd_pr__nfet_01v8 ad=0.406 pd=3.38 as=0.406 ps=3.38 w=1.4 l=0.6
X650 x2_diff__cc3_0.x2_foldp x2_cl_casc__cc4_0.bias_c on VDD sky130_fd_pr__pfet_01v8 ad=0.406 pd=3.38 as=0.406 ps=3.38 w=1.4 l=0.6
X651 x1_single_m5__f3_0.x1_m5d x1_single_m5__f3_0.x1_m5d x1_single_m5__f3_0.x1_m5d VSS sky130_fd_pr__nfet_01v8 ad=0.406 pd=3.38 as=0 ps=0 w=1.4 l=0.6
X652 x2_cm_tail__id6_0.x2_m4d x2_cm_casc__cc3_0.bias_d op VSS sky130_fd_pr__nfet_01v8 ad=0.406 pd=3.38 as=0.406 ps=3.38 w=1.4 l=0.6
X653 x2_cm_casc__cc3_0.bias_d x1_single_m3__f1_0.x1_m2d x1_single_m3__f1_0.x1_m2d VSS sky130_fd_pr__nfet_01v8 ad=0.406 pd=3.38 as=0.406 ps=3.38 w=1.4 l=0.6
X654 x2_cl_src__cc4_0.bias_b x2_cl_src__cc4_0.bias_b x2_cl_casc__cc4_0.bias_c VSS sky130_fd_pr__nfet_01v8_lvt ad=0.406 pd=3.38 as=0.406 ps=3.38 w=1.4 l=0.6
X655 on x2_cm_casc__cc3_0.bias_d x2_cm_tail__id6_0.x2_m3d VSS sky130_fd_pr__nfet_01v8 ad=0.406 pd=3.38 as=0.406 ps=3.38 w=1.4 l=0.6
X656 x1_single_m3__f1_0.x1_m2d x1_single_m3__f1_0.x1_m2d x2_cm_casc__cc3_0.bias_d VSS sky130_fd_pr__nfet_01v8 ad=0.406 pd=3.38 as=0.406 ps=3.38 w=1.4 l=0.6
X657 VSS cmc x2_diff__cc3_0.x2_tail VSS sky130_fd_pr__nfet_01v8 ad=0.406 pd=3.38 as=0.406 ps=3.38 w=1.4 l=0.6
X658 VSS VSS VSS VSS sky130_fd_pr__nfet_01v8 ad=0.406 pd=3.38 as=0 ps=0 w=1.4 l=0.6
X659 x2_cm_tail__id6_0.x2_m3d x2_cm_casc__cc3_0.bias_d on VSS sky130_fd_pr__nfet_01v8 ad=0.406 pd=3.38 as=0.406 ps=3.38 w=1.4 l=0.6
X660 x2_cm_casc__cc3_0.bias_d x1_single_m3__f1_0.x1_m2d x1_single_m3__f1_0.x1_m2d VSS sky130_fd_pr__nfet_01v8 ad=0.406 pd=3.38 as=0.406 ps=3.38 w=1.4 l=0.6
X661 VDD VDD VDD VDD sky130_fd_pr__pfet_01v8_lvt ad=0.406 pd=3.38 as=0 ps=0 w=1.4 l=0.6
X662 x2_cl_casc__cc4_0.bias_c x2_cl_src__cc4_0.bias_b x2_cl_src__cc4_0.bias_b VSS sky130_fd_pr__nfet_01v8_lvt ad=0.406 pd=3.38 as=0.406 ps=3.38 w=1.4 l=0.6
X663 x2_cl_src__cc4_0.bias_b x2_cl_src__cc4_0.bias_b x2_cl_casc__cc4_0.bias_c VSS sky130_fd_pr__nfet_01v8_lvt ad=0.406 pd=3.38 as=0.406 ps=3.38 w=1.4 l=0.6
X664 op x2_cm_casc__cc3_0.bias_d x2_cm_tail__id6_0.x2_m4d VSS sky130_fd_pr__nfet_01v8 ad=0.406 pd=3.38 as=0.406 ps=3.38 w=1.4 l=0.6
X665 VSS VSS VSS VSS sky130_fd_pr__nfet_01v8 ad=0.406 pd=3.38 as=0 ps=0 w=1.4 l=0.6
X666 VSS cmc x2_diff__cc3_0.x2_tail VSS sky130_fd_pr__nfet_01v8 ad=0.406 pd=3.38 as=0.406 ps=3.38 w=1.4 l=0.6
X667 x2_diff__cc3_0.x2_tail cmc VSS VSS sky130_fd_pr__nfet_01v8 ad=0.406 pd=3.38 as=0.406 ps=3.38 w=1.4 l=0.6
X668 VSS IBIAS x2_cl_casc__cc4_0.bias_c VSS sky130_fd_pr__nfet_01v8 ad=0.406 pd=3.38 as=0.406 ps=3.38 w=1.4 l=0.6
X669 VSS bias_a x1_single_m5__f3_0.x1_m5d VSS sky130_fd_pr__nfet_01v8 ad=0.406 pd=3.38 as=0.406 ps=3.38 w=1.4 l=0.6
X670 VSS cmc x2_diff__cc3_0.x2_tail VSS sky130_fd_pr__nfet_01v8 ad=0.406 pd=3.38 as=0.406 ps=3.38 w=1.4 l=0.6
X671 x2_diff__cc3_0.x2_tail bias_a VSS VSS sky130_fd_pr__nfet_01v8 ad=0.406 pd=3.38 as=0.406 ps=3.38 w=1.4 l=0.6
X672 VSS VSS x2_cm_tail__id6_0.x2_m3d VSS sky130_fd_pr__nfet_01v8 ad=0.406 pd=3.38 as=0.406 ps=3.38 w=1.4 l=0.6
X673 x2_diff__cc3_0.x2_tail cmc VSS VSS sky130_fd_pr__nfet_01v8 ad=0.406 pd=3.38 as=0.406 ps=3.38 w=1.4 l=0.6
X674 VDD VDD VDD VDD sky130_fd_pr__pfet_01v8_lvt ad=0.406 pd=3.38 as=0 ps=0 w=1.4 l=0.6
X675 op cmc sky130_fd_pr__cap_mim_m3_1 l=4.8 w=4.8
X676 x2_diff__cc3_0.x2_tail cmc VSS VSS sky130_fd_pr__nfet_01v8 ad=0.406 pd=3.38 as=0.406 ps=3.38 w=1.4 l=0.6
X677 x2_diff__cc3_0.x2_tail bias_a VSS VSS sky130_fd_pr__nfet_01v8 ad=0.406 pd=3.38 as=0.406 ps=3.38 w=1.4 l=0.6
X678 VSS bias_a x2_diff__cc3_0.x2_tail VSS sky130_fd_pr__nfet_01v8 ad=0.406 pd=3.38 as=0.406 ps=3.38 w=1.4 l=0.6
X679 VSS bias_a x1_single_m5__f3_0.x1_m5d VSS sky130_fd_pr__nfet_01v8 ad=0.406 pd=3.38 as=0.406 ps=3.38 w=1.4 l=0.6
X680 x2_diff__cc3_0.x2_tail bias_a VSS VSS sky130_fd_pr__nfet_01v8 ad=0.406 pd=3.38 as=0.406 ps=3.38 w=1.4 l=0.6
X681 on x2_cm_casc__cc3_0.bias_d x2_cm_tail__id6_0.x2_m3d VSS sky130_fd_pr__nfet_01v8 ad=0.406 pd=3.38 as=0.406 ps=3.38 w=1.4 l=0.6
X682 VSS bias_a x2_cm_tail__id6_0.x2_m3d VSS sky130_fd_pr__nfet_01v8 ad=0.406 pd=3.38 as=0.406 ps=3.38 w=1.4 l=0.6
X683 x2_diff__cc3_0.x2_tail cmc VSS VSS sky130_fd_pr__nfet_01v8 ad=0.406 pd=3.38 as=0.406 ps=3.38 w=1.4 l=0.6
X684 x2_diff__cc3_0.x2_foldn x2_cl_casc__cc4_0.bias_c op VDD sky130_fd_pr__pfet_01v8 ad=0.406 pd=3.38 as=0.406 ps=3.38 w=1.4 l=0.6
X685 x2_cm_tail__id6_0.x2_m4d bias_a VSS VSS sky130_fd_pr__nfet_01v8 ad=0.406 pd=3.38 as=0.406 ps=3.38 w=1.4 l=0.6
X686 x1_cm_bias_c__cc1_0.x1_m25d x1_cm_bias_c__cc1_0.x1_m25d x1_cm_bias_c__cc1_0.x1_m25d VDD sky130_fd_pr__pfet_01v8_lvt ad=0.406 pd=3.38 as=0 ps=0 w=1.4 l=0.6
X687 VDD x2_cl_src__cc4_0.bias_b x2_diff__cc3_0.x2_foldn VDD sky130_fd_pr__pfet_01v8_lvt ad=0.406 pd=3.38 as=0.406 ps=3.38 w=1.4 l=0.6
X688 on x2_cl_casc__cc4_0.bias_c x2_diff__cc3_0.x2_foldp VDD sky130_fd_pr__pfet_01v8 ad=0.406 pd=3.38 as=0.406 ps=3.38 w=1.4 l=0.6
X689 VSS VSS on VSS sky130_fd_pr__nfet_01v8 ad=0.406 pd=3.38 as=0.406 ps=3.38 w=1.4 l=0.6
X690 VSS bias_a x2_cm_tail__id6_0.x2_m3d VSS sky130_fd_pr__nfet_01v8 ad=0.406 pd=3.38 as=0.406 ps=3.38 w=1.4 l=0.6
X691 VSS IBIAS x2_cl_casc__cc4_0.bias_c VSS sky130_fd_pr__nfet_01v8 ad=0.406 pd=3.38 as=0.406 ps=3.38 w=1.4 l=0.6
X692 VSS bias_a x2_cm_tail__id6_0.x2_m4d VSS sky130_fd_pr__nfet_01v8 ad=0.406 pd=3.38 as=0.406 ps=3.38 w=1.4 l=0.6
X693 x2_cm_tail__id6_0.x2_m4d bias_a VSS VSS sky130_fd_pr__nfet_01v8 ad=0.406 pd=3.38 as=0.406 ps=3.38 w=1.4 l=0.6
X694 x2_cm_tail__id6_0.x2_m4d x2_cm_casc__cc3_0.bias_d op VSS sky130_fd_pr__nfet_01v8 ad=0.406 pd=3.38 as=0.406 ps=3.38 w=1.4 l=0.6
X695 x1_single_m5__f3_0.x1_m5d x2_cm_casc__cc3_0.bias_d bias_a VSS sky130_fd_pr__nfet_01v8 ad=0.406 pd=3.38 as=0.406 ps=3.38 w=1.4 l=0.6
X696 x2_diff__cc3_0.x2_tail bias_a VSS VSS sky130_fd_pr__nfet_01v8 ad=0.406 pd=3.38 as=0.406 ps=3.38 w=1.4 l=0.6
X697 x2_cl_casc__cc4_0.bias_c x2_cl_casc__cc4_0.bias_c x2_cl_casc__cc4_0.bias_c VSS sky130_fd_pr__nfet_01v8 ad=0.406 pd=3.38 as=0 ps=0 w=1.4 l=0.6
X698 x2_cm_casc__cc3_0.bias_d x2_cm_casc__cc3_0.bias_d x2_cm_casc__cc3_0.bias_d VSS sky130_fd_pr__nfet_01v8 ad=0.406 pd=3.38 as=0 ps=0 w=1.4 l=0.6
X699 x2_cl_casc__cc4_0.bias_c x2_cl_src__cc4_0.bias_b x2_cl_src__cc4_0.bias_b VSS sky130_fd_pr__nfet_01v8_lvt ad=0.406 pd=3.38 as=0.406 ps=3.38 w=1.4 l=0.6
X700 x2_diff__cc3_0.x2_tail ip x2_diff__cc3_0.x2_foldp VSS sky130_fd_pr__nfet_01v8_lvt ad=0.348 pd=2.98 as=0.348 ps=2.98 w=1.2 l=0.2
X701 x2_diff__cc3_0.x2_tail cmc VSS VSS sky130_fd_pr__nfet_01v8 ad=0.406 pd=3.38 as=0.406 ps=3.38 w=1.4 l=0.6
X702 VSS bias_a x2_cm_tail__id6_0.x2_m4d VSS sky130_fd_pr__nfet_01v8 ad=0.406 pd=3.38 as=0.406 ps=3.38 w=1.4 l=0.6
X703 x1_cm_bias_c__cc1_0.x1_m21d x1_cm_bias_c__cc1_0.x1_m21d x1_cm_bias_c__cc1_0.x1_m21d VDD sky130_fd_pr__pfet_01v8 ad=0.406 pd=3.38 as=0 ps=0 w=1.4 l=0.6
X704 x2_cl_src__cc4_0.bias_b x2_cl_src__cc4_0.bias_b x2_cl_casc__cc4_0.bias_c VSS sky130_fd_pr__nfet_01v8_lvt ad=0.406 pd=3.38 as=0.406 ps=3.38 w=1.4 l=0.6
X705 x2_cm_casc__cc3_0.bias_d x1_single_m3__f1_0.x1_m2d x1_single_m3__f1_0.x1_m2d VSS sky130_fd_pr__nfet_01v8 ad=0.406 pd=3.38 as=0.406 ps=3.38 w=1.4 l=0.6
X706 x1_cm_bias_c__cc1_0.x1_m25d x2_cl_src__cc4_0.bias_b VDD VDD sky130_fd_pr__pfet_01v8_lvt ad=0.406 pd=3.38 as=0.406 ps=3.38 w=1.4 l=0.6
X707 VSS cmc x2_diff__cc3_0.x2_tail VSS sky130_fd_pr__nfet_01v8 ad=0.406 pd=3.38 as=0.406 ps=3.38 w=1.4 l=0.6
X708 VDD VDD VDD VDD sky130_fd_pr__pfet_01v8_lvt ad=0.406 pd=3.38 as=0 ps=0 w=1.4 l=0.6
X709 x2_diff__cc3_0.x2_foldp x2_cl_src__cc4_0.bias_b VDD VDD sky130_fd_pr__pfet_01v8_lvt ad=0.406 pd=3.38 as=0.406 ps=3.38 w=1.4 l=0.6
X710 x2_cm_tail__id6_0.x2_m4d x2_cm_casc__cc3_0.bias_d op VSS sky130_fd_pr__nfet_01v8 ad=0.406 pd=3.38 as=0.406 ps=3.38 w=1.4 l=0.6
X711 x2_cm_tail__id6_0.x2_m4d x2_cm_casc__cc3_0.bias_d op VSS sky130_fd_pr__nfet_01v8 ad=0.406 pd=3.38 as=0.406 ps=3.38 w=1.4 l=0.6
X712 bias_a x2_cm_casc__cc3_0.bias_d x1_single_m5__f3_0.x1_m5d VSS sky130_fd_pr__nfet_01v8 ad=0.406 pd=3.38 as=0.406 ps=3.38 w=1.4 l=0.6
X713 VSS bias_a x2_cm_tail__id6_0.x2_m3d VSS sky130_fd_pr__nfet_01v8 ad=0.406 pd=3.38 as=0.406 ps=3.38 w=1.4 l=0.6
X714 x2_cl_casc__cc4_0.bias_c IBIAS VSS VSS sky130_fd_pr__nfet_01v8 ad=0.406 pd=3.38 as=0.406 ps=3.38 w=1.4 l=0.6
X715 x2_diff__cc3_0.x2_foldn in x2_diff__cc3_0.x2_tail VSS sky130_fd_pr__nfet_01v8_lvt ad=0.348 pd=2.98 as=0.348 ps=2.98 w=1.2 l=0.2
X716 VSS bias_a x2_diff__cc3_0.x2_tail VSS sky130_fd_pr__nfet_01v8 ad=0.406 pd=3.38 as=0.406 ps=3.38 w=1.4 l=0.6
X717 x2_diff__cc3_0.x2_foldp x2_cl_src__cc4_0.bias_b VDD VDD sky130_fd_pr__pfet_01v8_lvt ad=0.406 pd=3.38 as=0.406 ps=3.38 w=1.4 l=0.6
X718 VSS VSS VSS VSS sky130_fd_pr__nfet_01v8 ad=0.406 pd=3.38 as=0 ps=0 w=1.4 l=0.6
X719 x2_cm_tail__id6_0.x2_m3d bias_a VSS VSS sky130_fd_pr__nfet_01v8 ad=0.406 pd=3.38 as=0.406 ps=3.38 w=1.4 l=0.6
X720 VSS cmc x2_diff__cc3_0.x2_tail VSS sky130_fd_pr__nfet_01v8 ad=0.406 pd=3.38 as=0.406 ps=3.38 w=1.4 l=0.6
X721 x2_diff__cc3_0.x2_foldn x2_cl_casc__cc4_0.bias_c op VDD sky130_fd_pr__pfet_01v8 ad=0.406 pd=3.38 as=0.406 ps=3.38 w=1.4 l=0.6
X722 VSS VSS VSS VSS sky130_fd_pr__nfet_01v8 ad=0.406 pd=3.38 as=0 ps=0 w=1.4 l=0.6
X723 x2_diff__cc3_0.x2_tail cmc VSS VSS sky130_fd_pr__nfet_01v8 ad=0.406 pd=3.38 as=0.406 ps=3.38 w=1.4 l=0.6
X724 VSS VSS on VSS sky130_fd_pr__nfet_01v8 ad=0.406 pd=3.38 as=0.406 ps=3.38 w=1.4 l=0.6
X725 x2_diff__cc3_0.x2_foldp ip x2_diff__cc3_0.x2_tail VSS sky130_fd_pr__nfet_01v8_lvt ad=0.348 pd=2.98 as=0.348 ps=2.98 w=1.2 l=0.2
X726 x2_cl_src__cc4_0.bias_b x2_cl_src__cc4_0.bias_b x2_cl_casc__cc4_0.bias_c VSS sky130_fd_pr__nfet_01v8_lvt ad=0.406 pd=3.38 as=0.406 ps=3.38 w=1.4 l=0.6
X727 x2_diff__cc3_0.x2_tail cmc VSS VSS sky130_fd_pr__nfet_01v8 ad=0.406 pd=3.38 as=0.406 ps=3.38 w=1.4 l=0.6
X728 on x2_cl_casc__cc4_0.bias_c x2_diff__cc3_0.x2_foldp VDD sky130_fd_pr__pfet_01v8 ad=0.406 pd=3.38 as=0.406 ps=3.38 w=1.4 l=0.6
X729 VSS VSS x2_cm_tail__id6_0.x2_m3d VSS sky130_fd_pr__nfet_01v8 ad=0.406 pd=3.38 as=0.406 ps=3.38 w=1.4 l=0.6
X730 x1_single_m3__f1_0.x1_m2d x1_single_m3__f1_0.x1_m2d x2_cm_casc__cc3_0.bias_d VSS sky130_fd_pr__nfet_01v8 ad=0.406 pd=3.38 as=0.406 ps=3.38 w=1.4 l=0.6
X731 x1_single_m5__f3_0.x1_m5d bias_a VSS VSS sky130_fd_pr__nfet_01v8 ad=0.406 pd=3.38 as=0.406 ps=3.38 w=1.4 l=0.6
X732 VSS bias_a x2_cm_tail__id6_0.x2_m4d VSS sky130_fd_pr__nfet_01v8 ad=0.406 pd=3.38 as=0.406 ps=3.38 w=1.4 l=0.6
X733 x1_cc_cm__strings1_0.x1_net9 cm VSS VSS sky130_fd_pr__nfet_01v8 ad=0.406 pd=3.38 as=0.406 ps=3.38 w=1.4 l=0.6
X734 x2_diff__cc3_0.x2_tail bias_a VSS VSS sky130_fd_pr__nfet_01v8 ad=0.406 pd=3.38 as=0.406 ps=3.38 w=1.4 l=0.6
X735 x2_diff__cc3_0.x2_foldp x2_cl_src__cc4_0.bias_b VDD VDD sky130_fd_pr__pfet_01v8_lvt ad=0.406 pd=3.38 as=0.406 ps=3.38 w=1.4 l=0.6
X736 x2_cm_casc__cc3_0.bias_d x1_single_m3__f1_0.x1_m2d x1_single_m3__f1_0.x1_m2d VSS sky130_fd_pr__nfet_01v8 ad=0.406 pd=3.38 as=0.406 ps=3.38 w=1.4 l=0.6
X737 op x2_cm_casc__cc3_0.bias_d x2_cm_tail__id6_0.x2_m4d VSS sky130_fd_pr__nfet_01v8 ad=0.406 pd=3.38 as=0.406 ps=3.38 w=1.4 l=0.6
X738 x2_cl_src__cc4_0.bias_b x2_cl_src__cc4_0.bias_b x2_cl_casc__cc4_0.bias_c VSS sky130_fd_pr__nfet_01v8_lvt ad=0.406 pd=3.38 as=0.406 ps=3.38 w=1.4 l=0.6
X739 x1_single_m3__f1_0.x1_m2d x1_single_m3__f1_0.x1_m2d x2_cm_casc__cc3_0.bias_d VSS sky130_fd_pr__nfet_01v8 ad=0.406 pd=3.38 as=0.406 ps=3.38 w=1.4 l=0.6
X740 VSS bias_a x2_diff__cc3_0.x2_tail VSS sky130_fd_pr__nfet_01v8 ad=0.406 pd=3.38 as=0.406 ps=3.38 w=1.4 l=0.6
X741 bias_a bias_a bias_a VSS sky130_fd_pr__nfet_01v8 ad=0.406 pd=3.38 as=0 ps=0 w=1.4 l=0.6
X742 x1_single_m3__f1_0.x1_m2d x1_single_m3__f1_0.x1_m2d x2_cm_casc__cc3_0.bias_d VSS sky130_fd_pr__nfet_01v8 ad=0.406 pd=3.38 as=0.406 ps=3.38 w=1.4 l=0.6
X743 x2_diff__cc3_0.x2_foldn x2_cl_casc__cc4_0.bias_c op VDD sky130_fd_pr__pfet_01v8 ad=0.406 pd=3.38 as=0.406 ps=3.38 w=1.4 l=0.6
X744 x2_diff__cc3_0.x2_tail cmc VSS VSS sky130_fd_pr__nfet_01v8 ad=0.406 pd=3.38 as=0.406 ps=3.38 w=1.4 l=0.6
X745 x2_cm_casc__cc3_0.bias_d x1_single_m3__f1_0.x1_m2d x1_single_m3__f1_0.x1_m2d VSS sky130_fd_pr__nfet_01v8 ad=0.406 pd=3.38 as=0.406 ps=3.38 w=1.4 l=0.6
X746 op x2_cm_casc__cc3_0.bias_d x2_cm_tail__id6_0.x2_m4d VSS sky130_fd_pr__nfet_01v8 ad=0.406 pd=3.38 as=0.406 ps=3.38 w=1.4 l=0.6
X747 x2_diff__cc3_0.x2_tail x2_diff__cc3_0.x2_tail x2_diff__cc3_0.x2_tail VSS sky130_fd_pr__nfet_01v8 ad=0.406 pd=3.38 as=0 ps=0 w=1.4 l=0.6
X748 x2_cl_src__cc4_0.bias_b x2_cl_src__cc4_0.bias_b x2_cl_src__cc4_0.bias_b VSS sky130_fd_pr__nfet_01v8_lvt ad=0.406 pd=3.38 as=0 ps=0 w=1.4 l=0.6
X749 x2_diff__cc3_0.x2_tail cmc VSS VSS sky130_fd_pr__nfet_01v8 ad=0.406 pd=3.38 as=0.406 ps=3.38 w=1.4 l=0.6
X750 VSS IBIAS x2_cl_casc__cc4_0.bias_c VSS sky130_fd_pr__nfet_01v8 ad=0.406 pd=3.38 as=0.406 ps=3.38 w=1.4 l=0.6
X751 VSS bias_a x2_cm_tail__id6_0.x2_m3d VSS sky130_fd_pr__nfet_01v8 ad=0.406 pd=3.38 as=0.406 ps=3.38 w=1.4 l=0.6
X752 x2_cl_src__cc4_0.bias_b x2_cl_casc__cc4_0.bias_c x1_cm_bias_c__cc1_0.x1_m21d VDD sky130_fd_pr__pfet_01v8 ad=0.406 pd=3.38 as=0.406 ps=3.38 w=1.4 l=0.6
X753 op x2_cl_casc__cc4_0.bias_c x2_diff__cc3_0.x2_foldn VDD sky130_fd_pr__pfet_01v8 ad=0.406 pd=3.38 as=0.406 ps=3.38 w=1.4 l=0.6
X754 x1_cc_cm__strings1_0.x1_net14 cm x1_cc_cm__strings1_0.x1_net13 VSS sky130_fd_pr__nfet_01v8 ad=0.406 pd=3.38 as=0.406 ps=3.38 w=1.4 l=0.6
X755 VSS cmc x2_diff__cc3_0.x2_tail VSS sky130_fd_pr__nfet_01v8 ad=0.406 pd=3.38 as=0.406 ps=3.38 w=1.4 l=0.6
X756 x2_cl_src__cc4_0.bias_b x2_cl_src__cc4_0.bias_b x2_cl_src__cc4_0.bias_b VSS sky130_fd_pr__nfet_01v8_lvt ad=0.406 pd=3.38 as=0 ps=0 w=1.4 l=0.6
X757 op x2_cm_casc__cc3_0.bias_d x2_cm_tail__id6_0.x2_m4d VSS sky130_fd_pr__nfet_01v8 ad=0.406 pd=3.38 as=0.406 ps=3.38 w=1.4 l=0.6
X758 x2_cm_tail__id6_0.x2_m3d bias_a VSS VSS sky130_fd_pr__nfet_01v8 ad=0.406 pd=3.38 as=0.406 ps=3.38 w=1.4 l=0.6
X759 VSS bias_a x2_cm_tail__id6_0.x2_m4d VSS sky130_fd_pr__nfet_01v8 ad=0.406 pd=3.38 as=0.406 ps=3.38 w=1.4 l=0.6
X760 x2_diff__cc3_0.x2_tail bias_a VSS VSS sky130_fd_pr__nfet_01v8 ad=0.406 pd=3.38 as=0.406 ps=3.38 w=1.4 l=0.6
X761 x2_diff__cc3_0.x2_foldn x2_cl_src__cc4_0.bias_b VDD VDD sky130_fd_pr__pfet_01v8_lvt ad=0.406 pd=3.38 as=0.406 ps=3.38 w=1.4 l=0.6
X762 x2_cm_tail__id6_0.x2_m3d x2_cm_casc__cc3_0.bias_d on VSS sky130_fd_pr__nfet_01v8 ad=0.406 pd=3.38 as=0.406 ps=3.38 w=1.4 l=0.6
X763 VSS VSS x2_cm_tail__id6_0.x2_m4d VSS sky130_fd_pr__nfet_01v8 ad=0.406 pd=3.38 as=0.406 ps=3.38 w=1.4 l=0.6
X764 x2_cl_casc__cc4_0.bias_c x2_cl_src__cc4_0.bias_b x2_cl_src__cc4_0.bias_b VSS sky130_fd_pr__nfet_01v8_lvt ad=0.406 pd=3.38 as=0.406 ps=3.38 w=1.4 l=0.6
X765 VSS VSS VSS VSS sky130_fd_pr__nfet_01v8 ad=0.406 pd=3.38 as=0 ps=0 w=1.4 l=0.6
X766 VDD x2_cl_src__cc4_0.bias_b x2_diff__cc3_0.x2_foldp VDD sky130_fd_pr__pfet_01v8_lvt ad=0.406 pd=3.38 as=0.406 ps=3.38 w=1.4 l=0.6
X767 VDD VDD op VDD sky130_fd_pr__pfet_01v8 ad=0.406 pd=3.38 as=0.406 ps=3.38 w=1.4 l=0.6
X768 op op op VSS sky130_fd_pr__nfet_01v8 ad=0.406 pd=3.38 as=0 ps=0 w=1.4 l=0.6
X769 x2_diff__cc3_0.x2_foldp x2_cl_casc__cc4_0.bias_c on VDD sky130_fd_pr__pfet_01v8 ad=0.406 pd=3.38 as=0.406 ps=3.38 w=1.4 l=0.6
X770 x2_diff__cc3_0.x2_foldp x2_diff__cc3_0.x2_foldp x2_diff__cc3_0.x2_foldp VDD sky130_fd_pr__pfet_01v8 ad=0.406 pd=3.38 as=0 ps=0 w=1.4 l=0.6
X771 VSS bias_a x2_cm_tail__id6_0.x2_m3d VSS sky130_fd_pr__nfet_01v8 ad=0.406 pd=3.38 as=0.406 ps=3.38 w=1.4 l=0.6
X772 VDD VDD VDD VDD sky130_fd_pr__pfet_01v8_lvt ad=0.406 pd=3.38 as=0 ps=0 w=1.4 l=0.6
X773 x1_single_m3__f1_0.x1_m2d x1_single_m3__f1_0.x1_m2d x2_cm_casc__cc3_0.bias_d VSS sky130_fd_pr__nfet_01v8 ad=0.406 pd=3.38 as=0.406 ps=3.38 w=1.4 l=0.6
X774 x2_cm_tail__id6_0.x2_m3d x2_cm_casc__cc3_0.bias_d on VSS sky130_fd_pr__nfet_01v8 ad=0.406 pd=3.38 as=0.406 ps=3.38 w=1.4 l=0.6
X775 x1_single_m5__f3_0.x1_m5d x2_cm_casc__cc3_0.bias_d bias_a VSS sky130_fd_pr__nfet_01v8 ad=0.406 pd=3.38 as=0.406 ps=3.38 w=1.4 l=0.6
X776 VDD x2_cl_src__cc4_0.bias_b x2_diff__cc3_0.x2_foldn VDD sky130_fd_pr__pfet_01v8_lvt ad=0.406 pd=3.38 as=0.406 ps=3.38 w=1.4 l=0.6
X777 x2_cm_casc__cc3_0.bias_d x2_cm_casc__cc3_0.bias_d x2_cm_casc__cc3_0.bias_d VSS sky130_fd_pr__nfet_01v8 ad=0.406 pd=3.38 as=0 ps=0 w=1.4 l=0.6
X778 x2_diff__cc3_0.x2_tail cmc VSS VSS sky130_fd_pr__nfet_01v8 ad=0.406 pd=3.38 as=0.406 ps=3.38 w=1.4 l=0.6
X779 VSS VSS VSS VSS sky130_fd_pr__nfet_01v8 ad=0.406 pd=3.38 as=0 ps=0 w=1.4 l=0.6
X780 VDD x2_cl_src__cc4_0.bias_b x1_cm_bias_c__cc1_0.x1_m25d VDD sky130_fd_pr__pfet_01v8_lvt ad=0.406 pd=3.38 as=0.406 ps=3.38 w=1.4 l=0.6
X781 x2_diff__cc3_0.x2_tail bias_a VSS VSS sky130_fd_pr__nfet_01v8 ad=0.406 pd=3.38 as=0.406 ps=3.38 w=1.4 l=0.6
X782 VSS cmc x2_diff__cc3_0.x2_tail VSS sky130_fd_pr__nfet_01v8 ad=0.406 pd=3.38 as=0.406 ps=3.38 w=1.4 l=0.6
X783 VSS cmc x2_diff__cc3_0.x2_tail VSS sky130_fd_pr__nfet_01v8 ad=0.406 pd=3.38 as=0.406 ps=3.38 w=1.4 l=0.6
X784 x1_single_m5__f3_0.x1_m5d x2_cm_casc__cc3_0.bias_d bias_a VSS sky130_fd_pr__nfet_01v8 ad=0.406 pd=3.38 as=0.406 ps=3.38 w=1.4 l=0.6
X785 x1_cm_bias_c__cc1_0.x1_m21d x2_cl_casc__cc4_0.bias_c x2_cl_src__cc4_0.bias_b VDD sky130_fd_pr__pfet_01v8 ad=0.406 pd=3.38 as=0.406 ps=3.38 w=1.4 l=0.6
X786 VSS bias_a x2_cm_tail__id6_0.x2_m3d VSS sky130_fd_pr__nfet_01v8 ad=0.406 pd=3.38 as=0.406 ps=3.38 w=1.4 l=0.6
X787 VSS cmc x2_diff__cc3_0.x2_tail VSS sky130_fd_pr__nfet_01v8 ad=0.406 pd=3.38 as=0.406 ps=3.38 w=1.4 l=0.6
X788 x2_cm_casc__cc3_0.bias_d x2_cm_casc__cc3_0.bias_d x2_cm_casc__cc3_0.bias_d VSS sky130_fd_pr__nfet_01v8 ad=0.406 pd=3.38 as=0 ps=0 w=1.4 l=0.6
X789 x2_cm_tail__id6_0.x2_m4d bias_a VSS VSS sky130_fd_pr__nfet_01v8 ad=0.406 pd=3.38 as=0.406 ps=3.38 w=1.4 l=0.6
X790 VSS VSS x2_diff__cc3_0.x2_tail VSS sky130_fd_pr__nfet_01v8 ad=0.406 pd=3.38 as=0.406 ps=3.38 w=1.4 l=0.6
X791 op x2_cm_casc__cc3_0.bias_d x2_cm_tail__id6_0.x2_m4d VSS sky130_fd_pr__nfet_01v8 ad=0.406 pd=3.38 as=0.406 ps=3.38 w=1.4 l=0.6
X792 x1_cm_bias_c__cc1_0.x1_m31d x1_cm_bias_c__cc1_0.x1_m31d x1_cm_bias_c__cc1_0.x1_m31d VDD sky130_fd_pr__pfet_01v8_lvt ad=0.406 pd=3.38 as=0 ps=0 w=1.4 l=0.6
X793 VSS VSS VSS VSS sky130_fd_pr__nfet_01v8_lvt ad=0.348 pd=2.98 as=0 ps=0 w=1.2 l=0.2
X794 x2_cm_tail__id6_0.x2_m3d x2_cm_casc__cc3_0.bias_d on VSS sky130_fd_pr__nfet_01v8 ad=0.406 pd=3.38 as=0.406 ps=3.38 w=1.4 l=0.6
X795 x2_diff__cc3_0.x2_tail bias_a VSS VSS sky130_fd_pr__nfet_01v8 ad=0.406 pd=3.38 as=0.406 ps=3.38 w=1.4 l=0.6
X796 VSS cmc x2_diff__cc3_0.x2_tail VSS sky130_fd_pr__nfet_01v8 ad=0.406 pd=3.38 as=0.406 ps=3.38 w=1.4 l=0.6
X797 VSS IBIAS x2_cl_casc__cc4_0.bias_c VSS sky130_fd_pr__nfet_01v8 ad=0.406 pd=3.38 as=0.406 ps=3.38 w=1.4 l=0.6
X798 on x2_cm_casc__cc3_0.bias_d x2_cm_tail__id6_0.x2_m3d VSS sky130_fd_pr__nfet_01v8 ad=0.406 pd=3.38 as=0.406 ps=3.38 w=1.4 l=0.6
X799 bias_a bias_a bias_a VSS sky130_fd_pr__nfet_01v8 ad=0.406 pd=3.38 as=0 ps=0 w=1.4 l=0.6
X800 bias_a x2_cm_casc__cc3_0.bias_d x1_single_m5__f3_0.x1_m5d VSS sky130_fd_pr__nfet_01v8 ad=0.406 pd=3.38 as=0.406 ps=3.38 w=1.4 l=0.6
X801 x2_diff__cc3_0.x2_tail bias_a VSS VSS sky130_fd_pr__nfet_01v8 ad=0.406 pd=3.38 as=0.406 ps=3.38 w=1.4 l=0.6
X802 x1_single_m3__f1_0.x1_m2d x1_single_m3__f1_0.x1_m2d x1_single_m3__f1_0.x1_m2d VSS sky130_fd_pr__nfet_01v8 ad=0.406 pd=3.38 as=0 ps=0 w=1.4 l=0.6
X803 IBIAS IBIAS VSS VSS sky130_fd_pr__nfet_01v8 ad=0.406 pd=3.38 as=0.406 ps=3.38 w=1.4 l=0.6
X804 x2_cl_casc__cc4_0.bias_c x2_cl_casc__cc4_0.bias_c x2_cl_casc__cc4_0.bias_c VSS sky130_fd_pr__nfet_01v8_lvt ad=0.406 pd=3.38 as=0 ps=0 w=1.4 l=0.6
X805 x1_cm_bias_c__cc1_0.x1_m25d x2_cl_casc__cc4_0.bias_c x1_single_m3__f1_0.x1_m2d VDD sky130_fd_pr__pfet_01v8 ad=0.406 pd=3.38 as=0.406 ps=3.38 w=1.4 l=0.6
X806 op x2_cl_casc__cc4_0.bias_c x2_diff__cc3_0.x2_foldn VDD sky130_fd_pr__pfet_01v8 ad=0.406 pd=3.38 as=0.406 ps=3.38 w=1.4 l=0.6
X807 bias_a x2_cm_casc__cc3_0.bias_d x1_single_m5__f3_0.x1_m5d VSS sky130_fd_pr__nfet_01v8 ad=0.406 pd=3.38 as=0.406 ps=3.38 w=1.4 l=0.6
X808 VDD x2_cl_src__cc4_0.bias_b x2_diff__cc3_0.x2_foldp VDD sky130_fd_pr__pfet_01v8_lvt ad=0.406 pd=3.38 as=0.406 ps=3.38 w=1.4 l=0.6
X809 x2_diff__cc3_0.x2_tail cmc VSS VSS sky130_fd_pr__nfet_01v8 ad=0.406 pd=3.38 as=0.406 ps=3.38 w=1.4 l=0.6
X810 VSS bias_a x2_diff__cc3_0.x2_tail VSS sky130_fd_pr__nfet_01v8 ad=0.406 pd=3.38 as=0.406 ps=3.38 w=1.4 l=0.6
X811 VSS VSS VSS VSS sky130_fd_pr__nfet_01v8 ad=0.406 pd=3.38 as=0 ps=0 w=1.4 l=0.6
X812 x2_diff__cc3_0.x2_foldn x2_cl_src__cc4_0.bias_b VDD VDD sky130_fd_pr__pfet_01v8_lvt ad=0.406 pd=3.38 as=0.406 ps=3.38 w=1.4 l=0.6
X813 x2_cm_tail__id6_0.x2_m4d x2_cm_casc__cc3_0.bias_d op VSS sky130_fd_pr__nfet_01v8 ad=0.406 pd=3.38 as=0.406 ps=3.38 w=1.4 l=0.6
X814 VSS cmc x2_diff__cc3_0.x2_tail VSS sky130_fd_pr__nfet_01v8 ad=0.406 pd=3.38 as=0.406 ps=3.38 w=1.4 l=0.6
X815 VSS VSS VSS VSS sky130_fd_pr__nfet_01v8 ad=0.406 pd=3.38 as=0 ps=0 w=1.4 l=0.6
X816 x1_cm_bias_c__cc1_0.x1_m21d x2_cl_casc__cc4_0.bias_c x2_cl_src__cc4_0.bias_b VDD sky130_fd_pr__pfet_01v8 ad=0.406 pd=3.38 as=0.406 ps=3.38 w=1.4 l=0.6
X817 VDD x2_cl_src__cc4_0.bias_b x2_diff__cc3_0.x2_foldp VDD sky130_fd_pr__pfet_01v8_lvt ad=0.406 pd=3.38 as=0.406 ps=3.38 w=1.4 l=0.6
X818 x2_diff__cc3_0.x2_tail cmc VSS VSS sky130_fd_pr__nfet_01v8 ad=0.406 pd=3.38 as=0.406 ps=3.38 w=1.4 l=0.6
X819 x1_single_m5__f3_0.x1_m5d bias_a VSS VSS sky130_fd_pr__nfet_01v8 ad=0.406 pd=3.38 as=0.406 ps=3.38 w=1.4 l=0.6
X820 x2_diff__cc3_0.x2_foldp x2_cl_casc__cc4_0.bias_c on VDD sky130_fd_pr__pfet_01v8 ad=0.406 pd=3.38 as=0.406 ps=3.38 w=1.4 l=0.6
X821 VDD VDD x2_diff__cc3_0.x2_foldp VDD sky130_fd_pr__pfet_01v8 ad=0.406 pd=3.38 as=0.406 ps=3.38 w=1.4 l=0.6
X822 x2_cm_tail__id6_0.x2_m3d bias_a VSS VSS sky130_fd_pr__nfet_01v8 ad=0.406 pd=3.38 as=0.406 ps=3.38 w=1.4 l=0.6
X823 x1_single_m3__f1_0.x1_m2d x1_single_m3__f1_0.x1_m2d x2_cm_casc__cc3_0.bias_d VSS sky130_fd_pr__nfet_01v8 ad=0.406 pd=3.38 as=0.406 ps=3.38 w=1.4 l=0.6
X824 op x2_cl_casc__cc4_0.bias_c x2_diff__cc3_0.x2_foldn VDD sky130_fd_pr__pfet_01v8 ad=0.406 pd=3.38 as=0.406 ps=3.38 w=1.4 l=0.6
X825 x1_cc_cm__strings1_0.x1_net7 cm x1_cc_cm__strings1_0.x1_net8 VSS sky130_fd_pr__nfet_01v8 ad=0.406 pd=3.38 as=0.406 ps=3.38 w=1.4 l=0.6
X826 x2_diff__cc3_0.x2_tail bias_a VSS VSS sky130_fd_pr__nfet_01v8 ad=0.406 pd=3.38 as=0.406 ps=3.38 w=1.4 l=0.6
X827 x2_cl_casc__cc4_0.bias_c x2_cl_src__cc4_0.bias_b x2_cl_src__cc4_0.bias_b VSS sky130_fd_pr__nfet_01v8_lvt ad=0.406 pd=3.38 as=0.406 ps=3.38 w=1.4 l=0.6
X828 x2_cm_casc__cc3_0.bias_d x1_single_m3__f1_0.x1_m2d x1_single_m3__f1_0.x1_m2d VSS sky130_fd_pr__nfet_01v8 ad=0.406 pd=3.38 as=0.406 ps=3.38 w=1.4 l=0.6
X829 x1_single_m3__f1_0.x1_m2d x1_single_m3__f1_0.x1_m2d x2_cm_casc__cc3_0.bias_d VSS sky130_fd_pr__nfet_01v8 ad=0.406 pd=3.38 as=0.406 ps=3.38 w=1.4 l=0.6
X830 x2_cl_casc__cc4_0.bias_c x2_cl_src__cc4_0.bias_b x2_cl_src__cc4_0.bias_b VSS sky130_fd_pr__nfet_01v8_lvt ad=0.406 pd=3.38 as=0.406 ps=3.38 w=1.4 l=0.6
X831 x2_diff__cc3_0.x2_tail cmc VSS VSS sky130_fd_pr__nfet_01v8 ad=0.406 pd=3.38 as=0.406 ps=3.38 w=1.4 l=0.6
X832 VDD x2_cl_src__cc4_0.bias_b x1_cm_bias_c__cc1_0.x1_m21d VDD sky130_fd_pr__pfet_01v8_lvt ad=0.406 pd=3.38 as=0.406 ps=3.38 w=1.4 l=0.6
X833 x2_cm_casc__cc3_0.bias_d x1_single_m3__f1_0.x1_m2d x1_single_m3__f1_0.x1_m2d VSS sky130_fd_pr__nfet_01v8 ad=0.406 pd=3.38 as=0.406 ps=3.38 w=1.4 l=0.6
X834 on x2_cm_casc__cc3_0.bias_d x2_cm_tail__id6_0.x2_m3d VSS sky130_fd_pr__nfet_01v8 ad=0.406 pd=3.38 as=0.406 ps=3.38 w=1.4 l=0.6
X835 cm cm cm VSS sky130_fd_pr__nfet_01v8 ad=0.406 pd=3.38 as=0 ps=0 w=1.4 l=0.6
X836 VSS bias_a x2_cm_tail__id6_0.x2_m4d VSS sky130_fd_pr__nfet_01v8 ad=0.406 pd=3.38 as=0.406 ps=3.38 w=1.4 l=0.6
X837 VDD x2_cl_src__cc4_0.bias_b x2_diff__cc3_0.x2_foldn VDD sky130_fd_pr__pfet_01v8_lvt ad=0.406 pd=3.38 as=0.406 ps=3.38 w=1.4 l=0.6
X838 x1_cc_cm__strings1_0.x1_net2 cm x1_cc_cm__strings1_0.x1_net1 VSS sky130_fd_pr__nfet_01v8 ad=0.406 pd=3.38 as=0.406 ps=3.38 w=1.4 l=0.6
X839 x2_cm_tail__id6_0.x2_m4d bias_a VSS VSS sky130_fd_pr__nfet_01v8 ad=0.406 pd=3.38 as=0.406 ps=3.38 w=1.4 l=0.6
X840 VDD VDD VDD VDD sky130_fd_pr__pfet_01v8_lvt ad=0.406 pd=3.38 as=0 ps=0 w=1.4 l=0.6
X841 x2_diff__cc3_0.x2_tail cmc VSS VSS sky130_fd_pr__nfet_01v8 ad=0.406 pd=3.38 as=0.406 ps=3.38 w=1.4 l=0.6
X842 VSS cmc x2_diff__cc3_0.x2_tail VSS sky130_fd_pr__nfet_01v8 ad=0.406 pd=3.38 as=0.406 ps=3.38 w=1.4 l=0.6
X843 VSS cmc x2_diff__cc3_0.x2_tail VSS sky130_fd_pr__nfet_01v8 ad=0.406 pd=3.38 as=0.406 ps=3.38 w=1.4 l=0.6
X844 x2_cl_casc__cc4_0.bias_c x2_cl_casc__cc4_0.bias_c x2_cl_casc__cc4_0.bias_c VSS sky130_fd_pr__nfet_01v8_lvt ad=0.406 pd=3.38 as=0 ps=0 w=1.4 l=0.6
X845 x2_cm_tail__id6_0.x2_m4d x2_cm_casc__cc3_0.bias_d op VSS sky130_fd_pr__nfet_01v8 ad=0.406 pd=3.38 as=0.406 ps=3.38 w=1.4 l=0.6
X846 VSS cm x1_cc_cm__strings1_0.x1_net3 VSS sky130_fd_pr__nfet_01v8 ad=0.406 pd=3.38 as=0.406 ps=3.38 w=1.4 l=0.6
X847 x2_diff__cc3_0.x2_tail bias_a VSS VSS sky130_fd_pr__nfet_01v8 ad=0.406 pd=3.38 as=0.406 ps=3.38 w=1.4 l=0.6
X848 VDD VDD cm VDD sky130_fd_pr__pfet_01v8 ad=0.406 pd=3.38 as=0.406 ps=3.38 w=1.4 l=0.6
X849 x2_diff__cc3_0.x2_foldn x2_cl_src__cc4_0.bias_b VDD VDD sky130_fd_pr__pfet_01v8_lvt ad=0.406 pd=3.38 as=0.406 ps=3.38 w=1.4 l=0.6
X850 x2_diff__cc3_0.x2_tail cmc VSS VSS sky130_fd_pr__nfet_01v8 ad=0.406 pd=3.38 as=0.406 ps=3.38 w=1.4 l=0.6
X851 x2_cl_casc__cc4_0.bias_c x2_cl_src__cc4_0.bias_b x2_cl_src__cc4_0.bias_b VSS sky130_fd_pr__nfet_01v8_lvt ad=0.406 pd=3.38 as=0.406 ps=3.38 w=1.4 l=0.6
X852 VSS VSS VSS VSS sky130_fd_pr__nfet_01v8 ad=0.406 pd=3.38 as=0 ps=0 w=1.4 l=0.6
X853 VSS bias_a x2_cm_tail__id6_0.x2_m4d VSS sky130_fd_pr__nfet_01v8 ad=0.406 pd=3.38 as=0.406 ps=3.38 w=1.4 l=0.6
X854 x2_diff__cc3_0.x2_tail bias_a VSS VSS sky130_fd_pr__nfet_01v8 ad=0.406 pd=3.38 as=0.406 ps=3.38 w=1.4 l=0.6
X855 x2_cl_casc__cc4_0.bias_c x2_cl_src__cc4_0.bias_b x2_cl_src__cc4_0.bias_b VSS sky130_fd_pr__nfet_01v8_lvt ad=0.406 pd=3.38 as=0.406 ps=3.38 w=1.4 l=0.6
X856 x2_diff__cc3_0.x2_tail bias_a VSS VSS sky130_fd_pr__nfet_01v8 ad=0.406 pd=3.38 as=0.406 ps=3.38 w=1.4 l=0.6
.ends

.end
