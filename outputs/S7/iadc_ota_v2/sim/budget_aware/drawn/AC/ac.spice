* iadc_ota on dido_amp_AC
.lib $PDK_ROOT/sky130A/libs.tech/combined/sky130.lib.spice tt
.option rshunt=1e12
.param VDD_V=1.8 VCM_V=0.9 CL_F=0.3p
.temp 27

**.subckt dido_amp_AC
x1 INP INN OUTN VDD 0 OUTP dut_amp
Vsup VDD 0 'VDD_V'
* AC drive through 1 F couplers; DC set by unity feedback through 1 GH chokes (OUTP->INN, OUTN->INP)
Vacp ACP 0 dc 0 ac 0.5
Vacn ACN 0 dc 0 ac -0.5
Cinp ACP INP 1
Cinn ACN INN 1
Lfbp OUTP INN 1G
Lfbn OUTN INP 1G
Cloadp OUTP 0 'CL_F'
Cloadn OUTN 0 'CL_F'
.control
  save all
  ac dec 40 1 1G
  let hsig = v(OUTP) - v(OUTN)
  let hdb = db(hsig)
  let gph_deg = 180/pi * cph(hsig)
  meas ac gain_db find hdb at=1
  meas ac gbw_hz  when hdb=0
  meas ac ph_dc   find gph_deg at=1
  meas ac ph_ugb  find gph_deg when hdb=0
  let gbw_mhz = gbw_hz / 1e6
  let pm_deg  = 180 + (ph_ugb - ph_dc)
  echo MEAS gain_db $&gain_db
  echo MEAS gbw_mhz $&gbw_mhz
  echo MEAS pm_deg $&pm_deg
  write
  quit 0
.endc
**.ends

.subckt dut_amp INP INN OUTN VDD VSS OUTP
XDUT OUTN OUTP bias_a_w cm_w N_IBIAS VDD VSS cmc_w INN INP N_bias_d N_x1_m2d N_x1_m5d N_x2_m4d N_x2_m3d N_bias_b N_bias_c N_x1_net1 N_x1_net2 N_x1_net3 N_x1_net13 N_x1_net14 N_x1_net15 N_x1_net4 N_x1_net5 N_x1_net6 N_x1_net7 N_x1_net8 N_x1_net9 N_x1_net10 N_x1_net11 N_x1_net12 N_x2_foldp N_x2_foldn N_x2_tail N_x1_m21d N_x1_m25d N_x1_m31d iadc_ota_v2_routed_flat
* ideal CMFB: the steady-state law of the upstream switched-capacitor CMFB (ASSUMPTION)
Bcmfb cmc_w VSS V = v(bias_a_w) + (v(OUTP) + v(OUTN))/2 - v(cm_w)
IIbias_ext_layout VDD N_IBIAS 3e-05
.ends
.subckt iadc_ota ip in op on VDD VSS cmc cm bias_a
XX1_M22 bias_b bias_c x1_m21d VDD sky130_fd_pr__pfet_01v8 L=0.6 W=1.4 NF=1 AD=0.406 AS=0.406 PD=3.38 PS=3.38 NRD=0.207143 NRS=0.207143 SA=0 SB=0 SD=0 MULT=6 M=6
XX1_M26 x1_m2d bias_c x1_m25d VDD sky130_fd_pr__pfet_01v8 L=0.6 W=1.4 NF=1 AD=0.406 AS=0.406 PD=3.38 PS=3.38 NRD=0.207143 NRS=0.207143 SA=0 SB=0 SD=0 MULT=6 M=6
XX1_M32 cm bias_c x1_m31d VDD sky130_fd_pr__pfet_01v8 L=0.6 W=1.4 NF=1 AD=0.406 AS=0.406 PD=3.38 PS=3.38 NRD=0.207143 NRS=0.207143 SA=0 SB=0 SD=0 MULT=6 M=6
XX1_M21 x1_m21d bias_b VDD VDD sky130_fd_pr__pfet_01v8_lvt L=0.6 W=1.4 NF=1 AD=0.406 AS=0.406 PD=3.38 PS=3.38 NRD=0.207143 NRS=0.207143 SA=0 SB=0 SD=0 MULT=6 M=6
XX1_M25 x1_m25d bias_b VDD VDD sky130_fd_pr__pfet_01v8_lvt L=0.6 W=1.4 NF=1 AD=0.406 AS=0.406 PD=3.38 PS=3.38 NRD=0.207143 NRS=0.207143 SA=0 SB=0 SD=0 MULT=6 M=6
XX1_M31 x1_m31d bias_b VDD VDD sky130_fd_pr__pfet_01v8_lvt L=0.6 W=1.4 NF=1 AD=0.406 AS=0.406 PD=3.38 PS=3.38 NRD=0.207143 NRS=0.207143 SA=0 SB=0 SD=0 MULT=6 M=6
XX1_M1 bias_b bias_b bias_c VSS sky130_fd_pr__nfet_01v8_lvt L=0.6 W=1.4 NF=1 AD=0.406 AS=0.406 PD=3.38 PS=3.38 NRD=0.207143 NRS=0.207143 SA=0 SB=0 SD=0 MULT=56 M=56
XX1_M2 x1_m2d x1_m2d bias_d VSS sky130_fd_pr__nfet_01v8 L=0.6 W=1.4 NF=1 AD=0.406 AS=0.406 PD=3.38 PS=3.38 NRD=0.207143 NRS=0.207143 SA=0 SB=0 SD=0 MULT=50 M=50
XX1_M3 bias_d x1_m2d bias_a VSS sky130_fd_pr__nfet_01v8 L=0.6 W=1.4 NF=1 AD=0.406 AS=0.406 PD=3.38 PS=3.38 NRD=0.207143 NRS=0.207143 SA=0 SB=0 SD=0 MULT=2 M=2
XX1_M4 bias_a bias_d x1_m5d VSS sky130_fd_pr__nfet_01v8 L=0.6 W=1.4 NF=1 AD=0.406 AS=0.406 PD=3.38 PS=3.38 NRD=0.207143 NRS=0.207143 SA=0 SB=0 SD=0 MULT=18 M=18
XX1_M5 x1_m5d bias_a VSS VSS sky130_fd_pr__nfet_01v8 L=0.6 W=1.4 NF=1 AD=0.406 AS=0.406 PD=3.38 PS=3.38 NRD=0.207143 NRS=0.207143 SA=0 SB=0 SD=0 MULT=18 M=18
XX1_M6 bias_c i_bias VSS VSS sky130_fd_pr__nfet_01v8 L=0.6 W=1.4 NF=1 AD=0.406 AS=0.406 PD=3.38 PS=3.38 NRD=0.207143 NRS=0.207143 SA=0 SB=0 SD=0 MULT=18 M=18
XX1_M7 i_bias i_bias VSS VSS sky130_fd_pr__nfet_01v8 L=0.6 W=1.4 NF=1 AD=0.406 AS=0.406 PD=3.38 PS=3.38 NRD=0.207143 NRS=0.207143 SA=0 SB=0 SD=0 MULT=18 M=18
XX1_M33 cm cm x1_net1 VSS sky130_fd_pr__nfet_01v8 L=0.6 W=1.4 NF=1 AD=0.406 AS=0.406 PD=3.38 PS=3.38 NRD=0.207143 NRS=0.207143 SA=0 SB=0 SD=0 MULT=1 M=1
XX1_M49 x1_net1 cm x1_net2 VSS sky130_fd_pr__nfet_01v8 L=0.6 W=1.4 NF=1 AD=0.406 AS=0.406 PD=3.38 PS=3.38 NRD=0.207143 NRS=0.207143 SA=0 SB=0 SD=0 MULT=1 M=1
XX1_M50 x1_net2 cm x1_net3 VSS sky130_fd_pr__nfet_01v8 L=0.6 W=1.4 NF=1 AD=0.406 AS=0.406 PD=3.38 PS=3.38 NRD=0.207143 NRS=0.207143 SA=0 SB=0 SD=0 MULT=1 M=1
XX1_M63 x1_net3 cm VSS VSS sky130_fd_pr__nfet_01v8 L=0.6 W=1.4 NF=1 AD=0.406 AS=0.406 PD=3.38 PS=3.38 NRD=0.207143 NRS=0.207143 SA=0 SB=0 SD=0 MULT=1 M=1
XX1_M68 cm cm x1_net4 VSS sky130_fd_pr__nfet_01v8 L=0.6 W=1.4 NF=1 AD=0.406 AS=0.406 PD=3.38 PS=3.38 NRD=0.207143 NRS=0.207143 SA=0 SB=0 SD=0 MULT=1 M=1
XX1_M69 x1_net4 cm x1_net5 VSS sky130_fd_pr__nfet_01v8 L=0.6 W=1.4 NF=1 AD=0.406 AS=0.406 PD=3.38 PS=3.38 NRD=0.207143 NRS=0.207143 SA=0 SB=0 SD=0 MULT=1 M=1
XX1_M70 x1_net5 cm x1_net6 VSS sky130_fd_pr__nfet_01v8 L=0.6 W=1.4 NF=1 AD=0.406 AS=0.406 PD=3.38 PS=3.38 NRD=0.207143 NRS=0.207143 SA=0 SB=0 SD=0 MULT=1 M=1
XX1_M71 x1_net6 cm VSS VSS sky130_fd_pr__nfet_01v8 L=0.6 W=1.4 NF=1 AD=0.406 AS=0.406 PD=3.38 PS=3.38 NRD=0.207143 NRS=0.207143 SA=0 SB=0 SD=0 MULT=1 M=1
XX1_M72 cm cm x1_net7 VSS sky130_fd_pr__nfet_01v8 L=0.6 W=1.4 NF=1 AD=0.406 AS=0.406 PD=3.38 PS=3.38 NRD=0.207143 NRS=0.207143 SA=0 SB=0 SD=0 MULT=1 M=1
XX1_M73 x1_net7 cm x1_net8 VSS sky130_fd_pr__nfet_01v8 L=0.6 W=1.4 NF=1 AD=0.406 AS=0.406 PD=3.38 PS=3.38 NRD=0.207143 NRS=0.207143 SA=0 SB=0 SD=0 MULT=1 M=1
XX1_M74 x1_net8 cm x1_net9 VSS sky130_fd_pr__nfet_01v8 L=0.6 W=1.4 NF=1 AD=0.406 AS=0.406 PD=3.38 PS=3.38 NRD=0.207143 NRS=0.207143 SA=0 SB=0 SD=0 MULT=1 M=1
XX1_M75 x1_net9 cm VSS VSS sky130_fd_pr__nfet_01v8 L=0.6 W=1.4 NF=1 AD=0.406 AS=0.406 PD=3.38 PS=3.38 NRD=0.207143 NRS=0.207143 SA=0 SB=0 SD=0 MULT=1 M=1
XX1_M76 cm cm x1_net10 VSS sky130_fd_pr__nfet_01v8 L=0.6 W=1.4 NF=1 AD=0.406 AS=0.406 PD=3.38 PS=3.38 NRD=0.207143 NRS=0.207143 SA=0 SB=0 SD=0 MULT=1 M=1
XX1_M77 x1_net10 cm x1_net11 VSS sky130_fd_pr__nfet_01v8 L=0.6 W=1.4 NF=1 AD=0.406 AS=0.406 PD=3.38 PS=3.38 NRD=0.207143 NRS=0.207143 SA=0 SB=0 SD=0 MULT=1 M=1
XX1_M78 x1_net11 cm x1_net12 VSS sky130_fd_pr__nfet_01v8 L=0.6 W=1.4 NF=1 AD=0.406 AS=0.406 PD=3.38 PS=3.38 NRD=0.207143 NRS=0.207143 SA=0 SB=0 SD=0 MULT=1 M=1
XX1_M79 x1_net12 cm VSS VSS sky130_fd_pr__nfet_01v8 L=0.6 W=1.4 NF=1 AD=0.406 AS=0.406 PD=3.38 PS=3.38 NRD=0.207143 NRS=0.207143 SA=0 SB=0 SD=0 MULT=1 M=1
XX1_M64 cm cm x1_net13 VSS sky130_fd_pr__nfet_01v8 L=0.6 W=1.4 NF=1 AD=0.406 AS=0.406 PD=3.38 PS=3.38 NRD=0.207143 NRS=0.207143 SA=0 SB=0 SD=0 MULT=1 M=1
XX1_M65 x1_net13 cm x1_net14 VSS sky130_fd_pr__nfet_01v8 L=0.6 W=1.4 NF=1 AD=0.406 AS=0.406 PD=3.38 PS=3.38 NRD=0.207143 NRS=0.207143 SA=0 SB=0 SD=0 MULT=1 M=1
XX1_M66 x1_net14 cm x1_net15 VSS sky130_fd_pr__nfet_01v8 L=0.6 W=1.4 NF=1 AD=0.406 AS=0.406 PD=3.38 PS=3.38 NRD=0.207143 NRS=0.207143 SA=0 SB=0 SD=0 MULT=1 M=1
XX1_M67 x1_net15 cm VSS VSS sky130_fd_pr__nfet_01v8 L=0.6 W=1.4 NF=1 AD=0.406 AS=0.406 PD=3.38 PS=3.38 NRD=0.207143 NRS=0.207143 SA=0 SB=0 SD=0 MULT=1 M=1
XX1_M57 bias_b VDD VDD VDD sky130_fd_pr__pfet_01v8 L=0.6 W=1.4 NF=1 AD=0.406 AS=0.406 PD=3.38 PS=3.38 NRD=0.207143 NRS=0.207143 SA=0 SB=0 SD=0 MULT=2 M=2
XX1_M58 x1_m2d VDD VDD VDD sky130_fd_pr__pfet_01v8 L=0.6 W=1.4 NF=1 AD=0.406 AS=0.406 PD=3.38 PS=3.38 NRD=0.207143 NRS=0.207143 SA=0 SB=0 SD=0 MULT=2 M=2
XX1_M59 cm VDD VDD VDD sky130_fd_pr__pfet_01v8 L=0.6 W=1.4 NF=1 AD=0.406 AS=0.406 PD=3.38 PS=3.38 NRD=0.207143 NRS=0.207143 SA=0 SB=0 SD=0 MULT=2 M=2
XX1_M60 x1_m31d VDD VDD VDD sky130_fd_pr__pfet_01v8 L=0.6 W=1.4 NF=1 AD=0.406 AS=0.406 PD=3.38 PS=3.38 NRD=0.207143 NRS=0.207143 SA=0 SB=0 SD=0 MULT=2 M=2
XX1_M42 x1_m5d VSS VSS VSS sky130_fd_pr__nfet_01v8 L=0.6 W=1.4 NF=1 AD=0.406 AS=0.406 PD=3.38 PS=3.38 NRD=0.207143 NRS=0.207143 SA=0 SB=0 SD=0 MULT=6 M=6
XX1_M44 bias_c bias_c bias_c VSS sky130_fd_pr__nfet_01v8 L=0.6 W=1.4 NF=1 AD=0.406 AS=0.406 PD=3.38 PS=3.38 NRD=0.207143 NRS=0.207143 SA=0 SB=0 SD=0 MULT=2 M=2
XX1_M34 bias_d bias_d bias_d VSS sky130_fd_pr__nfet_01v8 L=0.6 W=1.4 NF=1 AD=0.406 AS=0.406 PD=3.38 PS=3.38 NRD=0.207143 NRS=0.207143 SA=0 SB=0 SD=0 MULT=8 M=8
XX1_M35 x1_m2d x1_m2d x1_m2d VSS sky130_fd_pr__nfet_01v8 L=0.6 W=1.4 NF=1 AD=0.406 AS=0.406 PD=3.38 PS=3.38 NRD=0.207143 NRS=0.207143 SA=0 SB=0 SD=0 MULT=2 M=2
XX1_M36 bias_a bias_a bias_a VSS sky130_fd_pr__nfet_01v8 L=0.6 W=1.4 NF=1 AD=0.406 AS=0.406 PD=3.38 PS=3.38 NRD=0.207143 NRS=0.207143 SA=0 SB=0 SD=0 MULT=4 M=4
XX1_M37 cm cm cm VSS sky130_fd_pr__nfet_01v8 L=0.6 W=1.4 NF=1 AD=0.406 AS=0.406 PD=3.38 PS=3.38 NRD=0.207143 NRS=0.207143 SA=0 SB=0 SD=0 MULT=8 M=8
XX1_M54 x1_m25d x1_m25d x1_m25d VDD sky130_fd_pr__pfet_01v8 L=0.6 W=1.4 NF=1 AD=0.406 AS=0.406 PD=3.38 PS=3.38 NRD=0.207143 NRS=0.207143 SA=0 SB=0 SD=0 MULT=2 M=2
XX1_M29 x1_m5d x1_m5d x1_m5d VSS sky130_fd_pr__nfet_01v8 L=0.6 W=1.4 NF=1 AD=0.406 AS=0.406 PD=3.38 PS=3.38 NRD=0.207143 NRS=0.207143 SA=0 SB=0 SD=0 MULT=6 M=6
XX1_M8 i_bias i_bias i_bias VSS sky130_fd_pr__nfet_01v8 L=0.6 W=1.4 NF=1 AD=0.406 AS=0.406 PD=3.38 PS=3.38 NRD=0.207143 NRS=0.207143 SA=0 SB=0 SD=0 MULT=2 M=2
XX1_M10 bias_c bias_c bias_c VSS sky130_fd_pr__nfet_01v8_lvt L=0.6 W=1.4 NF=1 AD=0.406 AS=0.406 PD=3.38 PS=3.38 NRD=0.207143 NRS=0.207143 SA=0 SB=0 SD=0 MULT=8 M=8
XX1_M27 bias_b bias_b bias_b VSS sky130_fd_pr__nfet_01v8_lvt L=0.6 W=1.4 NF=1 AD=0.406 AS=0.406 PD=3.38 PS=3.38 NRD=0.207143 NRS=0.207143 SA=0 SB=0 SD=0 MULT=8 M=8
XX1_M46 x1_m21d x1_m21d x1_m21d VDD sky130_fd_pr__pfet_01v8_lvt L=0.6 W=1.4 NF=1 AD=0.406 AS=0.406 PD=3.38 PS=3.38 NRD=0.207143 NRS=0.207143 SA=0 SB=0 SD=0 MULT=2 M=2
XX1_M47 x1_m25d x1_m25d x1_m25d VDD sky130_fd_pr__pfet_01v8_lvt L=0.6 W=1.4 NF=1 AD=0.406 AS=0.406 PD=3.38 PS=3.38 NRD=0.207143 NRS=0.207143 SA=0 SB=0 SD=0 MULT=2 M=2
XX1_M48 x1_m31d x1_m31d x1_m31d VDD sky130_fd_pr__pfet_01v8_lvt L=0.6 W=1.4 NF=1 AD=0.406 AS=0.406 PD=3.38 PS=3.38 NRD=0.207143 NRS=0.207143 SA=0 SB=0 SD=0 MULT=2 M=2
XX1_M51 x1_m21d x1_m21d x1_m21d VDD sky130_fd_pr__pfet_01v8 L=0.6 W=1.4 NF=1 AD=0.406 AS=0.406 PD=3.38 PS=3.38 NRD=0.207143 NRS=0.207143 SA=0 SB=0 SD=0 MULT=2 M=2
XX2_M1 x2_foldp ip x2_tail VSS sky130_fd_pr__nfet_01v8_lvt L=0.2 W=1.2 NF=1 AD=0.348 AS=0.348 PD=2.98 PS=2.98 NRD=0.241667 NRS=0.241667 SA=0 SB=0 SD=0 MULT=6 M=6
XX2_M2 x2_foldn in x2_tail VSS sky130_fd_pr__nfet_01v8_lvt L=0.2 W=1.2 NF=1 AD=0.348 AS=0.348 PD=2.98 PS=2.98 NRD=0.241667 NRS=0.241667 SA=0 SB=0 SD=0 MULT=6 M=6
XX2_M6 x2_tail cmc VSS VSS sky130_fd_pr__nfet_01v8 L=0.6 W=1.4 NF=1 AD=0.406 AS=0.406 PD=3.38 PS=3.38 NRD=0.207143 NRS=0.207143 SA=0 SB=0 SD=0 MULT=96 M=96
XX2_M5 x2_tail bias_a VSS VSS sky130_fd_pr__nfet_01v8 L=0.6 W=1.4 NF=1 AD=0.406 AS=0.406 PD=3.38 PS=3.38 NRD=0.207143 NRS=0.207143 SA=0 SB=0 SD=0 MULT=96 M=96
XX2_M11 x2_foldp bias_b VDD VDD sky130_fd_pr__pfet_01v8_lvt L=0.6 W=1.4 NF=1 AD=0.406 AS=0.406 PD=3.38 PS=3.38 NRD=0.207143 NRS=0.207143 SA=0 SB=0 SD=0 MULT=24 M=24
XX2_M12 x2_foldn bias_b VDD VDD sky130_fd_pr__pfet_01v8_lvt L=0.6 W=1.4 NF=1 AD=0.406 AS=0.406 PD=3.38 PS=3.38 NRD=0.207143 NRS=0.207143 SA=0 SB=0 SD=0 MULT=24 M=24
XX2_M1A on bias_c x2_foldp VDD sky130_fd_pr__pfet_01v8 L=0.6 W=1.4 NF=1 AD=0.406 AS=0.406 PD=3.38 PS=3.38 NRD=0.207143 NRS=0.207143 SA=0 SB=0 SD=0 MULT=20 M=20
XX2_M8 op bias_c x2_foldn VDD sky130_fd_pr__pfet_01v8 L=0.6 W=1.4 NF=1 AD=0.406 AS=0.406 PD=3.38 PS=3.38 NRD=0.207143 NRS=0.207143 SA=0 SB=0 SD=0 MULT=20 M=20
XX2_M3A on bias_d x2_m3d VSS sky130_fd_pr__nfet_01v8 L=0.6 W=1.4 NF=1 AD=0.406 AS=0.406 PD=3.38 PS=3.38 NRD=0.207143 NRS=0.207143 SA=0 SB=0 SD=0 MULT=36 M=36
XX2_M7 op bias_d x2_m4d VSS sky130_fd_pr__nfet_01v8 L=0.6 W=1.4 NF=1 AD=0.406 AS=0.406 PD=3.38 PS=3.38 NRD=0.207143 NRS=0.207143 SA=0 SB=0 SD=0 MULT=36 M=36
XX2_M3 x2_m3d bias_a VSS VSS sky130_fd_pr__nfet_01v8 L=0.6 W=1.4 NF=1 AD=0.406 AS=0.406 PD=3.38 PS=3.38 NRD=0.207143 NRS=0.207143 SA=0 SB=0 SD=0 MULT=36 M=36
XX2_M4 x2_m4d bias_a VSS VSS sky130_fd_pr__nfet_01v8 L=0.6 W=1.4 NF=1 AD=0.406 AS=0.406 PD=3.38 PS=3.38 NRD=0.207143 NRS=0.207143 SA=0 SB=0 SD=0 MULT=36 M=36
XX2_M82 x2_foldn x2_foldn x2_foldn VDD sky130_fd_pr__pfet_01v8 L=0.6 W=1.4 NF=1 AD=0.406 AS=0.406 PD=3.38 PS=3.38 NRD=0.207143 NRS=0.207143 SA=0 SB=0 SD=0 MULT=2 M=2
XX2_M83 x2_foldp x2_foldp x2_foldp VDD sky130_fd_pr__pfet_01v8 L=0.6 W=1.4 NF=1 AD=0.406 AS=0.406 PD=3.38 PS=3.38 NRD=0.207143 NRS=0.207143 SA=0 SB=0 SD=0 MULT=2 M=2
XX2_M55 x2_foldn VDD VDD VDD sky130_fd_pr__pfet_01v8 L=0.6 W=1.4 NF=1 AD=0.406 AS=0.406 PD=3.38 PS=3.38 NRD=0.207143 NRS=0.207143 SA=0 SB=0 SD=0 MULT=2 M=2
XX2_M56 op VDD VDD VDD sky130_fd_pr__pfet_01v8 L=0.6 W=1.4 NF=1 AD=0.406 AS=0.406 PD=3.38 PS=3.38 NRD=0.207143 NRS=0.207143 SA=0 SB=0 SD=0 MULT=4 M=4
XX2_M61 x2_foldp VDD VDD VDD sky130_fd_pr__pfet_01v8 L=0.6 W=1.4 NF=1 AD=0.406 AS=0.406 PD=3.38 PS=3.38 NRD=0.207143 NRS=0.207143 SA=0 SB=0 SD=0 MULT=2 M=2
XX2_M62 on VDD VDD VDD sky130_fd_pr__pfet_01v8 L=0.6 W=1.4 NF=1 AD=0.406 AS=0.406 PD=3.38 PS=3.38 NRD=0.207143 NRS=0.207143 SA=0 SB=0 SD=0 MULT=4 M=4
XX2_M40 x2_m4d VSS VSS VSS sky130_fd_pr__nfet_01v8 L=0.6 W=1.4 NF=1 AD=0.406 AS=0.406 PD=3.38 PS=3.38 NRD=0.207143 NRS=0.207143 SA=0 SB=0 SD=0 MULT=6 M=6
XX2_M41 x2_m3d VSS VSS VSS sky130_fd_pr__nfet_01v8 L=0.6 W=1.4 NF=1 AD=0.406 AS=0.406 PD=3.38 PS=3.38 NRD=0.207143 NRS=0.207143 SA=0 SB=0 SD=0 MULT=8 M=8
XX2_M38 op op op VSS sky130_fd_pr__nfet_01v8 L=0.6 W=1.4 NF=1 AD=0.406 AS=0.406 PD=3.38 PS=3.38 NRD=0.207143 NRS=0.207143 SA=0 SB=0 SD=0 MULT=2 M=2
XX2_M39 on on on VSS sky130_fd_pr__nfet_01v8 L=0.6 W=1.4 NF=1 AD=0.406 AS=0.406 PD=3.38 PS=3.38 NRD=0.207143 NRS=0.207143 SA=0 SB=0 SD=0 MULT=2 M=2
XX2_M30 x2_tail VSS VSS VSS sky130_fd_pr__nfet_01v8 L=0.6 W=1.4 NF=1 AD=0.406 AS=0.406 PD=3.38 PS=3.38 NRD=0.207143 NRS=0.207143 SA=0 SB=0 SD=0 MULT=2 M=2
XX2_M23 x2_foldp x2_foldp x2_foldp VSS sky130_fd_pr__nfet_01v8_lvt L=0.2 W=1.2 NF=1 AD=0.348 AS=0.348 PD=2.98 PS=2.98 NRD=0.241667 NRS=0.241667 SA=0 SB=0 SD=0 MULT=2 M=2
XX2_M24 x2_foldn x2_foldn x2_foldn VSS sky130_fd_pr__nfet_01v8_lvt L=0.2 W=1.2 NF=1 AD=0.348 AS=0.348 PD=2.98 PS=2.98 NRD=0.241667 NRS=0.241667 SA=0 SB=0 SD=0 MULT=2 M=2
XX2_M80 op VSS VSS VSS sky130_fd_pr__nfet_01v8 L=0.6 W=1.4 NF=1 AD=0.406 AS=0.406 PD=3.38 PS=3.38 NRD=0.207143 NRS=0.207143 SA=0 SB=0 SD=0 MULT=2 M=2
XX2_M81 on VSS VSS VSS sky130_fd_pr__nfet_01v8 L=0.6 W=1.4 NF=1 AD=0.406 AS=0.406 PD=3.38 PS=3.38 NRD=0.207143 NRS=0.207143 SA=0 SB=0 SD=0 MULT=2 M=2
XX2_M28 x2_tail x2_tail x2_tail VSS sky130_fd_pr__nfet_01v8 L=0.6 W=1.4 NF=1 AD=0.406 AS=0.406 PD=3.38 PS=3.38 NRD=0.207143 NRS=0.207143 SA=0 SB=0 SD=0 MULT=6 M=6
XM43 VDD VDD VDD VDD sky130_fd_pr__pfet_01v8_lvt L=0.6 W=1.4 NF=1 AD=0.406 AS=0.406 PD=3.38 PS=3.38 NRD=0.207143 NRS=0.207143 SA=0 SB=0 SD=0 MULT=8 M=8
XM45 VDD VDD VDD VDD sky130_fd_pr__pfet_01v8 L=0.6 W=1.4 NF=1 AD=0.406 AS=0.406 PD=3.38 PS=3.38 NRD=0.207143 NRS=0.207143 SA=0 SB=0 SD=0 MULT=6 M=6
XM9 VSS VSS VSS VSS sky130_fd_pr__nfet_01v8 L=0.6 W=1.4 NF=1 AD=0.406 AS=0.406 PD=3.38 PS=3.38 NRD=0.207143 NRS=0.207143 SA=0 SB=0 SD=0 MULT=23 M=23
Ibias_ext VDD i_bias 3e-05
XC3 op cmc sky130_fd_pr__cap_mim_m3_1 W=4.8 L=4.8 MF=4 M=4
XC4 on cmc sky130_fd_pr__cap_mim_m3_1 W=4.8 L=4.8 MF=4 M=4
.ends iadc_ota
* NGSPICE file created from iadc_ota_v2_routed_flat.ext - technology: sky130A

.subckt iadc_ota_v2_routed_flat on op bias_a cm IBIAS VDD VSS cmc in ip x2_cm_casc__cc6_0.bias_d
+ x1_single_m3__f1_0.x1_m2d x1_single_m5__f3_0.x1_m5d x2_cm_tail__cc6_0.x2_m4d x2_cm_tail__cc6_0.x2_m3d
+ x2_cl_src__id4_0.bias_b x2_cl_casc__cc1_0.bias_c x1_cc_cm__strings1_0.x1_net1 x1_cc_cm__strings1_0.x1_net2
+ x1_cc_cm__strings1_0.x1_net3 x1_cc_cm__strings1_0.x1_net13 x1_cc_cm__strings1_0.x1_net14
+ x1_cc_cm__strings1_0.x1_net15 x1_cc_cm__strings1_0.x1_net4 x1_cc_cm__strings1_0.x1_net5
+ x1_cc_cm__strings1_0.x1_net6 x1_cc_cm__strings1_0.x1_net7 x1_cc_cm__strings1_0.x1_net8
+ x1_cc_cm__strings1_0.x1_net9 x1_cc_cm__strings1_0.x1_net10 x1_cc_cm__strings1_0.x1_net11
+ x1_cc_cm__strings1_0.x1_net12 x2_diff__cc1_0.x2_foldp x2_diff__cc1_0.x2_foldn x2_diff__cc1_0.x2_tail
+ x1_cm_bias_c__cc1_0.x1_m21d x1_cm_bias_c__cc1_0.x1_m25d x1_cm_bias_c__cc1_0.x1_m31d
X0 x1_cm_bias_c__cc1_0.x1_m25d x1_cm_bias_c__cc1_0.x1_m25d x1_cm_bias_c__cc1_0.x1_m25d VDD sky130_fd_pr__pfet_01v8 ad=0.406 pd=3.38 as=8.12 ps=67.6 w=1.4 l=0.6
X1 VSS VSS VSS VSS sky130_fd_pr__nfet_01v8 ad=0.406 pd=3.38 as=173.362 ps=1.44326k w=1.4 l=0.6
X2 x2_cm_tail__cc6_0.x2_m4d x2_cm_casc__cc6_0.bias_d op VSS sky130_fd_pr__nfet_01v8 ad=0.406 pd=3.38 as=0.406 ps=3.38 w=1.4 l=0.6
X3 x2_diff__cc1_0.x2_tail cmc VSS VSS sky130_fd_pr__nfet_01v8 ad=0.406 pd=3.38 as=0.406 ps=3.38 w=1.4 l=0.6
X4 x2_cm_casc__cc6_0.bias_d x1_single_m3__f1_0.x1_m2d x1_single_m3__f1_0.x1_m2d VSS sky130_fd_pr__nfet_01v8 ad=0.406 pd=3.38 as=0.406 ps=3.38 w=1.4 l=0.6
X5 x2_cm_casc__cc6_0.bias_d x1_single_m3__f1_0.x1_m2d x1_single_m3__f1_0.x1_m2d VSS sky130_fd_pr__nfet_01v8 ad=0.406 pd=3.38 as=0.406 ps=3.38 w=1.4 l=0.6
X6 x1_single_m5__f3_0.x1_m5d x1_single_m5__f3_0.x1_m5d x1_single_m5__f3_0.x1_m5d VSS sky130_fd_pr__nfet_01v8 ad=0.406 pd=3.38 as=21.924 ps=182.52 w=1.4 l=0.6
X7 VSS cmc x2_diff__cc1_0.x2_tail VSS sky130_fd_pr__nfet_01v8 ad=0.406 pd=3.38 as=0.406 ps=3.38 w=1.4 l=0.6
X8 x2_cl_casc__cc1_0.bias_c x2_cl_src__id4_0.bias_b x2_cl_src__id4_0.bias_b VSS sky130_fd_pr__nfet_01v8_lvt ad=0.406 pd=3.38 as=0.406 ps=3.38 w=1.4 l=0.6
X9 x2_diff__cc1_0.x2_tail cmc VSS VSS sky130_fd_pr__nfet_01v8 ad=0.406 pd=3.38 as=0.406 ps=3.38 w=1.4 l=0.6
X10 x2_diff__cc1_0.x2_tail x2_diff__cc1_0.x2_tail x2_diff__cc1_0.x2_tail VSS sky130_fd_pr__nfet_01v8 ad=0.406 pd=3.38 as=87.812 ps=732.03998 w=1.4 l=0.6
X11 x2_diff__cc1_0.x2_tail x2_diff__cc1_0.x2_tail x2_diff__cc1_0.x2_tail VSS sky130_fd_pr__nfet_01v8 ad=0.406 pd=3.38 as=0 ps=0 w=1.4 l=0.6
X12 IBIAS IBIAS VSS VSS sky130_fd_pr__nfet_01v8 ad=0.406 pd=3.38 as=0.406 ps=3.38 w=1.4 l=0.6
X13 x2_diff__cc1_0.x2_foldp x2_cl_src__id4_0.bias_b VDD VDD sky130_fd_pr__pfet_01v8_lvt ad=0.406 pd=3.38 as=0.406 ps=3.38 w=1.4 l=0.6
X14 x1_single_m5__f3_0.x1_m5d x1_single_m5__f3_0.x1_m5d x1_single_m5__f3_0.x1_m5d VSS sky130_fd_pr__nfet_01v8 ad=0.406 pd=3.38 as=0 ps=0 w=1.4 l=0.6
X15 VSS VSS x2_cm_tail__cc6_0.x2_m3d VSS sky130_fd_pr__nfet_01v8 ad=0.406 pd=3.38 as=0.406 ps=3.38 w=1.4 l=0.6
X16 x2_cl_src__id4_0.bias_b x2_cl_src__id4_0.bias_b x2_cl_casc__cc1_0.bias_c VSS sky130_fd_pr__nfet_01v8_lvt ad=0.406 pd=3.38 as=0.406 ps=3.38 w=1.4 l=0.6
X17 VSS cmc x2_diff__cc1_0.x2_tail VSS sky130_fd_pr__nfet_01v8 ad=0.406 pd=3.38 as=0.406 ps=3.38 w=1.4 l=0.6
X18 cm cm cm VSS sky130_fd_pr__nfet_01v8 ad=0.406 pd=3.38 as=8.526 ps=70.98 w=1.4 l=0.6
X19 VDD VDD VDD VDD sky130_fd_pr__pfet_01v8_lvt ad=0.406 pd=3.38 as=52.78 ps=439.39999 w=1.4 l=0.6
X20 x2_diff__cc1_0.x2_tail bias_a VSS VSS sky130_fd_pr__nfet_01v8 ad=0.406 pd=3.38 as=0.406 ps=3.38 w=1.4 l=0.6
X21 x1_cc_cm__strings1_0.x1_net1 cm cm VSS sky130_fd_pr__nfet_01v8 ad=0.406 pd=3.38 as=0.406 ps=3.38 w=1.4 l=0.6
X22 x1_cc_cm__strings1_0.x1_net8 cm x1_cc_cm__strings1_0.x1_net9 VSS sky130_fd_pr__nfet_01v8 ad=0.406 pd=3.38 as=0.406 ps=3.38 w=1.4 l=0.6
X23 x1_single_m5__f3_0.x1_m5d x1_single_m5__f3_0.x1_m5d x1_single_m5__f3_0.x1_m5d VSS sky130_fd_pr__nfet_01v8 ad=0.406 pd=3.38 as=0 ps=0 w=1.4 l=0.6
X24 x2_diff__cc1_0.x2_tail cmc VSS VSS sky130_fd_pr__nfet_01v8 ad=0.406 pd=3.38 as=0.406 ps=3.38 w=1.4 l=0.6
X25 VSS cmc x2_diff__cc1_0.x2_tail VSS sky130_fd_pr__nfet_01v8 ad=0.406 pd=3.38 as=0.406 ps=3.38 w=1.4 l=0.6
X26 VDD x2_cl_src__id4_0.bias_b x2_diff__cc1_0.x2_foldn VDD sky130_fd_pr__pfet_01v8_lvt ad=0.406 pd=3.38 as=0.406 ps=3.38 w=1.4 l=0.6
X27 x1_cc_cm__strings1_0.x1_net2 cm x1_cc_cm__strings1_0.x1_net1 VSS sky130_fd_pr__nfet_01v8 ad=0.406 pd=3.38 as=0.406 ps=3.38 w=1.4 l=0.6
X28 x2_diff__cc1_0.x2_foldn in x2_diff__cc1_0.x2_tail VSS sky130_fd_pr__nfet_01v8_lvt ad=0.348 pd=2.98 as=0.348 ps=2.98 w=1.2 l=0.2
X29 VSS VSS op VSS sky130_fd_pr__nfet_01v8 ad=0.406 pd=3.38 as=0.406 ps=3.38 w=1.4 l=0.6
X30 VSS VSS VSS VSS sky130_fd_pr__nfet_01v8 ad=0.406 pd=3.38 as=0 ps=0 w=1.4 l=0.6
X31 x2_diff__cc1_0.x2_tail bias_a VSS VSS sky130_fd_pr__nfet_01v8 ad=0.406 pd=3.38 as=0.406 ps=3.38 w=1.4 l=0.6
X32 x2_cl_casc__cc1_0.bias_c x2_cl_src__id4_0.bias_b x2_cl_src__id4_0.bias_b VSS sky130_fd_pr__nfet_01v8_lvt ad=0.406 pd=3.38 as=0.406 ps=3.38 w=1.4 l=0.6
X33 on x2_cm_casc__cc6_0.bias_d x2_cm_tail__cc6_0.x2_m3d VSS sky130_fd_pr__nfet_01v8 ad=0.406 pd=3.38 as=0.406 ps=3.38 w=1.4 l=0.6
X34 VSS bias_a x2_cm_tail__cc6_0.x2_m4d VSS sky130_fd_pr__nfet_01v8 ad=0.406 pd=3.38 as=0.406 ps=3.38 w=1.4 l=0.6
X35 x2_diff__cc1_0.x2_foldn x2_cl_casc__cc1_0.bias_c op VDD sky130_fd_pr__pfet_01v8 ad=0.406 pd=3.38 as=0.406 ps=3.38 w=1.4 l=0.6
X36 op x2_cm_casc__cc6_0.bias_d x2_cm_tail__cc6_0.x2_m4d VSS sky130_fd_pr__nfet_01v8 ad=0.406 pd=3.38 as=0.406 ps=3.38 w=1.4 l=0.6
X37 x2_cl_casc__cc1_0.bias_c x2_cl_src__id4_0.bias_b x2_cl_src__id4_0.bias_b VSS sky130_fd_pr__nfet_01v8_lvt ad=0.406 pd=3.38 as=0.406 ps=3.38 w=1.4 l=0.6
X38 VSS bias_a x2_diff__cc1_0.x2_tail VSS sky130_fd_pr__nfet_01v8 ad=0.406 pd=3.38 as=0.406 ps=3.38 w=1.4 l=0.6
X39 x2_cl_casc__cc1_0.bias_c IBIAS VSS VSS sky130_fd_pr__nfet_01v8 ad=0.406 pd=3.38 as=0.406 ps=3.38 w=1.4 l=0.6
X40 VSS bias_a x2_diff__cc1_0.x2_tail VSS sky130_fd_pr__nfet_01v8 ad=0.406 pd=3.38 as=0.406 ps=3.38 w=1.4 l=0.6
X41 x1_cm_bias_c__cc1_0.x1_m31d x2_cl_casc__cc1_0.bias_c cm VDD sky130_fd_pr__pfet_01v8 ad=0.406 pd=3.38 as=0.406 ps=3.38 w=1.4 l=0.6
X42 x2_diff__cc1_0.x2_tail bias_a VSS VSS sky130_fd_pr__nfet_01v8 ad=0.406 pd=3.38 as=0.406 ps=3.38 w=1.4 l=0.6
X43 x2_diff__cc1_0.x2_tail bias_a VSS VSS sky130_fd_pr__nfet_01v8 ad=0.406 pd=3.38 as=0.406 ps=3.38 w=1.4 l=0.6
X44 VSS cmc x2_diff__cc1_0.x2_tail VSS sky130_fd_pr__nfet_01v8 ad=0.406 pd=3.38 as=0.406 ps=3.38 w=1.4 l=0.6
X45 VSS bias_a x2_cm_tail__cc6_0.x2_m3d VSS sky130_fd_pr__nfet_01v8 ad=0.406 pd=3.38 as=0.406 ps=3.38 w=1.4 l=0.6
X46 x1_single_m3__f1_0.x1_m2d x1_single_m3__f1_0.x1_m2d x2_cm_casc__cc6_0.bias_d VSS sky130_fd_pr__nfet_01v8 ad=0.406 pd=3.38 as=0.406 ps=3.38 w=1.4 l=0.6
X47 x2_diff__cc1_0.x2_tail bias_a VSS VSS sky130_fd_pr__nfet_01v8 ad=0.406 pd=3.38 as=0.406 ps=3.38 w=1.4 l=0.6
X48 VSS cmc x2_diff__cc1_0.x2_tail VSS sky130_fd_pr__nfet_01v8 ad=0.406 pd=3.38 as=0.406 ps=3.38 w=1.4 l=0.6
X49 x2_cl_src__id4_0.bias_b x2_cl_casc__cc1_0.bias_c x1_cm_bias_c__cc1_0.x1_m21d VDD sky130_fd_pr__pfet_01v8 ad=0.406 pd=3.38 as=0.406 ps=3.38 w=1.4 l=0.6
X50 VSS IBIAS x2_cl_casc__cc1_0.bias_c VSS sky130_fd_pr__nfet_01v8 ad=0.406 pd=3.38 as=0.406 ps=3.38 w=1.4 l=0.6
X51 x2_cm_tail__cc6_0.x2_m3d bias_a VSS VSS sky130_fd_pr__nfet_01v8 ad=0.406 pd=3.38 as=0.406 ps=3.38 w=1.4 l=0.6
X52 x2_diff__cc1_0.x2_tail bias_a VSS VSS sky130_fd_pr__nfet_01v8 ad=0.406 pd=3.38 as=0.406 ps=3.38 w=1.4 l=0.6
X53 on x2_cm_casc__cc6_0.bias_d x2_cm_tail__cc6_0.x2_m3d VSS sky130_fd_pr__nfet_01v8 ad=0.406 pd=3.38 as=0.406 ps=3.38 w=1.4 l=0.6
X54 x2_diff__cc1_0.x2_tail x2_diff__cc1_0.x2_tail x2_diff__cc1_0.x2_tail VSS sky130_fd_pr__nfet_01v8 ad=0.406 pd=3.38 as=0 ps=0 w=1.4 l=0.6
X55 x1_single_m3__f1_0.x1_m2d x1_single_m3__f1_0.x1_m2d x2_cm_casc__cc6_0.bias_d VSS sky130_fd_pr__nfet_01v8 ad=0.406 pd=3.38 as=0.406 ps=3.38 w=1.4 l=0.6
X56 VDD x2_cl_src__id4_0.bias_b x2_diff__cc1_0.x2_foldp VDD sky130_fd_pr__pfet_01v8_lvt ad=0.406 pd=3.38 as=0.406 ps=3.38 w=1.4 l=0.6
X57 VSS IBIAS IBIAS VSS sky130_fd_pr__nfet_01v8 ad=0.406 pd=3.38 as=0.406 ps=3.38 w=1.4 l=0.6
X58 x2_cm_tail__cc6_0.x2_m4d x2_cm_casc__cc6_0.bias_d op VSS sky130_fd_pr__nfet_01v8 ad=0.406 pd=3.38 as=0.406 ps=3.38 w=1.4 l=0.6
X59 VSS VSS x2_cm_tail__cc6_0.x2_m4d VSS sky130_fd_pr__nfet_01v8 ad=0.406 pd=3.38 as=0.406 ps=3.38 w=1.4 l=0.6
X60 on cmc sky130_fd_pr__cap_mim_m3_1 l=4.8 w=4.8
X61 VDD VDD VDD VDD sky130_fd_pr__pfet_01v8 ad=0.406 pd=3.38 as=0 ps=0 w=1.4 l=0.6
X62 on x2_cl_casc__cc1_0.bias_c x2_diff__cc1_0.x2_foldp VDD sky130_fd_pr__pfet_01v8 ad=0.406 pd=3.38 as=0.406 ps=3.38 w=1.4 l=0.6
X63 VDD VDD on VDD sky130_fd_pr__pfet_01v8 ad=0.406 pd=3.38 as=0.406 ps=3.38 w=1.4 l=0.6
X64 x2_diff__cc1_0.x2_foldn x2_diff__cc1_0.x2_foldn x2_diff__cc1_0.x2_foldn VSS sky130_fd_pr__nfet_01v8_lvt ad=0.348 pd=2.98 as=3.48 ps=29.8 w=1.2 l=0.2
X65 VSS bias_a x2_cm_tail__cc6_0.x2_m4d VSS sky130_fd_pr__nfet_01v8 ad=0.406 pd=3.38 as=0.406 ps=3.38 w=1.4 l=0.6
X66 VSS cmc x2_diff__cc1_0.x2_tail VSS sky130_fd_pr__nfet_01v8 ad=0.406 pd=3.38 as=0.406 ps=3.38 w=1.4 l=0.6
X67 VDD VDD VDD VDD sky130_fd_pr__pfet_01v8 ad=0.406 pd=3.38 as=0 ps=0 w=1.4 l=0.6
X68 VSS VSS VSS VSS sky130_fd_pr__nfet_01v8 ad=0.406 pd=3.38 as=0 ps=0 w=1.4 l=0.6
X69 x2_cm_tail__cc6_0.x2_m4d x2_cm_casc__cc6_0.bias_d op VSS sky130_fd_pr__nfet_01v8 ad=0.406 pd=3.38 as=0.406 ps=3.38 w=1.4 l=0.6
X70 op x2_cm_casc__cc6_0.bias_d x2_cm_tail__cc6_0.x2_m4d VSS sky130_fd_pr__nfet_01v8 ad=0.406 pd=3.38 as=0.406 ps=3.38 w=1.4 l=0.6
X71 x2_diff__cc1_0.x2_foldn x2_diff__cc1_0.x2_foldn x2_diff__cc1_0.x2_foldn VDD sky130_fd_pr__pfet_01v8 ad=0.406 pd=3.38 as=20.3 ps=169 w=1.4 l=0.6
X72 x2_cm_tail__cc6_0.x2_m3d bias_a VSS VSS sky130_fd_pr__nfet_01v8 ad=0.406 pd=3.38 as=0.406 ps=3.38 w=1.4 l=0.6
X73 x2_cm_tail__cc6_0.x2_m3d bias_a VSS VSS sky130_fd_pr__nfet_01v8 ad=0.406 pd=3.38 as=0.406 ps=3.38 w=1.4 l=0.6
X74 x2_diff__cc1_0.x2_tail bias_a VSS VSS sky130_fd_pr__nfet_01v8 ad=0.406 pd=3.38 as=0.406 ps=3.38 w=1.4 l=0.6
X75 x2_cm_casc__cc6_0.bias_d x1_single_m3__f1_0.x1_m2d x1_single_m3__f1_0.x1_m2d VSS sky130_fd_pr__nfet_01v8 ad=0.406 pd=3.38 as=0.406 ps=3.38 w=1.4 l=0.6
X76 IBIAS IBIAS VSS VSS sky130_fd_pr__nfet_01v8 ad=0.406 pd=3.38 as=0.406 ps=3.38 w=1.4 l=0.6
X77 x2_cl_src__id4_0.bias_b x2_cl_src__id4_0.bias_b x2_cl_casc__cc1_0.bias_c VSS sky130_fd_pr__nfet_01v8_lvt ad=0.406 pd=3.38 as=0.406 ps=3.38 w=1.4 l=0.6
X78 VSS VSS VSS VSS sky130_fd_pr__nfet_01v8 ad=0.406 pd=3.38 as=0 ps=0 w=1.4 l=0.6
X79 x2_cm_tail__cc6_0.x2_m3d bias_a VSS VSS sky130_fd_pr__nfet_01v8 ad=0.406 pd=3.38 as=0.406 ps=3.38 w=1.4 l=0.6
X80 x2_cm_casc__cc6_0.bias_d x1_single_m3__f1_0.x1_m2d x1_single_m3__f1_0.x1_m2d VSS sky130_fd_pr__nfet_01v8 ad=0.406 pd=3.38 as=0.406 ps=3.38 w=1.4 l=0.6
X81 bias_a x2_cm_casc__cc6_0.bias_d x1_single_m5__f3_0.x1_m5d VSS sky130_fd_pr__nfet_01v8 ad=0.406 pd=3.38 as=0.406 ps=3.38 w=1.4 l=0.6
X82 x1_cm_bias_c__cc1_0.x1_m25d x1_cm_bias_c__cc1_0.x1_m25d x1_cm_bias_c__cc1_0.x1_m25d VDD sky130_fd_pr__pfet_01v8 ad=0.406 pd=3.38 as=0 ps=0 w=1.4 l=0.6
X83 x2_diff__cc1_0.x2_foldn x2_cl_src__id4_0.bias_b VDD VDD sky130_fd_pr__pfet_01v8_lvt ad=0.406 pd=3.38 as=0.406 ps=3.38 w=1.4 l=0.6
X84 VSS VSS VSS VSS sky130_fd_pr__nfet_01v8 ad=0.406 pd=3.38 as=0 ps=0 w=1.4 l=0.6
X85 x2_cm_casc__cc6_0.bias_d x1_single_m3__f1_0.x1_m2d x1_single_m3__f1_0.x1_m2d VSS sky130_fd_pr__nfet_01v8 ad=0.406 pd=3.38 as=0.406 ps=3.38 w=1.4 l=0.6
X86 x2_diff__cc1_0.x2_tail cmc VSS VSS sky130_fd_pr__nfet_01v8 ad=0.406 pd=3.38 as=0.406 ps=3.38 w=1.4 l=0.6
X87 IBIAS IBIAS VSS VSS sky130_fd_pr__nfet_01v8 ad=0.406 pd=3.38 as=0.406 ps=3.38 w=1.4 l=0.6
X88 VDD VDD x2_cl_src__id4_0.bias_b VDD sky130_fd_pr__pfet_01v8 ad=0.406 pd=3.38 as=0.406 ps=3.38 w=1.4 l=0.6
X89 x2_cl_casc__cc1_0.bias_c x2_cl_src__id4_0.bias_b x2_cl_src__id4_0.bias_b VSS sky130_fd_pr__nfet_01v8_lvt ad=0.406 pd=3.38 as=0.406 ps=3.38 w=1.4 l=0.6
X90 x2_cm_casc__cc6_0.bias_d x1_single_m3__f1_0.x1_m2d x1_single_m3__f1_0.x1_m2d VSS sky130_fd_pr__nfet_01v8 ad=0.406 pd=3.38 as=0.406 ps=3.38 w=1.4 l=0.6
X91 x2_diff__cc1_0.x2_tail bias_a VSS VSS sky130_fd_pr__nfet_01v8 ad=0.406 pd=3.38 as=0.406 ps=3.38 w=1.4 l=0.6
X92 x2_cl_casc__cc1_0.bias_c IBIAS VSS VSS sky130_fd_pr__nfet_01v8 ad=0.406 pd=3.38 as=0.406 ps=3.38 w=1.4 l=0.6
X93 x2_diff__cc1_0.x2_tail bias_a VSS VSS sky130_fd_pr__nfet_01v8 ad=0.406 pd=3.38 as=0.406 ps=3.38 w=1.4 l=0.6
X94 VDD VDD VDD VDD sky130_fd_pr__pfet_01v8 ad=0.406 pd=3.38 as=0 ps=0 w=1.4 l=0.6
X95 VSS bias_a x2_diff__cc1_0.x2_tail VSS sky130_fd_pr__nfet_01v8 ad=0.406 pd=3.38 as=0.406 ps=3.38 w=1.4 l=0.6
X96 x2_cm_casc__cc6_0.bias_d x2_cm_casc__cc6_0.bias_d x2_cm_casc__cc6_0.bias_d VSS sky130_fd_pr__nfet_01v8 ad=0.406 pd=3.38 as=27.608 ps=229.84 w=1.4 l=0.6
X97 VSS bias_a x2_diff__cc1_0.x2_tail VSS sky130_fd_pr__nfet_01v8 ad=0.406 pd=3.38 as=0.406 ps=3.38 w=1.4 l=0.6
X98 x2_cl_casc__cc1_0.bias_c x2_cl_src__id4_0.bias_b x2_cl_src__id4_0.bias_b VSS sky130_fd_pr__nfet_01v8_lvt ad=0.406 pd=3.38 as=0.406 ps=3.38 w=1.4 l=0.6
X99 VSS VSS on VSS sky130_fd_pr__nfet_01v8 ad=0.406 pd=3.38 as=0.406 ps=3.38 w=1.4 l=0.6
X100 VSS VSS VSS VSS sky130_fd_pr__nfet_01v8 ad=0.406 pd=3.38 as=0 ps=0 w=1.4 l=0.6
X101 x2_diff__cc1_0.x2_foldp x2_cl_casc__cc1_0.bias_c on VDD sky130_fd_pr__pfet_01v8 ad=0.406 pd=3.38 as=0.406 ps=3.38 w=1.4 l=0.6
X102 cm cm cm VSS sky130_fd_pr__nfet_01v8 ad=0.406 pd=3.38 as=0 ps=0 w=1.4 l=0.6
X103 x1_single_m5__f3_0.x1_m5d bias_a VSS VSS sky130_fd_pr__nfet_01v8 ad=0.406 pd=3.38 as=0.406 ps=3.38 w=1.4 l=0.6
X104 VSS VSS x1_single_m5__f3_0.x1_m5d VSS sky130_fd_pr__nfet_01v8 ad=0.406 pd=3.38 as=0.406 ps=3.38 w=1.4 l=0.6
X105 VDD x2_cl_src__id4_0.bias_b x1_cm_bias_c__cc1_0.x1_m21d VDD sky130_fd_pr__pfet_01v8_lvt ad=0.406 pd=3.38 as=0.406 ps=3.38 w=1.4 l=0.6
X106 VSS bias_a x2_diff__cc1_0.x2_tail VSS sky130_fd_pr__nfet_01v8 ad=0.406 pd=3.38 as=0.406 ps=3.38 w=1.4 l=0.6
X107 x2_cm_tail__cc6_0.x2_m3d x2_cm_casc__cc6_0.bias_d on VSS sky130_fd_pr__nfet_01v8 ad=0.406 pd=3.38 as=0.406 ps=3.38 w=1.4 l=0.6
X108 x1_cc_cm__strings1_0.x1_net3 cm x1_cc_cm__strings1_0.x1_net2 VSS sky130_fd_pr__nfet_01v8 ad=0.406 pd=3.38 as=0.406 ps=3.38 w=1.4 l=0.6
X109 cm cm x1_cc_cm__strings1_0.x1_net10 VSS sky130_fd_pr__nfet_01v8 ad=0.406 pd=3.38 as=0.406 ps=3.38 w=1.4 l=0.6
X110 x2_cm_tail__cc6_0.x2_m4d x2_cm_casc__cc6_0.bias_d op VSS sky130_fd_pr__nfet_01v8 ad=0.406 pd=3.38 as=0.406 ps=3.38 w=1.4 l=0.6
X111 op cmc sky130_fd_pr__cap_mim_m3_1 l=4.8 w=4.8
X112 VSS bias_a x2_diff__cc1_0.x2_tail VSS sky130_fd_pr__nfet_01v8 ad=0.406 pd=3.38 as=0.406 ps=3.38 w=1.4 l=0.6
X113 x2_diff__cc1_0.x2_tail cmc VSS VSS sky130_fd_pr__nfet_01v8 ad=0.406 pd=3.38 as=0.406 ps=3.38 w=1.4 l=0.6
X114 VDD VDD x1_single_m3__f1_0.x1_m2d VDD sky130_fd_pr__pfet_01v8 ad=0.406 pd=3.38 as=0.406 ps=3.38 w=1.4 l=0.6
X115 x2_diff__cc1_0.x2_foldn x2_cl_casc__cc1_0.bias_c op VDD sky130_fd_pr__pfet_01v8 ad=0.406 pd=3.38 as=0.406 ps=3.38 w=1.4 l=0.6
X116 x1_single_m5__f3_0.x1_m5d bias_a VSS VSS sky130_fd_pr__nfet_01v8 ad=0.406 pd=3.38 as=0.406 ps=3.38 w=1.4 l=0.6
X117 on cmc sky130_fd_pr__cap_mim_m3_1 l=4.8 w=4.8
X118 x2_diff__cc1_0.x2_tail x2_diff__cc1_0.x2_tail x2_diff__cc1_0.x2_tail VSS sky130_fd_pr__nfet_01v8 ad=0.406 pd=3.38 as=0 ps=0 w=1.4 l=0.6
X119 VSS VSS VSS VSS sky130_fd_pr__nfet_01v8 ad=0.406 pd=3.38 as=0 ps=0 w=1.4 l=0.6
X120 x2_diff__cc1_0.x2_tail cmc VSS VSS sky130_fd_pr__nfet_01v8 ad=0.406 pd=3.38 as=0.406 ps=3.38 w=1.4 l=0.6
X121 VDD x2_cl_src__id4_0.bias_b x2_diff__cc1_0.x2_foldn VDD sky130_fd_pr__pfet_01v8_lvt ad=0.406 pd=3.38 as=0.406 ps=3.38 w=1.4 l=0.6
X122 VDD VDD op VDD sky130_fd_pr__pfet_01v8 ad=0.406 pd=3.38 as=0.406 ps=3.38 w=1.4 l=0.6
X123 VSS bias_a x2_diff__cc1_0.x2_tail VSS sky130_fd_pr__nfet_01v8 ad=0.406 pd=3.38 as=0.406 ps=3.38 w=1.4 l=0.6
X124 x2_diff__cc1_0.x2_tail cmc VSS VSS sky130_fd_pr__nfet_01v8 ad=0.406 pd=3.38 as=0.406 ps=3.38 w=1.4 l=0.6
X125 x1_single_m3__f1_0.x1_m2d x2_cl_casc__cc1_0.bias_c x1_cm_bias_c__cc1_0.x1_m25d VDD sky130_fd_pr__pfet_01v8 ad=0.406 pd=3.38 as=0.406 ps=3.38 w=1.4 l=0.6
X126 VSS bias_a x2_cm_tail__cc6_0.x2_m3d VSS sky130_fd_pr__nfet_01v8 ad=0.406 pd=3.38 as=0.406 ps=3.38 w=1.4 l=0.6
X127 VSS bias_a x2_diff__cc1_0.x2_tail VSS sky130_fd_pr__nfet_01v8 ad=0.406 pd=3.38 as=0.406 ps=3.38 w=1.4 l=0.6
X128 x1_single_m3__f1_0.x1_m2d x1_single_m3__f1_0.x1_m2d x2_cm_casc__cc6_0.bias_d VSS sky130_fd_pr__nfet_01v8 ad=0.406 pd=3.38 as=0.406 ps=3.38 w=1.4 l=0.6
X129 VSS cmc x2_diff__cc1_0.x2_tail VSS sky130_fd_pr__nfet_01v8 ad=0.406 pd=3.38 as=0.406 ps=3.38 w=1.4 l=0.6
X130 op x2_cl_casc__cc1_0.bias_c x2_diff__cc1_0.x2_foldn VDD sky130_fd_pr__pfet_01v8 ad=0.406 pd=3.38 as=0.406 ps=3.38 w=1.4 l=0.6
X131 VDD VDD op VDD sky130_fd_pr__pfet_01v8 ad=0.406 pd=3.38 as=0.406 ps=3.38 w=1.4 l=0.6
X132 x2_cl_casc__cc1_0.bias_c x2_cl_src__id4_0.bias_b x2_cl_src__id4_0.bias_b VSS sky130_fd_pr__nfet_01v8_lvt ad=0.406 pd=3.38 as=0.406 ps=3.38 w=1.4 l=0.6
X133 on x2_cm_casc__cc6_0.bias_d x2_cm_tail__cc6_0.x2_m3d VSS sky130_fd_pr__nfet_01v8 ad=0.406 pd=3.38 as=0.406 ps=3.38 w=1.4 l=0.6
X134 VSS bias_a x2_diff__cc1_0.x2_tail VSS sky130_fd_pr__nfet_01v8 ad=0.406 pd=3.38 as=0.406 ps=3.38 w=1.4 l=0.6
X135 VDD VDD op VDD sky130_fd_pr__pfet_01v8 ad=0.406 pd=3.38 as=0.406 ps=3.38 w=1.4 l=0.6
X136 VSS VSS x2_diff__cc1_0.x2_tail VSS sky130_fd_pr__nfet_01v8 ad=0.406 pd=3.38 as=0.406 ps=3.38 w=1.4 l=0.6
X137 VSS bias_a x2_cm_tail__cc6_0.x2_m4d VSS sky130_fd_pr__nfet_01v8 ad=0.406 pd=3.38 as=0.406 ps=3.38 w=1.4 l=0.6
X138 VSS IBIAS IBIAS VSS sky130_fd_pr__nfet_01v8 ad=0.406 pd=3.38 as=0.406 ps=3.38 w=1.4 l=0.6
X139 x1_single_m3__f1_0.x1_m2d x1_single_m3__f1_0.x1_m2d x2_cm_casc__cc6_0.bias_d VSS sky130_fd_pr__nfet_01v8 ad=0.406 pd=3.38 as=0.406 ps=3.38 w=1.4 l=0.6
X140 VSS bias_a x1_single_m5__f3_0.x1_m5d VSS sky130_fd_pr__nfet_01v8 ad=0.406 pd=3.38 as=0.406 ps=3.38 w=1.4 l=0.6
X141 VSS bias_a x2_cm_tail__cc6_0.x2_m4d VSS sky130_fd_pr__nfet_01v8 ad=0.406 pd=3.38 as=0.406 ps=3.38 w=1.4 l=0.6
X142 VDD x2_cl_src__id4_0.bias_b x2_diff__cc1_0.x2_foldp VDD sky130_fd_pr__pfet_01v8_lvt ad=0.406 pd=3.38 as=0.406 ps=3.38 w=1.4 l=0.6
X143 x2_cm_tail__cc6_0.x2_m4d bias_a VSS VSS sky130_fd_pr__nfet_01v8 ad=0.406 pd=3.38 as=0.406 ps=3.38 w=1.4 l=0.6
X144 x2_cl_src__id4_0.bias_b x2_cl_src__id4_0.bias_b x2_cl_casc__cc1_0.bias_c VSS sky130_fd_pr__nfet_01v8_lvt ad=0.406 pd=3.38 as=0.406 ps=3.38 w=1.4 l=0.6
X145 on x2_cm_casc__cc6_0.bias_d x2_cm_tail__cc6_0.x2_m3d VSS sky130_fd_pr__nfet_01v8 ad=0.406 pd=3.38 as=0.406 ps=3.38 w=1.4 l=0.6
X146 op x2_cm_casc__cc6_0.bias_d x2_cm_tail__cc6_0.x2_m4d VSS sky130_fd_pr__nfet_01v8 ad=0.406 pd=3.38 as=0.406 ps=3.38 w=1.4 l=0.6
X147 x1_single_m3__f1_0.x1_m2d x1_single_m3__f1_0.x1_m2d x2_cm_casc__cc6_0.bias_d VSS sky130_fd_pr__nfet_01v8 ad=0.406 pd=3.38 as=0.406 ps=3.38 w=1.4 l=0.6
X148 x2_cm_tail__cc6_0.x2_m3d x2_cm_casc__cc6_0.bias_d on VSS sky130_fd_pr__nfet_01v8 ad=0.406 pd=3.38 as=0.406 ps=3.38 w=1.4 l=0.6
X149 x1_single_m5__f3_0.x1_m5d x2_cm_casc__cc6_0.bias_d bias_a VSS sky130_fd_pr__nfet_01v8 ad=0.406 pd=3.38 as=0.406 ps=3.38 w=1.4 l=0.6
X150 VSS bias_a x2_diff__cc1_0.x2_tail VSS sky130_fd_pr__nfet_01v8 ad=0.406 pd=3.38 as=0.406 ps=3.38 w=1.4 l=0.6
X151 x2_diff__cc1_0.x2_tail cmc VSS VSS sky130_fd_pr__nfet_01v8 ad=0.406 pd=3.38 as=0.406 ps=3.38 w=1.4 l=0.6
X152 x2_diff__cc1_0.x2_foldn x2_cl_casc__cc1_0.bias_c op VDD sky130_fd_pr__pfet_01v8 ad=0.406 pd=3.38 as=0.406 ps=3.38 w=1.4 l=0.6
X153 x2_cl_casc__cc1_0.bias_c IBIAS VSS VSS sky130_fd_pr__nfet_01v8 ad=0.406 pd=3.38 as=0.406 ps=3.38 w=1.4 l=0.6
X154 x2_cm_tail__cc6_0.x2_m4d bias_a VSS VSS sky130_fd_pr__nfet_01v8 ad=0.406 pd=3.38 as=0.406 ps=3.38 w=1.4 l=0.6
X155 VSS bias_a x2_cm_tail__cc6_0.x2_m3d VSS sky130_fd_pr__nfet_01v8 ad=0.406 pd=3.38 as=0.406 ps=3.38 w=1.4 l=0.6
X156 VDD x2_cl_src__id4_0.bias_b x1_cm_bias_c__cc1_0.x1_m31d VDD sky130_fd_pr__pfet_01v8_lvt ad=0.406 pd=3.38 as=0.406 ps=3.38 w=1.4 l=0.6
X157 VDD VDD on VDD sky130_fd_pr__pfet_01v8 ad=0.406 pd=3.38 as=0.406 ps=3.38 w=1.4 l=0.6
X158 VSS VSS VSS VSS sky130_fd_pr__nfet_01v8 ad=0.406 pd=3.38 as=0 ps=0 w=1.4 l=0.6
X159 x2_cm_tail__cc6_0.x2_m4d bias_a VSS VSS sky130_fd_pr__nfet_01v8 ad=0.406 pd=3.38 as=0.406 ps=3.38 w=1.4 l=0.6
X160 VSS bias_a x2_diff__cc1_0.x2_tail VSS sky130_fd_pr__nfet_01v8 ad=0.406 pd=3.38 as=0.406 ps=3.38 w=1.4 l=0.6
X161 on x2_cm_casc__cc6_0.bias_d x2_cm_tail__cc6_0.x2_m3d VSS sky130_fd_pr__nfet_01v8 ad=0.406 pd=3.38 as=0.406 ps=3.38 w=1.4 l=0.6
X162 x2_cl_casc__cc1_0.bias_c x2_cl_src__id4_0.bias_b x2_cl_src__id4_0.bias_b VSS sky130_fd_pr__nfet_01v8_lvt ad=0.406 pd=3.38 as=0.406 ps=3.38 w=1.4 l=0.6
X163 VSS cmc x2_diff__cc1_0.x2_tail VSS sky130_fd_pr__nfet_01v8 ad=0.406 pd=3.38 as=0.406 ps=3.38 w=1.4 l=0.6
X164 x2_cm_tail__cc6_0.x2_m4d bias_a VSS VSS sky130_fd_pr__nfet_01v8 ad=0.406 pd=3.38 as=0.406 ps=3.38 w=1.4 l=0.6
X165 x2_diff__cc1_0.x2_tail x2_diff__cc1_0.x2_tail x2_diff__cc1_0.x2_tail VSS sky130_fd_pr__nfet_01v8 ad=0.406 pd=3.38 as=0 ps=0 w=1.4 l=0.6
X166 VDD VDD VDD VDD sky130_fd_pr__pfet_01v8 ad=0.406 pd=3.38 as=0 ps=0 w=1.4 l=0.6
X167 VSS VSS VSS VSS sky130_fd_pr__nfet_01v8 ad=0.406 pd=3.38 as=0 ps=0 w=1.4 l=0.6
X168 x2_diff__cc1_0.x2_tail cmc VSS VSS sky130_fd_pr__nfet_01v8 ad=0.406 pd=3.38 as=0.406 ps=3.38 w=1.4 l=0.6
X169 x2_diff__cc1_0.x2_tail cmc VSS VSS sky130_fd_pr__nfet_01v8 ad=0.406 pd=3.38 as=0.406 ps=3.38 w=1.4 l=0.6
X170 x2_cm_tail__cc6_0.x2_m4d bias_a VSS VSS sky130_fd_pr__nfet_01v8 ad=0.406 pd=3.38 as=0.406 ps=3.38 w=1.4 l=0.6
X171 x1_single_m3__f1_0.x1_m2d x1_single_m3__f1_0.x1_m2d x2_cm_casc__cc6_0.bias_d VSS sky130_fd_pr__nfet_01v8 ad=0.406 pd=3.38 as=0.406 ps=3.38 w=1.4 l=0.6
X172 bias_a x2_cm_casc__cc6_0.bias_d x1_single_m5__f3_0.x1_m5d VSS sky130_fd_pr__nfet_01v8 ad=0.406 pd=3.38 as=0.406 ps=3.38 w=1.4 l=0.6
X173 x2_cl_src__id4_0.bias_b x2_cl_casc__cc1_0.bias_c x1_cm_bias_c__cc1_0.x1_m21d VDD sky130_fd_pr__pfet_01v8 ad=0.406 pd=3.38 as=0.406 ps=3.38 w=1.4 l=0.6
X174 x2_cl_src__id4_0.bias_b x2_cl_src__id4_0.bias_b x2_cl_casc__cc1_0.bias_c VSS sky130_fd_pr__nfet_01v8_lvt ad=0.406 pd=3.38 as=0.406 ps=3.38 w=1.4 l=0.6
X175 VSS VSS VSS VSS sky130_fd_pr__nfet_01v8 ad=0.406 pd=3.38 as=0 ps=0 w=1.4 l=0.6
X176 x2_diff__cc1_0.x2_tail bias_a VSS VSS sky130_fd_pr__nfet_01v8 ad=0.406 pd=3.38 as=0.406 ps=3.38 w=1.4 l=0.6
X177 VSS cmc x2_diff__cc1_0.x2_tail VSS sky130_fd_pr__nfet_01v8 ad=0.406 pd=3.38 as=0.406 ps=3.38 w=1.4 l=0.6
X178 x2_diff__cc1_0.x2_foldn x2_cl_src__id4_0.bias_b VDD VDD sky130_fd_pr__pfet_01v8_lvt ad=0.406 pd=3.38 as=0.406 ps=3.38 w=1.4 l=0.6
X179 x1_single_m3__f1_0.x1_m2d x1_single_m3__f1_0.x1_m2d x2_cm_casc__cc6_0.bias_d VSS sky130_fd_pr__nfet_01v8 ad=0.406 pd=3.38 as=0.406 ps=3.38 w=1.4 l=0.6
X180 VSS VSS x2_diff__cc1_0.x2_tail VSS sky130_fd_pr__nfet_01v8 ad=0.406 pd=3.38 as=0.406 ps=3.38 w=1.4 l=0.6
X181 x2_diff__cc1_0.x2_tail cmc VSS VSS sky130_fd_pr__nfet_01v8 ad=0.406 pd=3.38 as=0.406 ps=3.38 w=1.4 l=0.6
X182 x1_cm_bias_c__cc1_0.x1_m25d x2_cl_src__id4_0.bias_b VDD VDD sky130_fd_pr__pfet_01v8_lvt ad=0.406 pd=3.38 as=0.406 ps=3.38 w=1.4 l=0.6
X183 x2_cl_casc__cc1_0.bias_c x2_cl_src__id4_0.bias_b x2_cl_src__id4_0.bias_b VSS sky130_fd_pr__nfet_01v8_lvt ad=0.406 pd=3.38 as=0.406 ps=3.38 w=1.4 l=0.6
X184 VSS cmc x2_diff__cc1_0.x2_tail VSS sky130_fd_pr__nfet_01v8 ad=0.406 pd=3.38 as=0.406 ps=3.38 w=1.4 l=0.6
X185 VDD x2_cl_src__id4_0.bias_b x1_cm_bias_c__cc1_0.x1_m25d VDD sky130_fd_pr__pfet_01v8_lvt ad=0.406 pd=3.38 as=0.406 ps=3.38 w=1.4 l=0.6
X186 x2_diff__cc1_0.x2_foldp x2_cl_src__id4_0.bias_b VDD VDD sky130_fd_pr__pfet_01v8_lvt ad=0.406 pd=3.38 as=0.406 ps=3.38 w=1.4 l=0.6
X187 x2_cl_src__id4_0.bias_b x2_cl_src__id4_0.bias_b x2_cl_src__id4_0.bias_b VSS sky130_fd_pr__nfet_01v8_lvt ad=0.406 pd=3.38 as=29.232 ps=243.36 w=1.4 l=0.6
X188 x2_cm_tail__cc6_0.x2_m3d x2_cm_casc__cc6_0.bias_d on VSS sky130_fd_pr__nfet_01v8 ad=0.406 pd=3.38 as=0.406 ps=3.38 w=1.4 l=0.6
X189 x2_cm_tail__cc6_0.x2_m4d x2_cm_casc__cc6_0.bias_d op VSS sky130_fd_pr__nfet_01v8 ad=0.406 pd=3.38 as=0.406 ps=3.38 w=1.4 l=0.6
X190 VDD x2_cl_src__id4_0.bias_b x2_diff__cc1_0.x2_foldp VDD sky130_fd_pr__pfet_01v8_lvt ad=0.406 pd=3.38 as=0.406 ps=3.38 w=1.4 l=0.6
X191 x2_cl_casc__cc1_0.bias_c x2_cl_src__id4_0.bias_b x2_cl_src__id4_0.bias_b VSS sky130_fd_pr__nfet_01v8_lvt ad=0.406 pd=3.38 as=0.406 ps=3.38 w=1.4 l=0.6
X192 x2_diff__cc1_0.x2_foldp x2_cl_casc__cc1_0.bias_c on VDD sky130_fd_pr__pfet_01v8 ad=0.406 pd=3.38 as=0.406 ps=3.38 w=1.4 l=0.6
X193 cm x2_cl_casc__cc1_0.bias_c x1_cm_bias_c__cc1_0.x1_m31d VDD sky130_fd_pr__pfet_01v8 ad=0.406 pd=3.38 as=0.406 ps=3.38 w=1.4 l=0.6
X194 on cmc sky130_fd_pr__cap_mim_m3_1 l=4.8 w=4.8
X195 VSS bias_a x2_diff__cc1_0.x2_tail VSS sky130_fd_pr__nfet_01v8 ad=0.406 pd=3.38 as=0.406 ps=3.38 w=1.4 l=0.6
X196 op x2_cl_casc__cc1_0.bias_c x2_diff__cc1_0.x2_foldn VDD sky130_fd_pr__pfet_01v8 ad=0.406 pd=3.38 as=0.406 ps=3.38 w=1.4 l=0.6
X197 x1_cc_cm__strings1_0.x1_net10 cm x1_cc_cm__strings1_0.x1_net11 VSS sky130_fd_pr__nfet_01v8 ad=0.406 pd=3.38 as=0.406 ps=3.38 w=1.4 l=0.6
X198 x2_cl_casc__cc1_0.bias_c x2_cl_casc__cc1_0.bias_c x2_cl_casc__cc1_0.bias_c VSS sky130_fd_pr__nfet_01v8 ad=0.406 pd=3.38 as=38.164 ps=317.72 w=1.4 l=0.6
X199 VSS VSS VSS VSS sky130_fd_pr__nfet_01v8 ad=0.406 pd=3.38 as=0 ps=0 w=1.4 l=0.6
X200 VSS bias_a x2_diff__cc1_0.x2_tail VSS sky130_fd_pr__nfet_01v8 ad=0.406 pd=3.38 as=0.406 ps=3.38 w=1.4 l=0.6
X201 x2_diff__cc1_0.x2_tail bias_a VSS VSS sky130_fd_pr__nfet_01v8 ad=0.406 pd=3.38 as=0.406 ps=3.38 w=1.4 l=0.6
X202 VSS bias_a x2_cm_tail__cc6_0.x2_m3d VSS sky130_fd_pr__nfet_01v8 ad=0.406 pd=3.38 as=0.406 ps=3.38 w=1.4 l=0.6
X203 x1_cc_cm__strings1_0.x1_net11 cm x1_cc_cm__strings1_0.x1_net12 VSS sky130_fd_pr__nfet_01v8 ad=0.406 pd=3.38 as=0.406 ps=3.38 w=1.4 l=0.6
X204 x2_cm_tail__cc6_0.x2_m4d x2_cm_casc__cc6_0.bias_d op VSS sky130_fd_pr__nfet_01v8 ad=0.406 pd=3.38 as=0.406 ps=3.38 w=1.4 l=0.6
X205 x2_cm_tail__cc6_0.x2_m3d x2_cm_casc__cc6_0.bias_d on VSS sky130_fd_pr__nfet_01v8 ad=0.406 pd=3.38 as=0.406 ps=3.38 w=1.4 l=0.6
X206 bias_a bias_a bias_a VSS sky130_fd_pr__nfet_01v8 ad=0.406 pd=3.38 as=11.368 ps=94.64 w=1.4 l=0.6
X207 VSS bias_a x2_cm_tail__cc6_0.x2_m4d VSS sky130_fd_pr__nfet_01v8 ad=0.406 pd=3.38 as=0.406 ps=3.38 w=1.4 l=0.6
X208 VSS cmc x2_diff__cc1_0.x2_tail VSS sky130_fd_pr__nfet_01v8 ad=0.406 pd=3.38 as=0.406 ps=3.38 w=1.4 l=0.6
X209 x2_diff__cc1_0.x2_tail bias_a VSS VSS sky130_fd_pr__nfet_01v8 ad=0.406 pd=3.38 as=0.406 ps=3.38 w=1.4 l=0.6
X210 VDD x2_cl_src__id4_0.bias_b x2_diff__cc1_0.x2_foldn VDD sky130_fd_pr__pfet_01v8_lvt ad=0.406 pd=3.38 as=0.406 ps=3.38 w=1.4 l=0.6
X211 VSS VSS VSS VSS sky130_fd_pr__nfet_01v8 ad=0.406 pd=3.38 as=0 ps=0 w=1.4 l=0.6
X212 VSS cmc x2_diff__cc1_0.x2_tail VSS sky130_fd_pr__nfet_01v8 ad=0.406 pd=3.38 as=0.406 ps=3.38 w=1.4 l=0.6
X213 VSS VSS VSS VSS sky130_fd_pr__nfet_01v8 ad=0.406 pd=3.38 as=0 ps=0 w=1.4 l=0.6
X214 on x2_cl_casc__cc1_0.bias_c x2_diff__cc1_0.x2_foldp VDD sky130_fd_pr__pfet_01v8 ad=0.406 pd=3.38 as=0.406 ps=3.38 w=1.4 l=0.6
X215 op x2_cm_casc__cc6_0.bias_d x2_cm_tail__cc6_0.x2_m4d VSS sky130_fd_pr__nfet_01v8 ad=0.406 pd=3.38 as=0.406 ps=3.38 w=1.4 l=0.6
X216 VSS cmc x2_diff__cc1_0.x2_tail VSS sky130_fd_pr__nfet_01v8 ad=0.406 pd=3.38 as=0.406 ps=3.38 w=1.4 l=0.6
X217 on x2_cm_casc__cc6_0.bias_d x2_cm_tail__cc6_0.x2_m3d VSS sky130_fd_pr__nfet_01v8 ad=0.406 pd=3.38 as=0.406 ps=3.38 w=1.4 l=0.6
X218 x2_diff__cc1_0.x2_foldp ip x2_diff__cc1_0.x2_tail VSS sky130_fd_pr__nfet_01v8_lvt ad=0.348 pd=2.98 as=0.348 ps=2.98 w=1.2 l=0.2
X219 VSS VSS VSS VSS sky130_fd_pr__nfet_01v8 ad=0.406 pd=3.38 as=0 ps=0 w=1.4 l=0.6
X220 VSS bias_a x1_single_m5__f3_0.x1_m5d VSS sky130_fd_pr__nfet_01v8 ad=0.406 pd=3.38 as=0.406 ps=3.38 w=1.4 l=0.6
X221 x2_diff__cc1_0.x2_foldp x2_cl_casc__cc1_0.bias_c on VDD sky130_fd_pr__pfet_01v8 ad=0.406 pd=3.38 as=0.406 ps=3.38 w=1.4 l=0.6
X222 x2_diff__cc1_0.x2_tail cmc VSS VSS sky130_fd_pr__nfet_01v8 ad=0.406 pd=3.38 as=0.406 ps=3.38 w=1.4 l=0.6
X223 x2_diff__cc1_0.x2_tail cmc VSS VSS sky130_fd_pr__nfet_01v8 ad=0.406 pd=3.38 as=0.406 ps=3.38 w=1.4 l=0.6
X224 VSS bias_a x2_cm_tail__cc6_0.x2_m4d VSS sky130_fd_pr__nfet_01v8 ad=0.406 pd=3.38 as=0.406 ps=3.38 w=1.4 l=0.6
X225 VSS IBIAS IBIAS VSS sky130_fd_pr__nfet_01v8 ad=0.406 pd=3.38 as=0.406 ps=3.38 w=1.4 l=0.6
X226 bias_a x1_single_m3__f1_0.x1_m2d x2_cm_casc__cc6_0.bias_d VSS sky130_fd_pr__nfet_01v8 ad=0.406 pd=3.38 as=0.406 ps=3.38 w=1.4 l=0.6
X227 x2_diff__cc1_0.x2_tail cmc VSS VSS sky130_fd_pr__nfet_01v8 ad=0.406 pd=3.38 as=0.406 ps=3.38 w=1.4 l=0.6
X228 VSS VSS VSS VSS sky130_fd_pr__nfet_01v8 ad=0.406 pd=3.38 as=0 ps=0 w=1.4 l=0.6
X229 x2_diff__cc1_0.x2_tail bias_a VSS VSS sky130_fd_pr__nfet_01v8 ad=0.406 pd=3.38 as=0.406 ps=3.38 w=1.4 l=0.6
X230 x2_cl_src__id4_0.bias_b x2_cl_src__id4_0.bias_b x2_cl_casc__cc1_0.bias_c VSS sky130_fd_pr__nfet_01v8_lvt ad=0.406 pd=3.38 as=0.406 ps=3.38 w=1.4 l=0.6
X231 x2_diff__cc1_0.x2_tail bias_a VSS VSS sky130_fd_pr__nfet_01v8 ad=0.406 pd=3.38 as=0.406 ps=3.38 w=1.4 l=0.6
X232 VDD x2_cl_src__id4_0.bias_b x2_diff__cc1_0.x2_foldn VDD sky130_fd_pr__pfet_01v8_lvt ad=0.406 pd=3.38 as=0.406 ps=3.38 w=1.4 l=0.6
X233 IBIAS IBIAS VSS VSS sky130_fd_pr__nfet_01v8 ad=0.406 pd=3.38 as=0.406 ps=3.38 w=1.4 l=0.6
X234 op x2_cm_casc__cc6_0.bias_d x2_cm_tail__cc6_0.x2_m4d VSS sky130_fd_pr__nfet_01v8 ad=0.406 pd=3.38 as=0.406 ps=3.38 w=1.4 l=0.6
X235 VDD VDD x2_diff__cc1_0.x2_foldp VDD sky130_fd_pr__pfet_01v8 ad=0.406 pd=3.38 as=0.406 ps=3.38 w=1.4 l=0.6
X236 x1_single_m5__f3_0.x1_m5d x2_cm_casc__cc6_0.bias_d bias_a VSS sky130_fd_pr__nfet_01v8 ad=0.406 pd=3.38 as=0.406 ps=3.38 w=1.4 l=0.6
X237 VSS bias_a x2_cm_tail__cc6_0.x2_m4d VSS sky130_fd_pr__nfet_01v8 ad=0.406 pd=3.38 as=0.406 ps=3.38 w=1.4 l=0.6
X238 x2_cm_tail__cc6_0.x2_m3d bias_a VSS VSS sky130_fd_pr__nfet_01v8 ad=0.406 pd=3.38 as=0.406 ps=3.38 w=1.4 l=0.6
X239 x1_single_m3__f1_0.x1_m2d x2_cl_casc__cc1_0.bias_c x1_cm_bias_c__cc1_0.x1_m25d VDD sky130_fd_pr__pfet_01v8 ad=0.406 pd=3.38 as=0.406 ps=3.38 w=1.4 l=0.6
X240 VSS cmc x2_diff__cc1_0.x2_tail VSS sky130_fd_pr__nfet_01v8 ad=0.406 pd=3.38 as=0.406 ps=3.38 w=1.4 l=0.6
X241 VSS VSS op VSS sky130_fd_pr__nfet_01v8 ad=0.406 pd=3.38 as=0.406 ps=3.38 w=1.4 l=0.6
X242 x2_diff__cc1_0.x2_foldp x2_diff__cc1_0.x2_foldp x2_diff__cc1_0.x2_foldp VSS sky130_fd_pr__nfet_01v8_lvt ad=0.348 pd=2.98 as=3.48 ps=29.8 w=1.2 l=0.2
X243 x2_cl_src__id4_0.bias_b x2_cl_src__id4_0.bias_b x2_cl_src__id4_0.bias_b VSS sky130_fd_pr__nfet_01v8_lvt ad=0.406 pd=3.38 as=0 ps=0 w=1.4 l=0.6
X244 VDD VDD x2_diff__cc1_0.x2_foldn VDD sky130_fd_pr__pfet_01v8 ad=0.406 pd=3.38 as=0.406 ps=3.38 w=1.4 l=0.6
X245 VSS VSS VSS VSS sky130_fd_pr__nfet_01v8 ad=0.406 pd=3.38 as=0 ps=0 w=1.4 l=0.6
X246 on x2_cm_casc__cc6_0.bias_d x2_cm_tail__cc6_0.x2_m3d VSS sky130_fd_pr__nfet_01v8 ad=0.406 pd=3.38 as=0.406 ps=3.38 w=1.4 l=0.6
X247 x2_diff__cc1_0.x2_foldp x2_cl_src__id4_0.bias_b VDD VDD sky130_fd_pr__pfet_01v8_lvt ad=0.406 pd=3.38 as=0.406 ps=3.38 w=1.4 l=0.6
X248 x2_diff__cc1_0.x2_tail bias_a VSS VSS sky130_fd_pr__nfet_01v8 ad=0.406 pd=3.38 as=0.406 ps=3.38 w=1.4 l=0.6
X249 x2_cl_casc__cc1_0.bias_c x2_cl_src__id4_0.bias_b x2_cl_src__id4_0.bias_b VSS sky130_fd_pr__nfet_01v8_lvt ad=0.406 pd=3.38 as=0.406 ps=3.38 w=1.4 l=0.6
X250 x2_diff__cc1_0.x2_tail bias_a VSS VSS sky130_fd_pr__nfet_01v8 ad=0.406 pd=3.38 as=0.406 ps=3.38 w=1.4 l=0.6
X251 x2_cm_casc__cc6_0.bias_d x2_cm_casc__cc6_0.bias_d x2_cm_casc__cc6_0.bias_d VSS sky130_fd_pr__nfet_01v8 ad=0.406 pd=3.38 as=0 ps=0 w=1.4 l=0.6
X252 x2_diff__cc1_0.x2_tail bias_a VSS VSS sky130_fd_pr__nfet_01v8 ad=0.406 pd=3.38 as=0.406 ps=3.38 w=1.4 l=0.6
X253 x2_diff__cc1_0.x2_tail cmc VSS VSS sky130_fd_pr__nfet_01v8 ad=0.406 pd=3.38 as=0.406 ps=3.38 w=1.4 l=0.6
X254 x1_single_m3__f1_0.x1_m2d x1_single_m3__f1_0.x1_m2d x2_cm_casc__cc6_0.bias_d VSS sky130_fd_pr__nfet_01v8 ad=0.406 pd=3.38 as=0.406 ps=3.38 w=1.4 l=0.6
X255 x2_cl_src__id4_0.bias_b x2_cl_src__id4_0.bias_b x2_cl_casc__cc1_0.bias_c VSS sky130_fd_pr__nfet_01v8_lvt ad=0.406 pd=3.38 as=0.406 ps=3.38 w=1.4 l=0.6
X256 VSS VSS VSS VSS sky130_fd_pr__nfet_01v8 ad=0.406 pd=3.38 as=0 ps=0 w=1.4 l=0.6
X257 x2_diff__cc1_0.x2_tail bias_a VSS VSS sky130_fd_pr__nfet_01v8 ad=0.406 pd=3.38 as=0.406 ps=3.38 w=1.4 l=0.6
X258 x1_single_m3__f1_0.x1_m2d x1_single_m3__f1_0.x1_m2d x2_cm_casc__cc6_0.bias_d VSS sky130_fd_pr__nfet_01v8 ad=0.406 pd=3.38 as=0.406 ps=3.38 w=1.4 l=0.6
X259 bias_a x2_cm_casc__cc6_0.bias_d x1_single_m5__f3_0.x1_m5d VSS sky130_fd_pr__nfet_01v8 ad=0.406 pd=3.38 as=0.406 ps=3.38 w=1.4 l=0.6
X260 VSS bias_a x2_diff__cc1_0.x2_tail VSS sky130_fd_pr__nfet_01v8 ad=0.406 pd=3.38 as=0.406 ps=3.38 w=1.4 l=0.6
X261 VSS VSS x2_cm_tail__cc6_0.x2_m3d VSS sky130_fd_pr__nfet_01v8 ad=0.406 pd=3.38 as=0.406 ps=3.38 w=1.4 l=0.6
X262 VDD x2_cl_src__id4_0.bias_b x1_cm_bias_c__cc1_0.x1_m25d VDD sky130_fd_pr__pfet_01v8_lvt ad=0.406 pd=3.38 as=0.406 ps=3.38 w=1.4 l=0.6
X263 VSS VSS VSS VSS sky130_fd_pr__nfet_01v8 ad=0.406 pd=3.38 as=0 ps=0 w=1.4 l=0.6
X264 x1_single_m3__f1_0.x1_m2d x1_single_m3__f1_0.x1_m2d x2_cm_casc__cc6_0.bias_d VSS sky130_fd_pr__nfet_01v8 ad=0.406 pd=3.38 as=0.406 ps=3.38 w=1.4 l=0.6
X265 x2_diff__cc1_0.x2_foldn x2_cl_src__id4_0.bias_b VDD VDD sky130_fd_pr__pfet_01v8_lvt ad=0.406 pd=3.38 as=0.406 ps=3.38 w=1.4 l=0.6
X266 x2_cl_src__id4_0.bias_b x2_cl_src__id4_0.bias_b x2_cl_src__id4_0.bias_b VSS sky130_fd_pr__nfet_01v8_lvt ad=0.406 pd=3.38 as=0 ps=0 w=1.4 l=0.6
X267 on x2_cl_casc__cc1_0.bias_c x2_diff__cc1_0.x2_foldp VDD sky130_fd_pr__pfet_01v8 ad=0.406 pd=3.38 as=0.406 ps=3.38 w=1.4 l=0.6
X268 x2_diff__cc1_0.x2_foldn x2_cl_casc__cc1_0.bias_c op VDD sky130_fd_pr__pfet_01v8 ad=0.406 pd=3.38 as=0.406 ps=3.38 w=1.4 l=0.6
X269 x1_single_m3__f1_0.x1_m2d x1_single_m3__f1_0.x1_m2d x2_cm_casc__cc6_0.bias_d VSS sky130_fd_pr__nfet_01v8 ad=0.406 pd=3.38 as=0.406 ps=3.38 w=1.4 l=0.6
X270 VSS bias_a x2_diff__cc1_0.x2_tail VSS sky130_fd_pr__nfet_01v8 ad=0.406 pd=3.38 as=0.406 ps=3.38 w=1.4 l=0.6
X271 x2_diff__cc1_0.x2_tail cmc VSS VSS sky130_fd_pr__nfet_01v8 ad=0.406 pd=3.38 as=0.406 ps=3.38 w=1.4 l=0.6
X272 x1_cm_bias_c__cc1_0.x1_m31d x1_cm_bias_c__cc1_0.x1_m31d x1_cm_bias_c__cc1_0.x1_m31d VDD sky130_fd_pr__pfet_01v8_lvt ad=0.406 pd=3.38 as=7.308 ps=60.84 w=1.4 l=0.6
X273 x2_cm_casc__cc6_0.bias_d x1_single_m3__f1_0.x1_m2d x1_single_m3__f1_0.x1_m2d VSS sky130_fd_pr__nfet_01v8 ad=0.406 pd=3.38 as=0.406 ps=3.38 w=1.4 l=0.6
X274 x2_cl_casc__cc1_0.bias_c x2_cl_src__id4_0.bias_b x2_cl_src__id4_0.bias_b VSS sky130_fd_pr__nfet_01v8_lvt ad=0.406 pd=3.38 as=0.406 ps=3.38 w=1.4 l=0.6
X275 x2_diff__cc1_0.x2_tail cmc VSS VSS sky130_fd_pr__nfet_01v8 ad=0.406 pd=3.38 as=0.406 ps=3.38 w=1.4 l=0.6
X276 VSS VSS x1_single_m5__f3_0.x1_m5d VSS sky130_fd_pr__nfet_01v8 ad=0.406 pd=3.38 as=0.406 ps=3.38 w=1.4 l=0.6
X277 x2_diff__cc1_0.x2_tail in x2_diff__cc1_0.x2_foldn VSS sky130_fd_pr__nfet_01v8_lvt ad=0.348 pd=2.98 as=0.348 ps=2.98 w=1.2 l=0.2
X278 x2_cm_tail__cc6_0.x2_m3d x2_cm_casc__cc6_0.bias_d on VSS sky130_fd_pr__nfet_01v8 ad=0.406 pd=3.38 as=0.406 ps=3.38 w=1.4 l=0.6
X279 VSS cmc x2_diff__cc1_0.x2_tail VSS sky130_fd_pr__nfet_01v8 ad=0.406 pd=3.38 as=0.406 ps=3.38 w=1.4 l=0.6
X280 x2_diff__cc1_0.x2_foldp x2_cl_src__id4_0.bias_b VDD VDD sky130_fd_pr__pfet_01v8_lvt ad=0.406 pd=3.38 as=0.406 ps=3.38 w=1.4 l=0.6
X281 VSS cmc x2_diff__cc1_0.x2_tail VSS sky130_fd_pr__nfet_01v8 ad=0.406 pd=3.38 as=0.406 ps=3.38 w=1.4 l=0.6
X282 x2_cm_tail__cc6_0.x2_m4d x2_cm_casc__cc6_0.bias_d op VSS sky130_fd_pr__nfet_01v8 ad=0.406 pd=3.38 as=0.406 ps=3.38 w=1.4 l=0.6
X283 x1_cc_cm__strings1_0.x1_net4 cm cm VSS sky130_fd_pr__nfet_01v8 ad=0.406 pd=3.38 as=0.406 ps=3.38 w=1.4 l=0.6
X284 VSS cmc x2_diff__cc1_0.x2_tail VSS sky130_fd_pr__nfet_01v8 ad=0.406 pd=3.38 as=0.406 ps=3.38 w=1.4 l=0.6
X285 IBIAS IBIAS IBIAS VSS sky130_fd_pr__nfet_01v8 ad=0.406 pd=3.38 as=8.932 ps=74.36 w=1.4 l=0.6
X286 x2_cm_casc__cc6_0.bias_d x1_single_m3__f1_0.x1_m2d x1_single_m3__f1_0.x1_m2d VSS sky130_fd_pr__nfet_01v8 ad=0.406 pd=3.38 as=0.406 ps=3.38 w=1.4 l=0.6
X287 VDD VDD VDD VDD sky130_fd_pr__pfet_01v8_lvt ad=0.406 pd=3.38 as=0 ps=0 w=1.4 l=0.6
X288 x1_cc_cm__strings1_0.x1_net14 cm x1_cc_cm__strings1_0.x1_net13 VSS sky130_fd_pr__nfet_01v8 ad=0.406 pd=3.38 as=0.406 ps=3.38 w=1.4 l=0.6
X289 x1_cc_cm__strings1_0.x1_net12 cm VSS VSS sky130_fd_pr__nfet_01v8 ad=0.406 pd=3.38 as=0.406 ps=3.38 w=1.4 l=0.6
X290 VSS IBIAS IBIAS VSS sky130_fd_pr__nfet_01v8 ad=0.406 pd=3.38 as=0.406 ps=3.38 w=1.4 l=0.6
X291 x2_cm_tail__cc6_0.x2_m3d x2_cm_casc__cc6_0.bias_d on VSS sky130_fd_pr__nfet_01v8 ad=0.406 pd=3.38 as=0.406 ps=3.38 w=1.4 l=0.6
X292 VSS bias_a x2_cm_tail__cc6_0.x2_m3d VSS sky130_fd_pr__nfet_01v8 ad=0.406 pd=3.38 as=0.406 ps=3.38 w=1.4 l=0.6
X293 cm cm cm VSS sky130_fd_pr__nfet_01v8 ad=0.406 pd=3.38 as=0 ps=0 w=1.4 l=0.6
X294 VSS IBIAS x2_cl_casc__cc1_0.bias_c VSS sky130_fd_pr__nfet_01v8 ad=0.406 pd=3.38 as=0.406 ps=3.38 w=1.4 l=0.6
X295 VSS bias_a x2_diff__cc1_0.x2_tail VSS sky130_fd_pr__nfet_01v8 ad=0.406 pd=3.38 as=0.406 ps=3.38 w=1.4 l=0.6
X296 x2_diff__cc1_0.x2_tail cmc VSS VSS sky130_fd_pr__nfet_01v8 ad=0.406 pd=3.38 as=0.406 ps=3.38 w=1.4 l=0.6
X297 VSS bias_a x1_single_m5__f3_0.x1_m5d VSS sky130_fd_pr__nfet_01v8 ad=0.406 pd=3.38 as=0.406 ps=3.38 w=1.4 l=0.6
X298 VDD x2_cl_src__id4_0.bias_b x2_diff__cc1_0.x2_foldp VDD sky130_fd_pr__pfet_01v8_lvt ad=0.406 pd=3.38 as=0.406 ps=3.38 w=1.4 l=0.6
X299 VSS VSS x2_cm_tail__cc6_0.x2_m3d VSS sky130_fd_pr__nfet_01v8 ad=0.406 pd=3.38 as=0.406 ps=3.38 w=1.4 l=0.6
X300 x2_cm_casc__cc6_0.bias_d x1_single_m3__f1_0.x1_m2d x1_single_m3__f1_0.x1_m2d VSS sky130_fd_pr__nfet_01v8 ad=0.406 pd=3.38 as=0.406 ps=3.38 w=1.4 l=0.6
X301 x2_diff__cc1_0.x2_tail bias_a VSS VSS sky130_fd_pr__nfet_01v8 ad=0.406 pd=3.38 as=0.406 ps=3.38 w=1.4 l=0.6
X302 VSS bias_a x2_cm_tail__cc6_0.x2_m3d VSS sky130_fd_pr__nfet_01v8 ad=0.406 pd=3.38 as=0.406 ps=3.38 w=1.4 l=0.6
X303 VSS IBIAS x2_cl_casc__cc1_0.bias_c VSS sky130_fd_pr__nfet_01v8 ad=0.406 pd=3.38 as=0.406 ps=3.38 w=1.4 l=0.6
X304 x1_single_m5__f3_0.x1_m5d bias_a VSS VSS sky130_fd_pr__nfet_01v8 ad=0.406 pd=3.38 as=0.406 ps=3.38 w=1.4 l=0.6
X305 x2_diff__cc1_0.x2_tail bias_a VSS VSS sky130_fd_pr__nfet_01v8 ad=0.406 pd=3.38 as=0.406 ps=3.38 w=1.4 l=0.6
X306 x2_cm_tail__cc6_0.x2_m3d x2_cm_casc__cc6_0.bias_d on VSS sky130_fd_pr__nfet_01v8 ad=0.406 pd=3.38 as=0.406 ps=3.38 w=1.4 l=0.6
X307 x2_cl_casc__cc1_0.bias_c x2_cl_casc__cc1_0.bias_c x2_cl_casc__cc1_0.bias_c VSS sky130_fd_pr__nfet_01v8_lvt ad=0.406 pd=3.38 as=0 ps=0 w=1.4 l=0.6
X308 x2_cm_tail__cc6_0.x2_m3d bias_a VSS VSS sky130_fd_pr__nfet_01v8 ad=0.406 pd=3.38 as=0.406 ps=3.38 w=1.4 l=0.6
X309 VSS bias_a x2_diff__cc1_0.x2_tail VSS sky130_fd_pr__nfet_01v8 ad=0.406 pd=3.38 as=0.406 ps=3.38 w=1.4 l=0.6
X310 VSS bias_a x2_diff__cc1_0.x2_tail VSS sky130_fd_pr__nfet_01v8 ad=0.406 pd=3.38 as=0.406 ps=3.38 w=1.4 l=0.6
X311 VDD VDD VDD VDD sky130_fd_pr__pfet_01v8_lvt ad=0.406 pd=3.38 as=0 ps=0 w=1.4 l=0.6
X312 x2_cl_src__id4_0.bias_b x2_cl_src__id4_0.bias_b x2_cl_casc__cc1_0.bias_c VSS sky130_fd_pr__nfet_01v8_lvt ad=0.406 pd=3.38 as=0.406 ps=3.38 w=1.4 l=0.6
X313 VSS bias_a x2_diff__cc1_0.x2_tail VSS sky130_fd_pr__nfet_01v8 ad=0.406 pd=3.38 as=0.406 ps=3.38 w=1.4 l=0.6
X314 x2_diff__cc1_0.x2_tail in x2_diff__cc1_0.x2_foldn VSS sky130_fd_pr__nfet_01v8_lvt ad=0.348 pd=2.98 as=0.348 ps=2.98 w=1.2 l=0.2
X315 on x2_cm_casc__cc6_0.bias_d x2_cm_tail__cc6_0.x2_m3d VSS sky130_fd_pr__nfet_01v8 ad=0.406 pd=3.38 as=0.406 ps=3.38 w=1.4 l=0.6
X316 VSS VSS on VSS sky130_fd_pr__nfet_01v8 ad=0.406 pd=3.38 as=0.406 ps=3.38 w=1.4 l=0.6
X317 x2_cl_src__id4_0.bias_b x2_cl_src__id4_0.bias_b x2_cl_src__id4_0.bias_b VSS sky130_fd_pr__nfet_01v8_lvt ad=0.406 pd=3.38 as=0 ps=0 w=1.4 l=0.6
X318 x1_single_m5__f3_0.x1_m5d x2_cm_casc__cc6_0.bias_d bias_a VSS sky130_fd_pr__nfet_01v8 ad=0.406 pd=3.38 as=0.406 ps=3.38 w=1.4 l=0.6
X319 VSS bias_a x2_cm_tail__cc6_0.x2_m3d VSS sky130_fd_pr__nfet_01v8 ad=0.406 pd=3.38 as=0.406 ps=3.38 w=1.4 l=0.6
X320 x2_cm_tail__cc6_0.x2_m4d bias_a VSS VSS sky130_fd_pr__nfet_01v8 ad=0.406 pd=3.38 as=0.406 ps=3.38 w=1.4 l=0.6
X321 x2_cl_casc__cc1_0.bias_c x2_cl_src__id4_0.bias_b x2_cl_src__id4_0.bias_b VSS sky130_fd_pr__nfet_01v8_lvt ad=0.406 pd=3.38 as=0.406 ps=3.38 w=1.4 l=0.6
X322 IBIAS IBIAS VSS VSS sky130_fd_pr__nfet_01v8 ad=0.406 pd=3.38 as=0.406 ps=3.38 w=1.4 l=0.6
X323 VSS VSS x2_cm_tail__cc6_0.x2_m3d VSS sky130_fd_pr__nfet_01v8 ad=0.406 pd=3.38 as=0.406 ps=3.38 w=1.4 l=0.6
X324 x2_diff__cc1_0.x2_foldp x2_diff__cc1_0.x2_foldp x2_diff__cc1_0.x2_foldp VDD sky130_fd_pr__pfet_01v8 ad=0.406 pd=3.38 as=20.3 ps=169 w=1.4 l=0.6
X325 x2_diff__cc1_0.x2_foldn x2_cl_src__id4_0.bias_b VDD VDD sky130_fd_pr__pfet_01v8_lvt ad=0.406 pd=3.38 as=0.406 ps=3.38 w=1.4 l=0.6
X326 VDD x2_cl_src__id4_0.bias_b x2_diff__cc1_0.x2_foldp VDD sky130_fd_pr__pfet_01v8_lvt ad=0.406 pd=3.38 as=0.406 ps=3.38 w=1.4 l=0.6
X327 x2_diff__cc1_0.x2_foldp x2_cl_casc__cc1_0.bias_c on VDD sky130_fd_pr__pfet_01v8 ad=0.406 pd=3.38 as=0.406 ps=3.38 w=1.4 l=0.6
X328 x2_cl_casc__cc1_0.bias_c x2_cl_casc__cc1_0.bias_c x2_cl_casc__cc1_0.bias_c VSS sky130_fd_pr__nfet_01v8 ad=0.406 pd=3.38 as=0 ps=0 w=1.4 l=0.6
X329 VSS VSS VSS VSS sky130_fd_pr__nfet_01v8 ad=0.406 pd=3.38 as=0 ps=0 w=1.4 l=0.6
X330 x2_diff__cc1_0.x2_tail cmc VSS VSS sky130_fd_pr__nfet_01v8 ad=0.406 pd=3.38 as=0.406 ps=3.38 w=1.4 l=0.6
X331 op x2_cm_casc__cc6_0.bias_d x2_cm_tail__cc6_0.x2_m4d VSS sky130_fd_pr__nfet_01v8 ad=0.406 pd=3.38 as=0.406 ps=3.38 w=1.4 l=0.6
X332 x2_diff__cc1_0.x2_tail cmc VSS VSS sky130_fd_pr__nfet_01v8 ad=0.406 pd=3.38 as=0.406 ps=3.38 w=1.4 l=0.6
X333 x2_cl_casc__cc1_0.bias_c x2_cl_src__id4_0.bias_b x2_cl_src__id4_0.bias_b VSS sky130_fd_pr__nfet_01v8_lvt ad=0.406 pd=3.38 as=0.406 ps=3.38 w=1.4 l=0.6
X334 x2_diff__cc1_0.x2_tail cmc VSS VSS sky130_fd_pr__nfet_01v8 ad=0.406 pd=3.38 as=0.406 ps=3.38 w=1.4 l=0.6
X335 x2_diff__cc1_0.x2_foldp x2_cl_src__id4_0.bias_b VDD VDD sky130_fd_pr__pfet_01v8_lvt ad=0.406 pd=3.38 as=0.406 ps=3.38 w=1.4 l=0.6
X336 VSS VSS VSS VSS sky130_fd_pr__nfet_01v8 ad=0.406 pd=3.38 as=0 ps=0 w=1.4 l=0.6
X337 x1_cm_bias_c__cc1_0.x1_m25d x2_cl_casc__cc1_0.bias_c x1_single_m3__f1_0.x1_m2d VDD sky130_fd_pr__pfet_01v8 ad=0.406 pd=3.38 as=0.406 ps=3.38 w=1.4 l=0.6
X338 x2_cm_casc__cc6_0.bias_d x2_cm_casc__cc6_0.bias_d x2_cm_casc__cc6_0.bias_d VSS sky130_fd_pr__nfet_01v8 ad=0.406 pd=3.38 as=0 ps=0 w=1.4 l=0.6
X339 x2_cm_tail__cc6_0.x2_m3d bias_a VSS VSS sky130_fd_pr__nfet_01v8 ad=0.406 pd=3.38 as=0.406 ps=3.38 w=1.4 l=0.6
X340 x1_single_m3__f1_0.x1_m2d x1_single_m3__f1_0.x1_m2d x2_cm_casc__cc6_0.bias_d VSS sky130_fd_pr__nfet_01v8 ad=0.406 pd=3.38 as=0.406 ps=3.38 w=1.4 l=0.6
X341 bias_a x2_cm_casc__cc6_0.bias_d x1_single_m5__f3_0.x1_m5d VSS sky130_fd_pr__nfet_01v8 ad=0.406 pd=3.38 as=0.406 ps=3.38 w=1.4 l=0.6
X342 x1_single_m5__f3_0.x1_m5d x1_single_m5__f3_0.x1_m5d x1_single_m5__f3_0.x1_m5d VSS sky130_fd_pr__nfet_01v8 ad=0.406 pd=3.38 as=0 ps=0 w=1.4 l=0.6
X343 x2_cl_src__id4_0.bias_b x2_cl_src__id4_0.bias_b x2_cl_casc__cc1_0.bias_c VSS sky130_fd_pr__nfet_01v8_lvt ad=0.406 pd=3.38 as=0.406 ps=3.38 w=1.4 l=0.6
X344 VSS VSS VSS VSS sky130_fd_pr__nfet_01v8 ad=0.406 pd=3.38 as=0 ps=0 w=1.4 l=0.6
X345 op x2_cm_casc__cc6_0.bias_d x2_cm_tail__cc6_0.x2_m4d VSS sky130_fd_pr__nfet_01v8 ad=0.406 pd=3.38 as=0.406 ps=3.38 w=1.4 l=0.6
X346 x1_single_m3__f1_0.x1_m2d x1_single_m3__f1_0.x1_m2d x2_cm_casc__cc6_0.bias_d VSS sky130_fd_pr__nfet_01v8 ad=0.406 pd=3.38 as=0.406 ps=3.38 w=1.4 l=0.6
X347 op x2_cl_casc__cc1_0.bias_c x2_diff__cc1_0.x2_foldn VDD sky130_fd_pr__pfet_01v8 ad=0.406 pd=3.38 as=0.406 ps=3.38 w=1.4 l=0.6
X348 x2_diff__cc1_0.x2_tail in x2_diff__cc1_0.x2_foldn VSS sky130_fd_pr__nfet_01v8_lvt ad=0.348 pd=2.98 as=0.348 ps=2.98 w=1.2 l=0.2
X349 x1_single_m5__f3_0.x1_m5d x1_single_m5__f3_0.x1_m5d x1_single_m5__f3_0.x1_m5d VSS sky130_fd_pr__nfet_01v8 ad=0.406 pd=3.38 as=0 ps=0 w=1.4 l=0.6
X350 x2_diff__cc1_0.x2_foldn x2_cl_src__id4_0.bias_b VDD VDD sky130_fd_pr__pfet_01v8_lvt ad=0.406 pd=3.38 as=0.406 ps=3.38 w=1.4 l=0.6
X351 VSS VSS VSS VSS sky130_fd_pr__nfet_01v8 ad=0.406 pd=3.38 as=0 ps=0 w=1.4 l=0.6
X352 x2_diff__cc1_0.x2_tail bias_a VSS VSS sky130_fd_pr__nfet_01v8 ad=0.406 pd=3.38 as=0.406 ps=3.38 w=1.4 l=0.6
X353 x2_cm_casc__cc6_0.bias_d x1_single_m3__f1_0.x1_m2d x1_single_m3__f1_0.x1_m2d VSS sky130_fd_pr__nfet_01v8 ad=0.406 pd=3.38 as=0.406 ps=3.38 w=1.4 l=0.6
X354 x2_diff__cc1_0.x2_tail bias_a VSS VSS sky130_fd_pr__nfet_01v8 ad=0.406 pd=3.38 as=0.406 ps=3.38 w=1.4 l=0.6
X355 x2_cm_tail__cc6_0.x2_m4d bias_a VSS VSS sky130_fd_pr__nfet_01v8 ad=0.406 pd=3.38 as=0.406 ps=3.38 w=1.4 l=0.6
X356 x1_cm_bias_c__cc1_0.x1_m31d x2_cl_src__id4_0.bias_b VDD VDD sky130_fd_pr__pfet_01v8_lvt ad=0.406 pd=3.38 as=0.406 ps=3.38 w=1.4 l=0.6
X357 x2_cm_tail__cc6_0.x2_m4d bias_a VSS VSS sky130_fd_pr__nfet_01v8 ad=0.406 pd=3.38 as=0.406 ps=3.38 w=1.4 l=0.6
X358 x2_cm_casc__cc6_0.bias_d x1_single_m3__f1_0.x1_m2d x1_single_m3__f1_0.x1_m2d VSS sky130_fd_pr__nfet_01v8 ad=0.406 pd=3.38 as=0.406 ps=3.38 w=1.4 l=0.6
X359 x2_cm_tail__cc6_0.x2_m3d x2_cm_casc__cc6_0.bias_d on VSS sky130_fd_pr__nfet_01v8 ad=0.406 pd=3.38 as=0.406 ps=3.38 w=1.4 l=0.6
X360 on x2_cl_casc__cc1_0.bias_c x2_diff__cc1_0.x2_foldp VDD sky130_fd_pr__pfet_01v8 ad=0.406 pd=3.38 as=0.406 ps=3.38 w=1.4 l=0.6
X361 x1_cc_cm__strings1_0.x1_net5 cm x1_cc_cm__strings1_0.x1_net4 VSS sky130_fd_pr__nfet_01v8 ad=0.406 pd=3.38 as=0.406 ps=3.38 w=1.4 l=0.6
X362 x2_cl_casc__cc1_0.bias_c x2_cl_src__id4_0.bias_b x2_cl_src__id4_0.bias_b VSS sky130_fd_pr__nfet_01v8_lvt ad=0.406 pd=3.38 as=0.406 ps=3.38 w=1.4 l=0.6
X363 bias_a bias_a bias_a VSS sky130_fd_pr__nfet_01v8 ad=0.406 pd=3.38 as=0 ps=0 w=1.4 l=0.6
X364 x2_cm_casc__cc6_0.bias_d x1_single_m3__f1_0.x1_m2d x1_single_m3__f1_0.x1_m2d VSS sky130_fd_pr__nfet_01v8 ad=0.406 pd=3.38 as=0.406 ps=3.38 w=1.4 l=0.6
X365 x2_cl_casc__cc1_0.bias_c IBIAS VSS VSS sky130_fd_pr__nfet_01v8 ad=0.406 pd=3.38 as=0.406 ps=3.38 w=1.4 l=0.6
X366 VSS cmc x2_diff__cc1_0.x2_tail VSS sky130_fd_pr__nfet_01v8 ad=0.406 pd=3.38 as=0.406 ps=3.38 w=1.4 l=0.6
X367 VSS IBIAS x2_cl_casc__cc1_0.bias_c VSS sky130_fd_pr__nfet_01v8 ad=0.406 pd=3.38 as=0.406 ps=3.38 w=1.4 l=0.6
X368 x2_cm_casc__cc6_0.bias_d x1_single_m3__f1_0.x1_m2d x1_single_m3__f1_0.x1_m2d VSS sky130_fd_pr__nfet_01v8 ad=0.406 pd=3.38 as=0.406 ps=3.38 w=1.4 l=0.6
X369 VSS bias_a x2_diff__cc1_0.x2_tail VSS sky130_fd_pr__nfet_01v8 ad=0.406 pd=3.38 as=0.406 ps=3.38 w=1.4 l=0.6
X370 VSS cmc x2_diff__cc1_0.x2_tail VSS sky130_fd_pr__nfet_01v8 ad=0.406 pd=3.38 as=0.406 ps=3.38 w=1.4 l=0.6
X371 VSS bias_a x2_cm_tail__cc6_0.x2_m4d VSS sky130_fd_pr__nfet_01v8 ad=0.406 pd=3.38 as=0.406 ps=3.38 w=1.4 l=0.6
X372 x2_cl_casc__cc1_0.bias_c x2_cl_src__id4_0.bias_b x2_cl_src__id4_0.bias_b VSS sky130_fd_pr__nfet_01v8_lvt ad=0.406 pd=3.38 as=0.406 ps=3.38 w=1.4 l=0.6
X373 cm cm cm VSS sky130_fd_pr__nfet_01v8 ad=0.406 pd=3.38 as=0 ps=0 w=1.4 l=0.6
X374 op x2_cm_casc__cc6_0.bias_d x2_cm_tail__cc6_0.x2_m4d VSS sky130_fd_pr__nfet_01v8 ad=0.406 pd=3.38 as=0.406 ps=3.38 w=1.4 l=0.6
X375 x2_cm_tail__cc6_0.x2_m4d x2_cm_casc__cc6_0.bias_d op VSS sky130_fd_pr__nfet_01v8 ad=0.406 pd=3.38 as=0.406 ps=3.38 w=1.4 l=0.6
X376 x2_diff__cc1_0.x2_tail bias_a VSS VSS sky130_fd_pr__nfet_01v8 ad=0.406 pd=3.38 as=0.406 ps=3.38 w=1.4 l=0.6
X377 VSS cmc x2_diff__cc1_0.x2_tail VSS sky130_fd_pr__nfet_01v8 ad=0.406 pd=3.38 as=0.406 ps=3.38 w=1.4 l=0.6
X378 x2_diff__cc1_0.x2_foldp x2_cl_src__id4_0.bias_b VDD VDD sky130_fd_pr__pfet_01v8_lvt ad=0.406 pd=3.38 as=0.406 ps=3.38 w=1.4 l=0.6
X379 VSS IBIAS IBIAS VSS sky130_fd_pr__nfet_01v8 ad=0.406 pd=3.38 as=0.406 ps=3.38 w=1.4 l=0.6
X380 op op op VSS sky130_fd_pr__nfet_01v8 ad=0.406 pd=3.38 as=17.052 ps=141.96001 w=1.4 l=0.6
X381 cm cm cm VSS sky130_fd_pr__nfet_01v8 ad=0.406 pd=3.38 as=0 ps=0 w=1.4 l=0.6
X382 x2_diff__cc1_0.x2_tail bias_a VSS VSS sky130_fd_pr__nfet_01v8 ad=0.406 pd=3.38 as=0.406 ps=3.38 w=1.4 l=0.6
X383 x1_cm_bias_c__cc1_0.x1_m31d x2_cl_casc__cc1_0.bias_c cm VDD sky130_fd_pr__pfet_01v8 ad=0.406 pd=3.38 as=0.406 ps=3.38 w=1.4 l=0.6
X384 VSS cmc x2_diff__cc1_0.x2_tail VSS sky130_fd_pr__nfet_01v8 ad=0.406 pd=3.38 as=0.406 ps=3.38 w=1.4 l=0.6
X385 VSS cmc x2_diff__cc1_0.x2_tail VSS sky130_fd_pr__nfet_01v8 ad=0.406 pd=3.38 as=0.406 ps=3.38 w=1.4 l=0.6
X386 VSS bias_a x2_cm_tail__cc6_0.x2_m4d VSS sky130_fd_pr__nfet_01v8 ad=0.406 pd=3.38 as=0.406 ps=3.38 w=1.4 l=0.6
X387 x2_cm_casc__cc6_0.bias_d x1_single_m3__f1_0.x1_m2d x1_single_m3__f1_0.x1_m2d VSS sky130_fd_pr__nfet_01v8 ad=0.406 pd=3.38 as=0.406 ps=3.38 w=1.4 l=0.6
X388 x2_cm_tail__cc6_0.x2_m3d bias_a VSS VSS sky130_fd_pr__nfet_01v8 ad=0.406 pd=3.38 as=0.406 ps=3.38 w=1.4 l=0.6
X389 x1_single_m5__f3_0.x1_m5d bias_a VSS VSS sky130_fd_pr__nfet_01v8 ad=0.406 pd=3.38 as=0.406 ps=3.38 w=1.4 l=0.6
X390 VSS cmc x2_diff__cc1_0.x2_tail VSS sky130_fd_pr__nfet_01v8 ad=0.406 pd=3.38 as=0.406 ps=3.38 w=1.4 l=0.6
X391 VSS cmc x2_diff__cc1_0.x2_tail VSS sky130_fd_pr__nfet_01v8 ad=0.406 pd=3.38 as=0.406 ps=3.38 w=1.4 l=0.6
X392 x2_diff__cc1_0.x2_foldn x2_cl_casc__cc1_0.bias_c op VDD sky130_fd_pr__pfet_01v8 ad=0.406 pd=3.38 as=0.406 ps=3.38 w=1.4 l=0.6
X393 VSS cmc x2_diff__cc1_0.x2_tail VSS sky130_fd_pr__nfet_01v8 ad=0.406 pd=3.38 as=0.406 ps=3.38 w=1.4 l=0.6
X394 VDD x2_cl_src__id4_0.bias_b x2_diff__cc1_0.x2_foldn VDD sky130_fd_pr__pfet_01v8_lvt ad=0.406 pd=3.38 as=0.406 ps=3.38 w=1.4 l=0.6
X395 x2_cm_tail__cc6_0.x2_m3d x2_cm_casc__cc6_0.bias_d on VSS sky130_fd_pr__nfet_01v8 ad=0.406 pd=3.38 as=0.406 ps=3.38 w=1.4 l=0.6
X396 x2_cl_src__id4_0.bias_b x2_cl_src__id4_0.bias_b x2_cl_casc__cc1_0.bias_c VSS sky130_fd_pr__nfet_01v8_lvt ad=0.406 pd=3.38 as=0.406 ps=3.38 w=1.4 l=0.6
X397 VSS bias_a x2_diff__cc1_0.x2_tail VSS sky130_fd_pr__nfet_01v8 ad=0.406 pd=3.38 as=0.406 ps=3.38 w=1.4 l=0.6
X398 op x2_cl_casc__cc1_0.bias_c x2_diff__cc1_0.x2_foldn VDD sky130_fd_pr__pfet_01v8 ad=0.406 pd=3.38 as=0.406 ps=3.38 w=1.4 l=0.6
X399 cm cm cm VSS sky130_fd_pr__nfet_01v8 ad=0.406 pd=3.38 as=0 ps=0 w=1.4 l=0.6
X400 x2_diff__cc1_0.x2_tail cmc VSS VSS sky130_fd_pr__nfet_01v8 ad=0.406 pd=3.38 as=0.406 ps=3.38 w=1.4 l=0.6
X401 VDD VDD on VDD sky130_fd_pr__pfet_01v8 ad=0.406 pd=3.38 as=0.406 ps=3.38 w=1.4 l=0.6
X402 x2_cl_casc__cc1_0.bias_c IBIAS VSS VSS sky130_fd_pr__nfet_01v8 ad=0.406 pd=3.38 as=0.406 ps=3.38 w=1.4 l=0.6
X403 on x2_cm_casc__cc6_0.bias_d x2_cm_tail__cc6_0.x2_m3d VSS sky130_fd_pr__nfet_01v8 ad=0.406 pd=3.38 as=0.406 ps=3.38 w=1.4 l=0.6
X404 x2_cm_tail__cc6_0.x2_m3d bias_a VSS VSS sky130_fd_pr__nfet_01v8 ad=0.406 pd=3.38 as=0.406 ps=3.38 w=1.4 l=0.6
X405 x1_single_m5__f3_0.x1_m5d x2_cm_casc__cc6_0.bias_d bias_a VSS sky130_fd_pr__nfet_01v8 ad=0.406 pd=3.38 as=0.406 ps=3.38 w=1.4 l=0.6
X406 x2_diff__cc1_0.x2_tail bias_a VSS VSS sky130_fd_pr__nfet_01v8 ad=0.406 pd=3.38 as=0.406 ps=3.38 w=1.4 l=0.6
X407 VSS cmc x2_diff__cc1_0.x2_tail VSS sky130_fd_pr__nfet_01v8 ad=0.406 pd=3.38 as=0.406 ps=3.38 w=1.4 l=0.6
X408 x2_diff__cc1_0.x2_tail bias_a VSS VSS sky130_fd_pr__nfet_01v8 ad=0.406 pd=3.38 as=0.406 ps=3.38 w=1.4 l=0.6
X409 VSS VSS x2_cm_tail__cc6_0.x2_m4d VSS sky130_fd_pr__nfet_01v8 ad=0.406 pd=3.38 as=0.406 ps=3.38 w=1.4 l=0.6
X410 x1_cm_bias_c__cc1_0.x1_m21d x2_cl_casc__cc1_0.bias_c x2_cl_src__id4_0.bias_b VDD sky130_fd_pr__pfet_01v8 ad=0.406 pd=3.38 as=0.406 ps=3.38 w=1.4 l=0.6
X411 VSS bias_a x2_cm_tail__cc6_0.x2_m3d VSS sky130_fd_pr__nfet_01v8 ad=0.406 pd=3.38 as=0.406 ps=3.38 w=1.4 l=0.6
X412 on x2_cl_casc__cc1_0.bias_c x2_diff__cc1_0.x2_foldp VDD sky130_fd_pr__pfet_01v8 ad=0.406 pd=3.38 as=0.406 ps=3.38 w=1.4 l=0.6
X413 VDD VDD op VDD sky130_fd_pr__pfet_01v8 ad=0.406 pd=3.38 as=0.406 ps=3.38 w=1.4 l=0.6
X414 VSS bias_a x2_cm_tail__cc6_0.x2_m3d VSS sky130_fd_pr__nfet_01v8 ad=0.406 pd=3.38 as=0.406 ps=3.38 w=1.4 l=0.6
X415 VSS VSS VSS VSS sky130_fd_pr__nfet_01v8 ad=0.406 pd=3.38 as=0 ps=0 w=1.4 l=0.6
X416 op x2_cm_casc__cc6_0.bias_d x2_cm_tail__cc6_0.x2_m4d VSS sky130_fd_pr__nfet_01v8 ad=0.406 pd=3.38 as=0.406 ps=3.38 w=1.4 l=0.6
X417 x2_cl_src__id4_0.bias_b x2_cl_src__id4_0.bias_b x2_cl_casc__cc1_0.bias_c VSS sky130_fd_pr__nfet_01v8_lvt ad=0.406 pd=3.38 as=0.406 ps=3.38 w=1.4 l=0.6
X418 x2_cl_casc__cc1_0.bias_c x2_cl_src__id4_0.bias_b x2_cl_src__id4_0.bias_b VSS sky130_fd_pr__nfet_01v8_lvt ad=0.406 pd=3.38 as=0.406 ps=3.38 w=1.4 l=0.6
X419 x2_diff__cc1_0.x2_tail cmc VSS VSS sky130_fd_pr__nfet_01v8 ad=0.406 pd=3.38 as=0.406 ps=3.38 w=1.4 l=0.6
X420 x2_cm_casc__cc6_0.bias_d x2_cm_casc__cc6_0.bias_d x2_cm_casc__cc6_0.bias_d VSS sky130_fd_pr__nfet_01v8 ad=0.406 pd=3.38 as=0 ps=0 w=1.4 l=0.6
X421 x2_diff__cc1_0.x2_foldp x2_diff__cc1_0.x2_foldp x2_diff__cc1_0.x2_foldp VSS sky130_fd_pr__nfet_01v8_lvt ad=0.348 pd=2.98 as=0 ps=0 w=1.2 l=0.2
X422 VSS VSS x1_single_m5__f3_0.x1_m5d VSS sky130_fd_pr__nfet_01v8 ad=0.406 pd=3.38 as=0.406 ps=3.38 w=1.4 l=0.6
X423 x2_diff__cc1_0.x2_foldp x2_cl_src__id4_0.bias_b VDD VDD sky130_fd_pr__pfet_01v8_lvt ad=0.406 pd=3.38 as=0.406 ps=3.38 w=1.4 l=0.6
X424 x2_cl_src__id4_0.bias_b x2_cl_src__id4_0.bias_b x2_cl_casc__cc1_0.bias_c VSS sky130_fd_pr__nfet_01v8_lvt ad=0.406 pd=3.38 as=0.406 ps=3.38 w=1.4 l=0.6
X425 x1_cm_bias_c__cc1_0.x1_m25d x2_cl_src__id4_0.bias_b VDD VDD sky130_fd_pr__pfet_01v8_lvt ad=0.406 pd=3.38 as=0.406 ps=3.38 w=1.4 l=0.6
X426 x2_diff__cc1_0.x2_foldp x2_cl_casc__cc1_0.bias_c on VDD sky130_fd_pr__pfet_01v8 ad=0.406 pd=3.38 as=0.406 ps=3.38 w=1.4 l=0.6
X427 VSS VSS x1_single_m5__f3_0.x1_m5d VSS sky130_fd_pr__nfet_01v8 ad=0.406 pd=3.38 as=0.406 ps=3.38 w=1.4 l=0.6
X428 x2_cm_tail__cc6_0.x2_m3d bias_a VSS VSS sky130_fd_pr__nfet_01v8 ad=0.406 pd=3.38 as=0.406 ps=3.38 w=1.4 l=0.6
X429 VSS VSS VSS VSS sky130_fd_pr__nfet_01v8 ad=0.406 pd=3.38 as=0 ps=0 w=1.4 l=0.6
X430 VSS VSS x2_cm_tail__cc6_0.x2_m3d VSS sky130_fd_pr__nfet_01v8 ad=0.406 pd=3.38 as=0.406 ps=3.38 w=1.4 l=0.6
X431 cm cm x1_cc_cm__strings1_0.x1_net7 VSS sky130_fd_pr__nfet_01v8 ad=0.406 pd=3.38 as=0.406 ps=3.38 w=1.4 l=0.6
X432 VDD VDD VDD VDD sky130_fd_pr__pfet_01v8 ad=0.406 pd=3.38 as=0 ps=0 w=1.4 l=0.6
X433 VDD VDD on VDD sky130_fd_pr__pfet_01v8 ad=0.406 pd=3.38 as=0.406 ps=3.38 w=1.4 l=0.6
X434 bias_a x2_cm_casc__cc6_0.bias_d x1_single_m5__f3_0.x1_m5d VSS sky130_fd_pr__nfet_01v8 ad=0.406 pd=3.38 as=0.406 ps=3.38 w=1.4 l=0.6
X435 x1_cm_bias_c__cc1_0.x1_m31d x1_cm_bias_c__cc1_0.x1_m31d x1_cm_bias_c__cc1_0.x1_m31d VDD sky130_fd_pr__pfet_01v8_lvt ad=0.406 pd=3.38 as=0 ps=0 w=1.4 l=0.6
X436 x1_single_m3__f1_0.x1_m2d x1_single_m3__f1_0.x1_m2d x2_cm_casc__cc6_0.bias_d VSS sky130_fd_pr__nfet_01v8 ad=0.406 pd=3.38 as=0.406 ps=3.38 w=1.4 l=0.6
X437 VSS bias_a x1_single_m5__f3_0.x1_m5d VSS sky130_fd_pr__nfet_01v8 ad=0.406 pd=3.38 as=0.406 ps=3.38 w=1.4 l=0.6
X438 x1_cc_cm__strings1_0.x1_net5 cm x1_cc_cm__strings1_0.x1_net6 VSS sky130_fd_pr__nfet_01v8 ad=0.406 pd=3.38 as=0.406 ps=3.38 w=1.4 l=0.6
X439 x2_cl_casc__cc1_0.bias_c x2_cl_src__id4_0.bias_b x2_cl_src__id4_0.bias_b VSS sky130_fd_pr__nfet_01v8_lvt ad=0.406 pd=3.38 as=0.406 ps=3.38 w=1.4 l=0.6
X440 x2_diff__cc1_0.x2_foldn x2_cl_src__id4_0.bias_b VDD VDD sky130_fd_pr__pfet_01v8_lvt ad=0.406 pd=3.38 as=0.406 ps=3.38 w=1.4 l=0.6
X441 x2_cm_tail__cc6_0.x2_m4d x2_cm_casc__cc6_0.bias_d op VSS sky130_fd_pr__nfet_01v8 ad=0.406 pd=3.38 as=0.406 ps=3.38 w=1.4 l=0.6
X442 VSS bias_a x2_diff__cc1_0.x2_tail VSS sky130_fd_pr__nfet_01v8 ad=0.406 pd=3.38 as=0.406 ps=3.38 w=1.4 l=0.6
X443 VSS bias_a x2_diff__cc1_0.x2_tail VSS sky130_fd_pr__nfet_01v8 ad=0.406 pd=3.38 as=0.406 ps=3.38 w=1.4 l=0.6
X444 VDD x2_cl_src__id4_0.bias_b x1_cm_bias_c__cc1_0.x1_m31d VDD sky130_fd_pr__pfet_01v8_lvt ad=0.406 pd=3.38 as=0.406 ps=3.38 w=1.4 l=0.6
X445 op x2_cm_casc__cc6_0.bias_d x2_cm_tail__cc6_0.x2_m4d VSS sky130_fd_pr__nfet_01v8 ad=0.406 pd=3.38 as=0.406 ps=3.38 w=1.4 l=0.6
X446 x1_cm_bias_c__cc1_0.x1_m25d x2_cl_casc__cc1_0.bias_c x1_single_m3__f1_0.x1_m2d VDD sky130_fd_pr__pfet_01v8 ad=0.406 pd=3.38 as=0.406 ps=3.38 w=1.4 l=0.6
X447 VSS IBIAS IBIAS VSS sky130_fd_pr__nfet_01v8 ad=0.406 pd=3.38 as=0.406 ps=3.38 w=1.4 l=0.6
X448 x2_cl_casc__cc1_0.bias_c IBIAS VSS VSS sky130_fd_pr__nfet_01v8 ad=0.406 pd=3.38 as=0.406 ps=3.38 w=1.4 l=0.6
X449 x1_single_m3__f1_0.x1_m2d x1_single_m3__f1_0.x1_m2d x2_cm_casc__cc6_0.bias_d VSS sky130_fd_pr__nfet_01v8 ad=0.406 pd=3.38 as=0.406 ps=3.38 w=1.4 l=0.6
X450 VSS bias_a x1_single_m5__f3_0.x1_m5d VSS sky130_fd_pr__nfet_01v8 ad=0.406 pd=3.38 as=0.406 ps=3.38 w=1.4 l=0.6
X451 VSS bias_a x2_cm_tail__cc6_0.x2_m3d VSS sky130_fd_pr__nfet_01v8 ad=0.406 pd=3.38 as=0.406 ps=3.38 w=1.4 l=0.6
X452 x2_cl_casc__cc1_0.bias_c IBIAS VSS VSS sky130_fd_pr__nfet_01v8 ad=0.406 pd=3.38 as=0.406 ps=3.38 w=1.4 l=0.6
X453 x2_diff__cc1_0.x2_tail bias_a VSS VSS sky130_fd_pr__nfet_01v8 ad=0.406 pd=3.38 as=0.406 ps=3.38 w=1.4 l=0.6
X454 on x2_cm_casc__cc6_0.bias_d x2_cm_tail__cc6_0.x2_m3d VSS sky130_fd_pr__nfet_01v8 ad=0.406 pd=3.38 as=0.406 ps=3.38 w=1.4 l=0.6
X455 VSS bias_a x2_cm_tail__cc6_0.x2_m4d VSS sky130_fd_pr__nfet_01v8 ad=0.406 pd=3.38 as=0.406 ps=3.38 w=1.4 l=0.6
X456 x2_diff__cc1_0.x2_tail bias_a VSS VSS sky130_fd_pr__nfet_01v8 ad=0.406 pd=3.38 as=0.406 ps=3.38 w=1.4 l=0.6
X457 VDD x2_cl_src__id4_0.bias_b x2_diff__cc1_0.x2_foldn VDD sky130_fd_pr__pfet_01v8_lvt ad=0.406 pd=3.38 as=0.406 ps=3.38 w=1.4 l=0.6
X458 VSS bias_a x2_diff__cc1_0.x2_tail VSS sky130_fd_pr__nfet_01v8 ad=0.406 pd=3.38 as=0.406 ps=3.38 w=1.4 l=0.6
X459 x2_cm_tail__cc6_0.x2_m3d x2_cm_casc__cc6_0.bias_d on VSS sky130_fd_pr__nfet_01v8 ad=0.406 pd=3.38 as=0.406 ps=3.38 w=1.4 l=0.6
X460 VDD VDD x1_cm_bias_c__cc1_0.x1_m31d VDD sky130_fd_pr__pfet_01v8 ad=0.406 pd=3.38 as=0.406 ps=3.38 w=1.4 l=0.6
X461 cm cm cm VSS sky130_fd_pr__nfet_01v8 ad=0.406 pd=3.38 as=0 ps=0 w=1.4 l=0.6
X462 x2_diff__cc1_0.x2_foldn x2_diff__cc1_0.x2_foldn x2_diff__cc1_0.x2_foldn VSS sky130_fd_pr__nfet_01v8_lvt ad=0.348 pd=2.98 as=0 ps=0 w=1.2 l=0.2
X463 VSS bias_a x2_diff__cc1_0.x2_tail VSS sky130_fd_pr__nfet_01v8 ad=0.406 pd=3.38 as=0.406 ps=3.38 w=1.4 l=0.6
X464 VSS bias_a x2_diff__cc1_0.x2_tail VSS sky130_fd_pr__nfet_01v8 ad=0.406 pd=3.38 as=0.406 ps=3.38 w=1.4 l=0.6
X465 VDD x2_cl_src__id4_0.bias_b x2_diff__cc1_0.x2_foldp VDD sky130_fd_pr__pfet_01v8_lvt ad=0.406 pd=3.38 as=0.406 ps=3.38 w=1.4 l=0.6
X466 VSS IBIAS IBIAS VSS sky130_fd_pr__nfet_01v8 ad=0.406 pd=3.38 as=0.406 ps=3.38 w=1.4 l=0.6
X467 VSS bias_a x2_cm_tail__cc6_0.x2_m3d VSS sky130_fd_pr__nfet_01v8 ad=0.406 pd=3.38 as=0.406 ps=3.38 w=1.4 l=0.6
X468 x2_cm_tail__cc6_0.x2_m4d bias_a VSS VSS sky130_fd_pr__nfet_01v8 ad=0.406 pd=3.38 as=0.406 ps=3.38 w=1.4 l=0.6
X469 x2_cl_src__id4_0.bias_b x2_cl_src__id4_0.bias_b x2_cl_casc__cc1_0.bias_c VSS sky130_fd_pr__nfet_01v8_lvt ad=0.406 pd=3.38 as=0.406 ps=3.38 w=1.4 l=0.6
X470 VDD x2_cl_src__id4_0.bias_b x1_cm_bias_c__cc1_0.x1_m31d VDD sky130_fd_pr__pfet_01v8_lvt ad=0.406 pd=3.38 as=0.406 ps=3.38 w=1.4 l=0.6
X471 VDD x2_cl_src__id4_0.bias_b x2_diff__cc1_0.x2_foldp VDD sky130_fd_pr__pfet_01v8_lvt ad=0.406 pd=3.38 as=0.406 ps=3.38 w=1.4 l=0.6
X472 op x2_cl_casc__cc1_0.bias_c x2_diff__cc1_0.x2_foldn VDD sky130_fd_pr__pfet_01v8 ad=0.406 pd=3.38 as=0.406 ps=3.38 w=1.4 l=0.6
X473 VSS bias_a x2_diff__cc1_0.x2_tail VSS sky130_fd_pr__nfet_01v8 ad=0.406 pd=3.38 as=0.406 ps=3.38 w=1.4 l=0.6
X474 x2_diff__cc1_0.x2_foldn x2_diff__cc1_0.x2_foldn x2_diff__cc1_0.x2_foldn VDD sky130_fd_pr__pfet_01v8 ad=0.406 pd=3.38 as=0 ps=0 w=1.4 l=0.6
X475 VSS bias_a x2_diff__cc1_0.x2_tail VSS sky130_fd_pr__nfet_01v8 ad=0.406 pd=3.38 as=0.406 ps=3.38 w=1.4 l=0.6
X476 VSS bias_a x2_diff__cc1_0.x2_tail VSS sky130_fd_pr__nfet_01v8 ad=0.406 pd=3.38 as=0.406 ps=3.38 w=1.4 l=0.6
X477 x2_diff__cc1_0.x2_foldn x2_cl_casc__cc1_0.bias_c op VDD sky130_fd_pr__pfet_01v8 ad=0.406 pd=3.38 as=0.406 ps=3.38 w=1.4 l=0.6
X478 x2_cl_casc__cc1_0.bias_c x2_cl_casc__cc1_0.bias_c x2_cl_casc__cc1_0.bias_c VSS sky130_fd_pr__nfet_01v8_lvt ad=0.406 pd=3.38 as=0 ps=0 w=1.4 l=0.6
X479 x2_cl_src__id4_0.bias_b x2_cl_src__id4_0.bias_b x2_cl_casc__cc1_0.bias_c VSS sky130_fd_pr__nfet_01v8_lvt ad=0.406 pd=3.38 as=0.406 ps=3.38 w=1.4 l=0.6
X480 on x2_cl_casc__cc1_0.bias_c x2_diff__cc1_0.x2_foldp VDD sky130_fd_pr__pfet_01v8 ad=0.406 pd=3.38 as=0.406 ps=3.38 w=1.4 l=0.6
X481 op x2_cm_casc__cc6_0.bias_d x2_cm_tail__cc6_0.x2_m4d VSS sky130_fd_pr__nfet_01v8 ad=0.406 pd=3.38 as=0.406 ps=3.38 w=1.4 l=0.6
X482 x2_diff__cc1_0.x2_tail cmc VSS VSS sky130_fd_pr__nfet_01v8 ad=0.406 pd=3.38 as=0.406 ps=3.38 w=1.4 l=0.6
X483 x2_cm_tail__cc6_0.x2_m4d bias_a VSS VSS sky130_fd_pr__nfet_01v8 ad=0.406 pd=3.38 as=0.406 ps=3.38 w=1.4 l=0.6
X484 x2_diff__cc1_0.x2_tail cmc VSS VSS sky130_fd_pr__nfet_01v8 ad=0.406 pd=3.38 as=0.406 ps=3.38 w=1.4 l=0.6
X485 VSS cmc x2_diff__cc1_0.x2_tail VSS sky130_fd_pr__nfet_01v8 ad=0.406 pd=3.38 as=0.406 ps=3.38 w=1.4 l=0.6
X486 cm cm cm VSS sky130_fd_pr__nfet_01v8 ad=0.406 pd=3.38 as=0 ps=0 w=1.4 l=0.6
X487 IBIAS IBIAS VSS VSS sky130_fd_pr__nfet_01v8 ad=0.406 pd=3.38 as=0.406 ps=3.38 w=1.4 l=0.6
X488 VSS cmc x2_diff__cc1_0.x2_tail VSS sky130_fd_pr__nfet_01v8 ad=0.406 pd=3.38 as=0.406 ps=3.38 w=1.4 l=0.6
X489 VSS bias_a x2_cm_tail__cc6_0.x2_m4d VSS sky130_fd_pr__nfet_01v8 ad=0.406 pd=3.38 as=0.406 ps=3.38 w=1.4 l=0.6
X490 x2_cm_tail__cc6_0.x2_m3d bias_a VSS VSS sky130_fd_pr__nfet_01v8 ad=0.406 pd=3.38 as=0.406 ps=3.38 w=1.4 l=0.6
X491 VSS VSS VSS VSS sky130_fd_pr__nfet_01v8 ad=0.406 pd=3.38 as=0 ps=0 w=1.4 l=0.6
X492 x2_cl_src__id4_0.bias_b x2_cl_src__id4_0.bias_b x2_cl_casc__cc1_0.bias_c VSS sky130_fd_pr__nfet_01v8_lvt ad=0.406 pd=3.38 as=0.406 ps=3.38 w=1.4 l=0.6
X493 x2_cl_casc__cc1_0.bias_c x2_cl_casc__cc1_0.bias_c x2_cl_casc__cc1_0.bias_c VSS sky130_fd_pr__nfet_01v8_lvt ad=0.406 pd=3.38 as=0 ps=0 w=1.4 l=0.6
X494 x2_diff__cc1_0.x2_tail cmc VSS VSS sky130_fd_pr__nfet_01v8 ad=0.406 pd=3.38 as=0.406 ps=3.38 w=1.4 l=0.6
X495 VSS cm x1_cc_cm__strings1_0.x1_net3 VSS sky130_fd_pr__nfet_01v8 ad=0.406 pd=3.38 as=0.406 ps=3.38 w=1.4 l=0.6
X496 x2_cm_tail__cc6_0.x2_m4d x2_cm_casc__cc6_0.bias_d op VSS sky130_fd_pr__nfet_01v8 ad=0.406 pd=3.38 as=0.406 ps=3.38 w=1.4 l=0.6
X497 VDD x2_cl_src__id4_0.bias_b x2_diff__cc1_0.x2_foldn VDD sky130_fd_pr__pfet_01v8_lvt ad=0.406 pd=3.38 as=0.406 ps=3.38 w=1.4 l=0.6
X498 VDD VDD VDD VDD sky130_fd_pr__pfet_01v8 ad=0.406 pd=3.38 as=0 ps=0 w=1.4 l=0.6
X499 x2_diff__cc1_0.x2_tail ip x2_diff__cc1_0.x2_foldp VSS sky130_fd_pr__nfet_01v8_lvt ad=0.348 pd=2.98 as=0.348 ps=2.98 w=1.2 l=0.2
X500 VDD VDD VDD VDD sky130_fd_pr__pfet_01v8_lvt ad=0.406 pd=3.38 as=0 ps=0 w=1.4 l=0.6
X501 x2_cl_src__id4_0.bias_b x2_cl_src__id4_0.bias_b x2_cl_casc__cc1_0.bias_c VSS sky130_fd_pr__nfet_01v8_lvt ad=0.406 pd=3.38 as=0.406 ps=3.38 w=1.4 l=0.6
X502 x1_cm_bias_c__cc1_0.x1_m21d x2_cl_src__id4_0.bias_b VDD VDD sky130_fd_pr__pfet_01v8_lvt ad=0.406 pd=3.38 as=0.406 ps=3.38 w=1.4 l=0.6
X503 x2_cl_casc__cc1_0.bias_c x2_cl_src__id4_0.bias_b x2_cl_src__id4_0.bias_b VSS sky130_fd_pr__nfet_01v8_lvt ad=0.406 pd=3.38 as=0.406 ps=3.38 w=1.4 l=0.6
X504 x2_cm_casc__cc6_0.bias_d x1_single_m3__f1_0.x1_m2d x1_single_m3__f1_0.x1_m2d VSS sky130_fd_pr__nfet_01v8 ad=0.406 pd=3.38 as=0.406 ps=3.38 w=1.4 l=0.6
X505 x2_diff__cc1_0.x2_tail bias_a VSS VSS sky130_fd_pr__nfet_01v8 ad=0.406 pd=3.38 as=0.406 ps=3.38 w=1.4 l=0.6
X506 x1_cm_bias_c__cc1_0.x1_m31d x2_cl_casc__cc1_0.bias_c cm VDD sky130_fd_pr__pfet_01v8 ad=0.406 pd=3.38 as=0.406 ps=3.38 w=1.4 l=0.6
X507 x2_cl_casc__cc1_0.bias_c IBIAS VSS VSS sky130_fd_pr__nfet_01v8 ad=0.406 pd=3.38 as=0.406 ps=3.38 w=1.4 l=0.6
X508 x2_diff__cc1_0.x2_tail cmc VSS VSS sky130_fd_pr__nfet_01v8 ad=0.406 pd=3.38 as=0.406 ps=3.38 w=1.4 l=0.6
X509 x2_diff__cc1_0.x2_tail cmc VSS VSS sky130_fd_pr__nfet_01v8 ad=0.406 pd=3.38 as=0.406 ps=3.38 w=1.4 l=0.6
X510 x2_diff__cc1_0.x2_foldp x2_cl_src__id4_0.bias_b VDD VDD sky130_fd_pr__pfet_01v8_lvt ad=0.406 pd=3.38 as=0.406 ps=3.38 w=1.4 l=0.6
X511 VDD VDD VDD VDD sky130_fd_pr__pfet_01v8 ad=0.406 pd=3.38 as=0 ps=0 w=1.4 l=0.6
X512 on x2_cl_casc__cc1_0.bias_c x2_diff__cc1_0.x2_foldp VDD sky130_fd_pr__pfet_01v8 ad=0.406 pd=3.38 as=0.406 ps=3.38 w=1.4 l=0.6
X513 x2_cm_casc__cc6_0.bias_d x1_single_m3__f1_0.x1_m2d x1_single_m3__f1_0.x1_m2d VSS sky130_fd_pr__nfet_01v8 ad=0.406 pd=3.38 as=0.406 ps=3.38 w=1.4 l=0.6
X514 x2_cl_src__id4_0.bias_b x2_cl_src__id4_0.bias_b x2_cl_casc__cc1_0.bias_c VSS sky130_fd_pr__nfet_01v8_lvt ad=0.406 pd=3.38 as=0.406 ps=3.38 w=1.4 l=0.6
X515 x2_cm_tail__cc6_0.x2_m4d bias_a VSS VSS sky130_fd_pr__nfet_01v8 ad=0.406 pd=3.38 as=0.406 ps=3.38 w=1.4 l=0.6
X516 on x2_cm_casc__cc6_0.bias_d x2_cm_tail__cc6_0.x2_m3d VSS sky130_fd_pr__nfet_01v8 ad=0.406 pd=3.38 as=0.406 ps=3.38 w=1.4 l=0.6
X517 x1_single_m3__f1_0.x1_m2d x1_single_m3__f1_0.x1_m2d x2_cm_casc__cc6_0.bias_d VSS sky130_fd_pr__nfet_01v8 ad=0.406 pd=3.38 as=0.406 ps=3.38 w=1.4 l=0.6
X518 x2_diff__cc1_0.x2_tail cmc VSS VSS sky130_fd_pr__nfet_01v8 ad=0.406 pd=3.38 as=0.406 ps=3.38 w=1.4 l=0.6
X519 x2_diff__cc1_0.x2_foldp x2_cl_src__id4_0.bias_b VDD VDD sky130_fd_pr__pfet_01v8_lvt ad=0.406 pd=3.38 as=0.406 ps=3.38 w=1.4 l=0.6
X520 VDD VDD VDD VDD sky130_fd_pr__pfet_01v8 ad=0.406 pd=3.38 as=0 ps=0 w=1.4 l=0.6
X521 op x2_cl_casc__cc1_0.bias_c x2_diff__cc1_0.x2_foldn VDD sky130_fd_pr__pfet_01v8 ad=0.406 pd=3.38 as=0.406 ps=3.38 w=1.4 l=0.6
X522 x1_single_m5__f3_0.x1_m5d x2_cm_casc__cc6_0.bias_d bias_a VSS sky130_fd_pr__nfet_01v8 ad=0.406 pd=3.38 as=0.406 ps=3.38 w=1.4 l=0.6
X523 x1_cm_bias_c__cc1_0.x1_m21d x2_cl_casc__cc1_0.bias_c x2_cl_src__id4_0.bias_b VDD sky130_fd_pr__pfet_01v8 ad=0.406 pd=3.38 as=0.406 ps=3.38 w=1.4 l=0.6
X524 x2_diff__cc1_0.x2_foldn x2_cl_src__id4_0.bias_b VDD VDD sky130_fd_pr__pfet_01v8_lvt ad=0.406 pd=3.38 as=0.406 ps=3.38 w=1.4 l=0.6
X525 on on on VSS sky130_fd_pr__nfet_01v8 ad=0.406 pd=3.38 as=17.052 ps=141.96001 w=1.4 l=0.6
X526 VSS bias_a x2_diff__cc1_0.x2_tail VSS sky130_fd_pr__nfet_01v8 ad=0.406 pd=3.38 as=0.406 ps=3.38 w=1.4 l=0.6
X527 x1_single_m3__f1_0.x1_m2d x1_single_m3__f1_0.x1_m2d x2_cm_casc__cc6_0.bias_d VSS sky130_fd_pr__nfet_01v8 ad=0.406 pd=3.38 as=0.406 ps=3.38 w=1.4 l=0.6
X528 VSS bias_a x1_single_m5__f3_0.x1_m5d VSS sky130_fd_pr__nfet_01v8 ad=0.406 pd=3.38 as=0.406 ps=3.38 w=1.4 l=0.6
X529 VSS VSS VSS VSS sky130_fd_pr__nfet_01v8 ad=0.406 pd=3.38 as=0 ps=0 w=1.4 l=0.6
X530 cm x2_cl_casc__cc1_0.bias_c x1_cm_bias_c__cc1_0.x1_m31d VDD sky130_fd_pr__pfet_01v8 ad=0.406 pd=3.38 as=0.406 ps=3.38 w=1.4 l=0.6
X531 VDD x2_cl_src__id4_0.bias_b x2_diff__cc1_0.x2_foldp VDD sky130_fd_pr__pfet_01v8_lvt ad=0.406 pd=3.38 as=0.406 ps=3.38 w=1.4 l=0.6
X532 x1_single_m3__f1_0.x1_m2d x1_single_m3__f1_0.x1_m2d x2_cm_casc__cc6_0.bias_d VSS sky130_fd_pr__nfet_01v8 ad=0.406 pd=3.38 as=0.406 ps=3.38 w=1.4 l=0.6
X533 VSS cmc x2_diff__cc1_0.x2_tail VSS sky130_fd_pr__nfet_01v8 ad=0.406 pd=3.38 as=0.406 ps=3.38 w=1.4 l=0.6
X534 on x2_cm_casc__cc6_0.bias_d x2_cm_tail__cc6_0.x2_m3d VSS sky130_fd_pr__nfet_01v8 ad=0.406 pd=3.38 as=0.406 ps=3.38 w=1.4 l=0.6
X535 x2_cl_casc__cc1_0.bias_c x2_cl_src__id4_0.bias_b x2_cl_src__id4_0.bias_b VSS sky130_fd_pr__nfet_01v8_lvt ad=0.406 pd=3.38 as=0.406 ps=3.38 w=1.4 l=0.6
X536 op x2_cm_casc__cc6_0.bias_d x2_cm_tail__cc6_0.x2_m4d VSS sky130_fd_pr__nfet_01v8 ad=0.406 pd=3.38 as=0.406 ps=3.38 w=1.4 l=0.6
X537 VDD VDD VDD VDD sky130_fd_pr__pfet_01v8_lvt ad=0.406 pd=3.38 as=0 ps=0 w=1.4 l=0.6
X538 x1_single_m3__f1_0.x1_m2d x1_single_m3__f1_0.x1_m2d x2_cm_casc__cc6_0.bias_d VSS sky130_fd_pr__nfet_01v8 ad=0.406 pd=3.38 as=0.406 ps=3.38 w=1.4 l=0.6
X539 VSS bias_a x1_single_m5__f3_0.x1_m5d VSS sky130_fd_pr__nfet_01v8 ad=0.406 pd=3.38 as=0.406 ps=3.38 w=1.4 l=0.6
X540 VSS bias_a x2_cm_tail__cc6_0.x2_m4d VSS sky130_fd_pr__nfet_01v8 ad=0.406 pd=3.38 as=0.406 ps=3.38 w=1.4 l=0.6
X541 IBIAS IBIAS VSS VSS sky130_fd_pr__nfet_01v8 ad=0.406 pd=3.38 as=0.406 ps=3.38 w=1.4 l=0.6
X542 x2_diff__cc1_0.x2_tail cmc VSS VSS sky130_fd_pr__nfet_01v8 ad=0.406 pd=3.38 as=0.406 ps=3.38 w=1.4 l=0.6
X543 VSS IBIAS IBIAS VSS sky130_fd_pr__nfet_01v8 ad=0.406 pd=3.38 as=0.406 ps=3.38 w=1.4 l=0.6
X544 x1_single_m3__f1_0.x1_m2d x1_single_m3__f1_0.x1_m2d x2_cm_casc__cc6_0.bias_d VSS sky130_fd_pr__nfet_01v8 ad=0.406 pd=3.38 as=0.406 ps=3.38 w=1.4 l=0.6
X545 x2_diff__cc1_0.x2_tail cmc VSS VSS sky130_fd_pr__nfet_01v8 ad=0.406 pd=3.38 as=0.406 ps=3.38 w=1.4 l=0.6
X546 bias_a x2_cm_casc__cc6_0.bias_d x1_single_m5__f3_0.x1_m5d VSS sky130_fd_pr__nfet_01v8 ad=0.406 pd=3.38 as=0.406 ps=3.38 w=1.4 l=0.6
X547 VSS cmc x2_diff__cc1_0.x2_tail VSS sky130_fd_pr__nfet_01v8 ad=0.406 pd=3.38 as=0.406 ps=3.38 w=1.4 l=0.6
X548 VDD x2_cl_src__id4_0.bias_b x2_diff__cc1_0.x2_foldn VDD sky130_fd_pr__pfet_01v8_lvt ad=0.406 pd=3.38 as=0.406 ps=3.38 w=1.4 l=0.6
X549 VDD VDD VDD VDD sky130_fd_pr__pfet_01v8_lvt ad=0.406 pd=3.38 as=0 ps=0 w=1.4 l=0.6
X550 op x2_cl_casc__cc1_0.bias_c x2_diff__cc1_0.x2_foldn VDD sky130_fd_pr__pfet_01v8 ad=0.406 pd=3.38 as=0.406 ps=3.38 w=1.4 l=0.6
X551 x2_cl_src__id4_0.bias_b x2_cl_src__id4_0.bias_b x2_cl_casc__cc1_0.bias_c VSS sky130_fd_pr__nfet_01v8_lvt ad=0.406 pd=3.38 as=0.406 ps=3.38 w=1.4 l=0.6
X552 on x2_cm_casc__cc6_0.bias_d x2_cm_tail__cc6_0.x2_m3d VSS sky130_fd_pr__nfet_01v8 ad=0.406 pd=3.38 as=0.406 ps=3.38 w=1.4 l=0.6
X553 x2_diff__cc1_0.x2_tail cmc VSS VSS sky130_fd_pr__nfet_01v8 ad=0.406 pd=3.38 as=0.406 ps=3.38 w=1.4 l=0.6
X554 x2_diff__cc1_0.x2_foldp x2_cl_casc__cc1_0.bias_c on VDD sky130_fd_pr__pfet_01v8 ad=0.406 pd=3.38 as=0.406 ps=3.38 w=1.4 l=0.6
X555 x2_diff__cc1_0.x2_foldp ip x2_diff__cc1_0.x2_tail VSS sky130_fd_pr__nfet_01v8_lvt ad=0.348 pd=2.98 as=0.348 ps=2.98 w=1.2 l=0.2
X556 VSS bias_a x2_diff__cc1_0.x2_tail VSS sky130_fd_pr__nfet_01v8 ad=0.406 pd=3.38 as=0.406 ps=3.38 w=1.4 l=0.6
X557 x2_cm_tail__cc6_0.x2_m3d x2_cm_casc__cc6_0.bias_d on VSS sky130_fd_pr__nfet_01v8 ad=0.406 pd=3.38 as=0.406 ps=3.38 w=1.4 l=0.6
X558 x2_diff__cc1_0.x2_foldn x2_cl_casc__cc1_0.bias_c op VDD sky130_fd_pr__pfet_01v8 ad=0.406 pd=3.38 as=0.406 ps=3.38 w=1.4 l=0.6
X559 x2_diff__cc1_0.x2_tail cmc VSS VSS sky130_fd_pr__nfet_01v8 ad=0.406 pd=3.38 as=0.406 ps=3.38 w=1.4 l=0.6
X560 VSS bias_a x2_diff__cc1_0.x2_tail VSS sky130_fd_pr__nfet_01v8 ad=0.406 pd=3.38 as=0.406 ps=3.38 w=1.4 l=0.6
X561 x2_cl_src__id4_0.bias_b x2_cl_src__id4_0.bias_b x2_cl_casc__cc1_0.bias_c VSS sky130_fd_pr__nfet_01v8_lvt ad=0.406 pd=3.38 as=0.406 ps=3.38 w=1.4 l=0.6
X562 x2_diff__cc1_0.x2_tail bias_a VSS VSS sky130_fd_pr__nfet_01v8 ad=0.406 pd=3.38 as=0.406 ps=3.38 w=1.4 l=0.6
X563 VSS cmc x2_diff__cc1_0.x2_tail VSS sky130_fd_pr__nfet_01v8 ad=0.406 pd=3.38 as=0.406 ps=3.38 w=1.4 l=0.6
X564 x1_cm_bias_c__cc1_0.x1_m21d x1_cm_bias_c__cc1_0.x1_m21d x1_cm_bias_c__cc1_0.x1_m21d VDD sky130_fd_pr__pfet_01v8_lvt ad=0.406 pd=3.38 as=8.12 ps=67.6 w=1.4 l=0.6
X565 x2_diff__cc1_0.x2_tail bias_a VSS VSS sky130_fd_pr__nfet_01v8 ad=0.406 pd=3.38 as=0.406 ps=3.38 w=1.4 l=0.6
X566 VDD VDD VDD VDD sky130_fd_pr__pfet_01v8 ad=0.406 pd=3.38 as=0 ps=0 w=1.4 l=0.6
X567 VSS cmc x2_diff__cc1_0.x2_tail VSS sky130_fd_pr__nfet_01v8 ad=0.406 pd=3.38 as=0.406 ps=3.38 w=1.4 l=0.6
X568 x1_single_m5__f3_0.x1_m5d x1_single_m5__f3_0.x1_m5d x1_single_m5__f3_0.x1_m5d VSS sky130_fd_pr__nfet_01v8 ad=0.406 pd=3.38 as=0 ps=0 w=1.4 l=0.6
X569 x2_cm_tail__cc6_0.x2_m4d x2_cm_casc__cc6_0.bias_d op VSS sky130_fd_pr__nfet_01v8 ad=0.406 pd=3.38 as=0.406 ps=3.38 w=1.4 l=0.6
X570 x2_diff__cc1_0.x2_tail bias_a VSS VSS sky130_fd_pr__nfet_01v8 ad=0.406 pd=3.38 as=0.406 ps=3.38 w=1.4 l=0.6
X571 x2_cm_tail__cc6_0.x2_m4d x2_cm_casc__cc6_0.bias_d op VSS sky130_fd_pr__nfet_01v8 ad=0.406 pd=3.38 as=0.406 ps=3.38 w=1.4 l=0.6
X572 x2_diff__cc1_0.x2_tail bias_a VSS VSS sky130_fd_pr__nfet_01v8 ad=0.406 pd=3.38 as=0.406 ps=3.38 w=1.4 l=0.6
X573 x2_cl_src__id4_0.bias_b x2_cl_src__id4_0.bias_b x2_cl_casc__cc1_0.bias_c VSS sky130_fd_pr__nfet_01v8_lvt ad=0.406 pd=3.38 as=0.406 ps=3.38 w=1.4 l=0.6
X574 VDD VDD VDD VDD sky130_fd_pr__pfet_01v8_lvt ad=0.406 pd=3.38 as=0 ps=0 w=1.4 l=0.6
X575 x2_cl_src__id4_0.bias_b x2_cl_src__id4_0.bias_b x2_cl_casc__cc1_0.bias_c VSS sky130_fd_pr__nfet_01v8_lvt ad=0.406 pd=3.38 as=0.406 ps=3.38 w=1.4 l=0.6
X576 x2_cl_casc__cc1_0.bias_c x2_cl_casc__cc1_0.bias_c x2_cl_casc__cc1_0.bias_c VSS sky130_fd_pr__nfet_01v8_lvt ad=0.406 pd=3.38 as=0 ps=0 w=1.4 l=0.6
X577 x2_diff__cc1_0.x2_tail bias_a VSS VSS sky130_fd_pr__nfet_01v8 ad=0.406 pd=3.38 as=0.406 ps=3.38 w=1.4 l=0.6
X578 x1_cm_bias_c__cc1_0.x1_m25d x2_cl_casc__cc1_0.bias_c x1_single_m3__f1_0.x1_m2d VDD sky130_fd_pr__pfet_01v8 ad=0.406 pd=3.38 as=0.406 ps=3.38 w=1.4 l=0.6
X579 x1_cc_cm__strings1_0.x1_net13 cm cm VSS sky130_fd_pr__nfet_01v8 ad=0.406 pd=3.38 as=0.406 ps=3.38 w=1.4 l=0.6
X580 x1_single_m5__f3_0.x1_m5d x2_cm_casc__cc6_0.bias_d bias_a VSS sky130_fd_pr__nfet_01v8 ad=0.406 pd=3.38 as=0.406 ps=3.38 w=1.4 l=0.6
X581 x2_diff__cc1_0.x2_tail cmc VSS VSS sky130_fd_pr__nfet_01v8 ad=0.406 pd=3.38 as=0.406 ps=3.38 w=1.4 l=0.6
X582 x2_cl_casc__cc1_0.bias_c x2_cl_casc__cc1_0.bias_c x2_cl_casc__cc1_0.bias_c VSS sky130_fd_pr__nfet_01v8_lvt ad=0.406 pd=3.38 as=0 ps=0 w=1.4 l=0.6
X583 x2_cm_tail__cc6_0.x2_m4d x2_cm_casc__cc6_0.bias_d op VSS sky130_fd_pr__nfet_01v8 ad=0.406 pd=3.38 as=0.406 ps=3.38 w=1.4 l=0.6
X584 bias_a bias_a bias_a VSS sky130_fd_pr__nfet_01v8 ad=0.406 pd=3.38 as=0 ps=0 w=1.4 l=0.6
X585 VSS bias_a x2_cm_tail__cc6_0.x2_m4d VSS sky130_fd_pr__nfet_01v8 ad=0.406 pd=3.38 as=0.406 ps=3.38 w=1.4 l=0.6
X586 x2_diff__cc1_0.x2_foldn x2_cl_src__id4_0.bias_b VDD VDD sky130_fd_pr__pfet_01v8_lvt ad=0.406 pd=3.38 as=0.406 ps=3.38 w=1.4 l=0.6
X587 VSS bias_a x2_cm_tail__cc6_0.x2_m4d VSS sky130_fd_pr__nfet_01v8 ad=0.406 pd=3.38 as=0.406 ps=3.38 w=1.4 l=0.6
X588 x2_cm_tail__cc6_0.x2_m3d bias_a VSS VSS sky130_fd_pr__nfet_01v8 ad=0.406 pd=3.38 as=0.406 ps=3.38 w=1.4 l=0.6
X589 VSS IBIAS IBIAS VSS sky130_fd_pr__nfet_01v8 ad=0.406 pd=3.38 as=0.406 ps=3.38 w=1.4 l=0.6
X590 x2_cl_src__id4_0.bias_b x2_cl_casc__cc1_0.bias_c x1_cm_bias_c__cc1_0.x1_m21d VDD sky130_fd_pr__pfet_01v8 ad=0.406 pd=3.38 as=0.406 ps=3.38 w=1.4 l=0.6
X591 x1_cm_bias_c__cc1_0.x1_m21d x1_cm_bias_c__cc1_0.x1_m21d x1_cm_bias_c__cc1_0.x1_m21d VDD sky130_fd_pr__pfet_01v8_lvt ad=0.406 pd=3.38 as=0 ps=0 w=1.4 l=0.6
X592 x2_cm_casc__cc6_0.bias_d x1_single_m3__f1_0.x1_m2d x1_single_m3__f1_0.x1_m2d VSS sky130_fd_pr__nfet_01v8 ad=0.406 pd=3.38 as=0.406 ps=3.38 w=1.4 l=0.6
X593 VSS VSS x1_single_m5__f3_0.x1_m5d VSS sky130_fd_pr__nfet_01v8 ad=0.406 pd=3.38 as=0.406 ps=3.38 w=1.4 l=0.6
X594 op op op VSS sky130_fd_pr__nfet_01v8 ad=0.406 pd=3.38 as=0 ps=0 w=1.4 l=0.6
X595 on x2_cm_casc__cc6_0.bias_d x2_cm_tail__cc6_0.x2_m3d VSS sky130_fd_pr__nfet_01v8 ad=0.406 pd=3.38 as=0.406 ps=3.38 w=1.4 l=0.6
X596 x2_diff__cc1_0.x2_tail bias_a VSS VSS sky130_fd_pr__nfet_01v8 ad=0.406 pd=3.38 as=0.406 ps=3.38 w=1.4 l=0.6
X597 x2_cl_casc__cc1_0.bias_c x2_cl_src__id4_0.bias_b x2_cl_src__id4_0.bias_b VSS sky130_fd_pr__nfet_01v8_lvt ad=0.406 pd=3.38 as=0.406 ps=3.38 w=1.4 l=0.6
X598 x2_cm_casc__cc6_0.bias_d x2_cm_casc__cc6_0.bias_d x2_cm_casc__cc6_0.bias_d VSS sky130_fd_pr__nfet_01v8 ad=0.406 pd=3.38 as=0 ps=0 w=1.4 l=0.6
X599 x2_diff__cc1_0.x2_tail bias_a VSS VSS sky130_fd_pr__nfet_01v8 ad=0.406 pd=3.38 as=0.406 ps=3.38 w=1.4 l=0.6
X600 x1_single_m3__f1_0.x1_m2d x1_single_m3__f1_0.x1_m2d x1_single_m3__f1_0.x1_m2d VSS sky130_fd_pr__nfet_01v8 ad=0.406 pd=3.38 as=21.924 ps=182.52 w=1.4 l=0.6
X601 x2_cm_casc__cc6_0.bias_d x1_single_m3__f1_0.x1_m2d x1_single_m3__f1_0.x1_m2d VSS sky130_fd_pr__nfet_01v8 ad=0.406 pd=3.38 as=0.406 ps=3.38 w=1.4 l=0.6
X602 x2_cm_tail__cc6_0.x2_m3d bias_a VSS VSS sky130_fd_pr__nfet_01v8 ad=0.406 pd=3.38 as=0.406 ps=3.38 w=1.4 l=0.6
X603 x2_diff__cc1_0.x2_foldp x2_cl_src__id4_0.bias_b VDD VDD sky130_fd_pr__pfet_01v8_lvt ad=0.406 pd=3.38 as=0.406 ps=3.38 w=1.4 l=0.6
X604 x2_cl_casc__cc1_0.bias_c x2_cl_src__id4_0.bias_b x2_cl_src__id4_0.bias_b VSS sky130_fd_pr__nfet_01v8_lvt ad=0.406 pd=3.38 as=0.406 ps=3.38 w=1.4 l=0.6
X605 VSS VSS x1_single_m5__f3_0.x1_m5d VSS sky130_fd_pr__nfet_01v8 ad=0.406 pd=3.38 as=0.406 ps=3.38 w=1.4 l=0.6
X606 x2_cm_tail__cc6_0.x2_m3d bias_a VSS VSS sky130_fd_pr__nfet_01v8 ad=0.406 pd=3.38 as=0.406 ps=3.38 w=1.4 l=0.6
X607 x2_cm_casc__cc6_0.bias_d x1_single_m3__f1_0.x1_m2d bias_a VSS sky130_fd_pr__nfet_01v8 ad=0.406 pd=3.38 as=0.406 ps=3.38 w=1.4 l=0.6
X608 VSS VSS x2_cm_tail__cc6_0.x2_m4d VSS sky130_fd_pr__nfet_01v8 ad=0.406 pd=3.38 as=0.406 ps=3.38 w=1.4 l=0.6
X609 x1_single_m3__f1_0.x1_m2d x1_single_m3__f1_0.x1_m2d x1_single_m3__f1_0.x1_m2d VSS sky130_fd_pr__nfet_01v8 ad=0.406 pd=3.38 as=0 ps=0 w=1.4 l=0.6
X610 VSS VSS VSS VSS sky130_fd_pr__nfet_01v8 ad=0.406 pd=3.38 as=0 ps=0 w=1.4 l=0.6
X611 x1_cm_bias_c__cc1_0.x1_m21d x2_cl_src__id4_0.bias_b VDD VDD sky130_fd_pr__pfet_01v8_lvt ad=0.406 pd=3.38 as=0.406 ps=3.38 w=1.4 l=0.6
X612 x2_diff__cc1_0.x2_tail bias_a VSS VSS sky130_fd_pr__nfet_01v8 ad=0.406 pd=3.38 as=0.406 ps=3.38 w=1.4 l=0.6
X613 x2_cl_casc__cc1_0.bias_c IBIAS VSS VSS sky130_fd_pr__nfet_01v8 ad=0.406 pd=3.38 as=0.406 ps=3.38 w=1.4 l=0.6
X614 VDD VDD VDD VDD sky130_fd_pr__pfet_01v8_lvt ad=0.406 pd=3.38 as=0 ps=0 w=1.4 l=0.6
X615 x1_cc_cm__strings1_0.x1_net9 cm VSS VSS sky130_fd_pr__nfet_01v8 ad=0.406 pd=3.38 as=0.406 ps=3.38 w=1.4 l=0.6
X616 x2_cm_tail__cc6_0.x2_m3d x2_cm_casc__cc6_0.bias_d on VSS sky130_fd_pr__nfet_01v8 ad=0.406 pd=3.38 as=0.406 ps=3.38 w=1.4 l=0.6
X617 VSS cmc x2_diff__cc1_0.x2_tail VSS sky130_fd_pr__nfet_01v8 ad=0.406 pd=3.38 as=0.406 ps=3.38 w=1.4 l=0.6
X618 VSS bias_a x1_single_m5__f3_0.x1_m5d VSS sky130_fd_pr__nfet_01v8 ad=0.406 pd=3.38 as=0.406 ps=3.38 w=1.4 l=0.6
X619 x2_diff__cc1_0.x2_foldn x2_cl_casc__cc1_0.bias_c op VDD sky130_fd_pr__pfet_01v8 ad=0.406 pd=3.38 as=0.406 ps=3.38 w=1.4 l=0.6
X620 x2_diff__cc1_0.x2_foldp x2_cl_casc__cc1_0.bias_c on VDD sky130_fd_pr__pfet_01v8 ad=0.406 pd=3.38 as=0.406 ps=3.38 w=1.4 l=0.6
X621 x1_single_m3__f1_0.x1_m2d x1_single_m3__f1_0.x1_m2d x2_cm_casc__cc6_0.bias_d VSS sky130_fd_pr__nfet_01v8 ad=0.406 pd=3.38 as=0.406 ps=3.38 w=1.4 l=0.6
X622 x1_single_m5__f3_0.x1_m5d bias_a VSS VSS sky130_fd_pr__nfet_01v8 ad=0.406 pd=3.38 as=0.406 ps=3.38 w=1.4 l=0.6
X623 IBIAS IBIAS IBIAS VSS sky130_fd_pr__nfet_01v8 ad=0.406 pd=3.38 as=0 ps=0 w=1.4 l=0.6
X624 x2_cl_casc__cc1_0.bias_c x2_cl_src__id4_0.bias_b x2_cl_src__id4_0.bias_b VSS sky130_fd_pr__nfet_01v8_lvt ad=0.406 pd=3.38 as=0.406 ps=3.38 w=1.4 l=0.6
X625 VSS bias_a x1_single_m5__f3_0.x1_m5d VSS sky130_fd_pr__nfet_01v8 ad=0.406 pd=3.38 as=0.406 ps=3.38 w=1.4 l=0.6
X626 VSS bias_a x2_cm_tail__cc6_0.x2_m3d VSS sky130_fd_pr__nfet_01v8 ad=0.406 pd=3.38 as=0.406 ps=3.38 w=1.4 l=0.6
X627 on x2_cm_casc__cc6_0.bias_d x2_cm_tail__cc6_0.x2_m3d VSS sky130_fd_pr__nfet_01v8 ad=0.406 pd=3.38 as=0.406 ps=3.38 w=1.4 l=0.6
X628 op cmc sky130_fd_pr__cap_mim_m3_1 l=4.8 w=4.8
X629 x1_single_m3__f1_0.x1_m2d x1_single_m3__f1_0.x1_m2d x2_cm_casc__cc6_0.bias_d VSS sky130_fd_pr__nfet_01v8 ad=0.406 pd=3.38 as=0.406 ps=3.38 w=1.4 l=0.6
X630 x1_single_m5__f3_0.x1_m5d bias_a VSS VSS sky130_fd_pr__nfet_01v8 ad=0.406 pd=3.38 as=0.406 ps=3.38 w=1.4 l=0.6
X631 x1_cm_bias_c__cc1_0.x1_m31d x2_cl_src__id4_0.bias_b VDD VDD sky130_fd_pr__pfet_01v8_lvt ad=0.406 pd=3.38 as=0.406 ps=3.38 w=1.4 l=0.6
X632 x2_cl_src__id4_0.bias_b x2_cl_src__id4_0.bias_b x2_cl_casc__cc1_0.bias_c VSS sky130_fd_pr__nfet_01v8_lvt ad=0.406 pd=3.38 as=0.406 ps=3.38 w=1.4 l=0.6
X633 x2_diff__cc1_0.x2_tail cmc VSS VSS sky130_fd_pr__nfet_01v8 ad=0.406 pd=3.38 as=0.406 ps=3.38 w=1.4 l=0.6
X634 VSS bias_a x2_diff__cc1_0.x2_tail VSS sky130_fd_pr__nfet_01v8 ad=0.406 pd=3.38 as=0.406 ps=3.38 w=1.4 l=0.6
X635 cm x2_cl_casc__cc1_0.bias_c x1_cm_bias_c__cc1_0.x1_m31d VDD sky130_fd_pr__pfet_01v8 ad=0.406 pd=3.38 as=0.406 ps=3.38 w=1.4 l=0.6
X636 x2_diff__cc1_0.x2_tail ip x2_diff__cc1_0.x2_foldp VSS sky130_fd_pr__nfet_01v8_lvt ad=0.348 pd=2.98 as=0.348 ps=2.98 w=1.2 l=0.2
X637 op x2_cm_casc__cc6_0.bias_d x2_cm_tail__cc6_0.x2_m4d VSS sky130_fd_pr__nfet_01v8 ad=0.406 pd=3.38 as=0.406 ps=3.38 w=1.4 l=0.6
X638 x2_diff__cc1_0.x2_tail bias_a VSS VSS sky130_fd_pr__nfet_01v8 ad=0.406 pd=3.38 as=0.406 ps=3.38 w=1.4 l=0.6
X639 x2_diff__cc1_0.x2_tail cmc VSS VSS sky130_fd_pr__nfet_01v8 ad=0.406 pd=3.38 as=0.406 ps=3.38 w=1.4 l=0.6
X640 VSS VSS VSS VSS sky130_fd_pr__nfet_01v8 ad=0.406 pd=3.38 as=0 ps=0 w=1.4 l=0.6
X641 VSS cmc x2_diff__cc1_0.x2_tail VSS sky130_fd_pr__nfet_01v8 ad=0.406 pd=3.38 as=0.406 ps=3.38 w=1.4 l=0.6
X642 VSS IBIAS x2_cl_casc__cc1_0.bias_c VSS sky130_fd_pr__nfet_01v8 ad=0.406 pd=3.38 as=0.406 ps=3.38 w=1.4 l=0.6
X643 VSS bias_a x2_diff__cc1_0.x2_tail VSS sky130_fd_pr__nfet_01v8 ad=0.406 pd=3.38 as=0.406 ps=3.38 w=1.4 l=0.6
X644 VSS bias_a x2_cm_tail__cc6_0.x2_m4d VSS sky130_fd_pr__nfet_01v8 ad=0.406 pd=3.38 as=0.406 ps=3.38 w=1.4 l=0.6
X645 x2_cm_tail__cc6_0.x2_m3d bias_a VSS VSS sky130_fd_pr__nfet_01v8 ad=0.406 pd=3.38 as=0.406 ps=3.38 w=1.4 l=0.6
X646 VSS VSS x2_cm_tail__cc6_0.x2_m4d VSS sky130_fd_pr__nfet_01v8 ad=0.406 pd=3.38 as=0.406 ps=3.38 w=1.4 l=0.6
X647 x1_cm_bias_c__cc1_0.x1_m21d x2_cl_casc__cc1_0.bias_c x2_cl_src__id4_0.bias_b VDD sky130_fd_pr__pfet_01v8 ad=0.406 pd=3.38 as=0.406 ps=3.38 w=1.4 l=0.6
X648 op x2_cl_casc__cc1_0.bias_c x2_diff__cc1_0.x2_foldn VDD sky130_fd_pr__pfet_01v8 ad=0.406 pd=3.38 as=0.406 ps=3.38 w=1.4 l=0.6
X649 x2_cl_casc__cc1_0.bias_c x2_cl_src__id4_0.bias_b x2_cl_src__id4_0.bias_b VSS sky130_fd_pr__nfet_01v8_lvt ad=0.406 pd=3.38 as=0.406 ps=3.38 w=1.4 l=0.6
X650 x2_diff__cc1_0.x2_foldp x2_cl_src__id4_0.bias_b VDD VDD sky130_fd_pr__pfet_01v8_lvt ad=0.406 pd=3.38 as=0.406 ps=3.38 w=1.4 l=0.6
X651 x2_cm_tail__cc6_0.x2_m4d x2_cm_casc__cc6_0.bias_d op VSS sky130_fd_pr__nfet_01v8 ad=0.406 pd=3.38 as=0.406 ps=3.38 w=1.4 l=0.6
X652 x2_diff__cc1_0.x2_tail cmc VSS VSS sky130_fd_pr__nfet_01v8 ad=0.406 pd=3.38 as=0.406 ps=3.38 w=1.4 l=0.6
X653 x1_single_m3__f1_0.x1_m2d x2_cl_casc__cc1_0.bias_c x1_cm_bias_c__cc1_0.x1_m25d VDD sky130_fd_pr__pfet_01v8 ad=0.406 pd=3.38 as=0.406 ps=3.38 w=1.4 l=0.6
X654 VSS bias_a x2_diff__cc1_0.x2_tail VSS sky130_fd_pr__nfet_01v8 ad=0.406 pd=3.38 as=0.406 ps=3.38 w=1.4 l=0.6
X655 VSS bias_a x2_diff__cc1_0.x2_tail VSS sky130_fd_pr__nfet_01v8 ad=0.406 pd=3.38 as=0.406 ps=3.38 w=1.4 l=0.6
X656 x2_diff__cc1_0.x2_tail bias_a VSS VSS sky130_fd_pr__nfet_01v8 ad=0.406 pd=3.38 as=0.406 ps=3.38 w=1.4 l=0.6
X657 VDD VDD x1_single_m3__f1_0.x1_m2d VDD sky130_fd_pr__pfet_01v8 ad=0.406 pd=3.38 as=0.406 ps=3.38 w=1.4 l=0.6
X658 VDD x2_cl_src__id4_0.bias_b x2_diff__cc1_0.x2_foldp VDD sky130_fd_pr__pfet_01v8_lvt ad=0.406 pd=3.38 as=0.406 ps=3.38 w=1.4 l=0.6
X659 x2_cl_src__id4_0.bias_b x2_cl_src__id4_0.bias_b x2_cl_casc__cc1_0.bias_c VSS sky130_fd_pr__nfet_01v8_lvt ad=0.406 pd=3.38 as=0.406 ps=3.38 w=1.4 l=0.6
X660 x2_cl_casc__cc1_0.bias_c x2_cl_casc__cc1_0.bias_c x2_cl_casc__cc1_0.bias_c VSS sky130_fd_pr__nfet_01v8_lvt ad=0.406 pd=3.38 as=0 ps=0 w=1.4 l=0.6
X661 VDD x2_cl_src__id4_0.bias_b x1_cm_bias_c__cc1_0.x1_m21d VDD sky130_fd_pr__pfet_01v8_lvt ad=0.406 pd=3.38 as=0.406 ps=3.38 w=1.4 l=0.6
X662 x1_cc_cm__strings1_0.x1_net15 cm x1_cc_cm__strings1_0.x1_net14 VSS sky130_fd_pr__nfet_01v8 ad=0.406 pd=3.38 as=0.406 ps=3.38 w=1.4 l=0.6
X663 x2_diff__cc1_0.x2_tail ip x2_diff__cc1_0.x2_foldp VSS sky130_fd_pr__nfet_01v8_lvt ad=0.348 pd=2.98 as=0.348 ps=2.98 w=1.2 l=0.2
X664 x2_cm_tail__cc6_0.x2_m3d x2_cm_casc__cc6_0.bias_d on VSS sky130_fd_pr__nfet_01v8 ad=0.406 pd=3.38 as=0.406 ps=3.38 w=1.4 l=0.6
X665 VSS bias_a x2_cm_tail__cc6_0.x2_m3d VSS sky130_fd_pr__nfet_01v8 ad=0.406 pd=3.38 as=0.406 ps=3.38 w=1.4 l=0.6
X666 VSS bias_a x2_diff__cc1_0.x2_tail VSS sky130_fd_pr__nfet_01v8 ad=0.406 pd=3.38 as=0.406 ps=3.38 w=1.4 l=0.6
X667 x2_cm_tail__cc6_0.x2_m4d bias_a VSS VSS sky130_fd_pr__nfet_01v8 ad=0.406 pd=3.38 as=0.406 ps=3.38 w=1.4 l=0.6
X668 x1_cm_bias_c__cc1_0.x1_m25d x1_cm_bias_c__cc1_0.x1_m25d x1_cm_bias_c__cc1_0.x1_m25d VDD sky130_fd_pr__pfet_01v8_lvt ad=0.406 pd=3.38 as=0 ps=0 w=1.4 l=0.6
X669 x2_cm_casc__cc6_0.bias_d x1_single_m3__f1_0.x1_m2d x1_single_m3__f1_0.x1_m2d VSS sky130_fd_pr__nfet_01v8 ad=0.406 pd=3.38 as=0.406 ps=3.38 w=1.4 l=0.6
X670 x1_single_m5__f3_0.x1_m5d bias_a VSS VSS sky130_fd_pr__nfet_01v8 ad=0.406 pd=3.38 as=0.406 ps=3.38 w=1.4 l=0.6
X671 VSS bias_a x2_cm_tail__cc6_0.x2_m3d VSS sky130_fd_pr__nfet_01v8 ad=0.406 pd=3.38 as=0.406 ps=3.38 w=1.4 l=0.6
X672 x2_diff__cc1_0.x2_foldn x2_cl_src__id4_0.bias_b VDD VDD sky130_fd_pr__pfet_01v8_lvt ad=0.406 pd=3.38 as=0.406 ps=3.38 w=1.4 l=0.6
X673 VSS bias_a x2_diff__cc1_0.x2_tail VSS sky130_fd_pr__nfet_01v8 ad=0.406 pd=3.38 as=0.406 ps=3.38 w=1.4 l=0.6
X674 VSS bias_a x2_diff__cc1_0.x2_tail VSS sky130_fd_pr__nfet_01v8 ad=0.406 pd=3.38 as=0.406 ps=3.38 w=1.4 l=0.6
X675 x2_diff__cc1_0.x2_tail cmc VSS VSS sky130_fd_pr__nfet_01v8 ad=0.406 pd=3.38 as=0.406 ps=3.38 w=1.4 l=0.6
X676 VSS VSS x2_cm_tail__cc6_0.x2_m3d VSS sky130_fd_pr__nfet_01v8 ad=0.406 pd=3.38 as=0.406 ps=3.38 w=1.4 l=0.6
X677 op x2_cl_casc__cc1_0.bias_c x2_diff__cc1_0.x2_foldn VDD sky130_fd_pr__pfet_01v8 ad=0.406 pd=3.38 as=0.406 ps=3.38 w=1.4 l=0.6
X678 x2_cl_casc__cc1_0.bias_c x2_cl_src__id4_0.bias_b x2_cl_src__id4_0.bias_b VSS sky130_fd_pr__nfet_01v8_lvt ad=0.406 pd=3.38 as=0.406 ps=3.38 w=1.4 l=0.6
X679 x1_cm_bias_c__cc1_0.x1_m31d x2_cl_src__id4_0.bias_b VDD VDD sky130_fd_pr__pfet_01v8_lvt ad=0.406 pd=3.38 as=0.406 ps=3.38 w=1.4 l=0.6
X680 x2_cm_tail__cc6_0.x2_m4d bias_a VSS VSS sky130_fd_pr__nfet_01v8 ad=0.406 pd=3.38 as=0.406 ps=3.38 w=1.4 l=0.6
X681 x2_diff__cc1_0.x2_foldp ip x2_diff__cc1_0.x2_tail VSS sky130_fd_pr__nfet_01v8_lvt ad=0.348 pd=2.98 as=0.348 ps=2.98 w=1.2 l=0.2
X682 x2_cm_casc__cc6_0.bias_d x2_cm_casc__cc6_0.bias_d x2_cm_casc__cc6_0.bias_d VSS sky130_fd_pr__nfet_01v8 ad=0.406 pd=3.38 as=0 ps=0 w=1.4 l=0.6
X683 x2_cm_tail__cc6_0.x2_m4d bias_a VSS VSS sky130_fd_pr__nfet_01v8 ad=0.406 pd=3.38 as=0.406 ps=3.38 w=1.4 l=0.6
X684 x2_cm_tail__cc6_0.x2_m3d x2_cm_casc__cc6_0.bias_d on VSS sky130_fd_pr__nfet_01v8 ad=0.406 pd=3.38 as=0.406 ps=3.38 w=1.4 l=0.6
X685 x2_cm_tail__cc6_0.x2_m4d x2_cm_casc__cc6_0.bias_d op VSS sky130_fd_pr__nfet_01v8 ad=0.406 pd=3.38 as=0.406 ps=3.38 w=1.4 l=0.6
X686 on x2_cl_casc__cc1_0.bias_c x2_diff__cc1_0.x2_foldp VDD sky130_fd_pr__pfet_01v8 ad=0.406 pd=3.38 as=0.406 ps=3.38 w=1.4 l=0.6
X687 x2_cl_casc__cc1_0.bias_c x2_cl_src__id4_0.bias_b x2_cl_src__id4_0.bias_b VSS sky130_fd_pr__nfet_01v8_lvt ad=0.406 pd=3.38 as=0.406 ps=3.38 w=1.4 l=0.6
X688 x2_cl_casc__cc1_0.bias_c x2_cl_casc__cc1_0.bias_c x2_cl_casc__cc1_0.bias_c VSS sky130_fd_pr__nfet_01v8_lvt ad=0.406 pd=3.38 as=0 ps=0 w=1.4 l=0.6
X689 x2_cm_tail__cc6_0.x2_m4d bias_a VSS VSS sky130_fd_pr__nfet_01v8 ad=0.406 pd=3.38 as=0.406 ps=3.38 w=1.4 l=0.6
X690 x2_diff__cc1_0.x2_tail cmc VSS VSS sky130_fd_pr__nfet_01v8 ad=0.406 pd=3.38 as=0.406 ps=3.38 w=1.4 l=0.6
X691 VDD VDD cm VDD sky130_fd_pr__pfet_01v8 ad=0.406 pd=3.38 as=0.406 ps=3.38 w=1.4 l=0.6
X692 op x2_cm_casc__cc6_0.bias_d x2_cm_tail__cc6_0.x2_m4d VSS sky130_fd_pr__nfet_01v8 ad=0.406 pd=3.38 as=0.406 ps=3.38 w=1.4 l=0.6
X693 x1_single_m5__f3_0.x1_m5d x2_cm_casc__cc6_0.bias_d bias_a VSS sky130_fd_pr__nfet_01v8 ad=0.406 pd=3.38 as=0.406 ps=3.38 w=1.4 l=0.6
X694 x1_cm_bias_c__cc1_0.x1_m25d x1_cm_bias_c__cc1_0.x1_m25d x1_cm_bias_c__cc1_0.x1_m25d VDD sky130_fd_pr__pfet_01v8_lvt ad=0.406 pd=3.38 as=0 ps=0 w=1.4 l=0.6
X695 VSS VSS VSS VSS sky130_fd_pr__nfet_01v8 ad=0.406 pd=3.38 as=0 ps=0 w=1.4 l=0.6
X696 x2_cm_tail__cc6_0.x2_m3d x2_cm_casc__cc6_0.bias_d on VSS sky130_fd_pr__nfet_01v8 ad=0.406 pd=3.38 as=0.406 ps=3.38 w=1.4 l=0.6
X697 VSS cmc x2_diff__cc1_0.x2_tail VSS sky130_fd_pr__nfet_01v8 ad=0.406 pd=3.38 as=0.406 ps=3.38 w=1.4 l=0.6
X698 VDD VDD cm VDD sky130_fd_pr__pfet_01v8 ad=0.406 pd=3.38 as=0.406 ps=3.38 w=1.4 l=0.6
X699 VDD VDD x2_diff__cc1_0.x2_foldp VDD sky130_fd_pr__pfet_01v8 ad=0.406 pd=3.38 as=0.406 ps=3.38 w=1.4 l=0.6
X700 x1_single_m5__f3_0.x1_m5d bias_a VSS VSS sky130_fd_pr__nfet_01v8 ad=0.406 pd=3.38 as=0.406 ps=3.38 w=1.4 l=0.6
X701 VDD x2_cl_src__id4_0.bias_b x2_diff__cc1_0.x2_foldp VDD sky130_fd_pr__pfet_01v8_lvt ad=0.406 pd=3.38 as=0.406 ps=3.38 w=1.4 l=0.6
X702 VSS bias_a x2_diff__cc1_0.x2_tail VSS sky130_fd_pr__nfet_01v8 ad=0.406 pd=3.38 as=0.406 ps=3.38 w=1.4 l=0.6
X703 VDD x2_cl_src__id4_0.bias_b x1_cm_bias_c__cc1_0.x1_m21d VDD sky130_fd_pr__pfet_01v8_lvt ad=0.406 pd=3.38 as=0.406 ps=3.38 w=1.4 l=0.6
X704 bias_a bias_a bias_a VSS sky130_fd_pr__nfet_01v8 ad=0.406 pd=3.38 as=0 ps=0 w=1.4 l=0.6
X705 VSS bias_a x2_diff__cc1_0.x2_tail VSS sky130_fd_pr__nfet_01v8 ad=0.406 pd=3.38 as=0.406 ps=3.38 w=1.4 l=0.6
X706 op x2_cm_casc__cc6_0.bias_d x2_cm_tail__cc6_0.x2_m4d VSS sky130_fd_pr__nfet_01v8 ad=0.406 pd=3.38 as=0.406 ps=3.38 w=1.4 l=0.6
X707 on x2_cm_casc__cc6_0.bias_d x2_cm_tail__cc6_0.x2_m3d VSS sky130_fd_pr__nfet_01v8 ad=0.406 pd=3.38 as=0.406 ps=3.38 w=1.4 l=0.6
X708 x2_diff__cc1_0.x2_tail bias_a VSS VSS sky130_fd_pr__nfet_01v8 ad=0.406 pd=3.38 as=0.406 ps=3.38 w=1.4 l=0.6
X709 x1_single_m5__f3_0.x1_m5d bias_a VSS VSS sky130_fd_pr__nfet_01v8 ad=0.406 pd=3.38 as=0.406 ps=3.38 w=1.4 l=0.6
X710 VSS cmc x2_diff__cc1_0.x2_tail VSS sky130_fd_pr__nfet_01v8 ad=0.406 pd=3.38 as=0.406 ps=3.38 w=1.4 l=0.6
X711 VSS cmc x2_diff__cc1_0.x2_tail VSS sky130_fd_pr__nfet_01v8 ad=0.406 pd=3.38 as=0.406 ps=3.38 w=1.4 l=0.6
X712 VDD VDD x2_diff__cc1_0.x2_foldn VDD sky130_fd_pr__pfet_01v8 ad=0.406 pd=3.38 as=0.406 ps=3.38 w=1.4 l=0.6
X713 on x2_cl_casc__cc1_0.bias_c x2_diff__cc1_0.x2_foldp VDD sky130_fd_pr__pfet_01v8 ad=0.406 pd=3.38 as=0.406 ps=3.38 w=1.4 l=0.6
X714 x2_diff__cc1_0.x2_tail bias_a VSS VSS sky130_fd_pr__nfet_01v8 ad=0.406 pd=3.38 as=0.406 ps=3.38 w=1.4 l=0.6
X715 VSS cmc x2_diff__cc1_0.x2_tail VSS sky130_fd_pr__nfet_01v8 ad=0.406 pd=3.38 as=0.406 ps=3.38 w=1.4 l=0.6
X716 x2_diff__cc1_0.x2_foldn x2_cl_src__id4_0.bias_b VDD VDD sky130_fd_pr__pfet_01v8_lvt ad=0.406 pd=3.38 as=0.406 ps=3.38 w=1.4 l=0.6
X717 VDD x2_cl_src__id4_0.bias_b x2_diff__cc1_0.x2_foldn VDD sky130_fd_pr__pfet_01v8_lvt ad=0.406 pd=3.38 as=0.406 ps=3.38 w=1.4 l=0.6
X718 VSS IBIAS x2_cl_casc__cc1_0.bias_c VSS sky130_fd_pr__nfet_01v8 ad=0.406 pd=3.38 as=0.406 ps=3.38 w=1.4 l=0.6
X719 x2_diff__cc1_0.x2_tail bias_a VSS VSS sky130_fd_pr__nfet_01v8 ad=0.406 pd=3.38 as=0.406 ps=3.38 w=1.4 l=0.6
X720 x2_cm_tail__cc6_0.x2_m4d bias_a VSS VSS sky130_fd_pr__nfet_01v8 ad=0.406 pd=3.38 as=0.406 ps=3.38 w=1.4 l=0.6
X721 VSS VSS VSS VSS sky130_fd_pr__nfet_01v8 ad=0.406 pd=3.38 as=0 ps=0 w=1.4 l=0.6
X722 x1_single_m3__f1_0.x1_m2d x1_single_m3__f1_0.x1_m2d x2_cm_casc__cc6_0.bias_d VSS sky130_fd_pr__nfet_01v8 ad=0.406 pd=3.38 as=0.406 ps=3.38 w=1.4 l=0.6
X723 bias_a x2_cm_casc__cc6_0.bias_d x1_single_m5__f3_0.x1_m5d VSS sky130_fd_pr__nfet_01v8 ad=0.406 pd=3.38 as=0.406 ps=3.38 w=1.4 l=0.6
X724 x2_diff__cc1_0.x2_foldn x2_cl_casc__cc1_0.bias_c op VDD sky130_fd_pr__pfet_01v8 ad=0.406 pd=3.38 as=0.406 ps=3.38 w=1.4 l=0.6
X725 op cmc sky130_fd_pr__cap_mim_m3_1 l=4.8 w=4.8
X726 VSS VSS x2_cm_tail__cc6_0.x2_m3d VSS sky130_fd_pr__nfet_01v8 ad=0.406 pd=3.38 as=0.406 ps=3.38 w=1.4 l=0.6
X727 x2_cl_src__id4_0.bias_b x2_cl_src__id4_0.bias_b x2_cl_casc__cc1_0.bias_c VSS sky130_fd_pr__nfet_01v8_lvt ad=0.406 pd=3.38 as=0.406 ps=3.38 w=1.4 l=0.6
X728 VSS VSS VSS VSS sky130_fd_pr__nfet_01v8 ad=0.406 pd=3.38 as=0 ps=0 w=1.4 l=0.6
X729 VSS cmc x2_diff__cc1_0.x2_tail VSS sky130_fd_pr__nfet_01v8 ad=0.406 pd=3.38 as=0.406 ps=3.38 w=1.4 l=0.6
X730 x2_diff__cc1_0.x2_foldp x2_diff__cc1_0.x2_foldp x2_diff__cc1_0.x2_foldp VDD sky130_fd_pr__pfet_01v8 ad=0.406 pd=3.38 as=0 ps=0 w=1.4 l=0.6
X731 x2_cm_tail__cc6_0.x2_m4d x2_cm_casc__cc6_0.bias_d op VSS sky130_fd_pr__nfet_01v8 ad=0.406 pd=3.38 as=0.406 ps=3.38 w=1.4 l=0.6
X732 bias_a x2_cm_casc__cc6_0.bias_d x1_single_m5__f3_0.x1_m5d VSS sky130_fd_pr__nfet_01v8 ad=0.406 pd=3.38 as=0.406 ps=3.38 w=1.4 l=0.6
X733 x1_cc_cm__strings1_0.x1_net6 cm VSS VSS sky130_fd_pr__nfet_01v8 ad=0.406 pd=3.38 as=0.406 ps=3.38 w=1.4 l=0.6
X734 x1_single_m3__f1_0.x1_m2d x1_single_m3__f1_0.x1_m2d x2_cm_casc__cc6_0.bias_d VSS sky130_fd_pr__nfet_01v8 ad=0.406 pd=3.38 as=0.406 ps=3.38 w=1.4 l=0.6
X735 VSS cmc x2_diff__cc1_0.x2_tail VSS sky130_fd_pr__nfet_01v8 ad=0.406 pd=3.38 as=0.406 ps=3.38 w=1.4 l=0.6
X736 VDD x2_cl_src__id4_0.bias_b x2_diff__cc1_0.x2_foldn VDD sky130_fd_pr__pfet_01v8_lvt ad=0.406 pd=3.38 as=0.406 ps=3.38 w=1.4 l=0.6
X737 x2_diff__cc1_0.x2_tail cmc VSS VSS sky130_fd_pr__nfet_01v8 ad=0.406 pd=3.38 as=0.406 ps=3.38 w=1.4 l=0.6
X738 x2_cl_src__id4_0.bias_b x2_cl_src__id4_0.bias_b x2_cl_src__id4_0.bias_b VSS sky130_fd_pr__nfet_01v8_lvt ad=0.406 pd=3.38 as=0 ps=0 w=1.4 l=0.6
X739 x2_diff__cc1_0.x2_foldn in x2_diff__cc1_0.x2_tail VSS sky130_fd_pr__nfet_01v8_lvt ad=0.348 pd=2.98 as=0.348 ps=2.98 w=1.2 l=0.2
X740 VDD VDD x2_cl_src__id4_0.bias_b VDD sky130_fd_pr__pfet_01v8 ad=0.406 pd=3.38 as=0.406 ps=3.38 w=1.4 l=0.6
X741 VDD x2_cl_src__id4_0.bias_b x2_diff__cc1_0.x2_foldn VDD sky130_fd_pr__pfet_01v8_lvt ad=0.406 pd=3.38 as=0.406 ps=3.38 w=1.4 l=0.6
X742 on x2_cl_casc__cc1_0.bias_c x2_diff__cc1_0.x2_foldp VDD sky130_fd_pr__pfet_01v8 ad=0.406 pd=3.38 as=0.406 ps=3.38 w=1.4 l=0.6
X743 on on on VSS sky130_fd_pr__nfet_01v8 ad=0.406 pd=3.38 as=0 ps=0 w=1.4 l=0.6
X744 VDD x2_cl_src__id4_0.bias_b x1_cm_bias_c__cc1_0.x1_m25d VDD sky130_fd_pr__pfet_01v8_lvt ad=0.406 pd=3.38 as=0.406 ps=3.38 w=1.4 l=0.6
X745 x2_cm_tail__cc6_0.x2_m3d bias_a VSS VSS sky130_fd_pr__nfet_01v8 ad=0.406 pd=3.38 as=0.406 ps=3.38 w=1.4 l=0.6
X746 x2_cm_tail__cc6_0.x2_m3d x2_cm_casc__cc6_0.bias_d on VSS sky130_fd_pr__nfet_01v8 ad=0.406 pd=3.38 as=0.406 ps=3.38 w=1.4 l=0.6
X747 VSS bias_a x2_cm_tail__cc6_0.x2_m3d VSS sky130_fd_pr__nfet_01v8 ad=0.406 pd=3.38 as=0.406 ps=3.38 w=1.4 l=0.6
X748 VDD VDD x1_cm_bias_c__cc1_0.x1_m31d VDD sky130_fd_pr__pfet_01v8 ad=0.406 pd=3.38 as=0.406 ps=3.38 w=1.4 l=0.6
X749 VDD x2_cl_src__id4_0.bias_b x2_diff__cc1_0.x2_foldp VDD sky130_fd_pr__pfet_01v8_lvt ad=0.406 pd=3.38 as=0.406 ps=3.38 w=1.4 l=0.6
X750 VSS cmc x2_diff__cc1_0.x2_tail VSS sky130_fd_pr__nfet_01v8 ad=0.406 pd=3.38 as=0.406 ps=3.38 w=1.4 l=0.6
X751 x2_cl_casc__cc1_0.bias_c x2_cl_src__id4_0.bias_b x2_cl_src__id4_0.bias_b VSS sky130_fd_pr__nfet_01v8_lvt ad=0.406 pd=3.38 as=0.406 ps=3.38 w=1.4 l=0.6
X752 VSS bias_a x2_cm_tail__cc6_0.x2_m4d VSS sky130_fd_pr__nfet_01v8 ad=0.406 pd=3.38 as=0.406 ps=3.38 w=1.4 l=0.6
X753 x1_cm_bias_c__cc1_0.x1_m25d x2_cl_src__id4_0.bias_b VDD VDD sky130_fd_pr__pfet_01v8_lvt ad=0.406 pd=3.38 as=0.406 ps=3.38 w=1.4 l=0.6
X754 VDD VDD VDD VDD sky130_fd_pr__pfet_01v8 ad=0.406 pd=3.38 as=0 ps=0 w=1.4 l=0.6
X755 VSS cm x1_cc_cm__strings1_0.x1_net15 VSS sky130_fd_pr__nfet_01v8 ad=0.406 pd=3.38 as=0.406 ps=3.38 w=1.4 l=0.6
X756 VSS bias_a x2_cm_tail__cc6_0.x2_m4d VSS sky130_fd_pr__nfet_01v8 ad=0.406 pd=3.38 as=0.406 ps=3.38 w=1.4 l=0.6
X757 VSS cmc x2_diff__cc1_0.x2_tail VSS sky130_fd_pr__nfet_01v8 ad=0.406 pd=3.38 as=0.406 ps=3.38 w=1.4 l=0.6
X758 x2_cm_casc__cc6_0.bias_d x1_single_m3__f1_0.x1_m2d x1_single_m3__f1_0.x1_m2d VSS sky130_fd_pr__nfet_01v8 ad=0.406 pd=3.38 as=0.406 ps=3.38 w=1.4 l=0.6
X759 op x2_cm_casc__cc6_0.bias_d x2_cm_tail__cc6_0.x2_m4d VSS sky130_fd_pr__nfet_01v8 ad=0.406 pd=3.38 as=0.406 ps=3.38 w=1.4 l=0.6
X760 VSS cmc x2_diff__cc1_0.x2_tail VSS sky130_fd_pr__nfet_01v8 ad=0.406 pd=3.38 as=0.406 ps=3.38 w=1.4 l=0.6
X761 x2_diff__cc1_0.x2_tail bias_a VSS VSS sky130_fd_pr__nfet_01v8 ad=0.406 pd=3.38 as=0.406 ps=3.38 w=1.4 l=0.6
X762 x2_cm_casc__cc6_0.bias_d x1_single_m3__f1_0.x1_m2d x1_single_m3__f1_0.x1_m2d VSS sky130_fd_pr__nfet_01v8 ad=0.406 pd=3.38 as=0.406 ps=3.38 w=1.4 l=0.6
X763 VSS cmc x2_diff__cc1_0.x2_tail VSS sky130_fd_pr__nfet_01v8 ad=0.406 pd=3.38 as=0.406 ps=3.38 w=1.4 l=0.6
X764 VSS IBIAS x2_cl_casc__cc1_0.bias_c VSS sky130_fd_pr__nfet_01v8 ad=0.406 pd=3.38 as=0.406 ps=3.38 w=1.4 l=0.6
X765 op cmc sky130_fd_pr__cap_mim_m3_1 l=4.8 w=4.8
X766 VDD x2_cl_src__id4_0.bias_b x2_diff__cc1_0.x2_foldn VDD sky130_fd_pr__pfet_01v8_lvt ad=0.406 pd=3.38 as=0.406 ps=3.38 w=1.4 l=0.6
X767 x1_cm_bias_c__cc1_0.x1_m21d x1_cm_bias_c__cc1_0.x1_m21d x1_cm_bias_c__cc1_0.x1_m21d VDD sky130_fd_pr__pfet_01v8 ad=0.406 pd=3.38 as=0 ps=0 w=1.4 l=0.6
X768 x2_diff__cc1_0.x2_tail cmc VSS VSS sky130_fd_pr__nfet_01v8 ad=0.406 pd=3.38 as=0.406 ps=3.38 w=1.4 l=0.6
X769 x2_cm_casc__cc6_0.bias_d x2_cm_casc__cc6_0.bias_d x2_cm_casc__cc6_0.bias_d VSS sky130_fd_pr__nfet_01v8 ad=0.406 pd=3.38 as=0 ps=0 w=1.4 l=0.6
X770 x2_diff__cc1_0.x2_tail cmc VSS VSS sky130_fd_pr__nfet_01v8 ad=0.406 pd=3.38 as=0.406 ps=3.38 w=1.4 l=0.6
X771 x2_diff__cc1_0.x2_foldp x2_cl_casc__cc1_0.bias_c on VDD sky130_fd_pr__pfet_01v8 ad=0.406 pd=3.38 as=0.406 ps=3.38 w=1.4 l=0.6
X772 x2_diff__cc1_0.x2_tail bias_a VSS VSS sky130_fd_pr__nfet_01v8 ad=0.406 pd=3.38 as=0.406 ps=3.38 w=1.4 l=0.6
X773 VSS bias_a x2_cm_tail__cc6_0.x2_m3d VSS sky130_fd_pr__nfet_01v8 ad=0.406 pd=3.38 as=0.406 ps=3.38 w=1.4 l=0.6
X774 x2_cl_casc__cc1_0.bias_c x2_cl_casc__cc1_0.bias_c x2_cl_casc__cc1_0.bias_c VSS sky130_fd_pr__nfet_01v8_lvt ad=0.406 pd=3.38 as=0 ps=0 w=1.4 l=0.6
X775 VSS VSS x2_cm_tail__cc6_0.x2_m4d VSS sky130_fd_pr__nfet_01v8 ad=0.406 pd=3.38 as=0.406 ps=3.38 w=1.4 l=0.6
X776 x2_diff__cc1_0.x2_tail bias_a VSS VSS sky130_fd_pr__nfet_01v8 ad=0.406 pd=3.38 as=0.406 ps=3.38 w=1.4 l=0.6
X777 x2_cl_src__id4_0.bias_b x2_cl_src__id4_0.bias_b x2_cl_src__id4_0.bias_b VSS sky130_fd_pr__nfet_01v8_lvt ad=0.406 pd=3.38 as=0 ps=0 w=1.4 l=0.6
X778 VSS VSS x2_cm_tail__cc6_0.x2_m3d VSS sky130_fd_pr__nfet_01v8 ad=0.406 pd=3.38 as=0.406 ps=3.38 w=1.4 l=0.6
X779 x2_cm_tail__cc6_0.x2_m3d x2_cm_casc__cc6_0.bias_d on VSS sky130_fd_pr__nfet_01v8 ad=0.406 pd=3.38 as=0.406 ps=3.38 w=1.4 l=0.6
X780 x2_cm_tail__cc6_0.x2_m4d x2_cm_casc__cc6_0.bias_d op VSS sky130_fd_pr__nfet_01v8 ad=0.406 pd=3.38 as=0.406 ps=3.38 w=1.4 l=0.6
X781 VDD VDD VDD VDD sky130_fd_pr__pfet_01v8 ad=0.406 pd=3.38 as=0 ps=0 w=1.4 l=0.6
X782 IBIAS IBIAS VSS VSS sky130_fd_pr__nfet_01v8 ad=0.406 pd=3.38 as=0.406 ps=3.38 w=1.4 l=0.6
X783 x2_cl_src__id4_0.bias_b x2_cl_src__id4_0.bias_b x2_cl_casc__cc1_0.bias_c VSS sky130_fd_pr__nfet_01v8_lvt ad=0.406 pd=3.38 as=0.406 ps=3.38 w=1.4 l=0.6
X784 VSS VSS VSS VSS sky130_fd_pr__nfet_01v8 ad=0.406 pd=3.38 as=0 ps=0 w=1.4 l=0.6
X785 x2_cm_casc__cc6_0.bias_d x1_single_m3__f1_0.x1_m2d x1_single_m3__f1_0.x1_m2d VSS sky130_fd_pr__nfet_01v8 ad=0.406 pd=3.38 as=0.406 ps=3.38 w=1.4 l=0.6
X786 x1_single_m5__f3_0.x1_m5d x2_cm_casc__cc6_0.bias_d bias_a VSS sky130_fd_pr__nfet_01v8 ad=0.406 pd=3.38 as=0.406 ps=3.38 w=1.4 l=0.6
X787 VSS bias_a x2_diff__cc1_0.x2_tail VSS sky130_fd_pr__nfet_01v8 ad=0.406 pd=3.38 as=0.406 ps=3.38 w=1.4 l=0.6
X788 x2_cl_src__id4_0.bias_b x2_cl_src__id4_0.bias_b x2_cl_src__id4_0.bias_b VSS sky130_fd_pr__nfet_01v8_lvt ad=0.406 pd=3.38 as=0 ps=0 w=1.4 l=0.6
X789 x2_diff__cc1_0.x2_foldp x2_cl_src__id4_0.bias_b VDD VDD sky130_fd_pr__pfet_01v8_lvt ad=0.406 pd=3.38 as=0.406 ps=3.38 w=1.4 l=0.6
X790 x2_diff__cc1_0.x2_tail bias_a VSS VSS sky130_fd_pr__nfet_01v8 ad=0.406 pd=3.38 as=0.406 ps=3.38 w=1.4 l=0.6
X791 VSS cmc x2_diff__cc1_0.x2_tail VSS sky130_fd_pr__nfet_01v8 ad=0.406 pd=3.38 as=0.406 ps=3.38 w=1.4 l=0.6
X792 x2_cm_casc__cc6_0.bias_d x1_single_m3__f1_0.x1_m2d x1_single_m3__f1_0.x1_m2d VSS sky130_fd_pr__nfet_01v8 ad=0.406 pd=3.38 as=0.406 ps=3.38 w=1.4 l=0.6
X793 VSS VSS VSS VSS sky130_fd_pr__nfet_01v8 ad=0.406 pd=3.38 as=0 ps=0 w=1.4 l=0.6
X794 VSS bias_a x2_cm_tail__cc6_0.x2_m4d VSS sky130_fd_pr__nfet_01v8 ad=0.406 pd=3.38 as=0.406 ps=3.38 w=1.4 l=0.6
X795 VSS bias_a x2_diff__cc1_0.x2_tail VSS sky130_fd_pr__nfet_01v8 ad=0.406 pd=3.38 as=0.406 ps=3.38 w=1.4 l=0.6
X796 op x2_cl_casc__cc1_0.bias_c x2_diff__cc1_0.x2_foldn VDD sky130_fd_pr__pfet_01v8 ad=0.406 pd=3.38 as=0.406 ps=3.38 w=1.4 l=0.6
X797 VSS VSS VSS VSS sky130_fd_pr__nfet_01v8 ad=0.406 pd=3.38 as=0 ps=0 w=1.4 l=0.6
X798 VSS VSS VSS VSS sky130_fd_pr__nfet_01v8 ad=0.406 pd=3.38 as=0 ps=0 w=1.4 l=0.6
X799 on cmc sky130_fd_pr__cap_mim_m3_1 l=4.8 w=4.8
X800 VSS VSS VSS VSS sky130_fd_pr__nfet_01v8 ad=0.406 pd=3.38 as=0 ps=0 w=1.4 l=0.6
X801 x2_cl_src__id4_0.bias_b x2_cl_src__id4_0.bias_b x2_cl_casc__cc1_0.bias_c VSS sky130_fd_pr__nfet_01v8_lvt ad=0.406 pd=3.38 as=0.406 ps=3.38 w=1.4 l=0.6
X802 VSS VSS VSS VSS sky130_fd_pr__nfet_01v8 ad=0.406 pd=3.38 as=0 ps=0 w=1.4 l=0.6
X803 VSS bias_a x2_diff__cc1_0.x2_tail VSS sky130_fd_pr__nfet_01v8 ad=0.406 pd=3.38 as=0.406 ps=3.38 w=1.4 l=0.6
X804 bias_a x2_cm_casc__cc6_0.bias_d x1_single_m5__f3_0.x1_m5d VSS sky130_fd_pr__nfet_01v8 ad=0.406 pd=3.38 as=0.406 ps=3.38 w=1.4 l=0.6
X805 VSS VSS VSS VSS sky130_fd_pr__nfet_01v8 ad=0.406 pd=3.38 as=0 ps=0 w=1.4 l=0.6
X806 VSS VSS VSS VSS sky130_fd_pr__nfet_01v8 ad=0.406 pd=3.38 as=0 ps=0 w=1.4 l=0.6
X807 x2_diff__cc1_0.x2_tail bias_a VSS VSS sky130_fd_pr__nfet_01v8 ad=0.406 pd=3.38 as=0.406 ps=3.38 w=1.4 l=0.6
X808 x2_diff__cc1_0.x2_tail cmc VSS VSS sky130_fd_pr__nfet_01v8 ad=0.406 pd=3.38 as=0.406 ps=3.38 w=1.4 l=0.6
X809 x2_diff__cc1_0.x2_foldn x2_cl_src__id4_0.bias_b VDD VDD sky130_fd_pr__pfet_01v8_lvt ad=0.406 pd=3.38 as=0.406 ps=3.38 w=1.4 l=0.6
X810 x1_cc_cm__strings1_0.x1_net7 cm x1_cc_cm__strings1_0.x1_net8 VSS sky130_fd_pr__nfet_01v8 ad=0.406 pd=3.38 as=0.406 ps=3.38 w=1.4 l=0.6
X811 VSS cmc x2_diff__cc1_0.x2_tail VSS sky130_fd_pr__nfet_01v8 ad=0.406 pd=3.38 as=0.406 ps=3.38 w=1.4 l=0.6
X812 x2_diff__cc1_0.x2_tail bias_a VSS VSS sky130_fd_pr__nfet_01v8 ad=0.406 pd=3.38 as=0.406 ps=3.38 w=1.4 l=0.6
X813 VSS bias_a x2_diff__cc1_0.x2_tail VSS sky130_fd_pr__nfet_01v8 ad=0.406 pd=3.38 as=0.406 ps=3.38 w=1.4 l=0.6
X814 x2_cm_tail__cc6_0.x2_m4d bias_a VSS VSS sky130_fd_pr__nfet_01v8 ad=0.406 pd=3.38 as=0.406 ps=3.38 w=1.4 l=0.6
X815 x1_cm_bias_c__cc1_0.x1_m21d x2_cl_src__id4_0.bias_b VDD VDD sky130_fd_pr__pfet_01v8_lvt ad=0.406 pd=3.38 as=0.406 ps=3.38 w=1.4 l=0.6
X816 VDD VDD VDD VDD sky130_fd_pr__pfet_01v8_lvt ad=0.406 pd=3.38 as=0 ps=0 w=1.4 l=0.6
X817 VSS bias_a x2_diff__cc1_0.x2_tail VSS sky130_fd_pr__nfet_01v8 ad=0.406 pd=3.38 as=0.406 ps=3.38 w=1.4 l=0.6
X818 x2_cl_src__id4_0.bias_b x2_cl_src__id4_0.bias_b x2_cl_src__id4_0.bias_b VSS sky130_fd_pr__nfet_01v8_lvt ad=0.406 pd=3.38 as=0 ps=0 w=1.4 l=0.6
X819 x2_cl_casc__cc1_0.bias_c x2_cl_src__id4_0.bias_b x2_cl_src__id4_0.bias_b VSS sky130_fd_pr__nfet_01v8_lvt ad=0.406 pd=3.38 as=0.406 ps=3.38 w=1.4 l=0.6
X820 x2_diff__cc1_0.x2_tail cmc VSS VSS sky130_fd_pr__nfet_01v8 ad=0.406 pd=3.38 as=0.406 ps=3.38 w=1.4 l=0.6
X821 VSS VSS x2_cm_tail__cc6_0.x2_m4d VSS sky130_fd_pr__nfet_01v8 ad=0.406 pd=3.38 as=0.406 ps=3.38 w=1.4 l=0.6
X822 op x2_cm_casc__cc6_0.bias_d x2_cm_tail__cc6_0.x2_m4d VSS sky130_fd_pr__nfet_01v8 ad=0.406 pd=3.38 as=0.406 ps=3.38 w=1.4 l=0.6
X823 x2_diff__cc1_0.x2_foldn x2_cl_casc__cc1_0.bias_c op VDD sky130_fd_pr__pfet_01v8 ad=0.406 pd=3.38 as=0.406 ps=3.38 w=1.4 l=0.6
X824 VDD x2_cl_src__id4_0.bias_b x2_diff__cc1_0.x2_foldp VDD sky130_fd_pr__pfet_01v8_lvt ad=0.406 pd=3.38 as=0.406 ps=3.38 w=1.4 l=0.6
X825 x2_cm_casc__cc6_0.bias_d x2_cm_casc__cc6_0.bias_d x2_cm_casc__cc6_0.bias_d VSS sky130_fd_pr__nfet_01v8 ad=0.406 pd=3.38 as=0 ps=0 w=1.4 l=0.6
X826 VSS bias_a x2_cm_tail__cc6_0.x2_m3d VSS sky130_fd_pr__nfet_01v8 ad=0.406 pd=3.38 as=0.406 ps=3.38 w=1.4 l=0.6
X827 VSS IBIAS x2_cl_casc__cc1_0.bias_c VSS sky130_fd_pr__nfet_01v8 ad=0.406 pd=3.38 as=0.406 ps=3.38 w=1.4 l=0.6
X828 IBIAS IBIAS VSS VSS sky130_fd_pr__nfet_01v8 ad=0.406 pd=3.38 as=0.406 ps=3.38 w=1.4 l=0.6
X829 VSS bias_a x2_cm_tail__cc6_0.x2_m3d VSS sky130_fd_pr__nfet_01v8 ad=0.406 pd=3.38 as=0.406 ps=3.38 w=1.4 l=0.6
X830 VSS bias_a x2_diff__cc1_0.x2_tail VSS sky130_fd_pr__nfet_01v8 ad=0.406 pd=3.38 as=0.406 ps=3.38 w=1.4 l=0.6
X831 x2_cl_src__id4_0.bias_b x2_cl_src__id4_0.bias_b x2_cl_casc__cc1_0.bias_c VSS sky130_fd_pr__nfet_01v8_lvt ad=0.406 pd=3.38 as=0.406 ps=3.38 w=1.4 l=0.6
X832 x2_diff__cc1_0.x2_tail cmc VSS VSS sky130_fd_pr__nfet_01v8 ad=0.406 pd=3.38 as=0.406 ps=3.38 w=1.4 l=0.6
X833 x2_diff__cc1_0.x2_foldp x2_cl_casc__cc1_0.bias_c on VDD sky130_fd_pr__pfet_01v8 ad=0.406 pd=3.38 as=0.406 ps=3.38 w=1.4 l=0.6
X834 x2_cl_src__id4_0.bias_b x2_cl_src__id4_0.bias_b x2_cl_casc__cc1_0.bias_c VSS sky130_fd_pr__nfet_01v8_lvt ad=0.406 pd=3.38 as=0.406 ps=3.38 w=1.4 l=0.6
X835 op x2_cm_casc__cc6_0.bias_d x2_cm_tail__cc6_0.x2_m4d VSS sky130_fd_pr__nfet_01v8 ad=0.406 pd=3.38 as=0.406 ps=3.38 w=1.4 l=0.6
X836 on x2_cm_casc__cc6_0.bias_d x2_cm_tail__cc6_0.x2_m3d VSS sky130_fd_pr__nfet_01v8 ad=0.406 pd=3.38 as=0.406 ps=3.38 w=1.4 l=0.6
X837 x2_diff__cc1_0.x2_tail x2_diff__cc1_0.x2_tail x2_diff__cc1_0.x2_tail VSS sky130_fd_pr__nfet_01v8 ad=0.406 pd=3.38 as=0 ps=0 w=1.4 l=0.6
X838 x2_diff__cc1_0.x2_tail cmc VSS VSS sky130_fd_pr__nfet_01v8 ad=0.406 pd=3.38 as=0.406 ps=3.38 w=1.4 l=0.6
X839 x1_single_m3__f1_0.x1_m2d x1_single_m3__f1_0.x1_m2d x2_cm_casc__cc6_0.bias_d VSS sky130_fd_pr__nfet_01v8 ad=0.406 pd=3.38 as=0.406 ps=3.38 w=1.4 l=0.6
X840 x2_cm_tail__cc6_0.x2_m4d x2_cm_casc__cc6_0.bias_d op VSS sky130_fd_pr__nfet_01v8 ad=0.406 pd=3.38 as=0.406 ps=3.38 w=1.4 l=0.6
X841 x2_diff__cc1_0.x2_tail cmc VSS VSS sky130_fd_pr__nfet_01v8 ad=0.406 pd=3.38 as=0.406 ps=3.38 w=1.4 l=0.6
X842 VSS cmc x2_diff__cc1_0.x2_tail VSS sky130_fd_pr__nfet_01v8 ad=0.406 pd=3.38 as=0.406 ps=3.38 w=1.4 l=0.6
X843 VSS IBIAS x2_cl_casc__cc1_0.bias_c VSS sky130_fd_pr__nfet_01v8 ad=0.406 pd=3.38 as=0.406 ps=3.38 w=1.4 l=0.6
X844 x1_cm_bias_c__cc1_0.x1_m21d x1_cm_bias_c__cc1_0.x1_m21d x1_cm_bias_c__cc1_0.x1_m21d VDD sky130_fd_pr__pfet_01v8 ad=0.406 pd=3.38 as=0 ps=0 w=1.4 l=0.6
X845 x2_diff__cc1_0.x2_foldp x2_cl_casc__cc1_0.bias_c on VDD sky130_fd_pr__pfet_01v8 ad=0.406 pd=3.38 as=0.406 ps=3.38 w=1.4 l=0.6
X846 x2_cm_tail__cc6_0.x2_m3d bias_a VSS VSS sky130_fd_pr__nfet_01v8 ad=0.406 pd=3.38 as=0.406 ps=3.38 w=1.4 l=0.6
X847 x2_cm_tail__cc6_0.x2_m3d bias_a VSS VSS sky130_fd_pr__nfet_01v8 ad=0.406 pd=3.38 as=0.406 ps=3.38 w=1.4 l=0.6
X848 x2_cm_tail__cc6_0.x2_m3d x2_cm_casc__cc6_0.bias_d on VSS sky130_fd_pr__nfet_01v8 ad=0.406 pd=3.38 as=0.406 ps=3.38 w=1.4 l=0.6
X849 x2_diff__cc1_0.x2_foldn x2_cl_src__id4_0.bias_b VDD VDD sky130_fd_pr__pfet_01v8_lvt ad=0.406 pd=3.38 as=0.406 ps=3.38 w=1.4 l=0.6
X850 VDD VDD VDD VDD sky130_fd_pr__pfet_01v8_lvt ad=0.406 pd=3.38 as=0 ps=0 w=1.4 l=0.6
X851 x2_cl_casc__cc1_0.bias_c x2_cl_src__id4_0.bias_b x2_cl_src__id4_0.bias_b VSS sky130_fd_pr__nfet_01v8_lvt ad=0.406 pd=3.38 as=0.406 ps=3.38 w=1.4 l=0.6
X852 x2_cl_src__id4_0.bias_b x2_cl_src__id4_0.bias_b x2_cl_casc__cc1_0.bias_c VSS sky130_fd_pr__nfet_01v8_lvt ad=0.406 pd=3.38 as=0.406 ps=3.38 w=1.4 l=0.6
X853 VSS bias_a x2_diff__cc1_0.x2_tail VSS sky130_fd_pr__nfet_01v8 ad=0.406 pd=3.38 as=0.406 ps=3.38 w=1.4 l=0.6
X854 on x2_cm_casc__cc6_0.bias_d x2_cm_tail__cc6_0.x2_m3d VSS sky130_fd_pr__nfet_01v8 ad=0.406 pd=3.38 as=0.406 ps=3.38 w=1.4 l=0.6
X855 VDD VDD VDD VDD sky130_fd_pr__pfet_01v8 ad=0.406 pd=3.38 as=0 ps=0 w=1.4 l=0.6
X856 x2_cm_casc__cc6_0.bias_d x1_single_m3__f1_0.x1_m2d x1_single_m3__f1_0.x1_m2d VSS sky130_fd_pr__nfet_01v8 ad=0.406 pd=3.38 as=0.406 ps=3.38 w=1.4 l=0.6
X857 x2_diff__cc1_0.x2_tail cmc VSS VSS sky130_fd_pr__nfet_01v8 ad=0.406 pd=3.38 as=0.406 ps=3.38 w=1.4 l=0.6
X858 x2_diff__cc1_0.x2_foldn in x2_diff__cc1_0.x2_tail VSS sky130_fd_pr__nfet_01v8_lvt ad=0.348 pd=2.98 as=0.348 ps=2.98 w=1.2 l=0.2
X859 x2_cm_casc__cc6_0.bias_d x1_single_m3__f1_0.x1_m2d x1_single_m3__f1_0.x1_m2d VSS sky130_fd_pr__nfet_01v8 ad=0.406 pd=3.38 as=0.406 ps=3.38 w=1.4 l=0.6
X860 x1_single_m5__f3_0.x1_m5d x2_cm_casc__cc6_0.bias_d bias_a VSS sky130_fd_pr__nfet_01v8 ad=0.406 pd=3.38 as=0.406 ps=3.38 w=1.4 l=0.6
X861 VSS cmc x2_diff__cc1_0.x2_tail VSS sky130_fd_pr__nfet_01v8 ad=0.406 pd=3.38 as=0.406 ps=3.38 w=1.4 l=0.6
X862 x2_cm_tail__cc6_0.x2_m4d bias_a VSS VSS sky130_fd_pr__nfet_01v8 ad=0.406 pd=3.38 as=0.406 ps=3.38 w=1.4 l=0.6
.ends

.end
