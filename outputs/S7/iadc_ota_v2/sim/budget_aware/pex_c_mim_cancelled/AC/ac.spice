* iadc_ota on dido_amp_AC
.lib $PDK_ROOT/sky130A/libs.tech/combined/sky130.lib.spice tt
.option rshunt=1e12
.param VDD_V=1.8 VCM_V=0.9 CL_F=0.3p
.temp 27

**.subckt dido_amp_AC
x1 INP INN OUTN VDD 0 OUTP dut_amp
Vsup VDD 0 'VDD_V'
* AC drive through 1 F couplers; DC set by unity feedback through 1 GH chokes (OUTP->INN, OUTN->INP)
Vacp ACP 0 dc 0 ac 0.5
Vacn ACN 0 dc 0 ac -0.5
Cinp ACP INP 1
Cinn ACN INN 1
Lfbp OUTP INN 1G
Lfbn OUTN INP 1G
Cloadp OUTP 0 'CL_F'
Cloadn OUTN 0 'CL_F'
.control
  save all
  ac dec 40 1 1G
  let hsig = v(OUTP) - v(OUTN)
  let hdb = db(hsig)
  let gph_deg = 180/pi * cph(hsig)
  meas ac gain_db find hdb at=1
  meas ac gbw_hz  when hdb=0
  meas ac ph_dc   find gph_deg at=1
  meas ac ph_ugb  find gph_deg when hdb=0
  let gbw_mhz = gbw_hz / 1e6
  let pm_deg  = 180 + (ph_ugb - ph_dc)
  echo MEAS gain_db $&gain_db
  echo MEAS gbw_mhz $&gbw_mhz
  echo MEAS pm_deg $&pm_deg
  write
  quit 0
.endc
**.ends

.subckt dut_amp INP INN OUTN VDD VSS OUTP
XDUT OUTN OUTP bias_a_w cm_w N_IBIAS VDD VSS cmc_w INN INP N_x2_m4d N_x2_m3d N_bias_d N_x1_m2d N_x1_net1 N_x1_net2 N_x1_net3 N_x1_net13 N_x1_net14 N_x1_net15 N_x1_net4 N_x1_net5 N_x1_net6 N_x1_net7 N_x1_net8 N_x1_net9 N_x1_net10 N_x1_net11 N_x1_net12 N_x1_m5d N_bias_b N_bias_c N_x2_foldp N_x2_foldn N_x2_tail N_x1_m21d N_x1_m25d N_x1_m31d iadc_ota_v2_routed_flat
* ideal CMFB: the steady-state law of the upstream switched-capacitor CMFB (ASSUMPTION)
Bcmfb cmc_w VSS V = v(bias_a_w) + (v(OUTP) + v(OUTN))/2 - v(cm_w)
IIbias_ext_layout VDD N_IBIAS 3e-05
.ends
.subckt iadc_ota ip in op on VDD VSS cmc cm bias_a
XX1_M22 bias_b bias_c x1_m21d VDD sky130_fd_pr__pfet_01v8 L=0.6 W=1.4 NF=1 AD=0.406 AS=0.406 PD=3.38 PS=3.38 NRD=0.207143 NRS=0.207143 SA=0 SB=0 SD=0 MULT=6 M=6
XX1_M26 x1_m2d bias_c x1_m25d VDD sky130_fd_pr__pfet_01v8 L=0.6 W=1.4 NF=1 AD=0.406 AS=0.406 PD=3.38 PS=3.38 NRD=0.207143 NRS=0.207143 SA=0 SB=0 SD=0 MULT=6 M=6
XX1_M32 cm bias_c x1_m31d VDD sky130_fd_pr__pfet_01v8 L=0.6 W=1.4 NF=1 AD=0.406 AS=0.406 PD=3.38 PS=3.38 NRD=0.207143 NRS=0.207143 SA=0 SB=0 SD=0 MULT=6 M=6
XX1_M21 x1_m21d bias_b VDD VDD sky130_fd_pr__pfet_01v8_lvt L=0.6 W=1.4 NF=1 AD=0.406 AS=0.406 PD=3.38 PS=3.38 NRD=0.207143 NRS=0.207143 SA=0 SB=0 SD=0 MULT=6 M=6
XX1_M25 x1_m25d bias_b VDD VDD sky130_fd_pr__pfet_01v8_lvt L=0.6 W=1.4 NF=1 AD=0.406 AS=0.406 PD=3.38 PS=3.38 NRD=0.207143 NRS=0.207143 SA=0 SB=0 SD=0 MULT=6 M=6
XX1_M31 x1_m31d bias_b VDD VDD sky130_fd_pr__pfet_01v8_lvt L=0.6 W=1.4 NF=1 AD=0.406 AS=0.406 PD=3.38 PS=3.38 NRD=0.207143 NRS=0.207143 SA=0 SB=0 SD=0 MULT=6 M=6
XX1_M1 bias_b bias_b bias_c VSS sky130_fd_pr__nfet_01v8_lvt L=0.6 W=1.4 NF=1 AD=0.406 AS=0.406 PD=3.38 PS=3.38 NRD=0.207143 NRS=0.207143 SA=0 SB=0 SD=0 MULT=56 M=56
XX1_M2 x1_m2d x1_m2d bias_d VSS sky130_fd_pr__nfet_01v8 L=0.6 W=1.4 NF=1 AD=0.406 AS=0.406 PD=3.38 PS=3.38 NRD=0.207143 NRS=0.207143 SA=0 SB=0 SD=0 MULT=50 M=50
XX1_M3 bias_d x1_m2d bias_a VSS sky130_fd_pr__nfet_01v8 L=0.6 W=1.4 NF=1 AD=0.406 AS=0.406 PD=3.38 PS=3.38 NRD=0.207143 NRS=0.207143 SA=0 SB=0 SD=0 MULT=2 M=2
XX1_M4 bias_a bias_d x1_m5d VSS sky130_fd_pr__nfet_01v8 L=0.6 W=1.4 NF=1 AD=0.406 AS=0.406 PD=3.38 PS=3.38 NRD=0.207143 NRS=0.207143 SA=0 SB=0 SD=0 MULT=18 M=18
XX1_M5 x1_m5d bias_a VSS VSS sky130_fd_pr__nfet_01v8 L=0.6 W=1.4 NF=1 AD=0.406 AS=0.406 PD=3.38 PS=3.38 NRD=0.207143 NRS=0.207143 SA=0 SB=0 SD=0 MULT=18 M=18
XX1_M6 bias_c i_bias VSS VSS sky130_fd_pr__nfet_01v8 L=0.6 W=1.4 NF=1 AD=0.406 AS=0.406 PD=3.38 PS=3.38 NRD=0.207143 NRS=0.207143 SA=0 SB=0 SD=0 MULT=18 M=18
XX1_M7 i_bias i_bias VSS VSS sky130_fd_pr__nfet_01v8 L=0.6 W=1.4 NF=1 AD=0.406 AS=0.406 PD=3.38 PS=3.38 NRD=0.207143 NRS=0.207143 SA=0 SB=0 SD=0 MULT=18 M=18
XX1_M33 cm cm x1_net1 VSS sky130_fd_pr__nfet_01v8 L=0.6 W=1.4 NF=1 AD=0.406 AS=0.406 PD=3.38 PS=3.38 NRD=0.207143 NRS=0.207143 SA=0 SB=0 SD=0 MULT=1 M=1
XX1_M49 x1_net1 cm x1_net2 VSS sky130_fd_pr__nfet_01v8 L=0.6 W=1.4 NF=1 AD=0.406 AS=0.406 PD=3.38 PS=3.38 NRD=0.207143 NRS=0.207143 SA=0 SB=0 SD=0 MULT=1 M=1
XX1_M50 x1_net2 cm x1_net3 VSS sky130_fd_pr__nfet_01v8 L=0.6 W=1.4 NF=1 AD=0.406 AS=0.406 PD=3.38 PS=3.38 NRD=0.207143 NRS=0.207143 SA=0 SB=0 SD=0 MULT=1 M=1
XX1_M63 x1_net3 cm VSS VSS sky130_fd_pr__nfet_01v8 L=0.6 W=1.4 NF=1 AD=0.406 AS=0.406 PD=3.38 PS=3.38 NRD=0.207143 NRS=0.207143 SA=0 SB=0 SD=0 MULT=1 M=1
XX1_M68 cm cm x1_net4 VSS sky130_fd_pr__nfet_01v8 L=0.6 W=1.4 NF=1 AD=0.406 AS=0.406 PD=3.38 PS=3.38 NRD=0.207143 NRS=0.207143 SA=0 SB=0 SD=0 MULT=1 M=1
XX1_M69 x1_net4 cm x1_net5 VSS sky130_fd_pr__nfet_01v8 L=0.6 W=1.4 NF=1 AD=0.406 AS=0.406 PD=3.38 PS=3.38 NRD=0.207143 NRS=0.207143 SA=0 SB=0 SD=0 MULT=1 M=1
XX1_M70 x1_net5 cm x1_net6 VSS sky130_fd_pr__nfet_01v8 L=0.6 W=1.4 NF=1 AD=0.406 AS=0.406 PD=3.38 PS=3.38 NRD=0.207143 NRS=0.207143 SA=0 SB=0 SD=0 MULT=1 M=1
XX1_M71 x1_net6 cm VSS VSS sky130_fd_pr__nfet_01v8 L=0.6 W=1.4 NF=1 AD=0.406 AS=0.406 PD=3.38 PS=3.38 NRD=0.207143 NRS=0.207143 SA=0 SB=0 SD=0 MULT=1 M=1
XX1_M72 cm cm x1_net7 VSS sky130_fd_pr__nfet_01v8 L=0.6 W=1.4 NF=1 AD=0.406 AS=0.406 PD=3.38 PS=3.38 NRD=0.207143 NRS=0.207143 SA=0 SB=0 SD=0 MULT=1 M=1
XX1_M73 x1_net7 cm x1_net8 VSS sky130_fd_pr__nfet_01v8 L=0.6 W=1.4 NF=1 AD=0.406 AS=0.406 PD=3.38 PS=3.38 NRD=0.207143 NRS=0.207143 SA=0 SB=0 SD=0 MULT=1 M=1
XX1_M74 x1_net8 cm x1_net9 VSS sky130_fd_pr__nfet_01v8 L=0.6 W=1.4 NF=1 AD=0.406 AS=0.406 PD=3.38 PS=3.38 NRD=0.207143 NRS=0.207143 SA=0 SB=0 SD=0 MULT=1 M=1
XX1_M75 x1_net9 cm VSS VSS sky130_fd_pr__nfet_01v8 L=0.6 W=1.4 NF=1 AD=0.406 AS=0.406 PD=3.38 PS=3.38 NRD=0.207143 NRS=0.207143 SA=0 SB=0 SD=0 MULT=1 M=1
XX1_M76 cm cm x1_net10 VSS sky130_fd_pr__nfet_01v8 L=0.6 W=1.4 NF=1 AD=0.406 AS=0.406 PD=3.38 PS=3.38 NRD=0.207143 NRS=0.207143 SA=0 SB=0 SD=0 MULT=1 M=1
XX1_M77 x1_net10 cm x1_net11 VSS sky130_fd_pr__nfet_01v8 L=0.6 W=1.4 NF=1 AD=0.406 AS=0.406 PD=3.38 PS=3.38 NRD=0.207143 NRS=0.207143 SA=0 SB=0 SD=0 MULT=1 M=1
XX1_M78 x1_net11 cm x1_net12 VSS sky130_fd_pr__nfet_01v8 L=0.6 W=1.4 NF=1 AD=0.406 AS=0.406 PD=3.38 PS=3.38 NRD=0.207143 NRS=0.207143 SA=0 SB=0 SD=0 MULT=1 M=1
XX1_M79 x1_net12 cm VSS VSS sky130_fd_pr__nfet_01v8 L=0.6 W=1.4 NF=1 AD=0.406 AS=0.406 PD=3.38 PS=3.38 NRD=0.207143 NRS=0.207143 SA=0 SB=0 SD=0 MULT=1 M=1
XX1_M64 cm cm x1_net13 VSS sky130_fd_pr__nfet_01v8 L=0.6 W=1.4 NF=1 AD=0.406 AS=0.406 PD=3.38 PS=3.38 NRD=0.207143 NRS=0.207143 SA=0 SB=0 SD=0 MULT=1 M=1
XX1_M65 x1_net13 cm x1_net14 VSS sky130_fd_pr__nfet_01v8 L=0.6 W=1.4 NF=1 AD=0.406 AS=0.406 PD=3.38 PS=3.38 NRD=0.207143 NRS=0.207143 SA=0 SB=0 SD=0 MULT=1 M=1
XX1_M66 x1_net14 cm x1_net15 VSS sky130_fd_pr__nfet_01v8 L=0.6 W=1.4 NF=1 AD=0.406 AS=0.406 PD=3.38 PS=3.38 NRD=0.207143 NRS=0.207143 SA=0 SB=0 SD=0 MULT=1 M=1
XX1_M67 x1_net15 cm VSS VSS sky130_fd_pr__nfet_01v8 L=0.6 W=1.4 NF=1 AD=0.406 AS=0.406 PD=3.38 PS=3.38 NRD=0.207143 NRS=0.207143 SA=0 SB=0 SD=0 MULT=1 M=1
XX1_M57 bias_b VDD VDD VDD sky130_fd_pr__pfet_01v8 L=0.6 W=1.4 NF=1 AD=0.406 AS=0.406 PD=3.38 PS=3.38 NRD=0.207143 NRS=0.207143 SA=0 SB=0 SD=0 MULT=2 M=2
XX1_M58 x1_m2d VDD VDD VDD sky130_fd_pr__pfet_01v8 L=0.6 W=1.4 NF=1 AD=0.406 AS=0.406 PD=3.38 PS=3.38 NRD=0.207143 NRS=0.207143 SA=0 SB=0 SD=0 MULT=2 M=2
XX1_M59 cm VDD VDD VDD sky130_fd_pr__pfet_01v8 L=0.6 W=1.4 NF=1 AD=0.406 AS=0.406 PD=3.38 PS=3.38 NRD=0.207143 NRS=0.207143 SA=0 SB=0 SD=0 MULT=2 M=2
XX1_M60 x1_m31d VDD VDD VDD sky130_fd_pr__pfet_01v8 L=0.6 W=1.4 NF=1 AD=0.406 AS=0.406 PD=3.38 PS=3.38 NRD=0.207143 NRS=0.207143 SA=0 SB=0 SD=0 MULT=2 M=2
XX1_M42 x1_m5d VSS VSS VSS sky130_fd_pr__nfet_01v8 L=0.6 W=1.4 NF=1 AD=0.406 AS=0.406 PD=3.38 PS=3.38 NRD=0.207143 NRS=0.207143 SA=0 SB=0 SD=0 MULT=6 M=6
XX1_M44 bias_c bias_c bias_c VSS sky130_fd_pr__nfet_01v8 L=0.6 W=1.4 NF=1 AD=0.406 AS=0.406 PD=3.38 PS=3.38 NRD=0.207143 NRS=0.207143 SA=0 SB=0 SD=0 MULT=2 M=2
XX1_M34 bias_d bias_d bias_d VSS sky130_fd_pr__nfet_01v8 L=0.6 W=1.4 NF=1 AD=0.406 AS=0.406 PD=3.38 PS=3.38 NRD=0.207143 NRS=0.207143 SA=0 SB=0 SD=0 MULT=8 M=8
XX1_M35 x1_m2d x1_m2d x1_m2d VSS sky130_fd_pr__nfet_01v8 L=0.6 W=1.4 NF=1 AD=0.406 AS=0.406 PD=3.38 PS=3.38 NRD=0.207143 NRS=0.207143 SA=0 SB=0 SD=0 MULT=2 M=2
XX1_M36 bias_a bias_a bias_a VSS sky130_fd_pr__nfet_01v8 L=0.6 W=1.4 NF=1 AD=0.406 AS=0.406 PD=3.38 PS=3.38 NRD=0.207143 NRS=0.207143 SA=0 SB=0 SD=0 MULT=4 M=4
XX1_M37 cm cm cm VSS sky130_fd_pr__nfet_01v8 L=0.6 W=1.4 NF=1 AD=0.406 AS=0.406 PD=3.38 PS=3.38 NRD=0.207143 NRS=0.207143 SA=0 SB=0 SD=0 MULT=8 M=8
XX1_M54 x1_m25d x1_m25d x1_m25d VDD sky130_fd_pr__pfet_01v8 L=0.6 W=1.4 NF=1 AD=0.406 AS=0.406 PD=3.38 PS=3.38 NRD=0.207143 NRS=0.207143 SA=0 SB=0 SD=0 MULT=2 M=2
XX1_M29 x1_m5d x1_m5d x1_m5d VSS sky130_fd_pr__nfet_01v8 L=0.6 W=1.4 NF=1 AD=0.406 AS=0.406 PD=3.38 PS=3.38 NRD=0.207143 NRS=0.207143 SA=0 SB=0 SD=0 MULT=6 M=6
XX1_M8 i_bias i_bias i_bias VSS sky130_fd_pr__nfet_01v8 L=0.6 W=1.4 NF=1 AD=0.406 AS=0.406 PD=3.38 PS=3.38 NRD=0.207143 NRS=0.207143 SA=0 SB=0 SD=0 MULT=2 M=2
XX1_M10 bias_c bias_c bias_c VSS sky130_fd_pr__nfet_01v8_lvt L=0.6 W=1.4 NF=1 AD=0.406 AS=0.406 PD=3.38 PS=3.38 NRD=0.207143 NRS=0.207143 SA=0 SB=0 SD=0 MULT=8 M=8
XX1_M27 bias_b bias_b bias_b VSS sky130_fd_pr__nfet_01v8_lvt L=0.6 W=1.4 NF=1 AD=0.406 AS=0.406 PD=3.38 PS=3.38 NRD=0.207143 NRS=0.207143 SA=0 SB=0 SD=0 MULT=8 M=8
XX1_M46 x1_m21d x1_m21d x1_m21d VDD sky130_fd_pr__pfet_01v8_lvt L=0.6 W=1.4 NF=1 AD=0.406 AS=0.406 PD=3.38 PS=3.38 NRD=0.207143 NRS=0.207143 SA=0 SB=0 SD=0 MULT=2 M=2
XX1_M47 x1_m25d x1_m25d x1_m25d VDD sky130_fd_pr__pfet_01v8_lvt L=0.6 W=1.4 NF=1 AD=0.406 AS=0.406 PD=3.38 PS=3.38 NRD=0.207143 NRS=0.207143 SA=0 SB=0 SD=0 MULT=2 M=2
XX1_M48 x1_m31d x1_m31d x1_m31d VDD sky130_fd_pr__pfet_01v8_lvt L=0.6 W=1.4 NF=1 AD=0.406 AS=0.406 PD=3.38 PS=3.38 NRD=0.207143 NRS=0.207143 SA=0 SB=0 SD=0 MULT=2 M=2
XX1_M51 x1_m21d x1_m21d x1_m21d VDD sky130_fd_pr__pfet_01v8 L=0.6 W=1.4 NF=1 AD=0.406 AS=0.406 PD=3.38 PS=3.38 NRD=0.207143 NRS=0.207143 SA=0 SB=0 SD=0 MULT=2 M=2
XX2_M1 x2_foldp ip x2_tail VSS sky130_fd_pr__nfet_01v8_lvt L=0.2 W=1.2 NF=1 AD=0.348 AS=0.348 PD=2.98 PS=2.98 NRD=0.241667 NRS=0.241667 SA=0 SB=0 SD=0 MULT=6 M=6
XX2_M2 x2_foldn in x2_tail VSS sky130_fd_pr__nfet_01v8_lvt L=0.2 W=1.2 NF=1 AD=0.348 AS=0.348 PD=2.98 PS=2.98 NRD=0.241667 NRS=0.241667 SA=0 SB=0 SD=0 MULT=6 M=6
XX2_M6 x2_tail cmc VSS VSS sky130_fd_pr__nfet_01v8 L=0.6 W=1.4 NF=1 AD=0.406 AS=0.406 PD=3.38 PS=3.38 NRD=0.207143 NRS=0.207143 SA=0 SB=0 SD=0 MULT=96 M=96
XX2_M5 x2_tail bias_a VSS VSS sky130_fd_pr__nfet_01v8 L=0.6 W=1.4 NF=1 AD=0.406 AS=0.406 PD=3.38 PS=3.38 NRD=0.207143 NRS=0.207143 SA=0 SB=0 SD=0 MULT=96 M=96
XX2_M11 x2_foldp bias_b VDD VDD sky130_fd_pr__pfet_01v8_lvt L=0.6 W=1.4 NF=1 AD=0.406 AS=0.406 PD=3.38 PS=3.38 NRD=0.207143 NRS=0.207143 SA=0 SB=0 SD=0 MULT=24 M=24
XX2_M12 x2_foldn bias_b VDD VDD sky130_fd_pr__pfet_01v8_lvt L=0.6 W=1.4 NF=1 AD=0.406 AS=0.406 PD=3.38 PS=3.38 NRD=0.207143 NRS=0.207143 SA=0 SB=0 SD=0 MULT=24 M=24
XX2_M1A on bias_c x2_foldp VDD sky130_fd_pr__pfet_01v8 L=0.6 W=1.4 NF=1 AD=0.406 AS=0.406 PD=3.38 PS=3.38 NRD=0.207143 NRS=0.207143 SA=0 SB=0 SD=0 MULT=20 M=20
XX2_M8 op bias_c x2_foldn VDD sky130_fd_pr__pfet_01v8 L=0.6 W=1.4 NF=1 AD=0.406 AS=0.406 PD=3.38 PS=3.38 NRD=0.207143 NRS=0.207143 SA=0 SB=0 SD=0 MULT=20 M=20
XX2_M3A on bias_d x2_m3d VSS sky130_fd_pr__nfet_01v8 L=0.6 W=1.4 NF=1 AD=0.406 AS=0.406 PD=3.38 PS=3.38 NRD=0.207143 NRS=0.207143 SA=0 SB=0 SD=0 MULT=36 M=36
XX2_M7 op bias_d x2_m4d VSS sky130_fd_pr__nfet_01v8 L=0.6 W=1.4 NF=1 AD=0.406 AS=0.406 PD=3.38 PS=3.38 NRD=0.207143 NRS=0.207143 SA=0 SB=0 SD=0 MULT=36 M=36
XX2_M3 x2_m3d bias_a VSS VSS sky130_fd_pr__nfet_01v8 L=0.6 W=1.4 NF=1 AD=0.406 AS=0.406 PD=3.38 PS=3.38 NRD=0.207143 NRS=0.207143 SA=0 SB=0 SD=0 MULT=36 M=36
XX2_M4 x2_m4d bias_a VSS VSS sky130_fd_pr__nfet_01v8 L=0.6 W=1.4 NF=1 AD=0.406 AS=0.406 PD=3.38 PS=3.38 NRD=0.207143 NRS=0.207143 SA=0 SB=0 SD=0 MULT=36 M=36
XX2_M82 x2_foldn x2_foldn x2_foldn VDD sky130_fd_pr__pfet_01v8 L=0.6 W=1.4 NF=1 AD=0.406 AS=0.406 PD=3.38 PS=3.38 NRD=0.207143 NRS=0.207143 SA=0 SB=0 SD=0 MULT=2 M=2
XX2_M83 x2_foldp x2_foldp x2_foldp VDD sky130_fd_pr__pfet_01v8 L=0.6 W=1.4 NF=1 AD=0.406 AS=0.406 PD=3.38 PS=3.38 NRD=0.207143 NRS=0.207143 SA=0 SB=0 SD=0 MULT=2 M=2
XX2_M55 x2_foldn VDD VDD VDD sky130_fd_pr__pfet_01v8 L=0.6 W=1.4 NF=1 AD=0.406 AS=0.406 PD=3.38 PS=3.38 NRD=0.207143 NRS=0.207143 SA=0 SB=0 SD=0 MULT=2 M=2
XX2_M56 op VDD VDD VDD sky130_fd_pr__pfet_01v8 L=0.6 W=1.4 NF=1 AD=0.406 AS=0.406 PD=3.38 PS=3.38 NRD=0.207143 NRS=0.207143 SA=0 SB=0 SD=0 MULT=4 M=4
XX2_M61 x2_foldp VDD VDD VDD sky130_fd_pr__pfet_01v8 L=0.6 W=1.4 NF=1 AD=0.406 AS=0.406 PD=3.38 PS=3.38 NRD=0.207143 NRS=0.207143 SA=0 SB=0 SD=0 MULT=2 M=2
XX2_M62 on VDD VDD VDD sky130_fd_pr__pfet_01v8 L=0.6 W=1.4 NF=1 AD=0.406 AS=0.406 PD=3.38 PS=3.38 NRD=0.207143 NRS=0.207143 SA=0 SB=0 SD=0 MULT=4 M=4
XX2_M40 x2_m4d VSS VSS VSS sky130_fd_pr__nfet_01v8 L=0.6 W=1.4 NF=1 AD=0.406 AS=0.406 PD=3.38 PS=3.38 NRD=0.207143 NRS=0.207143 SA=0 SB=0 SD=0 MULT=6 M=6
XX2_M41 x2_m3d VSS VSS VSS sky130_fd_pr__nfet_01v8 L=0.6 W=1.4 NF=1 AD=0.406 AS=0.406 PD=3.38 PS=3.38 NRD=0.207143 NRS=0.207143 SA=0 SB=0 SD=0 MULT=8 M=8
XX2_M38 op op op VSS sky130_fd_pr__nfet_01v8 L=0.6 W=1.4 NF=1 AD=0.406 AS=0.406 PD=3.38 PS=3.38 NRD=0.207143 NRS=0.207143 SA=0 SB=0 SD=0 MULT=2 M=2
XX2_M39 on on on VSS sky130_fd_pr__nfet_01v8 L=0.6 W=1.4 NF=1 AD=0.406 AS=0.406 PD=3.38 PS=3.38 NRD=0.207143 NRS=0.207143 SA=0 SB=0 SD=0 MULT=2 M=2
XX2_M30 x2_tail VSS VSS VSS sky130_fd_pr__nfet_01v8 L=0.6 W=1.4 NF=1 AD=0.406 AS=0.406 PD=3.38 PS=3.38 NRD=0.207143 NRS=0.207143 SA=0 SB=0 SD=0 MULT=2 M=2
XX2_M23 x2_foldp x2_foldp x2_foldp VSS sky130_fd_pr__nfet_01v8_lvt L=0.2 W=1.2 NF=1 AD=0.348 AS=0.348 PD=2.98 PS=2.98 NRD=0.241667 NRS=0.241667 SA=0 SB=0 SD=0 MULT=2 M=2
XX2_M24 x2_foldn x2_foldn x2_foldn VSS sky130_fd_pr__nfet_01v8_lvt L=0.2 W=1.2 NF=1 AD=0.348 AS=0.348 PD=2.98 PS=2.98 NRD=0.241667 NRS=0.241667 SA=0 SB=0 SD=0 MULT=2 M=2
XX2_M80 op VSS VSS VSS sky130_fd_pr__nfet_01v8 L=0.6 W=1.4 NF=1 AD=0.406 AS=0.406 PD=3.38 PS=3.38 NRD=0.207143 NRS=0.207143 SA=0 SB=0 SD=0 MULT=2 M=2
XX2_M81 on VSS VSS VSS sky130_fd_pr__nfet_01v8 L=0.6 W=1.4 NF=1 AD=0.406 AS=0.406 PD=3.38 PS=3.38 NRD=0.207143 NRS=0.207143 SA=0 SB=0 SD=0 MULT=2 M=2
XX2_M28 x2_tail x2_tail x2_tail VSS sky130_fd_pr__nfet_01v8 L=0.6 W=1.4 NF=1 AD=0.406 AS=0.406 PD=3.38 PS=3.38 NRD=0.207143 NRS=0.207143 SA=0 SB=0 SD=0 MULT=6 M=6
XM43 VDD VDD VDD VDD sky130_fd_pr__pfet_01v8_lvt L=0.6 W=1.4 NF=1 AD=0.406 AS=0.406 PD=3.38 PS=3.38 NRD=0.207143 NRS=0.207143 SA=0 SB=0 SD=0 MULT=8 M=8
XM45 VDD VDD VDD VDD sky130_fd_pr__pfet_01v8 L=0.6 W=1.4 NF=1 AD=0.406 AS=0.406 PD=3.38 PS=3.38 NRD=0.207143 NRS=0.207143 SA=0 SB=0 SD=0 MULT=6 M=6
XM9 VSS VSS VSS VSS sky130_fd_pr__nfet_01v8 L=0.6 W=1.4 NF=1 AD=0.406 AS=0.406 PD=3.38 PS=3.38 NRD=0.207143 NRS=0.207143 SA=0 SB=0 SD=0 MULT=23 M=23
Ibias_ext VDD i_bias 3e-05
XC3 op cmc sky130_fd_pr__cap_mim_m3_1 W=4.8 L=4.8 MF=4 M=4
XC4 on cmc sky130_fd_pr__cap_mim_m3_1 W=4.8 L=4.8 MF=4 M=4
.ends iadc_ota
* NGSPICE file created from iadc_ota_v2_routed_flat.ext - technology: sky130A

.subckt iadc_ota_v2_routed_flat on op bias_a cm IBIAS VDD VSS cmc in ip x2_cm_tail__cc6_0.x2_m4d
+ x2_cm_tail__cc6_0.x2_m3d x2_cm_casc__cc6_0.bias_d x1_single_m3__f1_0.x1_m2d x1_cc_cm__strings1_0.x1_net1
+ x1_cc_cm__strings1_0.x1_net2 x1_cc_cm__strings1_0.x1_net3 x1_cc_cm__strings1_0.x1_net13
+ x1_cc_cm__strings1_0.x1_net14 x1_cc_cm__strings1_0.x1_net15 x1_cc_cm__strings1_0.x1_net4
+ x1_cc_cm__strings1_0.x1_net5 x1_cc_cm__strings1_0.x1_net6 x1_cc_cm__strings1_0.x1_net7
+ x1_cc_cm__strings1_0.x1_net8 x1_cc_cm__strings1_0.x1_net9 x1_cc_cm__strings1_0.x1_net10
+ x1_cc_cm__strings1_0.x1_net11 x1_cc_cm__strings1_0.x1_net12 x1_single_m5__f1_0.x1_m5d
+ x2_cl_src__cc3_0.bias_b x2_cl_casc__cc2_0.bias_c x2_diff__cc1_0.x2_foldp x2_diff__cc1_0.x2_foldn
+ x2_diff__cc1_0.x2_tail x1_cm_bias_c__cc1_0.x1_m21d x1_cm_bias_c__cc1_0.x1_m25d x1_cm_bias_c__cc1_0.x1_m31d
X0 x2_cm_tail__cc6_0.x2_m4d x2_cm_casc__cc6_0.bias_d op VSS sky130_fd_pr__nfet_01v8 ad=0.406 pd=3.38 as=0.406 ps=3.38 w=1.4 l=0.6
X1 x2_diff__cc1_0.x2_tail cmc VSS VSS sky130_fd_pr__nfet_01v8 ad=0.406 pd=3.38 as=0.406 ps=3.38 w=1.4 l=0.6
X2 x2_diff__cc1_0.x2_tail bias_a VSS VSS sky130_fd_pr__nfet_01v8 ad=0.406 pd=3.38 as=0.406 ps=3.38 w=1.4 l=0.6
X3 VSS bias_a x2_diff__cc1_0.x2_tail VSS sky130_fd_pr__nfet_01v8 ad=0.406 pd=3.38 as=0.406 ps=3.38 w=1.4 l=0.6
X4 x2_cl_src__cc3_0.bias_b x2_cl_src__cc3_0.bias_b x2_cl_casc__cc2_0.bias_c VSS sky130_fd_pr__nfet_01v8_lvt ad=0.406 pd=3.38 as=0.406 ps=3.38 w=1.4 l=0.6
X5 VDD x2_cl_src__cc3_0.bias_b x2_diff__cc1_0.x2_foldn VDD sky130_fd_pr__pfet_01v8_lvt ad=0.406 pd=3.38 as=0.406 ps=3.38 w=1.4 l=0.6
X6 x2_diff__cc1_0.x2_tail cmc VSS VSS sky130_fd_pr__nfet_01v8 ad=0.406 pd=3.38 as=0.406 ps=3.38 w=1.4 l=0.6
X7 VSS bias_a x2_diff__cc1_0.x2_tail VSS sky130_fd_pr__nfet_01v8 ad=0.406 pd=3.38 as=0.406 ps=3.38 w=1.4 l=0.6
X8 VSS bias_a x2_diff__cc1_0.x2_tail VSS sky130_fd_pr__nfet_01v8 ad=0.406 pd=3.38 as=0.406 ps=3.38 w=1.4 l=0.6
X9 x1_single_m3__f1_0.x1_m2d x1_single_m3__f1_0.x1_m2d x2_cm_casc__cc6_0.bias_d VSS sky130_fd_pr__nfet_01v8 ad=0.406 pd=3.38 as=0.406 ps=3.38 w=1.4 l=0.6
X10 on x2_cm_casc__cc6_0.bias_d x2_cm_tail__cc6_0.x2_m3d VSS sky130_fd_pr__nfet_01v8 ad=0.406 pd=3.38 as=0.406 ps=3.38 w=1.4 l=0.6
X11 x2_diff__cc1_0.x2_tail bias_a VSS VSS sky130_fd_pr__nfet_01v8 ad=0.406 pd=3.38 as=0.406 ps=3.38 w=1.4 l=0.6
X12 VDD x2_cl_src__cc3_0.bias_b x2_diff__cc1_0.x2_foldp VDD sky130_fd_pr__pfet_01v8_lvt ad=0.406 pd=3.38 as=0.406 ps=3.38 w=1.4 l=0.6
X13 VDD VDD VDD VDD sky130_fd_pr__pfet_01v8 ad=0.406 pd=3.38 as=52.78 ps=439.39999 w=1.4 l=0.6
X14 VSS VSS x2_diff__cc1_0.x2_tail VSS sky130_fd_pr__nfet_01v8 ad=0.406 pd=3.38 as=0.406 ps=3.38 w=1.4 l=0.6
X15 VSS bias_a x2_diff__cc1_0.x2_tail VSS sky130_fd_pr__nfet_01v8 ad=0.406 pd=3.38 as=0.406 ps=3.38 w=1.4 l=0.6
X16 x2_diff__cc1_0.x2_foldp ip x2_diff__cc1_0.x2_tail VSS sky130_fd_pr__nfet_01v8_lvt ad=0.348 pd=2.98 as=0.348 ps=2.98 w=1.2 l=0.2
X17 x2_cl_casc__cc2_0.bias_c x2_cl_src__cc3_0.bias_b x2_cl_src__cc3_0.bias_b VSS sky130_fd_pr__nfet_01v8_lvt ad=0.406 pd=3.38 as=0.406 ps=3.38 w=1.4 l=0.6
X18 x2_diff__cc1_0.x2_foldn x2_cl_casc__cc2_0.bias_c op VDD sky130_fd_pr__pfet_01v8 ad=0.406 pd=3.38 as=0.406 ps=3.38 w=1.4 l=0.6
X19 VSS cmc x2_diff__cc1_0.x2_tail VSS sky130_fd_pr__nfet_01v8 ad=0.406 pd=3.38 as=0.406 ps=3.38 w=1.4 l=0.6
X20 VDD x2_cl_src__cc3_0.bias_b x1_cm_bias_c__cc1_0.x1_m21d VDD sky130_fd_pr__pfet_01v8_lvt ad=0.406 pd=3.38 as=0.406 ps=3.38 w=1.4 l=0.6
X21 x1_cm_bias_c__cc1_0.x1_m25d x1_cm_bias_c__cc1_0.x1_m25d x1_cm_bias_c__cc1_0.x1_m25d VDD sky130_fd_pr__pfet_01v8 ad=0.406 pd=3.38 as=8.12 ps=67.6 w=1.4 l=0.6
X22 VDD VDD VDD VDD sky130_fd_pr__pfet_01v8_lvt ad=0.406 pd=3.38 as=0 ps=0 w=1.4 l=0.6
X23 on x2_cm_casc__cc6_0.bias_d x2_cm_tail__cc6_0.x2_m3d VSS sky130_fd_pr__nfet_01v8 ad=0.406 pd=3.38 as=0.406 ps=3.38 w=1.4 l=0.6
X24 VSS bias_a x2_cm_tail__cc6_0.x2_m3d VSS sky130_fd_pr__nfet_01v8 ad=0.406 pd=3.38 as=0.406 ps=3.38 w=1.4 l=0.6
X25 VSS VSS VSS VSS sky130_fd_pr__nfet_01v8 ad=0.406 pd=3.38 as=166.866 ps=1.38918k w=1.4 l=0.6
X26 x1_single_m5__f1_0.x1_m5d x2_cm_casc__cc6_0.bias_d bias_a VSS sky130_fd_pr__nfet_01v8 ad=0.406 pd=3.38 as=0.406 ps=3.38 w=1.4 l=0.6
X27 x1_single_m5__f1_0.x1_m5d bias_a VSS VSS sky130_fd_pr__nfet_01v8 ad=0.406 pd=3.38 as=0.406 ps=3.38 w=1.4 l=0.6
X28 x2_cm_tail__cc6_0.x2_m3d x2_cm_casc__cc6_0.bias_d on VSS sky130_fd_pr__nfet_01v8 ad=0.406 pd=3.38 as=0.406 ps=3.38 w=1.4 l=0.6
X29 x2_diff__cc1_0.x2_foldn in x2_diff__cc1_0.x2_tail VSS sky130_fd_pr__nfet_01v8_lvt ad=0.348 pd=2.98 as=0.348 ps=2.98 w=1.2 l=0.2
X30 VSS VSS x2_cm_tail__cc6_0.x2_m3d VSS sky130_fd_pr__nfet_01v8 ad=0.406 pd=3.38 as=0.406 ps=3.38 w=1.4 l=0.6
X31 x2_cl_casc__cc2_0.bias_c x2_cl_src__cc3_0.bias_b x2_cl_src__cc3_0.bias_b VSS sky130_fd_pr__nfet_01v8_lvt ad=0.406 pd=3.38 as=0.406 ps=3.38 w=1.4 l=0.6
X32 x1_single_m5__f1_0.x1_m5d bias_a VSS VSS sky130_fd_pr__nfet_01v8 ad=0.406 pd=3.38 as=0.406 ps=3.38 w=1.4 l=0.6
X33 op x2_cl_casc__cc2_0.bias_c x2_diff__cc1_0.x2_foldn VDD sky130_fd_pr__pfet_01v8 ad=0.406 pd=3.38 as=0.406 ps=3.38 w=1.4 l=0.6
X34 x2_diff__cc1_0.x2_foldn x2_cl_casc__cc2_0.bias_c op VDD sky130_fd_pr__pfet_01v8 ad=0.406 pd=3.38 as=0.406 ps=3.38 w=1.4 l=0.6
X35 x2_cm_casc__cc6_0.bias_d x1_single_m3__f1_0.x1_m2d x1_single_m3__f1_0.x1_m2d VSS sky130_fd_pr__nfet_01v8 ad=0.406 pd=3.38 as=0.406 ps=3.38 w=1.4 l=0.6
X36 x2_cm_casc__cc6_0.bias_d x1_single_m3__f1_0.x1_m2d x1_single_m3__f1_0.x1_m2d VSS sky130_fd_pr__nfet_01v8 ad=0.406 pd=3.38 as=0.406 ps=3.38 w=1.4 l=0.6
X37 x2_cm_tail__cc6_0.x2_m4d x2_cm_casc__cc6_0.bias_d op VSS sky130_fd_pr__nfet_01v8 ad=0.406 pd=3.38 as=0.406 ps=3.38 w=1.4 l=0.6
X38 x2_cm_casc__cc6_0.bias_d x2_cm_casc__cc6_0.bias_d x2_cm_casc__cc6_0.bias_d VSS sky130_fd_pr__nfet_01v8 ad=0.406 pd=3.38 as=27.608 ps=229.84 w=1.4 l=0.6
X39 x1_cc_cm__strings1_0.x1_net8 cm x1_cc_cm__strings1_0.x1_net9 VSS sky130_fd_pr__nfet_01v8 ad=0.406 pd=3.38 as=0.406 ps=3.38 w=1.4 l=0.6
X40 VSS bias_a x2_diff__cc1_0.x2_tail VSS sky130_fd_pr__nfet_01v8 ad=0.406 pd=3.38 as=0.406 ps=3.38 w=1.4 l=0.6
X41 x2_cl_src__cc3_0.bias_b x2_cl_src__cc3_0.bias_b x2_cl_casc__cc2_0.bias_c VSS sky130_fd_pr__nfet_01v8_lvt ad=0.406 pd=3.38 as=0.406 ps=3.38 w=1.4 l=0.6
X42 x2_cl_casc__cc2_0.bias_c x2_cl_src__cc3_0.bias_b x2_cl_src__cc3_0.bias_b VSS sky130_fd_pr__nfet_01v8_lvt ad=0.406 pd=3.38 as=0.406 ps=3.38 w=1.4 l=0.6
X43 x2_cl_casc__cc2_0.bias_c x2_cl_src__cc3_0.bias_b x2_cl_src__cc3_0.bias_b VSS sky130_fd_pr__nfet_01v8_lvt ad=0.406 pd=3.38 as=0.406 ps=3.38 w=1.4 l=0.6
X44 x2_cl_casc__cc2_0.bias_c x2_cl_casc__cc2_0.bias_c x2_cl_casc__cc2_0.bias_c VSS sky130_fd_pr__nfet_01v8_lvt ad=0.406 pd=3.38 as=38.164 ps=317.72 w=1.4 l=0.6
X45 x1_cc_cm__strings1_0.x1_net2 cm x1_cc_cm__strings1_0.x1_net1 VSS sky130_fd_pr__nfet_01v8 ad=0.406 pd=3.38 as=0.406 ps=3.38 w=1.4 l=0.6
X46 on x2_cl_casc__cc2_0.bias_c x2_diff__cc1_0.x2_foldp VDD sky130_fd_pr__pfet_01v8 ad=0.406 pd=3.38 as=0.406 ps=3.38 w=1.4 l=0.6
X47 x1_cc_cm__strings1_0.x1_net9 cm VSS VSS sky130_fd_pr__nfet_01v8 ad=0.406 pd=3.38 as=0.406 ps=3.38 w=1.4 l=0.6
X48 x2_diff__cc1_0.x2_foldn x2_cl_src__cc3_0.bias_b VDD VDD sky130_fd_pr__pfet_01v8_lvt ad=0.406 pd=3.38 as=0.406 ps=3.38 w=1.4 l=0.6
X49 IBIAS IBIAS IBIAS VSS sky130_fd_pr__nfet_01v8 ad=0.406 pd=3.38 as=8.932 ps=74.36 w=1.4 l=0.6
X50 VSS bias_a x1_single_m5__f1_0.x1_m5d VSS sky130_fd_pr__nfet_01v8 ad=0.406 pd=3.38 as=0.406 ps=3.38 w=1.4 l=0.6
X51 x2_cm_tail__cc6_0.x2_m3d x2_cm_casc__cc6_0.bias_d on VSS sky130_fd_pr__nfet_01v8 ad=0.406 pd=3.38 as=0.406 ps=3.38 w=1.4 l=0.6
X52 VSS bias_a x2_diff__cc1_0.x2_tail VSS sky130_fd_pr__nfet_01v8 ad=0.406 pd=3.38 as=0.406 ps=3.38 w=1.4 l=0.6
X53 VDD VDD x1_single_m3__f1_0.x1_m2d VDD sky130_fd_pr__pfet_01v8 ad=0.406 pd=3.38 as=0.406 ps=3.38 w=1.4 l=0.6
X54 x2_cl_casc__cc2_0.bias_c IBIAS VSS VSS sky130_fd_pr__nfet_01v8 ad=0.406 pd=3.38 as=0.406 ps=3.38 w=1.4 l=0.6
X55 bias_a x1_single_m3__f1_0.x1_m2d x2_cm_casc__cc6_0.bias_d VSS sky130_fd_pr__nfet_01v8 ad=0.406 pd=3.38 as=0.406 ps=3.38 w=1.4 l=0.6
X56 VSS bias_a x2_diff__cc1_0.x2_tail VSS sky130_fd_pr__nfet_01v8 ad=0.406 pd=3.38 as=0.406 ps=3.38 w=1.4 l=0.6
X57 x2_cl_src__cc3_0.bias_b x2_cl_src__cc3_0.bias_b x2_cl_casc__cc2_0.bias_c VSS sky130_fd_pr__nfet_01v8_lvt ad=0.406 pd=3.38 as=0.406 ps=3.38 w=1.4 l=0.6
X58 x2_cl_casc__cc2_0.bias_c x2_cl_src__cc3_0.bias_b x2_cl_src__cc3_0.bias_b VSS sky130_fd_pr__nfet_01v8_lvt ad=0.406 pd=3.38 as=0.406 ps=3.38 w=1.4 l=0.6
X59 x2_cl_casc__cc2_0.bias_c x2_cl_casc__cc2_0.bias_c x2_cl_casc__cc2_0.bias_c VSS sky130_fd_pr__nfet_01v8_lvt ad=0.406 pd=3.38 as=0 ps=0 w=1.4 l=0.6
X60 x2_diff__cc1_0.x2_tail bias_a VSS VSS sky130_fd_pr__nfet_01v8 ad=0.406 pd=3.38 as=0.406 ps=3.38 w=1.4 l=0.6
X61 IBIAS IBIAS IBIAS VSS sky130_fd_pr__nfet_01v8 ad=0.406 pd=3.38 as=0 ps=0 w=1.4 l=0.6
X62 VSS bias_a x1_single_m5__f1_0.x1_m5d VSS sky130_fd_pr__nfet_01v8 ad=0.406 pd=3.38 as=0.406 ps=3.38 w=1.4 l=0.6
X63 VSS bias_a x2_diff__cc1_0.x2_tail VSS sky130_fd_pr__nfet_01v8 ad=0.406 pd=3.38 as=0.406 ps=3.38 w=1.4 l=0.6
X64 x1_single_m3__f1_0.x1_m2d x1_single_m3__f1_0.x1_m2d x2_cm_casc__cc6_0.bias_d VSS sky130_fd_pr__nfet_01v8 ad=0.406 pd=3.38 as=0.406 ps=3.38 w=1.4 l=0.6
X65 x2_diff__cc1_0.x2_foldn x2_cl_src__cc3_0.bias_b VDD VDD sky130_fd_pr__pfet_01v8_lvt ad=0.406 pd=3.38 as=0.406 ps=3.38 w=1.4 l=0.6
X66 VSS IBIAS x2_cl_casc__cc2_0.bias_c VSS sky130_fd_pr__nfet_01v8 ad=0.406 pd=3.38 as=0.406 ps=3.38 w=1.4 l=0.6
X67 x2_diff__cc1_0.x2_foldn x2_diff__cc1_0.x2_foldn x2_diff__cc1_0.x2_foldn VDD sky130_fd_pr__pfet_01v8 ad=0.406 pd=3.38 as=20.3 ps=169 w=1.4 l=0.6
X68 x2_diff__cc1_0.x2_tail bias_a VSS VSS sky130_fd_pr__nfet_01v8 ad=0.406 pd=3.38 as=0.406 ps=3.38 w=1.4 l=0.6
X69 x2_diff__cc1_0.x2_tail cmc VSS VSS sky130_fd_pr__nfet_01v8 ad=0.406 pd=3.38 as=0.406 ps=3.38 w=1.4 l=0.6
X70 x2_diff__cc1_0.x2_tail cmc VSS VSS sky130_fd_pr__nfet_01v8 ad=0.406 pd=3.38 as=0.406 ps=3.38 w=1.4 l=0.6
X71 VSS bias_a x2_diff__cc1_0.x2_tail VSS sky130_fd_pr__nfet_01v8 ad=0.406 pd=3.38 as=0.406 ps=3.38 w=1.4 l=0.6
X72 x2_cl_casc__cc2_0.bias_c IBIAS VSS VSS sky130_fd_pr__nfet_01v8 ad=0.406 pd=3.38 as=0.406 ps=3.38 w=1.4 l=0.6
X73 op x2_cm_casc__cc6_0.bias_d x2_cm_tail__cc6_0.x2_m4d VSS sky130_fd_pr__nfet_01v8 ad=0.406 pd=3.38 as=0.406 ps=3.38 w=1.4 l=0.6
X74 x2_cl_src__cc3_0.bias_b x2_cl_src__cc3_0.bias_b x2_cl_casc__cc2_0.bias_c VSS sky130_fd_pr__nfet_01v8_lvt ad=0.406 pd=3.38 as=0.406 ps=3.38 w=1.4 l=0.6
X75 x1_single_m3__f1_0.x1_m2d x1_single_m3__f1_0.x1_m2d x2_cm_casc__cc6_0.bias_d VSS sky130_fd_pr__nfet_01v8 ad=0.406 pd=3.38 as=0.406 ps=3.38 w=1.4 l=0.6
X76 VDD VDD op VDD sky130_fd_pr__pfet_01v8 ad=0.406 pd=3.38 as=0.406 ps=3.38 w=1.4 l=0.6
X77 x2_cm_tail__cc6_0.x2_m4d bias_a VSS VSS sky130_fd_pr__nfet_01v8 ad=0.406 pd=3.38 as=0.406 ps=3.38 w=1.4 l=0.6
X78 x2_cl_src__cc3_0.bias_b x2_cl_src__cc3_0.bias_b x2_cl_casc__cc2_0.bias_c VSS sky130_fd_pr__nfet_01v8_lvt ad=0.406 pd=3.38 as=0.406 ps=3.38 w=1.4 l=0.6
X79 x2_diff__cc1_0.x2_tail ip x2_diff__cc1_0.x2_foldp VSS sky130_fd_pr__nfet_01v8_lvt ad=0.348 pd=2.98 as=0.348 ps=2.98 w=1.2 l=0.2
X80 x2_cl_src__cc3_0.bias_b x2_cl_src__cc3_0.bias_b x2_cl_casc__cc2_0.bias_c VSS sky130_fd_pr__nfet_01v8_lvt ad=0.406 pd=3.38 as=0.406 ps=3.38 w=1.4 l=0.6
X81 x1_single_m3__f1_0.x1_m2d x1_single_m3__f1_0.x1_m2d x2_cm_casc__cc6_0.bias_d VSS sky130_fd_pr__nfet_01v8 ad=0.406 pd=3.38 as=0.406 ps=3.38 w=1.4 l=0.6
X82 VSS bias_a x2_cm_tail__cc6_0.x2_m3d VSS sky130_fd_pr__nfet_01v8 ad=0.406 pd=3.38 as=0.406 ps=3.38 w=1.4 l=0.6
X83 x2_diff__cc1_0.x2_tail bias_a VSS VSS sky130_fd_pr__nfet_01v8 ad=0.406 pd=3.38 as=0.406 ps=3.38 w=1.4 l=0.6
X84 x2_diff__cc1_0.x2_tail cmc VSS VSS sky130_fd_pr__nfet_01v8 ad=0.406 pd=3.38 as=0.406 ps=3.38 w=1.4 l=0.6
X85 VSS cmc x2_diff__cc1_0.x2_tail VSS sky130_fd_pr__nfet_01v8 ad=0.406 pd=3.38 as=0.406 ps=3.38 w=1.4 l=0.6
X86 VDD VDD VDD VDD sky130_fd_pr__pfet_01v8 ad=0.406 pd=3.38 as=0 ps=0 w=1.4 l=0.6
X87 x2_diff__cc1_0.x2_foldn x2_cl_src__cc3_0.bias_b VDD VDD sky130_fd_pr__pfet_01v8_lvt ad=0.406 pd=3.38 as=0.406 ps=3.38 w=1.4 l=0.6
X88 VDD VDD x2_diff__cc1_0.x2_foldn VDD sky130_fd_pr__pfet_01v8 ad=0.406 pd=3.38 as=0.406 ps=3.38 w=1.4 l=0.6
X89 VSS bias_a x2_diff__cc1_0.x2_tail VSS sky130_fd_pr__nfet_01v8 ad=0.406 pd=3.38 as=0.406 ps=3.38 w=1.4 l=0.6
X90 x2_cm_tail__cc6_0.x2_m4d bias_a VSS VSS sky130_fd_pr__nfet_01v8 ad=0.406 pd=3.38 as=0.406 ps=3.38 w=1.4 l=0.6
X91 x2_cm_tail__cc6_0.x2_m3d x2_cm_casc__cc6_0.bias_d on VSS sky130_fd_pr__nfet_01v8 ad=0.406 pd=3.38 as=0.406 ps=3.38 w=1.4 l=0.6
X92 VSS cmc x2_diff__cc1_0.x2_tail VSS sky130_fd_pr__nfet_01v8 ad=0.406 pd=3.38 as=0.406 ps=3.38 w=1.4 l=0.6
X93 x1_single_m3__f1_0.x1_m2d x1_single_m3__f1_0.x1_m2d x2_cm_casc__cc6_0.bias_d VSS sky130_fd_pr__nfet_01v8 ad=0.406 pd=3.38 as=0.406 ps=3.38 w=1.4 l=0.6
X94 VSS bias_a x2_cm_tail__cc6_0.x2_m3d VSS sky130_fd_pr__nfet_01v8 ad=0.406 pd=3.38 as=0.406 ps=3.38 w=1.4 l=0.6
X95 VSS bias_a x2_cm_tail__cc6_0.x2_m4d VSS sky130_fd_pr__nfet_01v8 ad=0.406 pd=3.38 as=0.406 ps=3.38 w=1.4 l=0.6
X96 x1_cm_bias_c__cc1_0.x1_m25d x1_cm_bias_c__cc1_0.x1_m25d x1_cm_bias_c__cc1_0.x1_m25d VDD sky130_fd_pr__pfet_01v8_lvt ad=0.406 pd=3.38 as=0 ps=0 w=1.4 l=0.6
X97 VDD VDD VDD VDD sky130_fd_pr__pfet_01v8_lvt ad=0.406 pd=3.38 as=0 ps=0 w=1.4 l=0.6
X98 bias_a x2_cm_casc__cc6_0.bias_d x1_single_m5__f1_0.x1_m5d VSS sky130_fd_pr__nfet_01v8 ad=0.406 pd=3.38 as=0.406 ps=3.38 w=1.4 l=0.6
X99 x2_diff__cc1_0.x2_foldp x2_cl_casc__cc2_0.bias_c on VDD sky130_fd_pr__pfet_01v8 ad=0.406 pd=3.38 as=0.406 ps=3.38 w=1.4 l=0.6
X100 on on on VSS sky130_fd_pr__nfet_01v8 ad=0.406 pd=3.38 as=17.052 ps=141.96001 w=1.4 l=0.6
X101 VSS bias_a x2_diff__cc1_0.x2_tail VSS sky130_fd_pr__nfet_01v8 ad=0.406 pd=3.38 as=0.406 ps=3.38 w=1.4 l=0.6
X102 x1_cm_bias_c__cc1_0.x1_m21d x2_cl_src__cc3_0.bias_b VDD VDD sky130_fd_pr__pfet_01v8_lvt ad=0.406 pd=3.38 as=0.406 ps=3.38 w=1.4 l=0.6
X103 x2_cl_casc__cc2_0.bias_c x2_cl_src__cc3_0.bias_b x2_cl_src__cc3_0.bias_b VSS sky130_fd_pr__nfet_01v8_lvt ad=0.406 pd=3.38 as=0.406 ps=3.38 w=1.4 l=0.6
X104 VSS bias_a x2_diff__cc1_0.x2_tail VSS sky130_fd_pr__nfet_01v8 ad=0.406 pd=3.38 as=0.406 ps=3.38 w=1.4 l=0.6
X105 x2_diff__cc1_0.x2_tail bias_a VSS VSS sky130_fd_pr__nfet_01v8 ad=0.406 pd=3.38 as=0.406 ps=3.38 w=1.4 l=0.6
X106 VSS bias_a x2_cm_tail__cc6_0.x2_m3d VSS sky130_fd_pr__nfet_01v8 ad=0.406 pd=3.38 as=0.406 ps=3.38 w=1.4 l=0.6
X107 x2_diff__cc1_0.x2_foldn x2_diff__cc1_0.x2_foldn x2_diff__cc1_0.x2_foldn VSS sky130_fd_pr__nfet_01v8_lvt ad=0.348 pd=2.98 as=3.48 ps=29.8 w=1.2 l=0.2
X108 op x2_cm_casc__cc6_0.bias_d x2_cm_tail__cc6_0.x2_m4d VSS sky130_fd_pr__nfet_01v8 ad=0.406 pd=3.38 as=0.406 ps=3.38 w=1.4 l=0.6
X109 VDD VDD VDD VDD sky130_fd_pr__pfet_01v8 ad=0.406 pd=3.38 as=0 ps=0 w=1.4 l=0.6
X110 x2_diff__cc1_0.x2_foldp x2_cl_src__cc3_0.bias_b VDD VDD sky130_fd_pr__pfet_01v8_lvt ad=0.406 pd=3.38 as=0.406 ps=3.38 w=1.4 l=0.6
X111 x2_cl_casc__cc2_0.bias_c x2_cl_src__cc3_0.bias_b x2_cl_src__cc3_0.bias_b VSS sky130_fd_pr__nfet_01v8_lvt ad=0.406 pd=3.38 as=0.406 ps=3.38 w=1.4 l=0.6
X112 x2_cl_casc__cc2_0.bias_c x2_cl_casc__cc2_0.bias_c x2_cl_casc__cc2_0.bias_c VSS sky130_fd_pr__nfet_01v8_lvt ad=0.406 pd=3.38 as=0 ps=0 w=1.4 l=0.6
X113 x2_cl_casc__cc2_0.bias_c x2_cl_src__cc3_0.bias_b x2_cl_src__cc3_0.bias_b VSS sky130_fd_pr__nfet_01v8_lvt ad=0.406 pd=3.38 as=0.406 ps=3.38 w=1.4 l=0.6
X114 x2_cm_tail__cc6_0.x2_m4d x2_cm_casc__cc6_0.bias_d op VSS sky130_fd_pr__nfet_01v8 ad=0.406 pd=3.38 as=0.406 ps=3.38 w=1.4 l=0.6
X115 VSS IBIAS IBIAS VSS sky130_fd_pr__nfet_01v8 ad=0.406 pd=3.38 as=0.406 ps=3.38 w=1.4 l=0.6
X116 x2_diff__cc1_0.x2_tail x2_diff__cc1_0.x2_tail x2_diff__cc1_0.x2_tail VSS sky130_fd_pr__nfet_01v8 ad=0.406 pd=3.38 as=87.812 ps=732.03998 w=1.4 l=0.6
X117 x1_single_m3__f1_0.x1_m2d x2_cl_casc__cc2_0.bias_c x1_cm_bias_c__cc1_0.x1_m25d VDD sky130_fd_pr__pfet_01v8 ad=0.406 pd=3.38 as=0.406 ps=3.38 w=1.4 l=0.6
X118 op op op VSS sky130_fd_pr__nfet_01v8 ad=0.406 pd=3.38 as=17.052 ps=141.96001 w=1.4 l=0.6
X119 VSS bias_a x2_cm_tail__cc6_0.x2_m4d VSS sky130_fd_pr__nfet_01v8 ad=0.406 pd=3.38 as=0.406 ps=3.38 w=1.4 l=0.6
X120 IBIAS IBIAS VSS VSS sky130_fd_pr__nfet_01v8 ad=0.406 pd=3.38 as=0.406 ps=3.38 w=1.4 l=0.6
X121 x2_cm_tail__cc6_0.x2_m3d x2_cm_casc__cc6_0.bias_d on VSS sky130_fd_pr__nfet_01v8 ad=0.406 pd=3.38 as=0.406 ps=3.38 w=1.4 l=0.6
X122 x2_cl_src__cc3_0.bias_b x2_cl_src__cc3_0.bias_b x2_cl_casc__cc2_0.bias_c VSS sky130_fd_pr__nfet_01v8_lvt ad=0.406 pd=3.38 as=0.406 ps=3.38 w=1.4 l=0.6
X123 VDD VDD VDD VDD sky130_fd_pr__pfet_01v8_lvt ad=0.406 pd=3.38 as=0 ps=0 w=1.4 l=0.6
X124 x1_single_m5__f1_0.x1_m5d x2_cm_casc__cc6_0.bias_d bias_a VSS sky130_fd_pr__nfet_01v8 ad=0.406 pd=3.38 as=0.406 ps=3.38 w=1.4 l=0.6
X125 x2_cm_casc__cc6_0.bias_d x1_single_m3__f1_0.x1_m2d x1_single_m3__f1_0.x1_m2d VSS sky130_fd_pr__nfet_01v8 ad=0.406 pd=3.38 as=0.406 ps=3.38 w=1.4 l=0.6
X126 x2_diff__cc1_0.x2_foldn x2_cl_src__cc3_0.bias_b VDD VDD sky130_fd_pr__pfet_01v8_lvt ad=0.406 pd=3.38 as=0.406 ps=3.38 w=1.4 l=0.6
X127 x2_cl_casc__cc2_0.bias_c x2_cl_src__cc3_0.bias_b x2_cl_src__cc3_0.bias_b VSS sky130_fd_pr__nfet_01v8_lvt ad=0.406 pd=3.38 as=0.406 ps=3.38 w=1.4 l=0.6
X128 x2_cl_casc__cc2_0.bias_c x2_cl_casc__cc2_0.bias_c x2_cl_casc__cc2_0.bias_c VSS sky130_fd_pr__nfet_01v8_lvt ad=0.406 pd=3.38 as=0 ps=0 w=1.4 l=0.6
X129 x2_cm_casc__cc6_0.bias_d x2_cm_casc__cc6_0.bias_d x2_cm_casc__cc6_0.bias_d VSS sky130_fd_pr__nfet_01v8 ad=0.406 pd=3.38 as=0 ps=0 w=1.4 l=0.6
X130 x2_cl_src__cc3_0.bias_b x2_cl_src__cc3_0.bias_b x2_cl_casc__cc2_0.bias_c VSS sky130_fd_pr__nfet_01v8_lvt ad=0.406 pd=3.38 as=0.406 ps=3.38 w=1.4 l=0.6
X131 x2_diff__cc1_0.x2_tail cmc VSS VSS sky130_fd_pr__nfet_01v8 ad=0.406 pd=3.38 as=0.406 ps=3.38 w=1.4 l=0.6
X132 VDD VDD x2_cl_src__cc3_0.bias_b VDD sky130_fd_pr__pfet_01v8 ad=0.406 pd=3.38 as=0.406 ps=3.38 w=1.4 l=0.6
X133 x2_cl_casc__cc2_0.bias_c x2_cl_src__cc3_0.bias_b x2_cl_src__cc3_0.bias_b VSS sky130_fd_pr__nfet_01v8_lvt ad=0.406 pd=3.38 as=0.406 ps=3.38 w=1.4 l=0.6
X134 x2_cm_casc__cc6_0.bias_d x1_single_m3__f1_0.x1_m2d x1_single_m3__f1_0.x1_m2d VSS sky130_fd_pr__nfet_01v8 ad=0.406 pd=3.38 as=0.406 ps=3.38 w=1.4 l=0.6
X135 x2_cm_casc__cc6_0.bias_d x1_single_m3__f1_0.x1_m2d x1_single_m3__f1_0.x1_m2d VSS sky130_fd_pr__nfet_01v8 ad=0.406 pd=3.38 as=0.406 ps=3.38 w=1.4 l=0.6
X136 VSS IBIAS IBIAS VSS sky130_fd_pr__nfet_01v8 ad=0.406 pd=3.38 as=0.406 ps=3.38 w=1.4 l=0.6
X137 x2_diff__cc1_0.x2_tail cmc VSS VSS sky130_fd_pr__nfet_01v8 ad=0.406 pd=3.38 as=0.406 ps=3.38 w=1.4 l=0.6
X138 x2_cl_src__cc3_0.bias_b x2_cl_src__cc3_0.bias_b x2_cl_casc__cc2_0.bias_c VSS sky130_fd_pr__nfet_01v8_lvt ad=0.406 pd=3.38 as=0.406 ps=3.38 w=1.4 l=0.6
X139 x1_cc_cm__strings1_0.x1_net3 cm x1_cc_cm__strings1_0.x1_net2 VSS sky130_fd_pr__nfet_01v8 ad=0.406 pd=3.38 as=0.406 ps=3.38 w=1.4 l=0.6
X140 x2_cm_tail__cc6_0.x2_m3d bias_a VSS VSS sky130_fd_pr__nfet_01v8 ad=0.406 pd=3.38 as=0.406 ps=3.38 w=1.4 l=0.6
X141 x2_cl_casc__cc2_0.bias_c x2_cl_src__cc3_0.bias_b x2_cl_src__cc3_0.bias_b VSS sky130_fd_pr__nfet_01v8_lvt ad=0.406 pd=3.38 as=0.406 ps=3.38 w=1.4 l=0.6
X142 IBIAS IBIAS VSS VSS sky130_fd_pr__nfet_01v8 ad=0.406 pd=3.38 as=0.406 ps=3.38 w=1.4 l=0.6
X143 cm cm x1_cc_cm__strings1_0.x1_net10 VSS sky130_fd_pr__nfet_01v8 ad=0.406 pd=3.38 as=0.406 ps=3.38 w=1.4 l=0.6
X144 x2_cm_tail__cc6_0.x2_m4d bias_a VSS VSS sky130_fd_pr__nfet_01v8 ad=0.406 pd=3.38 as=0.406 ps=3.38 w=1.4 l=0.6
X145 VSS cmc x2_diff__cc1_0.x2_tail VSS sky130_fd_pr__nfet_01v8 ad=0.406 pd=3.38 as=0.406 ps=3.38 w=1.4 l=0.6
X146 x2_cl_src__cc3_0.bias_b x2_cl_src__cc3_0.bias_b x2_cl_casc__cc2_0.bias_c VSS sky130_fd_pr__nfet_01v8_lvt ad=0.406 pd=3.38 as=0.406 ps=3.38 w=1.4 l=0.6
X147 x2_cl_casc__cc2_0.bias_c x2_cl_src__cc3_0.bias_b x2_cl_src__cc3_0.bias_b VSS sky130_fd_pr__nfet_01v8_lvt ad=0.406 pd=3.38 as=0.406 ps=3.38 w=1.4 l=0.6
X148 VSS bias_a x2_cm_tail__cc6_0.x2_m4d VSS sky130_fd_pr__nfet_01v8 ad=0.406 pd=3.38 as=0.406 ps=3.38 w=1.4 l=0.6
X149 VSS IBIAS IBIAS VSS sky130_fd_pr__nfet_01v8 ad=0.406 pd=3.38 as=0.406 ps=3.38 w=1.4 l=0.6
X150 VSS bias_a x1_single_m5__f1_0.x1_m5d VSS sky130_fd_pr__nfet_01v8 ad=0.406 pd=3.38 as=0.406 ps=3.38 w=1.4 l=0.6
X151 x2_cm_tail__cc6_0.x2_m3d x2_cm_casc__cc6_0.bias_d on VSS sky130_fd_pr__nfet_01v8 ad=0.406 pd=3.38 as=0.406 ps=3.38 w=1.4 l=0.6
X152 on cmc sky130_fd_pr__cap_mim_m3_1 l=4.8 w=4.8
Cmimself0 on cmc -2.601225f
X153 x2_cm_tail__cc6_0.x2_m4d bias_a VSS VSS sky130_fd_pr__nfet_01v8 ad=0.406 pd=3.38 as=0.406 ps=3.38 w=1.4 l=0.6
X154 x1_single_m3__f1_0.x1_m2d x1_single_m3__f1_0.x1_m2d x2_cm_casc__cc6_0.bias_d VSS sky130_fd_pr__nfet_01v8 ad=0.406 pd=3.38 as=0.406 ps=3.38 w=1.4 l=0.6
X155 IBIAS IBIAS VSS VSS sky130_fd_pr__nfet_01v8 ad=0.406 pd=3.38 as=0.406 ps=3.38 w=1.4 l=0.6
X156 VDD VDD VDD VDD sky130_fd_pr__pfet_01v8 ad=0.406 pd=3.38 as=0 ps=0 w=1.4 l=0.6
X157 VSS cmc x2_diff__cc1_0.x2_tail VSS sky130_fd_pr__nfet_01v8 ad=0.406 pd=3.38 as=0.406 ps=3.38 w=1.4 l=0.6
X158 x2_diff__cc1_0.x2_tail bias_a VSS VSS sky130_fd_pr__nfet_01v8 ad=0.406 pd=3.38 as=0.406 ps=3.38 w=1.4 l=0.6
X159 VDD VDD VDD VDD sky130_fd_pr__pfet_01v8_lvt ad=0.406 pd=3.38 as=0 ps=0 w=1.4 l=0.6
X160 VSS bias_a x2_diff__cc1_0.x2_tail VSS sky130_fd_pr__nfet_01v8 ad=0.406 pd=3.38 as=0.406 ps=3.38 w=1.4 l=0.6
X161 x2_diff__cc1_0.x2_tail cmc VSS VSS sky130_fd_pr__nfet_01v8 ad=0.406 pd=3.38 as=0.406 ps=3.38 w=1.4 l=0.6
X162 x2_cl_src__cc3_0.bias_b x2_cl_src__cc3_0.bias_b x2_cl_casc__cc2_0.bias_c VSS sky130_fd_pr__nfet_01v8_lvt ad=0.406 pd=3.38 as=0.406 ps=3.38 w=1.4 l=0.6
X163 x1_single_m3__f1_0.x1_m2d x1_single_m3__f1_0.x1_m2d x2_cm_casc__cc6_0.bias_d VSS sky130_fd_pr__nfet_01v8 ad=0.406 pd=3.38 as=0.406 ps=3.38 w=1.4 l=0.6
X164 on x2_cm_casc__cc6_0.bias_d x2_cm_tail__cc6_0.x2_m3d VSS sky130_fd_pr__nfet_01v8 ad=0.406 pd=3.38 as=0.406 ps=3.38 w=1.4 l=0.6
X165 x2_diff__cc1_0.x2_foldp x2_diff__cc1_0.x2_foldp x2_diff__cc1_0.x2_foldp VSS sky130_fd_pr__nfet_01v8_lvt ad=0.348 pd=2.98 as=3.48 ps=29.8 w=1.2 l=0.2
X166 x2_cl_src__cc3_0.bias_b x2_cl_src__cc3_0.bias_b x2_cl_casc__cc2_0.bias_c VSS sky130_fd_pr__nfet_01v8_lvt ad=0.406 pd=3.38 as=0.406 ps=3.38 w=1.4 l=0.6
X167 x2_diff__cc1_0.x2_tail bias_a VSS VSS sky130_fd_pr__nfet_01v8 ad=0.406 pd=3.38 as=0.406 ps=3.38 w=1.4 l=0.6
X168 op x2_cm_casc__cc6_0.bias_d x2_cm_tail__cc6_0.x2_m4d VSS sky130_fd_pr__nfet_01v8 ad=0.406 pd=3.38 as=0.406 ps=3.38 w=1.4 l=0.6
X169 VSS bias_a x2_diff__cc1_0.x2_tail VSS sky130_fd_pr__nfet_01v8 ad=0.406 pd=3.38 as=0.406 ps=3.38 w=1.4 l=0.6
X170 VDD VDD VDD VDD sky130_fd_pr__pfet_01v8 ad=0.406 pd=3.38 as=0 ps=0 w=1.4 l=0.6
X171 x1_single_m3__f1_0.x1_m2d x1_single_m3__f1_0.x1_m2d x2_cm_casc__cc6_0.bias_d VSS sky130_fd_pr__nfet_01v8 ad=0.406 pd=3.38 as=0.406 ps=3.38 w=1.4 l=0.6
X172 x1_cm_bias_c__cc1_0.x1_m31d x1_cm_bias_c__cc1_0.x1_m31d x1_cm_bias_c__cc1_0.x1_m31d VDD sky130_fd_pr__pfet_01v8_lvt ad=0.406 pd=3.38 as=7.308 ps=60.84 w=1.4 l=0.6
X173 VSS bias_a x2_diff__cc1_0.x2_tail VSS sky130_fd_pr__nfet_01v8 ad=0.406 pd=3.38 as=0.406 ps=3.38 w=1.4 l=0.6
X174 x2_diff__cc1_0.x2_foldn x2_cl_casc__cc2_0.bias_c op VDD sky130_fd_pr__pfet_01v8 ad=0.406 pd=3.38 as=0.406 ps=3.38 w=1.4 l=0.6
X175 x2_diff__cc1_0.x2_tail cmc VSS VSS sky130_fd_pr__nfet_01v8 ad=0.406 pd=3.38 as=0.406 ps=3.38 w=1.4 l=0.6
X176 VSS bias_a x2_cm_tail__cc6_0.x2_m4d VSS sky130_fd_pr__nfet_01v8 ad=0.406 pd=3.38 as=0.406 ps=3.38 w=1.4 l=0.6
X177 x2_cm_tail__cc6_0.x2_m3d bias_a VSS VSS sky130_fd_pr__nfet_01v8 ad=0.406 pd=3.38 as=0.406 ps=3.38 w=1.4 l=0.6
X178 x2_diff__cc1_0.x2_tail bias_a VSS VSS sky130_fd_pr__nfet_01v8 ad=0.406 pd=3.38 as=0.406 ps=3.38 w=1.4 l=0.6
X179 x2_diff__cc1_0.x2_foldn x2_cl_src__cc3_0.bias_b VDD VDD sky130_fd_pr__pfet_01v8_lvt ad=0.406 pd=3.38 as=0.406 ps=3.38 w=1.4 l=0.6
X180 VSS bias_a x2_cm_tail__cc6_0.x2_m3d VSS sky130_fd_pr__nfet_01v8 ad=0.406 pd=3.38 as=0.406 ps=3.38 w=1.4 l=0.6
X181 x2_diff__cc1_0.x2_tail cmc VSS VSS sky130_fd_pr__nfet_01v8 ad=0.406 pd=3.38 as=0.406 ps=3.38 w=1.4 l=0.6
X182 x2_cm_tail__cc6_0.x2_m3d bias_a VSS VSS sky130_fd_pr__nfet_01v8 ad=0.406 pd=3.38 as=0.406 ps=3.38 w=1.4 l=0.6
X183 x1_cm_bias_c__cc1_0.x1_m25d x2_cl_src__cc3_0.bias_b VDD VDD sky130_fd_pr__pfet_01v8_lvt ad=0.406 pd=3.38 as=0.406 ps=3.38 w=1.4 l=0.6
X184 x2_cl_casc__cc2_0.bias_c x2_cl_src__cc3_0.bias_b x2_cl_src__cc3_0.bias_b VSS sky130_fd_pr__nfet_01v8_lvt ad=0.406 pd=3.38 as=0.406 ps=3.38 w=1.4 l=0.6
X185 x2_diff__cc1_0.x2_foldp x2_cl_casc__cc2_0.bias_c on VDD sky130_fd_pr__pfet_01v8 ad=0.406 pd=3.38 as=0.406 ps=3.38 w=1.4 l=0.6
X186 VSS VSS op VSS sky130_fd_pr__nfet_01v8 ad=0.406 pd=3.38 as=0.406 ps=3.38 w=1.4 l=0.6
X187 x2_diff__cc1_0.x2_foldn x2_cl_casc__cc2_0.bias_c op VDD sky130_fd_pr__pfet_01v8 ad=0.406 pd=3.38 as=0.406 ps=3.38 w=1.4 l=0.6
X188 bias_a x2_cm_casc__cc6_0.bias_d x1_single_m5__f1_0.x1_m5d VSS sky130_fd_pr__nfet_01v8 ad=0.406 pd=3.38 as=0.406 ps=3.38 w=1.4 l=0.6
X189 VSS VSS VSS VSS sky130_fd_pr__nfet_01v8 ad=0.406 pd=3.38 as=0 ps=0 w=1.4 l=0.6
X190 x2_cl_casc__cc2_0.bias_c x2_cl_src__cc3_0.bias_b x2_cl_src__cc3_0.bias_b VSS sky130_fd_pr__nfet_01v8_lvt ad=0.406 pd=3.38 as=0.406 ps=3.38 w=1.4 l=0.6
X191 on x2_cm_casc__cc6_0.bias_d x2_cm_tail__cc6_0.x2_m3d VSS sky130_fd_pr__nfet_01v8 ad=0.406 pd=3.38 as=0.406 ps=3.38 w=1.4 l=0.6
X192 VSS cmc x2_diff__cc1_0.x2_tail VSS sky130_fd_pr__nfet_01v8 ad=0.406 pd=3.38 as=0.406 ps=3.38 w=1.4 l=0.6
X193 x2_diff__cc1_0.x2_tail cmc VSS VSS sky130_fd_pr__nfet_01v8 ad=0.406 pd=3.38 as=0.406 ps=3.38 w=1.4 l=0.6
X194 x2_cl_casc__cc2_0.bias_c x2_cl_src__cc3_0.bias_b x2_cl_src__cc3_0.bias_b VSS sky130_fd_pr__nfet_01v8_lvt ad=0.406 pd=3.38 as=0.406 ps=3.38 w=1.4 l=0.6
X195 bias_a x2_cm_casc__cc6_0.bias_d x1_single_m5__f1_0.x1_m5d VSS sky130_fd_pr__nfet_01v8 ad=0.406 pd=3.38 as=0.406 ps=3.38 w=1.4 l=0.6
X196 x2_cl_casc__cc2_0.bias_c x2_cl_src__cc3_0.bias_b x2_cl_src__cc3_0.bias_b VSS sky130_fd_pr__nfet_01v8_lvt ad=0.406 pd=3.38 as=0.406 ps=3.38 w=1.4 l=0.6
X197 x2_cm_tail__cc6_0.x2_m4d bias_a VSS VSS sky130_fd_pr__nfet_01v8 ad=0.406 pd=3.38 as=0.406 ps=3.38 w=1.4 l=0.6
X198 x1_cm_bias_c__cc1_0.x1_m21d x1_cm_bias_c__cc1_0.x1_m21d x1_cm_bias_c__cc1_0.x1_m21d VDD sky130_fd_pr__pfet_01v8_lvt ad=0.406 pd=3.38 as=8.12 ps=67.6 w=1.4 l=0.6
X199 x2_cl_src__cc3_0.bias_b x2_cl_src__cc3_0.bias_b x2_cl_casc__cc2_0.bias_c VSS sky130_fd_pr__nfet_01v8_lvt ad=0.406 pd=3.38 as=0.406 ps=3.38 w=1.4 l=0.6
X200 VSS bias_a x2_diff__cc1_0.x2_tail VSS sky130_fd_pr__nfet_01v8 ad=0.406 pd=3.38 as=0.406 ps=3.38 w=1.4 l=0.6
X201 VDD x2_cl_src__cc3_0.bias_b x1_cm_bias_c__cc1_0.x1_m25d VDD sky130_fd_pr__pfet_01v8_lvt ad=0.406 pd=3.38 as=0.406 ps=3.38 w=1.4 l=0.6
X202 x2_cl_casc__cc2_0.bias_c x2_cl_src__cc3_0.bias_b x2_cl_src__cc3_0.bias_b VSS sky130_fd_pr__nfet_01v8_lvt ad=0.406 pd=3.38 as=0.406 ps=3.38 w=1.4 l=0.6
X203 VSS cmc x2_diff__cc1_0.x2_tail VSS sky130_fd_pr__nfet_01v8 ad=0.406 pd=3.38 as=0.406 ps=3.38 w=1.4 l=0.6
X204 x2_cl_casc__cc2_0.bias_c x2_cl_src__cc3_0.bias_b x2_cl_src__cc3_0.bias_b VSS sky130_fd_pr__nfet_01v8_lvt ad=0.406 pd=3.38 as=0.406 ps=3.38 w=1.4 l=0.6
X205 x2_diff__cc1_0.x2_foldn x2_cl_src__cc3_0.bias_b VDD VDD sky130_fd_pr__pfet_01v8_lvt ad=0.406 pd=3.38 as=0.406 ps=3.38 w=1.4 l=0.6
X206 x2_cm_tail__cc6_0.x2_m3d bias_a VSS VSS sky130_fd_pr__nfet_01v8 ad=0.406 pd=3.38 as=0.406 ps=3.38 w=1.4 l=0.6
X207 VSS bias_a x2_cm_tail__cc6_0.x2_m4d VSS sky130_fd_pr__nfet_01v8 ad=0.406 pd=3.38 as=0.406 ps=3.38 w=1.4 l=0.6
X208 x2_cl_casc__cc2_0.bias_c IBIAS VSS VSS sky130_fd_pr__nfet_01v8 ad=0.406 pd=3.38 as=0.406 ps=3.38 w=1.4 l=0.6
X209 op x2_cl_casc__cc2_0.bias_c x2_diff__cc1_0.x2_foldn VDD sky130_fd_pr__pfet_01v8 ad=0.406 pd=3.38 as=0.406 ps=3.38 w=1.4 l=0.6
X210 x2_cm_tail__cc6_0.x2_m4d x2_cm_casc__cc6_0.bias_d op VSS sky130_fd_pr__nfet_01v8 ad=0.406 pd=3.38 as=0.406 ps=3.38 w=1.4 l=0.6
X211 x2_cm_tail__cc6_0.x2_m3d x2_cm_casc__cc6_0.bias_d on VSS sky130_fd_pr__nfet_01v8 ad=0.406 pd=3.38 as=0.406 ps=3.38 w=1.4 l=0.6
X212 on x2_cm_casc__cc6_0.bias_d x2_cm_tail__cc6_0.x2_m3d VSS sky130_fd_pr__nfet_01v8 ad=0.406 pd=3.38 as=0.406 ps=3.38 w=1.4 l=0.6
X213 VSS cmc x2_diff__cc1_0.x2_tail VSS sky130_fd_pr__nfet_01v8 ad=0.406 pd=3.38 as=0.406 ps=3.38 w=1.4 l=0.6
X214 x2_cl_src__cc3_0.bias_b x2_cl_src__cc3_0.bias_b x2_cl_casc__cc2_0.bias_c VSS sky130_fd_pr__nfet_01v8_lvt ad=0.406 pd=3.38 as=0.406 ps=3.38 w=1.4 l=0.6
X215 VDD x2_cl_src__cc3_0.bias_b x2_diff__cc1_0.x2_foldn VDD sky130_fd_pr__pfet_01v8_lvt ad=0.406 pd=3.38 as=0.406 ps=3.38 w=1.4 l=0.6
X216 x2_cm_tail__cc6_0.x2_m4d x2_cm_casc__cc6_0.bias_d op VSS sky130_fd_pr__nfet_01v8 ad=0.406 pd=3.38 as=0.406 ps=3.38 w=1.4 l=0.6
X217 x2_cl_casc__cc2_0.bias_c x2_cl_src__cc3_0.bias_b x2_cl_src__cc3_0.bias_b VSS sky130_fd_pr__nfet_01v8_lvt ad=0.406 pd=3.38 as=0.406 ps=3.38 w=1.4 l=0.6
X218 VDD VDD op VDD sky130_fd_pr__pfet_01v8 ad=0.406 pd=3.38 as=0.406 ps=3.38 w=1.4 l=0.6
X219 VSS VSS x2_cm_tail__cc6_0.x2_m4d VSS sky130_fd_pr__nfet_01v8 ad=0.406 pd=3.38 as=0.406 ps=3.38 w=1.4 l=0.6
X220 x2_cl_src__cc3_0.bias_b x2_cl_src__cc3_0.bias_b x2_cl_src__cc3_0.bias_b VSS sky130_fd_pr__nfet_01v8_lvt ad=0.406 pd=3.38 as=29.232 ps=243.36 w=1.4 l=0.6
X221 VSS IBIAS x2_cl_casc__cc2_0.bias_c VSS sky130_fd_pr__nfet_01v8 ad=0.406 pd=3.38 as=0.406 ps=3.38 w=1.4 l=0.6
X222 x2_cm_tail__cc6_0.x2_m3d bias_a VSS VSS sky130_fd_pr__nfet_01v8 ad=0.406 pd=3.38 as=0.406 ps=3.38 w=1.4 l=0.6
X223 x2_cl_src__cc3_0.bias_b x2_cl_src__cc3_0.bias_b x2_cl_casc__cc2_0.bias_c VSS sky130_fd_pr__nfet_01v8_lvt ad=0.406 pd=3.38 as=0.406 ps=3.38 w=1.4 l=0.6
X224 x2_cm_casc__cc6_0.bias_d x1_single_m3__f1_0.x1_m2d x1_single_m3__f1_0.x1_m2d VSS sky130_fd_pr__nfet_01v8 ad=0.406 pd=3.38 as=0.406 ps=3.38 w=1.4 l=0.6
X225 VDD VDD on VDD sky130_fd_pr__pfet_01v8 ad=0.406 pd=3.38 as=0.406 ps=3.38 w=1.4 l=0.6
X226 x2_cm_casc__cc6_0.bias_d x1_single_m3__f1_0.x1_m2d x1_single_m3__f1_0.x1_m2d VSS sky130_fd_pr__nfet_01v8 ad=0.406 pd=3.38 as=0.406 ps=3.38 w=1.4 l=0.6
X227 x2_diff__cc1_0.x2_tail bias_a VSS VSS sky130_fd_pr__nfet_01v8 ad=0.406 pd=3.38 as=0.406 ps=3.38 w=1.4 l=0.6
X228 x2_cm_casc__cc6_0.bias_d x2_cm_casc__cc6_0.bias_d x2_cm_casc__cc6_0.bias_d VSS sky130_fd_pr__nfet_01v8 ad=0.406 pd=3.38 as=0 ps=0 w=1.4 l=0.6
X229 x1_cc_cm__strings1_0.x1_net10 cm x1_cc_cm__strings1_0.x1_net11 VSS sky130_fd_pr__nfet_01v8 ad=0.406 pd=3.38 as=0.406 ps=3.38 w=1.4 l=0.6
X230 x2_cl_src__cc3_0.bias_b x2_cl_src__cc3_0.bias_b x2_cl_casc__cc2_0.bias_c VSS sky130_fd_pr__nfet_01v8_lvt ad=0.406 pd=3.38 as=0.406 ps=3.38 w=1.4 l=0.6
X231 x2_diff__cc1_0.x2_tail cmc VSS VSS sky130_fd_pr__nfet_01v8 ad=0.406 pd=3.38 as=0.406 ps=3.38 w=1.4 l=0.6
X232 VDD x2_cl_src__cc3_0.bias_b x1_cm_bias_c__cc1_0.x1_m31d VDD sky130_fd_pr__pfet_01v8_lvt ad=0.406 pd=3.38 as=0.406 ps=3.38 w=1.4 l=0.6
X233 x1_cc_cm__strings1_0.x1_net11 cm x1_cc_cm__strings1_0.x1_net12 VSS sky130_fd_pr__nfet_01v8 ad=0.406 pd=3.38 as=0.406 ps=3.38 w=1.4 l=0.6
X234 x2_cl_src__cc3_0.bias_b x2_cl_src__cc3_0.bias_b x2_cl_casc__cc2_0.bias_c VSS sky130_fd_pr__nfet_01v8_lvt ad=0.406 pd=3.38 as=0.406 ps=3.38 w=1.4 l=0.6
X235 x1_single_m3__f1_0.x1_m2d x1_single_m3__f1_0.x1_m2d x2_cm_casc__cc6_0.bias_d VSS sky130_fd_pr__nfet_01v8 ad=0.406 pd=3.38 as=0.406 ps=3.38 w=1.4 l=0.6
X236 x2_cm_tail__cc6_0.x2_m4d x2_cm_casc__cc6_0.bias_d op VSS sky130_fd_pr__nfet_01v8 ad=0.406 pd=3.38 as=0.406 ps=3.38 w=1.4 l=0.6
X237 x2_diff__cc1_0.x2_foldp x2_cl_src__cc3_0.bias_b VDD VDD sky130_fd_pr__pfet_01v8_lvt ad=0.406 pd=3.38 as=0.406 ps=3.38 w=1.4 l=0.6
X238 VDD VDD VDD VDD sky130_fd_pr__pfet_01v8 ad=0.406 pd=3.38 as=0 ps=0 w=1.4 l=0.6
X239 x2_diff__cc1_0.x2_tail cmc VSS VSS sky130_fd_pr__nfet_01v8 ad=0.406 pd=3.38 as=0.406 ps=3.38 w=1.4 l=0.6
X240 VSS cmc x2_diff__cc1_0.x2_tail VSS sky130_fd_pr__nfet_01v8 ad=0.406 pd=3.38 as=0.406 ps=3.38 w=1.4 l=0.6
X241 x1_single_m3__f1_0.x1_m2d x1_single_m3__f1_0.x1_m2d x2_cm_casc__cc6_0.bias_d VSS sky130_fd_pr__nfet_01v8 ad=0.406 pd=3.38 as=0.406 ps=3.38 w=1.4 l=0.6
X242 x2_diff__cc1_0.x2_tail x2_diff__cc1_0.x2_tail x2_diff__cc1_0.x2_tail VSS sky130_fd_pr__nfet_01v8 ad=0.406 pd=3.38 as=0 ps=0 w=1.4 l=0.6
X243 VDD x2_cl_src__cc3_0.bias_b x2_diff__cc1_0.x2_foldn VDD sky130_fd_pr__pfet_01v8_lvt ad=0.406 pd=3.38 as=0.406 ps=3.38 w=1.4 l=0.6
X244 x2_diff__cc1_0.x2_foldn x2_cl_casc__cc2_0.bias_c op VDD sky130_fd_pr__pfet_01v8 ad=0.406 pd=3.38 as=0.406 ps=3.38 w=1.4 l=0.6
X245 VSS cmc x2_diff__cc1_0.x2_tail VSS sky130_fd_pr__nfet_01v8 ad=0.406 pd=3.38 as=0.406 ps=3.38 w=1.4 l=0.6
X246 x2_diff__cc1_0.x2_tail x2_diff__cc1_0.x2_tail x2_diff__cc1_0.x2_tail VSS sky130_fd_pr__nfet_01v8 ad=0.406 pd=3.38 as=0 ps=0 w=1.4 l=0.6
X247 x2_cl_src__cc3_0.bias_b x2_cl_casc__cc2_0.bias_c x1_cm_bias_c__cc1_0.x1_m21d VDD sky130_fd_pr__pfet_01v8 ad=0.406 pd=3.38 as=0.406 ps=3.38 w=1.4 l=0.6
X248 x2_diff__cc1_0.x2_foldp x2_cl_casc__cc2_0.bias_c on VDD sky130_fd_pr__pfet_01v8 ad=0.406 pd=3.38 as=0.406 ps=3.38 w=1.4 l=0.6
X249 x2_diff__cc1_0.x2_tail cmc VSS VSS sky130_fd_pr__nfet_01v8 ad=0.406 pd=3.38 as=0.406 ps=3.38 w=1.4 l=0.6
X250 VSS cmc x2_diff__cc1_0.x2_tail VSS sky130_fd_pr__nfet_01v8 ad=0.406 pd=3.38 as=0.406 ps=3.38 w=1.4 l=0.6
X251 x1_cm_bias_c__cc1_0.x1_m21d x2_cl_casc__cc2_0.bias_c x2_cl_src__cc3_0.bias_b VDD sky130_fd_pr__pfet_01v8 ad=0.406 pd=3.38 as=0.406 ps=3.38 w=1.4 l=0.6
X252 on x2_cm_casc__cc6_0.bias_d x2_cm_tail__cc6_0.x2_m3d VSS sky130_fd_pr__nfet_01v8 ad=0.406 pd=3.38 as=0.406 ps=3.38 w=1.4 l=0.6
X253 x1_single_m3__f1_0.x1_m2d x1_single_m3__f1_0.x1_m2d x2_cm_casc__cc6_0.bias_d VSS sky130_fd_pr__nfet_01v8 ad=0.406 pd=3.38 as=0.406 ps=3.38 w=1.4 l=0.6
X254 x2_cm_tail__cc6_0.x2_m4d bias_a VSS VSS sky130_fd_pr__nfet_01v8 ad=0.406 pd=3.38 as=0.406 ps=3.38 w=1.4 l=0.6
X255 x1_cm_bias_c__cc1_0.x1_m31d x2_cl_src__cc3_0.bias_b VDD VDD sky130_fd_pr__pfet_01v8_lvt ad=0.406 pd=3.38 as=0.406 ps=3.38 w=1.4 l=0.6
X256 VSS cmc x2_diff__cc1_0.x2_tail VSS sky130_fd_pr__nfet_01v8 ad=0.406 pd=3.38 as=0.406 ps=3.38 w=1.4 l=0.6
X257 VSS IBIAS x2_cl_casc__cc2_0.bias_c VSS sky130_fd_pr__nfet_01v8 ad=0.406 pd=3.38 as=0.406 ps=3.38 w=1.4 l=0.6
X258 VSS VSS x1_single_m5__f1_0.x1_m5d VSS sky130_fd_pr__nfet_01v8 ad=0.406 pd=3.38 as=0.406 ps=3.38 w=1.4 l=0.6
X259 VDD x2_cl_src__cc3_0.bias_b x2_diff__cc1_0.x2_foldp VDD sky130_fd_pr__pfet_01v8_lvt ad=0.406 pd=3.38 as=0.406 ps=3.38 w=1.4 l=0.6
X260 x2_cm_tail__cc6_0.x2_m4d x2_cm_casc__cc6_0.bias_d op VSS sky130_fd_pr__nfet_01v8 ad=0.406 pd=3.38 as=0.406 ps=3.38 w=1.4 l=0.6
X261 x2_diff__cc1_0.x2_tail bias_a VSS VSS sky130_fd_pr__nfet_01v8 ad=0.406 pd=3.38 as=0.406 ps=3.38 w=1.4 l=0.6
X262 bias_a bias_a bias_a VSS sky130_fd_pr__nfet_01v8 ad=0.406 pd=3.38 as=11.368 ps=94.64 w=1.4 l=0.6
X263 VSS cmc x2_diff__cc1_0.x2_tail VSS sky130_fd_pr__nfet_01v8 ad=0.406 pd=3.38 as=0.406 ps=3.38 w=1.4 l=0.6
X264 VSS bias_a x2_diff__cc1_0.x2_tail VSS sky130_fd_pr__nfet_01v8 ad=0.406 pd=3.38 as=0.406 ps=3.38 w=1.4 l=0.6
X265 x2_cl_casc__cc2_0.bias_c x2_cl_src__cc3_0.bias_b x2_cl_src__cc3_0.bias_b VSS sky130_fd_pr__nfet_01v8_lvt ad=0.406 pd=3.38 as=0.406 ps=3.38 w=1.4 l=0.6
X266 VSS bias_a x2_diff__cc1_0.x2_tail VSS sky130_fd_pr__nfet_01v8 ad=0.406 pd=3.38 as=0.406 ps=3.38 w=1.4 l=0.6
X267 bias_a x2_cm_casc__cc6_0.bias_d x1_single_m5__f1_0.x1_m5d VSS sky130_fd_pr__nfet_01v8 ad=0.406 pd=3.38 as=0.406 ps=3.38 w=1.4 l=0.6
X268 x2_diff__cc1_0.x2_foldn x2_cl_src__cc3_0.bias_b VDD VDD sky130_fd_pr__pfet_01v8_lvt ad=0.406 pd=3.38 as=0.406 ps=3.38 w=1.4 l=0.6
X269 VSS IBIAS x2_cl_casc__cc2_0.bias_c VSS sky130_fd_pr__nfet_01v8 ad=0.406 pd=3.38 as=0.406 ps=3.38 w=1.4 l=0.6
X270 x2_diff__cc1_0.x2_tail bias_a VSS VSS sky130_fd_pr__nfet_01v8 ad=0.406 pd=3.38 as=0.406 ps=3.38 w=1.4 l=0.6
X271 VSS bias_a x2_diff__cc1_0.x2_tail VSS sky130_fd_pr__nfet_01v8 ad=0.406 pd=3.38 as=0.406 ps=3.38 w=1.4 l=0.6
X272 x2_cm_casc__cc6_0.bias_d x2_cm_casc__cc6_0.bias_d x2_cm_casc__cc6_0.bias_d VSS sky130_fd_pr__nfet_01v8 ad=0.406 pd=3.38 as=0 ps=0 w=1.4 l=0.6
X273 VDD x2_cl_src__cc3_0.bias_b x2_diff__cc1_0.x2_foldp VDD sky130_fd_pr__pfet_01v8_lvt ad=0.406 pd=3.38 as=0.406 ps=3.38 w=1.4 l=0.6
X274 VSS VSS x2_cm_tail__cc6_0.x2_m3d VSS sky130_fd_pr__nfet_01v8 ad=0.406 pd=3.38 as=0.406 ps=3.38 w=1.4 l=0.6
X275 VSS cmc x2_diff__cc1_0.x2_tail VSS sky130_fd_pr__nfet_01v8 ad=0.406 pd=3.38 as=0.406 ps=3.38 w=1.4 l=0.6
X276 x2_diff__cc1_0.x2_tail in x2_diff__cc1_0.x2_foldn VSS sky130_fd_pr__nfet_01v8_lvt ad=0.348 pd=2.98 as=0.348 ps=2.98 w=1.2 l=0.2
X277 x2_cl_casc__cc2_0.bias_c x2_cl_src__cc3_0.bias_b x2_cl_src__cc3_0.bias_b VSS sky130_fd_pr__nfet_01v8_lvt ad=0.406 pd=3.38 as=0.406 ps=3.38 w=1.4 l=0.6
X278 x1_single_m3__f1_0.x1_m2d x1_single_m3__f1_0.x1_m2d x2_cm_casc__cc6_0.bias_d VSS sky130_fd_pr__nfet_01v8 ad=0.406 pd=3.38 as=0.406 ps=3.38 w=1.4 l=0.6
X279 x1_cm_bias_c__cc1_0.x1_m25d x2_cl_casc__cc2_0.bias_c x1_single_m3__f1_0.x1_m2d VDD sky130_fd_pr__pfet_01v8 ad=0.406 pd=3.38 as=0.406 ps=3.38 w=1.4 l=0.6
X280 x2_cl_src__cc3_0.bias_b x2_cl_src__cc3_0.bias_b x2_cl_src__cc3_0.bias_b VSS sky130_fd_pr__nfet_01v8_lvt ad=0.406 pd=3.38 as=0 ps=0 w=1.4 l=0.6
X281 bias_a x2_cm_casc__cc6_0.bias_d x1_single_m5__f1_0.x1_m5d VSS sky130_fd_pr__nfet_01v8 ad=0.406 pd=3.38 as=0.406 ps=3.38 w=1.4 l=0.6
X282 x2_cm_tail__cc6_0.x2_m3d bias_a VSS VSS sky130_fd_pr__nfet_01v8 ad=0.406 pd=3.38 as=0.406 ps=3.38 w=1.4 l=0.6
X283 VSS VSS VSS VSS sky130_fd_pr__nfet_01v8 ad=0.406 pd=3.38 as=0 ps=0 w=1.4 l=0.6
X284 VSS bias_a x2_diff__cc1_0.x2_tail VSS sky130_fd_pr__nfet_01v8 ad=0.406 pd=3.38 as=0.406 ps=3.38 w=1.4 l=0.6
X285 x2_cl_src__cc3_0.bias_b x2_cl_src__cc3_0.bias_b x2_cl_casc__cc2_0.bias_c VSS sky130_fd_pr__nfet_01v8_lvt ad=0.406 pd=3.38 as=0.406 ps=3.38 w=1.4 l=0.6
X286 x2_cl_src__cc3_0.bias_b x2_cl_src__cc3_0.bias_b x2_cl_casc__cc2_0.bias_c VSS sky130_fd_pr__nfet_01v8_lvt ad=0.406 pd=3.38 as=0.406 ps=3.38 w=1.4 l=0.6
X287 x2_diff__cc1_0.x2_tail cmc VSS VSS sky130_fd_pr__nfet_01v8 ad=0.406 pd=3.38 as=0.406 ps=3.38 w=1.4 l=0.6
X288 x2_cl_casc__cc2_0.bias_c x2_cl_src__cc3_0.bias_b x2_cl_src__cc3_0.bias_b VSS sky130_fd_pr__nfet_01v8_lvt ad=0.406 pd=3.38 as=0.406 ps=3.38 w=1.4 l=0.6
X289 x2_diff__cc1_0.x2_tail cmc VSS VSS sky130_fd_pr__nfet_01v8 ad=0.406 pd=3.38 as=0.406 ps=3.38 w=1.4 l=0.6
X290 x2_cl_casc__cc2_0.bias_c x2_cl_casc__cc2_0.bias_c x2_cl_casc__cc2_0.bias_c VSS sky130_fd_pr__nfet_01v8_lvt ad=0.406 pd=3.38 as=0 ps=0 w=1.4 l=0.6
X291 x1_single_m3__f1_0.x1_m2d x1_single_m3__f1_0.x1_m2d x1_single_m3__f1_0.x1_m2d VSS sky130_fd_pr__nfet_01v8 ad=0.406 pd=3.38 as=21.924 ps=182.52 w=1.4 l=0.6
X292 VSS cmc x2_diff__cc1_0.x2_tail VSS sky130_fd_pr__nfet_01v8 ad=0.406 pd=3.38 as=0.406 ps=3.38 w=1.4 l=0.6
X293 x2_diff__cc1_0.x2_tail cmc VSS VSS sky130_fd_pr__nfet_01v8 ad=0.406 pd=3.38 as=0.406 ps=3.38 w=1.4 l=0.6
X294 VSS bias_a x2_diff__cc1_0.x2_tail VSS sky130_fd_pr__nfet_01v8 ad=0.406 pd=3.38 as=0.406 ps=3.38 w=1.4 l=0.6
X295 x2_cm_casc__cc6_0.bias_d x1_single_m3__f1_0.x1_m2d x1_single_m3__f1_0.x1_m2d VSS sky130_fd_pr__nfet_01v8 ad=0.406 pd=3.38 as=0.406 ps=3.38 w=1.4 l=0.6
X296 x2_cl_src__cc3_0.bias_b x2_cl_src__cc3_0.bias_b x2_cl_casc__cc2_0.bias_c VSS sky130_fd_pr__nfet_01v8_lvt ad=0.406 pd=3.38 as=0.406 ps=3.38 w=1.4 l=0.6
X297 x2_cl_casc__cc2_0.bias_c x2_cl_src__cc3_0.bias_b x2_cl_src__cc3_0.bias_b VSS sky130_fd_pr__nfet_01v8_lvt ad=0.406 pd=3.38 as=0.406 ps=3.38 w=1.4 l=0.6
X298 x2_cm_tail__cc6_0.x2_m3d x2_cm_casc__cc6_0.bias_d on VSS sky130_fd_pr__nfet_01v8 ad=0.406 pd=3.38 as=0.406 ps=3.38 w=1.4 l=0.6
X299 VDD x2_cl_src__cc3_0.bias_b x1_cm_bias_c__cc1_0.x1_m25d VDD sky130_fd_pr__pfet_01v8_lvt ad=0.406 pd=3.38 as=0.406 ps=3.38 w=1.4 l=0.6
X300 VSS cmc x2_diff__cc1_0.x2_tail VSS sky130_fd_pr__nfet_01v8 ad=0.406 pd=3.38 as=0.406 ps=3.38 w=1.4 l=0.6
X301 VSS VSS x2_cm_tail__cc6_0.x2_m3d VSS sky130_fd_pr__nfet_01v8 ad=0.406 pd=3.38 as=0.406 ps=3.38 w=1.4 l=0.6
X302 VSS bias_a x1_single_m5__f1_0.x1_m5d VSS sky130_fd_pr__nfet_01v8 ad=0.406 pd=3.38 as=0.406 ps=3.38 w=1.4 l=0.6
X303 x2_diff__cc1_0.x2_tail bias_a VSS VSS sky130_fd_pr__nfet_01v8 ad=0.406 pd=3.38 as=0.406 ps=3.38 w=1.4 l=0.6
X304 VDD x2_cl_src__cc3_0.bias_b x2_diff__cc1_0.x2_foldn VDD sky130_fd_pr__pfet_01v8_lvt ad=0.406 pd=3.38 as=0.406 ps=3.38 w=1.4 l=0.6
X305 x2_cm_casc__cc6_0.bias_d x1_single_m3__f1_0.x1_m2d x1_single_m3__f1_0.x1_m2d VSS sky130_fd_pr__nfet_01v8 ad=0.406 pd=3.38 as=0.406 ps=3.38 w=1.4 l=0.6
X306 x1_cc_cm__strings1_0.x1_net4 cm cm VSS sky130_fd_pr__nfet_01v8 ad=0.406 pd=3.38 as=0.406 ps=3.38 w=1.4 l=0.6
X307 x2_diff__cc1_0.x2_tail bias_a VSS VSS sky130_fd_pr__nfet_01v8 ad=0.406 pd=3.38 as=0.406 ps=3.38 w=1.4 l=0.6
X308 VDD VDD VDD VDD sky130_fd_pr__pfet_01v8 ad=0.406 pd=3.38 as=0 ps=0 w=1.4 l=0.6
X309 x2_cm_casc__cc6_0.bias_d x1_single_m3__f1_0.x1_m2d x1_single_m3__f1_0.x1_m2d VSS sky130_fd_pr__nfet_01v8 ad=0.406 pd=3.38 as=0.406 ps=3.38 w=1.4 l=0.6
X310 x2_diff__cc1_0.x2_foldn x2_cl_casc__cc2_0.bias_c op VDD sky130_fd_pr__pfet_01v8 ad=0.406 pd=3.38 as=0.406 ps=3.38 w=1.4 l=0.6
X311 VSS cmc x2_diff__cc1_0.x2_tail VSS sky130_fd_pr__nfet_01v8 ad=0.406 pd=3.38 as=0.406 ps=3.38 w=1.4 l=0.6
X312 x1_cm_bias_c__cc1_0.x1_m25d x1_cm_bias_c__cc1_0.x1_m25d x1_cm_bias_c__cc1_0.x1_m25d VDD sky130_fd_pr__pfet_01v8_lvt ad=0.406 pd=3.38 as=0 ps=0 w=1.4 l=0.6
X313 x2_cl_src__cc3_0.bias_b x2_cl_src__cc3_0.bias_b x2_cl_casc__cc2_0.bias_c VSS sky130_fd_pr__nfet_01v8_lvt ad=0.406 pd=3.38 as=0.406 ps=3.38 w=1.4 l=0.6
X314 VDD VDD x2_cl_src__cc3_0.bias_b VDD sky130_fd_pr__pfet_01v8 ad=0.406 pd=3.38 as=0.406 ps=3.38 w=1.4 l=0.6
X315 VSS cmc x2_diff__cc1_0.x2_tail VSS sky130_fd_pr__nfet_01v8 ad=0.406 pd=3.38 as=0.406 ps=3.38 w=1.4 l=0.6
X316 x1_cc_cm__strings1_0.x1_net12 cm VSS VSS sky130_fd_pr__nfet_01v8 ad=0.406 pd=3.38 as=0.406 ps=3.38 w=1.4 l=0.6
X317 x1_single_m3__f1_0.x1_m2d x1_single_m3__f1_0.x1_m2d x2_cm_casc__cc6_0.bias_d VSS sky130_fd_pr__nfet_01v8 ad=0.406 pd=3.38 as=0.406 ps=3.38 w=1.4 l=0.6
X318 x1_single_m3__f1_0.x1_m2d x2_cl_casc__cc2_0.bias_c x1_cm_bias_c__cc1_0.x1_m25d VDD sky130_fd_pr__pfet_01v8 ad=0.406 pd=3.38 as=0.406 ps=3.38 w=1.4 l=0.6
X319 x1_cm_bias_c__cc1_0.x1_m31d x2_cl_casc__cc2_0.bias_c cm VDD sky130_fd_pr__pfet_01v8 ad=0.406 pd=3.38 as=0.406 ps=3.38 w=1.4 l=0.6
X320 x2_diff__cc1_0.x2_foldp x2_cl_casc__cc2_0.bias_c on VDD sky130_fd_pr__pfet_01v8 ad=0.406 pd=3.38 as=0.406 ps=3.38 w=1.4 l=0.6
X321 x2_diff__cc1_0.x2_tail bias_a VSS VSS sky130_fd_pr__nfet_01v8 ad=0.406 pd=3.38 as=0.406 ps=3.38 w=1.4 l=0.6
X322 bias_a bias_a bias_a VSS sky130_fd_pr__nfet_01v8 ad=0.406 pd=3.38 as=0 ps=0 w=1.4 l=0.6
X323 x1_single_m3__f1_0.x1_m2d x1_single_m3__f1_0.x1_m2d x2_cm_casc__cc6_0.bias_d VSS sky130_fd_pr__nfet_01v8 ad=0.406 pd=3.38 as=0.406 ps=3.38 w=1.4 l=0.6
X324 x2_cl_casc__cc2_0.bias_c x2_cl_casc__cc2_0.bias_c x2_cl_casc__cc2_0.bias_c VSS sky130_fd_pr__nfet_01v8 ad=0.406 pd=3.38 as=0 ps=0 w=1.4 l=0.6
X325 VSS bias_a x2_diff__cc1_0.x2_tail VSS sky130_fd_pr__nfet_01v8 ad=0.406 pd=3.38 as=0.406 ps=3.38 w=1.4 l=0.6
X326 x2_cl_src__cc3_0.bias_b x2_cl_src__cc3_0.bias_b x2_cl_src__cc3_0.bias_b VSS sky130_fd_pr__nfet_01v8_lvt ad=0.406 pd=3.38 as=0 ps=0 w=1.4 l=0.6
X327 x2_diff__cc1_0.x2_tail bias_a VSS VSS sky130_fd_pr__nfet_01v8 ad=0.406 pd=3.38 as=0.406 ps=3.38 w=1.4 l=0.6
X328 x2_diff__cc1_0.x2_tail bias_a VSS VSS sky130_fd_pr__nfet_01v8 ad=0.406 pd=3.38 as=0.406 ps=3.38 w=1.4 l=0.6
X329 op x2_cm_casc__cc6_0.bias_d x2_cm_tail__cc6_0.x2_m4d VSS sky130_fd_pr__nfet_01v8 ad=0.406 pd=3.38 as=0.406 ps=3.38 w=1.4 l=0.6
X330 x2_cl_src__cc3_0.bias_b x2_cl_src__cc3_0.bias_b x2_cl_casc__cc2_0.bias_c VSS sky130_fd_pr__nfet_01v8_lvt ad=0.406 pd=3.38 as=0.406 ps=3.38 w=1.4 l=0.6
X331 VDD VDD VDD VDD sky130_fd_pr__pfet_01v8 ad=0.406 pd=3.38 as=0 ps=0 w=1.4 l=0.6
X332 x2_cl_casc__cc2_0.bias_c IBIAS VSS VSS sky130_fd_pr__nfet_01v8 ad=0.406 pd=3.38 as=0.406 ps=3.38 w=1.4 l=0.6
X333 x2_cm_tail__cc6_0.x2_m4d x2_cm_casc__cc6_0.bias_d op VSS sky130_fd_pr__nfet_01v8 ad=0.406 pd=3.38 as=0.406 ps=3.38 w=1.4 l=0.6
X334 VSS bias_a x2_diff__cc1_0.x2_tail VSS sky130_fd_pr__nfet_01v8 ad=0.406 pd=3.38 as=0.406 ps=3.38 w=1.4 l=0.6
X335 x2_cl_casc__cc2_0.bias_c x2_cl_src__cc3_0.bias_b x2_cl_src__cc3_0.bias_b VSS sky130_fd_pr__nfet_01v8_lvt ad=0.406 pd=3.38 as=0.406 ps=3.38 w=1.4 l=0.6
X336 x2_cl_casc__cc2_0.bias_c x2_cl_casc__cc2_0.bias_c x2_cl_casc__cc2_0.bias_c VSS sky130_fd_pr__nfet_01v8 ad=0.406 pd=3.38 as=0 ps=0 w=1.4 l=0.6
X337 VSS VSS x1_single_m5__f1_0.x1_m5d VSS sky130_fd_pr__nfet_01v8 ad=0.406 pd=3.38 as=0.406 ps=3.38 w=1.4 l=0.6
X338 bias_a x2_cm_casc__cc6_0.bias_d x1_single_m5__f1_0.x1_m5d VSS sky130_fd_pr__nfet_01v8 ad=0.406 pd=3.38 as=0.406 ps=3.38 w=1.4 l=0.6
X339 x2_diff__cc1_0.x2_tail cmc VSS VSS sky130_fd_pr__nfet_01v8 ad=0.406 pd=3.38 as=0.406 ps=3.38 w=1.4 l=0.6
X340 VSS IBIAS x2_cl_casc__cc2_0.bias_c VSS sky130_fd_pr__nfet_01v8 ad=0.406 pd=3.38 as=0.406 ps=3.38 w=1.4 l=0.6
X341 VSS bias_a x2_diff__cc1_0.x2_tail VSS sky130_fd_pr__nfet_01v8 ad=0.406 pd=3.38 as=0.406 ps=3.38 w=1.4 l=0.6
X342 VSS bias_a x2_cm_tail__cc6_0.x2_m3d VSS sky130_fd_pr__nfet_01v8 ad=0.406 pd=3.38 as=0.406 ps=3.38 w=1.4 l=0.6
X343 VSS cmc x2_diff__cc1_0.x2_tail VSS sky130_fd_pr__nfet_01v8 ad=0.406 pd=3.38 as=0.406 ps=3.38 w=1.4 l=0.6
X344 x2_cl_casc__cc2_0.bias_c IBIAS VSS VSS sky130_fd_pr__nfet_01v8 ad=0.406 pd=3.38 as=0.406 ps=3.38 w=1.4 l=0.6
X345 VSS VSS VSS VSS sky130_fd_pr__nfet_01v8 ad=0.406 pd=3.38 as=0 ps=0 w=1.4 l=0.6
X346 VSS bias_a x2_cm_tail__cc6_0.x2_m3d VSS sky130_fd_pr__nfet_01v8 ad=0.406 pd=3.38 as=0.406 ps=3.38 w=1.4 l=0.6
X347 x2_cl_casc__cc2_0.bias_c x2_cl_src__cc3_0.bias_b x2_cl_src__cc3_0.bias_b VSS sky130_fd_pr__nfet_01v8_lvt ad=0.406 pd=3.38 as=0.406 ps=3.38 w=1.4 l=0.6
X348 x2_cl_casc__cc2_0.bias_c IBIAS VSS VSS sky130_fd_pr__nfet_01v8 ad=0.406 pd=3.38 as=0.406 ps=3.38 w=1.4 l=0.6
X349 cm cm cm VSS sky130_fd_pr__nfet_01v8 ad=0.406 pd=3.38 as=8.526 ps=70.98 w=1.4 l=0.6
X350 x2_diff__cc1_0.x2_foldp x2_cl_src__cc3_0.bias_b VDD VDD sky130_fd_pr__pfet_01v8_lvt ad=0.406 pd=3.38 as=0.406 ps=3.38 w=1.4 l=0.6
X351 op x2_cl_casc__cc2_0.bias_c x2_diff__cc1_0.x2_foldn VDD sky130_fd_pr__pfet_01v8 ad=0.406 pd=3.38 as=0.406 ps=3.38 w=1.4 l=0.6
X352 x1_cc_cm__strings1_0.x1_net1 cm cm VSS sky130_fd_pr__nfet_01v8 ad=0.406 pd=3.38 as=0.406 ps=3.38 w=1.4 l=0.6
X353 VSS IBIAS x2_cl_casc__cc2_0.bias_c VSS sky130_fd_pr__nfet_01v8 ad=0.406 pd=3.38 as=0.406 ps=3.38 w=1.4 l=0.6
X354 x2_diff__cc1_0.x2_tail cmc VSS VSS sky130_fd_pr__nfet_01v8 ad=0.406 pd=3.38 as=0.406 ps=3.38 w=1.4 l=0.6
X355 bias_a x2_cm_casc__cc6_0.bias_d x1_single_m5__f1_0.x1_m5d VSS sky130_fd_pr__nfet_01v8 ad=0.406 pd=3.38 as=0.406 ps=3.38 w=1.4 l=0.6
X356 VSS bias_a x2_diff__cc1_0.x2_tail VSS sky130_fd_pr__nfet_01v8 ad=0.406 pd=3.38 as=0.406 ps=3.38 w=1.4 l=0.6
X357 x2_cm_tail__cc6_0.x2_m4d bias_a VSS VSS sky130_fd_pr__nfet_01v8 ad=0.406 pd=3.38 as=0.406 ps=3.38 w=1.4 l=0.6
X358 VSS cmc x2_diff__cc1_0.x2_tail VSS sky130_fd_pr__nfet_01v8 ad=0.406 pd=3.38 as=0.406 ps=3.38 w=1.4 l=0.6
X359 VDD x2_cl_src__cc3_0.bias_b x2_diff__cc1_0.x2_foldn VDD sky130_fd_pr__pfet_01v8_lvt ad=0.406 pd=3.38 as=0.406 ps=3.38 w=1.4 l=0.6
X360 x2_cl_casc__cc2_0.bias_c IBIAS VSS VSS sky130_fd_pr__nfet_01v8 ad=0.406 pd=3.38 as=0.406 ps=3.38 w=1.4 l=0.6
X361 x1_single_m3__f1_0.x1_m2d x1_single_m3__f1_0.x1_m2d x2_cm_casc__cc6_0.bias_d VSS sky130_fd_pr__nfet_01v8 ad=0.406 pd=3.38 as=0.406 ps=3.38 w=1.4 l=0.6
X362 VSS cmc x2_diff__cc1_0.x2_tail VSS sky130_fd_pr__nfet_01v8 ad=0.406 pd=3.38 as=0.406 ps=3.38 w=1.4 l=0.6
X363 x2_diff__cc1_0.x2_foldp x2_cl_src__cc3_0.bias_b VDD VDD sky130_fd_pr__pfet_01v8_lvt ad=0.406 pd=3.38 as=0.406 ps=3.38 w=1.4 l=0.6
X364 VDD VDD on VDD sky130_fd_pr__pfet_01v8 ad=0.406 pd=3.38 as=0.406 ps=3.38 w=1.4 l=0.6
X365 on x2_cm_casc__cc6_0.bias_d x2_cm_tail__cc6_0.x2_m3d VSS sky130_fd_pr__nfet_01v8 ad=0.406 pd=3.38 as=0.406 ps=3.38 w=1.4 l=0.6
X366 x2_diff__cc1_0.x2_tail bias_a VSS VSS sky130_fd_pr__nfet_01v8 ad=0.406 pd=3.38 as=0.406 ps=3.38 w=1.4 l=0.6
X367 VDD VDD VDD VDD sky130_fd_pr__pfet_01v8 ad=0.406 pd=3.38 as=0 ps=0 w=1.4 l=0.6
X368 op x2_cm_casc__cc6_0.bias_d x2_cm_tail__cc6_0.x2_m4d VSS sky130_fd_pr__nfet_01v8 ad=0.406 pd=3.38 as=0.406 ps=3.38 w=1.4 l=0.6
X369 VDD x2_cl_src__cc3_0.bias_b x2_diff__cc1_0.x2_foldp VDD sky130_fd_pr__pfet_01v8_lvt ad=0.406 pd=3.38 as=0.406 ps=3.38 w=1.4 l=0.6
X370 VDD VDD on VDD sky130_fd_pr__pfet_01v8 ad=0.406 pd=3.38 as=0.406 ps=3.38 w=1.4 l=0.6
X371 x2_diff__cc1_0.x2_tail bias_a VSS VSS sky130_fd_pr__nfet_01v8 ad=0.406 pd=3.38 as=0.406 ps=3.38 w=1.4 l=0.6
X372 x2_cl_src__cc3_0.bias_b x2_cl_src__cc3_0.bias_b x2_cl_src__cc3_0.bias_b VSS sky130_fd_pr__nfet_01v8_lvt ad=0.406 pd=3.38 as=0 ps=0 w=1.4 l=0.6
X373 x2_diff__cc1_0.x2_foldp ip x2_diff__cc1_0.x2_tail VSS sky130_fd_pr__nfet_01v8_lvt ad=0.348 pd=2.98 as=0.348 ps=2.98 w=1.2 l=0.2
X374 x2_cl_src__cc3_0.bias_b x2_cl_casc__cc2_0.bias_c x1_cm_bias_c__cc1_0.x1_m21d VDD sky130_fd_pr__pfet_01v8 ad=0.406 pd=3.38 as=0.406 ps=3.38 w=1.4 l=0.6
X375 x2_cl_src__cc3_0.bias_b x2_cl_src__cc3_0.bias_b x2_cl_casc__cc2_0.bias_c VSS sky130_fd_pr__nfet_01v8_lvt ad=0.406 pd=3.38 as=0.406 ps=3.38 w=1.4 l=0.6
X376 x1_single_m5__f1_0.x1_m5d bias_a VSS VSS sky130_fd_pr__nfet_01v8 ad=0.406 pd=3.38 as=0.406 ps=3.38 w=1.4 l=0.6
X377 x2_diff__cc1_0.x2_tail bias_a VSS VSS sky130_fd_pr__nfet_01v8 ad=0.406 pd=3.38 as=0.406 ps=3.38 w=1.4 l=0.6
X378 cm x2_cl_casc__cc2_0.bias_c x1_cm_bias_c__cc1_0.x1_m31d VDD sky130_fd_pr__pfet_01v8 ad=0.406 pd=3.38 as=0.406 ps=3.38 w=1.4 l=0.6
X379 x2_cm_casc__cc6_0.bias_d x1_single_m3__f1_0.x1_m2d x1_single_m3__f1_0.x1_m2d VSS sky130_fd_pr__nfet_01v8 ad=0.406 pd=3.38 as=0.406 ps=3.38 w=1.4 l=0.6
X380 VSS VSS x2_cm_tail__cc6_0.x2_m3d VSS sky130_fd_pr__nfet_01v8 ad=0.406 pd=3.38 as=0.406 ps=3.38 w=1.4 l=0.6
X381 x2_diff__cc1_0.x2_tail bias_a VSS VSS sky130_fd_pr__nfet_01v8 ad=0.406 pd=3.38 as=0.406 ps=3.38 w=1.4 l=0.6
X382 VDD x2_cl_src__cc3_0.bias_b x2_diff__cc1_0.x2_foldp VDD sky130_fd_pr__pfet_01v8_lvt ad=0.406 pd=3.38 as=0.406 ps=3.38 w=1.4 l=0.6
X383 VSS bias_a x2_diff__cc1_0.x2_tail VSS sky130_fd_pr__nfet_01v8 ad=0.406 pd=3.38 as=0.406 ps=3.38 w=1.4 l=0.6
X384 x2_diff__cc1_0.x2_tail cmc VSS VSS sky130_fd_pr__nfet_01v8 ad=0.406 pd=3.38 as=0.406 ps=3.38 w=1.4 l=0.6
X385 VSS VSS VSS VSS sky130_fd_pr__nfet_01v8 ad=0.406 pd=3.38 as=0 ps=0 w=1.4 l=0.6
X386 x2_cm_tail__cc6_0.x2_m3d x2_cm_casc__cc6_0.bias_d on VSS sky130_fd_pr__nfet_01v8 ad=0.406 pd=3.38 as=0.406 ps=3.38 w=1.4 l=0.6
X387 x2_cm_tail__cc6_0.x2_m4d x2_cm_casc__cc6_0.bias_d op VSS sky130_fd_pr__nfet_01v8 ad=0.406 pd=3.38 as=0.406 ps=3.38 w=1.4 l=0.6
X388 VSS bias_a x2_diff__cc1_0.x2_tail VSS sky130_fd_pr__nfet_01v8 ad=0.406 pd=3.38 as=0.406 ps=3.38 w=1.4 l=0.6
X389 x2_diff__cc1_0.x2_foldn x2_cl_src__cc3_0.bias_b VDD VDD sky130_fd_pr__pfet_01v8_lvt ad=0.406 pd=3.38 as=0.406 ps=3.38 w=1.4 l=0.6
X390 x2_diff__cc1_0.x2_foldp x2_cl_src__cc3_0.bias_b VDD VDD sky130_fd_pr__pfet_01v8_lvt ad=0.406 pd=3.38 as=0.406 ps=3.38 w=1.4 l=0.6
X391 x2_diff__cc1_0.x2_foldp x2_diff__cc1_0.x2_foldp x2_diff__cc1_0.x2_foldp VDD sky130_fd_pr__pfet_01v8 ad=0.406 pd=3.38 as=20.3 ps=169 w=1.4 l=0.6
X392 x2_diff__cc1_0.x2_foldn x2_cl_casc__cc2_0.bias_c op VDD sky130_fd_pr__pfet_01v8 ad=0.406 pd=3.38 as=0.406 ps=3.38 w=1.4 l=0.6
X393 VDD VDD x1_single_m3__f1_0.x1_m2d VDD sky130_fd_pr__pfet_01v8 ad=0.406 pd=3.38 as=0.406 ps=3.38 w=1.4 l=0.6
X394 VSS bias_a x2_cm_tail__cc6_0.x2_m4d VSS sky130_fd_pr__nfet_01v8 ad=0.406 pd=3.38 as=0.406 ps=3.38 w=1.4 l=0.6
X395 x2_cm_tail__cc6_0.x2_m4d bias_a VSS VSS sky130_fd_pr__nfet_01v8 ad=0.406 pd=3.38 as=0.406 ps=3.38 w=1.4 l=0.6
X396 x1_cm_bias_c__cc1_0.x1_m25d x2_cl_src__cc3_0.bias_b VDD VDD sky130_fd_pr__pfet_01v8_lvt ad=0.406 pd=3.38 as=0.406 ps=3.38 w=1.4 l=0.6
X397 x2_cl_src__cc3_0.bias_b x2_cl_src__cc3_0.bias_b x2_cl_src__cc3_0.bias_b VSS sky130_fd_pr__nfet_01v8_lvt ad=0.406 pd=3.38 as=0 ps=0 w=1.4 l=0.6
X398 VSS bias_a x2_cm_tail__cc6_0.x2_m3d VSS sky130_fd_pr__nfet_01v8 ad=0.406 pd=3.38 as=0.406 ps=3.38 w=1.4 l=0.6
X399 x1_cc_cm__strings1_0.x1_net5 cm x1_cc_cm__strings1_0.x1_net4 VSS sky130_fd_pr__nfet_01v8 ad=0.406 pd=3.38 as=0.406 ps=3.38 w=1.4 l=0.6
X400 VSS bias_a x1_single_m5__f1_0.x1_m5d VSS sky130_fd_pr__nfet_01v8 ad=0.406 pd=3.38 as=0.406 ps=3.38 w=1.4 l=0.6
X401 VSS VSS VSS VSS sky130_fd_pr__nfet_01v8 ad=0.406 pd=3.38 as=0 ps=0 w=1.4 l=0.6
X402 x2_cm_casc__cc6_0.bias_d x1_single_m3__f1_0.x1_m2d x1_single_m3__f1_0.x1_m2d VSS sky130_fd_pr__nfet_01v8 ad=0.406 pd=3.38 as=0.406 ps=3.38 w=1.4 l=0.6
X403 VSS IBIAS IBIAS VSS sky130_fd_pr__nfet_01v8 ad=0.406 pd=3.38 as=0.406 ps=3.38 w=1.4 l=0.6
X404 x2_cm_tail__cc6_0.x2_m4d bias_a VSS VSS sky130_fd_pr__nfet_01v8 ad=0.406 pd=3.38 as=0.406 ps=3.38 w=1.4 l=0.6
X405 VSS cmc x2_diff__cc1_0.x2_tail VSS sky130_fd_pr__nfet_01v8 ad=0.406 pd=3.38 as=0.406 ps=3.38 w=1.4 l=0.6
X406 x2_diff__cc1_0.x2_foldp ip x2_diff__cc1_0.x2_tail VSS sky130_fd_pr__nfet_01v8_lvt ad=0.348 pd=2.98 as=0.348 ps=2.98 w=1.2 l=0.2
X407 VSS cmc x2_diff__cc1_0.x2_tail VSS sky130_fd_pr__nfet_01v8 ad=0.406 pd=3.38 as=0.406 ps=3.38 w=1.4 l=0.6
X408 VDD x2_cl_src__cc3_0.bias_b x1_cm_bias_c__cc1_0.x1_m21d VDD sky130_fd_pr__pfet_01v8_lvt ad=0.406 pd=3.38 as=0.406 ps=3.38 w=1.4 l=0.6
X409 IBIAS IBIAS VSS VSS sky130_fd_pr__nfet_01v8 ad=0.406 pd=3.38 as=0.406 ps=3.38 w=1.4 l=0.6
X410 VSS VSS x2_cm_tail__cc6_0.x2_m4d VSS sky130_fd_pr__nfet_01v8 ad=0.406 pd=3.38 as=0.406 ps=3.38 w=1.4 l=0.6
X411 VSS VSS x2_cm_tail__cc6_0.x2_m3d VSS sky130_fd_pr__nfet_01v8 ad=0.406 pd=3.38 as=0.406 ps=3.38 w=1.4 l=0.6
X412 x2_diff__cc1_0.x2_tail cmc VSS VSS sky130_fd_pr__nfet_01v8 ad=0.406 pd=3.38 as=0.406 ps=3.38 w=1.4 l=0.6
X413 VSS IBIAS IBIAS VSS sky130_fd_pr__nfet_01v8 ad=0.406 pd=3.38 as=0.406 ps=3.38 w=1.4 l=0.6
X414 op x2_cm_casc__cc6_0.bias_d x2_cm_tail__cc6_0.x2_m4d VSS sky130_fd_pr__nfet_01v8 ad=0.406 pd=3.38 as=0.406 ps=3.38 w=1.4 l=0.6
X415 op cmc sky130_fd_pr__cap_mim_m3_1 l=4.8 w=4.8
Cmimself1 op cmc -2.601225f
X416 VSS IBIAS IBIAS VSS sky130_fd_pr__nfet_01v8 ad=0.406 pd=3.38 as=0.406 ps=3.38 w=1.4 l=0.6
X417 x2_diff__cc1_0.x2_foldn x2_cl_src__cc3_0.bias_b VDD VDD sky130_fd_pr__pfet_01v8_lvt ad=0.406 pd=3.38 as=0.406 ps=3.38 w=1.4 l=0.6
X418 IBIAS IBIAS VSS VSS sky130_fd_pr__nfet_01v8 ad=0.406 pd=3.38 as=0.406 ps=3.38 w=1.4 l=0.6
X419 x2_diff__cc1_0.x2_foldp x2_cl_casc__cc2_0.bias_c on VDD sky130_fd_pr__pfet_01v8 ad=0.406 pd=3.38 as=0.406 ps=3.38 w=1.4 l=0.6
X420 IBIAS IBIAS VSS VSS sky130_fd_pr__nfet_01v8 ad=0.406 pd=3.38 as=0.406 ps=3.38 w=1.4 l=0.6
X421 VDD x2_cl_src__cc3_0.bias_b x2_diff__cc1_0.x2_foldn VDD sky130_fd_pr__pfet_01v8_lvt ad=0.406 pd=3.38 as=0.406 ps=3.38 w=1.4 l=0.6
X422 x2_diff__cc1_0.x2_tail cmc VSS VSS sky130_fd_pr__nfet_01v8 ad=0.406 pd=3.38 as=0.406 ps=3.38 w=1.4 l=0.6
X423 VDD VDD x2_diff__cc1_0.x2_foldp VDD sky130_fd_pr__pfet_01v8 ad=0.406 pd=3.38 as=0.406 ps=3.38 w=1.4 l=0.6
X424 x2_diff__cc1_0.x2_tail ip x2_diff__cc1_0.x2_foldp VSS sky130_fd_pr__nfet_01v8_lvt ad=0.348 pd=2.98 as=0.348 ps=2.98 w=1.2 l=0.2
X425 VSS IBIAS IBIAS VSS sky130_fd_pr__nfet_01v8 ad=0.406 pd=3.38 as=0.406 ps=3.38 w=1.4 l=0.6
X426 VSS bias_a x2_cm_tail__cc6_0.x2_m4d VSS sky130_fd_pr__nfet_01v8 ad=0.406 pd=3.38 as=0.406 ps=3.38 w=1.4 l=0.6
X427 x2_diff__cc1_0.x2_tail bias_a VSS VSS sky130_fd_pr__nfet_01v8 ad=0.406 pd=3.38 as=0.406 ps=3.38 w=1.4 l=0.6
X428 x2_diff__cc1_0.x2_tail bias_a VSS VSS sky130_fd_pr__nfet_01v8 ad=0.406 pd=3.38 as=0.406 ps=3.38 w=1.4 l=0.6
X429 VSS IBIAS IBIAS VSS sky130_fd_pr__nfet_01v8 ad=0.406 pd=3.38 as=0.406 ps=3.38 w=1.4 l=0.6
X430 x1_single_m5__f1_0.x1_m5d bias_a VSS VSS sky130_fd_pr__nfet_01v8 ad=0.406 pd=3.38 as=0.406 ps=3.38 w=1.4 l=0.6
X431 x2_cm_tail__cc6_0.x2_m4d x2_cm_casc__cc6_0.bias_d op VSS sky130_fd_pr__nfet_01v8 ad=0.406 pd=3.38 as=0.406 ps=3.38 w=1.4 l=0.6
X432 x2_cm_tail__cc6_0.x2_m3d x2_cm_casc__cc6_0.bias_d on VSS sky130_fd_pr__nfet_01v8 ad=0.406 pd=3.38 as=0.406 ps=3.38 w=1.4 l=0.6
X433 VSS bias_a x2_cm_tail__cc6_0.x2_m3d VSS sky130_fd_pr__nfet_01v8 ad=0.406 pd=3.38 as=0.406 ps=3.38 w=1.4 l=0.6
X434 x2_cl_src__cc3_0.bias_b x2_cl_src__cc3_0.bias_b x2_cl_src__cc3_0.bias_b VSS sky130_fd_pr__nfet_01v8_lvt ad=0.406 pd=3.38 as=0 ps=0 w=1.4 l=0.6
X435 IBIAS IBIAS VSS VSS sky130_fd_pr__nfet_01v8 ad=0.406 pd=3.38 as=0.406 ps=3.38 w=1.4 l=0.6
X436 IBIAS IBIAS VSS VSS sky130_fd_pr__nfet_01v8 ad=0.406 pd=3.38 as=0.406 ps=3.38 w=1.4 l=0.6
X437 x2_diff__cc1_0.x2_tail bias_a VSS VSS sky130_fd_pr__nfet_01v8 ad=0.406 pd=3.38 as=0.406 ps=3.38 w=1.4 l=0.6
X438 x2_cl_src__cc3_0.bias_b x2_cl_src__cc3_0.bias_b x2_cl_casc__cc2_0.bias_c VSS sky130_fd_pr__nfet_01v8_lvt ad=0.406 pd=3.38 as=0.406 ps=3.38 w=1.4 l=0.6
X439 x2_diff__cc1_0.x2_foldp x2_diff__cc1_0.x2_foldp x2_diff__cc1_0.x2_foldp VDD sky130_fd_pr__pfet_01v8 ad=0.406 pd=3.38 as=0 ps=0 w=1.4 l=0.6
X440 x2_diff__cc1_0.x2_tail cmc VSS VSS sky130_fd_pr__nfet_01v8 ad=0.406 pd=3.38 as=0.406 ps=3.38 w=1.4 l=0.6
X441 VSS bias_a x2_cm_tail__cc6_0.x2_m4d VSS sky130_fd_pr__nfet_01v8 ad=0.406 pd=3.38 as=0.406 ps=3.38 w=1.4 l=0.6
X442 x1_cm_bias_c__cc1_0.x1_m21d x2_cl_src__cc3_0.bias_b VDD VDD sky130_fd_pr__pfet_01v8_lvt ad=0.406 pd=3.38 as=0.406 ps=3.38 w=1.4 l=0.6
X443 x2_cm_casc__cc6_0.bias_d x1_single_m3__f1_0.x1_m2d x1_single_m3__f1_0.x1_m2d VSS sky130_fd_pr__nfet_01v8 ad=0.406 pd=3.38 as=0.406 ps=3.38 w=1.4 l=0.6
X444 VSS VSS x2_cm_tail__cc6_0.x2_m4d VSS sky130_fd_pr__nfet_01v8 ad=0.406 pd=3.38 as=0.406 ps=3.38 w=1.4 l=0.6
X445 x2_cm_tail__cc6_0.x2_m3d x2_cm_casc__cc6_0.bias_d on VSS sky130_fd_pr__nfet_01v8 ad=0.406 pd=3.38 as=0.406 ps=3.38 w=1.4 l=0.6
X446 VSS IBIAS IBIAS VSS sky130_fd_pr__nfet_01v8 ad=0.406 pd=3.38 as=0.406 ps=3.38 w=1.4 l=0.6
X447 VSS bias_a x2_cm_tail__cc6_0.x2_m4d VSS sky130_fd_pr__nfet_01v8 ad=0.406 pd=3.38 as=0.406 ps=3.38 w=1.4 l=0.6
X448 x2_diff__cc1_0.x2_tail bias_a VSS VSS sky130_fd_pr__nfet_01v8 ad=0.406 pd=3.38 as=0.406 ps=3.38 w=1.4 l=0.6
X449 IBIAS IBIAS VSS VSS sky130_fd_pr__nfet_01v8 ad=0.406 pd=3.38 as=0.406 ps=3.38 w=1.4 l=0.6
X450 x2_cm_tail__cc6_0.x2_m3d bias_a VSS VSS sky130_fd_pr__nfet_01v8 ad=0.406 pd=3.38 as=0.406 ps=3.38 w=1.4 l=0.6
X451 x2_cm_tail__cc6_0.x2_m4d x2_cm_casc__cc6_0.bias_d op VSS sky130_fd_pr__nfet_01v8 ad=0.406 pd=3.38 as=0.406 ps=3.38 w=1.4 l=0.6
X452 VSS bias_a x2_diff__cc1_0.x2_tail VSS sky130_fd_pr__nfet_01v8 ad=0.406 pd=3.38 as=0.406 ps=3.38 w=1.4 l=0.6
X453 x2_cl_src__cc3_0.bias_b x2_cl_casc__cc2_0.bias_c x1_cm_bias_c__cc1_0.x1_m21d VDD sky130_fd_pr__pfet_01v8 ad=0.406 pd=3.38 as=0.406 ps=3.38 w=1.4 l=0.6
X454 x2_cl_casc__cc2_0.bias_c x2_cl_casc__cc2_0.bias_c x2_cl_casc__cc2_0.bias_c VSS sky130_fd_pr__nfet_01v8_lvt ad=0.406 pd=3.38 as=0 ps=0 w=1.4 l=0.6
X455 on x2_cm_casc__cc6_0.bias_d x2_cm_tail__cc6_0.x2_m3d VSS sky130_fd_pr__nfet_01v8 ad=0.406 pd=3.38 as=0.406 ps=3.38 w=1.4 l=0.6
X456 on x2_cl_casc__cc2_0.bias_c x2_diff__cc1_0.x2_foldp VDD sky130_fd_pr__pfet_01v8 ad=0.406 pd=3.38 as=0.406 ps=3.38 w=1.4 l=0.6
X457 VSS bias_a x2_cm_tail__cc6_0.x2_m3d VSS sky130_fd_pr__nfet_01v8 ad=0.406 pd=3.38 as=0.406 ps=3.38 w=1.4 l=0.6
X458 VSS bias_a x2_diff__cc1_0.x2_tail VSS sky130_fd_pr__nfet_01v8 ad=0.406 pd=3.38 as=0.406 ps=3.38 w=1.4 l=0.6
X459 x2_cm_tail__cc6_0.x2_m3d bias_a VSS VSS sky130_fd_pr__nfet_01v8 ad=0.406 pd=3.38 as=0.406 ps=3.38 w=1.4 l=0.6
X460 op x2_cm_casc__cc6_0.bias_d x2_cm_tail__cc6_0.x2_m4d VSS sky130_fd_pr__nfet_01v8 ad=0.406 pd=3.38 as=0.406 ps=3.38 w=1.4 l=0.6
X461 x1_single_m5__f1_0.x1_m5d bias_a VSS VSS sky130_fd_pr__nfet_01v8 ad=0.406 pd=3.38 as=0.406 ps=3.38 w=1.4 l=0.6
X462 x2_cm_tail__cc6_0.x2_m4d bias_a VSS VSS sky130_fd_pr__nfet_01v8 ad=0.406 pd=3.38 as=0.406 ps=3.38 w=1.4 l=0.6
X463 VSS cmc x2_diff__cc1_0.x2_tail VSS sky130_fd_pr__nfet_01v8 ad=0.406 pd=3.38 as=0.406 ps=3.38 w=1.4 l=0.6
X464 x1_single_m5__f1_0.x1_m5d bias_a VSS VSS sky130_fd_pr__nfet_01v8 ad=0.406 pd=3.38 as=0.406 ps=3.38 w=1.4 l=0.6
X465 VSS VSS x2_cm_tail__cc6_0.x2_m4d VSS sky130_fd_pr__nfet_01v8 ad=0.406 pd=3.38 as=0.406 ps=3.38 w=1.4 l=0.6
X466 x2_diff__cc1_0.x2_foldp x2_cl_casc__cc2_0.bias_c on VDD sky130_fd_pr__pfet_01v8 ad=0.406 pd=3.38 as=0.406 ps=3.38 w=1.4 l=0.6
X467 x2_diff__cc1_0.x2_tail cmc VSS VSS sky130_fd_pr__nfet_01v8 ad=0.406 pd=3.38 as=0.406 ps=3.38 w=1.4 l=0.6
X468 VSS cmc x2_diff__cc1_0.x2_tail VSS sky130_fd_pr__nfet_01v8 ad=0.406 pd=3.38 as=0.406 ps=3.38 w=1.4 l=0.6
X469 VSS VSS VSS VSS sky130_fd_pr__nfet_01v8 ad=0.406 pd=3.38 as=0 ps=0 w=1.4 l=0.6
X470 x2_cm_casc__cc6_0.bias_d x1_single_m3__f1_0.x1_m2d x1_single_m3__f1_0.x1_m2d VSS sky130_fd_pr__nfet_01v8 ad=0.406 pd=3.38 as=0.406 ps=3.38 w=1.4 l=0.6
X471 x2_diff__cc1_0.x2_tail bias_a VSS VSS sky130_fd_pr__nfet_01v8 ad=0.406 pd=3.38 as=0.406 ps=3.38 w=1.4 l=0.6
X472 x2_diff__cc1_0.x2_tail bias_a VSS VSS sky130_fd_pr__nfet_01v8 ad=0.406 pd=3.38 as=0.406 ps=3.38 w=1.4 l=0.6
X473 x2_cm_tail__cc6_0.x2_m4d bias_a VSS VSS sky130_fd_pr__nfet_01v8 ad=0.406 pd=3.38 as=0.406 ps=3.38 w=1.4 l=0.6
X474 VSS VSS on VSS sky130_fd_pr__nfet_01v8 ad=0.406 pd=3.38 as=0.406 ps=3.38 w=1.4 l=0.6
X475 x2_diff__cc1_0.x2_foldp x2_cl_src__cc3_0.bias_b VDD VDD sky130_fd_pr__pfet_01v8_lvt ad=0.406 pd=3.38 as=0.406 ps=3.38 w=1.4 l=0.6
X476 x1_cm_bias_c__cc1_0.x1_m31d x1_cm_bias_c__cc1_0.x1_m31d x1_cm_bias_c__cc1_0.x1_m31d VDD sky130_fd_pr__pfet_01v8_lvt ad=0.406 pd=3.38 as=0 ps=0 w=1.4 l=0.6
X477 VSS VSS VSS VSS sky130_fd_pr__nfet_01v8 ad=0.406 pd=3.38 as=0 ps=0 w=1.4 l=0.6
X478 x2_diff__cc1_0.x2_tail cmc VSS VSS sky130_fd_pr__nfet_01v8 ad=0.406 pd=3.38 as=0.406 ps=3.38 w=1.4 l=0.6
X479 VSS bias_a x2_diff__cc1_0.x2_tail VSS sky130_fd_pr__nfet_01v8 ad=0.406 pd=3.38 as=0.406 ps=3.38 w=1.4 l=0.6
X480 x2_diff__cc1_0.x2_tail cmc VSS VSS sky130_fd_pr__nfet_01v8 ad=0.406 pd=3.38 as=0.406 ps=3.38 w=1.4 l=0.6
X481 VSS bias_a x2_cm_tail__cc6_0.x2_m4d VSS sky130_fd_pr__nfet_01v8 ad=0.406 pd=3.38 as=0.406 ps=3.38 w=1.4 l=0.6
X482 VSS VSS VSS VSS sky130_fd_pr__nfet_01v8 ad=0.406 pd=3.38 as=0 ps=0 w=1.4 l=0.6
X483 VSS bias_a x1_single_m5__f1_0.x1_m5d VSS sky130_fd_pr__nfet_01v8 ad=0.406 pd=3.38 as=0.406 ps=3.38 w=1.4 l=0.6
X484 x2_cl_src__cc3_0.bias_b x2_cl_src__cc3_0.bias_b x2_cl_src__cc3_0.bias_b VSS sky130_fd_pr__nfet_01v8_lvt ad=0.406 pd=3.38 as=0 ps=0 w=1.4 l=0.6
X485 x2_cl_casc__cc2_0.bias_c IBIAS VSS VSS sky130_fd_pr__nfet_01v8 ad=0.406 pd=3.38 as=0.406 ps=3.38 w=1.4 l=0.6
X486 x1_cc_cm__strings1_0.x1_net6 cm VSS VSS sky130_fd_pr__nfet_01v8 ad=0.406 pd=3.38 as=0.406 ps=3.38 w=1.4 l=0.6
X487 x1_single_m5__f1_0.x1_m5d x1_single_m5__f1_0.x1_m5d x1_single_m5__f1_0.x1_m5d VSS sky130_fd_pr__nfet_01v8 ad=0.406 pd=3.38 as=21.924 ps=182.52 w=1.4 l=0.6
X488 x2_cm_tail__cc6_0.x2_m3d bias_a VSS VSS sky130_fd_pr__nfet_01v8 ad=0.406 pd=3.38 as=0.406 ps=3.38 w=1.4 l=0.6
X489 x2_cl_src__cc3_0.bias_b x2_cl_src__cc3_0.bias_b x2_cl_casc__cc2_0.bias_c VSS sky130_fd_pr__nfet_01v8_lvt ad=0.406 pd=3.38 as=0.406 ps=3.38 w=1.4 l=0.6
X490 x1_single_m3__f1_0.x1_m2d x1_single_m3__f1_0.x1_m2d x2_cm_casc__cc6_0.bias_d VSS sky130_fd_pr__nfet_01v8 ad=0.406 pd=3.38 as=0.406 ps=3.38 w=1.4 l=0.6
X491 VSS bias_a x2_cm_tail__cc6_0.x2_m4d VSS sky130_fd_pr__nfet_01v8 ad=0.406 pd=3.38 as=0.406 ps=3.38 w=1.4 l=0.6
X492 x1_single_m3__f1_0.x1_m2d x1_single_m3__f1_0.x1_m2d x2_cm_casc__cc6_0.bias_d VSS sky130_fd_pr__nfet_01v8 ad=0.406 pd=3.38 as=0.406 ps=3.38 w=1.4 l=0.6
X493 x2_diff__cc1_0.x2_tail x2_diff__cc1_0.x2_tail x2_diff__cc1_0.x2_tail VSS sky130_fd_pr__nfet_01v8 ad=0.406 pd=3.38 as=0 ps=0 w=1.4 l=0.6
X494 x2_diff__cc1_0.x2_tail x2_diff__cc1_0.x2_tail x2_diff__cc1_0.x2_tail VSS sky130_fd_pr__nfet_01v8 ad=0.406 pd=3.38 as=0 ps=0 w=1.4 l=0.6
X495 x2_cm_tail__cc6_0.x2_m3d bias_a VSS VSS sky130_fd_pr__nfet_01v8 ad=0.406 pd=3.38 as=0.406 ps=3.38 w=1.4 l=0.6
X496 VSS bias_a x2_cm_tail__cc6_0.x2_m4d VSS sky130_fd_pr__nfet_01v8 ad=0.406 pd=3.38 as=0.406 ps=3.38 w=1.4 l=0.6
X497 VSS IBIAS x2_cl_casc__cc2_0.bias_c VSS sky130_fd_pr__nfet_01v8 ad=0.406 pd=3.38 as=0.406 ps=3.38 w=1.4 l=0.6
X498 VSS VSS op VSS sky130_fd_pr__nfet_01v8 ad=0.406 pd=3.38 as=0.406 ps=3.38 w=1.4 l=0.6
X499 x2_cl_casc__cc2_0.bias_c IBIAS VSS VSS sky130_fd_pr__nfet_01v8 ad=0.406 pd=3.38 as=0.406 ps=3.38 w=1.4 l=0.6
X500 x1_single_m5__f1_0.x1_m5d x2_cm_casc__cc6_0.bias_d bias_a VSS sky130_fd_pr__nfet_01v8 ad=0.406 pd=3.38 as=0.406 ps=3.38 w=1.4 l=0.6
X501 x1_single_m3__f1_0.x1_m2d x1_single_m3__f1_0.x1_m2d x2_cm_casc__cc6_0.bias_d VSS sky130_fd_pr__nfet_01v8 ad=0.406 pd=3.38 as=0.406 ps=3.38 w=1.4 l=0.6
X502 on x2_cm_casc__cc6_0.bias_d x2_cm_tail__cc6_0.x2_m3d VSS sky130_fd_pr__nfet_01v8 ad=0.406 pd=3.38 as=0.406 ps=3.38 w=1.4 l=0.6
X503 x2_diff__cc1_0.x2_foldp x2_cl_src__cc3_0.bias_b VDD VDD sky130_fd_pr__pfet_01v8_lvt ad=0.406 pd=3.38 as=0.406 ps=3.38 w=1.4 l=0.6
X504 x2_diff__cc1_0.x2_tail cmc VSS VSS sky130_fd_pr__nfet_01v8 ad=0.406 pd=3.38 as=0.406 ps=3.38 w=1.4 l=0.6
X505 op x2_cm_casc__cc6_0.bias_d x2_cm_tail__cc6_0.x2_m4d VSS sky130_fd_pr__nfet_01v8 ad=0.406 pd=3.38 as=0.406 ps=3.38 w=1.4 l=0.6
X506 VSS IBIAS x2_cl_casc__cc2_0.bias_c VSS sky130_fd_pr__nfet_01v8 ad=0.406 pd=3.38 as=0.406 ps=3.38 w=1.4 l=0.6
X507 bias_a x2_cm_casc__cc6_0.bias_d x1_single_m5__f1_0.x1_m5d VSS sky130_fd_pr__nfet_01v8 ad=0.406 pd=3.38 as=0.406 ps=3.38 w=1.4 l=0.6
X508 on x2_cl_casc__cc2_0.bias_c x2_diff__cc1_0.x2_foldp VDD sky130_fd_pr__pfet_01v8 ad=0.406 pd=3.38 as=0.406 ps=3.38 w=1.4 l=0.6
X509 VDD VDD VDD VDD sky130_fd_pr__pfet_01v8_lvt ad=0.406 pd=3.38 as=0 ps=0 w=1.4 l=0.6
X510 x1_cm_bias_c__cc1_0.x1_m25d x2_cl_src__cc3_0.bias_b VDD VDD sky130_fd_pr__pfet_01v8_lvt ad=0.406 pd=3.38 as=0.406 ps=3.38 w=1.4 l=0.6
X511 x2_cm_casc__cc6_0.bias_d x1_single_m3__f1_0.x1_m2d x1_single_m3__f1_0.x1_m2d VSS sky130_fd_pr__nfet_01v8 ad=0.406 pd=3.38 as=0.406 ps=3.38 w=1.4 l=0.6
X512 VDD VDD VDD VDD sky130_fd_pr__pfet_01v8 ad=0.406 pd=3.38 as=0 ps=0 w=1.4 l=0.6
X513 VDD VDD on VDD sky130_fd_pr__pfet_01v8 ad=0.406 pd=3.38 as=0.406 ps=3.38 w=1.4 l=0.6
X514 x2_diff__cc1_0.x2_tail cmc VSS VSS sky130_fd_pr__nfet_01v8 ad=0.406 pd=3.38 as=0.406 ps=3.38 w=1.4 l=0.6
X515 op x2_cl_casc__cc2_0.bias_c x2_diff__cc1_0.x2_foldn VDD sky130_fd_pr__pfet_01v8 ad=0.406 pd=3.38 as=0.406 ps=3.38 w=1.4 l=0.6
X516 x2_cm_tail__cc6_0.x2_m3d x2_cm_casc__cc6_0.bias_d on VSS sky130_fd_pr__nfet_01v8 ad=0.406 pd=3.38 as=0.406 ps=3.38 w=1.4 l=0.6
X517 VSS cmc x2_diff__cc1_0.x2_tail VSS sky130_fd_pr__nfet_01v8 ad=0.406 pd=3.38 as=0.406 ps=3.38 w=1.4 l=0.6
X518 VDD VDD cm VDD sky130_fd_pr__pfet_01v8 ad=0.406 pd=3.38 as=0.406 ps=3.38 w=1.4 l=0.6
X519 VSS VSS VSS VSS sky130_fd_pr__nfet_01v8 ad=0.406 pd=3.38 as=0 ps=0 w=1.4 l=0.6
X520 x2_cm_casc__cc6_0.bias_d x2_cm_casc__cc6_0.bias_d x2_cm_casc__cc6_0.bias_d VSS sky130_fd_pr__nfet_01v8 ad=0.406 pd=3.38 as=0 ps=0 w=1.4 l=0.6
X521 x1_single_m3__f1_0.x1_m2d x2_cl_casc__cc2_0.bias_c x1_cm_bias_c__cc1_0.x1_m25d VDD sky130_fd_pr__pfet_01v8 ad=0.406 pd=3.38 as=0.406 ps=3.38 w=1.4 l=0.6
X522 VSS bias_a x2_diff__cc1_0.x2_tail VSS sky130_fd_pr__nfet_01v8 ad=0.406 pd=3.38 as=0.406 ps=3.38 w=1.4 l=0.6
X523 x2_diff__cc1_0.x2_tail cmc VSS VSS sky130_fd_pr__nfet_01v8 ad=0.406 pd=3.38 as=0.406 ps=3.38 w=1.4 l=0.6
X524 VSS cm x1_cc_cm__strings1_0.x1_net3 VSS sky130_fd_pr__nfet_01v8 ad=0.406 pd=3.38 as=0.406 ps=3.38 w=1.4 l=0.6
X525 x2_diff__cc1_0.x2_tail bias_a VSS VSS sky130_fd_pr__nfet_01v8 ad=0.406 pd=3.38 as=0.406 ps=3.38 w=1.4 l=0.6
X526 VSS VSS x2_cm_tail__cc6_0.x2_m3d VSS sky130_fd_pr__nfet_01v8 ad=0.406 pd=3.38 as=0.406 ps=3.38 w=1.4 l=0.6
X527 VSS cmc x2_diff__cc1_0.x2_tail VSS sky130_fd_pr__nfet_01v8 ad=0.406 pd=3.38 as=0.406 ps=3.38 w=1.4 l=0.6
X528 VSS cmc x2_diff__cc1_0.x2_tail VSS sky130_fd_pr__nfet_01v8 ad=0.406 pd=3.38 as=0.406 ps=3.38 w=1.4 l=0.6
X529 x2_diff__cc1_0.x2_tail cmc VSS VSS sky130_fd_pr__nfet_01v8 ad=0.406 pd=3.38 as=0.406 ps=3.38 w=1.4 l=0.6
X530 cm cm cm VSS sky130_fd_pr__nfet_01v8 ad=0.406 pd=3.38 as=0 ps=0 w=1.4 l=0.6
X531 x2_cm_tail__cc6_0.x2_m4d bias_a VSS VSS sky130_fd_pr__nfet_01v8 ad=0.406 pd=3.38 as=0.406 ps=3.38 w=1.4 l=0.6
X532 VSS bias_a x2_cm_tail__cc6_0.x2_m4d VSS sky130_fd_pr__nfet_01v8 ad=0.406 pd=3.38 as=0.406 ps=3.38 w=1.4 l=0.6
X533 VDD x2_cl_src__cc3_0.bias_b x2_diff__cc1_0.x2_foldp VDD sky130_fd_pr__pfet_01v8_lvt ad=0.406 pd=3.38 as=0.406 ps=3.38 w=1.4 l=0.6
X534 VDD VDD op VDD sky130_fd_pr__pfet_01v8 ad=0.406 pd=3.38 as=0.406 ps=3.38 w=1.4 l=0.6
X535 op x2_cl_casc__cc2_0.bias_c x2_diff__cc1_0.x2_foldn VDD sky130_fd_pr__pfet_01v8 ad=0.406 pd=3.38 as=0.406 ps=3.38 w=1.4 l=0.6
X536 on x2_cm_casc__cc6_0.bias_d x2_cm_tail__cc6_0.x2_m3d VSS sky130_fd_pr__nfet_01v8 ad=0.406 pd=3.38 as=0.406 ps=3.38 w=1.4 l=0.6
X537 x2_cl_src__cc3_0.bias_b x2_cl_src__cc3_0.bias_b x2_cl_src__cc3_0.bias_b VSS sky130_fd_pr__nfet_01v8_lvt ad=0.406 pd=3.38 as=0 ps=0 w=1.4 l=0.6
X538 VSS VSS VSS VSS sky130_fd_pr__nfet_01v8 ad=0.406 pd=3.38 as=0 ps=0 w=1.4 l=0.6
X539 bias_a bias_a bias_a VSS sky130_fd_pr__nfet_01v8 ad=0.406 pd=3.38 as=0 ps=0 w=1.4 l=0.6
X540 VSS bias_a x2_diff__cc1_0.x2_tail VSS sky130_fd_pr__nfet_01v8 ad=0.406 pd=3.38 as=0.406 ps=3.38 w=1.4 l=0.6
X541 x2_cm_tail__cc6_0.x2_m3d bias_a VSS VSS sky130_fd_pr__nfet_01v8 ad=0.406 pd=3.38 as=0.406 ps=3.38 w=1.4 l=0.6
X542 VDD x2_cl_src__cc3_0.bias_b x2_diff__cc1_0.x2_foldn VDD sky130_fd_pr__pfet_01v8_lvt ad=0.406 pd=3.38 as=0.406 ps=3.38 w=1.4 l=0.6
X543 VSS VSS VSS VSS sky130_fd_pr__nfet_01v8 ad=0.406 pd=3.38 as=0 ps=0 w=1.4 l=0.6
X544 x1_single_m5__f1_0.x1_m5d bias_a VSS VSS sky130_fd_pr__nfet_01v8 ad=0.406 pd=3.38 as=0.406 ps=3.38 w=1.4 l=0.6
X545 x2_cm_casc__cc6_0.bias_d x1_single_m3__f1_0.x1_m2d x1_single_m3__f1_0.x1_m2d VSS sky130_fd_pr__nfet_01v8 ad=0.406 pd=3.38 as=0.406 ps=3.38 w=1.4 l=0.6
X546 VDD x2_cl_src__cc3_0.bias_b x1_cm_bias_c__cc1_0.x1_m31d VDD sky130_fd_pr__pfet_01v8_lvt ad=0.406 pd=3.38 as=0.406 ps=3.38 w=1.4 l=0.6
X547 VDD VDD VDD VDD sky130_fd_pr__pfet_01v8_lvt ad=0.406 pd=3.38 as=0 ps=0 w=1.4 l=0.6
X548 VSS VSS x1_single_m5__f1_0.x1_m5d VSS sky130_fd_pr__nfet_01v8 ad=0.406 pd=3.38 as=0.406 ps=3.38 w=1.4 l=0.6
X549 VSS VSS VSS VSS sky130_fd_pr__nfet_01v8 ad=0.406 pd=3.38 as=0 ps=0 w=1.4 l=0.6
X550 x2_diff__cc1_0.x2_tail cmc VSS VSS sky130_fd_pr__nfet_01v8 ad=0.406 pd=3.38 as=0.406 ps=3.38 w=1.4 l=0.6
X551 x2_diff__cc1_0.x2_foldp x2_cl_src__cc3_0.bias_b VDD VDD sky130_fd_pr__pfet_01v8_lvt ad=0.406 pd=3.38 as=0.406 ps=3.38 w=1.4 l=0.6
X552 x2_diff__cc1_0.x2_foldp x2_cl_casc__cc2_0.bias_c on VDD sky130_fd_pr__pfet_01v8 ad=0.406 pd=3.38 as=0.406 ps=3.38 w=1.4 l=0.6
X553 x2_cm_tail__cc6_0.x2_m3d bias_a VSS VSS sky130_fd_pr__nfet_01v8 ad=0.406 pd=3.38 as=0.406 ps=3.38 w=1.4 l=0.6
X554 VSS cmc x2_diff__cc1_0.x2_tail VSS sky130_fd_pr__nfet_01v8 ad=0.406 pd=3.38 as=0.406 ps=3.38 w=1.4 l=0.6
X555 x2_diff__cc1_0.x2_foldn in x2_diff__cc1_0.x2_tail VSS sky130_fd_pr__nfet_01v8_lvt ad=0.348 pd=2.98 as=0.348 ps=2.98 w=1.2 l=0.2
X556 cm cm cm VSS sky130_fd_pr__nfet_01v8 ad=0.406 pd=3.38 as=0 ps=0 w=1.4 l=0.6
X557 x2_diff__cc1_0.x2_tail cmc VSS VSS sky130_fd_pr__nfet_01v8 ad=0.406 pd=3.38 as=0.406 ps=3.38 w=1.4 l=0.6
X558 VSS cmc x2_diff__cc1_0.x2_tail VSS sky130_fd_pr__nfet_01v8 ad=0.406 pd=3.38 as=0.406 ps=3.38 w=1.4 l=0.6
X559 VDD x2_cl_src__cc3_0.bias_b x2_diff__cc1_0.x2_foldn VDD sky130_fd_pr__pfet_01v8_lvt ad=0.406 pd=3.38 as=0.406 ps=3.38 w=1.4 l=0.6
X560 x2_diff__cc1_0.x2_tail cmc VSS VSS sky130_fd_pr__nfet_01v8 ad=0.406 pd=3.38 as=0.406 ps=3.38 w=1.4 l=0.6
X561 VSS bias_a x2_diff__cc1_0.x2_tail VSS sky130_fd_pr__nfet_01v8 ad=0.406 pd=3.38 as=0.406 ps=3.38 w=1.4 l=0.6
X562 bias_a x2_cm_casc__cc6_0.bias_d x1_single_m5__f1_0.x1_m5d VSS sky130_fd_pr__nfet_01v8 ad=0.406 pd=3.38 as=0.406 ps=3.38 w=1.4 l=0.6
X563 cm cm x1_cc_cm__strings1_0.x1_net7 VSS sky130_fd_pr__nfet_01v8 ad=0.406 pd=3.38 as=0.406 ps=3.38 w=1.4 l=0.6
X564 x1_single_m5__f1_0.x1_m5d x1_single_m5__f1_0.x1_m5d x1_single_m5__f1_0.x1_m5d VSS sky130_fd_pr__nfet_01v8 ad=0.406 pd=3.38 as=0 ps=0 w=1.4 l=0.6
X565 on cmc sky130_fd_pr__cap_mim_m3_1 l=4.8 w=4.8
Cmimself2 on cmc -2.601225f
X566 x1_single_m3__f1_0.x1_m2d x1_single_m3__f1_0.x1_m2d x2_cm_casc__cc6_0.bias_d VSS sky130_fd_pr__nfet_01v8 ad=0.406 pd=3.38 as=0.406 ps=3.38 w=1.4 l=0.6
X567 x1_single_m5__f1_0.x1_m5d x1_single_m5__f1_0.x1_m5d x1_single_m5__f1_0.x1_m5d VSS sky130_fd_pr__nfet_01v8 ad=0.406 pd=3.38 as=0 ps=0 w=1.4 l=0.6
X568 VDD x2_cl_src__cc3_0.bias_b x2_diff__cc1_0.x2_foldp VDD sky130_fd_pr__pfet_01v8_lvt ad=0.406 pd=3.38 as=0.406 ps=3.38 w=1.4 l=0.6
X569 VSS VSS x2_cm_tail__cc6_0.x2_m4d VSS sky130_fd_pr__nfet_01v8 ad=0.406 pd=3.38 as=0.406 ps=3.38 w=1.4 l=0.6
X570 VSS cmc x2_diff__cc1_0.x2_tail VSS sky130_fd_pr__nfet_01v8 ad=0.406 pd=3.38 as=0.406 ps=3.38 w=1.4 l=0.6
X571 x1_single_m5__f1_0.x1_m5d bias_a VSS VSS sky130_fd_pr__nfet_01v8 ad=0.406 pd=3.38 as=0.406 ps=3.38 w=1.4 l=0.6
X572 on x2_cm_casc__cc6_0.bias_d x2_cm_tail__cc6_0.x2_m3d VSS sky130_fd_pr__nfet_01v8 ad=0.406 pd=3.38 as=0.406 ps=3.38 w=1.4 l=0.6
X573 VSS bias_a x2_diff__cc1_0.x2_tail VSS sky130_fd_pr__nfet_01v8 ad=0.406 pd=3.38 as=0.406 ps=3.38 w=1.4 l=0.6
X574 x2_diff__cc1_0.x2_tail bias_a VSS VSS sky130_fd_pr__nfet_01v8 ad=0.406 pd=3.38 as=0.406 ps=3.38 w=1.4 l=0.6
X575 op x2_cm_casc__cc6_0.bias_d x2_cm_tail__cc6_0.x2_m4d VSS sky130_fd_pr__nfet_01v8 ad=0.406 pd=3.38 as=0.406 ps=3.38 w=1.4 l=0.6
X576 x1_cm_bias_c__cc1_0.x1_m31d x2_cl_src__cc3_0.bias_b VDD VDD sky130_fd_pr__pfet_01v8_lvt ad=0.406 pd=3.38 as=0.406 ps=3.38 w=1.4 l=0.6
X577 VDD VDD VDD VDD sky130_fd_pr__pfet_01v8_lvt ad=0.406 pd=3.38 as=0 ps=0 w=1.4 l=0.6
X578 x1_single_m5__f1_0.x1_m5d x2_cm_casc__cc6_0.bias_d bias_a VSS sky130_fd_pr__nfet_01v8 ad=0.406 pd=3.38 as=0.406 ps=3.38 w=1.4 l=0.6
X579 x2_diff__cc1_0.x2_tail bias_a VSS VSS sky130_fd_pr__nfet_01v8 ad=0.406 pd=3.38 as=0.406 ps=3.38 w=1.4 l=0.6
X580 on x2_cm_casc__cc6_0.bias_d x2_cm_tail__cc6_0.x2_m3d VSS sky130_fd_pr__nfet_01v8 ad=0.406 pd=3.38 as=0.406 ps=3.38 w=1.4 l=0.6
X581 VDD x2_cl_src__cc3_0.bias_b x2_diff__cc1_0.x2_foldp VDD sky130_fd_pr__pfet_01v8_lvt ad=0.406 pd=3.38 as=0.406 ps=3.38 w=1.4 l=0.6
X582 VSS bias_a x2_diff__cc1_0.x2_tail VSS sky130_fd_pr__nfet_01v8 ad=0.406 pd=3.38 as=0.406 ps=3.38 w=1.4 l=0.6
X583 on x2_cl_casc__cc2_0.bias_c x2_diff__cc1_0.x2_foldp VDD sky130_fd_pr__pfet_01v8 ad=0.406 pd=3.38 as=0.406 ps=3.38 w=1.4 l=0.6
X584 x1_cm_bias_c__cc1_0.x1_m21d x2_cl_casc__cc2_0.bias_c x2_cl_src__cc3_0.bias_b VDD sky130_fd_pr__pfet_01v8 ad=0.406 pd=3.38 as=0.406 ps=3.38 w=1.4 l=0.6
X585 x2_cm_casc__cc6_0.bias_d x1_single_m3__f1_0.x1_m2d x1_single_m3__f1_0.x1_m2d VSS sky130_fd_pr__nfet_01v8 ad=0.406 pd=3.38 as=0.406 ps=3.38 w=1.4 l=0.6
X586 x2_diff__cc1_0.x2_tail bias_a VSS VSS sky130_fd_pr__nfet_01v8 ad=0.406 pd=3.38 as=0.406 ps=3.38 w=1.4 l=0.6
X587 x2_diff__cc1_0.x2_foldn in x2_diff__cc1_0.x2_tail VSS sky130_fd_pr__nfet_01v8_lvt ad=0.348 pd=2.98 as=0.348 ps=2.98 w=1.2 l=0.2
X588 x2_cm_tail__cc6_0.x2_m4d x2_cm_casc__cc6_0.bias_d op VSS sky130_fd_pr__nfet_01v8 ad=0.406 pd=3.38 as=0.406 ps=3.38 w=1.4 l=0.6
X589 x2_cm_casc__cc6_0.bias_d x1_single_m3__f1_0.x1_m2d x1_single_m3__f1_0.x1_m2d VSS sky130_fd_pr__nfet_01v8 ad=0.406 pd=3.38 as=0.406 ps=3.38 w=1.4 l=0.6
X590 VDD x2_cl_src__cc3_0.bias_b x2_diff__cc1_0.x2_foldp VDD sky130_fd_pr__pfet_01v8_lvt ad=0.406 pd=3.38 as=0.406 ps=3.38 w=1.4 l=0.6
X591 VDD x2_cl_src__cc3_0.bias_b x1_cm_bias_c__cc1_0.x1_m21d VDD sky130_fd_pr__pfet_01v8_lvt ad=0.406 pd=3.38 as=0.406 ps=3.38 w=1.4 l=0.6
X592 op x2_cm_casc__cc6_0.bias_d x2_cm_tail__cc6_0.x2_m4d VSS sky130_fd_pr__nfet_01v8 ad=0.406 pd=3.38 as=0.406 ps=3.38 w=1.4 l=0.6
X593 VSS cmc x2_diff__cc1_0.x2_tail VSS sky130_fd_pr__nfet_01v8 ad=0.406 pd=3.38 as=0.406 ps=3.38 w=1.4 l=0.6
X594 VSS bias_a x2_diff__cc1_0.x2_tail VSS sky130_fd_pr__nfet_01v8 ad=0.406 pd=3.38 as=0.406 ps=3.38 w=1.4 l=0.6
X595 x2_diff__cc1_0.x2_tail cmc VSS VSS sky130_fd_pr__nfet_01v8 ad=0.406 pd=3.38 as=0.406 ps=3.38 w=1.4 l=0.6
X596 x2_cm_tail__cc6_0.x2_m3d x2_cm_casc__cc6_0.bias_d on VSS sky130_fd_pr__nfet_01v8 ad=0.406 pd=3.38 as=0.406 ps=3.38 w=1.4 l=0.6
X597 x2_cm_tail__cc6_0.x2_m4d x2_cm_casc__cc6_0.bias_d op VSS sky130_fd_pr__nfet_01v8 ad=0.406 pd=3.38 as=0.406 ps=3.38 w=1.4 l=0.6
X598 VSS bias_a x2_diff__cc1_0.x2_tail VSS sky130_fd_pr__nfet_01v8 ad=0.406 pd=3.38 as=0.406 ps=3.38 w=1.4 l=0.6
X599 VSS VSS VSS VSS sky130_fd_pr__nfet_01v8 ad=0.406 pd=3.38 as=0 ps=0 w=1.4 l=0.6
X600 x2_diff__cc1_0.x2_foldp x2_cl_casc__cc2_0.bias_c on VDD sky130_fd_pr__pfet_01v8 ad=0.406 pd=3.38 as=0.406 ps=3.38 w=1.4 l=0.6
X601 VSS VSS x2_cm_tail__cc6_0.x2_m3d VSS sky130_fd_pr__nfet_01v8 ad=0.406 pd=3.38 as=0.406 ps=3.38 w=1.4 l=0.6
X602 VSS bias_a x2_cm_tail__cc6_0.x2_m3d VSS sky130_fd_pr__nfet_01v8 ad=0.406 pd=3.38 as=0.406 ps=3.38 w=1.4 l=0.6
X603 x2_diff__cc1_0.x2_tail in x2_diff__cc1_0.x2_foldn VSS sky130_fd_pr__nfet_01v8_lvt ad=0.348 pd=2.98 as=0.348 ps=2.98 w=1.2 l=0.2
X604 VSS VSS VSS VSS sky130_fd_pr__nfet_01v8 ad=0.406 pd=3.38 as=0 ps=0 w=1.4 l=0.6
X605 x1_cc_cm__strings1_0.x1_net13 cm cm VSS sky130_fd_pr__nfet_01v8 ad=0.406 pd=3.38 as=0.406 ps=3.38 w=1.4 l=0.6
X606 x2_diff__cc1_0.x2_tail cmc VSS VSS sky130_fd_pr__nfet_01v8 ad=0.406 pd=3.38 as=0.406 ps=3.38 w=1.4 l=0.6
X607 x1_cc_cm__strings1_0.x1_net14 cm x1_cc_cm__strings1_0.x1_net13 VSS sky130_fd_pr__nfet_01v8 ad=0.406 pd=3.38 as=0.406 ps=3.38 w=1.4 l=0.6
X608 x1_cm_bias_c__cc1_0.x1_m25d x2_cl_casc__cc2_0.bias_c x1_single_m3__f1_0.x1_m2d VDD sky130_fd_pr__pfet_01v8 ad=0.406 pd=3.38 as=0.406 ps=3.38 w=1.4 l=0.6
X609 cm cm cm VSS sky130_fd_pr__nfet_01v8 ad=0.406 pd=3.38 as=0 ps=0 w=1.4 l=0.6
X610 x2_cm_tail__cc6_0.x2_m3d x2_cm_casc__cc6_0.bias_d on VSS sky130_fd_pr__nfet_01v8 ad=0.406 pd=3.38 as=0.406 ps=3.38 w=1.4 l=0.6
X611 VDD x2_cl_src__cc3_0.bias_b x2_diff__cc1_0.x2_foldn VDD sky130_fd_pr__pfet_01v8_lvt ad=0.406 pd=3.38 as=0.406 ps=3.38 w=1.4 l=0.6
X612 op x2_cm_casc__cc6_0.bias_d x2_cm_tail__cc6_0.x2_m4d VSS sky130_fd_pr__nfet_01v8 ad=0.406 pd=3.38 as=0.406 ps=3.38 w=1.4 l=0.6
X613 x2_diff__cc1_0.x2_tail cmc VSS VSS sky130_fd_pr__nfet_01v8 ad=0.406 pd=3.38 as=0.406 ps=3.38 w=1.4 l=0.6
X614 VSS bias_a x2_diff__cc1_0.x2_tail VSS sky130_fd_pr__nfet_01v8 ad=0.406 pd=3.38 as=0.406 ps=3.38 w=1.4 l=0.6
X615 VDD VDD x1_cm_bias_c__cc1_0.x1_m31d VDD sky130_fd_pr__pfet_01v8 ad=0.406 pd=3.38 as=0.406 ps=3.38 w=1.4 l=0.6
X616 VDD x2_cl_src__cc3_0.bias_b x1_cm_bias_c__cc1_0.x1_m25d VDD sky130_fd_pr__pfet_01v8_lvt ad=0.406 pd=3.38 as=0.406 ps=3.38 w=1.4 l=0.6
X617 cm cm cm VSS sky130_fd_pr__nfet_01v8 ad=0.406 pd=3.38 as=0 ps=0 w=1.4 l=0.6
X618 x2_diff__cc1_0.x2_foldn x2_diff__cc1_0.x2_foldn x2_diff__cc1_0.x2_foldn VDD sky130_fd_pr__pfet_01v8 ad=0.406 pd=3.38 as=0 ps=0 w=1.4 l=0.6
X619 VSS cmc x2_diff__cc1_0.x2_tail VSS sky130_fd_pr__nfet_01v8 ad=0.406 pd=3.38 as=0.406 ps=3.38 w=1.4 l=0.6
X620 x2_cm_tail__cc6_0.x2_m4d x2_cm_casc__cc6_0.bias_d op VSS sky130_fd_pr__nfet_01v8 ad=0.406 pd=3.38 as=0.406 ps=3.38 w=1.4 l=0.6
X621 VSS VSS x2_cm_tail__cc6_0.x2_m4d VSS sky130_fd_pr__nfet_01v8 ad=0.406 pd=3.38 as=0.406 ps=3.38 w=1.4 l=0.6
X622 VSS VSS VSS VSS sky130_fd_pr__nfet_01v8 ad=0.406 pd=3.38 as=0 ps=0 w=1.4 l=0.6
X623 VSS VSS x2_cm_tail__cc6_0.x2_m3d VSS sky130_fd_pr__nfet_01v8 ad=0.406 pd=3.38 as=0.406 ps=3.38 w=1.4 l=0.6
X624 x1_single_m5__f1_0.x1_m5d x2_cm_casc__cc6_0.bias_d bias_a VSS sky130_fd_pr__nfet_01v8 ad=0.406 pd=3.38 as=0.406 ps=3.38 w=1.4 l=0.6
X625 x2_diff__cc1_0.x2_tail bias_a VSS VSS sky130_fd_pr__nfet_01v8 ad=0.406 pd=3.38 as=0.406 ps=3.38 w=1.4 l=0.6
X626 VSS cmc x2_diff__cc1_0.x2_tail VSS sky130_fd_pr__nfet_01v8 ad=0.406 pd=3.38 as=0.406 ps=3.38 w=1.4 l=0.6
X627 x1_single_m5__f1_0.x1_m5d x2_cm_casc__cc6_0.bias_d bias_a VSS sky130_fd_pr__nfet_01v8 ad=0.406 pd=3.38 as=0.406 ps=3.38 w=1.4 l=0.6
X628 on x2_cl_casc__cc2_0.bias_c x2_diff__cc1_0.x2_foldp VDD sky130_fd_pr__pfet_01v8 ad=0.406 pd=3.38 as=0.406 ps=3.38 w=1.4 l=0.6
X629 x2_diff__cc1_0.x2_foldp x2_cl_casc__cc2_0.bias_c on VDD sky130_fd_pr__pfet_01v8 ad=0.406 pd=3.38 as=0.406 ps=3.38 w=1.4 l=0.6
X630 x2_diff__cc1_0.x2_tail bias_a VSS VSS sky130_fd_pr__nfet_01v8 ad=0.406 pd=3.38 as=0.406 ps=3.38 w=1.4 l=0.6
X631 cm cm cm VSS sky130_fd_pr__nfet_01v8 ad=0.406 pd=3.38 as=0 ps=0 w=1.4 l=0.6
X632 x2_diff__cc1_0.x2_foldp x2_diff__cc1_0.x2_foldp x2_diff__cc1_0.x2_foldp VSS sky130_fd_pr__nfet_01v8_lvt ad=0.348 pd=2.98 as=0 ps=0 w=1.2 l=0.2
X633 op cmc sky130_fd_pr__cap_mim_m3_1 l=4.8 w=4.8
Cmimself3 op cmc -2.601225f
X634 x2_diff__cc1_0.x2_tail cmc VSS VSS sky130_fd_pr__nfet_01v8 ad=0.406 pd=3.38 as=0.406 ps=3.38 w=1.4 l=0.6
X635 x2_diff__cc1_0.x2_tail bias_a VSS VSS sky130_fd_pr__nfet_01v8 ad=0.406 pd=3.38 as=0.406 ps=3.38 w=1.4 l=0.6
X636 op cmc sky130_fd_pr__cap_mim_m3_1 l=4.8 w=4.8
Cmimself4 op cmc -2.601225f
X637 VSS bias_a x2_diff__cc1_0.x2_tail VSS sky130_fd_pr__nfet_01v8 ad=0.406 pd=3.38 as=0.406 ps=3.38 w=1.4 l=0.6
X638 x2_cm_tail__cc6_0.x2_m4d bias_a VSS VSS sky130_fd_pr__nfet_01v8 ad=0.406 pd=3.38 as=0.406 ps=3.38 w=1.4 l=0.6
X639 x1_single_m5__f1_0.x1_m5d x2_cm_casc__cc6_0.bias_d bias_a VSS sky130_fd_pr__nfet_01v8 ad=0.406 pd=3.38 as=0.406 ps=3.38 w=1.4 l=0.6
X640 VDD x2_cl_src__cc3_0.bias_b x2_diff__cc1_0.x2_foldp VDD sky130_fd_pr__pfet_01v8_lvt ad=0.406 pd=3.38 as=0.406 ps=3.38 w=1.4 l=0.6
X641 x2_diff__cc1_0.x2_tail bias_a VSS VSS sky130_fd_pr__nfet_01v8 ad=0.406 pd=3.38 as=0.406 ps=3.38 w=1.4 l=0.6
X642 x2_diff__cc1_0.x2_tail bias_a VSS VSS sky130_fd_pr__nfet_01v8 ad=0.406 pd=3.38 as=0.406 ps=3.38 w=1.4 l=0.6
X643 VDD VDD x1_cm_bias_c__cc1_0.x1_m31d VDD sky130_fd_pr__pfet_01v8 ad=0.406 pd=3.38 as=0.406 ps=3.38 w=1.4 l=0.6
X644 VSS bias_a x2_cm_tail__cc6_0.x2_m3d VSS sky130_fd_pr__nfet_01v8 ad=0.406 pd=3.38 as=0.406 ps=3.38 w=1.4 l=0.6
X645 op x2_cl_casc__cc2_0.bias_c x2_diff__cc1_0.x2_foldn VDD sky130_fd_pr__pfet_01v8 ad=0.406 pd=3.38 as=0.406 ps=3.38 w=1.4 l=0.6
X646 VDD x2_cl_src__cc3_0.bias_b x2_diff__cc1_0.x2_foldn VDD sky130_fd_pr__pfet_01v8_lvt ad=0.406 pd=3.38 as=0.406 ps=3.38 w=1.4 l=0.6
X647 VSS VSS x1_single_m5__f1_0.x1_m5d VSS sky130_fd_pr__nfet_01v8 ad=0.406 pd=3.38 as=0.406 ps=3.38 w=1.4 l=0.6
X648 VSS cmc x2_diff__cc1_0.x2_tail VSS sky130_fd_pr__nfet_01v8 ad=0.406 pd=3.38 as=0.406 ps=3.38 w=1.4 l=0.6
X649 VDD x2_cl_src__cc3_0.bias_b x1_cm_bias_c__cc1_0.x1_m31d VDD sky130_fd_pr__pfet_01v8_lvt ad=0.406 pd=3.38 as=0.406 ps=3.38 w=1.4 l=0.6
X650 on x2_cm_casc__cc6_0.bias_d x2_cm_tail__cc6_0.x2_m3d VSS sky130_fd_pr__nfet_01v8 ad=0.406 pd=3.38 as=0.406 ps=3.38 w=1.4 l=0.6
X651 VSS bias_a x2_cm_tail__cc6_0.x2_m3d VSS sky130_fd_pr__nfet_01v8 ad=0.406 pd=3.38 as=0.406 ps=3.38 w=1.4 l=0.6
X652 x1_cm_bias_c__cc1_0.x1_m31d x2_cl_casc__cc2_0.bias_c cm VDD sky130_fd_pr__pfet_01v8 ad=0.406 pd=3.38 as=0.406 ps=3.38 w=1.4 l=0.6
X653 op x2_cm_casc__cc6_0.bias_d x2_cm_tail__cc6_0.x2_m4d VSS sky130_fd_pr__nfet_01v8 ad=0.406 pd=3.38 as=0.406 ps=3.38 w=1.4 l=0.6
X654 op x2_cm_casc__cc6_0.bias_d x2_cm_tail__cc6_0.x2_m4d VSS sky130_fd_pr__nfet_01v8 ad=0.406 pd=3.38 as=0.406 ps=3.38 w=1.4 l=0.6
X655 VSS VSS x2_diff__cc1_0.x2_tail VSS sky130_fd_pr__nfet_01v8 ad=0.406 pd=3.38 as=0.406 ps=3.38 w=1.4 l=0.6
X656 x2_cm_tail__cc6_0.x2_m4d bias_a VSS VSS sky130_fd_pr__nfet_01v8 ad=0.406 pd=3.38 as=0.406 ps=3.38 w=1.4 l=0.6
X657 x2_cm_casc__cc6_0.bias_d x1_single_m3__f1_0.x1_m2d x1_single_m3__f1_0.x1_m2d VSS sky130_fd_pr__nfet_01v8 ad=0.406 pd=3.38 as=0.406 ps=3.38 w=1.4 l=0.6
X658 x2_cm_tail__cc6_0.x2_m4d x2_cm_casc__cc6_0.bias_d op VSS sky130_fd_pr__nfet_01v8 ad=0.406 pd=3.38 as=0.406 ps=3.38 w=1.4 l=0.6
X659 VSS cmc x2_diff__cc1_0.x2_tail VSS sky130_fd_pr__nfet_01v8 ad=0.406 pd=3.38 as=0.406 ps=3.38 w=1.4 l=0.6
X660 VDD VDD VDD VDD sky130_fd_pr__pfet_01v8_lvt ad=0.406 pd=3.38 as=0 ps=0 w=1.4 l=0.6
X661 VSS VSS VSS VSS sky130_fd_pr__nfet_01v8 ad=0.406 pd=3.38 as=0 ps=0 w=1.4 l=0.6
X662 x2_cm_casc__cc6_0.bias_d x2_cm_casc__cc6_0.bias_d x2_cm_casc__cc6_0.bias_d VSS sky130_fd_pr__nfet_01v8 ad=0.406 pd=3.38 as=0 ps=0 w=1.4 l=0.6
X663 x2_diff__cc1_0.x2_foldp x2_cl_src__cc3_0.bias_b VDD VDD sky130_fd_pr__pfet_01v8_lvt ad=0.406 pd=3.38 as=0.406 ps=3.38 w=1.4 l=0.6
X664 VDD VDD op VDD sky130_fd_pr__pfet_01v8 ad=0.406 pd=3.38 as=0.406 ps=3.38 w=1.4 l=0.6
X665 op x2_cl_casc__cc2_0.bias_c x2_diff__cc1_0.x2_foldn VDD sky130_fd_pr__pfet_01v8 ad=0.406 pd=3.38 as=0.406 ps=3.38 w=1.4 l=0.6
X666 x2_cl_casc__cc2_0.bias_c x2_cl_casc__cc2_0.bias_c x2_cl_casc__cc2_0.bias_c VSS sky130_fd_pr__nfet_01v8_lvt ad=0.406 pd=3.38 as=0 ps=0 w=1.4 l=0.6
X667 VSS VSS VSS VSS sky130_fd_pr__nfet_01v8 ad=0.406 pd=3.38 as=0 ps=0 w=1.4 l=0.6
X668 x2_cm_casc__cc6_0.bias_d x1_single_m3__f1_0.x1_m2d x1_single_m3__f1_0.x1_m2d VSS sky130_fd_pr__nfet_01v8 ad=0.406 pd=3.38 as=0.406 ps=3.38 w=1.4 l=0.6
X669 on x2_cm_casc__cc6_0.bias_d x2_cm_tail__cc6_0.x2_m3d VSS sky130_fd_pr__nfet_01v8 ad=0.406 pd=3.38 as=0.406 ps=3.38 w=1.4 l=0.6
X670 x2_diff__cc1_0.x2_tail bias_a VSS VSS sky130_fd_pr__nfet_01v8 ad=0.406 pd=3.38 as=0.406 ps=3.38 w=1.4 l=0.6
X671 VSS bias_a x2_cm_tail__cc6_0.x2_m3d VSS sky130_fd_pr__nfet_01v8 ad=0.406 pd=3.38 as=0.406 ps=3.38 w=1.4 l=0.6
X672 x2_cm_casc__cc6_0.bias_d x2_cm_casc__cc6_0.bias_d x2_cm_casc__cc6_0.bias_d VSS sky130_fd_pr__nfet_01v8 ad=0.406 pd=3.38 as=0 ps=0 w=1.4 l=0.6
X673 on on on VSS sky130_fd_pr__nfet_01v8 ad=0.406 pd=3.38 as=0 ps=0 w=1.4 l=0.6
X674 VSS bias_a x1_single_m5__f1_0.x1_m5d VSS sky130_fd_pr__nfet_01v8 ad=0.406 pd=3.38 as=0.406 ps=3.38 w=1.4 l=0.6
X675 op x2_cm_casc__cc6_0.bias_d x2_cm_tail__cc6_0.x2_m4d VSS sky130_fd_pr__nfet_01v8 ad=0.406 pd=3.38 as=0.406 ps=3.38 w=1.4 l=0.6
X676 x2_diff__cc1_0.x2_tail cmc VSS VSS sky130_fd_pr__nfet_01v8 ad=0.406 pd=3.38 as=0.406 ps=3.38 w=1.4 l=0.6
X677 VSS VSS VSS VSS sky130_fd_pr__nfet_01v8 ad=0.406 pd=3.38 as=0 ps=0 w=1.4 l=0.6
X678 VSS bias_a x2_diff__cc1_0.x2_tail VSS sky130_fd_pr__nfet_01v8 ad=0.406 pd=3.38 as=0.406 ps=3.38 w=1.4 l=0.6
X679 VSS VSS VSS VSS sky130_fd_pr__nfet_01v8 ad=0.406 pd=3.38 as=0 ps=0 w=1.4 l=0.6
X680 VSS VSS VSS VSS sky130_fd_pr__nfet_01v8 ad=0.406 pd=3.38 as=0 ps=0 w=1.4 l=0.6
X681 x2_diff__cc1_0.x2_foldp x2_cl_src__cc3_0.bias_b VDD VDD sky130_fd_pr__pfet_01v8_lvt ad=0.406 pd=3.38 as=0.406 ps=3.38 w=1.4 l=0.6
X682 x2_cm_tail__cc6_0.x2_m4d bias_a VSS VSS sky130_fd_pr__nfet_01v8 ad=0.406 pd=3.38 as=0.406 ps=3.38 w=1.4 l=0.6
X683 x1_single_m3__f1_0.x1_m2d x1_single_m3__f1_0.x1_m2d x1_single_m3__f1_0.x1_m2d VSS sky130_fd_pr__nfet_01v8 ad=0.406 pd=3.38 as=0 ps=0 w=1.4 l=0.6
X684 VSS bias_a x2_diff__cc1_0.x2_tail VSS sky130_fd_pr__nfet_01v8 ad=0.406 pd=3.38 as=0.406 ps=3.38 w=1.4 l=0.6
X685 x2_diff__cc1_0.x2_tail bias_a VSS VSS sky130_fd_pr__nfet_01v8 ad=0.406 pd=3.38 as=0.406 ps=3.38 w=1.4 l=0.6
X686 x1_cc_cm__strings1_0.x1_net15 cm x1_cc_cm__strings1_0.x1_net14 VSS sky130_fd_pr__nfet_01v8 ad=0.406 pd=3.38 as=0.406 ps=3.38 w=1.4 l=0.6
X687 x2_diff__cc1_0.x2_foldn x2_cl_src__cc3_0.bias_b VDD VDD sky130_fd_pr__pfet_01v8_lvt ad=0.406 pd=3.38 as=0.406 ps=3.38 w=1.4 l=0.6
X688 VSS bias_a x2_diff__cc1_0.x2_tail VSS sky130_fd_pr__nfet_01v8 ad=0.406 pd=3.38 as=0.406 ps=3.38 w=1.4 l=0.6
X689 x2_diff__cc1_0.x2_foldp x2_cl_src__cc3_0.bias_b VDD VDD sky130_fd_pr__pfet_01v8_lvt ad=0.406 pd=3.38 as=0.406 ps=3.38 w=1.4 l=0.6
X690 x1_single_m3__f1_0.x1_m2d x1_single_m3__f1_0.x1_m2d x2_cm_casc__cc6_0.bias_d VSS sky130_fd_pr__nfet_01v8 ad=0.406 pd=3.38 as=0.406 ps=3.38 w=1.4 l=0.6
X691 x2_diff__cc1_0.x2_foldn x2_cl_casc__cc2_0.bias_c op VDD sky130_fd_pr__pfet_01v8 ad=0.406 pd=3.38 as=0.406 ps=3.38 w=1.4 l=0.6
X692 op op op VSS sky130_fd_pr__nfet_01v8 ad=0.406 pd=3.38 as=0 ps=0 w=1.4 l=0.6
X693 VSS cmc x2_diff__cc1_0.x2_tail VSS sky130_fd_pr__nfet_01v8 ad=0.406 pd=3.38 as=0.406 ps=3.38 w=1.4 l=0.6
X694 VSS bias_a x2_cm_tail__cc6_0.x2_m4d VSS sky130_fd_pr__nfet_01v8 ad=0.406 pd=3.38 as=0.406 ps=3.38 w=1.4 l=0.6
X695 bias_a bias_a bias_a VSS sky130_fd_pr__nfet_01v8 ad=0.406 pd=3.38 as=0 ps=0 w=1.4 l=0.6
X696 VDD x2_cl_src__cc3_0.bias_b x2_diff__cc1_0.x2_foldp VDD sky130_fd_pr__pfet_01v8_lvt ad=0.406 pd=3.38 as=0.406 ps=3.38 w=1.4 l=0.6
X697 VSS bias_a x2_cm_tail__cc6_0.x2_m3d VSS sky130_fd_pr__nfet_01v8 ad=0.406 pd=3.38 as=0.406 ps=3.38 w=1.4 l=0.6
X698 cm cm cm VSS sky130_fd_pr__nfet_01v8 ad=0.406 pd=3.38 as=0 ps=0 w=1.4 l=0.6
X699 x2_diff__cc1_0.x2_tail bias_a VSS VSS sky130_fd_pr__nfet_01v8 ad=0.406 pd=3.38 as=0.406 ps=3.38 w=1.4 l=0.6
X700 VDD VDD VDD VDD sky130_fd_pr__pfet_01v8 ad=0.406 pd=3.38 as=0 ps=0 w=1.4 l=0.6
X701 VDD VDD VDD VDD sky130_fd_pr__pfet_01v8 ad=0.406 pd=3.38 as=0 ps=0 w=1.4 l=0.6
X702 x2_cm_tail__cc6_0.x2_m3d bias_a VSS VSS sky130_fd_pr__nfet_01v8 ad=0.406 pd=3.38 as=0.406 ps=3.38 w=1.4 l=0.6
X703 x2_cm_tail__cc6_0.x2_m3d x2_cm_casc__cc6_0.bias_d on VSS sky130_fd_pr__nfet_01v8 ad=0.406 pd=3.38 as=0.406 ps=3.38 w=1.4 l=0.6
X704 cm x2_cl_casc__cc2_0.bias_c x1_cm_bias_c__cc1_0.x1_m31d VDD sky130_fd_pr__pfet_01v8 ad=0.406 pd=3.38 as=0.406 ps=3.38 w=1.4 l=0.6
X705 x2_diff__cc1_0.x2_tail bias_a VSS VSS sky130_fd_pr__nfet_01v8 ad=0.406 pd=3.38 as=0.406 ps=3.38 w=1.4 l=0.6
X706 x2_diff__cc1_0.x2_tail cmc VSS VSS sky130_fd_pr__nfet_01v8 ad=0.406 pd=3.38 as=0.406 ps=3.38 w=1.4 l=0.6
X707 VDD VDD x2_diff__cc1_0.x2_foldn VDD sky130_fd_pr__pfet_01v8 ad=0.406 pd=3.38 as=0.406 ps=3.38 w=1.4 l=0.6
X708 x2_cl_casc__cc2_0.bias_c x2_cl_casc__cc2_0.bias_c x2_cl_casc__cc2_0.bias_c VSS sky130_fd_pr__nfet_01v8_lvt ad=0.406 pd=3.38 as=0 ps=0 w=1.4 l=0.6
X709 x2_diff__cc1_0.x2_tail bias_a VSS VSS sky130_fd_pr__nfet_01v8 ad=0.406 pd=3.38 as=0.406 ps=3.38 w=1.4 l=0.6
X710 x1_single_m5__f1_0.x1_m5d x1_single_m5__f1_0.x1_m5d x1_single_m5__f1_0.x1_m5d VSS sky130_fd_pr__nfet_01v8 ad=0.406 pd=3.38 as=0 ps=0 w=1.4 l=0.6
X711 x1_single_m5__f1_0.x1_m5d x2_cm_casc__cc6_0.bias_d bias_a VSS sky130_fd_pr__nfet_01v8 ad=0.406 pd=3.38 as=0.406 ps=3.38 w=1.4 l=0.6
X712 on x2_cl_casc__cc2_0.bias_c x2_diff__cc1_0.x2_foldp VDD sky130_fd_pr__pfet_01v8 ad=0.406 pd=3.38 as=0.406 ps=3.38 w=1.4 l=0.6
X713 x2_diff__cc1_0.x2_tail bias_a VSS VSS sky130_fd_pr__nfet_01v8 ad=0.406 pd=3.38 as=0.406 ps=3.38 w=1.4 l=0.6
X714 on x2_cl_casc__cc2_0.bias_c x2_diff__cc1_0.x2_foldp VDD sky130_fd_pr__pfet_01v8 ad=0.406 pd=3.38 as=0.406 ps=3.38 w=1.4 l=0.6
X715 VSS bias_a x2_cm_tail__cc6_0.x2_m3d VSS sky130_fd_pr__nfet_01v8 ad=0.406 pd=3.38 as=0.406 ps=3.38 w=1.4 l=0.6
X716 VSS bias_a x2_cm_tail__cc6_0.x2_m3d VSS sky130_fd_pr__nfet_01v8 ad=0.406 pd=3.38 as=0.406 ps=3.38 w=1.4 l=0.6
X717 VSS bias_a x2_cm_tail__cc6_0.x2_m4d VSS sky130_fd_pr__nfet_01v8 ad=0.406 pd=3.38 as=0.406 ps=3.38 w=1.4 l=0.6
X718 cm cm cm VSS sky130_fd_pr__nfet_01v8 ad=0.406 pd=3.38 as=0 ps=0 w=1.4 l=0.6
X719 x2_diff__cc1_0.x2_tail cmc VSS VSS sky130_fd_pr__nfet_01v8 ad=0.406 pd=3.38 as=0.406 ps=3.38 w=1.4 l=0.6
X720 x1_cm_bias_c__cc1_0.x1_m25d x2_cl_casc__cc2_0.bias_c x1_single_m3__f1_0.x1_m2d VDD sky130_fd_pr__pfet_01v8 ad=0.406 pd=3.38 as=0.406 ps=3.38 w=1.4 l=0.6
X721 x2_cm_tail__cc6_0.x2_m4d bias_a VSS VSS sky130_fd_pr__nfet_01v8 ad=0.406 pd=3.38 as=0.406 ps=3.38 w=1.4 l=0.6
X722 op x2_cl_casc__cc2_0.bias_c x2_diff__cc1_0.x2_foldn VDD sky130_fd_pr__pfet_01v8 ad=0.406 pd=3.38 as=0.406 ps=3.38 w=1.4 l=0.6
X723 VSS cmc x2_diff__cc1_0.x2_tail VSS sky130_fd_pr__nfet_01v8 ad=0.406 pd=3.38 as=0.406 ps=3.38 w=1.4 l=0.6
X724 x2_diff__cc1_0.x2_tail bias_a VSS VSS sky130_fd_pr__nfet_01v8 ad=0.406 pd=3.38 as=0.406 ps=3.38 w=1.4 l=0.6
X725 x2_diff__cc1_0.x2_tail in x2_diff__cc1_0.x2_foldn VSS sky130_fd_pr__nfet_01v8_lvt ad=0.348 pd=2.98 as=0.348 ps=2.98 w=1.2 l=0.2
X726 VSS VSS VSS VSS sky130_fd_pr__nfet_01v8 ad=0.406 pd=3.38 as=0 ps=0 w=1.4 l=0.6
X727 x1_single_m3__f1_0.x1_m2d x1_single_m3__f1_0.x1_m2d x2_cm_casc__cc6_0.bias_d VSS sky130_fd_pr__nfet_01v8 ad=0.406 pd=3.38 as=0.406 ps=3.38 w=1.4 l=0.6
X728 VSS VSS x1_single_m5__f1_0.x1_m5d VSS sky130_fd_pr__nfet_01v8 ad=0.406 pd=3.38 as=0.406 ps=3.38 w=1.4 l=0.6
X729 x2_diff__cc1_0.x2_tail cmc VSS VSS sky130_fd_pr__nfet_01v8 ad=0.406 pd=3.38 as=0.406 ps=3.38 w=1.4 l=0.6
X730 x1_single_m3__f1_0.x1_m2d x1_single_m3__f1_0.x1_m2d x2_cm_casc__cc6_0.bias_d VSS sky130_fd_pr__nfet_01v8 ad=0.406 pd=3.38 as=0.406 ps=3.38 w=1.4 l=0.6
X731 op x2_cm_casc__cc6_0.bias_d x2_cm_tail__cc6_0.x2_m4d VSS sky130_fd_pr__nfet_01v8 ad=0.406 pd=3.38 as=0.406 ps=3.38 w=1.4 l=0.6
X732 x2_diff__cc1_0.x2_tail cmc VSS VSS sky130_fd_pr__nfet_01v8 ad=0.406 pd=3.38 as=0.406 ps=3.38 w=1.4 l=0.6
X733 VDD VDD VDD VDD sky130_fd_pr__pfet_01v8_lvt ad=0.406 pd=3.38 as=0 ps=0 w=1.4 l=0.6
X734 VSS VSS x1_single_m5__f1_0.x1_m5d VSS sky130_fd_pr__nfet_01v8 ad=0.406 pd=3.38 as=0.406 ps=3.38 w=1.4 l=0.6
X735 VSS bias_a x2_cm_tail__cc6_0.x2_m4d VSS sky130_fd_pr__nfet_01v8 ad=0.406 pd=3.38 as=0.406 ps=3.38 w=1.4 l=0.6
X736 x2_cm_tail__cc6_0.x2_m4d bias_a VSS VSS sky130_fd_pr__nfet_01v8 ad=0.406 pd=3.38 as=0.406 ps=3.38 w=1.4 l=0.6
X737 on x2_cm_casc__cc6_0.bias_d x2_cm_tail__cc6_0.x2_m3d VSS sky130_fd_pr__nfet_01v8 ad=0.406 pd=3.38 as=0.406 ps=3.38 w=1.4 l=0.6
X738 x1_cm_bias_c__cc1_0.x1_m21d x1_cm_bias_c__cc1_0.x1_m21d x1_cm_bias_c__cc1_0.x1_m21d VDD sky130_fd_pr__pfet_01v8 ad=0.406 pd=3.38 as=0 ps=0 w=1.4 l=0.6
X739 VDD VDD x2_diff__cc1_0.x2_foldp VDD sky130_fd_pr__pfet_01v8 ad=0.406 pd=3.38 as=0.406 ps=3.38 w=1.4 l=0.6
X740 x2_cm_tail__cc6_0.x2_m3d bias_a VSS VSS sky130_fd_pr__nfet_01v8 ad=0.406 pd=3.38 as=0.406 ps=3.38 w=1.4 l=0.6
X741 VSS VSS VSS VSS sky130_fd_pr__nfet_01v8 ad=0.406 pd=3.38 as=0 ps=0 w=1.4 l=0.6
X742 x2_cm_tail__cc6_0.x2_m3d bias_a VSS VSS sky130_fd_pr__nfet_01v8 ad=0.406 pd=3.38 as=0.406 ps=3.38 w=1.4 l=0.6
X743 x2_cm_casc__cc6_0.bias_d x1_single_m3__f1_0.x1_m2d x1_single_m3__f1_0.x1_m2d VSS sky130_fd_pr__nfet_01v8 ad=0.406 pd=3.38 as=0.406 ps=3.38 w=1.4 l=0.6
X744 x2_cm_casc__cc6_0.bias_d x1_single_m3__f1_0.x1_m2d x1_single_m3__f1_0.x1_m2d VSS sky130_fd_pr__nfet_01v8 ad=0.406 pd=3.38 as=0.406 ps=3.38 w=1.4 l=0.6
X745 x2_cm_tail__cc6_0.x2_m3d x2_cm_casc__cc6_0.bias_d on VSS sky130_fd_pr__nfet_01v8 ad=0.406 pd=3.38 as=0.406 ps=3.38 w=1.4 l=0.6
X746 VSS cmc x2_diff__cc1_0.x2_tail VSS sky130_fd_pr__nfet_01v8 ad=0.406 pd=3.38 as=0.406 ps=3.38 w=1.4 l=0.6
X747 VSS VSS VSS VSS sky130_fd_pr__nfet_01v8 ad=0.406 pd=3.38 as=0 ps=0 w=1.4 l=0.6
X748 x2_cm_casc__cc6_0.bias_d x1_single_m3__f1_0.x1_m2d x1_single_m3__f1_0.x1_m2d VSS sky130_fd_pr__nfet_01v8 ad=0.406 pd=3.38 as=0.406 ps=3.38 w=1.4 l=0.6
X749 x2_cm_casc__cc6_0.bias_d x2_cm_casc__cc6_0.bias_d x2_cm_casc__cc6_0.bias_d VSS sky130_fd_pr__nfet_01v8 ad=0.406 pd=3.38 as=0 ps=0 w=1.4 l=0.6
X750 VSS VSS VSS VSS sky130_fd_pr__nfet_01v8 ad=0.406 pd=3.38 as=0 ps=0 w=1.4 l=0.6
X751 x2_cm_tail__cc6_0.x2_m3d x2_cm_casc__cc6_0.bias_d on VSS sky130_fd_pr__nfet_01v8 ad=0.406 pd=3.38 as=0.406 ps=3.38 w=1.4 l=0.6
X752 x2_diff__cc1_0.x2_tail x2_diff__cc1_0.x2_tail x2_diff__cc1_0.x2_tail VSS sky130_fd_pr__nfet_01v8 ad=0.406 pd=3.38 as=0 ps=0 w=1.4 l=0.6
X753 VSS VSS VSS VSS sky130_fd_pr__nfet_01v8 ad=0.406 pd=3.38 as=0 ps=0 w=1.4 l=0.6
X754 x2_diff__cc1_0.x2_tail bias_a VSS VSS sky130_fd_pr__nfet_01v8 ad=0.406 pd=3.38 as=0.406 ps=3.38 w=1.4 l=0.6
X755 VSS bias_a x2_cm_tail__cc6_0.x2_m4d VSS sky130_fd_pr__nfet_01v8 ad=0.406 pd=3.38 as=0.406 ps=3.38 w=1.4 l=0.6
X756 on x2_cm_casc__cc6_0.bias_d x2_cm_tail__cc6_0.x2_m3d VSS sky130_fd_pr__nfet_01v8 ad=0.406 pd=3.38 as=0.406 ps=3.38 w=1.4 l=0.6
X757 VSS cmc x2_diff__cc1_0.x2_tail VSS sky130_fd_pr__nfet_01v8 ad=0.406 pd=3.38 as=0.406 ps=3.38 w=1.4 l=0.6
X758 VSS cmc x2_diff__cc1_0.x2_tail VSS sky130_fd_pr__nfet_01v8 ad=0.406 pd=3.38 as=0.406 ps=3.38 w=1.4 l=0.6
X759 x2_diff__cc1_0.x2_foldn x2_cl_casc__cc2_0.bias_c op VDD sky130_fd_pr__pfet_01v8 ad=0.406 pd=3.38 as=0.406 ps=3.38 w=1.4 l=0.6
X760 x2_cm_tail__cc6_0.x2_m4d bias_a VSS VSS sky130_fd_pr__nfet_01v8 ad=0.406 pd=3.38 as=0.406 ps=3.38 w=1.4 l=0.6
X761 x1_cc_cm__strings1_0.x1_net5 cm x1_cc_cm__strings1_0.x1_net6 VSS sky130_fd_pr__nfet_01v8 ad=0.406 pd=3.38 as=0.406 ps=3.38 w=1.4 l=0.6
X762 VSS VSS on VSS sky130_fd_pr__nfet_01v8 ad=0.406 pd=3.38 as=0.406 ps=3.38 w=1.4 l=0.6
X763 x1_single_m3__f1_0.x1_m2d x1_single_m3__f1_0.x1_m2d x2_cm_casc__cc6_0.bias_d VSS sky130_fd_pr__nfet_01v8 ad=0.406 pd=3.38 as=0.406 ps=3.38 w=1.4 l=0.6
X764 x2_diff__cc1_0.x2_foldp x2_cl_casc__cc2_0.bias_c on VDD sky130_fd_pr__pfet_01v8 ad=0.406 pd=3.38 as=0.406 ps=3.38 w=1.4 l=0.6
X765 VSS cm x1_cc_cm__strings1_0.x1_net15 VSS sky130_fd_pr__nfet_01v8 ad=0.406 pd=3.38 as=0.406 ps=3.38 w=1.4 l=0.6
X766 VSS bias_a x2_diff__cc1_0.x2_tail VSS sky130_fd_pr__nfet_01v8 ad=0.406 pd=3.38 as=0.406 ps=3.38 w=1.4 l=0.6
X767 x2_diff__cc1_0.x2_tail bias_a VSS VSS sky130_fd_pr__nfet_01v8 ad=0.406 pd=3.38 as=0.406 ps=3.38 w=1.4 l=0.6
X768 VDD x2_cl_src__cc3_0.bias_b x2_diff__cc1_0.x2_foldn VDD sky130_fd_pr__pfet_01v8_lvt ad=0.406 pd=3.38 as=0.406 ps=3.38 w=1.4 l=0.6
X769 VSS bias_a x2_cm_tail__cc6_0.x2_m3d VSS sky130_fd_pr__nfet_01v8 ad=0.406 pd=3.38 as=0.406 ps=3.38 w=1.4 l=0.6
X770 x1_single_m3__f1_0.x1_m2d x1_single_m3__f1_0.x1_m2d x2_cm_casc__cc6_0.bias_d VSS sky130_fd_pr__nfet_01v8 ad=0.406 pd=3.38 as=0.406 ps=3.38 w=1.4 l=0.6
X771 x1_cm_bias_c__cc1_0.x1_m31d x2_cl_casc__cc2_0.bias_c cm VDD sky130_fd_pr__pfet_01v8 ad=0.406 pd=3.38 as=0.406 ps=3.38 w=1.4 l=0.6
X772 op x2_cl_casc__cc2_0.bias_c x2_diff__cc1_0.x2_foldn VDD sky130_fd_pr__pfet_01v8 ad=0.406 pd=3.38 as=0.406 ps=3.38 w=1.4 l=0.6
X773 x1_single_m5__f1_0.x1_m5d x2_cm_casc__cc6_0.bias_d bias_a VSS sky130_fd_pr__nfet_01v8 ad=0.406 pd=3.38 as=0.406 ps=3.38 w=1.4 l=0.6
X774 x2_diff__cc1_0.x2_tail cmc VSS VSS sky130_fd_pr__nfet_01v8 ad=0.406 pd=3.38 as=0.406 ps=3.38 w=1.4 l=0.6
X775 x2_cm_tail__cc6_0.x2_m3d bias_a VSS VSS sky130_fd_pr__nfet_01v8 ad=0.406 pd=3.38 as=0.406 ps=3.38 w=1.4 l=0.6
X776 x2_cm_tail__cc6_0.x2_m3d x2_cm_casc__cc6_0.bias_d on VSS sky130_fd_pr__nfet_01v8 ad=0.406 pd=3.38 as=0.406 ps=3.38 w=1.4 l=0.6
X777 on cmc sky130_fd_pr__cap_mim_m3_1 l=4.8 w=4.8
Cmimself5 on cmc -2.601225f
X778 x2_diff__cc1_0.x2_foldp x2_cl_src__cc3_0.bias_b VDD VDD sky130_fd_pr__pfet_01v8_lvt ad=0.406 pd=3.38 as=0.406 ps=3.38 w=1.4 l=0.6
X779 on x2_cl_casc__cc2_0.bias_c x2_diff__cc1_0.x2_foldp VDD sky130_fd_pr__pfet_01v8 ad=0.406 pd=3.38 as=0.406 ps=3.38 w=1.4 l=0.6
X780 on cmc sky130_fd_pr__cap_mim_m3_1 l=4.8 w=4.8
Cmimself6 on cmc -2.601225f
X781 x2_diff__cc1_0.x2_tail bias_a VSS VSS sky130_fd_pr__nfet_01v8 ad=0.406 pd=3.38 as=0.406 ps=3.38 w=1.4 l=0.6
X782 x2_diff__cc1_0.x2_tail cmc VSS VSS sky130_fd_pr__nfet_01v8 ad=0.406 pd=3.38 as=0.406 ps=3.38 w=1.4 l=0.6
X783 x1_cm_bias_c__cc1_0.x1_m21d x1_cm_bias_c__cc1_0.x1_m21d x1_cm_bias_c__cc1_0.x1_m21d VDD sky130_fd_pr__pfet_01v8 ad=0.406 pd=3.38 as=0 ps=0 w=1.4 l=0.6
X784 x2_cm_tail__cc6_0.x2_m4d x2_cm_casc__cc6_0.bias_d op VSS sky130_fd_pr__nfet_01v8 ad=0.406 pd=3.38 as=0.406 ps=3.38 w=1.4 l=0.6
X785 x1_cm_bias_c__cc1_0.x1_m21d x2_cl_casc__cc2_0.bias_c x2_cl_src__cc3_0.bias_b VDD sky130_fd_pr__pfet_01v8 ad=0.406 pd=3.38 as=0.406 ps=3.38 w=1.4 l=0.6
X786 x1_single_m5__f1_0.x1_m5d x1_single_m5__f1_0.x1_m5d x1_single_m5__f1_0.x1_m5d VSS sky130_fd_pr__nfet_01v8 ad=0.406 pd=3.38 as=0 ps=0 w=1.4 l=0.6
X787 x2_diff__cc1_0.x2_foldn x2_cl_src__cc3_0.bias_b VDD VDD sky130_fd_pr__pfet_01v8_lvt ad=0.406 pd=3.38 as=0.406 ps=3.38 w=1.4 l=0.6
X788 x2_cm_tail__cc6_0.x2_m3d bias_a VSS VSS sky130_fd_pr__nfet_01v8 ad=0.406 pd=3.38 as=0.406 ps=3.38 w=1.4 l=0.6
X789 x2_diff__cc1_0.x2_tail cmc VSS VSS sky130_fd_pr__nfet_01v8 ad=0.406 pd=3.38 as=0.406 ps=3.38 w=1.4 l=0.6
X790 VSS bias_a x2_cm_tail__cc6_0.x2_m4d VSS sky130_fd_pr__nfet_01v8 ad=0.406 pd=3.38 as=0.406 ps=3.38 w=1.4 l=0.6
X791 VSS cmc x2_diff__cc1_0.x2_tail VSS sky130_fd_pr__nfet_01v8 ad=0.406 pd=3.38 as=0.406 ps=3.38 w=1.4 l=0.6
X792 x2_cl_src__cc3_0.bias_b x2_cl_src__cc3_0.bias_b x2_cl_casc__cc2_0.bias_c VSS sky130_fd_pr__nfet_01v8_lvt ad=0.406 pd=3.38 as=0.406 ps=3.38 w=1.4 l=0.6
X793 x1_single_m5__f1_0.x1_m5d x1_single_m5__f1_0.x1_m5d x1_single_m5__f1_0.x1_m5d VSS sky130_fd_pr__nfet_01v8 ad=0.406 pd=3.38 as=0 ps=0 w=1.4 l=0.6
X794 x1_cm_bias_c__cc1_0.x1_m31d x2_cl_src__cc3_0.bias_b VDD VDD sky130_fd_pr__pfet_01v8_lvt ad=0.406 pd=3.38 as=0.406 ps=3.38 w=1.4 l=0.6
X795 VSS cmc x2_diff__cc1_0.x2_tail VSS sky130_fd_pr__nfet_01v8 ad=0.406 pd=3.38 as=0.406 ps=3.38 w=1.4 l=0.6
X796 x2_diff__cc1_0.x2_foldn x2_diff__cc1_0.x2_foldn x2_diff__cc1_0.x2_foldn VSS sky130_fd_pr__nfet_01v8_lvt ad=0.348 pd=2.98 as=0 ps=0 w=1.2 l=0.2
X797 x2_cm_tail__cc6_0.x2_m3d bias_a VSS VSS sky130_fd_pr__nfet_01v8 ad=0.406 pd=3.38 as=0.406 ps=3.38 w=1.4 l=0.6
X798 x2_diff__cc1_0.x2_tail cmc VSS VSS sky130_fd_pr__nfet_01v8 ad=0.406 pd=3.38 as=0.406 ps=3.38 w=1.4 l=0.6
X799 VSS VSS VSS VSS sky130_fd_pr__nfet_01v8 ad=0.406 pd=3.38 as=0 ps=0 w=1.4 l=0.6
X800 x2_diff__cc1_0.x2_tail bias_a VSS VSS sky130_fd_pr__nfet_01v8 ad=0.406 pd=3.38 as=0.406 ps=3.38 w=1.4 l=0.6
X801 on x2_cm_casc__cc6_0.bias_d x2_cm_tail__cc6_0.x2_m3d VSS sky130_fd_pr__nfet_01v8 ad=0.406 pd=3.38 as=0.406 ps=3.38 w=1.4 l=0.6
X802 x2_diff__cc1_0.x2_foldn x2_cl_src__cc3_0.bias_b VDD VDD sky130_fd_pr__pfet_01v8_lvt ad=0.406 pd=3.38 as=0.406 ps=3.38 w=1.4 l=0.6
X803 x2_diff__cc1_0.x2_tail ip x2_diff__cc1_0.x2_foldp VSS sky130_fd_pr__nfet_01v8_lvt ad=0.348 pd=2.98 as=0.348 ps=2.98 w=1.2 l=0.2
X804 VSS bias_a x2_diff__cc1_0.x2_tail VSS sky130_fd_pr__nfet_01v8 ad=0.406 pd=3.38 as=0.406 ps=3.38 w=1.4 l=0.6
X805 VSS VSS VSS VSS sky130_fd_pr__nfet_01v8 ad=0.406 pd=3.38 as=0 ps=0 w=1.4 l=0.6
X806 op x2_cm_casc__cc6_0.bias_d x2_cm_tail__cc6_0.x2_m4d VSS sky130_fd_pr__nfet_01v8 ad=0.406 pd=3.38 as=0.406 ps=3.38 w=1.4 l=0.6
X807 op x2_cm_casc__cc6_0.bias_d x2_cm_tail__cc6_0.x2_m4d VSS sky130_fd_pr__nfet_01v8 ad=0.406 pd=3.38 as=0.406 ps=3.38 w=1.4 l=0.6
X808 cm x2_cl_casc__cc2_0.bias_c x1_cm_bias_c__cc1_0.x1_m31d VDD sky130_fd_pr__pfet_01v8 ad=0.406 pd=3.38 as=0.406 ps=3.38 w=1.4 l=0.6
X809 VSS bias_a x2_diff__cc1_0.x2_tail VSS sky130_fd_pr__nfet_01v8 ad=0.406 pd=3.38 as=0.406 ps=3.38 w=1.4 l=0.6
X810 VSS cmc x2_diff__cc1_0.x2_tail VSS sky130_fd_pr__nfet_01v8 ad=0.406 pd=3.38 as=0.406 ps=3.38 w=1.4 l=0.6
X811 x2_cm_casc__cc6_0.bias_d x1_single_m3__f1_0.x1_m2d x1_single_m3__f1_0.x1_m2d VSS sky130_fd_pr__nfet_01v8 ad=0.406 pd=3.38 as=0.406 ps=3.38 w=1.4 l=0.6
X812 x1_single_m5__f1_0.x1_m5d bias_a VSS VSS sky130_fd_pr__nfet_01v8 ad=0.406 pd=3.38 as=0.406 ps=3.38 w=1.4 l=0.6
X813 x2_cm_tail__cc6_0.x2_m4d x2_cm_casc__cc6_0.bias_d op VSS sky130_fd_pr__nfet_01v8 ad=0.406 pd=3.38 as=0.406 ps=3.38 w=1.4 l=0.6
X814 x2_diff__cc1_0.x2_foldn x2_cl_casc__cc2_0.bias_c op VDD sky130_fd_pr__pfet_01v8 ad=0.406 pd=3.38 as=0.406 ps=3.38 w=1.4 l=0.6
X815 VDD VDD VDD VDD sky130_fd_pr__pfet_01v8_lvt ad=0.406 pd=3.38 as=0 ps=0 w=1.4 l=0.6
X816 VSS bias_a x2_diff__cc1_0.x2_tail VSS sky130_fd_pr__nfet_01v8 ad=0.406 pd=3.38 as=0.406 ps=3.38 w=1.4 l=0.6
X817 x1_cm_bias_c__cc1_0.x1_m21d x2_cl_src__cc3_0.bias_b VDD VDD sky130_fd_pr__pfet_01v8_lvt ad=0.406 pd=3.38 as=0.406 ps=3.38 w=1.4 l=0.6
X818 VSS VSS VSS VSS sky130_fd_pr__nfet_01v8 ad=0.406 pd=3.38 as=0 ps=0 w=1.4 l=0.6
X819 x2_cm_casc__cc6_0.bias_d x1_single_m3__f1_0.x1_m2d x1_single_m3__f1_0.x1_m2d VSS sky130_fd_pr__nfet_01v8 ad=0.406 pd=3.38 as=0.406 ps=3.38 w=1.4 l=0.6
X820 x2_cm_tail__cc6_0.x2_m3d x2_cm_casc__cc6_0.bias_d on VSS sky130_fd_pr__nfet_01v8 ad=0.406 pd=3.38 as=0.406 ps=3.38 w=1.4 l=0.6
X821 x1_cc_cm__strings1_0.x1_net7 cm x1_cc_cm__strings1_0.x1_net8 VSS sky130_fd_pr__nfet_01v8 ad=0.406 pd=3.38 as=0.406 ps=3.38 w=1.4 l=0.6
X822 VDD x2_cl_src__cc3_0.bias_b x2_diff__cc1_0.x2_foldp VDD sky130_fd_pr__pfet_01v8_lvt ad=0.406 pd=3.38 as=0.406 ps=3.38 w=1.4 l=0.6
X823 VSS VSS VSS VSS sky130_fd_pr__nfet_01v8 ad=0.406 pd=3.38 as=0 ps=0 w=1.4 l=0.6
X824 op x2_cm_casc__cc6_0.bias_d x2_cm_tail__cc6_0.x2_m4d VSS sky130_fd_pr__nfet_01v8 ad=0.406 pd=3.38 as=0.406 ps=3.38 w=1.4 l=0.6
X825 VSS VSS VSS VSS sky130_fd_pr__nfet_01v8 ad=0.406 pd=3.38 as=0 ps=0 w=1.4 l=0.6
X826 x2_diff__cc1_0.x2_tail cmc VSS VSS sky130_fd_pr__nfet_01v8 ad=0.406 pd=3.38 as=0.406 ps=3.38 w=1.4 l=0.6
X827 VSS bias_a x2_diff__cc1_0.x2_tail VSS sky130_fd_pr__nfet_01v8 ad=0.406 pd=3.38 as=0.406 ps=3.38 w=1.4 l=0.6
X828 VDD x2_cl_src__cc3_0.bias_b x2_diff__cc1_0.x2_foldn VDD sky130_fd_pr__pfet_01v8_lvt ad=0.406 pd=3.38 as=0.406 ps=3.38 w=1.4 l=0.6
X829 x2_cl_casc__cc2_0.bias_c x2_cl_src__cc3_0.bias_b x2_cl_src__cc3_0.bias_b VSS sky130_fd_pr__nfet_01v8_lvt ad=0.406 pd=3.38 as=0.406 ps=3.38 w=1.4 l=0.6
X830 VSS cmc x2_diff__cc1_0.x2_tail VSS sky130_fd_pr__nfet_01v8 ad=0.406 pd=3.38 as=0.406 ps=3.38 w=1.4 l=0.6
X831 VSS bias_a x1_single_m5__f1_0.x1_m5d VSS sky130_fd_pr__nfet_01v8 ad=0.406 pd=3.38 as=0.406 ps=3.38 w=1.4 l=0.6
X832 x2_cm_tail__cc6_0.x2_m4d x2_cm_casc__cc6_0.bias_d op VSS sky130_fd_pr__nfet_01v8 ad=0.406 pd=3.38 as=0.406 ps=3.38 w=1.4 l=0.6
X833 x1_cm_bias_c__cc1_0.x1_m25d x1_cm_bias_c__cc1_0.x1_m25d x1_cm_bias_c__cc1_0.x1_m25d VDD sky130_fd_pr__pfet_01v8 ad=0.406 pd=3.38 as=0 ps=0 w=1.4 l=0.6
X834 x2_cm_casc__cc6_0.bias_d x1_single_m3__f1_0.x1_m2d bias_a VSS sky130_fd_pr__nfet_01v8 ad=0.406 pd=3.38 as=0.406 ps=3.38 w=1.4 l=0.6
X835 on x2_cm_casc__cc6_0.bias_d x2_cm_tail__cc6_0.x2_m3d VSS sky130_fd_pr__nfet_01v8 ad=0.406 pd=3.38 as=0.406 ps=3.38 w=1.4 l=0.6
X836 on x2_cl_casc__cc2_0.bias_c x2_diff__cc1_0.x2_foldp VDD sky130_fd_pr__pfet_01v8 ad=0.406 pd=3.38 as=0.406 ps=3.38 w=1.4 l=0.6
X837 x2_diff__cc1_0.x2_tail cmc VSS VSS sky130_fd_pr__nfet_01v8 ad=0.406 pd=3.38 as=0.406 ps=3.38 w=1.4 l=0.6
X838 VSS IBIAS x2_cl_casc__cc2_0.bias_c VSS sky130_fd_pr__nfet_01v8 ad=0.406 pd=3.38 as=0.406 ps=3.38 w=1.4 l=0.6
X839 VSS bias_a x1_single_m5__f1_0.x1_m5d VSS sky130_fd_pr__nfet_01v8 ad=0.406 pd=3.38 as=0.406 ps=3.38 w=1.4 l=0.6
X840 on x2_cl_casc__cc2_0.bias_c x2_diff__cc1_0.x2_foldp VDD sky130_fd_pr__pfet_01v8 ad=0.406 pd=3.38 as=0.406 ps=3.38 w=1.4 l=0.6
X841 VSS cmc x2_diff__cc1_0.x2_tail VSS sky130_fd_pr__nfet_01v8 ad=0.406 pd=3.38 as=0.406 ps=3.38 w=1.4 l=0.6
X842 x2_cl_src__cc3_0.bias_b x2_cl_src__cc3_0.bias_b x2_cl_casc__cc2_0.bias_c VSS sky130_fd_pr__nfet_01v8_lvt ad=0.406 pd=3.38 as=0.406 ps=3.38 w=1.4 l=0.6
X843 x2_cl_casc__cc2_0.bias_c x2_cl_src__cc3_0.bias_b x2_cl_src__cc3_0.bias_b VSS sky130_fd_pr__nfet_01v8_lvt ad=0.406 pd=3.38 as=0.406 ps=3.38 w=1.4 l=0.6
X844 VDD VDD cm VDD sky130_fd_pr__pfet_01v8 ad=0.406 pd=3.38 as=0.406 ps=3.38 w=1.4 l=0.6
X845 VSS cmc x2_diff__cc1_0.x2_tail VSS sky130_fd_pr__nfet_01v8 ad=0.406 pd=3.38 as=0.406 ps=3.38 w=1.4 l=0.6
X846 x1_single_m3__f1_0.x1_m2d x1_single_m3__f1_0.x1_m2d x2_cm_casc__cc6_0.bias_d VSS sky130_fd_pr__nfet_01v8 ad=0.406 pd=3.38 as=0.406 ps=3.38 w=1.4 l=0.6
X847 op cmc sky130_fd_pr__cap_mim_m3_1 l=4.8 w=4.8
Cmimself7 op cmc -2.601225f
X848 op x2_cl_casc__cc2_0.bias_c x2_diff__cc1_0.x2_foldn VDD sky130_fd_pr__pfet_01v8 ad=0.406 pd=3.38 as=0.406 ps=3.38 w=1.4 l=0.6
X849 VSS bias_a x2_diff__cc1_0.x2_tail VSS sky130_fd_pr__nfet_01v8 ad=0.406 pd=3.38 as=0.406 ps=3.38 w=1.4 l=0.6
X850 x1_cm_bias_c__cc1_0.x1_m21d x1_cm_bias_c__cc1_0.x1_m21d x1_cm_bias_c__cc1_0.x1_m21d VDD sky130_fd_pr__pfet_01v8_lvt ad=0.406 pd=3.38 as=0 ps=0 w=1.4 l=0.6
X851 x2_cl_src__cc3_0.bias_b x2_cl_src__cc3_0.bias_b x2_cl_casc__cc2_0.bias_c VSS sky130_fd_pr__nfet_01v8_lvt ad=0.406 pd=3.38 as=0.406 ps=3.38 w=1.4 l=0.6
X852 VSS cmc x2_diff__cc1_0.x2_tail VSS sky130_fd_pr__nfet_01v8 ad=0.406 pd=3.38 as=0.406 ps=3.38 w=1.4 l=0.6
X853 x2_cl_casc__cc2_0.bias_c x2_cl_src__cc3_0.bias_b x2_cl_src__cc3_0.bias_b VSS sky130_fd_pr__nfet_01v8_lvt ad=0.406 pd=3.38 as=0.406 ps=3.38 w=1.4 l=0.6
X854 x2_diff__cc1_0.x2_tail bias_a VSS VSS sky130_fd_pr__nfet_01v8 ad=0.406 pd=3.38 as=0.406 ps=3.38 w=1.4 l=0.6
C0 VDD ip 0.00634f
C1 cm x1_cc_cm__strings1_0.x1_net4 0.35345f
C2 cm x1_cc_cm__strings1_0.x1_net11 0.44368f
C3 x2_diff__cc1_0.x2_tail cmc 14.2785f
C4 op ip 0.03641f
C5 x2_cm_casc__cc6_0.bias_d x1_cc_cm__strings1_0.x1_net4 0
C6 VDD x2_diff__cc1_0.x2_tail 0.20546f
C7 cm x1_cc_cm__strings1_0.x1_net5 0.24427f
C8 x2_cm_tail__cc6_0.x2_m4d cmc 0.91201f
C9 x2_cm_casc__cc6_0.bias_d x1_cc_cm__strings1_0.x1_net11 0
C10 x2_cm_casc__cc6_0.bias_d x1_cc_cm__strings1_0.x1_net5 0
C11 x1_cm_bias_c__cc1_0.x1_m21d x1_single_m3__f1_0.x1_m2d 1.50358f
C12 op x2_diff__cc1_0.x2_tail 0.05675f
C13 op x2_cm_tail__cc6_0.x2_m4d 11.5141f
C14 x2_cm_casc__cc6_0.bias_d in 0.00514f
C15 x2_cl_casc__cc2_0.bias_c IBIAS 16.7707f
C16 in bias_a 0.00576f
C17 x1_cm_bias_c__cc1_0.x1_m25d cm 1.63803f
C18 x2_cm_tail__cc6_0.x2_m3d x2_cm_casc__cc6_0.bias_d 3.73338f
C19 x2_cl_src__cc3_0.bias_b IBIAS 0.03913f
C20 x2_cm_tail__cc6_0.x2_m3d bias_a 7.81757f
C21 x2_diff__cc1_0.x2_tail ip 0.3678f
C22 x1_cc_cm__strings1_0.x1_net8 x1_cc_cm__strings1_0.x1_net10 0
C23 x2_diff__cc1_0.x2_foldp in 0.3639f
C24 cm x1_cc_cm__strings1_0.x1_net12 0.60605f
C25 x1_cm_bias_c__cc1_0.x1_m21d VDD 11.2437f
C26 x1_cc_cm__strings1_0.x1_net4 x1_single_m3__f1_0.x1_m2d 0.0033f
C27 x2_cm_casc__cc6_0.bias_d x1_cc_cm__strings1_0.x1_net12 0
C28 x1_cc_cm__strings1_0.x1_net11 x1_single_m3__f1_0.x1_m2d 0.00326f
C29 x2_diff__cc1_0.x2_tail x2_cm_tail__cc6_0.x2_m4d 14.6174f
C30 x1_cc_cm__strings1_0.x1_net5 x1_single_m3__f1_0.x1_m2d 0.00574f
C31 x1_cm_bias_c__cc1_0.x1_m25d x1_cm_bias_c__cc1_0.x1_m31d 4.6579f
C32 x1_cm_bias_c__cc1_0.x1_m25d x1_single_m3__f1_0.x1_m2d 1.16146f
C33 x1_cc_cm__strings1_0.x1_net4 x1_cc_cm__strings1_0.x1_net15 0.00836f
C34 cm IBIAS 0.0054f
C35 x1_single_m5__f1_0.x1_m5d IBIAS 0
C36 x2_cm_casc__cc6_0.bias_d IBIAS 0.01033f
C37 IBIAS bias_a 0.00473f
C38 x1_cc_cm__strings1_0.x1_net12 x1_single_m3__f1_0.x1_m2d 0.003f
C39 VDD in 0.00702f
C40 x1_cc_cm__strings1_0.x1_net13 x1_cc_cm__strings1_0.x1_net14 0.11998f
C41 op in 0.04649f
C42 x2_cm_tail__cc6_0.x2_m3d cmc 0.59767f
C43 x1_cm_bias_c__cc1_0.x1_m25d VDD 9.70801f
C44 x2_cl_casc__cc2_0.bias_c on 1.91906f
C45 x2_cl_casc__cc2_0.bias_c x2_cl_src__cc3_0.bias_b 33.9188f
C46 cm x1_cc_cm__strings1_0.x1_net14 0.24958f
C47 x1_cm_bias_c__cc1_0.x1_m31d IBIAS 0.16411f
C48 x1_cc_cm__strings1_0.x1_net7 x1_cc_cm__strings1_0.x1_net9 0.17279f
C49 x2_cm_tail__cc6_0.x2_m3d op 13.0753f
C50 x1_cc_cm__strings1_0.x1_net2 x1_cc_cm__strings1_0.x1_net14 0.00313f
C51 x2_cm_casc__cc6_0.bias_d x1_cc_cm__strings1_0.x1_net14 0
C52 x2_cl_src__cc3_0.bias_b on 0.0049f
C53 x1_cc_cm__strings1_0.x1_net11 x1_cc_cm__strings1_0.x1_net8 0.00502f
C54 x1_cc_cm__strings1_0.x1_net11 x1_cc_cm__strings1_0.x1_net10 0.24886f
C55 x1_cc_cm__strings1_0.x1_net5 x1_cc_cm__strings1_0.x1_net8 0.00502f
C56 ip in 2.083f
C57 IBIAS x1_single_m3__f1_0.x1_m2d 0.20112f
C58 x2_diff__cc1_0.x2_tail in 0.37195f
C59 x2_cl_casc__cc2_0.bias_c x2_diff__cc1_0.x2_foldn 3.71273f
C60 x1_cc_cm__strings1_0.x1_net7 x1_cc_cm__strings1_0.x1_net6 0.18327f
C61 x2_cm_tail__cc6_0.x2_m4d in 0.08893f
C62 x1_cc_cm__strings1_0.x1_net13 x1_cc_cm__strings1_0.x1_net3 0.00836f
C63 x1_cc_cm__strings1_0.x1_net9 x1_cc_cm__strings1_0.x1_net6 0.00502f
C64 x2_cm_tail__cc6_0.x2_m3d x2_diff__cc1_0.x2_tail 19.7345f
C65 x2_diff__cc1_0.x2_foldn on 4.28797f
C66 x2_diff__cc1_0.x2_foldn x2_cl_src__cc3_0.bias_b 7.39693f
C67 x2_cm_tail__cc6_0.x2_m3d x2_cm_tail__cc6_0.x2_m4d 12.5896f
C68 cm x1_cc_cm__strings1_0.x1_net3 0.24241f
C69 x1_single_m3__f1_0.x1_m2d x1_cc_cm__strings1_0.x1_net14 0.00325f
C70 x2_cl_casc__cc2_0.bias_c cm 1.27916f
C71 x1_cc_cm__strings1_0.x1_net3 x1_cc_cm__strings1_0.x1_net1 0.00836f
C72 x1_cc_cm__strings1_0.x1_net2 x1_cc_cm__strings1_0.x1_net3 0.11998f
C73 x2_cm_casc__cc6_0.bias_d x1_cc_cm__strings1_0.x1_net3 0
C74 VDD IBIAS 0.15739f
C75 x1_cc_cm__strings1_0.x1_net7 cm 0.42265f
C76 x2_cl_casc__cc2_0.bias_c x1_single_m5__f1_0.x1_m5d 0.09157f
C77 x1_cc_cm__strings1_0.x1_net12 x1_cc_cm__strings1_0.x1_net10 0.17281f
C78 x2_cl_casc__cc2_0.bias_c x2_cm_casc__cc6_0.bias_d 2.10616f
C79 x2_cl_casc__cc2_0.bias_c bias_a 0.14552f
C80 x1_cc_cm__strings1_0.x1_net7 x2_cm_casc__cc6_0.bias_d 0
C81 cm x1_cc_cm__strings1_0.x1_net9 0.4063f
C82 x2_cl_src__cc3_0.bias_b cm 0.4532f
C83 x2_cm_casc__cc6_0.bias_d x1_cc_cm__strings1_0.x1_net9 0
C84 x1_single_m5__f1_0.x1_m5d on 0.00346f
C85 x2_cm_casc__cc6_0.bias_d on 6.48022f
C86 x2_cl_src__cc3_0.bias_b x1_single_m5__f1_0.x1_m5d 1.21935f
C87 x2_cl_src__cc3_0.bias_b x2_cm_casc__cc6_0.bias_d 0.94517f
C88 on bias_a 0.07048f
C89 x2_cl_src__cc3_0.bias_b bias_a 0.36768f
C90 x1_cc_cm__strings1_0.x1_net15 x1_cc_cm__strings1_0.x1_net14 0.11998f
C91 x2_cl_casc__cc2_0.bias_c x2_diff__cc1_0.x2_foldp 1.76543f
C92 x2_cl_casc__cc2_0.bias_c x1_cm_bias_c__cc1_0.x1_m31d 0.88233f
C93 x1_cm_bias_c__cc1_0.x1_m25d x1_cm_bias_c__cc1_0.x1_m21d 5.78339f
C94 cm x1_cc_cm__strings1_0.x1_net6 0.40281f
C95 on x2_diff__cc1_0.x2_foldp 8.44726f
C96 x2_cl_src__cc3_0.bias_b x2_diff__cc1_0.x2_foldp 6.33445f
C97 x2_cl_src__cc3_0.bias_b x1_cm_bias_c__cc1_0.x1_m31d 3.24646f
C98 x2_cm_casc__cc6_0.bias_d x1_cc_cm__strings1_0.x1_net6 0
C99 x1_cc_cm__strings1_0.x1_net3 x1_single_m3__f1_0.x1_m2d 0.0033f
C100 x1_cc_cm__strings1_0.x1_net5 x1_cc_cm__strings1_0.x1_net4 0.11892f
C101 x2_diff__cc1_0.x2_foldn x1_single_m5__f1_0.x1_m5d 0.00401f
C102 x2_cl_casc__cc2_0.bias_c x1_single_m3__f1_0.x1_m2d 2.75199f
C103 x2_diff__cc1_0.x2_foldn x2_cm_casc__cc6_0.bias_d 0.44338f
C104 x2_diff__cc1_0.x2_foldn bias_a 0.13869f
C105 x1_cc_cm__strings1_0.x1_net13 cm 0.35353f
C106 x1_cc_cm__strings1_0.x1_net7 x1_single_m3__f1_0.x1_m2d 0.00334f
C107 x1_cc_cm__strings1_0.x1_net13 x2_cm_casc__cc6_0.bias_d 0
C108 x1_cc_cm__strings1_0.x1_net9 x1_single_m3__f1_0.x1_m2d 0.003f
C109 x2_cl_src__cc3_0.bias_b x1_single_m3__f1_0.x1_m2d 0.4975f
C110 cm x1_cc_cm__strings1_0.x1_net1 0.35805f
C111 cm x1_cc_cm__strings1_0.x1_net2 0.25111f
C112 x1_single_m5__f1_0.x1_m5d cm 0.09197f
C113 cm x2_cm_casc__cc6_0.bias_d 0.76168f
C114 cm bias_a 1.09986f
C115 x2_diff__cc1_0.x2_foldn x2_diff__cc1_0.x2_foldp 15.7543f
C116 x1_cc_cm__strings1_0.x1_net2 x1_cc_cm__strings1_0.x1_net1 0.11998f
C117 x2_cm_casc__cc6_0.bias_d x1_cc_cm__strings1_0.x1_net2 0
C118 x2_cm_casc__cc6_0.bias_d x1_cc_cm__strings1_0.x1_net1 0
C119 x1_single_m5__f1_0.x1_m5d x2_cm_casc__cc6_0.bias_d 1.96478f
C120 x1_single_m5__f1_0.x1_m5d bias_a 10.637f
C121 x2_cm_casc__cc6_0.bias_d bias_a 8.12896f
C122 x2_cl_casc__cc2_0.bias_c cmc 0.17423f
C123 x2_cl_casc__cc2_0.bias_c VDD 34.9146f
C124 x1_cm_bias_c__cc1_0.x1_m21d IBIAS 0.02407f
C125 x1_cc_cm__strings1_0.x1_net12 x1_cc_cm__strings1_0.x1_net11 0.28444f
C126 x1_cc_cm__strings1_0.x1_net6 x1_single_m3__f1_0.x1_m2d 0.003f
C127 x2_cl_casc__cc2_0.bias_c op 2.80569f
C128 on cmc 11.19f
C129 x2_cl_src__cc3_0.bias_b cmc 0.00336f
C130 x1_cm_bias_c__cc1_0.x1_m31d cm 1.30148f
C131 VDD on 11.5005f
C132 x2_cl_src__cc3_0.bias_b VDD 47.5258f
C133 x2_cm_casc__cc6_0.bias_d x2_diff__cc1_0.x2_foldp 0.12703f
C134 x1_cc_cm__strings1_0.x1_net13 x1_single_m3__f1_0.x1_m2d 0.0033f
C135 x2_diff__cc1_0.x2_foldp bias_a 0.30052f
C136 op on 9.74896f
C137 x2_cl_src__cc3_0.bias_b op 0.01185f
C138 cm x1_single_m3__f1_0.x1_m2d 4.7843f
C139 x1_cc_cm__strings1_0.x1_net1 x1_single_m3__f1_0.x1_m2d 0.0033f
C140 x1_cc_cm__strings1_0.x1_net2 x1_single_m3__f1_0.x1_m2d 0.00325f
C141 x1_single_m5__f1_0.x1_m5d x1_single_m3__f1_0.x1_m2d 0.03644f
C142 x2_cm_casc__cc6_0.bias_d x1_single_m3__f1_0.x1_m2d 25.2694f
C143 x1_single_m3__f1_0.x1_m2d bias_a 0.61456f
C144 x2_diff__cc1_0.x2_foldn cmc 0.06066f
C145 x1_cc_cm__strings1_0.x1_net7 x1_cc_cm__strings1_0.x1_net8 0.24886f
C146 x2_diff__cc1_0.x2_foldn VDD 27.4805f
C147 on ip 0.06894f
C148 x1_cc_cm__strings1_0.x1_net13 x1_cc_cm__strings1_0.x1_net15 0.00836f
C149 x1_cc_cm__strings1_0.x1_net7 x1_cc_cm__strings1_0.x1_net10 0.00502f
C150 x1_cc_cm__strings1_0.x1_net9 x1_cc_cm__strings1_0.x1_net8 0.28444f
C151 x1_cc_cm__strings1_0.x1_net9 x1_cc_cm__strings1_0.x1_net10 0.18326f
C152 x2_diff__cc1_0.x2_foldn op 3.23614f
C153 x2_diff__cc1_0.x2_tail on 0.08969f
C154 x2_cl_src__cc3_0.bias_b x2_diff__cc1_0.x2_tail 0.005f
C155 cm x1_cc_cm__strings1_0.x1_net15 0.2421f
C156 x2_cm_tail__cc6_0.x2_m4d on 6.27562f
C157 x1_cm_bias_c__cc1_0.x1_m31d x1_single_m3__f1_0.x1_m2d 0.32742f
C158 x2_cm_casc__cc6_0.bias_d x1_cc_cm__strings1_0.x1_net15 0
C159 cm VDD 2.61686f
C160 x1_cm_bias_c__cc1_0.x1_m25d IBIAS 0.36922f
C161 x1_single_m5__f1_0.x1_m5d cmc 0.00244f
C162 x2_cm_casc__cc6_0.bias_d cmc 0.82991f
C163 cmc bias_a 43.8947f
C164 x1_single_m5__f1_0.x1_m5d VDD 0.37551f
C165 x2_cm_casc__cc6_0.bias_d VDD 0.8516f
C166 VDD bias_a 0.61786f
C167 x1_cc_cm__strings1_0.x1_net5 x1_cc_cm__strings1_0.x1_net14 0.00313f
C168 x2_diff__cc1_0.x2_foldn ip 1.32058f
C169 x1_cc_cm__strings1_0.x1_net8 x1_cc_cm__strings1_0.x1_net6 0
C170 x1_single_m5__f1_0.x1_m5d op 0
C171 x2_cm_casc__cc6_0.bias_d op 8.88633f
C172 op bias_a 0.06264f
C173 x2_cl_casc__cc2_0.bias_c x1_cm_bias_c__cc1_0.x1_m21d 0.69652f
C174 x2_diff__cc1_0.x2_foldn x2_diff__cc1_0.x2_tail 4.01965f
C175 x2_diff__cc1_0.x2_foldp cmc 0.05062f
C176 x1_cm_bias_c__cc1_0.x1_m31d VDD 11.849f
C177 VDD x2_diff__cc1_0.x2_foldp 25.8732f
C178 x2_cl_src__cc3_0.bias_b x1_cm_bias_c__cc1_0.x1_m21d 3.65439f
C179 op x2_diff__cc1_0.x2_foldp 4.03266f
C180 cm x1_cc_cm__strings1_0.x1_net8 0.44144f
C181 x2_cm_casc__cc6_0.bias_d ip 0.00553f
C182 ip bias_a 0.0053f
C183 cm x1_cc_cm__strings1_0.x1_net10 0.42367f
C184 x1_cc_cm__strings1_0.x1_net15 x1_single_m3__f1_0.x1_m2d 0.0033f
C185 x2_cm_casc__cc6_0.bias_d x1_cc_cm__strings1_0.x1_net8 0
C186 x2_cm_casc__cc6_0.bias_d x1_cc_cm__strings1_0.x1_net10 0
C187 cmc x1_single_m3__f1_0.x1_m2d 0.00217f
C188 x2_cm_casc__cc6_0.bias_d x2_diff__cc1_0.x2_tail 0.10134f
C189 x2_diff__cc1_0.x2_tail bias_a 22.2098f
C190 VDD x1_single_m3__f1_0.x1_m2d 4.42315f
C191 x2_cm_casc__cc6_0.bias_d x2_cm_tail__cc6_0.x2_m4d 9.53702f
C192 x2_cm_tail__cc6_0.x2_m4d bias_a 16.1397f
C193 x1_cc_cm__strings1_0.x1_net7 x1_cc_cm__strings1_0.x1_net4 0.00385f
C194 x2_diff__cc1_0.x2_foldp ip 0.77079f
C195 x1_cc_cm__strings1_0.x1_net7 x1_cc_cm__strings1_0.x1_net5 0
C196 x1_cc_cm__strings1_0.x1_net11 x1_cc_cm__strings1_0.x1_net9 0
C197 x2_diff__cc1_0.x2_tail x2_diff__cc1_0.x2_foldp 2.58786f
C198 on in 0.07706f
C199 VDD cmc 1.41267f
C200 x1_cm_bias_c__cc1_0.x1_m25d x2_cl_casc__cc2_0.bias_c 0.63332f
C201 x1_cm_bias_c__cc1_0.x1_m21d cm 2.31333f
C202 x1_cc_cm__strings1_0.x1_net8 x1_single_m3__f1_0.x1_m2d 0.00326f
C203 op cmc 11.2554f
C204 x1_cc_cm__strings1_0.x1_net10 x1_single_m3__f1_0.x1_m2d 0.00334f
C205 VDD op 11.4589f
C206 x2_cm_tail__cc6_0.x2_m3d on 13.3335f
C207 x1_cm_bias_c__cc1_0.x1_m25d x2_cl_src__cc3_0.bias_b 3.383f
C208 x1_cc_cm__strings1_0.x1_net4 x1_cc_cm__strings1_0.x1_net6 0.00177f
C209 x1_cc_cm__strings1_0.x1_net5 x1_cc_cm__strings1_0.x1_net6 0.45252f
C210 x1_cc_cm__strings1_0.x1_net12 x1_cc_cm__strings1_0.x1_net9 0.00502f
C211 x1_cm_bias_c__cc1_0.x1_m31d x1_cm_bias_c__cc1_0.x1_m21d 1.87503f
C212 x2_diff__cc1_0.x2_foldn in 0.62087f
C213 x2_cm_tail__cc6_0.x2_m3d VSS 69.91435f
C214 x2_cm_tail__cc6_0.x2_m4d VSS 92.304f
C215 x1_cc_cm__strings1_0.x1_net12 VSS 0.5007f
C216 x1_cc_cm__strings1_0.x1_net11 VSS 0.45257f
C217 x1_cc_cm__strings1_0.x1_net10 VSS 0.23551f
C218 x1_cc_cm__strings1_0.x1_net9 VSS 11.15761f
C219 x1_cc_cm__strings1_0.x1_net8 VSS 11.11349f
C220 x1_cc_cm__strings1_0.x1_net7 VSS 0.2275f
C221 x1_cc_cm__strings1_0.x1_net6 VSS 0.49716f
C222 x1_cc_cm__strings1_0.x1_net5 VSS 0.43723f
C223 x1_cc_cm__strings1_0.x1_net4 VSS 0.20185f
C224 x1_cc_cm__strings1_0.x1_net15 VSS 0.31005f
C225 x1_cc_cm__strings1_0.x1_net14 VSS 0.25182f
C226 x1_cc_cm__strings1_0.x1_net13 VSS 0.19869f
C227 x1_cc_cm__strings1_0.x1_net3 VSS 0.31002f
C228 x1_cc_cm__strings1_0.x1_net2 VSS 0.25817f
C229 x1_cc_cm__strings1_0.x1_net1 VSS 0.20793f
.ends

.end
