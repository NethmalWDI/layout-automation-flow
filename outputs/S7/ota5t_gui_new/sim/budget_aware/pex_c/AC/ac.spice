* ota5t_gui_new on diso_amp_AC
.lib $PDK_ROOT/sky130A/libs.tech/combined/sky130.lib.spice tt
.option rshunt=1e12
.param VDD_V=1.8 VCM_V=0.9 CL_F=1p
.temp 27

**.subckt diso_amp_AC
x1 INP INN net1 VDD 0 OUT dut_amp
Vsup VDD 0 'VDD_V'
Vinp INP 0 dc 'VCM_V' ac 1
* DC unity feedback through a 1 GH choke, INN held at AC ground by 1 F (loop open from 1 Hz up)
Lfb OUT INN 1G
Cfb INN 0 1
Cload OUT 0 'CL_F'
.control
  save all
  ac dec 40 1 1G
  let hsig = v(OUT)
  let hdb = db(hsig)
  let gph_deg = 180/pi * cph(hsig)
  meas ac gain_db find hdb at=1
  meas ac gbw_hz  when hdb=0
  meas ac ph_dc   find gph_deg at=1
  meas ac ph_ugb  find gph_deg when hdb=0
  let gbw_mhz = gbw_hz / 1e6
  let ph_ref  = 180 * floor(ph_dc / 180 + 0.5)
  let pm_deg  = 180 + (ph_ugb - ph_ref)
  echo MEAS gain_db $&gain_db
  echo MEAS gbw_mhz $&gbw_mhz
  echo MEAS pm_deg $&pm_deg
  write
  quit 0
.endc
**.ends

.subckt dut_amp INP INN OUTN VDD VSS OUTP
XDUT OUTP INN INP N_VBIAS VDD VSS N_net3 N_net1 ota5t_gui_new_routed_flat
VV1_layout N_VBIAS VSS 0.75
.ends
.subckt example_ota_5t_sized VDD OUTP INP INN VSS
XM3 net3 net3 VDD VDD sky130_fd_pr__pfet_01v8 L=1 W=8 NF=1 AD=2.32 AS=2.32 PD=16.58 PS=16.58 NRD=0.03625 NRS=0.03625 SA=0 SB=0 SD=0 MULT=1
XM4 OUTP net3 VDD VDD sky130_fd_pr__pfet_01v8 L=1 W=8 NF=1 AD=2.32 AS=2.32 PD=16.58 PS=16.58 NRD=0.03625 NRS=0.03625 SA=0 SB=0 SD=0 MULT=1
XM1 net3 INP net1 VSS sky130_fd_pr__nfet_01v8 L=0.5 W=24 NF=1 AD=6.96 AS=6.96 PD=48.58 PS=48.58 NRD=0.0120833333333333 NRS=0.0120833333333333 SA=0 SB=0 SD=0 MULT=1
XM2 OUTP INN net1 VSS sky130_fd_pr__nfet_01v8 L=0.5 W=24 NF=1 AD=6.96 AS=6.96 PD=48.58 PS=48.58 NRD=0.0120833333333333 NRS=0.0120833333333333 SA=0 SB=0 SD=0 MULT=1
XM5 net1 net2 VSS VSS sky130_fd_pr__nfet_01v8 L=1 W=24 NF=1 AD=6.96 AS=6.96 PD=48.58 PS=48.58 NRD=0.0120833333333333 NRS=0.0120833333333333 SA=0 SB=0 SD=0 MULT=1
V1 net2 VSS 0.75
.ends example_ota_5t_sized
* NGSPICE file created from ota5t_gui_new_routed_flat.ext - technology: sky130A

.subckt ota5t_gui_new_routed_flat OUTP INN INP VBIAS VDD VSS XM4__A_0.net3 XM5__A_0.net1
X0 XM5__A_0.net1 INN OUTP VSS sky130_fd_pr__nfet_01v8 ad=3.48 pd=24.58 as=1.74 ps=12.29 w=12 l=0.5
X1 VSS VBIAS XM5__A_0.net1 VSS sky130_fd_pr__nfet_01v8 ad=6.96 pd=48.58 as=6.96 ps=48.58 w=24 l=1
X2 XM5__A_0.net1 INP XM4__A_0.net3 VSS sky130_fd_pr__nfet_01v8 ad=3.48 pd=24.58 as=1.74 ps=12.29 w=12 l=0.5
X3 VDD XM4__A_0.net3 OUTP VDD sky130_fd_pr__pfet_01v8 ad=2.32 pd=16.58 as=2.32 ps=16.58 w=8 l=1
X4 OUTP INN XM5__A_0.net1 VSS sky130_fd_pr__nfet_01v8 ad=1.74 pd=12.29 as=3.48 ps=24.58 w=12 l=0.5
X5 VDD XM4__A_0.net3 XM4__A_0.net3 VDD sky130_fd_pr__pfet_01v8 ad=2.32 pd=16.58 as=2.32 ps=16.58 w=8 l=1
X6 XM4__A_0.net3 INP XM5__A_0.net1 VSS sky130_fd_pr__nfet_01v8 ad=1.74 pd=12.29 as=3.48 ps=24.58 w=12 l=0.5
C0 XM4__A_0.net3 VDD 4.69561f
C1 XM5__A_0.net1 VDD 0.00135f
C2 OUTP XM4__A_0.net3 0.5999f
C3 INP INN 0.00748f
C4 OUTP XM5__A_0.net1 1.31921f
C5 XM4__A_0.net3 XM5__A_0.net1 1.31927f
C6 INP VDD 0.00614f
C7 INP OUTP 0
C8 INN VDD 0.00638f
C9 OUTP INN 1.08914f
C10 INP XM4__A_0.net3 1.08922f
C11 INP XM5__A_0.net1 1.46619f
C12 XM4__A_0.net3 INN 0
C13 OUTP VDD 1.55476f
C14 INN XM5__A_0.net1 1.43088f
C15 XM5__A_0.net1 VBIAS 1.37812f
C16 XM5__A_0.net1 VSS 10.4881f
C17 OUTP VSS 3.97229f
C18 VDD VSS 21.7631f
.ends

.end
