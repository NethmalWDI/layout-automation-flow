* iadc_ota on dido_amp_AC
.lib $PDK_ROOT/sky130A/libs.tech/combined/sky130.lib.spice tt
.option rshunt=1e12
.param VDD_V=1.8 VCM_V=0.9 CL_F=0.3p
.temp 27

**.subckt dido_amp_AC
x1 INP INN OUTN VDD 0 OUTP dut_amp
Vsup VDD 0 'VDD_V'
* AC drive through 1 F couplers; DC set by unity feedback through 1 GH chokes (OUTP->INN, OUTN->INP)
Vacp ACP 0 dc 0 ac 0.5
Vacn ACN 0 dc 0 ac -0.5
Cinp ACP INP 1
Cinn ACN INN 1
Lfbp OUTP INN 1G
Lfbn OUTN INP 1G
Cloadp OUTP 0 'CL_F'
Cloadn OUTN 0 'CL_F'
.control
  save all
  ac dec 40 1 1G
  let hsig = v(OUTP) - v(OUTN)
  let hdb = db(hsig)
  let gph_deg = 180/pi * cph(hsig)
  meas ac gain_db find hdb at=1
  meas ac gbw_hz  when hdb=0
  meas ac ph_dc   find gph_deg at=1
  meas ac ph_ugb  find gph_deg when hdb=0
  let gbw_mhz = gbw_hz / 1e6
  let pm_deg  = 180 + (ph_ugb - ph_dc)
  echo MEAS gain_db $&gain_db
  echo MEAS gbw_mhz $&gbw_mhz
  echo MEAS pm_deg $&pm_deg
  write
  quit 0
.endc
**.ends

.subckt dut_amp INP INN OUTN VDD VSS OUTP
XDUT OUTN OUTP bias_a_w cm_w N_IBIAS VDD VSS cmc_w INN INP N_x2_tail N_x2_m3d N_x2_m4d N_x2_foldn N_x2_foldp N_x1_net5 N_x1_net6 N_x1_net8 N_x1_net9 N_x1_net11 N_x1_net12 N_x1_m2d N_bias_d N_x1_m5d N_x1_net4 N_x1_net7 N_x1_net10 N_x1_net14 N_x1_net15 N_x1_net2 N_x1_net3 N_bias_b N_bias_c N_x1_net13 N_x1_net1 N_x1_m21d N_x1_m25d N_x1_m31d iadc_ota_routed_flat
* ideal CMFB: the steady-state law of the upstream switched-capacitor CMFB (ASSUMPTION)
Bcmfb cmc_w VSS V = v(bias_a_w) + (v(OUTP) + v(OUTN))/2 - v(cm_w)
IIbias_ext_layout VDD N_IBIAS 3e-05
.ends
.subckt iadc_ota ip in op on VDD VSS cmc cm bias_a
XX1_M22 bias_b bias_c x1_m21d VDD sky130_fd_pr__pfet_01v8 L=0.6 W=1.4 NF=1 AD=0.406 AS=0.406 PD=3.38 PS=3.38 NRD=0.207143 NRS=0.207143 SA=0 SB=0 SD=0 MULT=6 M=6
XX1_M26 x1_m2d bias_c x1_m25d VDD sky130_fd_pr__pfet_01v8 L=0.6 W=1.4 NF=1 AD=0.406 AS=0.406 PD=3.38 PS=3.38 NRD=0.207143 NRS=0.207143 SA=0 SB=0 SD=0 MULT=6 M=6
XX1_M32 cm bias_c x1_m31d VDD sky130_fd_pr__pfet_01v8 L=0.6 W=1.4 NF=1 AD=0.406 AS=0.406 PD=3.38 PS=3.38 NRD=0.207143 NRS=0.207143 SA=0 SB=0 SD=0 MULT=6 M=6
XX1_M21 x1_m21d bias_b VDD VDD sky130_fd_pr__pfet_01v8_lvt L=0.6 W=1.4 NF=1 AD=0.406 AS=0.406 PD=3.38 PS=3.38 NRD=0.207143 NRS=0.207143 SA=0 SB=0 SD=0 MULT=6 M=6
XX1_M25 x1_m25d bias_b VDD VDD sky130_fd_pr__pfet_01v8_lvt L=0.6 W=1.4 NF=1 AD=0.406 AS=0.406 PD=3.38 PS=3.38 NRD=0.207143 NRS=0.207143 SA=0 SB=0 SD=0 MULT=6 M=6
XX1_M31 x1_m31d bias_b VDD VDD sky130_fd_pr__pfet_01v8_lvt L=0.6 W=1.4 NF=1 AD=0.406 AS=0.406 PD=3.38 PS=3.38 NRD=0.207143 NRS=0.207143 SA=0 SB=0 SD=0 MULT=6 M=6
XX1_M1 bias_b bias_b bias_c VSS sky130_fd_pr__nfet_01v8_lvt L=0.6 W=1.4 NF=1 AD=0.406 AS=0.406 PD=3.38 PS=3.38 NRD=0.207143 NRS=0.207143 SA=0 SB=0 SD=0 MULT=56 M=56
XX1_M2 x1_m2d x1_m2d bias_d VSS sky130_fd_pr__nfet_01v8 L=0.6 W=1.4 NF=1 AD=0.406 AS=0.406 PD=3.38 PS=3.38 NRD=0.207143 NRS=0.207143 SA=0 SB=0 SD=0 MULT=50 M=50
XX1_M3 bias_d x1_m2d bias_a VSS sky130_fd_pr__nfet_01v8 L=0.6 W=1.4 NF=1 AD=0.406 AS=0.406 PD=3.38 PS=3.38 NRD=0.207143 NRS=0.207143 SA=0 SB=0 SD=0 MULT=2 M=2
XX1_M4 bias_a bias_d x1_m5d VSS sky130_fd_pr__nfet_01v8 L=0.6 W=1.4 NF=1 AD=0.406 AS=0.406 PD=3.38 PS=3.38 NRD=0.207143 NRS=0.207143 SA=0 SB=0 SD=0 MULT=18 M=18
XX1_M5 x1_m5d bias_a VSS VSS sky130_fd_pr__nfet_01v8 L=0.6 W=1.4 NF=1 AD=0.406 AS=0.406 PD=3.38 PS=3.38 NRD=0.207143 NRS=0.207143 SA=0 SB=0 SD=0 MULT=18 M=18
XX1_M6 bias_c i_bias VSS VSS sky130_fd_pr__nfet_01v8 L=0.6 W=1.4 NF=1 AD=0.406 AS=0.406 PD=3.38 PS=3.38 NRD=0.207143 NRS=0.207143 SA=0 SB=0 SD=0 MULT=18 M=18
XX1_M7 i_bias i_bias VSS VSS sky130_fd_pr__nfet_01v8 L=0.6 W=1.4 NF=1 AD=0.406 AS=0.406 PD=3.38 PS=3.38 NRD=0.207143 NRS=0.207143 SA=0 SB=0 SD=0 MULT=18 M=18
XX1_M33 cm cm x1_net1 VSS sky130_fd_pr__nfet_01v8 L=0.6 W=1.4 NF=1 AD=0.406 AS=0.406 PD=3.38 PS=3.38 NRD=0.207143 NRS=0.207143 SA=0 SB=0 SD=0 MULT=1 M=1
XX1_M49 x1_net1 cm x1_net2 VSS sky130_fd_pr__nfet_01v8 L=0.6 W=1.4 NF=1 AD=0.406 AS=0.406 PD=3.38 PS=3.38 NRD=0.207143 NRS=0.207143 SA=0 SB=0 SD=0 MULT=1 M=1
XX1_M50 x1_net2 cm x1_net3 VSS sky130_fd_pr__nfet_01v8 L=0.6 W=1.4 NF=1 AD=0.406 AS=0.406 PD=3.38 PS=3.38 NRD=0.207143 NRS=0.207143 SA=0 SB=0 SD=0 MULT=1 M=1
XX1_M63 x1_net3 cm VSS VSS sky130_fd_pr__nfet_01v8 L=0.6 W=1.4 NF=1 AD=0.406 AS=0.406 PD=3.38 PS=3.38 NRD=0.207143 NRS=0.207143 SA=0 SB=0 SD=0 MULT=1 M=1
XX1_M68 cm cm x1_net4 VSS sky130_fd_pr__nfet_01v8 L=0.6 W=1.4 NF=1 AD=0.406 AS=0.406 PD=3.38 PS=3.38 NRD=0.207143 NRS=0.207143 SA=0 SB=0 SD=0 MULT=1 M=1
XX1_M69 x1_net4 cm x1_net5 VSS sky130_fd_pr__nfet_01v8 L=0.6 W=1.4 NF=1 AD=0.406 AS=0.406 PD=3.38 PS=3.38 NRD=0.207143 NRS=0.207143 SA=0 SB=0 SD=0 MULT=1 M=1
XX1_M70 x1_net5 cm x1_net6 VSS sky130_fd_pr__nfet_01v8 L=0.6 W=1.4 NF=1 AD=0.406 AS=0.406 PD=3.38 PS=3.38 NRD=0.207143 NRS=0.207143 SA=0 SB=0 SD=0 MULT=1 M=1
XX1_M71 x1_net6 cm VSS VSS sky130_fd_pr__nfet_01v8 L=0.6 W=1.4 NF=1 AD=0.406 AS=0.406 PD=3.38 PS=3.38 NRD=0.207143 NRS=0.207143 SA=0 SB=0 SD=0 MULT=1 M=1
XX1_M72 cm cm x1_net7 VSS sky130_fd_pr__nfet_01v8 L=0.6 W=1.4 NF=1 AD=0.406 AS=0.406 PD=3.38 PS=3.38 NRD=0.207143 NRS=0.207143 SA=0 SB=0 SD=0 MULT=1 M=1
XX1_M73 x1_net7 cm x1_net8 VSS sky130_fd_pr__nfet_01v8 L=0.6 W=1.4 NF=1 AD=0.406 AS=0.406 PD=3.38 PS=3.38 NRD=0.207143 NRS=0.207143 SA=0 SB=0 SD=0 MULT=1 M=1
XX1_M74 x1_net8 cm x1_net9 VSS sky130_fd_pr__nfet_01v8 L=0.6 W=1.4 NF=1 AD=0.406 AS=0.406 PD=3.38 PS=3.38 NRD=0.207143 NRS=0.207143 SA=0 SB=0 SD=0 MULT=1 M=1
XX1_M75 x1_net9 cm VSS VSS sky130_fd_pr__nfet_01v8 L=0.6 W=1.4 NF=1 AD=0.406 AS=0.406 PD=3.38 PS=3.38 NRD=0.207143 NRS=0.207143 SA=0 SB=0 SD=0 MULT=1 M=1
XX1_M76 cm cm x1_net10 VSS sky130_fd_pr__nfet_01v8 L=0.6 W=1.4 NF=1 AD=0.406 AS=0.406 PD=3.38 PS=3.38 NRD=0.207143 NRS=0.207143 SA=0 SB=0 SD=0 MULT=1 M=1
XX1_M77 x1_net10 cm x1_net11 VSS sky130_fd_pr__nfet_01v8 L=0.6 W=1.4 NF=1 AD=0.406 AS=0.406 PD=3.38 PS=3.38 NRD=0.207143 NRS=0.207143 SA=0 SB=0 SD=0 MULT=1 M=1
XX1_M78 x1_net11 cm x1_net12 VSS sky130_fd_pr__nfet_01v8 L=0.6 W=1.4 NF=1 AD=0.406 AS=0.406 PD=3.38 PS=3.38 NRD=0.207143 NRS=0.207143 SA=0 SB=0 SD=0 MULT=1 M=1
XX1_M79 x1_net12 cm VSS VSS sky130_fd_pr__nfet_01v8 L=0.6 W=1.4 NF=1 AD=0.406 AS=0.406 PD=3.38 PS=3.38 NRD=0.207143 NRS=0.207143 SA=0 SB=0 SD=0 MULT=1 M=1
XX1_M64 cm cm x1_net13 VSS sky130_fd_pr__nfet_01v8 L=0.6 W=1.4 NF=1 AD=0.406 AS=0.406 PD=3.38 PS=3.38 NRD=0.207143 NRS=0.207143 SA=0 SB=0 SD=0 MULT=1 M=1
XX1_M65 x1_net13 cm x1_net14 VSS sky130_fd_pr__nfet_01v8 L=0.6 W=1.4 NF=1 AD=0.406 AS=0.406 PD=3.38 PS=3.38 NRD=0.207143 NRS=0.207143 SA=0 SB=0 SD=0 MULT=1 M=1
XX1_M66 x1_net14 cm x1_net15 VSS sky130_fd_pr__nfet_01v8 L=0.6 W=1.4 NF=1 AD=0.406 AS=0.406 PD=3.38 PS=3.38 NRD=0.207143 NRS=0.207143 SA=0 SB=0 SD=0 MULT=1 M=1
XX1_M67 x1_net15 cm VSS VSS sky130_fd_pr__nfet_01v8 L=0.6 W=1.4 NF=1 AD=0.406 AS=0.406 PD=3.38 PS=3.38 NRD=0.207143 NRS=0.207143 SA=0 SB=0 SD=0 MULT=1 M=1
XX1_M57 bias_b VDD VDD VDD sky130_fd_pr__pfet_01v8 L=0.6 W=1.4 NF=1 AD=0.406 AS=0.406 PD=3.38 PS=3.38 NRD=0.207143 NRS=0.207143 SA=0 SB=0 SD=0 MULT=2 M=2
XX1_M58 x1_m2d VDD VDD VDD sky130_fd_pr__pfet_01v8 L=0.6 W=1.4 NF=1 AD=0.406 AS=0.406 PD=3.38 PS=3.38 NRD=0.207143 NRS=0.207143 SA=0 SB=0 SD=0 MULT=2 M=2
XX1_M59 cm VDD VDD VDD sky130_fd_pr__pfet_01v8 L=0.6 W=1.4 NF=1 AD=0.406 AS=0.406 PD=3.38 PS=3.38 NRD=0.207143 NRS=0.207143 SA=0 SB=0 SD=0 MULT=2 M=2
XX1_M60 x1_m31d VDD VDD VDD sky130_fd_pr__pfet_01v8 L=0.6 W=1.4 NF=1 AD=0.406 AS=0.406 PD=3.38 PS=3.38 NRD=0.207143 NRS=0.207143 SA=0 SB=0 SD=0 MULT=2 M=2
XX1_M42 x1_m5d VSS VSS VSS sky130_fd_pr__nfet_01v8 L=0.6 W=1.4 NF=1 AD=0.406 AS=0.406 PD=3.38 PS=3.38 NRD=0.207143 NRS=0.207143 SA=0 SB=0 SD=0 MULT=6 M=6
XX1_M44 bias_c bias_c bias_c VSS sky130_fd_pr__nfet_01v8 L=0.6 W=1.4 NF=1 AD=0.406 AS=0.406 PD=3.38 PS=3.38 NRD=0.207143 NRS=0.207143 SA=0 SB=0 SD=0 MULT=2 M=2
XX1_M34 bias_d bias_d bias_d VSS sky130_fd_pr__nfet_01v8 L=0.6 W=1.4 NF=1 AD=0.406 AS=0.406 PD=3.38 PS=3.38 NRD=0.207143 NRS=0.207143 SA=0 SB=0 SD=0 MULT=8 M=8
XX1_M35 x1_m2d x1_m2d x1_m2d VSS sky130_fd_pr__nfet_01v8 L=0.6 W=1.4 NF=1 AD=0.406 AS=0.406 PD=3.38 PS=3.38 NRD=0.207143 NRS=0.207143 SA=0 SB=0 SD=0 MULT=2 M=2
XX1_M36 bias_a bias_a bias_a VSS sky130_fd_pr__nfet_01v8 L=0.6 W=1.4 NF=1 AD=0.406 AS=0.406 PD=3.38 PS=3.38 NRD=0.207143 NRS=0.207143 SA=0 SB=0 SD=0 MULT=4 M=4
XX1_M37 cm cm cm VSS sky130_fd_pr__nfet_01v8 L=0.6 W=1.4 NF=1 AD=0.406 AS=0.406 PD=3.38 PS=3.38 NRD=0.207143 NRS=0.207143 SA=0 SB=0 SD=0 MULT=8 M=8
XX1_M54 x1_m25d x1_m25d x1_m25d VDD sky130_fd_pr__pfet_01v8 L=0.6 W=1.4 NF=1 AD=0.406 AS=0.406 PD=3.38 PS=3.38 NRD=0.207143 NRS=0.207143 SA=0 SB=0 SD=0 MULT=2 M=2
XX1_M29 x1_m5d x1_m5d x1_m5d VSS sky130_fd_pr__nfet_01v8 L=0.6 W=1.4 NF=1 AD=0.406 AS=0.406 PD=3.38 PS=3.38 NRD=0.207143 NRS=0.207143 SA=0 SB=0 SD=0 MULT=6 M=6
XX1_M8 i_bias i_bias i_bias VSS sky130_fd_pr__nfet_01v8 L=0.6 W=1.4 NF=1 AD=0.406 AS=0.406 PD=3.38 PS=3.38 NRD=0.207143 NRS=0.207143 SA=0 SB=0 SD=0 MULT=2 M=2
XX1_M10 bias_c bias_c bias_c VSS sky130_fd_pr__nfet_01v8_lvt L=0.6 W=1.4 NF=1 AD=0.406 AS=0.406 PD=3.38 PS=3.38 NRD=0.207143 NRS=0.207143 SA=0 SB=0 SD=0 MULT=8 M=8
XX1_M27 bias_b bias_b bias_b VSS sky130_fd_pr__nfet_01v8_lvt L=0.6 W=1.4 NF=1 AD=0.406 AS=0.406 PD=3.38 PS=3.38 NRD=0.207143 NRS=0.207143 SA=0 SB=0 SD=0 MULT=8 M=8
XX1_M46 x1_m21d x1_m21d x1_m21d VDD sky130_fd_pr__pfet_01v8_lvt L=0.6 W=1.4 NF=1 AD=0.406 AS=0.406 PD=3.38 PS=3.38 NRD=0.207143 NRS=0.207143 SA=0 SB=0 SD=0 MULT=2 M=2
XX1_M47 x1_m25d x1_m25d x1_m25d VDD sky130_fd_pr__pfet_01v8_lvt L=0.6 W=1.4 NF=1 AD=0.406 AS=0.406 PD=3.38 PS=3.38 NRD=0.207143 NRS=0.207143 SA=0 SB=0 SD=0 MULT=2 M=2
XX1_M48 x1_m31d x1_m31d x1_m31d VDD sky130_fd_pr__pfet_01v8_lvt L=0.6 W=1.4 NF=1 AD=0.406 AS=0.406 PD=3.38 PS=3.38 NRD=0.207143 NRS=0.207143 SA=0 SB=0 SD=0 MULT=2 M=2
XX1_M51 x1_m21d x1_m21d x1_m21d VDD sky130_fd_pr__pfet_01v8 L=0.6 W=1.4 NF=1 AD=0.406 AS=0.406 PD=3.38 PS=3.38 NRD=0.207143 NRS=0.207143 SA=0 SB=0 SD=0 MULT=2 M=2
XX2_M1 x2_foldp ip x2_tail VSS sky130_fd_pr__nfet_01v8_lvt L=0.2 W=1.2 NF=1 AD=0.348 AS=0.348 PD=2.98 PS=2.98 NRD=0.241667 NRS=0.241667 SA=0 SB=0 SD=0 MULT=6 M=6
XX2_M2 x2_foldn in x2_tail VSS sky130_fd_pr__nfet_01v8_lvt L=0.2 W=1.2 NF=1 AD=0.348 AS=0.348 PD=2.98 PS=2.98 NRD=0.241667 NRS=0.241667 SA=0 SB=0 SD=0 MULT=6 M=6
XX2_M6 x2_tail cmc VSS VSS sky130_fd_pr__nfet_01v8 L=0.6 W=1.4 NF=1 AD=0.406 AS=0.406 PD=3.38 PS=3.38 NRD=0.207143 NRS=0.207143 SA=0 SB=0 SD=0 MULT=96 M=96
XX2_M5 x2_tail bias_a VSS VSS sky130_fd_pr__nfet_01v8 L=0.6 W=1.4 NF=1 AD=0.406 AS=0.406 PD=3.38 PS=3.38 NRD=0.207143 NRS=0.207143 SA=0 SB=0 SD=0 MULT=96 M=96
XX2_M11 x2_foldp bias_b VDD VDD sky130_fd_pr__pfet_01v8_lvt L=0.6 W=1.4 NF=1 AD=0.406 AS=0.406 PD=3.38 PS=3.38 NRD=0.207143 NRS=0.207143 SA=0 SB=0 SD=0 MULT=24 M=24
XX2_M12 x2_foldn bias_b VDD VDD sky130_fd_pr__pfet_01v8_lvt L=0.6 W=1.4 NF=1 AD=0.406 AS=0.406 PD=3.38 PS=3.38 NRD=0.207143 NRS=0.207143 SA=0 SB=0 SD=0 MULT=24 M=24
XX2_M1A on bias_c x2_foldp VDD sky130_fd_pr__pfet_01v8 L=0.6 W=1.4 NF=1 AD=0.406 AS=0.406 PD=3.38 PS=3.38 NRD=0.207143 NRS=0.207143 SA=0 SB=0 SD=0 MULT=20 M=20
XX2_M8 op bias_c x2_foldn VDD sky130_fd_pr__pfet_01v8 L=0.6 W=1.4 NF=1 AD=0.406 AS=0.406 PD=3.38 PS=3.38 NRD=0.207143 NRS=0.207143 SA=0 SB=0 SD=0 MULT=20 M=20
XX2_M3A on bias_d x2_m3d VSS sky130_fd_pr__nfet_01v8 L=0.6 W=1.4 NF=1 AD=0.406 AS=0.406 PD=3.38 PS=3.38 NRD=0.207143 NRS=0.207143 SA=0 SB=0 SD=0 MULT=36 M=36
XX2_M7 op bias_d x2_m4d VSS sky130_fd_pr__nfet_01v8 L=0.6 W=1.4 NF=1 AD=0.406 AS=0.406 PD=3.38 PS=3.38 NRD=0.207143 NRS=0.207143 SA=0 SB=0 SD=0 MULT=36 M=36
XX2_M3 x2_m3d bias_a VSS VSS sky130_fd_pr__nfet_01v8 L=0.6 W=1.4 NF=1 AD=0.406 AS=0.406 PD=3.38 PS=3.38 NRD=0.207143 NRS=0.207143 SA=0 SB=0 SD=0 MULT=36 M=36
XX2_M4 x2_m4d bias_a VSS VSS sky130_fd_pr__nfet_01v8 L=0.6 W=1.4 NF=1 AD=0.406 AS=0.406 PD=3.38 PS=3.38 NRD=0.207143 NRS=0.207143 SA=0 SB=0 SD=0 MULT=36 M=36
XX2_M82 x2_foldn x2_foldn x2_foldn VDD sky130_fd_pr__pfet_01v8 L=0.6 W=1.4 NF=1 AD=0.406 AS=0.406 PD=3.38 PS=3.38 NRD=0.207143 NRS=0.207143 SA=0 SB=0 SD=0 MULT=2 M=2
XX2_M83 x2_foldp x2_foldp x2_foldp VDD sky130_fd_pr__pfet_01v8 L=0.6 W=1.4 NF=1 AD=0.406 AS=0.406 PD=3.38 PS=3.38 NRD=0.207143 NRS=0.207143 SA=0 SB=0 SD=0 MULT=2 M=2
XX2_M55 x2_foldn VDD VDD VDD sky130_fd_pr__pfet_01v8 L=0.6 W=1.4 NF=1 AD=0.406 AS=0.406 PD=3.38 PS=3.38 NRD=0.207143 NRS=0.207143 SA=0 SB=0 SD=0 MULT=2 M=2
XX2_M56 op VDD VDD VDD sky130_fd_pr__pfet_01v8 L=0.6 W=1.4 NF=1 AD=0.406 AS=0.406 PD=3.38 PS=3.38 NRD=0.207143 NRS=0.207143 SA=0 SB=0 SD=0 MULT=4 M=4
XX2_M61 x2_foldp VDD VDD VDD sky130_fd_pr__pfet_01v8 L=0.6 W=1.4 NF=1 AD=0.406 AS=0.406 PD=3.38 PS=3.38 NRD=0.207143 NRS=0.207143 SA=0 SB=0 SD=0 MULT=2 M=2
XX2_M62 on VDD VDD VDD sky130_fd_pr__pfet_01v8 L=0.6 W=1.4 NF=1 AD=0.406 AS=0.406 PD=3.38 PS=3.38 NRD=0.207143 NRS=0.207143 SA=0 SB=0 SD=0 MULT=4 M=4
XX2_M40 x2_m4d VSS VSS VSS sky130_fd_pr__nfet_01v8 L=0.6 W=1.4 NF=1 AD=0.406 AS=0.406 PD=3.38 PS=3.38 NRD=0.207143 NRS=0.207143 SA=0 SB=0 SD=0 MULT=6 M=6
XX2_M41 x2_m3d VSS VSS VSS sky130_fd_pr__nfet_01v8 L=0.6 W=1.4 NF=1 AD=0.406 AS=0.406 PD=3.38 PS=3.38 NRD=0.207143 NRS=0.207143 SA=0 SB=0 SD=0 MULT=8 M=8
XX2_M38 op op op VSS sky130_fd_pr__nfet_01v8 L=0.6 W=1.4 NF=1 AD=0.406 AS=0.406 PD=3.38 PS=3.38 NRD=0.207143 NRS=0.207143 SA=0 SB=0 SD=0 MULT=2 M=2
XX2_M39 on on on VSS sky130_fd_pr__nfet_01v8 L=0.6 W=1.4 NF=1 AD=0.406 AS=0.406 PD=3.38 PS=3.38 NRD=0.207143 NRS=0.207143 SA=0 SB=0 SD=0 MULT=2 M=2
XX2_M30 x2_tail VSS VSS VSS sky130_fd_pr__nfet_01v8 L=0.6 W=1.4 NF=1 AD=0.406 AS=0.406 PD=3.38 PS=3.38 NRD=0.207143 NRS=0.207143 SA=0 SB=0 SD=0 MULT=2 M=2
XX2_M23 x2_foldp x2_foldp x2_foldp VSS sky130_fd_pr__nfet_01v8_lvt L=0.2 W=1.2 NF=1 AD=0.348 AS=0.348 PD=2.98 PS=2.98 NRD=0.241667 NRS=0.241667 SA=0 SB=0 SD=0 MULT=2 M=2
XX2_M24 x2_foldn x2_foldn x2_foldn VSS sky130_fd_pr__nfet_01v8_lvt L=0.2 W=1.2 NF=1 AD=0.348 AS=0.348 PD=2.98 PS=2.98 NRD=0.241667 NRS=0.241667 SA=0 SB=0 SD=0 MULT=2 M=2
XX2_M80 op VSS VSS VSS sky130_fd_pr__nfet_01v8 L=0.6 W=1.4 NF=1 AD=0.406 AS=0.406 PD=3.38 PS=3.38 NRD=0.207143 NRS=0.207143 SA=0 SB=0 SD=0 MULT=2 M=2
XX2_M81 on VSS VSS VSS sky130_fd_pr__nfet_01v8 L=0.6 W=1.4 NF=1 AD=0.406 AS=0.406 PD=3.38 PS=3.38 NRD=0.207143 NRS=0.207143 SA=0 SB=0 SD=0 MULT=2 M=2
XX2_M28 x2_tail x2_tail x2_tail VSS sky130_fd_pr__nfet_01v8 L=0.6 W=1.4 NF=1 AD=0.406 AS=0.406 PD=3.38 PS=3.38 NRD=0.207143 NRS=0.207143 SA=0 SB=0 SD=0 MULT=6 M=6
XM43 VDD VDD VDD VDD sky130_fd_pr__pfet_01v8_lvt L=0.6 W=1.4 NF=1 AD=0.406 AS=0.406 PD=3.38 PS=3.38 NRD=0.207143 NRS=0.207143 SA=0 SB=0 SD=0 MULT=8 M=8
XM45 VDD VDD VDD VDD sky130_fd_pr__pfet_01v8 L=0.6 W=1.4 NF=1 AD=0.406 AS=0.406 PD=3.38 PS=3.38 NRD=0.207143 NRS=0.207143 SA=0 SB=0 SD=0 MULT=6 M=6
XM9 VSS VSS VSS VSS sky130_fd_pr__nfet_01v8 L=0.6 W=1.4 NF=1 AD=0.406 AS=0.406 PD=3.38 PS=3.38 NRD=0.207143 NRS=0.207143 SA=0 SB=0 SD=0 MULT=23 M=23
Ibias_ext VDD i_bias 3e-05
XC3 op cmc sky130_fd_pr__cap_mim_m3_1 W=4.8 L=4.8 MF=4 M=4
XC4 on cmc sky130_fd_pr__cap_mim_m3_1 W=4.8 L=4.8 MF=4 M=4
.ends iadc_ota
* NGSPICE file created from iadc_ota_routed_flat.ext - technology: sky130A

.subckt iadc_ota_routed_flat on op bias_a cm IBIAS VDD VSS cmc in ip nmos_single_5__A_0.x2_tail
+ nmos_dummy_19__A_0.x2_m3d nmos_dummy_18__A_0.x2_m4d pmos_dummy_16__A_0.x2_foldn
+ pmos_dummy_17__A_0.x2_foldp nmos_matched_cascode_pair_5__AB_0.x1_net5 nmos_matched_cascode_pair_5__AB_0.x1_net6
+ nmos_matched_cascode_pair_7__AB_0.x1_net8 nmos_matched_cascode_pair_7__AB_0.x1_net9
+ nmos_matched_cascode_pair_9__AB_0.x1_net11 nmos_matched_cascode_pair_9__AB_0.x1_net12
+ nmos_single__A_0.x1_m2d nmos_single__A_0.bias_d nmos_dummy_9__A_0.x1_m5d nmos_matched_cascode_pair_4__AB_0.x1_net4
+ nmos_matched_cascode_pair_6__AB_0.x1_net7 nmos_matched_cascode_pair_8__AB_0.x1_net10
+ nmos_matched_cascode_pair_11__AB_0.x1_net14 nmos_matched_cascode_pair_11__AB_0.x1_net15
+ nmos_matched_cascode_pair_3__AB_0.x1_net2 nmos_matched_cascode_pair_3__AB_0.x1_net3
+ nmos_diode__A_0.bias_b nmos_diode__A_0.bias_c nmos_matched_cascode_pair_10__AB_0.x1_net13
+ nmos_matched_cascode_pair_2__AB_0.x1_net1 pmos_dummy_6__A_0.x1_m21d pmos_dummy_7__A_0.x1_m25d
+ pmos_single__A_0.x1_m31d
X0 VSS cmc nmos_single_5__A_0.x2_tail VSS sky130_fd_pr__nfet_01v8 ad=0.406 pd=3.38 as=0.406 ps=3.38 w=1.4 l=0.6
X1 VSS bias_a nmos_dummy_19__A_0.x2_m3d VSS sky130_fd_pr__nfet_01v8 ad=0.406 pd=3.38 as=0.406 ps=3.38 w=1.4 l=0.6
X2 IBIAS IBIAS VSS VSS sky130_fd_pr__nfet_01v8 ad=0.406 pd=3.38 as=0.406 ps=3.38 w=1.4 l=0.6
X3 VDD VDD on VDD sky130_fd_pr__pfet_01v8 ad=0.406 pd=3.38 as=0.406 ps=3.38 w=1.4 l=0.6
X4 VSS bias_a nmos_dummy_19__A_0.x2_m3d VSS sky130_fd_pr__nfet_01v8 ad=0.406 pd=3.38 as=0.406 ps=3.38 w=1.4 l=0.6
X5 nmos_matched_cascode_pair_11__AB_0.x1_net15 cm nmos_matched_cascode_pair_11__AB_0.x1_net14 VSS sky130_fd_pr__nfet_01v8 ad=0.406 pd=3.38 as=0.406 ps=3.38 w=1.4 l=0.6
X6 pmos_single__A_0.x1_m31d nmos_diode__A_0.bias_c cm VDD sky130_fd_pr__pfet_01v8 ad=0.406 pd=3.38 as=0.406 ps=3.38 w=1.4 l=0.6
X7 VSS VSS nmos_dummy_18__A_0.x2_m4d VSS sky130_fd_pr__nfet_01v8 ad=0.406 pd=3.38 as=0.406 ps=3.38 w=1.4 l=0.6
X8 VSS bias_a nmos_dummy_18__A_0.x2_m4d VSS sky130_fd_pr__nfet_01v8 ad=0.406 pd=3.38 as=0.406 ps=3.38 w=1.4 l=0.6
X9 VDD nmos_diode__A_0.bias_b pmos_single__A_0.x1_m31d VDD sky130_fd_pr__pfet_01v8_lvt ad=0.406 pd=3.38 as=0.406 ps=3.38 w=1.4 l=0.6
X10 nmos_dummy_9__A_0.x1_m5d nmos_dummy_9__A_0.x1_m5d nmos_dummy_9__A_0.x1_m5d VSS sky130_fd_pr__nfet_01v8 ad=0.406 pd=3.38 as=21.924 ps=182.52 w=1.4 l=0.6
X11 VSS cmc nmos_single_5__A_0.x2_tail VSS sky130_fd_pr__nfet_01v8 ad=0.406 pd=3.38 as=0.406 ps=3.38 w=1.4 l=0.6
X12 VSS bias_a nmos_dummy_18__A_0.x2_m4d VSS sky130_fd_pr__nfet_01v8 ad=0.406 pd=3.38 as=0.406 ps=3.38 w=1.4 l=0.6
X13 VSS VSS VSS VSS sky130_fd_pr__nfet_01v8 ad=0.406 pd=3.38 as=182.87399 ps=1.52278k w=1.4 l=0.6
X14 op nmos_single__A_0.bias_d nmos_dummy_18__A_0.x2_m4d VSS sky130_fd_pr__nfet_01v8 ad=0.406 pd=3.38 as=0.406 ps=3.38 w=1.4 l=0.6
X15 VDD nmos_diode__A_0.bias_b pmos_dummy_16__A_0.x2_foldn VDD sky130_fd_pr__pfet_01v8_lvt ad=0.406 pd=3.38 as=0.406 ps=3.38 w=1.4 l=0.6
X16 nmos_diode__A_0.bias_c nmos_diode__A_0.bias_b nmos_diode__A_0.bias_b VSS sky130_fd_pr__nfet_01v8_lvt ad=0.406 pd=3.38 as=0.406 ps=3.38 w=1.4 l=0.6
X17 nmos_single__A_0.bias_d nmos_single__A_0.x1_m2d nmos_single__A_0.x1_m2d VSS sky130_fd_pr__nfet_01v8 ad=0.406 pd=3.38 as=0.406 ps=3.38 w=1.4 l=0.6
X18 VSS VSS VSS VSS sky130_fd_pr__nfet_01v8 ad=0.406 pd=3.38 as=0 ps=0 w=1.4 l=0.6
X19 VSS cmc nmos_single_5__A_0.x2_tail VSS sky130_fd_pr__nfet_01v8 ad=0.406 pd=3.38 as=0.406 ps=3.38 w=1.4 l=0.6
X20 VSS VSS VSS VSS sky130_fd_pr__nfet_01v8 ad=0.406 pd=3.38 as=0 ps=0 w=1.4 l=0.6
X21 pmos_dummy_16__A_0.x2_foldn nmos_diode__A_0.bias_c op VDD sky130_fd_pr__pfet_01v8 ad=0.406 pd=3.38 as=0.406 ps=3.38 w=1.4 l=0.6
X22 VSS bias_a nmos_single_5__A_0.x2_tail VSS sky130_fd_pr__nfet_01v8 ad=0.406 pd=3.38 as=0.406 ps=3.38 w=1.4 l=0.6
X23 nmos_diode__A_0.bias_c IBIAS VSS VSS sky130_fd_pr__nfet_01v8 ad=0.406 pd=3.38 as=0.406 ps=3.38 w=1.4 l=0.6
X24 nmos_dummy_19__A_0.x2_m3d nmos_single__A_0.bias_d on VSS sky130_fd_pr__nfet_01v8 ad=0.406 pd=3.38 as=0.406 ps=3.38 w=1.4 l=0.6
X25 nmos_single_5__A_0.x2_tail in pmos_dummy_16__A_0.x2_foldn VSS sky130_fd_pr__nfet_01v8_lvt ad=0.348 pd=2.98 as=0.348 ps=2.98 w=1.2 l=0.2
X26 VSS bias_a nmos_dummy_19__A_0.x2_m3d VSS sky130_fd_pr__nfet_01v8 ad=0.406 pd=3.38 as=0.406 ps=3.38 w=1.4 l=0.6
X27 op nmos_single__A_0.bias_d nmos_dummy_18__A_0.x2_m4d VSS sky130_fd_pr__nfet_01v8 ad=0.406 pd=3.38 as=0.406 ps=3.38 w=1.4 l=0.6
X28 VSS VSS VSS VSS sky130_fd_pr__nfet_01v8 ad=0.406 pd=3.38 as=0 ps=0 w=1.4 l=0.6
X29 op op op VSS sky130_fd_pr__nfet_01v8 ad=0.406 pd=3.38 as=17.052 ps=141.96001 w=1.4 l=0.6
X30 nmos_dummy_18__A_0.x2_m4d nmos_single__A_0.bias_d op VSS sky130_fd_pr__nfet_01v8 ad=0.406 pd=3.38 as=0.406 ps=3.38 w=1.4 l=0.6
X31 VSS cmc nmos_single_5__A_0.x2_tail VSS sky130_fd_pr__nfet_01v8 ad=0.406 pd=3.38 as=0.406 ps=3.38 w=1.4 l=0.6
X32 bias_a nmos_single__A_0.x1_m2d nmos_single__A_0.bias_d VSS sky130_fd_pr__nfet_01v8 ad=0.406 pd=3.38 as=0.406 ps=3.38 w=1.4 l=0.6
X33 VDD nmos_diode__A_0.bias_b pmos_dummy_17__A_0.x2_foldp VDD sky130_fd_pr__pfet_01v8_lvt ad=0.406 pd=3.38 as=0.406 ps=3.38 w=1.4 l=0.6
X34 on nmos_single__A_0.bias_d nmos_dummy_19__A_0.x2_m3d VSS sky130_fd_pr__nfet_01v8 ad=0.406 pd=3.38 as=0.406 ps=3.38 w=1.4 l=0.6
X35 VSS bias_a nmos_single_5__A_0.x2_tail VSS sky130_fd_pr__nfet_01v8 ad=0.406 pd=3.38 as=0.406 ps=3.38 w=1.4 l=0.6
X36 VSS bias_a nmos_dummy_18__A_0.x2_m4d VSS sky130_fd_pr__nfet_01v8 ad=0.406 pd=3.38 as=0.406 ps=3.38 w=1.4 l=0.6
X37 nmos_diode__A_0.bias_c nmos_diode__A_0.bias_b nmos_diode__A_0.bias_b VSS sky130_fd_pr__nfet_01v8_lvt ad=0.406 pd=3.38 as=0.406 ps=3.38 w=1.4 l=0.6
X38 nmos_diode__A_0.bias_c nmos_diode__A_0.bias_b nmos_diode__A_0.bias_b VSS sky130_fd_pr__nfet_01v8_lvt ad=0.406 pd=3.38 as=0.406 ps=3.38 w=1.4 l=0.6
X39 nmos_single__A_0.bias_d nmos_single__A_0.x1_m2d nmos_single__A_0.x1_m2d VSS sky130_fd_pr__nfet_01v8 ad=0.406 pd=3.38 as=0.406 ps=3.38 w=1.4 l=0.6
X40 nmos_diode__A_0.bias_b nmos_diode__A_0.bias_b nmos_diode__A_0.bias_b VSS sky130_fd_pr__nfet_01v8_lvt ad=0.406 pd=3.38 as=29.232 ps=243.36 w=1.4 l=0.6
X41 nmos_diode__A_0.bias_c nmos_diode__A_0.bias_b nmos_diode__A_0.bias_b VSS sky130_fd_pr__nfet_01v8_lvt ad=0.406 pd=3.38 as=0.406 ps=3.38 w=1.4 l=0.6
X42 nmos_diode__A_0.bias_c nmos_diode__A_0.bias_b nmos_diode__A_0.bias_b VSS sky130_fd_pr__nfet_01v8_lvt ad=0.406 pd=3.38 as=0.406 ps=3.38 w=1.4 l=0.6
X43 VSS bias_a nmos_single_5__A_0.x2_tail VSS sky130_fd_pr__nfet_01v8 ad=0.406 pd=3.38 as=0.406 ps=3.38 w=1.4 l=0.6
X44 VDD VDD VDD VDD sky130_fd_pr__pfet_01v8 ad=0.406 pd=3.38 as=52.78 ps=439.39999 w=1.4 l=0.6
X45 VSS bias_a nmos_dummy_19__A_0.x2_m3d VSS sky130_fd_pr__nfet_01v8 ad=0.406 pd=3.38 as=0.406 ps=3.38 w=1.4 l=0.6
X46 nmos_single__A_0.bias_d nmos_single__A_0.x1_m2d nmos_single__A_0.x1_m2d VSS sky130_fd_pr__nfet_01v8 ad=0.406 pd=3.38 as=0.406 ps=3.38 w=1.4 l=0.6
X47 VSS bias_a nmos_single_5__A_0.x2_tail VSS sky130_fd_pr__nfet_01v8 ad=0.406 pd=3.38 as=0.406 ps=3.38 w=1.4 l=0.6
X48 VSS bias_a nmos_single_5__A_0.x2_tail VSS sky130_fd_pr__nfet_01v8 ad=0.406 pd=3.38 as=0.406 ps=3.38 w=1.4 l=0.6
X49 VSS bias_a nmos_single_5__A_0.x2_tail VSS sky130_fd_pr__nfet_01v8 ad=0.406 pd=3.38 as=0.406 ps=3.38 w=1.4 l=0.6
X50 nmos_dummy_19__A_0.x2_m3d nmos_single__A_0.bias_d on VSS sky130_fd_pr__nfet_01v8 ad=0.406 pd=3.38 as=0.406 ps=3.38 w=1.4 l=0.6
X51 VSS VSS VSS VSS sky130_fd_pr__nfet_01v8 ad=0.406 pd=3.38 as=0 ps=0 w=1.4 l=0.6
X52 pmos_dummy_7__A_0.x1_m25d pmos_dummy_7__A_0.x1_m25d pmos_dummy_7__A_0.x1_m25d VDD sky130_fd_pr__pfet_01v8 ad=0.406 pd=3.38 as=8.12 ps=67.6 w=1.4 l=0.6
X53 cm cm cm VSS sky130_fd_pr__nfet_01v8 ad=0.406 pd=3.38 as=8.526 ps=70.98 w=1.4 l=0.6
X54 pmos_dummy_16__A_0.x2_foldn nmos_diode__A_0.bias_c op VDD sky130_fd_pr__pfet_01v8 ad=0.406 pd=3.38 as=0.406 ps=3.38 w=1.4 l=0.6
X55 VSS VSS VSS VSS sky130_fd_pr__nfet_01v8 ad=0.406 pd=3.38 as=0 ps=0 w=1.4 l=0.6
X56 VSS IBIAS IBIAS VSS sky130_fd_pr__nfet_01v8 ad=0.406 pd=3.38 as=0.406 ps=3.38 w=1.4 l=0.6
X57 VSS VSS VSS VSS sky130_fd_pr__nfet_01v8 ad=0.406 pd=3.38 as=0 ps=0 w=1.4 l=0.6
X58 nmos_single__A_0.bias_d nmos_single__A_0.x1_m2d nmos_single__A_0.x1_m2d VSS sky130_fd_pr__nfet_01v8 ad=0.406 pd=3.38 as=0.406 ps=3.38 w=1.4 l=0.6
X59 VSS bias_a nmos_dummy_19__A_0.x2_m3d VSS sky130_fd_pr__nfet_01v8 ad=0.406 pd=3.38 as=0.406 ps=3.38 w=1.4 l=0.6
X60 nmos_dummy_9__A_0.x1_m5d nmos_single__A_0.bias_d bias_a VSS sky130_fd_pr__nfet_01v8 ad=0.406 pd=3.38 as=0.406 ps=3.38 w=1.4 l=0.6
X61 VSS cmc nmos_single_5__A_0.x2_tail VSS sky130_fd_pr__nfet_01v8 ad=0.406 pd=3.38 as=0.406 ps=3.38 w=1.4 l=0.6
X62 VSS bias_a nmos_single_5__A_0.x2_tail VSS sky130_fd_pr__nfet_01v8 ad=0.406 pd=3.38 as=0.406 ps=3.38 w=1.4 l=0.6
X63 VDD VDD op VDD sky130_fd_pr__pfet_01v8 ad=0.406 pd=3.38 as=0.406 ps=3.38 w=1.4 l=0.6
X64 VSS VSS nmos_single_5__A_0.x2_tail VSS sky130_fd_pr__nfet_01v8 ad=0.406 pd=3.38 as=0.406 ps=3.38 w=1.4 l=0.6
X65 VDD nmos_diode__A_0.bias_b pmos_dummy_7__A_0.x1_m25d VDD sky130_fd_pr__pfet_01v8_lvt ad=0.406 pd=3.38 as=0.406 ps=3.38 w=1.4 l=0.6
X66 nmos_dummy_18__A_0.x2_m4d nmos_single__A_0.bias_d op VSS sky130_fd_pr__nfet_01v8 ad=0.406 pd=3.38 as=0.406 ps=3.38 w=1.4 l=0.6
X67 VSS bias_a nmos_dummy_9__A_0.x1_m5d VSS sky130_fd_pr__nfet_01v8 ad=0.406 pd=3.38 as=0.406 ps=3.38 w=1.4 l=0.6
X68 VSS cmc nmos_single_5__A_0.x2_tail VSS sky130_fd_pr__nfet_01v8 ad=0.406 pd=3.38 as=0.406 ps=3.38 w=1.4 l=0.6
X69 pmos_dummy_17__A_0.x2_foldp nmos_diode__A_0.bias_c on VDD sky130_fd_pr__pfet_01v8 ad=0.406 pd=3.38 as=0.406 ps=3.38 w=1.4 l=0.6
X70 op nmos_single__A_0.bias_d nmos_dummy_18__A_0.x2_m4d VSS sky130_fd_pr__nfet_01v8 ad=0.406 pd=3.38 as=0.406 ps=3.38 w=1.4 l=0.6
X71 pmos_single__A_0.x1_m31d pmos_single__A_0.x1_m31d pmos_single__A_0.x1_m31d VDD sky130_fd_pr__pfet_01v8_lvt ad=0.406 pd=3.38 as=7.308 ps=60.84 w=1.4 l=0.6
X72 nmos_diode__A_0.bias_c nmos_diode__A_0.bias_c nmos_diode__A_0.bias_c VSS sky130_fd_pr__nfet_01v8_lvt ad=0.406 pd=3.38 as=38.164 ps=317.72 w=1.4 l=0.6
X73 nmos_single__A_0.bias_d nmos_single__A_0.bias_d nmos_single__A_0.bias_d VSS sky130_fd_pr__nfet_01v8 ad=0.406 pd=3.38 as=27.608 ps=229.84 w=1.4 l=0.6
X74 op cmc sky130_fd_pr__cap_mim_m3_1 l=4.8 w=4.8
X75 op cmc sky130_fd_pr__cap_mim_m3_1 l=4.8 w=4.8
X76 VSS cmc nmos_single_5__A_0.x2_tail VSS sky130_fd_pr__nfet_01v8 ad=0.406 pd=3.38 as=0.406 ps=3.38 w=1.4 l=0.6
X77 VSS cmc nmos_single_5__A_0.x2_tail VSS sky130_fd_pr__nfet_01v8 ad=0.406 pd=3.38 as=0.406 ps=3.38 w=1.4 l=0.6
X78 VSS bias_a nmos_single_5__A_0.x2_tail VSS sky130_fd_pr__nfet_01v8 ad=0.406 pd=3.38 as=0.406 ps=3.38 w=1.4 l=0.6
X79 nmos_dummy_19__A_0.x2_m3d nmos_single__A_0.bias_d on VSS sky130_fd_pr__nfet_01v8 ad=0.406 pd=3.38 as=0.406 ps=3.38 w=1.4 l=0.6
X80 VSS bias_a nmos_dummy_19__A_0.x2_m3d VSS sky130_fd_pr__nfet_01v8 ad=0.406 pd=3.38 as=0.406 ps=3.38 w=1.4 l=0.6
X81 pmos_dummy_7__A_0.x1_m25d nmos_diode__A_0.bias_c nmos_single__A_0.x1_m2d VDD sky130_fd_pr__pfet_01v8 ad=0.406 pd=3.38 as=0.406 ps=3.38 w=1.4 l=0.6
X82 VSS bias_a nmos_dummy_9__A_0.x1_m5d VSS sky130_fd_pr__nfet_01v8 ad=0.406 pd=3.38 as=0.406 ps=3.38 w=1.4 l=0.6
X83 VSS cmc nmos_single_5__A_0.x2_tail VSS sky130_fd_pr__nfet_01v8 ad=0.406 pd=3.38 as=0.406 ps=3.38 w=1.4 l=0.6
X84 nmos_diode__A_0.bias_c nmos_diode__A_0.bias_b nmos_diode__A_0.bias_b VSS sky130_fd_pr__nfet_01v8_lvt ad=0.406 pd=3.38 as=0.406 ps=3.38 w=1.4 l=0.6
X85 pmos_dummy_17__A_0.x2_foldp nmos_diode__A_0.bias_c on VDD sky130_fd_pr__pfet_01v8 ad=0.406 pd=3.38 as=0.406 ps=3.38 w=1.4 l=0.6
X86 VSS bias_a nmos_single_5__A_0.x2_tail VSS sky130_fd_pr__nfet_01v8 ad=0.406 pd=3.38 as=0.406 ps=3.38 w=1.4 l=0.6
X87 nmos_diode__A_0.bias_c IBIAS VSS VSS sky130_fd_pr__nfet_01v8 ad=0.406 pd=3.38 as=0.406 ps=3.38 w=1.4 l=0.6
X88 VSS cmc nmos_single_5__A_0.x2_tail VSS sky130_fd_pr__nfet_01v8 ad=0.406 pd=3.38 as=0.406 ps=3.38 w=1.4 l=0.6
X89 VSS bias_a nmos_single_5__A_0.x2_tail VSS sky130_fd_pr__nfet_01v8 ad=0.406 pd=3.38 as=0.406 ps=3.38 w=1.4 l=0.6
X90 VDD nmos_diode__A_0.bias_b pmos_dummy_16__A_0.x2_foldn VDD sky130_fd_pr__pfet_01v8_lvt ad=0.406 pd=3.38 as=0.406 ps=3.38 w=1.4 l=0.6
X91 VSS VSS nmos_dummy_19__A_0.x2_m3d VSS sky130_fd_pr__nfet_01v8 ad=0.406 pd=3.38 as=0.406 ps=3.38 w=1.4 l=0.6
X92 nmos_dummy_9__A_0.x1_m5d nmos_single__A_0.bias_d bias_a VSS sky130_fd_pr__nfet_01v8 ad=0.406 pd=3.38 as=0.406 ps=3.38 w=1.4 l=0.6
X93 VDD nmos_diode__A_0.bias_b pmos_dummy_17__A_0.x2_foldp VDD sky130_fd_pr__pfet_01v8_lvt ad=0.406 pd=3.38 as=0.406 ps=3.38 w=1.4 l=0.6
X94 VDD VDD VDD VDD sky130_fd_pr__pfet_01v8 ad=0.406 pd=3.38 as=0 ps=0 w=1.4 l=0.6
X95 VSS cmc nmos_single_5__A_0.x2_tail VSS sky130_fd_pr__nfet_01v8 ad=0.406 pd=3.38 as=0.406 ps=3.38 w=1.4 l=0.6
X96 VSS cmc nmos_single_5__A_0.x2_tail VSS sky130_fd_pr__nfet_01v8 ad=0.406 pd=3.38 as=0.406 ps=3.38 w=1.4 l=0.6
X97 nmos_diode__A_0.bias_c nmos_diode__A_0.bias_b nmos_diode__A_0.bias_b VSS sky130_fd_pr__nfet_01v8_lvt ad=0.406 pd=3.38 as=0.406 ps=3.38 w=1.4 l=0.6
X98 nmos_single__A_0.bias_d nmos_single__A_0.x1_m2d nmos_single__A_0.x1_m2d VSS sky130_fd_pr__nfet_01v8 ad=0.406 pd=3.38 as=0.406 ps=3.38 w=1.4 l=0.6
X99 nmos_single__A_0.bias_d nmos_single__A_0.x1_m2d nmos_single__A_0.x1_m2d VSS sky130_fd_pr__nfet_01v8 ad=0.406 pd=3.38 as=0.406 ps=3.38 w=1.4 l=0.6
X100 VSS VSS VSS VSS sky130_fd_pr__nfet_01v8 ad=0.406 pd=3.38 as=0 ps=0 w=1.4 l=0.6
X101 VDD VDD pmos_dummy_17__A_0.x2_foldp VDD sky130_fd_pr__pfet_01v8 ad=0.406 pd=3.38 as=0.406 ps=3.38 w=1.4 l=0.6
X102 nmos_dummy_19__A_0.x2_m3d nmos_single__A_0.bias_d on VSS sky130_fd_pr__nfet_01v8 ad=0.406 pd=3.38 as=0.406 ps=3.38 w=1.4 l=0.6
X103 VSS bias_a nmos_single_5__A_0.x2_tail VSS sky130_fd_pr__nfet_01v8 ad=0.406 pd=3.38 as=0.406 ps=3.38 w=1.4 l=0.6
X104 VSS bias_a nmos_single_5__A_0.x2_tail VSS sky130_fd_pr__nfet_01v8 ad=0.406 pd=3.38 as=0.406 ps=3.38 w=1.4 l=0.6
X105 VSS bias_a nmos_single_5__A_0.x2_tail VSS sky130_fd_pr__nfet_01v8 ad=0.406 pd=3.38 as=0.406 ps=3.38 w=1.4 l=0.6
X106 nmos_single_5__A_0.x2_tail nmos_single_5__A_0.x2_tail nmos_single_5__A_0.x2_tail VSS sky130_fd_pr__nfet_01v8 ad=0.406 pd=3.38 as=87.812 ps=732.03998 w=1.4 l=0.6
X107 VSS bias_a nmos_dummy_19__A_0.x2_m3d VSS sky130_fd_pr__nfet_01v8 ad=0.406 pd=3.38 as=0.406 ps=3.38 w=1.4 l=0.6
X108 nmos_single_5__A_0.x2_tail ip pmos_dummy_17__A_0.x2_foldp VSS sky130_fd_pr__nfet_01v8_lvt ad=0.348 pd=2.98 as=0.348 ps=2.98 w=1.2 l=0.2
X109 on on on VSS sky130_fd_pr__nfet_01v8 ad=0.406 pd=3.38 as=17.052 ps=141.96001 w=1.4 l=0.6
X110 IBIAS IBIAS VSS VSS sky130_fd_pr__nfet_01v8 ad=0.406 pd=3.38 as=0.406 ps=3.38 w=1.4 l=0.6
X111 VDD VDD pmos_dummy_16__A_0.x2_foldn VDD sky130_fd_pr__pfet_01v8 ad=0.406 pd=3.38 as=0.406 ps=3.38 w=1.4 l=0.6
X112 bias_a bias_a bias_a VSS sky130_fd_pr__nfet_01v8 ad=0.406 pd=3.38 as=11.368 ps=94.64 w=1.4 l=0.6
X113 VSS bias_a nmos_single_5__A_0.x2_tail VSS sky130_fd_pr__nfet_01v8 ad=0.406 pd=3.38 as=0.406 ps=3.38 w=1.4 l=0.6
X114 VSS bias_a nmos_dummy_18__A_0.x2_m4d VSS sky130_fd_pr__nfet_01v8 ad=0.406 pd=3.38 as=0.406 ps=3.38 w=1.4 l=0.6
X115 nmos_diode__A_0.bias_b nmos_diode__A_0.bias_b nmos_diode__A_0.bias_b VSS sky130_fd_pr__nfet_01v8_lvt ad=0.406 pd=3.38 as=0 ps=0 w=1.4 l=0.6
X116 pmos_dummy_16__A_0.x2_foldn nmos_diode__A_0.bias_c op VDD sky130_fd_pr__pfet_01v8 ad=0.406 pd=3.38 as=0.406 ps=3.38 w=1.4 l=0.6
X117 nmos_diode__A_0.bias_c nmos_diode__A_0.bias_b nmos_diode__A_0.bias_b VSS sky130_fd_pr__nfet_01v8_lvt ad=0.406 pd=3.38 as=0.406 ps=3.38 w=1.4 l=0.6
X118 nmos_diode__A_0.bias_c IBIAS VSS VSS sky130_fd_pr__nfet_01v8 ad=0.406 pd=3.38 as=0.406 ps=3.38 w=1.4 l=0.6
X119 nmos_diode__A_0.bias_c nmos_diode__A_0.bias_b nmos_diode__A_0.bias_b VSS sky130_fd_pr__nfet_01v8_lvt ad=0.406 pd=3.38 as=0.406 ps=3.38 w=1.4 l=0.6
X120 nmos_diode__A_0.bias_c nmos_diode__A_0.bias_b nmos_diode__A_0.bias_b VSS sky130_fd_pr__nfet_01v8_lvt ad=0.406 pd=3.38 as=0.406 ps=3.38 w=1.4 l=0.6
X121 nmos_dummy_19__A_0.x2_m3d nmos_single__A_0.bias_d on VSS sky130_fd_pr__nfet_01v8 ad=0.406 pd=3.38 as=0.406 ps=3.38 w=1.4 l=0.6
X122 VSS cmc nmos_single_5__A_0.x2_tail VSS sky130_fd_pr__nfet_01v8 ad=0.406 pd=3.38 as=0.406 ps=3.38 w=1.4 l=0.6
X123 VSS bias_a nmos_dummy_18__A_0.x2_m4d VSS sky130_fd_pr__nfet_01v8 ad=0.406 pd=3.38 as=0.406 ps=3.38 w=1.4 l=0.6
X124 VSS VSS VSS VSS sky130_fd_pr__nfet_01v8 ad=0.406 pd=3.38 as=0 ps=0 w=1.4 l=0.6
X125 cm cm cm VSS sky130_fd_pr__nfet_01v8 ad=0.406 pd=3.38 as=0 ps=0 w=1.4 l=0.6
X126 VDD nmos_diode__A_0.bias_b pmos_dummy_16__A_0.x2_foldn VDD sky130_fd_pr__pfet_01v8_lvt ad=0.406 pd=3.38 as=0.406 ps=3.38 w=1.4 l=0.6
X127 VSS cmc nmos_single_5__A_0.x2_tail VSS sky130_fd_pr__nfet_01v8 ad=0.406 pd=3.38 as=0.406 ps=3.38 w=1.4 l=0.6
X128 pmos_dummy_7__A_0.x1_m25d pmos_dummy_7__A_0.x1_m25d pmos_dummy_7__A_0.x1_m25d VDD sky130_fd_pr__pfet_01v8_lvt ad=0.406 pd=3.38 as=0 ps=0 w=1.4 l=0.6
X129 pmos_dummy_17__A_0.x2_foldp nmos_diode__A_0.bias_c on VDD sky130_fd_pr__pfet_01v8 ad=0.406 pd=3.38 as=0.406 ps=3.38 w=1.4 l=0.6
X130 VSS bias_a nmos_dummy_9__A_0.x1_m5d VSS sky130_fd_pr__nfet_01v8 ad=0.406 pd=3.38 as=0.406 ps=3.38 w=1.4 l=0.6
X131 pmos_dummy_17__A_0.x2_foldp nmos_diode__A_0.bias_c on VDD sky130_fd_pr__pfet_01v8 ad=0.406 pd=3.38 as=0.406 ps=3.38 w=1.4 l=0.6
X132 VSS cmc nmos_single_5__A_0.x2_tail VSS sky130_fd_pr__nfet_01v8 ad=0.406 pd=3.38 as=0.406 ps=3.38 w=1.4 l=0.6
X133 VSS IBIAS nmos_diode__A_0.bias_c VSS sky130_fd_pr__nfet_01v8 ad=0.406 pd=3.38 as=0.406 ps=3.38 w=1.4 l=0.6
X134 nmos_dummy_18__A_0.x2_m4d nmos_single__A_0.bias_d op VSS sky130_fd_pr__nfet_01v8 ad=0.406 pd=3.38 as=0.406 ps=3.38 w=1.4 l=0.6
X135 VSS bias_a nmos_dummy_19__A_0.x2_m3d VSS sky130_fd_pr__nfet_01v8 ad=0.406 pd=3.38 as=0.406 ps=3.38 w=1.4 l=0.6
X136 VSS cmc nmos_single_5__A_0.x2_tail VSS sky130_fd_pr__nfet_01v8 ad=0.406 pd=3.38 as=0.406 ps=3.38 w=1.4 l=0.6
X137 VSS bias_a nmos_single_5__A_0.x2_tail VSS sky130_fd_pr__nfet_01v8 ad=0.406 pd=3.38 as=0.406 ps=3.38 w=1.4 l=0.6
X138 pmos_dummy_16__A_0.x2_foldn nmos_diode__A_0.bias_c op VDD sky130_fd_pr__pfet_01v8 ad=0.406 pd=3.38 as=0.406 ps=3.38 w=1.4 l=0.6
X139 VDD VDD pmos_single__A_0.x1_m31d VDD sky130_fd_pr__pfet_01v8 ad=0.406 pd=3.38 as=0.406 ps=3.38 w=1.4 l=0.6
X140 VSS bias_a nmos_dummy_9__A_0.x1_m5d VSS sky130_fd_pr__nfet_01v8 ad=0.406 pd=3.38 as=0.406 ps=3.38 w=1.4 l=0.6
X141 VSS VSS VSS VSS sky130_fd_pr__nfet_01v8 ad=0.406 pd=3.38 as=0 ps=0 w=1.4 l=0.6
X142 nmos_matched_cascode_pair_5__AB_0.x1_net6 cm nmos_matched_cascode_pair_5__AB_0.x1_net5 VSS sky130_fd_pr__nfet_01v8 ad=0.406 pd=3.38 as=0.406 ps=3.38 w=1.4 l=0.6
X143 on nmos_single__A_0.bias_d nmos_dummy_19__A_0.x2_m3d VSS sky130_fd_pr__nfet_01v8 ad=0.406 pd=3.38 as=0.406 ps=3.38 w=1.4 l=0.6
X144 VSS cmc nmos_single_5__A_0.x2_tail VSS sky130_fd_pr__nfet_01v8 ad=0.406 pd=3.38 as=0.406 ps=3.38 w=1.4 l=0.6
X145 VSS VSS VSS VSS sky130_fd_pr__nfet_01v8 ad=0.406 pd=3.38 as=0 ps=0 w=1.4 l=0.6
X146 VSS cmc nmos_single_5__A_0.x2_tail VSS sky130_fd_pr__nfet_01v8 ad=0.406 pd=3.38 as=0.406 ps=3.38 w=1.4 l=0.6
X147 pmos_dummy_7__A_0.x1_m25d nmos_diode__A_0.bias_b VDD VDD sky130_fd_pr__pfet_01v8_lvt ad=0.406 pd=3.38 as=0.406 ps=3.38 w=1.4 l=0.6
X148 nmos_single__A_0.bias_d nmos_single__A_0.x1_m2d nmos_single__A_0.x1_m2d VSS sky130_fd_pr__nfet_01v8 ad=0.406 pd=3.38 as=0.406 ps=3.38 w=1.4 l=0.6
X149 VSS VSS VSS VSS sky130_fd_pr__nfet_01v8 ad=0.406 pd=3.38 as=0 ps=0 w=1.4 l=0.6
X150 nmos_single_5__A_0.x2_tail ip pmos_dummy_17__A_0.x2_foldp VSS sky130_fd_pr__nfet_01v8_lvt ad=0.348 pd=2.98 as=0.348 ps=2.98 w=1.2 l=0.2
X151 VSS bias_a nmos_dummy_18__A_0.x2_m4d VSS sky130_fd_pr__nfet_01v8 ad=0.406 pd=3.38 as=0.406 ps=3.38 w=1.4 l=0.6
X152 VDD nmos_diode__A_0.bias_b pmos_dummy_16__A_0.x2_foldn VDD sky130_fd_pr__pfet_01v8_lvt ad=0.406 pd=3.38 as=0.406 ps=3.38 w=1.4 l=0.6
X153 nmos_diode__A_0.bias_c nmos_diode__A_0.bias_b nmos_diode__A_0.bias_b VSS sky130_fd_pr__nfet_01v8_lvt ad=0.406 pd=3.38 as=0.406 ps=3.38 w=1.4 l=0.6
X154 nmos_single__A_0.bias_d nmos_single__A_0.x1_m2d nmos_single__A_0.x1_m2d VSS sky130_fd_pr__nfet_01v8 ad=0.406 pd=3.38 as=0.406 ps=3.38 w=1.4 l=0.6
X155 op nmos_single__A_0.bias_d nmos_dummy_18__A_0.x2_m4d VSS sky130_fd_pr__nfet_01v8 ad=0.406 pd=3.38 as=0.406 ps=3.38 w=1.4 l=0.6
X156 pmos_dummy_6__A_0.x1_m21d nmos_diode__A_0.bias_b VDD VDD sky130_fd_pr__pfet_01v8_lvt ad=0.406 pd=3.38 as=0.406 ps=3.38 w=1.4 l=0.6
X157 nmos_diode__A_0.bias_c nmos_diode__A_0.bias_b nmos_diode__A_0.bias_b VSS sky130_fd_pr__nfet_01v8_lvt ad=0.406 pd=3.38 as=0.406 ps=3.38 w=1.4 l=0.6
X158 IBIAS IBIAS VSS VSS sky130_fd_pr__nfet_01v8 ad=0.406 pd=3.38 as=0.406 ps=3.38 w=1.4 l=0.6
X159 VSS bias_a nmos_dummy_18__A_0.x2_m4d VSS sky130_fd_pr__nfet_01v8 ad=0.406 pd=3.38 as=0.406 ps=3.38 w=1.4 l=0.6
X160 VSS VSS nmos_dummy_9__A_0.x1_m5d VSS sky130_fd_pr__nfet_01v8 ad=0.406 pd=3.38 as=0.406 ps=3.38 w=1.4 l=0.6
X161 VDD VDD op VDD sky130_fd_pr__pfet_01v8 ad=0.406 pd=3.38 as=0.406 ps=3.38 w=1.4 l=0.6
X162 VSS VSS VSS VSS sky130_fd_pr__nfet_01v8 ad=0.406 pd=3.38 as=0 ps=0 w=1.4 l=0.6
X163 VSS bias_a nmos_single_5__A_0.x2_tail VSS sky130_fd_pr__nfet_01v8 ad=0.406 pd=3.38 as=0.406 ps=3.38 w=1.4 l=0.6
X164 nmos_matched_cascode_pair_4__AB_0.x1_net4 cm cm VSS sky130_fd_pr__nfet_01v8 ad=0.406 pd=3.38 as=0.406 ps=3.38 w=1.4 l=0.6
X165 nmos_matched_cascode_pair_9__AB_0.x1_net12 cm VSS VSS sky130_fd_pr__nfet_01v8 ad=0.406 pd=3.38 as=0.406 ps=3.38 w=1.4 l=0.6
X166 VSS VSS VSS VSS sky130_fd_pr__nfet_01v8 ad=0.406 pd=3.38 as=0 ps=0 w=1.4 l=0.6
X167 VSS bias_a nmos_single_5__A_0.x2_tail VSS sky130_fd_pr__nfet_01v8 ad=0.406 pd=3.38 as=0.406 ps=3.38 w=1.4 l=0.6
X168 nmos_single__A_0.x1_m2d nmos_diode__A_0.bias_c pmos_dummy_7__A_0.x1_m25d VDD sky130_fd_pr__pfet_01v8 ad=0.406 pd=3.38 as=0.406 ps=3.38 w=1.4 l=0.6
X169 nmos_dummy_9__A_0.x1_m5d nmos_single__A_0.bias_d bias_a VSS sky130_fd_pr__nfet_01v8 ad=0.406 pd=3.38 as=0.406 ps=3.38 w=1.4 l=0.6
X170 VDD nmos_diode__A_0.bias_b pmos_dummy_17__A_0.x2_foldp VDD sky130_fd_pr__pfet_01v8_lvt ad=0.406 pd=3.38 as=0.406 ps=3.38 w=1.4 l=0.6
X171 VSS bias_a nmos_dummy_18__A_0.x2_m4d VSS sky130_fd_pr__nfet_01v8 ad=0.406 pd=3.38 as=0.406 ps=3.38 w=1.4 l=0.6
X172 VSS VSS nmos_dummy_9__A_0.x1_m5d VSS sky130_fd_pr__nfet_01v8 ad=0.406 pd=3.38 as=0.406 ps=3.38 w=1.4 l=0.6
X173 VSS bias_a nmos_single_5__A_0.x2_tail VSS sky130_fd_pr__nfet_01v8 ad=0.406 pd=3.38 as=0.406 ps=3.38 w=1.4 l=0.6
X174 nmos_dummy_9__A_0.x1_m5d nmos_single__A_0.bias_d bias_a VSS sky130_fd_pr__nfet_01v8 ad=0.406 pd=3.38 as=0.406 ps=3.38 w=1.4 l=0.6
X175 nmos_diode__A_0.bias_c nmos_diode__A_0.bias_c nmos_diode__A_0.bias_c VSS sky130_fd_pr__nfet_01v8_lvt ad=0.406 pd=3.38 as=0 ps=0 w=1.4 l=0.6
X176 on nmos_single__A_0.bias_d nmos_dummy_19__A_0.x2_m3d VSS sky130_fd_pr__nfet_01v8 ad=0.406 pd=3.38 as=0.406 ps=3.38 w=1.4 l=0.6
X177 nmos_single__A_0.bias_d nmos_single__A_0.x1_m2d nmos_single__A_0.x1_m2d VSS sky130_fd_pr__nfet_01v8 ad=0.406 pd=3.38 as=0.406 ps=3.38 w=1.4 l=0.6
X178 nmos_diode__A_0.bias_c nmos_diode__A_0.bias_b nmos_diode__A_0.bias_b VSS sky130_fd_pr__nfet_01v8_lvt ad=0.406 pd=3.38 as=0.406 ps=3.38 w=1.4 l=0.6
X179 VSS bias_a nmos_dummy_9__A_0.x1_m5d VSS sky130_fd_pr__nfet_01v8 ad=0.406 pd=3.38 as=0.406 ps=3.38 w=1.4 l=0.6
X180 VDD nmos_diode__A_0.bias_b pmos_dummy_17__A_0.x2_foldp VDD sky130_fd_pr__pfet_01v8_lvt ad=0.406 pd=3.38 as=0.406 ps=3.38 w=1.4 l=0.6
X181 VSS cmc nmos_single_5__A_0.x2_tail VSS sky130_fd_pr__nfet_01v8 ad=0.406 pd=3.38 as=0.406 ps=3.38 w=1.4 l=0.6
X182 VSS bias_a nmos_single_5__A_0.x2_tail VSS sky130_fd_pr__nfet_01v8 ad=0.406 pd=3.38 as=0.406 ps=3.38 w=1.4 l=0.6
X183 nmos_single__A_0.bias_d nmos_single__A_0.x1_m2d nmos_single__A_0.x1_m2d VSS sky130_fd_pr__nfet_01v8 ad=0.406 pd=3.38 as=0.406 ps=3.38 w=1.4 l=0.6
X184 nmos_single__A_0.bias_d nmos_single__A_0.x1_m2d nmos_single__A_0.x1_m2d VSS sky130_fd_pr__nfet_01v8 ad=0.406 pd=3.38 as=0.406 ps=3.38 w=1.4 l=0.6
X185 on nmos_single__A_0.bias_d nmos_dummy_19__A_0.x2_m3d VSS sky130_fd_pr__nfet_01v8 ad=0.406 pd=3.38 as=0.406 ps=3.38 w=1.4 l=0.6
X186 pmos_dummy_7__A_0.x1_m25d pmos_dummy_7__A_0.x1_m25d pmos_dummy_7__A_0.x1_m25d VDD sky130_fd_pr__pfet_01v8 ad=0.406 pd=3.38 as=0 ps=0 w=1.4 l=0.6
X187 VSS bias_a nmos_dummy_18__A_0.x2_m4d VSS sky130_fd_pr__nfet_01v8 ad=0.406 pd=3.38 as=0.406 ps=3.38 w=1.4 l=0.6
X188 VSS IBIAS nmos_diode__A_0.bias_c VSS sky130_fd_pr__nfet_01v8 ad=0.406 pd=3.38 as=0.406 ps=3.38 w=1.4 l=0.6
X189 nmos_diode__A_0.bias_c nmos_diode__A_0.bias_c nmos_diode__A_0.bias_c VSS sky130_fd_pr__nfet_01v8_lvt ad=0.406 pd=3.38 as=0 ps=0 w=1.4 l=0.6
X190 VSS cmc nmos_single_5__A_0.x2_tail VSS sky130_fd_pr__nfet_01v8 ad=0.406 pd=3.38 as=0.406 ps=3.38 w=1.4 l=0.6
X191 VSS cmc nmos_single_5__A_0.x2_tail VSS sky130_fd_pr__nfet_01v8 ad=0.406 pd=3.38 as=0.406 ps=3.38 w=1.4 l=0.6
X192 VSS bias_a nmos_single_5__A_0.x2_tail VSS sky130_fd_pr__nfet_01v8 ad=0.406 pd=3.38 as=0.406 ps=3.38 w=1.4 l=0.6
X193 nmos_dummy_18__A_0.x2_m4d nmos_single__A_0.bias_d op VSS sky130_fd_pr__nfet_01v8 ad=0.406 pd=3.38 as=0.406 ps=3.38 w=1.4 l=0.6
X194 VSS VSS VSS VSS sky130_fd_pr__nfet_01v8 ad=0.406 pd=3.38 as=0 ps=0 w=1.4 l=0.6
X195 VSS cmc nmos_single_5__A_0.x2_tail VSS sky130_fd_pr__nfet_01v8 ad=0.406 pd=3.38 as=0.406 ps=3.38 w=1.4 l=0.6
X196 nmos_diode__A_0.bias_c nmos_diode__A_0.bias_b nmos_diode__A_0.bias_b VSS sky130_fd_pr__nfet_01v8_lvt ad=0.406 pd=3.38 as=0.406 ps=3.38 w=1.4 l=0.6
X197 VSS cmc nmos_single_5__A_0.x2_tail VSS sky130_fd_pr__nfet_01v8 ad=0.406 pd=3.38 as=0.406 ps=3.38 w=1.4 l=0.6
X198 VDD VDD VDD VDD sky130_fd_pr__pfet_01v8 ad=0.406 pd=3.38 as=0 ps=0 w=1.4 l=0.6
X199 pmos_dummy_16__A_0.x2_foldn nmos_diode__A_0.bias_c op VDD sky130_fd_pr__pfet_01v8 ad=0.406 pd=3.38 as=0.406 ps=3.38 w=1.4 l=0.6
X200 VSS bias_a nmos_single_5__A_0.x2_tail VSS sky130_fd_pr__nfet_01v8 ad=0.406 pd=3.38 as=0.406 ps=3.38 w=1.4 l=0.6
X201 VDD VDD VDD VDD sky130_fd_pr__pfet_01v8 ad=0.406 pd=3.38 as=0 ps=0 w=1.4 l=0.6
X202 on nmos_single__A_0.bias_d nmos_dummy_19__A_0.x2_m3d VSS sky130_fd_pr__nfet_01v8 ad=0.406 pd=3.38 as=0.406 ps=3.38 w=1.4 l=0.6
X203 op op op VSS sky130_fd_pr__nfet_01v8 ad=0.406 pd=3.38 as=0 ps=0 w=1.4 l=0.6
X204 VDD VDD pmos_dummy_16__A_0.x2_foldn VDD sky130_fd_pr__pfet_01v8 ad=0.406 pd=3.38 as=0.406 ps=3.38 w=1.4 l=0.6
X205 VSS cmc nmos_single_5__A_0.x2_tail VSS sky130_fd_pr__nfet_01v8 ad=0.406 pd=3.38 as=0.406 ps=3.38 w=1.4 l=0.6
X206 VDD nmos_diode__A_0.bias_b pmos_dummy_16__A_0.x2_foldn VDD sky130_fd_pr__pfet_01v8_lvt ad=0.406 pd=3.38 as=0.406 ps=3.38 w=1.4 l=0.6
X207 VSS cmc nmos_single_5__A_0.x2_tail VSS sky130_fd_pr__nfet_01v8 ad=0.406 pd=3.38 as=0.406 ps=3.38 w=1.4 l=0.6
X208 VSS bias_a nmos_single_5__A_0.x2_tail VSS sky130_fd_pr__nfet_01v8 ad=0.406 pd=3.38 as=0.406 ps=3.38 w=1.4 l=0.6
X209 nmos_single_5__A_0.x2_tail nmos_single_5__A_0.x2_tail nmos_single_5__A_0.x2_tail VSS sky130_fd_pr__nfet_01v8 ad=0.406 pd=3.38 as=0 ps=0 w=1.4 l=0.6
X210 VSS bias_a nmos_single_5__A_0.x2_tail VSS sky130_fd_pr__nfet_01v8 ad=0.406 pd=3.38 as=0.406 ps=3.38 w=1.4 l=0.6
X211 VSS bias_a nmos_single_5__A_0.x2_tail VSS sky130_fd_pr__nfet_01v8 ad=0.406 pd=3.38 as=0.406 ps=3.38 w=1.4 l=0.6
X212 VSS bias_a nmos_dummy_18__A_0.x2_m4d VSS sky130_fd_pr__nfet_01v8 ad=0.406 pd=3.38 as=0.406 ps=3.38 w=1.4 l=0.6
X213 pmos_dummy_17__A_0.x2_foldp nmos_diode__A_0.bias_c on VDD sky130_fd_pr__pfet_01v8 ad=0.406 pd=3.38 as=0.406 ps=3.38 w=1.4 l=0.6
X214 VDD VDD nmos_diode__A_0.bias_b VDD sky130_fd_pr__pfet_01v8 ad=0.406 pd=3.38 as=0.406 ps=3.38 w=1.4 l=0.6
X215 IBIAS IBIAS VSS VSS sky130_fd_pr__nfet_01v8 ad=0.406 pd=3.38 as=0.406 ps=3.38 w=1.4 l=0.6
X216 VSS bias_a nmos_single_5__A_0.x2_tail VSS sky130_fd_pr__nfet_01v8 ad=0.406 pd=3.38 as=0.406 ps=3.38 w=1.4 l=0.6
X217 VSS bias_a nmos_dummy_19__A_0.x2_m3d VSS sky130_fd_pr__nfet_01v8 ad=0.406 pd=3.38 as=0.406 ps=3.38 w=1.4 l=0.6
X218 nmos_diode__A_0.bias_b nmos_diode__A_0.bias_b nmos_diode__A_0.bias_b VSS sky130_fd_pr__nfet_01v8_lvt ad=0.406 pd=3.38 as=0 ps=0 w=1.4 l=0.6
X219 VSS bias_a nmos_single_5__A_0.x2_tail VSS sky130_fd_pr__nfet_01v8 ad=0.406 pd=3.38 as=0.406 ps=3.38 w=1.4 l=0.6
X220 VSS bias_a nmos_dummy_18__A_0.x2_m4d VSS sky130_fd_pr__nfet_01v8 ad=0.406 pd=3.38 as=0.406 ps=3.38 w=1.4 l=0.6
X221 nmos_dummy_9__A_0.x1_m5d nmos_dummy_9__A_0.x1_m5d nmos_dummy_9__A_0.x1_m5d VSS sky130_fd_pr__nfet_01v8 ad=0.406 pd=3.38 as=0 ps=0 w=1.4 l=0.6
X222 nmos_single__A_0.bias_d nmos_single__A_0.x1_m2d nmos_single__A_0.x1_m2d VSS sky130_fd_pr__nfet_01v8 ad=0.406 pd=3.38 as=0.406 ps=3.38 w=1.4 l=0.6
X223 nmos_single__A_0.bias_d nmos_single__A_0.x1_m2d nmos_single__A_0.x1_m2d VSS sky130_fd_pr__nfet_01v8 ad=0.406 pd=3.38 as=0.406 ps=3.38 w=1.4 l=0.6
X224 cm cm cm VSS sky130_fd_pr__nfet_01v8 ad=0.406 pd=3.38 as=0 ps=0 w=1.4 l=0.6
X225 VDD nmos_diode__A_0.bias_b pmos_dummy_17__A_0.x2_foldp VDD sky130_fd_pr__pfet_01v8_lvt ad=0.406 pd=3.38 as=0.406 ps=3.38 w=1.4 l=0.6
X226 VSS VSS VSS VSS sky130_fd_pr__nfet_01v8 ad=0.406 pd=3.38 as=0 ps=0 w=1.4 l=0.6
X227 VDD nmos_diode__A_0.bias_b pmos_dummy_17__A_0.x2_foldp VDD sky130_fd_pr__pfet_01v8_lvt ad=0.406 pd=3.38 as=0.406 ps=3.38 w=1.4 l=0.6
X228 VSS VSS VSS VSS sky130_fd_pr__nfet_01v8 ad=0.406 pd=3.38 as=0 ps=0 w=1.4 l=0.6
X229 op cmc sky130_fd_pr__cap_mim_m3_1 l=4.8 w=4.8
X230 VSS VSS VSS VSS sky130_fd_pr__nfet_01v8_lvt ad=0.348 pd=2.98 as=0 ps=0 w=1.2 l=0.2
X231 nmos_diode__A_0.bias_c nmos_diode__A_0.bias_b nmos_diode__A_0.bias_b VSS sky130_fd_pr__nfet_01v8_lvt ad=0.406 pd=3.38 as=0.406 ps=3.38 w=1.4 l=0.6
X232 nmos_diode__A_0.bias_c nmos_diode__A_0.bias_b nmos_diode__A_0.bias_b VSS sky130_fd_pr__nfet_01v8_lvt ad=0.406 pd=3.38 as=0.406 ps=3.38 w=1.4 l=0.6
X233 nmos_single__A_0.bias_d nmos_single__A_0.x1_m2d nmos_single__A_0.x1_m2d VSS sky130_fd_pr__nfet_01v8 ad=0.406 pd=3.38 as=0.406 ps=3.38 w=1.4 l=0.6
X234 pmos_dummy_17__A_0.x2_foldp nmos_diode__A_0.bias_c on VDD sky130_fd_pr__pfet_01v8 ad=0.406 pd=3.38 as=0.406 ps=3.38 w=1.4 l=0.6
X235 VSS cmc nmos_single_5__A_0.x2_tail VSS sky130_fd_pr__nfet_01v8 ad=0.406 pd=3.38 as=0.406 ps=3.38 w=1.4 l=0.6
X236 VSS bias_a nmos_single_5__A_0.x2_tail VSS sky130_fd_pr__nfet_01v8 ad=0.406 pd=3.38 as=0.406 ps=3.38 w=1.4 l=0.6
X237 nmos_diode__A_0.bias_c nmos_diode__A_0.bias_b nmos_diode__A_0.bias_b VSS sky130_fd_pr__nfet_01v8_lvt ad=0.406 pd=3.38 as=0.406 ps=3.38 w=1.4 l=0.6
X238 nmos_diode__A_0.bias_c nmos_diode__A_0.bias_b nmos_diode__A_0.bias_b VSS sky130_fd_pr__nfet_01v8_lvt ad=0.406 pd=3.38 as=0.406 ps=3.38 w=1.4 l=0.6
X239 nmos_dummy_18__A_0.x2_m4d nmos_single__A_0.bias_d op VSS sky130_fd_pr__nfet_01v8 ad=0.406 pd=3.38 as=0.406 ps=3.38 w=1.4 l=0.6
X240 cm cm cm VSS sky130_fd_pr__nfet_01v8 ad=0.406 pd=3.38 as=0 ps=0 w=1.4 l=0.6
X241 VSS VSS VSS VSS sky130_fd_pr__nfet_01v8 ad=0.406 pd=3.38 as=0 ps=0 w=1.4 l=0.6
X242 VDD nmos_diode__A_0.bias_b pmos_dummy_16__A_0.x2_foldn VDD sky130_fd_pr__pfet_01v8_lvt ad=0.406 pd=3.38 as=0.406 ps=3.38 w=1.4 l=0.6
X243 VSS cmc nmos_single_5__A_0.x2_tail VSS sky130_fd_pr__nfet_01v8 ad=0.406 pd=3.38 as=0.406 ps=3.38 w=1.4 l=0.6
X244 VSS bias_a nmos_dummy_18__A_0.x2_m4d VSS sky130_fd_pr__nfet_01v8 ad=0.406 pd=3.38 as=0.406 ps=3.38 w=1.4 l=0.6
X245 pmos_dummy_6__A_0.x1_m21d nmos_diode__A_0.bias_b VDD VDD sky130_fd_pr__pfet_01v8_lvt ad=0.406 pd=3.38 as=0.406 ps=3.38 w=1.4 l=0.6
X246 VSS bias_a nmos_dummy_9__A_0.x1_m5d VSS sky130_fd_pr__nfet_01v8 ad=0.406 pd=3.38 as=0.406 ps=3.38 w=1.4 l=0.6
X247 VSS cmc nmos_single_5__A_0.x2_tail VSS sky130_fd_pr__nfet_01v8 ad=0.406 pd=3.38 as=0.406 ps=3.38 w=1.4 l=0.6
X248 VSS bias_a nmos_single_5__A_0.x2_tail VSS sky130_fd_pr__nfet_01v8 ad=0.406 pd=3.38 as=0.406 ps=3.38 w=1.4 l=0.6
X249 VSS VSS nmos_single_5__A_0.x2_tail VSS sky130_fd_pr__nfet_01v8 ad=0.406 pd=3.38 as=0.406 ps=3.38 w=1.4 l=0.6
X250 VSS VSS VSS VSS sky130_fd_pr__nfet_01v8 ad=0.406 pd=3.38 as=0 ps=0 w=1.4 l=0.6
X251 nmos_dummy_19__A_0.x2_m3d nmos_single__A_0.bias_d on VSS sky130_fd_pr__nfet_01v8 ad=0.406 pd=3.38 as=0.406 ps=3.38 w=1.4 l=0.6
X252 nmos_matched_cascode_pair_10__AB_0.x1_net13 cm nmos_matched_cascode_pair_11__AB_0.x1_net14 VSS sky130_fd_pr__nfet_01v8 ad=0.406 pd=3.38 as=0.406 ps=3.38 w=1.4 l=0.6
X253 on nmos_single__A_0.bias_d nmos_dummy_19__A_0.x2_m3d VSS sky130_fd_pr__nfet_01v8 ad=0.406 pd=3.38 as=0.406 ps=3.38 w=1.4 l=0.6
X254 VSS cmc nmos_single_5__A_0.x2_tail VSS sky130_fd_pr__nfet_01v8 ad=0.406 pd=3.38 as=0.406 ps=3.38 w=1.4 l=0.6
X255 VSS VSS VSS VSS sky130_fd_pr__nfet_01v8 ad=0.406 pd=3.38 as=0 ps=0 w=1.4 l=0.6
X256 VSS bias_a nmos_dummy_9__A_0.x1_m5d VSS sky130_fd_pr__nfet_01v8 ad=0.406 pd=3.38 as=0.406 ps=3.38 w=1.4 l=0.6
X257 pmos_dummy_16__A_0.x2_foldn nmos_diode__A_0.bias_c op VDD sky130_fd_pr__pfet_01v8 ad=0.406 pd=3.38 as=0.406 ps=3.38 w=1.4 l=0.6
X258 VSS cmc nmos_single_5__A_0.x2_tail VSS sky130_fd_pr__nfet_01v8 ad=0.406 pd=3.38 as=0.406 ps=3.38 w=1.4 l=0.6
X259 VSS bias_a nmos_single_5__A_0.x2_tail VSS sky130_fd_pr__nfet_01v8 ad=0.406 pd=3.38 as=0.406 ps=3.38 w=1.4 l=0.6
X260 VSS VSS VSS VSS sky130_fd_pr__nfet_01v8 ad=0.406 pd=3.38 as=0 ps=0 w=1.4 l=0.6
X261 pmos_dummy_17__A_0.x2_foldp pmos_dummy_17__A_0.x2_foldp pmos_dummy_17__A_0.x2_foldp VDD sky130_fd_pr__pfet_01v8 ad=0.406 pd=3.38 as=20.3 ps=169 w=1.4 l=0.6
X262 VSS bias_a nmos_dummy_9__A_0.x1_m5d VSS sky130_fd_pr__nfet_01v8 ad=0.406 pd=3.38 as=0.406 ps=3.38 w=1.4 l=0.6
X263 VSS bias_a nmos_single_5__A_0.x2_tail VSS sky130_fd_pr__nfet_01v8 ad=0.406 pd=3.38 as=0.406 ps=3.38 w=1.4 l=0.6
X264 VDD VDD VDD VDD sky130_fd_pr__pfet_01v8_lvt ad=0.406 pd=3.38 as=0 ps=0 w=1.4 l=0.6
X265 nmos_diode__A_0.bias_c nmos_diode__A_0.bias_b nmos_diode__A_0.bias_b VSS sky130_fd_pr__nfet_01v8_lvt ad=0.406 pd=3.38 as=0.406 ps=3.38 w=1.4 l=0.6
X266 nmos_diode__A_0.bias_c nmos_diode__A_0.bias_b nmos_diode__A_0.bias_b VSS sky130_fd_pr__nfet_01v8_lvt ad=0.406 pd=3.38 as=0.406 ps=3.38 w=1.4 l=0.6
X267 nmos_matched_cascode_pair_2__AB_0.x1_net1 cm nmos_matched_cascode_pair_3__AB_0.x1_net2 VSS sky130_fd_pr__nfet_01v8 ad=0.406 pd=3.38 as=0.406 ps=3.38 w=1.4 l=0.6
X268 nmos_single__A_0.bias_d nmos_single__A_0.x1_m2d nmos_single__A_0.x1_m2d VSS sky130_fd_pr__nfet_01v8 ad=0.406 pd=3.38 as=0.406 ps=3.38 w=1.4 l=0.6
X269 nmos_single__A_0.bias_d nmos_single__A_0.x1_m2d nmos_single__A_0.x1_m2d VSS sky130_fd_pr__nfet_01v8 ad=0.406 pd=3.38 as=0.406 ps=3.38 w=1.4 l=0.6
X270 nmos_single__A_0.bias_d nmos_single__A_0.bias_d nmos_single__A_0.bias_d VSS sky130_fd_pr__nfet_01v8 ad=0.406 pd=3.38 as=0 ps=0 w=1.4 l=0.6
X271 VSS cmc nmos_single_5__A_0.x2_tail VSS sky130_fd_pr__nfet_01v8 ad=0.406 pd=3.38 as=0.406 ps=3.38 w=1.4 l=0.6
X272 VSS cmc nmos_single_5__A_0.x2_tail VSS sky130_fd_pr__nfet_01v8 ad=0.406 pd=3.38 as=0.406 ps=3.38 w=1.4 l=0.6
X273 VDD VDD VDD VDD sky130_fd_pr__pfet_01v8_lvt ad=0.406 pd=3.38 as=0 ps=0 w=1.4 l=0.6
X274 VSS bias_a nmos_dummy_9__A_0.x1_m5d VSS sky130_fd_pr__nfet_01v8 ad=0.406 pd=3.38 as=0.406 ps=3.38 w=1.4 l=0.6
X275 nmos_dummy_18__A_0.x2_m4d nmos_single__A_0.bias_d op VSS sky130_fd_pr__nfet_01v8 ad=0.406 pd=3.38 as=0.406 ps=3.38 w=1.4 l=0.6
X276 VSS IBIAS IBIAS VSS sky130_fd_pr__nfet_01v8 ad=0.406 pd=3.38 as=0.406 ps=3.38 w=1.4 l=0.6
X277 VDD nmos_diode__A_0.bias_b pmos_dummy_16__A_0.x2_foldn VDD sky130_fd_pr__pfet_01v8_lvt ad=0.406 pd=3.38 as=0.406 ps=3.38 w=1.4 l=0.6
X278 VSS VSS VSS VSS sky130_fd_pr__nfet_01v8 ad=0.406 pd=3.38 as=0 ps=0 w=1.4 l=0.6
X279 VSS bias_a nmos_dummy_19__A_0.x2_m3d VSS sky130_fd_pr__nfet_01v8 ad=0.406 pd=3.38 as=0.406 ps=3.38 w=1.4 l=0.6
X280 VDD nmos_diode__A_0.bias_b pmos_dummy_6__A_0.x1_m21d VDD sky130_fd_pr__pfet_01v8_lvt ad=0.406 pd=3.38 as=0.406 ps=3.38 w=1.4 l=0.6
X281 VSS bias_a nmos_dummy_9__A_0.x1_m5d VSS sky130_fd_pr__nfet_01v8 ad=0.406 pd=3.38 as=0.406 ps=3.38 w=1.4 l=0.6
X282 pmos_dummy_17__A_0.x2_foldp nmos_diode__A_0.bias_c on VDD sky130_fd_pr__pfet_01v8 ad=0.406 pd=3.38 as=0.406 ps=3.38 w=1.4 l=0.6
X283 nmos_dummy_9__A_0.x1_m5d nmos_single__A_0.bias_d bias_a VSS sky130_fd_pr__nfet_01v8 ad=0.406 pd=3.38 as=0.406 ps=3.38 w=1.4 l=0.6
X284 nmos_dummy_9__A_0.x1_m5d nmos_single__A_0.bias_d bias_a VSS sky130_fd_pr__nfet_01v8 ad=0.406 pd=3.38 as=0.406 ps=3.38 w=1.4 l=0.6
X285 VSS cmc nmos_single_5__A_0.x2_tail VSS sky130_fd_pr__nfet_01v8 ad=0.406 pd=3.38 as=0.406 ps=3.38 w=1.4 l=0.6
X286 VSS bias_a nmos_dummy_19__A_0.x2_m3d VSS sky130_fd_pr__nfet_01v8 ad=0.406 pd=3.38 as=0.406 ps=3.38 w=1.4 l=0.6
X287 VDD nmos_diode__A_0.bias_b pmos_single__A_0.x1_m31d VDD sky130_fd_pr__pfet_01v8_lvt ad=0.406 pd=3.38 as=0.406 ps=3.38 w=1.4 l=0.6
X288 nmos_dummy_9__A_0.x1_m5d nmos_single__A_0.bias_d bias_a VSS sky130_fd_pr__nfet_01v8 ad=0.406 pd=3.38 as=0.406 ps=3.38 w=1.4 l=0.6
X289 VSS VSS VSS VSS sky130_fd_pr__nfet_01v8 ad=0.406 pd=3.38 as=0 ps=0 w=1.4 l=0.6
X290 VSS VSS nmos_dummy_19__A_0.x2_m3d VSS sky130_fd_pr__nfet_01v8 ad=0.406 pd=3.38 as=0.406 ps=3.38 w=1.4 l=0.6
X291 nmos_diode__A_0.bias_c nmos_diode__A_0.bias_c nmos_diode__A_0.bias_c VSS sky130_fd_pr__nfet_01v8_lvt ad=0.406 pd=3.38 as=0 ps=0 w=1.4 l=0.6
X292 VSS VSS nmos_dummy_18__A_0.x2_m4d VSS sky130_fd_pr__nfet_01v8 ad=0.406 pd=3.38 as=0.406 ps=3.38 w=1.4 l=0.6
X293 VDD VDD on VDD sky130_fd_pr__pfet_01v8 ad=0.406 pd=3.38 as=0.406 ps=3.38 w=1.4 l=0.6
X294 VSS bias_a nmos_dummy_19__A_0.x2_m3d VSS sky130_fd_pr__nfet_01v8 ad=0.406 pd=3.38 as=0.406 ps=3.38 w=1.4 l=0.6
X295 VSS bias_a nmos_single_5__A_0.x2_tail VSS sky130_fd_pr__nfet_01v8 ad=0.406 pd=3.38 as=0.406 ps=3.38 w=1.4 l=0.6
X296 on cmc sky130_fd_pr__cap_mim_m3_1 l=4.8 w=4.8
X297 on cmc sky130_fd_pr__cap_mim_m3_1 l=4.8 w=4.8
X298 VSS bias_a nmos_dummy_19__A_0.x2_m3d VSS sky130_fd_pr__nfet_01v8 ad=0.406 pd=3.38 as=0.406 ps=3.38 w=1.4 l=0.6
X299 op nmos_single__A_0.bias_d nmos_dummy_18__A_0.x2_m4d VSS sky130_fd_pr__nfet_01v8 ad=0.406 pd=3.38 as=0.406 ps=3.38 w=1.4 l=0.6
X300 nmos_diode__A_0.bias_c nmos_diode__A_0.bias_c nmos_diode__A_0.bias_c VSS sky130_fd_pr__nfet_01v8_lvt ad=0.406 pd=3.38 as=0 ps=0 w=1.4 l=0.6
X301 pmos_dummy_16__A_0.x2_foldn nmos_diode__A_0.bias_c op VDD sky130_fd_pr__pfet_01v8 ad=0.406 pd=3.38 as=0.406 ps=3.38 w=1.4 l=0.6
X302 on on on VSS sky130_fd_pr__nfet_01v8 ad=0.406 pd=3.38 as=0 ps=0 w=1.4 l=0.6
X303 nmos_single__A_0.bias_d nmos_single__A_0.x1_m2d nmos_single__A_0.x1_m2d VSS sky130_fd_pr__nfet_01v8 ad=0.406 pd=3.38 as=0.406 ps=3.38 w=1.4 l=0.6
X304 VSS cmc nmos_single_5__A_0.x2_tail VSS sky130_fd_pr__nfet_01v8 ad=0.406 pd=3.38 as=0.406 ps=3.38 w=1.4 l=0.6
X305 VDD VDD cm VDD sky130_fd_pr__pfet_01v8 ad=0.406 pd=3.38 as=0.406 ps=3.38 w=1.4 l=0.6
X306 nmos_matched_cascode_pair_7__AB_0.x1_net9 cm nmos_matched_cascode_pair_7__AB_0.x1_net8 VSS sky130_fd_pr__nfet_01v8 ad=0.406 pd=3.38 as=0.406 ps=3.38 w=1.4 l=0.6
X307 IBIAS IBIAS IBIAS VSS sky130_fd_pr__nfet_01v8 ad=0.406 pd=3.38 as=8.932 ps=74.36 w=1.4 l=0.6
X308 VSS cmc nmos_single_5__A_0.x2_tail VSS sky130_fd_pr__nfet_01v8 ad=0.406 pd=3.38 as=0.406 ps=3.38 w=1.4 l=0.6
X309 pmos_dummy_6__A_0.x1_m21d nmos_diode__A_0.bias_c nmos_diode__A_0.bias_b VDD sky130_fd_pr__pfet_01v8 ad=0.406 pd=3.38 as=0.406 ps=3.38 w=1.4 l=0.6
X310 nmos_diode__A_0.bias_c IBIAS VSS VSS sky130_fd_pr__nfet_01v8 ad=0.406 pd=3.38 as=0.406 ps=3.38 w=1.4 l=0.6
X311 VSS VSS nmos_dummy_19__A_0.x2_m3d VSS sky130_fd_pr__nfet_01v8 ad=0.406 pd=3.38 as=0.406 ps=3.38 w=1.4 l=0.6
X312 op nmos_single__A_0.bias_d nmos_dummy_18__A_0.x2_m4d VSS sky130_fd_pr__nfet_01v8 ad=0.406 pd=3.38 as=0.406 ps=3.38 w=1.4 l=0.6
X313 VSS cmc nmos_single_5__A_0.x2_tail VSS sky130_fd_pr__nfet_01v8 ad=0.406 pd=3.38 as=0.406 ps=3.38 w=1.4 l=0.6
X314 VSS bias_a nmos_dummy_19__A_0.x2_m3d VSS sky130_fd_pr__nfet_01v8 ad=0.406 pd=3.38 as=0.406 ps=3.38 w=1.4 l=0.6
X315 nmos_diode__A_0.bias_b nmos_diode__A_0.bias_c pmos_dummy_6__A_0.x1_m21d VDD sky130_fd_pr__pfet_01v8 ad=0.406 pd=3.38 as=0.406 ps=3.38 w=1.4 l=0.6
X316 pmos_single__A_0.x1_m31d nmos_diode__A_0.bias_c cm VDD sky130_fd_pr__pfet_01v8 ad=0.406 pd=3.38 as=0.406 ps=3.38 w=1.4 l=0.6
X317 VDD nmos_diode__A_0.bias_b pmos_dummy_16__A_0.x2_foldn VDD sky130_fd_pr__pfet_01v8_lvt ad=0.406 pd=3.38 as=0.406 ps=3.38 w=1.4 l=0.6
X318 VSS cmc nmos_single_5__A_0.x2_tail VSS sky130_fd_pr__nfet_01v8 ad=0.406 pd=3.38 as=0.406 ps=3.38 w=1.4 l=0.6
X319 nmos_dummy_19__A_0.x2_m3d nmos_single__A_0.bias_d on VSS sky130_fd_pr__nfet_01v8 ad=0.406 pd=3.38 as=0.406 ps=3.38 w=1.4 l=0.6
X320 nmos_single__A_0.bias_d nmos_single__A_0.x1_m2d nmos_single__A_0.x1_m2d VSS sky130_fd_pr__nfet_01v8 ad=0.406 pd=3.38 as=0.406 ps=3.38 w=1.4 l=0.6
X321 pmos_dummy_17__A_0.x2_foldp nmos_diode__A_0.bias_c on VDD sky130_fd_pr__pfet_01v8 ad=0.406 pd=3.38 as=0.406 ps=3.38 w=1.4 l=0.6
X322 op nmos_single__A_0.bias_d nmos_dummy_18__A_0.x2_m4d VSS sky130_fd_pr__nfet_01v8 ad=0.406 pd=3.38 as=0.406 ps=3.38 w=1.4 l=0.6
X323 nmos_diode__A_0.bias_c nmos_diode__A_0.bias_b nmos_diode__A_0.bias_b VSS sky130_fd_pr__nfet_01v8_lvt ad=0.406 pd=3.38 as=0.406 ps=3.38 w=1.4 l=0.6
X324 nmos_dummy_9__A_0.x1_m5d nmos_dummy_9__A_0.x1_m5d nmos_dummy_9__A_0.x1_m5d VSS sky130_fd_pr__nfet_01v8 ad=0.406 pd=3.38 as=0 ps=0 w=1.4 l=0.6
X325 pmos_dummy_16__A_0.x2_foldn nmos_diode__A_0.bias_c op VDD sky130_fd_pr__pfet_01v8 ad=0.406 pd=3.38 as=0.406 ps=3.38 w=1.4 l=0.6
X326 VSS cmc nmos_single_5__A_0.x2_tail VSS sky130_fd_pr__nfet_01v8 ad=0.406 pd=3.38 as=0.406 ps=3.38 w=1.4 l=0.6
X327 nmos_diode__A_0.bias_c nmos_diode__A_0.bias_b nmos_diode__A_0.bias_b VSS sky130_fd_pr__nfet_01v8_lvt ad=0.406 pd=3.38 as=0.406 ps=3.38 w=1.4 l=0.6
X328 nmos_diode__A_0.bias_c nmos_diode__A_0.bias_b nmos_diode__A_0.bias_b VSS sky130_fd_pr__nfet_01v8_lvt ad=0.406 pd=3.38 as=0.406 ps=3.38 w=1.4 l=0.6
X329 VSS cmc nmos_single_5__A_0.x2_tail VSS sky130_fd_pr__nfet_01v8 ad=0.406 pd=3.38 as=0.406 ps=3.38 w=1.4 l=0.6
X330 VSS cmc nmos_single_5__A_0.x2_tail VSS sky130_fd_pr__nfet_01v8 ad=0.406 pd=3.38 as=0.406 ps=3.38 w=1.4 l=0.6
X331 bias_a bias_a bias_a VSS sky130_fd_pr__nfet_01v8 ad=0.406 pd=3.38 as=0 ps=0 w=1.4 l=0.6
X332 VDD VDD VDD VDD sky130_fd_pr__pfet_01v8 ad=0.406 pd=3.38 as=0 ps=0 w=1.4 l=0.6
X333 VDD nmos_diode__A_0.bias_b pmos_dummy_17__A_0.x2_foldp VDD sky130_fd_pr__pfet_01v8_lvt ad=0.406 pd=3.38 as=0.406 ps=3.38 w=1.4 l=0.6
X334 VSS bias_a nmos_single_5__A_0.x2_tail VSS sky130_fd_pr__nfet_01v8 ad=0.406 pd=3.38 as=0.406 ps=3.38 w=1.4 l=0.6
X335 VSS bias_a nmos_dummy_18__A_0.x2_m4d VSS sky130_fd_pr__nfet_01v8 ad=0.406 pd=3.38 as=0.406 ps=3.38 w=1.4 l=0.6
X336 nmos_diode__A_0.bias_b nmos_diode__A_0.bias_b nmos_diode__A_0.bias_b VSS sky130_fd_pr__nfet_01v8_lvt ad=0.406 pd=3.38 as=0 ps=0 w=1.4 l=0.6
X337 VDD VDD VDD VDD sky130_fd_pr__pfet_01v8_lvt ad=0.406 pd=3.38 as=0 ps=0 w=1.4 l=0.6
X338 nmos_diode__A_0.bias_c nmos_diode__A_0.bias_c nmos_diode__A_0.bias_c VSS sky130_fd_pr__nfet_01v8 ad=0.406 pd=3.38 as=0 ps=0 w=1.4 l=0.6
X339 VSS bias_a nmos_dummy_18__A_0.x2_m4d VSS sky130_fd_pr__nfet_01v8 ad=0.406 pd=3.38 as=0.406 ps=3.38 w=1.4 l=0.6
X340 op nmos_single__A_0.bias_d nmos_dummy_18__A_0.x2_m4d VSS sky130_fd_pr__nfet_01v8 ad=0.406 pd=3.38 as=0.406 ps=3.38 w=1.4 l=0.6
X341 VSS IBIAS IBIAS VSS sky130_fd_pr__nfet_01v8 ad=0.406 pd=3.38 as=0.406 ps=3.38 w=1.4 l=0.6
X342 VSS bias_a nmos_single_5__A_0.x2_tail VSS sky130_fd_pr__nfet_01v8 ad=0.406 pd=3.38 as=0.406 ps=3.38 w=1.4 l=0.6
X343 nmos_single__A_0.bias_d nmos_single__A_0.x1_m2d nmos_single__A_0.x1_m2d VSS sky130_fd_pr__nfet_01v8 ad=0.406 pd=3.38 as=0.406 ps=3.38 w=1.4 l=0.6
X344 VSS VSS VSS VSS sky130_fd_pr__nfet_01v8 ad=0.406 pd=3.38 as=0 ps=0 w=1.4 l=0.6
X345 VSS VSS VSS VSS sky130_fd_pr__nfet_01v8 ad=0.406 pd=3.38 as=0 ps=0 w=1.4 l=0.6
X346 cm cm cm VSS sky130_fd_pr__nfet_01v8 ad=0.406 pd=3.38 as=0 ps=0 w=1.4 l=0.6
X347 pmos_dummy_6__A_0.x1_m21d pmos_dummy_6__A_0.x1_m21d pmos_dummy_6__A_0.x1_m21d VDD sky130_fd_pr__pfet_01v8_lvt ad=0.406 pd=3.38 as=8.12 ps=67.6 w=1.4 l=0.6
X348 nmos_diode__A_0.bias_c nmos_diode__A_0.bias_b nmos_diode__A_0.bias_b VSS sky130_fd_pr__nfet_01v8_lvt ad=0.406 pd=3.38 as=0.406 ps=3.38 w=1.4 l=0.6
X349 VDD nmos_diode__A_0.bias_b pmos_dummy_17__A_0.x2_foldp VDD sky130_fd_pr__pfet_01v8_lvt ad=0.406 pd=3.38 as=0.406 ps=3.38 w=1.4 l=0.6
X350 VSS cmc nmos_single_5__A_0.x2_tail VSS sky130_fd_pr__nfet_01v8 ad=0.406 pd=3.38 as=0.406 ps=3.38 w=1.4 l=0.6
X351 nmos_dummy_18__A_0.x2_m4d nmos_single__A_0.bias_d op VSS sky130_fd_pr__nfet_01v8 ad=0.406 pd=3.38 as=0.406 ps=3.38 w=1.4 l=0.6
X352 VSS bias_a nmos_dummy_19__A_0.x2_m3d VSS sky130_fd_pr__nfet_01v8 ad=0.406 pd=3.38 as=0.406 ps=3.38 w=1.4 l=0.6
X353 VDD nmos_diode__A_0.bias_b pmos_single__A_0.x1_m31d VDD sky130_fd_pr__pfet_01v8_lvt ad=0.406 pd=3.38 as=0.406 ps=3.38 w=1.4 l=0.6
X354 nmos_single_5__A_0.x2_tail ip pmos_dummy_17__A_0.x2_foldp VSS sky130_fd_pr__nfet_01v8_lvt ad=0.348 pd=2.98 as=0.348 ps=2.98 w=1.2 l=0.2
X355 on nmos_single__A_0.bias_d nmos_dummy_19__A_0.x2_m3d VSS sky130_fd_pr__nfet_01v8 ad=0.406 pd=3.38 as=0.406 ps=3.38 w=1.4 l=0.6
X356 nmos_single__A_0.bias_d nmos_single__A_0.x1_m2d nmos_single__A_0.x1_m2d VSS sky130_fd_pr__nfet_01v8 ad=0.406 pd=3.38 as=0.406 ps=3.38 w=1.4 l=0.6
X357 VSS IBIAS nmos_diode__A_0.bias_c VSS sky130_fd_pr__nfet_01v8 ad=0.406 pd=3.38 as=0.406 ps=3.38 w=1.4 l=0.6
X358 VSS IBIAS IBIAS VSS sky130_fd_pr__nfet_01v8 ad=0.406 pd=3.38 as=0.406 ps=3.38 w=1.4 l=0.6
X359 VSS bias_a nmos_dummy_9__A_0.x1_m5d VSS sky130_fd_pr__nfet_01v8 ad=0.406 pd=3.38 as=0.406 ps=3.38 w=1.4 l=0.6
X360 VSS VSS VSS VSS sky130_fd_pr__nfet_01v8 ad=0.406 pd=3.38 as=0 ps=0 w=1.4 l=0.6
X361 VSS VSS nmos_dummy_9__A_0.x1_m5d VSS sky130_fd_pr__nfet_01v8 ad=0.406 pd=3.38 as=0.406 ps=3.38 w=1.4 l=0.6
X362 VSS VSS op VSS sky130_fd_pr__nfet_01v8 ad=0.406 pd=3.38 as=0.406 ps=3.38 w=1.4 l=0.6
X363 nmos_dummy_9__A_0.x1_m5d nmos_single__A_0.bias_d bias_a VSS sky130_fd_pr__nfet_01v8 ad=0.406 pd=3.38 as=0.406 ps=3.38 w=1.4 l=0.6
X364 pmos_dummy_16__A_0.x2_foldn nmos_diode__A_0.bias_c op VDD sky130_fd_pr__pfet_01v8 ad=0.406 pd=3.38 as=0.406 ps=3.38 w=1.4 l=0.6
X365 VSS bias_a nmos_single_5__A_0.x2_tail VSS sky130_fd_pr__nfet_01v8 ad=0.406 pd=3.38 as=0.406 ps=3.38 w=1.4 l=0.6
X366 VDD nmos_diode__A_0.bias_b pmos_dummy_6__A_0.x1_m21d VDD sky130_fd_pr__pfet_01v8_lvt ad=0.406 pd=3.38 as=0.406 ps=3.38 w=1.4 l=0.6
X367 nmos_diode__A_0.bias_c IBIAS VSS VSS sky130_fd_pr__nfet_01v8 ad=0.406 pd=3.38 as=0.406 ps=3.38 w=1.4 l=0.6
X368 VDD nmos_diode__A_0.bias_b pmos_dummy_16__A_0.x2_foldn VDD sky130_fd_pr__pfet_01v8_lvt ad=0.406 pd=3.38 as=0.406 ps=3.38 w=1.4 l=0.6
X369 nmos_single__A_0.bias_d nmos_single__A_0.bias_d nmos_single__A_0.bias_d VSS sky130_fd_pr__nfet_01v8 ad=0.406 pd=3.38 as=0 ps=0 w=1.4 l=0.6
X370 VSS bias_a nmos_dummy_19__A_0.x2_m3d VSS sky130_fd_pr__nfet_01v8 ad=0.406 pd=3.38 as=0.406 ps=3.38 w=1.4 l=0.6
X371 pmos_dummy_6__A_0.x1_m21d nmos_diode__A_0.bias_b VDD VDD sky130_fd_pr__pfet_01v8_lvt ad=0.406 pd=3.38 as=0.406 ps=3.38 w=1.4 l=0.6
X372 VSS bias_a nmos_dummy_9__A_0.x1_m5d VSS sky130_fd_pr__nfet_01v8 ad=0.406 pd=3.38 as=0.406 ps=3.38 w=1.4 l=0.6
X373 pmos_dummy_17__A_0.x2_foldp pmos_dummy_17__A_0.x2_foldp pmos_dummy_17__A_0.x2_foldp VDD sky130_fd_pr__pfet_01v8 ad=0.406 pd=3.38 as=0 ps=0 w=1.4 l=0.6
X374 VSS bias_a nmos_single_5__A_0.x2_tail VSS sky130_fd_pr__nfet_01v8 ad=0.406 pd=3.38 as=0.406 ps=3.38 w=1.4 l=0.6
X375 op nmos_single__A_0.bias_d nmos_dummy_18__A_0.x2_m4d VSS sky130_fd_pr__nfet_01v8 ad=0.406 pd=3.38 as=0.406 ps=3.38 w=1.4 l=0.6
X376 VSS bias_a nmos_single_5__A_0.x2_tail VSS sky130_fd_pr__nfet_01v8 ad=0.406 pd=3.38 as=0.406 ps=3.38 w=1.4 l=0.6
X377 VSS cmc nmos_single_5__A_0.x2_tail VSS sky130_fd_pr__nfet_01v8 ad=0.406 pd=3.38 as=0.406 ps=3.38 w=1.4 l=0.6
X378 VSS cmc nmos_single_5__A_0.x2_tail VSS sky130_fd_pr__nfet_01v8 ad=0.406 pd=3.38 as=0.406 ps=3.38 w=1.4 l=0.6
X379 VSS bias_a nmos_single_5__A_0.x2_tail VSS sky130_fd_pr__nfet_01v8 ad=0.406 pd=3.38 as=0.406 ps=3.38 w=1.4 l=0.6
X380 nmos_single__A_0.bias_d nmos_single__A_0.x1_m2d nmos_single__A_0.x1_m2d VSS sky130_fd_pr__nfet_01v8 ad=0.406 pd=3.38 as=0.406 ps=3.38 w=1.4 l=0.6
X381 VSS bias_a nmos_single_5__A_0.x2_tail VSS sky130_fd_pr__nfet_01v8 ad=0.406 pd=3.38 as=0.406 ps=3.38 w=1.4 l=0.6
X382 nmos_diode__A_0.bias_c nmos_diode__A_0.bias_b nmos_diode__A_0.bias_b VSS sky130_fd_pr__nfet_01v8_lvt ad=0.406 pd=3.38 as=0.406 ps=3.38 w=1.4 l=0.6
X383 VDD nmos_diode__A_0.bias_b pmos_dummy_17__A_0.x2_foldp VDD sky130_fd_pr__pfet_01v8_lvt ad=0.406 pd=3.38 as=0.406 ps=3.38 w=1.4 l=0.6
X384 VSS VSS nmos_dummy_19__A_0.x2_m3d VSS sky130_fd_pr__nfet_01v8 ad=0.406 pd=3.38 as=0.406 ps=3.38 w=1.4 l=0.6
X385 VDD nmos_diode__A_0.bias_b pmos_dummy_17__A_0.x2_foldp VDD sky130_fd_pr__pfet_01v8_lvt ad=0.406 pd=3.38 as=0.406 ps=3.38 w=1.4 l=0.6
X386 VSS cmc nmos_single_5__A_0.x2_tail VSS sky130_fd_pr__nfet_01v8 ad=0.406 pd=3.38 as=0.406 ps=3.38 w=1.4 l=0.6
X387 VSS cmc nmos_single_5__A_0.x2_tail VSS sky130_fd_pr__nfet_01v8 ad=0.406 pd=3.38 as=0.406 ps=3.38 w=1.4 l=0.6
X388 nmos_dummy_9__A_0.x1_m5d nmos_single__A_0.bias_d bias_a VSS sky130_fd_pr__nfet_01v8 ad=0.406 pd=3.38 as=0.406 ps=3.38 w=1.4 l=0.6
X389 pmos_dummy_16__A_0.x2_foldn nmos_diode__A_0.bias_c op VDD sky130_fd_pr__pfet_01v8 ad=0.406 pd=3.38 as=0.406 ps=3.38 w=1.4 l=0.6
X390 nmos_dummy_19__A_0.x2_m3d nmos_single__A_0.bias_d on VSS sky130_fd_pr__nfet_01v8 ad=0.406 pd=3.38 as=0.406 ps=3.38 w=1.4 l=0.6
X391 VSS bias_a nmos_single_5__A_0.x2_tail VSS sky130_fd_pr__nfet_01v8 ad=0.406 pd=3.38 as=0.406 ps=3.38 w=1.4 l=0.6
X392 VDD VDD on VDD sky130_fd_pr__pfet_01v8 ad=0.406 pd=3.38 as=0.406 ps=3.38 w=1.4 l=0.6
X393 VSS bias_a nmos_single_5__A_0.x2_tail VSS sky130_fd_pr__nfet_01v8 ad=0.406 pd=3.38 as=0.406 ps=3.38 w=1.4 l=0.6
X394 VSS IBIAS IBIAS VSS sky130_fd_pr__nfet_01v8 ad=0.406 pd=3.38 as=0.406 ps=3.38 w=1.4 l=0.6
X395 VSS bias_a nmos_dummy_18__A_0.x2_m4d VSS sky130_fd_pr__nfet_01v8 ad=0.406 pd=3.38 as=0.406 ps=3.38 w=1.4 l=0.6
X396 bias_a bias_a bias_a VSS sky130_fd_pr__nfet_01v8 ad=0.406 pd=3.38 as=0 ps=0 w=1.4 l=0.6
X397 nmos_diode__A_0.bias_b nmos_diode__A_0.bias_c pmos_dummy_6__A_0.x1_m21d VDD sky130_fd_pr__pfet_01v8 ad=0.406 pd=3.38 as=0.406 ps=3.38 w=1.4 l=0.6
X398 VSS cmc nmos_single_5__A_0.x2_tail VSS sky130_fd_pr__nfet_01v8 ad=0.406 pd=3.38 as=0.406 ps=3.38 w=1.4 l=0.6
X399 VSS bias_a nmos_dummy_18__A_0.x2_m4d VSS sky130_fd_pr__nfet_01v8 ad=0.406 pd=3.38 as=0.406 ps=3.38 w=1.4 l=0.6
X400 VSS VSS VSS VSS sky130_fd_pr__nfet_01v8 ad=0.406 pd=3.38 as=0 ps=0 w=1.4 l=0.6
X401 VDD nmos_diode__A_0.bias_b pmos_dummy_16__A_0.x2_foldn VDD sky130_fd_pr__pfet_01v8_lvt ad=0.406 pd=3.38 as=0.406 ps=3.38 w=1.4 l=0.6
X402 nmos_single_5__A_0.x2_tail nmos_single_5__A_0.x2_tail nmos_single_5__A_0.x2_tail VSS sky130_fd_pr__nfet_01v8 ad=0.406 pd=3.38 as=0 ps=0 w=1.4 l=0.6
X403 nmos_diode__A_0.bias_c nmos_diode__A_0.bias_b nmos_diode__A_0.bias_b VSS sky130_fd_pr__nfet_01v8_lvt ad=0.406 pd=3.38 as=0.406 ps=3.38 w=1.4 l=0.6
X404 VSS bias_a nmos_dummy_18__A_0.x2_m4d VSS sky130_fd_pr__nfet_01v8 ad=0.406 pd=3.38 as=0.406 ps=3.38 w=1.4 l=0.6
X405 nmos_matched_cascode_pair_8__AB_0.x1_net10 cm cm VSS sky130_fd_pr__nfet_01v8 ad=0.406 pd=3.38 as=0.406 ps=3.38 w=1.4 l=0.6
X406 pmos_dummy_17__A_0.x2_foldp nmos_diode__A_0.bias_c on VDD sky130_fd_pr__pfet_01v8 ad=0.406 pd=3.38 as=0.406 ps=3.38 w=1.4 l=0.6
X407 VSS VSS nmos_dummy_18__A_0.x2_m4d VSS sky130_fd_pr__nfet_01v8 ad=0.406 pd=3.38 as=0.406 ps=3.38 w=1.4 l=0.6
X408 VSS cmc nmos_single_5__A_0.x2_tail VSS sky130_fd_pr__nfet_01v8 ad=0.406 pd=3.38 as=0.406 ps=3.38 w=1.4 l=0.6
X409 VDD VDD VDD VDD sky130_fd_pr__pfet_01v8_lvt ad=0.406 pd=3.38 as=0 ps=0 w=1.4 l=0.6
X410 VSS bias_a nmos_dummy_19__A_0.x2_m3d VSS sky130_fd_pr__nfet_01v8 ad=0.406 pd=3.38 as=0.406 ps=3.38 w=1.4 l=0.6
X411 VSS bias_a nmos_single_5__A_0.x2_tail VSS sky130_fd_pr__nfet_01v8 ad=0.406 pd=3.38 as=0.406 ps=3.38 w=1.4 l=0.6
X412 VSS bias_a nmos_dummy_18__A_0.x2_m4d VSS sky130_fd_pr__nfet_01v8 ad=0.406 pd=3.38 as=0.406 ps=3.38 w=1.4 l=0.6
X413 on nmos_single__A_0.bias_d nmos_dummy_19__A_0.x2_m3d VSS sky130_fd_pr__nfet_01v8 ad=0.406 pd=3.38 as=0.406 ps=3.38 w=1.4 l=0.6
X414 VSS IBIAS nmos_diode__A_0.bias_c VSS sky130_fd_pr__nfet_01v8 ad=0.406 pd=3.38 as=0.406 ps=3.38 w=1.4 l=0.6
X415 VSS bias_a nmos_dummy_18__A_0.x2_m4d VSS sky130_fd_pr__nfet_01v8 ad=0.406 pd=3.38 as=0.406 ps=3.38 w=1.4 l=0.6
X416 nmos_dummy_9__A_0.x1_m5d nmos_dummy_9__A_0.x1_m5d nmos_dummy_9__A_0.x1_m5d VSS sky130_fd_pr__nfet_01v8 ad=0.406 pd=3.38 as=0 ps=0 w=1.4 l=0.6
X417 nmos_diode__A_0.bias_c nmos_diode__A_0.bias_b nmos_diode__A_0.bias_b VSS sky130_fd_pr__nfet_01v8_lvt ad=0.406 pd=3.38 as=0.406 ps=3.38 w=1.4 l=0.6
X418 nmos_single__A_0.bias_d nmos_single__A_0.x1_m2d nmos_single__A_0.x1_m2d VSS sky130_fd_pr__nfet_01v8 ad=0.406 pd=3.38 as=0.406 ps=3.38 w=1.4 l=0.6
X419 VSS cmc nmos_single_5__A_0.x2_tail VSS sky130_fd_pr__nfet_01v8 ad=0.406 pd=3.38 as=0.406 ps=3.38 w=1.4 l=0.6
X420 VSS cmc nmos_single_5__A_0.x2_tail VSS sky130_fd_pr__nfet_01v8 ad=0.406 pd=3.38 as=0.406 ps=3.38 w=1.4 l=0.6
X421 VDD nmos_diode__A_0.bias_b pmos_dummy_17__A_0.x2_foldp VDD sky130_fd_pr__pfet_01v8_lvt ad=0.406 pd=3.38 as=0.406 ps=3.38 w=1.4 l=0.6
X422 VSS VSS VSS VSS sky130_fd_pr__nfet_01v8 ad=0.406 pd=3.38 as=0 ps=0 w=1.4 l=0.6
X423 on nmos_single__A_0.bias_d nmos_dummy_19__A_0.x2_m3d VSS sky130_fd_pr__nfet_01v8 ad=0.406 pd=3.38 as=0.406 ps=3.38 w=1.4 l=0.6
X424 VSS bias_a nmos_single_5__A_0.x2_tail VSS sky130_fd_pr__nfet_01v8 ad=0.406 pd=3.38 as=0.406 ps=3.38 w=1.4 l=0.6
X425 VDD nmos_diode__A_0.bias_b pmos_dummy_16__A_0.x2_foldn VDD sky130_fd_pr__pfet_01v8_lvt ad=0.406 pd=3.38 as=0.406 ps=3.38 w=1.4 l=0.6
X426 on nmos_single__A_0.bias_d nmos_dummy_19__A_0.x2_m3d VSS sky130_fd_pr__nfet_01v8 ad=0.406 pd=3.38 as=0.406 ps=3.38 w=1.4 l=0.6
X427 VSS cmc nmos_single_5__A_0.x2_tail VSS sky130_fd_pr__nfet_01v8 ad=0.406 pd=3.38 as=0.406 ps=3.38 w=1.4 l=0.6
X428 VDD VDD VDD VDD sky130_fd_pr__pfet_01v8_lvt ad=0.406 pd=3.38 as=0 ps=0 w=1.4 l=0.6
X429 VDD nmos_diode__A_0.bias_b pmos_dummy_16__A_0.x2_foldn VDD sky130_fd_pr__pfet_01v8_lvt ad=0.406 pd=3.38 as=0.406 ps=3.38 w=1.4 l=0.6
X430 VSS cmc nmos_single_5__A_0.x2_tail VSS sky130_fd_pr__nfet_01v8 ad=0.406 pd=3.38 as=0.406 ps=3.38 w=1.4 l=0.6
X431 VSS cmc nmos_single_5__A_0.x2_tail VSS sky130_fd_pr__nfet_01v8 ad=0.406 pd=3.38 as=0.406 ps=3.38 w=1.4 l=0.6
X432 op nmos_single__A_0.bias_d nmos_dummy_18__A_0.x2_m4d VSS sky130_fd_pr__nfet_01v8 ad=0.406 pd=3.38 as=0.406 ps=3.38 w=1.4 l=0.6
X433 nmos_single__A_0.bias_d nmos_single__A_0.x1_m2d nmos_single__A_0.x1_m2d VSS sky130_fd_pr__nfet_01v8 ad=0.406 pd=3.38 as=0.406 ps=3.38 w=1.4 l=0.6
X434 nmos_single__A_0.bias_d nmos_single__A_0.x1_m2d nmos_single__A_0.x1_m2d VSS sky130_fd_pr__nfet_01v8 ad=0.406 pd=3.38 as=0.406 ps=3.38 w=1.4 l=0.6
X435 VSS VSS VSS VSS sky130_fd_pr__nfet_01v8 ad=0.406 pd=3.38 as=0 ps=0 w=1.4 l=0.6
X436 nmos_diode__A_0.bias_c nmos_diode__A_0.bias_c nmos_diode__A_0.bias_c VSS sky130_fd_pr__nfet_01v8 ad=0.406 pd=3.38 as=0 ps=0 w=1.4 l=0.6
X437 VSS bias_a nmos_single_5__A_0.x2_tail VSS sky130_fd_pr__nfet_01v8 ad=0.406 pd=3.38 as=0.406 ps=3.38 w=1.4 l=0.6
X438 on nmos_single__A_0.bias_d nmos_dummy_19__A_0.x2_m3d VSS sky130_fd_pr__nfet_01v8 ad=0.406 pd=3.38 as=0.406 ps=3.38 w=1.4 l=0.6
X439 VDD VDD VDD VDD sky130_fd_pr__pfet_01v8_lvt ad=0.406 pd=3.38 as=0 ps=0 w=1.4 l=0.6
X440 nmos_dummy_18__A_0.x2_m4d nmos_single__A_0.bias_d op VSS sky130_fd_pr__nfet_01v8 ad=0.406 pd=3.38 as=0.406 ps=3.38 w=1.4 l=0.6
X441 VSS VSS VSS VSS sky130_fd_pr__nfet_01v8 ad=0.406 pd=3.38 as=0 ps=0 w=1.4 l=0.6
X442 VSS VSS VSS VSS sky130_fd_pr__nfet_01v8 ad=0.406 pd=3.38 as=0 ps=0 w=1.4 l=0.6
X443 VSS cmc nmos_single_5__A_0.x2_tail VSS sky130_fd_pr__nfet_01v8 ad=0.406 pd=3.38 as=0.406 ps=3.38 w=1.4 l=0.6
X444 VSS cmc nmos_single_5__A_0.x2_tail VSS sky130_fd_pr__nfet_01v8 ad=0.406 pd=3.38 as=0.406 ps=3.38 w=1.4 l=0.6
X445 VSS bias_a nmos_dummy_19__A_0.x2_m3d VSS sky130_fd_pr__nfet_01v8 ad=0.406 pd=3.38 as=0.406 ps=3.38 w=1.4 l=0.6
X446 VSS bias_a nmos_dummy_18__A_0.x2_m4d VSS sky130_fd_pr__nfet_01v8 ad=0.406 pd=3.38 as=0.406 ps=3.38 w=1.4 l=0.6
X447 nmos_diode__A_0.bias_b nmos_diode__A_0.bias_b nmos_diode__A_0.bias_b VSS sky130_fd_pr__nfet_01v8_lvt ad=0.406 pd=3.38 as=0 ps=0 w=1.4 l=0.6
X448 VSS bias_a nmos_single_5__A_0.x2_tail VSS sky130_fd_pr__nfet_01v8 ad=0.406 pd=3.38 as=0.406 ps=3.38 w=1.4 l=0.6
X449 VDD VDD VDD VDD sky130_fd_pr__pfet_01v8_lvt ad=0.406 pd=3.38 as=0 ps=0 w=1.4 l=0.6
X450 VSS bias_a nmos_single_5__A_0.x2_tail VSS sky130_fd_pr__nfet_01v8 ad=0.406 pd=3.38 as=0.406 ps=3.38 w=1.4 l=0.6
X451 VDD nmos_diode__A_0.bias_b pmos_single__A_0.x1_m31d VDD sky130_fd_pr__pfet_01v8_lvt ad=0.406 pd=3.38 as=0.406 ps=3.38 w=1.4 l=0.6
X452 VSS VSS nmos_dummy_9__A_0.x1_m5d VSS sky130_fd_pr__nfet_01v8 ad=0.406 pd=3.38 as=0.406 ps=3.38 w=1.4 l=0.6
X453 pmos_dummy_16__A_0.x2_foldn pmos_dummy_16__A_0.x2_foldn pmos_dummy_16__A_0.x2_foldn VDD sky130_fd_pr__pfet_01v8 ad=0.406 pd=3.38 as=20.3 ps=169 w=1.4 l=0.6
X454 pmos_dummy_16__A_0.x2_foldn nmos_diode__A_0.bias_c op VDD sky130_fd_pr__pfet_01v8 ad=0.406 pd=3.38 as=0.406 ps=3.38 w=1.4 l=0.6
X455 VSS VSS VSS VSS sky130_fd_pr__nfet_01v8 ad=0.406 pd=3.38 as=0 ps=0 w=1.4 l=0.6
X456 on cmc sky130_fd_pr__cap_mim_m3_1 l=4.8 w=4.8
X457 cm cm cm VSS sky130_fd_pr__nfet_01v8 ad=0.406 pd=3.38 as=0 ps=0 w=1.4 l=0.6
X458 nmos_diode__A_0.bias_c nmos_diode__A_0.bias_b nmos_diode__A_0.bias_b VSS sky130_fd_pr__nfet_01v8_lvt ad=0.406 pd=3.38 as=0.406 ps=3.38 w=1.4 l=0.6
X459 nmos_diode__A_0.bias_c nmos_diode__A_0.bias_b nmos_diode__A_0.bias_b VSS sky130_fd_pr__nfet_01v8_lvt ad=0.406 pd=3.38 as=0.406 ps=3.38 w=1.4 l=0.6
X460 nmos_dummy_9__A_0.x1_m5d nmos_single__A_0.bias_d bias_a VSS sky130_fd_pr__nfet_01v8 ad=0.406 pd=3.38 as=0.406 ps=3.38 w=1.4 l=0.6
X461 VDD nmos_diode__A_0.bias_b pmos_dummy_16__A_0.x2_foldn VDD sky130_fd_pr__pfet_01v8_lvt ad=0.406 pd=3.38 as=0.406 ps=3.38 w=1.4 l=0.6
X462 pmos_dummy_16__A_0.x2_foldn nmos_diode__A_0.bias_c op VDD sky130_fd_pr__pfet_01v8 ad=0.406 pd=3.38 as=0.406 ps=3.38 w=1.4 l=0.6
X463 nmos_dummy_19__A_0.x2_m3d nmos_single__A_0.bias_d on VSS sky130_fd_pr__nfet_01v8 ad=0.406 pd=3.38 as=0.406 ps=3.38 w=1.4 l=0.6
X464 VSS cmc nmos_single_5__A_0.x2_tail VSS sky130_fd_pr__nfet_01v8 ad=0.406 pd=3.38 as=0.406 ps=3.38 w=1.4 l=0.6
X465 VSS bias_a nmos_dummy_18__A_0.x2_m4d VSS sky130_fd_pr__nfet_01v8 ad=0.406 pd=3.38 as=0.406 ps=3.38 w=1.4 l=0.6
X466 nmos_dummy_9__A_0.x1_m5d nmos_single__A_0.bias_d bias_a VSS sky130_fd_pr__nfet_01v8 ad=0.406 pd=3.38 as=0.406 ps=3.38 w=1.4 l=0.6
X467 on nmos_single__A_0.bias_d nmos_dummy_19__A_0.x2_m3d VSS sky130_fd_pr__nfet_01v8 ad=0.406 pd=3.38 as=0.406 ps=3.38 w=1.4 l=0.6
X468 pmos_dummy_17__A_0.x2_foldp nmos_diode__A_0.bias_c on VDD sky130_fd_pr__pfet_01v8 ad=0.406 pd=3.38 as=0.406 ps=3.38 w=1.4 l=0.6
X469 op cmc sky130_fd_pr__cap_mim_m3_1 l=4.8 w=4.8
X470 VSS VSS nmos_dummy_19__A_0.x2_m3d VSS sky130_fd_pr__nfet_01v8 ad=0.406 pd=3.38 as=0.406 ps=3.38 w=1.4 l=0.6
X471 VSS IBIAS nmos_diode__A_0.bias_c VSS sky130_fd_pr__nfet_01v8 ad=0.406 pd=3.38 as=0.406 ps=3.38 w=1.4 l=0.6
X472 VSS bias_a nmos_dummy_9__A_0.x1_m5d VSS sky130_fd_pr__nfet_01v8 ad=0.406 pd=3.38 as=0.406 ps=3.38 w=1.4 l=0.6
X473 VSS cmc nmos_single_5__A_0.x2_tail VSS sky130_fd_pr__nfet_01v8 ad=0.406 pd=3.38 as=0.406 ps=3.38 w=1.4 l=0.6
X474 nmos_matched_cascode_pair_6__AB_0.x1_net7 cm cm VSS sky130_fd_pr__nfet_01v8 ad=0.406 pd=3.38 as=0.406 ps=3.38 w=1.4 l=0.6
X475 pmos_dummy_16__A_0.x2_foldn nmos_diode__A_0.bias_c op VDD sky130_fd_pr__pfet_01v8 ad=0.406 pd=3.38 as=0.406 ps=3.38 w=1.4 l=0.6
X476 VSS bias_a nmos_dummy_18__A_0.x2_m4d VSS sky130_fd_pr__nfet_01v8 ad=0.406 pd=3.38 as=0.406 ps=3.38 w=1.4 l=0.6
X477 nmos_diode__A_0.bias_c nmos_diode__A_0.bias_c nmos_diode__A_0.bias_c VSS sky130_fd_pr__nfet_01v8_lvt ad=0.406 pd=3.38 as=0 ps=0 w=1.4 l=0.6
X478 VSS VSS nmos_dummy_18__A_0.x2_m4d VSS sky130_fd_pr__nfet_01v8 ad=0.406 pd=3.38 as=0.406 ps=3.38 w=1.4 l=0.6
X479 nmos_single__A_0.bias_d nmos_single__A_0.bias_d nmos_single__A_0.bias_d VSS sky130_fd_pr__nfet_01v8 ad=0.406 pd=3.38 as=0 ps=0 w=1.4 l=0.6
X480 VSS bias_a nmos_dummy_19__A_0.x2_m3d VSS sky130_fd_pr__nfet_01v8 ad=0.406 pd=3.38 as=0.406 ps=3.38 w=1.4 l=0.6
X481 IBIAS IBIAS VSS VSS sky130_fd_pr__nfet_01v8 ad=0.406 pd=3.38 as=0.406 ps=3.38 w=1.4 l=0.6
X482 VSS bias_a nmos_dummy_18__A_0.x2_m4d VSS sky130_fd_pr__nfet_01v8 ad=0.406 pd=3.38 as=0.406 ps=3.38 w=1.4 l=0.6
X483 nmos_single__A_0.bias_d nmos_single__A_0.x1_m2d nmos_single__A_0.x1_m2d VSS sky130_fd_pr__nfet_01v8 ad=0.406 pd=3.38 as=0.406 ps=3.38 w=1.4 l=0.6
X484 VSS VSS VSS VSS sky130_fd_pr__nfet_01v8_lvt ad=0.348 pd=2.98 as=0 ps=0 w=1.2 l=0.2
X485 nmos_matched_cascode_pair_7__AB_0.x1_net9 cm VSS VSS sky130_fd_pr__nfet_01v8 ad=0.406 pd=3.38 as=0.406 ps=3.38 w=1.4 l=0.6
X486 on nmos_single__A_0.bias_d nmos_dummy_19__A_0.x2_m3d VSS sky130_fd_pr__nfet_01v8 ad=0.406 pd=3.38 as=0.406 ps=3.38 w=1.4 l=0.6
X487 nmos_diode__A_0.bias_b nmos_diode__A_0.bias_c pmos_dummy_6__A_0.x1_m21d VDD sky130_fd_pr__pfet_01v8 ad=0.406 pd=3.38 as=0.406 ps=3.38 w=1.4 l=0.6
X488 VSS cmc nmos_single_5__A_0.x2_tail VSS sky130_fd_pr__nfet_01v8 ad=0.406 pd=3.38 as=0.406 ps=3.38 w=1.4 l=0.6
X489 VSS VSS nmos_dummy_19__A_0.x2_m3d VSS sky130_fd_pr__nfet_01v8 ad=0.406 pd=3.38 as=0.406 ps=3.38 w=1.4 l=0.6
X490 VSS bias_a nmos_dummy_19__A_0.x2_m3d VSS sky130_fd_pr__nfet_01v8 ad=0.406 pd=3.38 as=0.406 ps=3.38 w=1.4 l=0.6
X491 VDD nmos_diode__A_0.bias_b pmos_dummy_16__A_0.x2_foldn VDD sky130_fd_pr__pfet_01v8_lvt ad=0.406 pd=3.38 as=0.406 ps=3.38 w=1.4 l=0.6
X492 VSS cmc nmos_single_5__A_0.x2_tail VSS sky130_fd_pr__nfet_01v8 ad=0.406 pd=3.38 as=0.406 ps=3.38 w=1.4 l=0.6
X493 VSS bias_a nmos_single_5__A_0.x2_tail VSS sky130_fd_pr__nfet_01v8 ad=0.406 pd=3.38 as=0.406 ps=3.38 w=1.4 l=0.6
X494 nmos_single_5__A_0.x2_tail nmos_single_5__A_0.x2_tail nmos_single_5__A_0.x2_tail VSS sky130_fd_pr__nfet_01v8 ad=0.406 pd=3.38 as=0 ps=0 w=1.4 l=0.6
X495 nmos_diode__A_0.bias_c nmos_diode__A_0.bias_b nmos_diode__A_0.bias_b VSS sky130_fd_pr__nfet_01v8_lvt ad=0.406 pd=3.38 as=0.406 ps=3.38 w=1.4 l=0.6
X496 nmos_diode__A_0.bias_c nmos_diode__A_0.bias_b nmos_diode__A_0.bias_b VSS sky130_fd_pr__nfet_01v8_lvt ad=0.406 pd=3.38 as=0.406 ps=3.38 w=1.4 l=0.6
X497 VSS bias_a nmos_dummy_18__A_0.x2_m4d VSS sky130_fd_pr__nfet_01v8 ad=0.406 pd=3.38 as=0.406 ps=3.38 w=1.4 l=0.6
X498 on nmos_single__A_0.bias_d nmos_dummy_19__A_0.x2_m3d VSS sky130_fd_pr__nfet_01v8 ad=0.406 pd=3.38 as=0.406 ps=3.38 w=1.4 l=0.6
X499 IBIAS IBIAS VSS VSS sky130_fd_pr__nfet_01v8 ad=0.406 pd=3.38 as=0.406 ps=3.38 w=1.4 l=0.6
X500 VDD VDD pmos_single__A_0.x1_m31d VDD sky130_fd_pr__pfet_01v8 ad=0.406 pd=3.38 as=0.406 ps=3.38 w=1.4 l=0.6
X501 op nmos_single__A_0.bias_d nmos_dummy_18__A_0.x2_m4d VSS sky130_fd_pr__nfet_01v8 ad=0.406 pd=3.38 as=0.406 ps=3.38 w=1.4 l=0.6
X502 VSS cmc nmos_single_5__A_0.x2_tail VSS sky130_fd_pr__nfet_01v8 ad=0.406 pd=3.38 as=0.406 ps=3.38 w=1.4 l=0.6
X503 nmos_dummy_18__A_0.x2_m4d nmos_single__A_0.bias_d op VSS sky130_fd_pr__nfet_01v8 ad=0.406 pd=3.38 as=0.406 ps=3.38 w=1.4 l=0.6
X504 VSS bias_a nmos_single_5__A_0.x2_tail VSS sky130_fd_pr__nfet_01v8 ad=0.406 pd=3.38 as=0.406 ps=3.38 w=1.4 l=0.6
X505 nmos_single_5__A_0.x2_tail nmos_single_5__A_0.x2_tail nmos_single_5__A_0.x2_tail VSS sky130_fd_pr__nfet_01v8 ad=0.406 pd=3.38 as=0 ps=0 w=1.4 l=0.6
X506 VSS bias_a nmos_dummy_18__A_0.x2_m4d VSS sky130_fd_pr__nfet_01v8 ad=0.406 pd=3.38 as=0.406 ps=3.38 w=1.4 l=0.6
X507 VDD nmos_diode__A_0.bias_b pmos_dummy_17__A_0.x2_foldp VDD sky130_fd_pr__pfet_01v8_lvt ad=0.406 pd=3.38 as=0.406 ps=3.38 w=1.4 l=0.6
X508 VSS bias_a nmos_single_5__A_0.x2_tail VSS sky130_fd_pr__nfet_01v8 ad=0.406 pd=3.38 as=0.406 ps=3.38 w=1.4 l=0.6
X509 VSS bias_a nmos_dummy_19__A_0.x2_m3d VSS sky130_fd_pr__nfet_01v8 ad=0.406 pd=3.38 as=0.406 ps=3.38 w=1.4 l=0.6
X510 nmos_diode__A_0.bias_b nmos_diode__A_0.bias_b nmos_diode__A_0.bias_b VSS sky130_fd_pr__nfet_01v8_lvt ad=0.406 pd=3.38 as=0 ps=0 w=1.4 l=0.6
X511 nmos_dummy_19__A_0.x2_m3d nmos_single__A_0.bias_d on VSS sky130_fd_pr__nfet_01v8 ad=0.406 pd=3.38 as=0.406 ps=3.38 w=1.4 l=0.6
X512 pmos_dummy_6__A_0.x1_m21d nmos_diode__A_0.bias_c nmos_diode__A_0.bias_b VDD sky130_fd_pr__pfet_01v8 ad=0.406 pd=3.38 as=0.406 ps=3.38 w=1.4 l=0.6
X513 nmos_single__A_0.bias_d nmos_single__A_0.x1_m2d nmos_single__A_0.x1_m2d VSS sky130_fd_pr__nfet_01v8 ad=0.406 pd=3.38 as=0.406 ps=3.38 w=1.4 l=0.6
X514 nmos_single__A_0.bias_d nmos_single__A_0.x1_m2d nmos_single__A_0.x1_m2d VSS sky130_fd_pr__nfet_01v8 ad=0.406 pd=3.38 as=0.406 ps=3.38 w=1.4 l=0.6
X515 VDD VDD VDD VDD sky130_fd_pr__pfet_01v8_lvt ad=0.406 pd=3.38 as=0 ps=0 w=1.4 l=0.6
X516 VSS bias_a nmos_dummy_19__A_0.x2_m3d VSS sky130_fd_pr__nfet_01v8 ad=0.406 pd=3.38 as=0.406 ps=3.38 w=1.4 l=0.6
X517 pmos_dummy_6__A_0.x1_m21d pmos_dummy_6__A_0.x1_m21d pmos_dummy_6__A_0.x1_m21d VDD sky130_fd_pr__pfet_01v8 ad=0.406 pd=3.38 as=0 ps=0 w=1.4 l=0.6
X518 nmos_diode__A_0.bias_b nmos_diode__A_0.bias_b nmos_diode__A_0.bias_b VSS sky130_fd_pr__nfet_01v8_lvt ad=0.406 pd=3.38 as=0 ps=0 w=1.4 l=0.6
X519 nmos_diode__A_0.bias_c nmos_diode__A_0.bias_b nmos_diode__A_0.bias_b VSS sky130_fd_pr__nfet_01v8_lvt ad=0.406 pd=3.38 as=0.406 ps=3.38 w=1.4 l=0.6
X520 nmos_dummy_9__A_0.x1_m5d nmos_dummy_9__A_0.x1_m5d nmos_dummy_9__A_0.x1_m5d VSS sky130_fd_pr__nfet_01v8 ad=0.406 pd=3.38 as=0 ps=0 w=1.4 l=0.6
X521 nmos_dummy_18__A_0.x2_m4d nmos_single__A_0.bias_d op VSS sky130_fd_pr__nfet_01v8 ad=0.406 pd=3.38 as=0.406 ps=3.38 w=1.4 l=0.6
X522 VSS VSS VSS VSS sky130_fd_pr__nfet_01v8 ad=0.406 pd=3.38 as=0 ps=0 w=1.4 l=0.6
X523 VSS bias_a nmos_dummy_19__A_0.x2_m3d VSS sky130_fd_pr__nfet_01v8 ad=0.406 pd=3.38 as=0.406 ps=3.38 w=1.4 l=0.6
X524 cm cm cm VSS sky130_fd_pr__nfet_01v8 ad=0.406 pd=3.38 as=0 ps=0 w=1.4 l=0.6
X525 nmos_matched_cascode_pair_11__AB_0.x1_net15 cm VSS VSS sky130_fd_pr__nfet_01v8 ad=0.406 pd=3.38 as=0.406 ps=3.38 w=1.4 l=0.6
X526 VSS cmc nmos_single_5__A_0.x2_tail VSS sky130_fd_pr__nfet_01v8 ad=0.406 pd=3.38 as=0.406 ps=3.38 w=1.4 l=0.6
X527 VSS bias_a nmos_single_5__A_0.x2_tail VSS sky130_fd_pr__nfet_01v8 ad=0.406 pd=3.38 as=0.406 ps=3.38 w=1.4 l=0.6
X528 VSS bias_a nmos_single_5__A_0.x2_tail VSS sky130_fd_pr__nfet_01v8 ad=0.406 pd=3.38 as=0.406 ps=3.38 w=1.4 l=0.6
X529 nmos_dummy_18__A_0.x2_m4d nmos_single__A_0.bias_d op VSS sky130_fd_pr__nfet_01v8 ad=0.406 pd=3.38 as=0.406 ps=3.38 w=1.4 l=0.6
X530 VSS VSS VSS VSS sky130_fd_pr__nfet_01v8 ad=0.406 pd=3.38 as=0 ps=0 w=1.4 l=0.6
X531 nmos_dummy_19__A_0.x2_m3d nmos_single__A_0.bias_d on VSS sky130_fd_pr__nfet_01v8 ad=0.406 pd=3.38 as=0.406 ps=3.38 w=1.4 l=0.6
X532 nmos_single_5__A_0.x2_tail in pmos_dummy_16__A_0.x2_foldn VSS sky130_fd_pr__nfet_01v8_lvt ad=0.348 pd=2.98 as=0.348 ps=2.98 w=1.2 l=0.2
X533 nmos_single__A_0.x1_m2d nmos_diode__A_0.bias_c pmos_dummy_7__A_0.x1_m25d VDD sky130_fd_pr__pfet_01v8 ad=0.406 pd=3.38 as=0.406 ps=3.38 w=1.4 l=0.6
X534 pmos_dummy_17__A_0.x2_foldp nmos_diode__A_0.bias_c on VDD sky130_fd_pr__pfet_01v8 ad=0.406 pd=3.38 as=0.406 ps=3.38 w=1.4 l=0.6
X535 VSS cmc nmos_single_5__A_0.x2_tail VSS sky130_fd_pr__nfet_01v8 ad=0.406 pd=3.38 as=0.406 ps=3.38 w=1.4 l=0.6
X536 VSS cmc nmos_single_5__A_0.x2_tail VSS sky130_fd_pr__nfet_01v8 ad=0.406 pd=3.38 as=0.406 ps=3.38 w=1.4 l=0.6
X537 nmos_single__A_0.bias_d nmos_single__A_0.x1_m2d nmos_single__A_0.x1_m2d VSS sky130_fd_pr__nfet_01v8 ad=0.406 pd=3.38 as=0.406 ps=3.38 w=1.4 l=0.6
X538 VSS bias_a nmos_dummy_18__A_0.x2_m4d VSS sky130_fd_pr__nfet_01v8 ad=0.406 pd=3.38 as=0.406 ps=3.38 w=1.4 l=0.6
X539 VSS bias_a nmos_dummy_9__A_0.x1_m5d VSS sky130_fd_pr__nfet_01v8 ad=0.406 pd=3.38 as=0.406 ps=3.38 w=1.4 l=0.6
X540 VSS cmc nmos_single_5__A_0.x2_tail VSS sky130_fd_pr__nfet_01v8 ad=0.406 pd=3.38 as=0.406 ps=3.38 w=1.4 l=0.6
X541 nmos_dummy_19__A_0.x2_m3d nmos_single__A_0.bias_d on VSS sky130_fd_pr__nfet_01v8 ad=0.406 pd=3.38 as=0.406 ps=3.38 w=1.4 l=0.6
X542 pmos_single__A_0.x1_m31d nmos_diode__A_0.bias_c cm VDD sky130_fd_pr__pfet_01v8 ad=0.406 pd=3.38 as=0.406 ps=3.38 w=1.4 l=0.6
X543 nmos_diode__A_0.bias_c nmos_diode__A_0.bias_b nmos_diode__A_0.bias_b VSS sky130_fd_pr__nfet_01v8_lvt ad=0.406 pd=3.38 as=0.406 ps=3.38 w=1.4 l=0.6
X544 nmos_dummy_9__A_0.x1_m5d nmos_single__A_0.bias_d bias_a VSS sky130_fd_pr__nfet_01v8 ad=0.406 pd=3.38 as=0.406 ps=3.38 w=1.4 l=0.6
X545 op nmos_single__A_0.bias_d nmos_dummy_18__A_0.x2_m4d VSS sky130_fd_pr__nfet_01v8 ad=0.406 pd=3.38 as=0.406 ps=3.38 w=1.4 l=0.6
X546 VSS cmc nmos_single_5__A_0.x2_tail VSS sky130_fd_pr__nfet_01v8 ad=0.406 pd=3.38 as=0.406 ps=3.38 w=1.4 l=0.6
X547 pmos_single__A_0.x1_m31d nmos_diode__A_0.bias_c cm VDD sky130_fd_pr__pfet_01v8 ad=0.406 pd=3.38 as=0.406 ps=3.38 w=1.4 l=0.6
X548 nmos_single__A_0.bias_d nmos_single__A_0.bias_d nmos_single__A_0.bias_d VSS sky130_fd_pr__nfet_01v8 ad=0.406 pd=3.38 as=0 ps=0 w=1.4 l=0.6
X549 VSS cmc nmos_single_5__A_0.x2_tail VSS sky130_fd_pr__nfet_01v8 ad=0.406 pd=3.38 as=0.406 ps=3.38 w=1.4 l=0.6
X550 VDD VDD nmos_single__A_0.x1_m2d VDD sky130_fd_pr__pfet_01v8 ad=0.406 pd=3.38 as=0.406 ps=3.38 w=1.4 l=0.6
X551 VSS IBIAS IBIAS VSS sky130_fd_pr__nfet_01v8 ad=0.406 pd=3.38 as=0.406 ps=3.38 w=1.4 l=0.6
X552 VSS bias_a nmos_single_5__A_0.x2_tail VSS sky130_fd_pr__nfet_01v8 ad=0.406 pd=3.38 as=0.406 ps=3.38 w=1.4 l=0.6
X553 VSS VSS VSS VSS sky130_fd_pr__nfet_01v8 ad=0.406 pd=3.38 as=0 ps=0 w=1.4 l=0.6
X554 VSS bias_a nmos_single_5__A_0.x2_tail VSS sky130_fd_pr__nfet_01v8 ad=0.406 pd=3.38 as=0.406 ps=3.38 w=1.4 l=0.6
X555 VSS bias_a nmos_single_5__A_0.x2_tail VSS sky130_fd_pr__nfet_01v8 ad=0.406 pd=3.38 as=0.406 ps=3.38 w=1.4 l=0.6
X556 nmos_diode__A_0.bias_c nmos_diode__A_0.bias_b nmos_diode__A_0.bias_b VSS sky130_fd_pr__nfet_01v8_lvt ad=0.406 pd=3.38 as=0.406 ps=3.38 w=1.4 l=0.6
X557 nmos_single__A_0.bias_d nmos_single__A_0.bias_d nmos_single__A_0.bias_d VSS sky130_fd_pr__nfet_01v8 ad=0.406 pd=3.38 as=0 ps=0 w=1.4 l=0.6
X558 VSS cmc nmos_single_5__A_0.x2_tail VSS sky130_fd_pr__nfet_01v8 ad=0.406 pd=3.38 as=0.406 ps=3.38 w=1.4 l=0.6
X559 VSS cmc nmos_single_5__A_0.x2_tail VSS sky130_fd_pr__nfet_01v8 ad=0.406 pd=3.38 as=0.406 ps=3.38 w=1.4 l=0.6
X560 VDD nmos_diode__A_0.bias_b pmos_dummy_16__A_0.x2_foldn VDD sky130_fd_pr__pfet_01v8_lvt ad=0.406 pd=3.38 as=0.406 ps=3.38 w=1.4 l=0.6
X561 nmos_dummy_18__A_0.x2_m4d nmos_single__A_0.bias_d op VSS sky130_fd_pr__nfet_01v8 ad=0.406 pd=3.38 as=0.406 ps=3.38 w=1.4 l=0.6
X562 VSS cmc nmos_single_5__A_0.x2_tail VSS sky130_fd_pr__nfet_01v8 ad=0.406 pd=3.38 as=0.406 ps=3.38 w=1.4 l=0.6
X563 VSS bias_a nmos_dummy_19__A_0.x2_m3d VSS sky130_fd_pr__nfet_01v8 ad=0.406 pd=3.38 as=0.406 ps=3.38 w=1.4 l=0.6
X564 VDD VDD VDD VDD sky130_fd_pr__pfet_01v8 ad=0.406 pd=3.38 as=0 ps=0 w=1.4 l=0.6
X565 VSS bias_a nmos_single_5__A_0.x2_tail VSS sky130_fd_pr__nfet_01v8 ad=0.406 pd=3.38 as=0.406 ps=3.38 w=1.4 l=0.6
X566 nmos_matched_cascode_pair_9__AB_0.x1_net12 cm nmos_matched_cascode_pair_9__AB_0.x1_net11 VSS sky130_fd_pr__nfet_01v8 ad=0.406 pd=3.38 as=0.406 ps=3.38 w=1.4 l=0.6
X567 nmos_single__A_0.bias_d nmos_single__A_0.x1_m2d nmos_single__A_0.x1_m2d VSS sky130_fd_pr__nfet_01v8 ad=0.406 pd=3.38 as=0.406 ps=3.38 w=1.4 l=0.6
X568 nmos_single__A_0.bias_d nmos_single__A_0.x1_m2d nmos_single__A_0.x1_m2d VSS sky130_fd_pr__nfet_01v8 ad=0.406 pd=3.38 as=0.406 ps=3.38 w=1.4 l=0.6
X569 nmos_diode__A_0.bias_c IBIAS VSS VSS sky130_fd_pr__nfet_01v8 ad=0.406 pd=3.38 as=0.406 ps=3.38 w=1.4 l=0.6
X570 nmos_dummy_9__A_0.x1_m5d nmos_single__A_0.bias_d bias_a VSS sky130_fd_pr__nfet_01v8 ad=0.406 pd=3.38 as=0.406 ps=3.38 w=1.4 l=0.6
X571 nmos_single__A_0.x1_m2d nmos_single__A_0.x1_m2d nmos_single__A_0.x1_m2d VSS sky130_fd_pr__nfet_01v8 ad=0.406 pd=3.38 as=21.924 ps=182.52 w=1.4 l=0.6
X572 VDD nmos_diode__A_0.bias_b pmos_dummy_16__A_0.x2_foldn VDD sky130_fd_pr__pfet_01v8_lvt ad=0.406 pd=3.38 as=0.406 ps=3.38 w=1.4 l=0.6
X573 VSS bias_a nmos_single_5__A_0.x2_tail VSS sky130_fd_pr__nfet_01v8 ad=0.406 pd=3.38 as=0.406 ps=3.38 w=1.4 l=0.6
X574 VSS bias_a nmos_single_5__A_0.x2_tail VSS sky130_fd_pr__nfet_01v8 ad=0.406 pd=3.38 as=0.406 ps=3.38 w=1.4 l=0.6
X575 VSS VSS nmos_dummy_9__A_0.x1_m5d VSS sky130_fd_pr__nfet_01v8 ad=0.406 pd=3.38 as=0.406 ps=3.38 w=1.4 l=0.6
X576 VDD nmos_diode__A_0.bias_b pmos_dummy_17__A_0.x2_foldp VDD sky130_fd_pr__pfet_01v8_lvt ad=0.406 pd=3.38 as=0.406 ps=3.38 w=1.4 l=0.6
X577 VSS bias_a nmos_single_5__A_0.x2_tail VSS sky130_fd_pr__nfet_01v8 ad=0.406 pd=3.38 as=0.406 ps=3.38 w=1.4 l=0.6
X578 pmos_dummy_17__A_0.x2_foldp nmos_diode__A_0.bias_c on VDD sky130_fd_pr__pfet_01v8 ad=0.406 pd=3.38 as=0.406 ps=3.38 w=1.4 l=0.6
X579 VSS VSS nmos_dummy_19__A_0.x2_m3d VSS sky130_fd_pr__nfet_01v8 ad=0.406 pd=3.38 as=0.406 ps=3.38 w=1.4 l=0.6
X580 nmos_diode__A_0.bias_c nmos_diode__A_0.bias_b nmos_diode__A_0.bias_b VSS sky130_fd_pr__nfet_01v8_lvt ad=0.406 pd=3.38 as=0.406 ps=3.38 w=1.4 l=0.6
X581 IBIAS IBIAS VSS VSS sky130_fd_pr__nfet_01v8 ad=0.406 pd=3.38 as=0.406 ps=3.38 w=1.4 l=0.6
X582 VDD nmos_diode__A_0.bias_b pmos_dummy_16__A_0.x2_foldn VDD sky130_fd_pr__pfet_01v8_lvt ad=0.406 pd=3.38 as=0.406 ps=3.38 w=1.4 l=0.6
X583 VSS bias_a nmos_single_5__A_0.x2_tail VSS sky130_fd_pr__nfet_01v8 ad=0.406 pd=3.38 as=0.406 ps=3.38 w=1.4 l=0.6
X584 nmos_single_5__A_0.x2_tail ip pmos_dummy_17__A_0.x2_foldp VSS sky130_fd_pr__nfet_01v8_lvt ad=0.348 pd=2.98 as=0.348 ps=2.98 w=1.2 l=0.2
X585 VDD VDD pmos_dummy_17__A_0.x2_foldp VDD sky130_fd_pr__pfet_01v8 ad=0.406 pd=3.38 as=0.406 ps=3.38 w=1.4 l=0.6
X586 VSS cmc nmos_single_5__A_0.x2_tail VSS sky130_fd_pr__nfet_01v8 ad=0.406 pd=3.38 as=0.406 ps=3.38 w=1.4 l=0.6
X587 VSS bias_a nmos_dummy_19__A_0.x2_m3d VSS sky130_fd_pr__nfet_01v8 ad=0.406 pd=3.38 as=0.406 ps=3.38 w=1.4 l=0.6
X588 op nmos_single__A_0.bias_d nmos_dummy_18__A_0.x2_m4d VSS sky130_fd_pr__nfet_01v8 ad=0.406 pd=3.38 as=0.406 ps=3.38 w=1.4 l=0.6
X589 VSS VSS VSS VSS sky130_fd_pr__nfet_01v8 ad=0.406 pd=3.38 as=0 ps=0 w=1.4 l=0.6
X590 VSS cmc nmos_single_5__A_0.x2_tail VSS sky130_fd_pr__nfet_01v8 ad=0.406 pd=3.38 as=0.406 ps=3.38 w=1.4 l=0.6
X591 VDD VDD VDD VDD sky130_fd_pr__pfet_01v8 ad=0.406 pd=3.38 as=0 ps=0 w=1.4 l=0.6
X592 nmos_single_5__A_0.x2_tail in pmos_dummy_16__A_0.x2_foldn VSS sky130_fd_pr__nfet_01v8_lvt ad=0.348 pd=2.98 as=0.348 ps=2.98 w=1.2 l=0.2
X593 nmos_single__A_0.bias_d nmos_single__A_0.x1_m2d nmos_single__A_0.x1_m2d VSS sky130_fd_pr__nfet_01v8 ad=0.406 pd=3.38 as=0.406 ps=3.38 w=1.4 l=0.6
X594 VSS bias_a nmos_dummy_19__A_0.x2_m3d VSS sky130_fd_pr__nfet_01v8 ad=0.406 pd=3.38 as=0.406 ps=3.38 w=1.4 l=0.6
X595 VDD nmos_diode__A_0.bias_b pmos_dummy_7__A_0.x1_m25d VDD sky130_fd_pr__pfet_01v8_lvt ad=0.406 pd=3.38 as=0.406 ps=3.38 w=1.4 l=0.6
X596 nmos_single_5__A_0.x2_tail in pmos_dummy_16__A_0.x2_foldn VSS sky130_fd_pr__nfet_01v8_lvt ad=0.348 pd=2.98 as=0.348 ps=2.98 w=1.2 l=0.2
X597 pmos_dummy_17__A_0.x2_foldp nmos_diode__A_0.bias_c on VDD sky130_fd_pr__pfet_01v8 ad=0.406 pd=3.38 as=0.406 ps=3.38 w=1.4 l=0.6
X598 nmos_diode__A_0.bias_c nmos_diode__A_0.bias_b nmos_diode__A_0.bias_b VSS sky130_fd_pr__nfet_01v8_lvt ad=0.406 pd=3.38 as=0.406 ps=3.38 w=1.4 l=0.6
X599 VSS cmc nmos_single_5__A_0.x2_tail VSS sky130_fd_pr__nfet_01v8 ad=0.406 pd=3.38 as=0.406 ps=3.38 w=1.4 l=0.6
X600 pmos_dummy_7__A_0.x1_m25d nmos_diode__A_0.bias_b VDD VDD sky130_fd_pr__pfet_01v8_lvt ad=0.406 pd=3.38 as=0.406 ps=3.38 w=1.4 l=0.6
X601 pmos_dummy_17__A_0.x2_foldp pmos_dummy_17__A_0.x2_foldp pmos_dummy_17__A_0.x2_foldp VSS sky130_fd_pr__nfet_01v8_lvt ad=0.348 pd=2.98 as=3.48 ps=29.8 w=1.2 l=0.2
X602 op nmos_single__A_0.bias_d nmos_dummy_18__A_0.x2_m4d VSS sky130_fd_pr__nfet_01v8 ad=0.406 pd=3.38 as=0.406 ps=3.38 w=1.4 l=0.6
X603 pmos_dummy_16__A_0.x2_foldn nmos_diode__A_0.bias_c op VDD sky130_fd_pr__pfet_01v8 ad=0.406 pd=3.38 as=0.406 ps=3.38 w=1.4 l=0.6
X604 VSS cmc nmos_single_5__A_0.x2_tail VSS sky130_fd_pr__nfet_01v8 ad=0.406 pd=3.38 as=0.406 ps=3.38 w=1.4 l=0.6
X605 VSS cmc nmos_single_5__A_0.x2_tail VSS sky130_fd_pr__nfet_01v8 ad=0.406 pd=3.38 as=0.406 ps=3.38 w=1.4 l=0.6
X606 nmos_single_5__A_0.x2_tail in pmos_dummy_16__A_0.x2_foldn VSS sky130_fd_pr__nfet_01v8_lvt ad=0.348 pd=2.98 as=0.348 ps=2.98 w=1.2 l=0.2
X607 pmos_dummy_16__A_0.x2_foldn pmos_dummy_16__A_0.x2_foldn pmos_dummy_16__A_0.x2_foldn VSS sky130_fd_pr__nfet_01v8_lvt ad=0.348 pd=2.98 as=3.48 ps=29.8 w=1.2 l=0.2
X608 nmos_matched_cascode_pair_10__AB_0.x1_net13 cm cm VSS sky130_fd_pr__nfet_01v8 ad=0.406 pd=3.38 as=0.406 ps=3.38 w=1.4 l=0.6
X609 VSS cmc nmos_single_5__A_0.x2_tail VSS sky130_fd_pr__nfet_01v8 ad=0.406 pd=3.38 as=0.406 ps=3.38 w=1.4 l=0.6
X610 VSS bias_a nmos_single_5__A_0.x2_tail VSS sky130_fd_pr__nfet_01v8 ad=0.406 pd=3.38 as=0.406 ps=3.38 w=1.4 l=0.6
X611 VSS bias_a nmos_dummy_19__A_0.x2_m3d VSS sky130_fd_pr__nfet_01v8 ad=0.406 pd=3.38 as=0.406 ps=3.38 w=1.4 l=0.6
X612 nmos_diode__A_0.bias_c nmos_diode__A_0.bias_b nmos_diode__A_0.bias_b VSS sky130_fd_pr__nfet_01v8_lvt ad=0.406 pd=3.38 as=0.406 ps=3.38 w=1.4 l=0.6
X613 nmos_single__A_0.bias_d nmos_single__A_0.x1_m2d nmos_single__A_0.x1_m2d VSS sky130_fd_pr__nfet_01v8 ad=0.406 pd=3.38 as=0.406 ps=3.38 w=1.4 l=0.6
X614 nmos_single__A_0.bias_d nmos_single__A_0.x1_m2d nmos_single__A_0.x1_m2d VSS sky130_fd_pr__nfet_01v8 ad=0.406 pd=3.38 as=0.406 ps=3.38 w=1.4 l=0.6
X615 nmos_matched_cascode_pair_6__AB_0.x1_net7 cm nmos_matched_cascode_pair_7__AB_0.x1_net8 VSS sky130_fd_pr__nfet_01v8 ad=0.406 pd=3.38 as=0.406 ps=3.38 w=1.4 l=0.6
X616 VSS bias_a nmos_dummy_18__A_0.x2_m4d VSS sky130_fd_pr__nfet_01v8 ad=0.406 pd=3.38 as=0.406 ps=3.38 w=1.4 l=0.6
X617 op nmos_single__A_0.bias_d nmos_dummy_18__A_0.x2_m4d VSS sky130_fd_pr__nfet_01v8 ad=0.406 pd=3.38 as=0.406 ps=3.38 w=1.4 l=0.6
X618 VSS VSS VSS VSS sky130_fd_pr__nfet_01v8 ad=0.406 pd=3.38 as=0 ps=0 w=1.4 l=0.6
X619 nmos_matched_cascode_pair_2__AB_0.x1_net1 cm cm VSS sky130_fd_pr__nfet_01v8 ad=0.406 pd=3.38 as=0.406 ps=3.38 w=1.4 l=0.6
X620 pmos_dummy_17__A_0.x2_foldp nmos_diode__A_0.bias_c on VDD sky130_fd_pr__pfet_01v8 ad=0.406 pd=3.38 as=0.406 ps=3.38 w=1.4 l=0.6
X621 VSS bias_a nmos_single_5__A_0.x2_tail VSS sky130_fd_pr__nfet_01v8 ad=0.406 pd=3.38 as=0.406 ps=3.38 w=1.4 l=0.6
X622 VSS bias_a nmos_dummy_18__A_0.x2_m4d VSS sky130_fd_pr__nfet_01v8 ad=0.406 pd=3.38 as=0.406 ps=3.38 w=1.4 l=0.6
X623 VSS bias_a nmos_dummy_19__A_0.x2_m3d VSS sky130_fd_pr__nfet_01v8 ad=0.406 pd=3.38 as=0.406 ps=3.38 w=1.4 l=0.6
X624 nmos_matched_cascode_pair_4__AB_0.x1_net4 cm nmos_matched_cascode_pair_5__AB_0.x1_net5 VSS sky130_fd_pr__nfet_01v8 ad=0.406 pd=3.38 as=0.406 ps=3.38 w=1.4 l=0.6
X625 nmos_matched_cascode_pair_5__AB_0.x1_net6 cm VSS VSS sky130_fd_pr__nfet_01v8 ad=0.406 pd=3.38 as=0.406 ps=3.38 w=1.4 l=0.6
X626 nmos_diode__A_0.bias_b nmos_diode__A_0.bias_b nmos_diode__A_0.bias_b VSS sky130_fd_pr__nfet_01v8_lvt ad=0.406 pd=3.38 as=0 ps=0 w=1.4 l=0.6
X627 VSS VSS VSS VSS sky130_fd_pr__nfet_01v8 ad=0.406 pd=3.38 as=0 ps=0 w=1.4 l=0.6
X628 VSS bias_a nmos_dummy_19__A_0.x2_m3d VSS sky130_fd_pr__nfet_01v8 ad=0.406 pd=3.38 as=0.406 ps=3.38 w=1.4 l=0.6
X629 VDD VDD nmos_single__A_0.x1_m2d VDD sky130_fd_pr__pfet_01v8 ad=0.406 pd=3.38 as=0.406 ps=3.38 w=1.4 l=0.6
X630 VSS bias_a nmos_dummy_19__A_0.x2_m3d VSS sky130_fd_pr__nfet_01v8 ad=0.406 pd=3.38 as=0.406 ps=3.38 w=1.4 l=0.6
X631 nmos_diode__A_0.bias_c nmos_diode__A_0.bias_b nmos_diode__A_0.bias_b VSS sky130_fd_pr__nfet_01v8_lvt ad=0.406 pd=3.38 as=0.406 ps=3.38 w=1.4 l=0.6
X632 nmos_diode__A_0.bias_c nmos_diode__A_0.bias_b nmos_diode__A_0.bias_b VSS sky130_fd_pr__nfet_01v8_lvt ad=0.406 pd=3.38 as=0.406 ps=3.38 w=1.4 l=0.6
X633 nmos_dummy_19__A_0.x2_m3d nmos_single__A_0.bias_d on VSS sky130_fd_pr__nfet_01v8 ad=0.406 pd=3.38 as=0.406 ps=3.38 w=1.4 l=0.6
X634 VSS bias_a nmos_single_5__A_0.x2_tail VSS sky130_fd_pr__nfet_01v8 ad=0.406 pd=3.38 as=0.406 ps=3.38 w=1.4 l=0.6
X635 VDD nmos_diode__A_0.bias_b pmos_dummy_17__A_0.x2_foldp VDD sky130_fd_pr__pfet_01v8_lvt ad=0.406 pd=3.38 as=0.406 ps=3.38 w=1.4 l=0.6
X636 on nmos_single__A_0.bias_d nmos_dummy_19__A_0.x2_m3d VSS sky130_fd_pr__nfet_01v8 ad=0.406 pd=3.38 as=0.406 ps=3.38 w=1.4 l=0.6
X637 VSS VSS VSS VSS sky130_fd_pr__nfet_01v8 ad=0.406 pd=3.38 as=0 ps=0 w=1.4 l=0.6
X638 VSS VSS VSS VSS sky130_fd_pr__nfet_01v8 ad=0.406 pd=3.38 as=0 ps=0 w=1.4 l=0.6
X639 nmos_diode__A_0.bias_c nmos_diode__A_0.bias_b nmos_diode__A_0.bias_b VSS sky130_fd_pr__nfet_01v8_lvt ad=0.406 pd=3.38 as=0.406 ps=3.38 w=1.4 l=0.6
X640 cm cm cm VSS sky130_fd_pr__nfet_01v8 ad=0.406 pd=3.38 as=0 ps=0 w=1.4 l=0.6
X641 VDD VDD op VDD sky130_fd_pr__pfet_01v8 ad=0.406 pd=3.38 as=0.406 ps=3.38 w=1.4 l=0.6
X642 pmos_dummy_16__A_0.x2_foldn pmos_dummy_16__A_0.x2_foldn pmos_dummy_16__A_0.x2_foldn VDD sky130_fd_pr__pfet_01v8 ad=0.406 pd=3.38 as=0 ps=0 w=1.4 l=0.6
X643 pmos_dummy_16__A_0.x2_foldn nmos_diode__A_0.bias_c op VDD sky130_fd_pr__pfet_01v8 ad=0.406 pd=3.38 as=0.406 ps=3.38 w=1.4 l=0.6
X644 VSS bias_a nmos_single_5__A_0.x2_tail VSS sky130_fd_pr__nfet_01v8 ad=0.406 pd=3.38 as=0.406 ps=3.38 w=1.4 l=0.6
X645 pmos_dummy_6__A_0.x1_m21d nmos_diode__A_0.bias_c nmos_diode__A_0.bias_b VDD sky130_fd_pr__pfet_01v8 ad=0.406 pd=3.38 as=0.406 ps=3.38 w=1.4 l=0.6
X646 nmos_dummy_9__A_0.x1_m5d nmos_single__A_0.bias_d bias_a VSS sky130_fd_pr__nfet_01v8 ad=0.406 pd=3.38 as=0.406 ps=3.38 w=1.4 l=0.6
X647 pmos_dummy_16__A_0.x2_foldn nmos_diode__A_0.bias_c op VDD sky130_fd_pr__pfet_01v8 ad=0.406 pd=3.38 as=0.406 ps=3.38 w=1.4 l=0.6
X648 VSS bias_a nmos_dummy_19__A_0.x2_m3d VSS sky130_fd_pr__nfet_01v8 ad=0.406 pd=3.38 as=0.406 ps=3.38 w=1.4 l=0.6
X649 nmos_single__A_0.bias_d nmos_single__A_0.x1_m2d nmos_single__A_0.x1_m2d VSS sky130_fd_pr__nfet_01v8 ad=0.406 pd=3.38 as=0.406 ps=3.38 w=1.4 l=0.6
X650 VSS VSS nmos_dummy_9__A_0.x1_m5d VSS sky130_fd_pr__nfet_01v8 ad=0.406 pd=3.38 as=0.406 ps=3.38 w=1.4 l=0.6
X651 VSS bias_a nmos_single_5__A_0.x2_tail VSS sky130_fd_pr__nfet_01v8 ad=0.406 pd=3.38 as=0.406 ps=3.38 w=1.4 l=0.6
X652 nmos_dummy_19__A_0.x2_m3d nmos_single__A_0.bias_d on VSS sky130_fd_pr__nfet_01v8 ad=0.406 pd=3.38 as=0.406 ps=3.38 w=1.4 l=0.6
X653 nmos_dummy_18__A_0.x2_m4d nmos_single__A_0.bias_d op VSS sky130_fd_pr__nfet_01v8 ad=0.406 pd=3.38 as=0.406 ps=3.38 w=1.4 l=0.6
X654 VSS bias_a nmos_single_5__A_0.x2_tail VSS sky130_fd_pr__nfet_01v8 ad=0.406 pd=3.38 as=0.406 ps=3.38 w=1.4 l=0.6
X655 VSS bias_a nmos_single_5__A_0.x2_tail VSS sky130_fd_pr__nfet_01v8 ad=0.406 pd=3.38 as=0.406 ps=3.38 w=1.4 l=0.6
X656 VSS bias_a nmos_single_5__A_0.x2_tail VSS sky130_fd_pr__nfet_01v8 ad=0.406 pd=3.38 as=0.406 ps=3.38 w=1.4 l=0.6
X657 pmos_dummy_7__A_0.x1_m25d nmos_diode__A_0.bias_c nmos_single__A_0.x1_m2d VDD sky130_fd_pr__pfet_01v8 ad=0.406 pd=3.38 as=0.406 ps=3.38 w=1.4 l=0.6
X658 pmos_dummy_17__A_0.x2_foldp nmos_diode__A_0.bias_c on VDD sky130_fd_pr__pfet_01v8 ad=0.406 pd=3.38 as=0.406 ps=3.38 w=1.4 l=0.6
X659 op nmos_single__A_0.bias_d nmos_dummy_18__A_0.x2_m4d VSS sky130_fd_pr__nfet_01v8 ad=0.406 pd=3.38 as=0.406 ps=3.38 w=1.4 l=0.6
X660 VSS cmc nmos_single_5__A_0.x2_tail VSS sky130_fd_pr__nfet_01v8 ad=0.406 pd=3.38 as=0.406 ps=3.38 w=1.4 l=0.6
X661 VSS bias_a nmos_dummy_19__A_0.x2_m3d VSS sky130_fd_pr__nfet_01v8 ad=0.406 pd=3.38 as=0.406 ps=3.38 w=1.4 l=0.6
X662 nmos_single__A_0.bias_d nmos_single__A_0.x1_m2d nmos_single__A_0.x1_m2d VSS sky130_fd_pr__nfet_01v8 ad=0.406 pd=3.38 as=0.406 ps=3.38 w=1.4 l=0.6
X663 VSS bias_a nmos_dummy_9__A_0.x1_m5d VSS sky130_fd_pr__nfet_01v8 ad=0.406 pd=3.38 as=0.406 ps=3.38 w=1.4 l=0.6
X664 VSS bias_a nmos_single_5__A_0.x2_tail VSS sky130_fd_pr__nfet_01v8 ad=0.406 pd=3.38 as=0.406 ps=3.38 w=1.4 l=0.6
X665 op nmos_single__A_0.bias_d nmos_dummy_18__A_0.x2_m4d VSS sky130_fd_pr__nfet_01v8 ad=0.406 pd=3.38 as=0.406 ps=3.38 w=1.4 l=0.6
X666 pmos_dummy_17__A_0.x2_foldp pmos_dummy_17__A_0.x2_foldp pmos_dummy_17__A_0.x2_foldp VSS sky130_fd_pr__nfet_01v8_lvt ad=0.348 pd=2.98 as=0 ps=0 w=1.2 l=0.2
X667 nmos_diode__A_0.bias_c nmos_diode__A_0.bias_b nmos_diode__A_0.bias_b VSS sky130_fd_pr__nfet_01v8_lvt ad=0.406 pd=3.38 as=0.406 ps=3.38 w=1.4 l=0.6
X668 VSS cmc nmos_single_5__A_0.x2_tail VSS sky130_fd_pr__nfet_01v8 ad=0.406 pd=3.38 as=0.406 ps=3.38 w=1.4 l=0.6
X669 pmos_dummy_17__A_0.x2_foldp nmos_diode__A_0.bias_c on VDD sky130_fd_pr__pfet_01v8 ad=0.406 pd=3.38 as=0.406 ps=3.38 w=1.4 l=0.6
X670 nmos_single__A_0.bias_d nmos_single__A_0.bias_d nmos_single__A_0.bias_d VSS sky130_fd_pr__nfet_01v8 ad=0.406 pd=3.38 as=0 ps=0 w=1.4 l=0.6
X671 VSS cmc nmos_single_5__A_0.x2_tail VSS sky130_fd_pr__nfet_01v8 ad=0.406 pd=3.38 as=0.406 ps=3.38 w=1.4 l=0.6
X672 VSS bias_a nmos_single_5__A_0.x2_tail VSS sky130_fd_pr__nfet_01v8 ad=0.406 pd=3.38 as=0.406 ps=3.38 w=1.4 l=0.6
X673 VDD nmos_diode__A_0.bias_b pmos_dummy_17__A_0.x2_foldp VDD sky130_fd_pr__pfet_01v8_lvt ad=0.406 pd=3.38 as=0.406 ps=3.38 w=1.4 l=0.6
X674 nmos_dummy_19__A_0.x2_m3d nmos_single__A_0.bias_d on VSS sky130_fd_pr__nfet_01v8 ad=0.406 pd=3.38 as=0.406 ps=3.38 w=1.4 l=0.6
X675 VSS bias_a nmos_single_5__A_0.x2_tail VSS sky130_fd_pr__nfet_01v8 ad=0.406 pd=3.38 as=0.406 ps=3.38 w=1.4 l=0.6
X676 VDD VDD VDD VDD sky130_fd_pr__pfet_01v8 ad=0.406 pd=3.38 as=0 ps=0 w=1.4 l=0.6
X677 VSS bias_a nmos_dummy_18__A_0.x2_m4d VSS sky130_fd_pr__nfet_01v8 ad=0.406 pd=3.38 as=0.406 ps=3.38 w=1.4 l=0.6
X678 nmos_single__A_0.bias_d nmos_single__A_0.bias_d nmos_single__A_0.bias_d VSS sky130_fd_pr__nfet_01v8 ad=0.406 pd=3.38 as=0 ps=0 w=1.4 l=0.6
X679 VSS cmc nmos_single_5__A_0.x2_tail VSS sky130_fd_pr__nfet_01v8 ad=0.406 pd=3.38 as=0.406 ps=3.38 w=1.4 l=0.6
X680 VSS bias_a nmos_dummy_9__A_0.x1_m5d VSS sky130_fd_pr__nfet_01v8 ad=0.406 pd=3.38 as=0.406 ps=3.38 w=1.4 l=0.6
X681 VSS bias_a nmos_single_5__A_0.x2_tail VSS sky130_fd_pr__nfet_01v8 ad=0.406 pd=3.38 as=0.406 ps=3.38 w=1.4 l=0.6
X682 nmos_dummy_19__A_0.x2_m3d nmos_single__A_0.bias_d on VSS sky130_fd_pr__nfet_01v8 ad=0.406 pd=3.38 as=0.406 ps=3.38 w=1.4 l=0.6
X683 VDD nmos_diode__A_0.bias_b pmos_dummy_17__A_0.x2_foldp VDD sky130_fd_pr__pfet_01v8_lvt ad=0.406 pd=3.38 as=0.406 ps=3.38 w=1.4 l=0.6
X684 VSS VSS on VSS sky130_fd_pr__nfet_01v8 ad=0.406 pd=3.38 as=0.406 ps=3.38 w=1.4 l=0.6
X685 VSS bias_a nmos_dummy_18__A_0.x2_m4d VSS sky130_fd_pr__nfet_01v8 ad=0.406 pd=3.38 as=0.406 ps=3.38 w=1.4 l=0.6
X686 pmos_dummy_16__A_0.x2_foldn nmos_diode__A_0.bias_c op VDD sky130_fd_pr__pfet_01v8 ad=0.406 pd=3.38 as=0.406 ps=3.38 w=1.4 l=0.6
X687 VDD VDD VDD VDD sky130_fd_pr__pfet_01v8 ad=0.406 pd=3.38 as=0 ps=0 w=1.4 l=0.6
X688 VSS VSS VSS VSS sky130_fd_pr__nfet_01v8 ad=0.406 pd=3.38 as=0 ps=0 w=1.4 l=0.6
X689 nmos_diode__A_0.bias_c IBIAS VSS VSS sky130_fd_pr__nfet_01v8 ad=0.406 pd=3.38 as=0.406 ps=3.38 w=1.4 l=0.6
X690 VSS cmc nmos_single_5__A_0.x2_tail VSS sky130_fd_pr__nfet_01v8 ad=0.406 pd=3.38 as=0.406 ps=3.38 w=1.4 l=0.6
X691 on cmc sky130_fd_pr__cap_mim_m3_1 l=4.8 w=4.8
X692 VSS bias_a nmos_single_5__A_0.x2_tail VSS sky130_fd_pr__nfet_01v8 ad=0.406 pd=3.38 as=0.406 ps=3.38 w=1.4 l=0.6
X693 nmos_single_5__A_0.x2_tail nmos_single_5__A_0.x2_tail nmos_single_5__A_0.x2_tail VSS sky130_fd_pr__nfet_01v8 ad=0.406 pd=3.38 as=0 ps=0 w=1.4 l=0.6
X694 pmos_dummy_17__A_0.x2_foldp nmos_diode__A_0.bias_c on VDD sky130_fd_pr__pfet_01v8 ad=0.406 pd=3.38 as=0.406 ps=3.38 w=1.4 l=0.6
X695 VSS bias_a nmos_single_5__A_0.x2_tail VSS sky130_fd_pr__nfet_01v8 ad=0.406 pd=3.38 as=0.406 ps=3.38 w=1.4 l=0.6
X696 VSS bias_a nmos_dummy_19__A_0.x2_m3d VSS sky130_fd_pr__nfet_01v8 ad=0.406 pd=3.38 as=0.406 ps=3.38 w=1.4 l=0.6
X697 pmos_dummy_7__A_0.x1_m25d nmos_diode__A_0.bias_b VDD VDD sky130_fd_pr__pfet_01v8_lvt ad=0.406 pd=3.38 as=0.406 ps=3.38 w=1.4 l=0.6
X698 nmos_dummy_18__A_0.x2_m4d nmos_single__A_0.bias_d op VSS sky130_fd_pr__nfet_01v8 ad=0.406 pd=3.38 as=0.406 ps=3.38 w=1.4 l=0.6
X699 VSS VSS nmos_dummy_18__A_0.x2_m4d VSS sky130_fd_pr__nfet_01v8 ad=0.406 pd=3.38 as=0.406 ps=3.38 w=1.4 l=0.6
X700 nmos_diode__A_0.bias_c nmos_diode__A_0.bias_b nmos_diode__A_0.bias_b VSS sky130_fd_pr__nfet_01v8_lvt ad=0.406 pd=3.38 as=0.406 ps=3.38 w=1.4 l=0.6
X701 nmos_diode__A_0.bias_c nmos_diode__A_0.bias_b nmos_diode__A_0.bias_b VSS sky130_fd_pr__nfet_01v8_lvt ad=0.406 pd=3.38 as=0.406 ps=3.38 w=1.4 l=0.6
X702 nmos_single__A_0.bias_d nmos_single__A_0.x1_m2d nmos_single__A_0.x1_m2d VSS sky130_fd_pr__nfet_01v8 ad=0.406 pd=3.38 as=0.406 ps=3.38 w=1.4 l=0.6
X703 nmos_single__A_0.bias_d nmos_single__A_0.x1_m2d nmos_single__A_0.x1_m2d VSS sky130_fd_pr__nfet_01v8 ad=0.406 pd=3.38 as=0.406 ps=3.38 w=1.4 l=0.6
X704 VSS bias_a nmos_single_5__A_0.x2_tail VSS sky130_fd_pr__nfet_01v8 ad=0.406 pd=3.38 as=0.406 ps=3.38 w=1.4 l=0.6
X705 IBIAS IBIAS IBIAS VSS sky130_fd_pr__nfet_01v8 ad=0.406 pd=3.38 as=0 ps=0 w=1.4 l=0.6
X706 VSS bias_a nmos_single_5__A_0.x2_tail VSS sky130_fd_pr__nfet_01v8 ad=0.406 pd=3.38 as=0.406 ps=3.38 w=1.4 l=0.6
X707 on nmos_single__A_0.bias_d nmos_dummy_19__A_0.x2_m3d VSS sky130_fd_pr__nfet_01v8 ad=0.406 pd=3.38 as=0.406 ps=3.38 w=1.4 l=0.6
X708 VDD nmos_diode__A_0.bias_b pmos_dummy_6__A_0.x1_m21d VDD sky130_fd_pr__pfet_01v8_lvt ad=0.406 pd=3.38 as=0.406 ps=3.38 w=1.4 l=0.6
X709 nmos_single__A_0.bias_d nmos_single__A_0.x1_m2d nmos_single__A_0.x1_m2d VSS sky130_fd_pr__nfet_01v8 ad=0.406 pd=3.38 as=0.406 ps=3.38 w=1.4 l=0.6
X710 nmos_single__A_0.bias_d nmos_single__A_0.x1_m2d nmos_single__A_0.x1_m2d VSS sky130_fd_pr__nfet_01v8 ad=0.406 pd=3.38 as=0.406 ps=3.38 w=1.4 l=0.6
X711 VSS IBIAS nmos_diode__A_0.bias_c VSS sky130_fd_pr__nfet_01v8 ad=0.406 pd=3.38 as=0.406 ps=3.38 w=1.4 l=0.6
X712 nmos_dummy_9__A_0.x1_m5d nmos_dummy_9__A_0.x1_m5d nmos_dummy_9__A_0.x1_m5d VSS sky130_fd_pr__nfet_01v8 ad=0.406 pd=3.38 as=0 ps=0 w=1.4 l=0.6
X713 VDD nmos_diode__A_0.bias_b pmos_dummy_17__A_0.x2_foldp VDD sky130_fd_pr__pfet_01v8_lvt ad=0.406 pd=3.38 as=0.406 ps=3.38 w=1.4 l=0.6
X714 VDD nmos_diode__A_0.bias_b pmos_dummy_16__A_0.x2_foldn VDD sky130_fd_pr__pfet_01v8_lvt ad=0.406 pd=3.38 as=0.406 ps=3.38 w=1.4 l=0.6
X715 VDD VDD VDD VDD sky130_fd_pr__pfet_01v8_lvt ad=0.406 pd=3.38 as=0 ps=0 w=1.4 l=0.6
X716 VSS bias_a nmos_single_5__A_0.x2_tail VSS sky130_fd_pr__nfet_01v8 ad=0.406 pd=3.38 as=0.406 ps=3.38 w=1.4 l=0.6
X717 VSS bias_a nmos_single_5__A_0.x2_tail VSS sky130_fd_pr__nfet_01v8 ad=0.406 pd=3.38 as=0.406 ps=3.38 w=1.4 l=0.6
X718 nmos_single__A_0.bias_d nmos_single__A_0.x1_m2d nmos_single__A_0.x1_m2d VSS sky130_fd_pr__nfet_01v8 ad=0.406 pd=3.38 as=0.406 ps=3.38 w=1.4 l=0.6
X719 nmos_dummy_19__A_0.x2_m3d nmos_single__A_0.bias_d on VSS sky130_fd_pr__nfet_01v8 ad=0.406 pd=3.38 as=0.406 ps=3.38 w=1.4 l=0.6
X720 VSS bias_a nmos_dummy_18__A_0.x2_m4d VSS sky130_fd_pr__nfet_01v8 ad=0.406 pd=3.38 as=0.406 ps=3.38 w=1.4 l=0.6
X721 pmos_dummy_17__A_0.x2_foldp nmos_diode__A_0.bias_c on VDD sky130_fd_pr__pfet_01v8 ad=0.406 pd=3.38 as=0.406 ps=3.38 w=1.4 l=0.6
X722 nmos_diode__A_0.bias_c nmos_diode__A_0.bias_b nmos_diode__A_0.bias_b VSS sky130_fd_pr__nfet_01v8_lvt ad=0.406 pd=3.38 as=0.406 ps=3.38 w=1.4 l=0.6
X723 nmos_matched_cascode_pair_3__AB_0.x1_net3 cm VSS VSS sky130_fd_pr__nfet_01v8 ad=0.406 pd=3.38 as=0.406 ps=3.38 w=1.4 l=0.6
X724 VSS cmc nmos_single_5__A_0.x2_tail VSS sky130_fd_pr__nfet_01v8 ad=0.406 pd=3.38 as=0.406 ps=3.38 w=1.4 l=0.6
X725 nmos_diode__A_0.bias_c IBIAS VSS VSS sky130_fd_pr__nfet_01v8 ad=0.406 pd=3.38 as=0.406 ps=3.38 w=1.4 l=0.6
X726 bias_a nmos_single__A_0.x1_m2d nmos_single__A_0.bias_d VSS sky130_fd_pr__nfet_01v8 ad=0.406 pd=3.38 as=0.406 ps=3.38 w=1.4 l=0.6
X727 nmos_diode__A_0.bias_c nmos_diode__A_0.bias_b nmos_diode__A_0.bias_b VSS sky130_fd_pr__nfet_01v8_lvt ad=0.406 pd=3.38 as=0.406 ps=3.38 w=1.4 l=0.6
X728 nmos_diode__A_0.bias_c nmos_diode__A_0.bias_b nmos_diode__A_0.bias_b VSS sky130_fd_pr__nfet_01v8_lvt ad=0.406 pd=3.38 as=0.406 ps=3.38 w=1.4 l=0.6
X729 VSS cmc nmos_single_5__A_0.x2_tail VSS sky130_fd_pr__nfet_01v8 ad=0.406 pd=3.38 as=0.406 ps=3.38 w=1.4 l=0.6
X730 VDD nmos_diode__A_0.bias_b pmos_dummy_16__A_0.x2_foldn VDD sky130_fd_pr__pfet_01v8_lvt ad=0.406 pd=3.38 as=0.406 ps=3.38 w=1.4 l=0.6
X731 VDD nmos_diode__A_0.bias_b pmos_dummy_17__A_0.x2_foldp VDD sky130_fd_pr__pfet_01v8_lvt ad=0.406 pd=3.38 as=0.406 ps=3.38 w=1.4 l=0.6
X732 VSS cmc nmos_single_5__A_0.x2_tail VSS sky130_fd_pr__nfet_01v8 ad=0.406 pd=3.38 as=0.406 ps=3.38 w=1.4 l=0.6
X733 VSS cmc nmos_single_5__A_0.x2_tail VSS sky130_fd_pr__nfet_01v8 ad=0.406 pd=3.38 as=0.406 ps=3.38 w=1.4 l=0.6
X734 VDD nmos_diode__A_0.bias_b pmos_single__A_0.x1_m31d VDD sky130_fd_pr__pfet_01v8_lvt ad=0.406 pd=3.38 as=0.406 ps=3.38 w=1.4 l=0.6
X735 VSS IBIAS nmos_diode__A_0.bias_c VSS sky130_fd_pr__nfet_01v8 ad=0.406 pd=3.38 as=0.406 ps=3.38 w=1.4 l=0.6
X736 VSS IBIAS IBIAS VSS sky130_fd_pr__nfet_01v8 ad=0.406 pd=3.38 as=0.406 ps=3.38 w=1.4 l=0.6
X737 pmos_dummy_16__A_0.x2_foldn nmos_diode__A_0.bias_c op VDD sky130_fd_pr__pfet_01v8 ad=0.406 pd=3.38 as=0.406 ps=3.38 w=1.4 l=0.6
X738 VDD VDD cm VDD sky130_fd_pr__pfet_01v8 ad=0.406 pd=3.38 as=0.406 ps=3.38 w=1.4 l=0.6
X739 nmos_single__A_0.bias_d nmos_single__A_0.x1_m2d nmos_single__A_0.x1_m2d VSS sky130_fd_pr__nfet_01v8 ad=0.406 pd=3.38 as=0.406 ps=3.38 w=1.4 l=0.6
X740 on nmos_single__A_0.bias_d nmos_dummy_19__A_0.x2_m3d VSS sky130_fd_pr__nfet_01v8 ad=0.406 pd=3.38 as=0.406 ps=3.38 w=1.4 l=0.6
X741 nmos_diode__A_0.bias_c nmos_diode__A_0.bias_b nmos_diode__A_0.bias_b VSS sky130_fd_pr__nfet_01v8_lvt ad=0.406 pd=3.38 as=0.406 ps=3.38 w=1.4 l=0.6
X742 pmos_dummy_7__A_0.x1_m25d nmos_diode__A_0.bias_c nmos_single__A_0.x1_m2d VDD sky130_fd_pr__pfet_01v8 ad=0.406 pd=3.38 as=0.406 ps=3.38 w=1.4 l=0.6
X743 VSS bias_a nmos_single_5__A_0.x2_tail VSS sky130_fd_pr__nfet_01v8 ad=0.406 pd=3.38 as=0.406 ps=3.38 w=1.4 l=0.6
X744 nmos_diode__A_0.bias_c nmos_diode__A_0.bias_b nmos_diode__A_0.bias_b VSS sky130_fd_pr__nfet_01v8_lvt ad=0.406 pd=3.38 as=0.406 ps=3.38 w=1.4 l=0.6
X745 VSS cmc nmos_single_5__A_0.x2_tail VSS sky130_fd_pr__nfet_01v8 ad=0.406 pd=3.38 as=0.406 ps=3.38 w=1.4 l=0.6
X746 VSS bias_a nmos_dummy_9__A_0.x1_m5d VSS sky130_fd_pr__nfet_01v8 ad=0.406 pd=3.38 as=0.406 ps=3.38 w=1.4 l=0.6
X747 VSS VSS VSS VSS sky130_fd_pr__nfet_01v8 ad=0.406 pd=3.38 as=0 ps=0 w=1.4 l=0.6
X748 VSS VSS VSS VSS sky130_fd_pr__nfet_01v8 ad=0.406 pd=3.38 as=0 ps=0 w=1.4 l=0.6
X749 VDD nmos_diode__A_0.bias_b pmos_dummy_16__A_0.x2_foldn VDD sky130_fd_pr__pfet_01v8_lvt ad=0.406 pd=3.38 as=0.406 ps=3.38 w=1.4 l=0.6
X750 pmos_single__A_0.x1_m31d nmos_diode__A_0.bias_c cm VDD sky130_fd_pr__pfet_01v8 ad=0.406 pd=3.38 as=0.406 ps=3.38 w=1.4 l=0.6
X751 VDD VDD op VDD sky130_fd_pr__pfet_01v8 ad=0.406 pd=3.38 as=0.406 ps=3.38 w=1.4 l=0.6
X752 VDD nmos_diode__A_0.bias_b pmos_dummy_16__A_0.x2_foldn VDD sky130_fd_pr__pfet_01v8_lvt ad=0.406 pd=3.38 as=0.406 ps=3.38 w=1.4 l=0.6
X753 nmos_single_5__A_0.x2_tail ip pmos_dummy_17__A_0.x2_foldp VSS sky130_fd_pr__nfet_01v8_lvt ad=0.348 pd=2.98 as=0.348 ps=2.98 w=1.2 l=0.2
X754 VSS IBIAS nmos_diode__A_0.bias_c VSS sky130_fd_pr__nfet_01v8 ad=0.406 pd=3.38 as=0.406 ps=3.38 w=1.4 l=0.6
X755 nmos_dummy_9__A_0.x1_m5d nmos_single__A_0.bias_d bias_a VSS sky130_fd_pr__nfet_01v8 ad=0.406 pd=3.38 as=0.406 ps=3.38 w=1.4 l=0.6
X756 nmos_single__A_0.x1_m2d nmos_single__A_0.x1_m2d nmos_single__A_0.x1_m2d VSS sky130_fd_pr__nfet_01v8 ad=0.406 pd=3.38 as=0 ps=0 w=1.4 l=0.6
X757 pmos_dummy_17__A_0.x2_foldp nmos_diode__A_0.bias_c on VDD sky130_fd_pr__pfet_01v8 ad=0.406 pd=3.38 as=0.406 ps=3.38 w=1.4 l=0.6
X758 pmos_single__A_0.x1_m31d nmos_diode__A_0.bias_c cm VDD sky130_fd_pr__pfet_01v8 ad=0.406 pd=3.38 as=0.406 ps=3.38 w=1.4 l=0.6
X759 VSS bias_a nmos_dummy_18__A_0.x2_m4d VSS sky130_fd_pr__nfet_01v8 ad=0.406 pd=3.38 as=0.406 ps=3.38 w=1.4 l=0.6
X760 nmos_diode__A_0.bias_c nmos_diode__A_0.bias_b nmos_diode__A_0.bias_b VSS sky130_fd_pr__nfet_01v8_lvt ad=0.406 pd=3.38 as=0.406 ps=3.38 w=1.4 l=0.6
X761 VDD nmos_diode__A_0.bias_b pmos_dummy_17__A_0.x2_foldp VDD sky130_fd_pr__pfet_01v8_lvt ad=0.406 pd=3.38 as=0.406 ps=3.38 w=1.4 l=0.6
X762 VSS VSS VSS VSS sky130_fd_pr__nfet_01v8 ad=0.406 pd=3.38 as=0 ps=0 w=1.4 l=0.6
X763 VSS VSS VSS VSS sky130_fd_pr__nfet_01v8 ad=0.406 pd=3.38 as=0 ps=0 w=1.4 l=0.6
X764 IBIAS IBIAS VSS VSS sky130_fd_pr__nfet_01v8 ad=0.406 pd=3.38 as=0.406 ps=3.38 w=1.4 l=0.6
X765 nmos_dummy_9__A_0.x1_m5d nmos_single__A_0.bias_d bias_a VSS sky130_fd_pr__nfet_01v8 ad=0.406 pd=3.38 as=0.406 ps=3.38 w=1.4 l=0.6
X766 VSS bias_a nmos_dummy_18__A_0.x2_m4d VSS sky130_fd_pr__nfet_01v8 ad=0.406 pd=3.38 as=0.406 ps=3.38 w=1.4 l=0.6
X767 nmos_matched_cascode_pair_8__AB_0.x1_net10 cm nmos_matched_cascode_pair_9__AB_0.x1_net11 VSS sky130_fd_pr__nfet_01v8 ad=0.406 pd=3.38 as=0.406 ps=3.38 w=1.4 l=0.6
X768 VSS VSS VSS VSS sky130_fd_pr__nfet_01v8 ad=0.406 pd=3.38 as=0 ps=0 w=1.4 l=0.6
X769 VSS bias_a nmos_single_5__A_0.x2_tail VSS sky130_fd_pr__nfet_01v8 ad=0.406 pd=3.38 as=0.406 ps=3.38 w=1.4 l=0.6
X770 nmos_diode__A_0.bias_c nmos_diode__A_0.bias_c nmos_diode__A_0.bias_c VSS sky130_fd_pr__nfet_01v8_lvt ad=0.406 pd=3.38 as=0 ps=0 w=1.4 l=0.6
X771 VDD nmos_diode__A_0.bias_b pmos_dummy_17__A_0.x2_foldp VDD sky130_fd_pr__pfet_01v8_lvt ad=0.406 pd=3.38 as=0.406 ps=3.38 w=1.4 l=0.6
X772 pmos_dummy_16__A_0.x2_foldn nmos_diode__A_0.bias_c op VDD sky130_fd_pr__pfet_01v8 ad=0.406 pd=3.38 as=0.406 ps=3.38 w=1.4 l=0.6
X773 VSS cmc nmos_single_5__A_0.x2_tail VSS sky130_fd_pr__nfet_01v8 ad=0.406 pd=3.38 as=0.406 ps=3.38 w=1.4 l=0.6
X774 VSS bias_a nmos_dummy_18__A_0.x2_m4d VSS sky130_fd_pr__nfet_01v8 ad=0.406 pd=3.38 as=0.406 ps=3.38 w=1.4 l=0.6
X775 VSS cmc nmos_single_5__A_0.x2_tail VSS sky130_fd_pr__nfet_01v8 ad=0.406 pd=3.38 as=0.406 ps=3.38 w=1.4 l=0.6
X776 VDD VDD on VDD sky130_fd_pr__pfet_01v8 ad=0.406 pd=3.38 as=0.406 ps=3.38 w=1.4 l=0.6
X777 nmos_single_5__A_0.x2_tail in pmos_dummy_16__A_0.x2_foldn VSS sky130_fd_pr__nfet_01v8_lvt ad=0.348 pd=2.98 as=0.348 ps=2.98 w=1.2 l=0.2
X778 pmos_dummy_6__A_0.x1_m21d pmos_dummy_6__A_0.x1_m21d pmos_dummy_6__A_0.x1_m21d VDD sky130_fd_pr__pfet_01v8_lvt ad=0.406 pd=3.38 as=0 ps=0 w=1.4 l=0.6
X779 VSS VSS nmos_dummy_19__A_0.x2_m3d VSS sky130_fd_pr__nfet_01v8 ad=0.406 pd=3.38 as=0.406 ps=3.38 w=1.4 l=0.6
X780 on nmos_single__A_0.bias_d nmos_dummy_19__A_0.x2_m3d VSS sky130_fd_pr__nfet_01v8 ad=0.406 pd=3.38 as=0.406 ps=3.38 w=1.4 l=0.6
X781 nmos_diode__A_0.bias_c nmos_diode__A_0.bias_b nmos_diode__A_0.bias_b VSS sky130_fd_pr__nfet_01v8_lvt ad=0.406 pd=3.38 as=0.406 ps=3.38 w=1.4 l=0.6
X782 nmos_single__A_0.bias_d nmos_single__A_0.x1_m2d nmos_single__A_0.x1_m2d VSS sky130_fd_pr__nfet_01v8 ad=0.406 pd=3.38 as=0.406 ps=3.38 w=1.4 l=0.6
X783 VSS cmc nmos_single_5__A_0.x2_tail VSS sky130_fd_pr__nfet_01v8 ad=0.406 pd=3.38 as=0.406 ps=3.38 w=1.4 l=0.6
X784 nmos_single__A_0.bias_d nmos_single__A_0.x1_m2d nmos_single__A_0.x1_m2d VSS sky130_fd_pr__nfet_01v8 ad=0.406 pd=3.38 as=0.406 ps=3.38 w=1.4 l=0.6
X785 nmos_single__A_0.bias_d nmos_single__A_0.x1_m2d nmos_single__A_0.x1_m2d VSS sky130_fd_pr__nfet_01v8 ad=0.406 pd=3.38 as=0.406 ps=3.38 w=1.4 l=0.6
X786 nmos_dummy_18__A_0.x2_m4d nmos_single__A_0.bias_d op VSS sky130_fd_pr__nfet_01v8 ad=0.406 pd=3.38 as=0.406 ps=3.38 w=1.4 l=0.6
X787 VSS bias_a nmos_single_5__A_0.x2_tail VSS sky130_fd_pr__nfet_01v8 ad=0.406 pd=3.38 as=0.406 ps=3.38 w=1.4 l=0.6
X788 VSS bias_a nmos_single_5__A_0.x2_tail VSS sky130_fd_pr__nfet_01v8 ad=0.406 pd=3.38 as=0.406 ps=3.38 w=1.4 l=0.6
X789 nmos_diode__A_0.bias_c nmos_diode__A_0.bias_c nmos_diode__A_0.bias_c VSS sky130_fd_pr__nfet_01v8_lvt ad=0.406 pd=3.38 as=0 ps=0 w=1.4 l=0.6
X790 VDD nmos_diode__A_0.bias_b pmos_dummy_16__A_0.x2_foldn VDD sky130_fd_pr__pfet_01v8_lvt ad=0.406 pd=3.38 as=0.406 ps=3.38 w=1.4 l=0.6
X791 pmos_dummy_16__A_0.x2_foldn nmos_diode__A_0.bias_c op VDD sky130_fd_pr__pfet_01v8 ad=0.406 pd=3.38 as=0.406 ps=3.38 w=1.4 l=0.6
X792 VSS cmc nmos_single_5__A_0.x2_tail VSS sky130_fd_pr__nfet_01v8 ad=0.406 pd=3.38 as=0.406 ps=3.38 w=1.4 l=0.6
X793 nmos_single__A_0.bias_d nmos_single__A_0.x1_m2d nmos_single__A_0.x1_m2d VSS sky130_fd_pr__nfet_01v8 ad=0.406 pd=3.38 as=0.406 ps=3.38 w=1.4 l=0.6
X794 nmos_single__A_0.bias_d nmos_single__A_0.x1_m2d nmos_single__A_0.x1_m2d VSS sky130_fd_pr__nfet_01v8 ad=0.406 pd=3.38 as=0.406 ps=3.38 w=1.4 l=0.6
X795 nmos_dummy_18__A_0.x2_m4d nmos_single__A_0.bias_d op VSS sky130_fd_pr__nfet_01v8 ad=0.406 pd=3.38 as=0.406 ps=3.38 w=1.4 l=0.6
X796 VSS bias_a nmos_single_5__A_0.x2_tail VSS sky130_fd_pr__nfet_01v8 ad=0.406 pd=3.38 as=0.406 ps=3.38 w=1.4 l=0.6
X797 pmos_dummy_7__A_0.x1_m25d pmos_dummy_7__A_0.x1_m25d pmos_dummy_7__A_0.x1_m25d VDD sky130_fd_pr__pfet_01v8_lvt ad=0.406 pd=3.38 as=0 ps=0 w=1.4 l=0.6
X798 VDD nmos_diode__A_0.bias_b pmos_dummy_17__A_0.x2_foldp VDD sky130_fd_pr__pfet_01v8_lvt ad=0.406 pd=3.38 as=0.406 ps=3.38 w=1.4 l=0.6
X799 VSS bias_a nmos_dummy_19__A_0.x2_m3d VSS sky130_fd_pr__nfet_01v8 ad=0.406 pd=3.38 as=0.406 ps=3.38 w=1.4 l=0.6
X800 nmos_diode__A_0.bias_c nmos_diode__A_0.bias_b nmos_diode__A_0.bias_b VSS sky130_fd_pr__nfet_01v8_lvt ad=0.406 pd=3.38 as=0.406 ps=3.38 w=1.4 l=0.6
X801 bias_a bias_a bias_a VSS sky130_fd_pr__nfet_01v8 ad=0.406 pd=3.38 as=0 ps=0 w=1.4 l=0.6
X802 VDD nmos_diode__A_0.bias_b pmos_dummy_17__A_0.x2_foldp VDD sky130_fd_pr__pfet_01v8_lvt ad=0.406 pd=3.38 as=0.406 ps=3.38 w=1.4 l=0.6
X803 VSS bias_a nmos_single_5__A_0.x2_tail VSS sky130_fd_pr__nfet_01v8 ad=0.406 pd=3.38 as=0.406 ps=3.38 w=1.4 l=0.6
X804 VDD nmos_diode__A_0.bias_b pmos_dummy_7__A_0.x1_m25d VDD sky130_fd_pr__pfet_01v8_lvt ad=0.406 pd=3.38 as=0.406 ps=3.38 w=1.4 l=0.6
X805 VSS bias_a nmos_single_5__A_0.x2_tail VSS sky130_fd_pr__nfet_01v8 ad=0.406 pd=3.38 as=0.406 ps=3.38 w=1.4 l=0.6
X806 VSS bias_a nmos_dummy_18__A_0.x2_m4d VSS sky130_fd_pr__nfet_01v8 ad=0.406 pd=3.38 as=0.406 ps=3.38 w=1.4 l=0.6
X807 VSS VSS VSS VSS sky130_fd_pr__nfet_01v8 ad=0.406 pd=3.38 as=0 ps=0 w=1.4 l=0.6
X808 VSS bias_a nmos_dummy_19__A_0.x2_m3d VSS sky130_fd_pr__nfet_01v8 ad=0.406 pd=3.38 as=0.406 ps=3.38 w=1.4 l=0.6
X809 VDD nmos_diode__A_0.bias_b pmos_single__A_0.x1_m31d VDD sky130_fd_pr__pfet_01v8_lvt ad=0.406 pd=3.38 as=0.406 ps=3.38 w=1.4 l=0.6
X810 VDD VDD VDD VDD sky130_fd_pr__pfet_01v8_lvt ad=0.406 pd=3.38 as=0 ps=0 w=1.4 l=0.6
X811 nmos_diode__A_0.bias_c nmos_diode__A_0.bias_b nmos_diode__A_0.bias_b VSS sky130_fd_pr__nfet_01v8_lvt ad=0.406 pd=3.38 as=0.406 ps=3.38 w=1.4 l=0.6
X812 VDD VDD VDD VDD sky130_fd_pr__pfet_01v8_lvt ad=0.406 pd=3.38 as=0 ps=0 w=1.4 l=0.6
X813 VSS cmc nmos_single_5__A_0.x2_tail VSS sky130_fd_pr__nfet_01v8 ad=0.406 pd=3.38 as=0.406 ps=3.38 w=1.4 l=0.6
X814 VSS bias_a nmos_single_5__A_0.x2_tail VSS sky130_fd_pr__nfet_01v8 ad=0.406 pd=3.38 as=0.406 ps=3.38 w=1.4 l=0.6
X815 VDD nmos_diode__A_0.bias_b pmos_dummy_17__A_0.x2_foldp VDD sky130_fd_pr__pfet_01v8_lvt ad=0.406 pd=3.38 as=0.406 ps=3.38 w=1.4 l=0.6
X816 VDD VDD VDD VDD sky130_fd_pr__pfet_01v8_lvt ad=0.406 pd=3.38 as=0 ps=0 w=1.4 l=0.6
X817 VSS bias_a nmos_single_5__A_0.x2_tail VSS sky130_fd_pr__nfet_01v8 ad=0.406 pd=3.38 as=0.406 ps=3.38 w=1.4 l=0.6
X818 op nmos_single__A_0.bias_d nmos_dummy_18__A_0.x2_m4d VSS sky130_fd_pr__nfet_01v8 ad=0.406 pd=3.38 as=0.406 ps=3.38 w=1.4 l=0.6
X819 VSS VSS VSS VSS sky130_fd_pr__nfet_01v8 ad=0.406 pd=3.38 as=0 ps=0 w=1.4 l=0.6
X820 VSS bias_a nmos_dummy_9__A_0.x1_m5d VSS sky130_fd_pr__nfet_01v8 ad=0.406 pd=3.38 as=0.406 ps=3.38 w=1.4 l=0.6
X821 pmos_single__A_0.x1_m31d pmos_single__A_0.x1_m31d pmos_single__A_0.x1_m31d VDD sky130_fd_pr__pfet_01v8_lvt ad=0.406 pd=3.38 as=0 ps=0 w=1.4 l=0.6
X822 nmos_dummy_18__A_0.x2_m4d nmos_single__A_0.bias_d op VSS sky130_fd_pr__nfet_01v8 ad=0.406 pd=3.38 as=0.406 ps=3.38 w=1.4 l=0.6
X823 VSS bias_a nmos_single_5__A_0.x2_tail VSS sky130_fd_pr__nfet_01v8 ad=0.406 pd=3.38 as=0.406 ps=3.38 w=1.4 l=0.6
X824 VSS bias_a nmos_single_5__A_0.x2_tail VSS sky130_fd_pr__nfet_01v8 ad=0.406 pd=3.38 as=0.406 ps=3.38 w=1.4 l=0.6
X825 VSS bias_a nmos_single_5__A_0.x2_tail VSS sky130_fd_pr__nfet_01v8 ad=0.406 pd=3.38 as=0.406 ps=3.38 w=1.4 l=0.6
X826 VSS bias_a nmos_single_5__A_0.x2_tail VSS sky130_fd_pr__nfet_01v8 ad=0.406 pd=3.38 as=0.406 ps=3.38 w=1.4 l=0.6
X827 nmos_dummy_19__A_0.x2_m3d nmos_single__A_0.bias_d on VSS sky130_fd_pr__nfet_01v8 ad=0.406 pd=3.38 as=0.406 ps=3.38 w=1.4 l=0.6
X828 nmos_diode__A_0.bias_c nmos_diode__A_0.bias_b nmos_diode__A_0.bias_b VSS sky130_fd_pr__nfet_01v8_lvt ad=0.406 pd=3.38 as=0.406 ps=3.38 w=1.4 l=0.6
X829 nmos_diode__A_0.bias_c nmos_diode__A_0.bias_b nmos_diode__A_0.bias_b VSS sky130_fd_pr__nfet_01v8_lvt ad=0.406 pd=3.38 as=0.406 ps=3.38 w=1.4 l=0.6
X830 nmos_single__A_0.bias_d nmos_single__A_0.x1_m2d nmos_single__A_0.x1_m2d VSS sky130_fd_pr__nfet_01v8 ad=0.406 pd=3.38 as=0.406 ps=3.38 w=1.4 l=0.6
X831 VSS cmc nmos_single_5__A_0.x2_tail VSS sky130_fd_pr__nfet_01v8 ad=0.406 pd=3.38 as=0.406 ps=3.38 w=1.4 l=0.6
X832 VSS bias_a nmos_dummy_18__A_0.x2_m4d VSS sky130_fd_pr__nfet_01v8 ad=0.406 pd=3.38 as=0.406 ps=3.38 w=1.4 l=0.6
X833 VDD nmos_diode__A_0.bias_b pmos_dummy_16__A_0.x2_foldn VDD sky130_fd_pr__pfet_01v8_lvt ad=0.406 pd=3.38 as=0.406 ps=3.38 w=1.4 l=0.6
X834 VSS VSS op VSS sky130_fd_pr__nfet_01v8 ad=0.406 pd=3.38 as=0.406 ps=3.38 w=1.4 l=0.6
X835 VSS cmc nmos_single_5__A_0.x2_tail VSS sky130_fd_pr__nfet_01v8 ad=0.406 pd=3.38 as=0.406 ps=3.38 w=1.4 l=0.6
X836 nmos_diode__A_0.bias_c nmos_diode__A_0.bias_b nmos_diode__A_0.bias_b VSS sky130_fd_pr__nfet_01v8_lvt ad=0.406 pd=3.38 as=0.406 ps=3.38 w=1.4 l=0.6
X837 VSS bias_a nmos_single_5__A_0.x2_tail VSS sky130_fd_pr__nfet_01v8 ad=0.406 pd=3.38 as=0.406 ps=3.38 w=1.4 l=0.6
X838 VSS bias_a nmos_single_5__A_0.x2_tail VSS sky130_fd_pr__nfet_01v8 ad=0.406 pd=3.38 as=0.406 ps=3.38 w=1.4 l=0.6
X839 VSS cmc nmos_single_5__A_0.x2_tail VSS sky130_fd_pr__nfet_01v8 ad=0.406 pd=3.38 as=0.406 ps=3.38 w=1.4 l=0.6
X840 nmos_single__A_0.x1_m2d nmos_diode__A_0.bias_c pmos_dummy_7__A_0.x1_m25d VDD sky130_fd_pr__pfet_01v8 ad=0.406 pd=3.38 as=0.406 ps=3.38 w=1.4 l=0.6
X841 nmos_diode__A_0.bias_c IBIAS VSS VSS sky130_fd_pr__nfet_01v8 ad=0.406 pd=3.38 as=0.406 ps=3.38 w=1.4 l=0.6
X842 nmos_single__A_0.bias_d nmos_single__A_0.x1_m2d nmos_single__A_0.x1_m2d VSS sky130_fd_pr__nfet_01v8 ad=0.406 pd=3.38 as=0.406 ps=3.38 w=1.4 l=0.6
X843 VSS cmc nmos_single_5__A_0.x2_tail VSS sky130_fd_pr__nfet_01v8 ad=0.406 pd=3.38 as=0.406 ps=3.38 w=1.4 l=0.6
X844 VSS bias_a nmos_single_5__A_0.x2_tail VSS sky130_fd_pr__nfet_01v8 ad=0.406 pd=3.38 as=0.406 ps=3.38 w=1.4 l=0.6
X845 VSS bias_a nmos_single_5__A_0.x2_tail VSS sky130_fd_pr__nfet_01v8 ad=0.406 pd=3.38 as=0.406 ps=3.38 w=1.4 l=0.6
X846 nmos_single__A_0.bias_d nmos_single__A_0.x1_m2d nmos_single__A_0.x1_m2d VSS sky130_fd_pr__nfet_01v8 ad=0.406 pd=3.38 as=0.406 ps=3.38 w=1.4 l=0.6
X847 nmos_dummy_9__A_0.x1_m5d nmos_single__A_0.bias_d bias_a VSS sky130_fd_pr__nfet_01v8 ad=0.406 pd=3.38 as=0.406 ps=3.38 w=1.4 l=0.6
X848 VSS VSS VSS VSS sky130_fd_pr__nfet_01v8 ad=0.406 pd=3.38 as=0 ps=0 w=1.4 l=0.6
X849 nmos_single_5__A_0.x2_tail ip pmos_dummy_17__A_0.x2_foldp VSS sky130_fd_pr__nfet_01v8_lvt ad=0.348 pd=2.98 as=0.348 ps=2.98 w=1.2 l=0.2
X850 VDD nmos_diode__A_0.bias_b pmos_dummy_17__A_0.x2_foldp VDD sky130_fd_pr__pfet_01v8_lvt ad=0.406 pd=3.38 as=0.406 ps=3.38 w=1.4 l=0.6
X851 VSS cmc nmos_single_5__A_0.x2_tail VSS sky130_fd_pr__nfet_01v8 ad=0.406 pd=3.38 as=0.406 ps=3.38 w=1.4 l=0.6
X852 VSS cmc nmos_single_5__A_0.x2_tail VSS sky130_fd_pr__nfet_01v8 ad=0.406 pd=3.38 as=0.406 ps=3.38 w=1.4 l=0.6
X853 pmos_dummy_16__A_0.x2_foldn pmos_dummy_16__A_0.x2_foldn pmos_dummy_16__A_0.x2_foldn VSS sky130_fd_pr__nfet_01v8_lvt ad=0.348 pd=2.98 as=0 ps=0 w=1.2 l=0.2
X854 IBIAS IBIAS VSS VSS sky130_fd_pr__nfet_01v8 ad=0.406 pd=3.38 as=0.406 ps=3.38 w=1.4 l=0.6
X855 nmos_matched_cascode_pair_3__AB_0.x1_net3 cm nmos_matched_cascode_pair_3__AB_0.x1_net2 VSS sky130_fd_pr__nfet_01v8 ad=0.406 pd=3.38 as=0.406 ps=3.38 w=1.4 l=0.6
X856 nmos_dummy_18__A_0.x2_m4d nmos_single__A_0.bias_d op VSS sky130_fd_pr__nfet_01v8 ad=0.406 pd=3.38 as=0.406 ps=3.38 w=1.4 l=0.6
X857 VSS bias_a nmos_single_5__A_0.x2_tail VSS sky130_fd_pr__nfet_01v8 ad=0.406 pd=3.38 as=0.406 ps=3.38 w=1.4 l=0.6
X858 VSS bias_a nmos_single_5__A_0.x2_tail VSS sky130_fd_pr__nfet_01v8 ad=0.406 pd=3.38 as=0.406 ps=3.38 w=1.4 l=0.6
X859 VSS bias_a nmos_single_5__A_0.x2_tail VSS sky130_fd_pr__nfet_01v8 ad=0.406 pd=3.38 as=0.406 ps=3.38 w=1.4 l=0.6
X860 VSS VSS on VSS sky130_fd_pr__nfet_01v8 ad=0.406 pd=3.38 as=0.406 ps=3.38 w=1.4 l=0.6
X861 VDD VDD nmos_diode__A_0.bias_b VDD sky130_fd_pr__pfet_01v8 ad=0.406 pd=3.38 as=0.406 ps=3.38 w=1.4 l=0.6
X862 pmos_dummy_6__A_0.x1_m21d pmos_dummy_6__A_0.x1_m21d pmos_dummy_6__A_0.x1_m21d VDD sky130_fd_pr__pfet_01v8 ad=0.406 pd=3.38 as=0 ps=0 w=1.4 l=0.6
X863 VDD VDD VDD VDD sky130_fd_pr__pfet_01v8 ad=0.406 pd=3.38 as=0 ps=0 w=1.4 l=0.6
X864 nmos_dummy_9__A_0.x1_m5d nmos_single__A_0.bias_d bias_a VSS sky130_fd_pr__nfet_01v8 ad=0.406 pd=3.38 as=0.406 ps=3.38 w=1.4 l=0.6
X865 pmos_dummy_17__A_0.x2_foldp nmos_diode__A_0.bias_c on VDD sky130_fd_pr__pfet_01v8 ad=0.406 pd=3.38 as=0.406 ps=3.38 w=1.4 l=0.6
X866 VSS cmc nmos_single_5__A_0.x2_tail VSS sky130_fd_pr__nfet_01v8 ad=0.406 pd=3.38 as=0.406 ps=3.38 w=1.4 l=0.6
X867 VSS bias_a nmos_dummy_19__A_0.x2_m3d VSS sky130_fd_pr__nfet_01v8 ad=0.406 pd=3.38 as=0.406 ps=3.38 w=1.4 l=0.6
X868 VSS IBIAS IBIAS VSS sky130_fd_pr__nfet_01v8 ad=0.406 pd=3.38 as=0.406 ps=3.38 w=1.4 l=0.6
X869 VSS IBIAS nmos_diode__A_0.bias_c VSS sky130_fd_pr__nfet_01v8 ad=0.406 pd=3.38 as=0.406 ps=3.38 w=1.4 l=0.6
X870 nmos_single__A_0.bias_d nmos_single__A_0.x1_m2d nmos_single__A_0.x1_m2d VSS sky130_fd_pr__nfet_01v8 ad=0.406 pd=3.38 as=0.406 ps=3.38 w=1.4 l=0.6
X871 VSS IBIAS IBIAS VSS sky130_fd_pr__nfet_01v8 ad=0.406 pd=3.38 as=0.406 ps=3.38 w=1.4 l=0.6
X872 VDD nmos_diode__A_0.bias_b pmos_dummy_16__A_0.x2_foldn VDD sky130_fd_pr__pfet_01v8_lvt ad=0.406 pd=3.38 as=0.406 ps=3.38 w=1.4 l=0.6
X873 nmos_diode__A_0.bias_c nmos_diode__A_0.bias_b nmos_diode__A_0.bias_b VSS sky130_fd_pr__nfet_01v8_lvt ad=0.406 pd=3.38 as=0.406 ps=3.38 w=1.4 l=0.6
X874 VSS VSS nmos_dummy_18__A_0.x2_m4d VSS sky130_fd_pr__nfet_01v8 ad=0.406 pd=3.38 as=0.406 ps=3.38 w=1.4 l=0.6
.ends

.end
