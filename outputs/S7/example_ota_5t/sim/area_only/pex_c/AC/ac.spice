* example_ota_5t on diso_amp_AC
.lib $PDK_ROOT/sky130A/libs.tech/combined/sky130.lib.spice tt
.option rshunt=1e12
.param VDD_V=1.8 VCM_V=0.9 CL_F=1p
.temp 27

** sch_path: /foss/designs/PROJECTS/llm-analog-sizing/testbenches/diso_amp_AC.sch
**.subckt diso_amp_AC
x1 INP INN net1 VDD 0 OUT dut_amp
Vsup VDD 0 'VDD_V'
Vinp INP 0 dc 'VCM_V' ac 0.5
Vinn INN 0 dc 'VCM_V' ac -0.5
Cload OUT 0 'CL_F'
* noconn #net1
**** begin user architecture code

.control
  save all
  ac dec 40 1 1G

  * open-loop gain [dB], gain-bandwidth product [MHz], phase margin [deg].
  * Phase is measured RELATIVE to its low-frequency value, so an inverting
  * stage -- whose phase starts at 180 deg -- reports the same margin as a
  * non-inverting one. cph is the unwrapped phase, so a sweep that crosses
  * +/-180 deg does not jump.
  let gph_deg = 180/pi * cph(v(OUT))
  meas ac gain_db find vdb(OUT) at=1
  meas ac gbw_hz  when vdb(OUT)=0
  meas ac ph_dc   find gph_deg at=1
  meas ac ph_ugb  find gph_deg when vdb(OUT)=0
  let gbw_mhz = gbw_hz / 1e6
  let pm_deg  = 180 + (ph_ugb - ph_dc)

  echo MEAS gain_db $&gain_db
  echo MEAS gbw_mhz $&gbw_mhz
  echo MEAS pm_deg $&pm_deg

  write
  quit 0
.endc

**** end user architecture code
**.ends

* expanding   symbol:  dut_amp.sym # of pins=6
** sym_path: /foss/designs/PROJECTS/llm-analog-sizing/testbenches/dut_amp.sym
** sch_path: /foss/designs/PROJECTS/llm-analog-sizing/testbenches/dut_amp.sch
.subckt dut_amp INP INN OUTN VDD VSS OUTP
XDUT OUTP INN INP N_VBIAS VDD VSS N_net1 N_net3 example_ota_5t_routed_flat
VV1_layout N_VBIAS VSS 0.75
.ends
.subckt example_ota_5t_sized VDD OUTP INP INN VSS
XM3 net3 net3 VDD VDD sky130_fd_pr__pfet_01v8 L=1 W=8 NF=1 AD=2.32 AS=2.32 PD=16.58 PS=16.58 NRD=0.03625 NRS=0.03625 SA=0 SB=0 SD=0 MULT=1
XM4 OUTP net3 VDD VDD sky130_fd_pr__pfet_01v8 L=1 W=8 NF=1 AD=2.32 AS=2.32 PD=16.58 PS=16.58 NRD=0.03625 NRS=0.03625 SA=0 SB=0 SD=0 MULT=1
XM1 net3 INP net1 VSS sky130_fd_pr__nfet_01v8 L=0.5 W=24 NF=1 AD=6.96 AS=6.96 PD=48.58 PS=48.58 NRD=0.0120833333333333 NRS=0.0120833333333333 SA=0 SB=0 SD=0 MULT=1
XM2 OUTP INN net1 VSS sky130_fd_pr__nfet_01v8 L=0.5 W=24 NF=1 AD=6.96 AS=6.96 PD=48.58 PS=48.58 NRD=0.0120833333333333 NRS=0.0120833333333333 SA=0 SB=0 SD=0 MULT=1
XM5 net1 net2 VSS VSS sky130_fd_pr__nfet_01v8 L=1 W=24 NF=1 AD=6.96 AS=6.96 PD=48.58 PS=48.58 NRD=0.0120833333333333 NRS=0.0120833333333333 SA=0 SB=0 SD=0 MULT=1
V1 net2 VSS 0.75
.ends example_ota_5t_sized
* NGSPICE file created from example_ota_5t_routed_flat.ext - technology: sky130A

.subckt example_ota_5t_routed_flat OUTP INN INP VBIAS VDD VSS nmos_differential_pair__AB_0.net1
+ nmos_differential_pair__AB_0.net3
X0 nmos_differential_pair__AB_0.net1 INP nmos_differential_pair__AB_0.net3 VSS sky130_fd_pr__nfet_01v8 ad=3.48 pd=24.58 as=1.74 ps=12.29 w=12 l=0.5
X1 nmos_differential_pair__AB_0.net1 VBIAS VSS VSS sky130_fd_pr__nfet_01v8 ad=3.48 pd=24.58 as=1.74 ps=12.29 w=12 l=1
X2 OUTP INN nmos_differential_pair__AB_0.net1 VSS sky130_fd_pr__nfet_01v8 ad=1.74 pd=12.29 as=3.48 ps=24.58 w=12 l=0.5
X3 OUTP nmos_differential_pair__AB_0.net3 VDD VDD sky130_fd_pr__pfet_01v8 ad=2.32 pd=16.58 as=2.32 ps=16.58 w=8 l=1
X4 nmos_differential_pair__AB_0.net3 INP nmos_differential_pair__AB_0.net1 VSS sky130_fd_pr__nfet_01v8 ad=1.74 pd=12.29 as=3.48 ps=24.58 w=12 l=0.5
X5 VDD nmos_differential_pair__AB_0.net3 nmos_differential_pair__AB_0.net3 VDD sky130_fd_pr__pfet_01v8 ad=2.32 pd=16.58 as=2.32 ps=16.58 w=8 l=1
X6 nmos_differential_pair__AB_0.net1 INN OUTP VSS sky130_fd_pr__nfet_01v8 ad=3.48 pd=24.58 as=1.74 ps=12.29 w=12 l=0.5
X7 VSS VBIAS nmos_differential_pair__AB_0.net1 VSS sky130_fd_pr__nfet_01v8 ad=1.74 pd=12.29 as=3.48 ps=24.58 w=12 l=1
C0 nmos_differential_pair__AB_0.net1 VDD 0.00636f
C1 nmos_differential_pair__AB_0.net3 VDD 4.04835f
C2 INN INP 0.46014f
C3 OUTP INP 0.14977f
C4 INN nmos_differential_pair__AB_0.net1 1.25257f
C5 OUTP nmos_differential_pair__AB_0.net1 1.61441f
C6 nmos_differential_pair__AB_0.net3 INN 0.12455f
C7 OUTP nmos_differential_pair__AB_0.net3 2.33837f
C8 INP nmos_differential_pair__AB_0.net1 1.53017f
C9 nmos_differential_pair__AB_0.net3 INP 1.11334f
C10 nmos_differential_pair__AB_0.net3 nmos_differential_pair__AB_0.net1 1.97086f
C11 INN VBIAS 0
C12 OUTP VBIAS 0.04176f
C13 INP VBIAS 0
C14 VBIAS nmos_differential_pair__AB_0.net1 1.75393f
C15 nmos_differential_pair__AB_0.net3 VBIAS 0
C16 INN VDD 0.03878f
C17 OUTP VDD 1.65731f
C18 OUTP INN 1.07477f
C19 INP VDD 0.00625f
C20 nmos_differential_pair__AB_0.net1 VSS 10.83932f
C21 OUTP VSS 3.59477f
C22 VDD VSS 16.6127f
.ends

.end
