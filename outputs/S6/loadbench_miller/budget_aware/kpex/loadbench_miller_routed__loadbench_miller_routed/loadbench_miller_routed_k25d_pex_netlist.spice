*********************************************************
*** NGSPICE file created by KLayout-PEX 0.6.8
*** -----------------------------------------------------
***     Extraction Engine: KPEX/2.5D
***     Technology: sky130a
***     Date: 2026-11-04 05:22:48
*********************************************************

.SUBCKT loadbench_miller_routed IBIAS in1 in2 out sky130_gnd sourceNmos
+ sourcePmos
X$2 out IBIAS sourcePmos sourcePmos sky130_fd_pr__pfet_01v8_lvt l=0.74 w=55.44
+ as=16.0776 ad=8.0388 ps=111.46 pd=55.73
X$3 sourcePmos IBIAS out sourcePmos sky130_fd_pr__pfet_01v8_lvt l=0.74 w=55.44
+ as=8.0388 ad=8.0388 ps=55.73 pd=55.73
X$4 out IBIAS sourcePmos sourcePmos sky130_fd_pr__pfet_01v8_lvt l=0.74 w=55.44
+ as=8.0388 ad=8.0388 ps=55.73 pd=55.73
X$5 sourcePmos IBIAS out sourcePmos sky130_fd_pr__pfet_01v8_lvt l=0.74 w=55.44
+ as=8.0388 ad=8.0388 ps=55.73 pd=55.73
X$6 out IBIAS sourcePmos sourcePmos sky130_fd_pr__pfet_01v8_lvt l=0.74 w=55.44
+ as=8.0388 ad=8.0388 ps=55.73 pd=55.73
X$7 sourcePmos IBIAS out sourcePmos sky130_fd_pr__pfet_01v8_lvt l=0.74 w=55.44
+ as=8.0388 ad=8.0388 ps=55.73 pd=55.73
X$8 out IBIAS sourcePmos sourcePmos sky130_fd_pr__pfet_01v8_lvt l=0.74 w=55.44
+ as=8.0388 ad=8.0388 ps=55.73 pd=55.73
X$9 sourcePmos IBIAS out sourcePmos sky130_fd_pr__pfet_01v8_lvt l=0.74 w=55.44
+ as=8.0388 ad=8.0388 ps=55.73 pd=55.73
X$10 out IBIAS sourcePmos sourcePmos sky130_fd_pr__pfet_01v8_lvt l=0.74 w=55.44
+ as=8.0388 ad=8.0388 ps=55.73 pd=55.73
X$11 sourcePmos IBIAS out sourcePmos sky130_fd_pr__pfet_01v8_lvt l=0.74 w=55.44
+ as=8.0388 ad=8.0388 ps=55.73 pd=55.73
X$12 out IBIAS sourcePmos sourcePmos sky130_fd_pr__pfet_01v8_lvt l=0.74 w=55.44
+ as=8.0388 ad=8.0388 ps=55.73 pd=55.73
X$13 sourcePmos IBIAS out sourcePmos sky130_fd_pr__pfet_01v8_lvt l=0.74 w=55.44
+ as=8.0388 ad=8.0388 ps=55.73 pd=55.73
X$14 out IBIAS sourcePmos sourcePmos sky130_fd_pr__pfet_01v8_lvt l=0.74 w=55.44
+ as=8.0388 ad=8.0388 ps=55.73 pd=55.73
X$15 sourcePmos IBIAS out sourcePmos sky130_fd_pr__pfet_01v8_lvt l=0.74 w=55.44
+ as=8.0388 ad=8.0388 ps=55.73 pd=55.73
X$16 out IBIAS sourcePmos sourcePmos sky130_fd_pr__pfet_01v8_lvt l=0.74 w=55.44
+ as=8.0388 ad=8.0388 ps=55.73 pd=55.73
X$17 sourcePmos IBIAS out sourcePmos sky130_fd_pr__pfet_01v8_lvt l=0.74 w=55.44
+ as=8.0388 ad=16.0776 ps=55.73 pd=111.46
X$18 \$17 IBIAS sourcePmos sourcePmos sky130_fd_pr__pfet_01v8_lvt l=0.74
+ w=11.33 as=3.2857 ad=1.64285 ps=23.24 pd=11.62
X$19 sourcePmos IBIAS \$17 sourcePmos sky130_fd_pr__pfet_01v8_lvt l=0.74
+ w=11.33 as=1.64285 ad=1.64285 ps=11.62 pd=11.62
X$20 \$17 IBIAS sourcePmos sourcePmos sky130_fd_pr__pfet_01v8_lvt l=0.74
+ w=11.33 as=1.64285 ad=1.64285 ps=11.62 pd=11.62
X$21 sourcePmos IBIAS \$17 sourcePmos sky130_fd_pr__pfet_01v8_lvt l=0.74
+ w=11.33 as=1.64285 ad=1.64285 ps=11.62 pd=11.62
X$22 \$17 IBIAS sourcePmos sourcePmos sky130_fd_pr__pfet_01v8_lvt l=0.74
+ w=11.33 as=1.64285 ad=1.64285 ps=11.62 pd=11.62
X$23 sourcePmos IBIAS \$17 sourcePmos sky130_fd_pr__pfet_01v8_lvt l=0.74
+ w=11.33 as=1.64285 ad=1.64285 ps=11.62 pd=11.62
X$24 \$17 IBIAS sourcePmos sourcePmos sky130_fd_pr__pfet_01v8_lvt l=0.74
+ w=11.33 as=1.64285 ad=1.64285 ps=11.62 pd=11.62
X$25 sourcePmos IBIAS \$17 sourcePmos sky130_fd_pr__pfet_01v8_lvt l=0.74
+ w=11.33 as=1.64285 ad=3.2857 ps=11.62 pd=23.24
X$26 sourcePmos IBIAS IBIAS sourcePmos sky130_fd_pr__pfet_01v8_lvt l=0.74
+ w=37.3 as=10.817 ad=10.817 ps=75.18 pd=75.18
X$27 \$13 in1 \$17 \$17 sky130_fd_pr__pfet_01v8_lvt l=0.89 w=7.11 as=2.0619
+ ad=1.03095 ps=14.8 pd=7.4
X$28 \$17 in1 \$13 \$17 sky130_fd_pr__pfet_01v8_lvt l=0.89 w=7.11 as=1.03095
+ ad=2.0619 ps=7.4 pd=14.8
X$29 \$9 in2 \$17 \$17 sky130_fd_pr__pfet_01v8_lvt l=0.89 w=7.11 as=2.0619
+ ad=1.03095 ps=14.8 pd=7.4
X$30 \$17 in2 \$9 \$17 sky130_fd_pr__pfet_01v8_lvt l=0.89 w=7.11 as=1.03095
+ ad=2.0619 ps=7.4 pd=14.8
X$31 \$9 \$13 sourceNmos sky130_gnd sky130_fd_pr__nfet_01v8_lvt l=2.03 w=8.27
+ as=2.3983 ad=1.19915 ps=17.12 pd=8.56
X$32 sourceNmos \$13 \$9 sky130_gnd sky130_fd_pr__nfet_01v8_lvt l=2.03 w=8.27
+ as=1.19915 ad=1.19915 ps=8.56 pd=8.56
X$33 \$9 \$13 sourceNmos sky130_gnd sky130_fd_pr__nfet_01v8_lvt l=2.03 w=8.27
+ as=1.19915 ad=1.19915 ps=8.56 pd=8.56
X$34 sourceNmos \$13 \$9 sky130_gnd sky130_fd_pr__nfet_01v8_lvt l=2.03 w=8.27
+ as=1.19915 ad=1.19915 ps=8.56 pd=8.56
X$35 \$9 \$13 sourceNmos sky130_gnd sky130_fd_pr__nfet_01v8_lvt l=2.03 w=8.27
+ as=1.19915 ad=1.19915 ps=8.56 pd=8.56
X$36 sourceNmos \$13 \$9 sky130_gnd sky130_fd_pr__nfet_01v8_lvt l=2.03 w=8.27
+ as=1.19915 ad=1.19915 ps=8.56 pd=8.56
X$37 \$9 \$13 sourceNmos sky130_gnd sky130_fd_pr__nfet_01v8_lvt l=2.03 w=8.27
+ as=1.19915 ad=1.19915 ps=8.56 pd=8.56
X$38 sourceNmos \$13 \$9 sky130_gnd sky130_fd_pr__nfet_01v8_lvt l=2.03 w=8.27
+ as=1.19915 ad=2.3983 ps=8.56 pd=17.12
X$39 \$13 \$13 sourceNmos sky130_gnd sky130_fd_pr__nfet_01v8_lvt l=2.03 w=8.27
+ as=2.3983 ad=1.19915 ps=17.12 pd=8.56
X$40 sourceNmos \$13 \$13 sky130_gnd sky130_fd_pr__nfet_01v8_lvt l=2.03 w=8.27
+ as=1.19915 ad=1.19915 ps=8.56 pd=8.56
X$41 \$13 \$13 sourceNmos sky130_gnd sky130_fd_pr__nfet_01v8_lvt l=2.03 w=8.27
+ as=1.19915 ad=1.19915 ps=8.56 pd=8.56
X$42 sourceNmos \$13 \$13 sky130_gnd sky130_fd_pr__nfet_01v8_lvt l=2.03 w=8.27
+ as=1.19915 ad=1.19915 ps=8.56 pd=8.56
X$43 \$13 \$13 sourceNmos sky130_gnd sky130_fd_pr__nfet_01v8_lvt l=2.03 w=8.27
+ as=1.19915 ad=1.19915 ps=8.56 pd=8.56
X$44 sourceNmos \$13 \$13 sky130_gnd sky130_fd_pr__nfet_01v8_lvt l=2.03 w=8.27
+ as=1.19915 ad=1.19915 ps=8.56 pd=8.56
X$45 \$13 \$13 sourceNmos sky130_gnd sky130_fd_pr__nfet_01v8_lvt l=2.03 w=8.27
+ as=1.19915 ad=1.19915 ps=8.56 pd=8.56
X$46 sourceNmos \$13 \$13 sky130_gnd sky130_fd_pr__nfet_01v8_lvt l=2.03 w=8.27
+ as=1.19915 ad=2.3983 ps=8.56 pd=17.12
X$47 out \$9 sourceNmos sky130_gnd sky130_fd_pr__nfet_01v8_lvt l=0.24 w=15.13
+ as=4.3877 ad=2.19385 ps=30.84 pd=15.42
X$48 sourceNmos \$9 out sky130_gnd sky130_fd_pr__nfet_01v8_lvt l=0.24 w=15.13
+ as=2.19385 ad=2.19385 ps=15.42 pd=15.42
X$49 out \$9 sourceNmos sky130_gnd sky130_fd_pr__nfet_01v8_lvt l=0.24 w=15.13
+ as=2.19385 ad=2.19385 ps=15.42 pd=15.42
X$50 sourceNmos \$9 out sky130_gnd sky130_fd_pr__nfet_01v8_lvt l=0.24 w=15.13
+ as=2.19385 ad=2.19385 ps=15.42 pd=15.42
X$51 out \$9 sourceNmos sky130_gnd sky130_fd_pr__nfet_01v8_lvt l=0.24 w=15.13
+ as=2.19385 ad=2.19385 ps=15.42 pd=15.42
X$52 sourceNmos \$9 out sky130_gnd sky130_fd_pr__nfet_01v8_lvt l=0.24 w=15.13
+ as=2.19385 ad=2.19385 ps=15.42 pd=15.42
X$53 out \$9 sourceNmos sky130_gnd sky130_fd_pr__nfet_01v8_lvt l=0.24 w=15.13
+ as=2.19385 ad=2.19385 ps=15.42 pd=15.42
X$54 sourceNmos \$9 out sky130_gnd sky130_fd_pr__nfet_01v8_lvt l=0.24 w=15.13
+ as=2.19385 ad=2.19385 ps=15.42 pd=15.42
X$55 out \$9 sourceNmos sky130_gnd sky130_fd_pr__nfet_01v8_lvt l=0.24 w=15.13
+ as=2.19385 ad=2.19385 ps=15.42 pd=15.42
X$56 sourceNmos \$9 out sky130_gnd sky130_fd_pr__nfet_01v8_lvt l=0.24 w=15.13
+ as=2.19385 ad=2.19385 ps=15.42 pd=15.42
X$57 out \$9 sourceNmos sky130_gnd sky130_fd_pr__nfet_01v8_lvt l=0.24 w=15.13
+ as=2.19385 ad=2.19385 ps=15.42 pd=15.42
X$58 sourceNmos \$9 out sky130_gnd sky130_fd_pr__nfet_01v8_lvt l=0.24 w=15.13
+ as=2.19385 ad=2.19385 ps=15.42 pd=15.42
X$59 out \$9 sourceNmos sky130_gnd sky130_fd_pr__nfet_01v8_lvt l=0.24 w=15.13
+ as=2.19385 ad=2.19385 ps=15.42 pd=15.42
X$60 sourceNmos \$9 out sky130_gnd sky130_fd_pr__nfet_01v8_lvt l=0.24 w=15.13
+ as=2.19385 ad=2.19385 ps=15.42 pd=15.42
X$61 out \$9 sourceNmos sky130_gnd sky130_fd_pr__nfet_01v8_lvt l=0.24 w=15.13
+ as=2.19385 ad=2.19385 ps=15.42 pd=15.42
X$62 sourceNmos \$9 out sky130_gnd sky130_fd_pr__nfet_01v8_lvt l=0.24 w=15.13
+ as=2.19385 ad=2.19385 ps=15.42 pd=15.42
X$63 out \$9 sourceNmos sky130_gnd sky130_fd_pr__nfet_01v8_lvt l=0.24 w=15.13
+ as=2.19385 ad=2.19385 ps=15.42 pd=15.42
X$64 sourceNmos \$9 out sky130_gnd sky130_fd_pr__nfet_01v8_lvt l=0.24 w=15.13
+ as=2.19385 ad=2.19385 ps=15.42 pd=15.42
X$65 out \$9 sourceNmos sky130_gnd sky130_fd_pr__nfet_01v8_lvt l=0.24 w=15.13
+ as=2.19385 ad=2.19385 ps=15.42 pd=15.42
X$66 sourceNmos \$9 out sky130_gnd sky130_fd_pr__nfet_01v8_lvt l=0.24 w=15.13
+ as=2.19385 ad=2.19385 ps=15.42 pd=15.42
X$67 out \$9 sourceNmos sky130_gnd sky130_fd_pr__nfet_01v8_lvt l=0.24 w=15.13
+ as=2.19385 ad=2.19385 ps=15.42 pd=15.42
X$68 sourceNmos \$9 out sky130_gnd sky130_fd_pr__nfet_01v8_lvt l=0.24 w=15.13
+ as=2.19385 ad=2.19385 ps=15.42 pd=15.42
X$69 out \$9 sourceNmos sky130_gnd sky130_fd_pr__nfet_01v8_lvt l=0.24 w=15.13
+ as=2.19385 ad=2.19385 ps=15.42 pd=15.42
X$70 sourceNmos \$9 out sky130_gnd sky130_fd_pr__nfet_01v8_lvt l=0.24 w=15.13
+ as=2.19385 ad=2.19385 ps=15.42 pd=15.42
X$71 out \$9 sourceNmos sky130_gnd sky130_fd_pr__nfet_01v8_lvt l=0.24 w=15.13
+ as=2.19385 ad=2.19385 ps=15.42 pd=15.42
X$72 sourceNmos \$9 out sky130_gnd sky130_fd_pr__nfet_01v8_lvt l=0.24 w=15.13
+ as=2.19385 ad=2.19385 ps=15.42 pd=15.42
X$73 out \$9 sourceNmos sky130_gnd sky130_fd_pr__nfet_01v8_lvt l=0.24 w=15.13
+ as=2.19385 ad=2.19385 ps=15.42 pd=15.42
X$74 sourceNmos \$9 out sky130_gnd sky130_fd_pr__nfet_01v8_lvt l=0.24 w=15.13
+ as=2.19385 ad=2.19385 ps=15.42 pd=15.42
X$75 out \$9 sourceNmos sky130_gnd sky130_fd_pr__nfet_01v8_lvt l=0.24 w=15.13
+ as=2.19385 ad=2.19385 ps=15.42 pd=15.42
X$76 sourceNmos \$9 out sky130_gnd sky130_fd_pr__nfet_01v8_lvt l=0.24 w=15.13
+ as=2.19385 ad=2.19385 ps=15.42 pd=15.42
X$77 out \$9 sourceNmos sky130_gnd sky130_fd_pr__nfet_01v8_lvt l=0.24 w=15.13
+ as=2.19385 ad=2.19385 ps=15.42 pd=15.42
X$78 sourceNmos \$9 out sky130_gnd sky130_fd_pr__nfet_01v8_lvt l=0.24 w=15.13
+ as=2.19385 ad=4.3877 ps=15.42 pd=30.84
Cext_1 \$13 \$17 1.34937f
Cext_2 \$13 \$9 10.6515f
Cext_3 \$13 in1 1.1903f
Cext_4 \$13 in2 72.5105a
Cext_5 \$13 out 840.346a
Cext_6 \$13 sourceNmos 20.7509f
Cext_7 \$13 sky130_gnd 17.0597f
Cext_8 \$17 \$9 1.29026f
Cext_9 \$17 IBIAS 5.93251f
Cext_10 \$17 in1 2.98961f
Cext_11 \$17 in2 2.79954f
Cext_12 \$17 out 2.35181f
Cext_13 \$17 sourceNmos 50.2838a
Cext_14 \$17 sourcePmos 6.66486f
Cext_15 \$17 sky130_gnd 2.26032f
Cext_16 \$9 in1 9.25991a
Cext_17 \$9 in2 1.12566f
Cext_18 \$9 out 512.281f
Cext_19 \$9 sourceNmos 12.0315f
Cext_20 \$9 sky130_gnd 10.6369f
Cext_21 IBIAS out 26.9981f
Cext_22 IBIAS sourcePmos 61.6474f
Cext_23 IBIAS sky130_gnd 1.54857f
Cext_24 in1 in2 578.073a
Cext_25 in1 out 245.275a
Cext_26 in1 sourcePmos 5.83004a
Cext_27 in2 out 149.43a
Cext_28 in2 sourcePmos 57.2676a
Cext_29 out sourceNmos 22.9517f
Cext_30 out sourcePmos 20.1536f
Cext_31 sky130_gnd in1 146.118a
Cext_32 sky130_gnd in2 369.558a
Cext_33 sky130_gnd out 11.1f
Cext_34 sky130_gnd sourceNmos 19.0038f
Cext_35 sky130_gnd sourcePmos 9.61362f
.ENDS loadbench_miller_routed
