* Extracted by KLayout with SKY130 LVS runset on : 04/11/2026 13:39

.SUBCKT loadbench_miller_routed IBIAS in1 in2 out sky130_gnd sourceNmos
+ sourcePmos
C$1 out \$9 sky130_fd_pr__model__cap_mim C=4.904712e-13 A=245.2356 P=62.64
M$2 sourcePmos IBIAS out sourcePmos sky130_fd_pr__pfet_01v8_lvt L=0.74 W=55.44
+ AS=16.0776 AD=8.0388 PS=111.46 PD=55.73
M$3 out IBIAS sourcePmos sourcePmos sky130_fd_pr__pfet_01v8_lvt L=0.74 W=55.44
+ AS=8.0388 AD=8.0388 PS=55.73 PD=55.73
M$4 sourcePmos IBIAS out sourcePmos sky130_fd_pr__pfet_01v8_lvt L=0.74 W=55.44
+ AS=8.0388 AD=8.0388 PS=55.73 PD=55.73
M$5 out IBIAS sourcePmos sourcePmos sky130_fd_pr__pfet_01v8_lvt L=0.74 W=55.44
+ AS=8.0388 AD=8.0388 PS=55.73 PD=55.73
M$6 sourcePmos IBIAS out sourcePmos sky130_fd_pr__pfet_01v8_lvt L=0.74 W=55.44
+ AS=8.0388 AD=8.0388 PS=55.73 PD=55.73
M$7 out IBIAS sourcePmos sourcePmos sky130_fd_pr__pfet_01v8_lvt L=0.74 W=55.44
+ AS=8.0388 AD=8.0388 PS=55.73 PD=55.73
M$8 sourcePmos IBIAS out sourcePmos sky130_fd_pr__pfet_01v8_lvt L=0.74 W=55.44
+ AS=8.0388 AD=8.0388 PS=55.73 PD=55.73
M$9 out IBIAS sourcePmos sourcePmos sky130_fd_pr__pfet_01v8_lvt L=0.74 W=55.44
+ AS=8.0388 AD=8.0388 PS=55.73 PD=55.73
M$10 sourcePmos IBIAS out sourcePmos sky130_fd_pr__pfet_01v8_lvt L=0.74 W=55.44
+ AS=8.0388 AD=8.0388 PS=55.73 PD=55.73
M$11 out IBIAS sourcePmos sourcePmos sky130_fd_pr__pfet_01v8_lvt L=0.74 W=55.44
+ AS=8.0388 AD=8.0388 PS=55.73 PD=55.73
M$12 sourcePmos IBIAS out sourcePmos sky130_fd_pr__pfet_01v8_lvt L=0.74 W=55.44
+ AS=8.0388 AD=8.0388 PS=55.73 PD=55.73
M$13 out IBIAS sourcePmos sourcePmos sky130_fd_pr__pfet_01v8_lvt L=0.74 W=55.44
+ AS=8.0388 AD=8.0388 PS=55.73 PD=55.73
M$14 sourcePmos IBIAS out sourcePmos sky130_fd_pr__pfet_01v8_lvt L=0.74 W=55.44
+ AS=8.0388 AD=8.0388 PS=55.73 PD=55.73
M$15 out IBIAS sourcePmos sourcePmos sky130_fd_pr__pfet_01v8_lvt L=0.74 W=55.44
+ AS=8.0388 AD=8.0388 PS=55.73 PD=55.73
M$16 sourcePmos IBIAS out sourcePmos sky130_fd_pr__pfet_01v8_lvt L=0.74 W=55.44
+ AS=8.0388 AD=8.0388 PS=55.73 PD=55.73
M$17 out IBIAS sourcePmos sourcePmos sky130_fd_pr__pfet_01v8_lvt L=0.74 W=55.44
+ AS=8.0388 AD=16.0776 PS=55.73 PD=111.46
M$18 sourcePmos IBIAS \$17 sourcePmos sky130_fd_pr__pfet_01v8_lvt L=0.74
+ W=11.33 AS=3.2857 AD=1.64285 PS=23.24 PD=11.62
M$19 \$17 IBIAS sourcePmos sourcePmos sky130_fd_pr__pfet_01v8_lvt L=0.74
+ W=11.33 AS=1.64285 AD=1.64285 PS=11.62 PD=11.62
M$20 sourcePmos IBIAS \$17 sourcePmos sky130_fd_pr__pfet_01v8_lvt L=0.74
+ W=11.33 AS=1.64285 AD=1.64285 PS=11.62 PD=11.62
M$21 \$17 IBIAS sourcePmos sourcePmos sky130_fd_pr__pfet_01v8_lvt L=0.74
+ W=11.33 AS=1.64285 AD=1.64285 PS=11.62 PD=11.62
M$22 sourcePmos IBIAS \$17 sourcePmos sky130_fd_pr__pfet_01v8_lvt L=0.74
+ W=11.33 AS=1.64285 AD=1.64285 PS=11.62 PD=11.62
M$23 \$17 IBIAS sourcePmos sourcePmos sky130_fd_pr__pfet_01v8_lvt L=0.74
+ W=11.33 AS=1.64285 AD=1.64285 PS=11.62 PD=11.62
M$24 sourcePmos IBIAS \$17 sourcePmos sky130_fd_pr__pfet_01v8_lvt L=0.74
+ W=11.33 AS=1.64285 AD=1.64285 PS=11.62 PD=11.62
M$25 \$17 IBIAS sourcePmos sourcePmos sky130_fd_pr__pfet_01v8_lvt L=0.74
+ W=11.33 AS=1.64285 AD=3.2857 PS=11.62 PD=23.24
M$26 IBIAS IBIAS sourcePmos sourcePmos sky130_fd_pr__pfet_01v8_lvt L=0.74
+ W=37.3 AS=10.817 AD=10.817 PS=75.18 PD=75.18
M$27 \$17 in1 \$13 \$17 sky130_fd_pr__pfet_01v8_lvt L=0.89 W=7.11 AS=2.0619
+ AD=1.03095 PS=14.8 PD=7.4
M$28 \$13 in1 \$17 \$17 sky130_fd_pr__pfet_01v8_lvt L=0.89 W=7.11 AS=1.03095
+ AD=2.0619 PS=7.4 PD=14.8
M$29 \$17 in2 \$9 \$17 sky130_fd_pr__pfet_01v8_lvt L=0.89 W=7.11 AS=2.0619
+ AD=1.03095 PS=14.8 PD=7.4
M$30 \$9 in2 \$17 \$17 sky130_fd_pr__pfet_01v8_lvt L=0.89 W=7.11 AS=1.03095
+ AD=2.0619 PS=7.4 PD=14.8
M$31 sourceNmos \$13 \$9 sky130_gnd sky130_fd_pr__nfet_01v8_lvt L=2.03 W=8.27
+ AS=2.3983 AD=1.19915 PS=17.12 PD=8.56
M$32 \$9 \$13 sourceNmos sky130_gnd sky130_fd_pr__nfet_01v8_lvt L=2.03 W=8.27
+ AS=1.19915 AD=1.19915 PS=8.56 PD=8.56
M$33 sourceNmos \$13 \$9 sky130_gnd sky130_fd_pr__nfet_01v8_lvt L=2.03 W=8.27
+ AS=1.19915 AD=1.19915 PS=8.56 PD=8.56
M$34 \$9 \$13 sourceNmos sky130_gnd sky130_fd_pr__nfet_01v8_lvt L=2.03 W=8.27
+ AS=1.19915 AD=1.19915 PS=8.56 PD=8.56
M$35 sourceNmos \$13 \$9 sky130_gnd sky130_fd_pr__nfet_01v8_lvt L=2.03 W=8.27
+ AS=1.19915 AD=1.19915 PS=8.56 PD=8.56
M$36 \$9 \$13 sourceNmos sky130_gnd sky130_fd_pr__nfet_01v8_lvt L=2.03 W=8.27
+ AS=1.19915 AD=1.19915 PS=8.56 PD=8.56
M$37 sourceNmos \$13 \$9 sky130_gnd sky130_fd_pr__nfet_01v8_lvt L=2.03 W=8.27
+ AS=1.19915 AD=1.19915 PS=8.56 PD=8.56
M$38 \$9 \$13 sourceNmos sky130_gnd sky130_fd_pr__nfet_01v8_lvt L=2.03 W=8.27
+ AS=1.19915 AD=2.3983 PS=8.56 PD=17.12
M$39 sourceNmos \$13 \$13 sky130_gnd sky130_fd_pr__nfet_01v8_lvt L=2.03 W=8.27
+ AS=2.3983 AD=1.19915 PS=17.12 PD=8.56
M$40 \$13 \$13 sourceNmos sky130_gnd sky130_fd_pr__nfet_01v8_lvt L=2.03 W=8.27
+ AS=1.19915 AD=1.19915 PS=8.56 PD=8.56
M$41 sourceNmos \$13 \$13 sky130_gnd sky130_fd_pr__nfet_01v8_lvt L=2.03 W=8.27
+ AS=1.19915 AD=1.19915 PS=8.56 PD=8.56
M$42 \$13 \$13 sourceNmos sky130_gnd sky130_fd_pr__nfet_01v8_lvt L=2.03 W=8.27
+ AS=1.19915 AD=1.19915 PS=8.56 PD=8.56
M$43 sourceNmos \$13 \$13 sky130_gnd sky130_fd_pr__nfet_01v8_lvt L=2.03 W=8.27
+ AS=1.19915 AD=1.19915 PS=8.56 PD=8.56
M$44 \$13 \$13 sourceNmos sky130_gnd sky130_fd_pr__nfet_01v8_lvt L=2.03 W=8.27
+ AS=1.19915 AD=1.19915 PS=8.56 PD=8.56
M$45 sourceNmos \$13 \$13 sky130_gnd sky130_fd_pr__nfet_01v8_lvt L=2.03 W=8.27
+ AS=1.19915 AD=1.19915 PS=8.56 PD=8.56
M$46 \$13 \$13 sourceNmos sky130_gnd sky130_fd_pr__nfet_01v8_lvt L=2.03 W=8.27
+ AS=1.19915 AD=2.3983 PS=8.56 PD=17.12
M$47 sourceNmos \$9 out sky130_gnd sky130_fd_pr__nfet_01v8_lvt L=0.24 W=15.13
+ AS=4.3877 AD=2.19385 PS=30.84 PD=15.42
M$48 out \$9 sourceNmos sky130_gnd sky130_fd_pr__nfet_01v8_lvt L=0.24 W=15.13
+ AS=2.19385 AD=2.19385 PS=15.42 PD=15.42
M$49 sourceNmos \$9 out sky130_gnd sky130_fd_pr__nfet_01v8_lvt L=0.24 W=15.13
+ AS=2.19385 AD=2.19385 PS=15.42 PD=15.42
M$50 out \$9 sourceNmos sky130_gnd sky130_fd_pr__nfet_01v8_lvt L=0.24 W=15.13
+ AS=2.19385 AD=2.19385 PS=15.42 PD=15.42
M$51 sourceNmos \$9 out sky130_gnd sky130_fd_pr__nfet_01v8_lvt L=0.24 W=15.13
+ AS=2.19385 AD=2.19385 PS=15.42 PD=15.42
M$52 out \$9 sourceNmos sky130_gnd sky130_fd_pr__nfet_01v8_lvt L=0.24 W=15.13
+ AS=2.19385 AD=2.19385 PS=15.42 PD=15.42
M$53 sourceNmos \$9 out sky130_gnd sky130_fd_pr__nfet_01v8_lvt L=0.24 W=15.13
+ AS=2.19385 AD=2.19385 PS=15.42 PD=15.42
M$54 out \$9 sourceNmos sky130_gnd sky130_fd_pr__nfet_01v8_lvt L=0.24 W=15.13
+ AS=2.19385 AD=2.19385 PS=15.42 PD=15.42
M$55 sourceNmos \$9 out sky130_gnd sky130_fd_pr__nfet_01v8_lvt L=0.24 W=15.13
+ AS=2.19385 AD=2.19385 PS=15.42 PD=15.42
M$56 out \$9 sourceNmos sky130_gnd sky130_fd_pr__nfet_01v8_lvt L=0.24 W=15.13
+ AS=2.19385 AD=2.19385 PS=15.42 PD=15.42
M$57 sourceNmos \$9 out sky130_gnd sky130_fd_pr__nfet_01v8_lvt L=0.24 W=15.13
+ AS=2.19385 AD=2.19385 PS=15.42 PD=15.42
M$58 out \$9 sourceNmos sky130_gnd sky130_fd_pr__nfet_01v8_lvt L=0.24 W=15.13
+ AS=2.19385 AD=2.19385 PS=15.42 PD=15.42
M$59 sourceNmos \$9 out sky130_gnd sky130_fd_pr__nfet_01v8_lvt L=0.24 W=15.13
+ AS=2.19385 AD=2.19385 PS=15.42 PD=15.42
M$60 out \$9 sourceNmos sky130_gnd sky130_fd_pr__nfet_01v8_lvt L=0.24 W=15.13
+ AS=2.19385 AD=2.19385 PS=15.42 PD=15.42
M$61 sourceNmos \$9 out sky130_gnd sky130_fd_pr__nfet_01v8_lvt L=0.24 W=15.13
+ AS=2.19385 AD=2.19385 PS=15.42 PD=15.42
M$62 out \$9 sourceNmos sky130_gnd sky130_fd_pr__nfet_01v8_lvt L=0.24 W=15.13
+ AS=2.19385 AD=2.19385 PS=15.42 PD=15.42
M$63 sourceNmos \$9 out sky130_gnd sky130_fd_pr__nfet_01v8_lvt L=0.24 W=15.13
+ AS=2.19385 AD=2.19385 PS=15.42 PD=15.42
M$64 out \$9 sourceNmos sky130_gnd sky130_fd_pr__nfet_01v8_lvt L=0.24 W=15.13
+ AS=2.19385 AD=2.19385 PS=15.42 PD=15.42
M$65 sourceNmos \$9 out sky130_gnd sky130_fd_pr__nfet_01v8_lvt L=0.24 W=15.13
+ AS=2.19385 AD=2.19385 PS=15.42 PD=15.42
M$66 out \$9 sourceNmos sky130_gnd sky130_fd_pr__nfet_01v8_lvt L=0.24 W=15.13
+ AS=2.19385 AD=2.19385 PS=15.42 PD=15.42
M$67 sourceNmos \$9 out sky130_gnd sky130_fd_pr__nfet_01v8_lvt L=0.24 W=15.13
+ AS=2.19385 AD=2.19385 PS=15.42 PD=15.42
M$68 out \$9 sourceNmos sky130_gnd sky130_fd_pr__nfet_01v8_lvt L=0.24 W=15.13
+ AS=2.19385 AD=2.19385 PS=15.42 PD=15.42
M$69 sourceNmos \$9 out sky130_gnd sky130_fd_pr__nfet_01v8_lvt L=0.24 W=15.13
+ AS=2.19385 AD=2.19385 PS=15.42 PD=15.42
M$70 out \$9 sourceNmos sky130_gnd sky130_fd_pr__nfet_01v8_lvt L=0.24 W=15.13
+ AS=2.19385 AD=2.19385 PS=15.42 PD=15.42
M$71 sourceNmos \$9 out sky130_gnd sky130_fd_pr__nfet_01v8_lvt L=0.24 W=15.13
+ AS=2.19385 AD=2.19385 PS=15.42 PD=15.42
M$72 out \$9 sourceNmos sky130_gnd sky130_fd_pr__nfet_01v8_lvt L=0.24 W=15.13
+ AS=2.19385 AD=2.19385 PS=15.42 PD=15.42
M$73 sourceNmos \$9 out sky130_gnd sky130_fd_pr__nfet_01v8_lvt L=0.24 W=15.13
+ AS=2.19385 AD=2.19385 PS=15.42 PD=15.42
M$74 out \$9 sourceNmos sky130_gnd sky130_fd_pr__nfet_01v8_lvt L=0.24 W=15.13
+ AS=2.19385 AD=2.19385 PS=15.42 PD=15.42
M$75 sourceNmos \$9 out sky130_gnd sky130_fd_pr__nfet_01v8_lvt L=0.24 W=15.13
+ AS=2.19385 AD=2.19385 PS=15.42 PD=15.42
M$76 out \$9 sourceNmos sky130_gnd sky130_fd_pr__nfet_01v8_lvt L=0.24 W=15.13
+ AS=2.19385 AD=2.19385 PS=15.42 PD=15.42
M$77 sourceNmos \$9 out sky130_gnd sky130_fd_pr__nfet_01v8_lvt L=0.24 W=15.13
+ AS=2.19385 AD=2.19385 PS=15.42 PD=15.42
M$78 out \$9 sourceNmos sky130_gnd sky130_fd_pr__nfet_01v8_lvt L=0.24 W=15.13
+ AS=2.19385 AD=4.3877 PS=15.42 PD=30.84
.ENDS loadbench_miller_routed
