* NGSPICE file created from Capacitor2__A_flat.ext - technology: sky130A

.subckt Capacitor2__A_flat outFirstStage out
X0 outFirstStage out sky130_fd_pr__cap_mim_m3_1 l=15.66 w=15.66
C0 out outFirstStage 22.4749f
C1 out VSUBS 10.17414f
.ends
