* NGSPICE file created from ota5t_gui_new_routed_flat.ext - technology: sky130A

.subckt ota5t_gui_new_routed_flat OUTP INN INP VBIAS VDD VSS XM4__A_0.net3 XM5__A_0.net1
X0 XM5__A_0.net1 INP XM4__A_0.net3 VSS sky130_fd_pr__nfet_01v8 ad=3.48 pd=24.58 as=1.74 ps=12.29 w=12 l=0.5
X1 XM5__A_0.net1 INN OUTP VSS sky130_fd_pr__nfet_01v8 ad=3.48 pd=24.58 as=1.74 ps=12.29 w=12 l=0.5
X2 VSS VBIAS XM5__A_0.net1 VSS sky130_fd_pr__nfet_01v8 ad=6.96 pd=48.58 as=6.96 ps=48.58 w=24 l=1
X3 XM4__A_0.net3 INP XM5__A_0.net1 VSS sky130_fd_pr__nfet_01v8 ad=1.74 pd=12.29 as=3.48 ps=24.58 w=12 l=0.5
X4 OUTP INN XM5__A_0.net1 VSS sky130_fd_pr__nfet_01v8 ad=1.74 pd=12.29 as=3.48 ps=24.58 w=12 l=0.5
X5 VDD XM4__A_0.net3 OUTP VDD sky130_fd_pr__pfet_01v8 ad=2.32 pd=16.58 as=2.32 ps=16.58 w=8 l=1
X6 VDD XM4__A_0.net3 XM4__A_0.net3 VDD sky130_fd_pr__pfet_01v8 ad=2.32 pd=16.58 as=2.32 ps=16.58 w=8 l=1
C0 XM5__A_0.net1 VBIAS 1.50038f
C1 XM4__A_0.net3 VDD 5.3035f
C2 XM5__A_0.net1 VDD 0.00554f
C3 OUTP XM4__A_0.net3 1.0998f
C4 INP INN 0.00227f
C5 OUTP XM5__A_0.net1 2.36671f
C6 INN VBIAS 0.00359f
C7 XM4__A_0.net3 XM5__A_0.net1 1.47689f
C8 INP VDD 0.06552f
C9 INP OUTP 0.18023f
C10 OUTP INN 1.26817f
C11 INP XM4__A_0.net3 1.24871f
C12 OUTP VBIAS 0.03384f
C13 INP XM5__A_0.net1 1.43201f
C14 XM4__A_0.net3 INN 0.03585f
C15 OUTP VDD 1.5828f
C16 INN XM5__A_0.net1 1.45759f
C17 XM5__A_0.net1 VSS 13.71342f
C18 OUTP VSS 5.17053f
C19 VDD VSS 22.2353f
.ends
