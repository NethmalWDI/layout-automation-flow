* Extracted by KLayout with SKY130 LVS runset on : 04/11/2026 18:47

.SUBCKT ota5t_gui_new_routed INN INP OUTP VBIAS VDD VSS sky130_gnd
M$1 \$12 \$12 VDD VDD sky130_fd_pr__pfet_01v8 L=1 W=8 AS=2.32 AD=2.32 PS=16.58
+ PD=16.58
M$2 OUTP \$12 VDD VDD sky130_fd_pr__pfet_01v8 L=1 W=8 AS=2.32 AD=2.32 PS=16.58
+ PD=16.58
M$3 \$4 INP \$12 sky130_gnd sky130_fd_pr__nfet_01v8 L=0.5 W=12 AS=3.48 AD=1.74
+ PS=24.58 PD=12.29
M$4 \$12 INP \$4 sky130_gnd sky130_fd_pr__nfet_01v8 L=0.5 W=12 AS=1.74 AD=3.48
+ PS=12.29 PD=24.58
M$5 \$4 INN OUTP sky130_gnd sky130_fd_pr__nfet_01v8 L=0.5 W=12 AS=3.48 AD=1.74
+ PS=24.58 PD=12.29
M$6 OUTP INN \$4 sky130_gnd sky130_fd_pr__nfet_01v8 L=0.5 W=12 AS=1.74 AD=3.48
+ PS=12.29 PD=24.58
M$7 \$4 VBIAS VSS sky130_gnd sky130_fd_pr__nfet_01v8 L=1 W=24 AS=6.96 AD=6.96
+ PS=48.58 PD=48.58
.ENDS ota5t_gui_new_routed
