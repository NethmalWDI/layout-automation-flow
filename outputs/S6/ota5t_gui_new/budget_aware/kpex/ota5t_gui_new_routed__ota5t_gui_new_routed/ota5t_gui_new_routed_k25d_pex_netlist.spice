*********************************************************
*** NGSPICE file created by KLayout-PEX 0.6.8
*** -----------------------------------------------------
***     Extraction Engine: KPEX/2.5D
***     Technology: sky130a
***     Date: 2026-11-04 18:48:10
*********************************************************

.SUBCKT ota5t_gui_new_routed INN INP OUTP VBIAS VDD VSS sky130_gnd
X$1 VDD \$12 \$12 VDD sky130_fd_pr__pfet_01v8 l=1 w=8 as=2.32 ad=2.32 ps=16.58
+ pd=16.58
X$2 VDD \$12 OUTP VDD sky130_fd_pr__pfet_01v8 l=1 w=8 as=2.32 ad=2.32 ps=16.58
+ pd=16.58
X$3 \$12 INP \$4 sky130_gnd sky130_fd_pr__nfet_01v8 l=0.5 w=12 as=3.48 ad=1.74
+ ps=24.58 pd=12.29
X$4 \$4 INP \$12 sky130_gnd sky130_fd_pr__nfet_01v8 l=0.5 w=12 as=1.74 ad=3.48
+ ps=12.29 pd=24.58
X$5 OUTP INN \$4 sky130_gnd sky130_fd_pr__nfet_01v8 l=0.5 w=12 as=3.48 ad=1.74
+ ps=24.58 pd=12.29
X$6 \$4 INN OUTP sky130_gnd sky130_fd_pr__nfet_01v8 l=0.5 w=12 as=1.74 ad=3.48
+ ps=12.29 pd=24.58
X$7 VSS VBIAS \$4 sky130_gnd sky130_fd_pr__nfet_01v8 l=1 w=24 as=6.96 ad=6.96
+ ps=48.58 pd=48.58
Cext_1 \$12 \$4 1.33198f
Cext_2 \$12 INP 1.27063f
Cext_3 \$12 OUTP 663.401a
Cext_4 \$12 VDD 5.21862f
Cext_5 \$12 VSS 363.299a
Cext_6 \$12 sky130_gnd 2.71114f
Cext_7 \$4 INN 1.61711f
Cext_8 \$4 INP 1.65308f
Cext_9 \$4 OUTP 1.33189f
Cext_10 \$4 VBIAS 1.5845f
Cext_11 \$4 VDD 0.670206a
Cext_12 \$4 VSS 2.98288f
Cext_13 \$4 sky130_gnd 5.53445f
Cext_14 INN INP 20.3286a
Cext_15 INN OUTP 1.27042f
Cext_16 INN VDD 3.93751a
Cext_17 INN VSS 202.576a
Cext_18 INN sky130_gnd 1.08673f
Cext_19 INP VDD 3.8225a
Cext_20 INP VSS 187.342a
Cext_21 INP sky130_gnd 1.08226f
Cext_22 OUTP VDD 1.56774f
Cext_23 OUTP VSS 360.525a
Cext_24 OUTP sky130_gnd 1.01538f
Cext_25 VBIAS VSS 1.73652f
Cext_26 VBIAS sky130_gnd 1.09347f
Cext_27 VDD VSS 155.032a
Cext_28 VDD sky130_gnd 3.27658f
Cext_29 VSS sky130_gnd 12.9686f
.ENDS ota5t_gui_new_routed
