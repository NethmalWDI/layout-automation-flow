* NGSPICE file created from example_ota_5t_routed_flat.ext - technology: sky130A

.subckt example_ota_5t_routed_flat OUTP INN INP VBIAS VDD VSS nmos_differential_pair__AB_0.net1
+ nmos_differential_pair__AB_0.net3
X0 nmos_differential_pair__AB_0.net1 INP nmos_differential_pair__AB_0.net3 VSS sky130_fd_pr__nfet_01v8 ad=3.48 pd=24.58 as=1.74 ps=12.29 w=12 l=0.5
X1 nmos_differential_pair__AB_0.net1 VBIAS VSS VSS sky130_fd_pr__nfet_01v8 ad=3.48 pd=24.58 as=1.74 ps=12.29 w=12 l=1
X2 OUTP INN nmos_differential_pair__AB_0.net1 VSS sky130_fd_pr__nfet_01v8 ad=1.74 pd=12.29 as=3.48 ps=24.58 w=12 l=0.5
X3 OUTP nmos_differential_pair__AB_0.net3 VDD VDD sky130_fd_pr__pfet_01v8 ad=2.32 pd=16.58 as=2.32 ps=16.58 w=8 l=1
X4 nmos_differential_pair__AB_0.net3 INP nmos_differential_pair__AB_0.net1 VSS sky130_fd_pr__nfet_01v8 ad=1.74 pd=12.29 as=3.48 ps=24.58 w=12 l=0.5
X5 VDD nmos_differential_pair__AB_0.net3 nmos_differential_pair__AB_0.net3 VDD sky130_fd_pr__pfet_01v8 ad=2.32 pd=16.58 as=2.32 ps=16.58 w=8 l=1
X6 nmos_differential_pair__AB_0.net1 INN OUTP VSS sky130_fd_pr__nfet_01v8 ad=3.48 pd=24.58 as=1.74 ps=12.29 w=12 l=0.5
X7 VSS VBIAS nmos_differential_pair__AB_0.net1 VSS sky130_fd_pr__nfet_01v8 ad=1.74 pd=12.29 as=3.48 ps=24.58 w=12 l=1
C0 OUTP INN 1.07477f
C1 INP VDD 0.00625f
C2 nmos_differential_pair__AB_0.net1 VDD 0.00636f
C3 nmos_differential_pair__AB_0.net3 VDD 4.29297f
C4 INN INP 0.46014f
C5 OUTP INP 0.14977f
C6 INN nmos_differential_pair__AB_0.net1 1.25257f
C7 OUTP nmos_differential_pair__AB_0.net1 1.61441f
C8 nmos_differential_pair__AB_0.net3 INN 0.12455f
C9 OUTP nmos_differential_pair__AB_0.net3 2.35121f
C10 INP nmos_differential_pair__AB_0.net1 1.53017f
C11 nmos_differential_pair__AB_0.net3 INP 1.11334f
C12 nmos_differential_pair__AB_0.net3 nmos_differential_pair__AB_0.net1 1.97086f
C13 INN VBIAS 0
C14 OUTP VBIAS 0.04176f
C15 INP VBIAS 0
C16 VBIAS nmos_differential_pair__AB_0.net1 1.75393f
C17 nmos_differential_pair__AB_0.net3 VBIAS 0
C18 INN VDD 0.03878f
C19 OUTP VDD 1.65731f
C20 nmos_differential_pair__AB_0.net1 VSS 10.83932f
C21 OUTP VSS 3.84684f
C22 VDD VSS 16.86477f
.ends
