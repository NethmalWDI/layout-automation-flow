*********************************************************
*** NGSPICE file created by KLayout-PEX 0.6.8
*** -----------------------------------------------------
***     Extraction Engine: KPEX/2.5D
***     Technology: sky130a
***     Date: 2026-11-03 22:33:31
*********************************************************

.SUBCKT example_ota_5t_routed INN INP OUTP VBIAS VDD VSS sky130_gnd
X$1 VDD \$10 \$10 VDD sky130_fd_pr__pfet_01v8 l=1 w=8 as=2.32 ad=2.32 ps=16.58
+ pd=16.58
X$2 VDD \$10 OUTP VDD sky130_fd_pr__pfet_01v8 l=1 w=8 as=2.32 ad=2.32 ps=16.58
+ pd=16.58
X$3 \$10 INP \$11 sky130_gnd sky130_fd_pr__nfet_01v8 l=0.5 w=12 as=3.48 ad=1.74
+ ps=24.58 pd=12.29
X$4 \$11 INP \$10 sky130_gnd sky130_fd_pr__nfet_01v8 l=0.5 w=12 as=1.74 ad=3.48
+ ps=12.29 pd=24.58
X$5 OUTP INN \$11 sky130_gnd sky130_fd_pr__nfet_01v8 l=0.5 w=12 as=3.48 ad=1.74
+ ps=24.58 pd=12.29
X$6 \$11 INN OUTP sky130_gnd sky130_fd_pr__nfet_01v8 l=0.5 w=12 as=1.74 ad=3.48
+ ps=12.29 pd=24.58
X$7 VSS VBIAS \$11 sky130_gnd sky130_fd_pr__nfet_01v8 l=1 w=12 as=3.48 ad=1.74
+ ps=24.58 pd=12.29
X$8 \$11 VBIAS VSS sky130_gnd sky130_fd_pr__nfet_01v8 l=1 w=12 as=1.74 ad=3.48
+ ps=12.29 pd=24.58
Cext_1 \$10 \$11 2.01046f
Cext_2 \$10 INN 113.937a
Cext_3 \$10 INP 1.30625f
Cext_4 \$10 OUTP 2.46143f
Cext_5 \$10 VBIAS 0.121459a
Cext_6 \$10 VDD 4.75415f
Cext_7 \$10 VSS 82.0695a
Cext_8 \$10 sky130_gnd 2.0606f
Cext_9 \$11 INN 1.47447f
Cext_10 \$11 INP 1.72775f
Cext_11 \$11 OUTP 1.66794f
Cext_12 \$11 VBIAS 1.99899f
Cext_13 \$11 VDD 4.84094a
Cext_14 \$11 VSS 2.84172f
Cext_15 \$11 sky130_gnd 5.14184f
Cext_16 INN INP 526.644a
Cext_17 INN OUTP 1.27093f
Cext_18 INN VDD 48.0536a
Cext_19 INN VSS 84.1021a
Cext_20 INN sky130_gnd 962.09a
Cext_21 INP OUTP 167.939a
Cext_22 INP VDD 6.13555a
Cext_23 INP VSS 60.5986a
Cext_24 INP sky130_gnd 701.924a
Cext_25 OUTP VBIAS 40.6396a
Cext_26 OUTP VDD 1.67497f
Cext_27 OUTP VSS 167.132a
Cext_28 OUTP sky130_gnd 1.34225f
Cext_29 VBIAS VSS 2.6357f
Cext_30 VBIAS sky130_gnd 1.09354f
Cext_31 VDD VSS 31.0057a
Cext_32 VDD sky130_gnd 1.5297f
Cext_33 VSS sky130_gnd 7.3647f
.ENDS example_ota_5t_routed
