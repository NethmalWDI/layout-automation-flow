* NGSPICE file created from example_ota_5t_routed_flat.ext - technology: sky130A

.subckt example_ota_5t_routed_flat OUTP INN INP VBIAS VDD VSS nmos_differential_pair__AB_0.net1
+ nmos_differential_pair__AB_0.net3
X0 nmos_differential_pair__AB_0.net1 INP nmos_differential_pair__AB_0.net3 VSS sky130_fd_pr__nfet_01v8 ad=3.48 pd=24.58 as=1.74 ps=12.29 w=12 l=0.5
X1 nmos_differential_pair__AB_0.net1 VBIAS VSS VSS sky130_fd_pr__nfet_01v8 ad=3.48 pd=24.58 as=1.74 ps=12.29 w=12 l=1
X2 OUTP INN nmos_differential_pair__AB_0.net1 VSS sky130_fd_pr__nfet_01v8 ad=1.74 pd=12.29 as=3.48 ps=24.58 w=12 l=0.5
X3 OUTP nmos_differential_pair__AB_0.net3 VDD VDD sky130_fd_pr__pfet_01v8 ad=2.32 pd=16.58 as=2.32 ps=16.58 w=8 l=1
X4 nmos_differential_pair__AB_0.net3 INP nmos_differential_pair__AB_0.net1 VSS sky130_fd_pr__nfet_01v8 ad=1.74 pd=12.29 as=3.48 ps=24.58 w=12 l=0.5
X5 VDD nmos_differential_pair__AB_0.net3 nmos_differential_pair__AB_0.net3 VDD sky130_fd_pr__pfet_01v8 ad=2.32 pd=16.58 as=2.32 ps=16.58 w=8 l=1
X6 nmos_differential_pair__AB_0.net1 INN OUTP VSS sky130_fd_pr__nfet_01v8 ad=3.48 pd=24.58 as=1.74 ps=12.29 w=12 l=0.5
X7 VSS VBIAS nmos_differential_pair__AB_0.net1 VSS sky130_fd_pr__nfet_01v8 ad=1.74 pd=12.29 as=3.48 ps=24.58 w=12 l=1
.ends
