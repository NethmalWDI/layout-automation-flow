* NGSPICE file created from example_ota_5t_routed_flat.ext - technology: sky130A

.subckt example_ota_5t_routed_flat OUTP INN INP VBIAS VDD VSS nmos_differential_pair__AB_0.net1
+ nmos_differential_pair__AB_0.net3
X0 nmos_differential_pair__AB_0.net3 INP nmos_differential_pair__AB_0.net1 VSS sky130_fd_pr__nfet_01v8 ad=1.74 pd=12.29 as=3.48 ps=24.58 w=12 l=0.5
X1 nmos_differential_pair__AB_0.net1 VBIAS VSS VSS sky130_fd_pr__nfet_01v8 ad=3.48 pd=24.58 as=1.74 ps=12.29 w=12 l=1
X2 nmos_differential_pair__AB_0.net1 INN OUTP VSS sky130_fd_pr__nfet_01v8 ad=3.48 pd=24.58 as=1.74 ps=12.29 w=12 l=0.5
X3 OUTP nmos_differential_pair__AB_0.net3 VDD VDD sky130_fd_pr__pfet_01v8 ad=2.32 pd=16.58 as=2.32 ps=16.58 w=8 l=1
X4 VSS VBIAS nmos_differential_pair__AB_0.net1 VSS sky130_fd_pr__nfet_01v8 ad=1.74 pd=12.29 as=3.48 ps=24.58 w=12 l=1
X5 VDD nmos_differential_pair__AB_0.net3 nmos_differential_pair__AB_0.net3 VDD sky130_fd_pr__pfet_01v8 ad=2.32 pd=16.58 as=2.32 ps=16.58 w=8 l=1
X6 nmos_differential_pair__AB_0.net1 INP nmos_differential_pair__AB_0.net3 VSS sky130_fd_pr__nfet_01v8 ad=3.48 pd=24.58 as=1.74 ps=12.29 w=12 l=0.5
X7 OUTP INN nmos_differential_pair__AB_0.net1 VSS sky130_fd_pr__nfet_01v8 ad=1.74 pd=12.29 as=3.48 ps=24.58 w=12 l=0.5
C0 INN VBIAS 0
C1 INP VBIAS 0
C2 VBIAS nmos_differential_pair__AB_0.net1 1.5273f
C3 INN VDD 0
C4 OUTP VDD 1.68612f
C5 OUTP INN 0.93034f
C6 INP VDD 0
C7 nmos_differential_pair__AB_0.net1 VDD 0.0019f
C8 nmos_differential_pair__AB_0.net3 VDD 4.05456f
C9 INN INP 0.47605f
C10 OUTP INP 0.00796f
C11 INN nmos_differential_pair__AB_0.net1 1.30522f
C12 OUTP nmos_differential_pair__AB_0.net1 1.30933f
C13 nmos_differential_pair__AB_0.net3 INN 0.0477f
C14 OUTP nmos_differential_pair__AB_0.net3 1.47689f
C15 INP nmos_differential_pair__AB_0.net1 1.60906f
C16 nmos_differential_pair__AB_0.net3 INP 0.98202f
C17 nmos_differential_pair__AB_0.net3 nmos_differential_pair__AB_0.net1 1.34113f
C18 nmos_differential_pair__AB_0.net1 VSS 9.7015f
C19 OUTP VSS 3.26809f
C20 VDD VSS 16.71247f
.ends
