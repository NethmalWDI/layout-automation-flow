* NGSPICE file created from XC3__A_flat.ext - technology: sky130A

.subckt XC3__A_flat op cmc
X0 op cmc sky130_fd_pr__cap_mim_m3_1 l=4.8 w=4.8
X1 op cmc sky130_fd_pr__cap_mim_m3_1 l=4.8 w=4.8
X2 op cmc sky130_fd_pr__cap_mim_m3_1 l=4.8 w=4.8
X3 op cmc sky130_fd_pr__cap_mim_m3_1 l=4.8 w=4.8
C0 op cmc 10.4049f
C1 cmc VSUBS 10.90631f
.ends
