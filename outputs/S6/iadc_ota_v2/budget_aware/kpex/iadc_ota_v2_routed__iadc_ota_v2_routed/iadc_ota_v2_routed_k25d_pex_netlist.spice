*********************************************************
*** NGSPICE file created by KLayout-PEX 0.6.8
*** -----------------------------------------------------
***     Extraction Engine: KPEX/2.5D
***     Technology: sky130a
***     Date: 2026-11-05 20:02:57
*********************************************************

.SUBCKT iadc_ota_v2_routed \$11.x1_net1 \$11.x1_net10 \$11.x1_net11
+ \$11.x1_net12 \$11.x1_net13 \$11.x1_net14 \$11.x1_net15 \$11.x1_net2
+ \$11.x1_net3 \$11.x1_net4 \$11.x1_net5 \$11.x1_net6 \$11.x1_net7 \$11.x1_net8
+ \$11.x1_net9 IBIAS VDD VSS bias_a cm cmc in ip on op sky130_gnd
X$9 \$150 \$168 \$168 sky130_gnd sky130_fd_pr__nfet_01v8_lvt l=0.6 w=1.4
+ as=0.406 ad=0.406 ps=3.38 pd=3.38
X$10 \$150 \$168 \$168 sky130_gnd sky130_fd_pr__nfet_01v8_lvt l=0.6 w=1.4
+ as=0.406 ad=0.406 ps=3.38 pd=3.38
X$11 \$150 \$168 \$168 sky130_gnd sky130_fd_pr__nfet_01v8_lvt l=0.6 w=1.4
+ as=0.406 ad=0.406 ps=3.38 pd=3.38
X$12 \$150 \$168 \$168 sky130_gnd sky130_fd_pr__nfet_01v8_lvt l=0.6 w=1.4
+ as=0.406 ad=0.406 ps=3.38 pd=3.38
X$13 \$150 \$168 \$168 sky130_gnd sky130_fd_pr__nfet_01v8_lvt l=0.6 w=1.4
+ as=0.406 ad=0.406 ps=3.38 pd=3.38
X$14 \$150 \$168 \$168 sky130_gnd sky130_fd_pr__nfet_01v8_lvt l=0.6 w=1.4
+ as=0.406 ad=0.406 ps=3.38 pd=3.38
X$15 \$150 \$168 \$168 sky130_gnd sky130_fd_pr__nfet_01v8_lvt l=0.6 w=1.4
+ as=0.406 ad=0.406 ps=3.38 pd=3.38
X$16 \$150 \$168 \$168 sky130_gnd sky130_fd_pr__nfet_01v8_lvt l=0.6 w=1.4
+ as=0.406 ad=0.406 ps=3.38 pd=3.38
X$17 \$150 \$168 \$168 sky130_gnd sky130_fd_pr__nfet_01v8_lvt l=0.6 w=1.4
+ as=0.406 ad=0.406 ps=3.38 pd=3.38
X$18 \$150 \$168 \$168 sky130_gnd sky130_fd_pr__nfet_01v8_lvt l=0.6 w=1.4
+ as=0.406 ad=0.406 ps=3.38 pd=3.38
X$19 \$150 \$168 \$168 sky130_gnd sky130_fd_pr__nfet_01v8_lvt l=0.6 w=1.4
+ as=0.406 ad=0.406 ps=3.38 pd=3.38
X$20 \$150 \$168 \$168 sky130_gnd sky130_fd_pr__nfet_01v8_lvt l=0.6 w=1.4
+ as=0.406 ad=0.406 ps=3.38 pd=3.38
X$21 \$150 \$168 \$168 sky130_gnd sky130_fd_pr__nfet_01v8_lvt l=0.6 w=1.4
+ as=0.406 ad=0.406 ps=3.38 pd=3.38
X$22 \$150 \$168 \$168 sky130_gnd sky130_fd_pr__nfet_01v8_lvt l=0.6 w=1.4
+ as=0.406 ad=0.406 ps=3.38 pd=3.38
X$23 \$150 \$168 \$168 sky130_gnd sky130_fd_pr__nfet_01v8_lvt l=0.6 w=1.4
+ as=0.406 ad=0.406 ps=3.38 pd=3.38
X$24 \$150 \$168 \$168 sky130_gnd sky130_fd_pr__nfet_01v8_lvt l=0.6 w=1.4
+ as=0.406 ad=0.406 ps=3.38 pd=3.38
X$25 \$150 \$168 \$168 sky130_gnd sky130_fd_pr__nfet_01v8_lvt l=0.6 w=1.4
+ as=0.406 ad=0.406 ps=3.38 pd=3.38
X$26 \$150 \$168 \$168 sky130_gnd sky130_fd_pr__nfet_01v8_lvt l=0.6 w=1.4
+ as=0.406 ad=0.406 ps=3.38 pd=3.38
X$27 \$150 \$168 \$168 sky130_gnd sky130_fd_pr__nfet_01v8_lvt l=0.6 w=1.4
+ as=0.406 ad=0.406 ps=3.38 pd=3.38
X$28 \$150 \$168 \$168 sky130_gnd sky130_fd_pr__nfet_01v8_lvt l=0.6 w=1.4
+ as=0.406 ad=0.406 ps=3.38 pd=3.38
X$29 \$150 \$168 \$168 sky130_gnd sky130_fd_pr__nfet_01v8_lvt l=0.6 w=1.4
+ as=0.406 ad=0.406 ps=3.38 pd=3.38
X$30 \$150 \$168 \$168 sky130_gnd sky130_fd_pr__nfet_01v8_lvt l=0.6 w=1.4
+ as=0.406 ad=0.406 ps=3.38 pd=3.38
X$31 \$150 \$168 \$168 sky130_gnd sky130_fd_pr__nfet_01v8_lvt l=0.6 w=1.4
+ as=0.406 ad=0.406 ps=3.38 pd=3.38
X$32 \$150 \$168 \$168 sky130_gnd sky130_fd_pr__nfet_01v8_lvt l=0.6 w=1.4
+ as=0.406 ad=0.406 ps=3.38 pd=3.38
X$33 \$150 \$168 \$168 sky130_gnd sky130_fd_pr__nfet_01v8_lvt l=0.6 w=1.4
+ as=0.406 ad=0.406 ps=3.38 pd=3.38
X$34 \$150 \$168 \$168 sky130_gnd sky130_fd_pr__nfet_01v8_lvt l=0.6 w=1.4
+ as=0.406 ad=0.406 ps=3.38 pd=3.38
X$35 \$150 \$168 \$168 sky130_gnd sky130_fd_pr__nfet_01v8_lvt l=0.6 w=1.4
+ as=0.406 ad=0.406 ps=3.38 pd=3.38
X$36 \$150 \$168 \$168 sky130_gnd sky130_fd_pr__nfet_01v8_lvt l=0.6 w=1.4
+ as=0.406 ad=0.406 ps=3.38 pd=3.38
X$37 \$150 \$168 \$168 sky130_gnd sky130_fd_pr__nfet_01v8_lvt l=0.6 w=1.4
+ as=0.406 ad=0.406 ps=3.38 pd=3.38
X$38 \$150 \$168 \$168 sky130_gnd sky130_fd_pr__nfet_01v8_lvt l=0.6 w=1.4
+ as=0.406 ad=0.406 ps=3.38 pd=3.38
X$39 \$150 \$168 \$168 sky130_gnd sky130_fd_pr__nfet_01v8_lvt l=0.6 w=1.4
+ as=0.406 ad=0.406 ps=3.38 pd=3.38
X$40 \$150 \$168 \$168 sky130_gnd sky130_fd_pr__nfet_01v8_lvt l=0.6 w=1.4
+ as=0.406 ad=0.406 ps=3.38 pd=3.38
X$41 \$150 \$168 \$168 sky130_gnd sky130_fd_pr__nfet_01v8_lvt l=0.6 w=1.4
+ as=0.406 ad=0.406 ps=3.38 pd=3.38
X$42 \$150 \$168 \$168 sky130_gnd sky130_fd_pr__nfet_01v8_lvt l=0.6 w=1.4
+ as=0.406 ad=0.406 ps=3.38 pd=3.38
X$43 \$150 \$168 \$168 sky130_gnd sky130_fd_pr__nfet_01v8_lvt l=0.6 w=1.4
+ as=0.406 ad=0.406 ps=3.38 pd=3.38
X$44 \$150 \$168 \$168 sky130_gnd sky130_fd_pr__nfet_01v8_lvt l=0.6 w=1.4
+ as=0.406 ad=0.406 ps=3.38 pd=3.38
X$45 \$150 \$168 \$168 sky130_gnd sky130_fd_pr__nfet_01v8_lvt l=0.6 w=1.4
+ as=0.406 ad=0.406 ps=3.38 pd=3.38
X$46 \$150 \$168 \$168 sky130_gnd sky130_fd_pr__nfet_01v8_lvt l=0.6 w=1.4
+ as=0.406 ad=0.406 ps=3.38 pd=3.38
X$47 \$150 \$168 \$168 sky130_gnd sky130_fd_pr__nfet_01v8_lvt l=0.6 w=1.4
+ as=0.406 ad=0.406 ps=3.38 pd=3.38
X$48 \$150 \$168 \$168 sky130_gnd sky130_fd_pr__nfet_01v8_lvt l=0.6 w=1.4
+ as=0.406 ad=0.406 ps=3.38 pd=3.38
X$49 \$150 \$168 \$168 sky130_gnd sky130_fd_pr__nfet_01v8_lvt l=0.6 w=1.4
+ as=0.406 ad=0.406 ps=3.38 pd=3.38
X$50 \$150 \$168 \$168 sky130_gnd sky130_fd_pr__nfet_01v8_lvt l=0.6 w=1.4
+ as=0.406 ad=0.406 ps=3.38 pd=3.38
X$51 \$150 \$168 \$168 sky130_gnd sky130_fd_pr__nfet_01v8_lvt l=0.6 w=1.4
+ as=0.406 ad=0.406 ps=3.38 pd=3.38
X$52 \$150 \$168 \$168 sky130_gnd sky130_fd_pr__nfet_01v8_lvt l=0.6 w=1.4
+ as=0.406 ad=0.406 ps=3.38 pd=3.38
X$53 \$150 \$168 \$168 sky130_gnd sky130_fd_pr__nfet_01v8_lvt l=0.6 w=1.4
+ as=0.406 ad=0.406 ps=3.38 pd=3.38
X$54 \$150 \$168 \$168 sky130_gnd sky130_fd_pr__nfet_01v8_lvt l=0.6 w=1.4
+ as=0.406 ad=0.406 ps=3.38 pd=3.38
X$55 \$150 \$168 \$168 sky130_gnd sky130_fd_pr__nfet_01v8_lvt l=0.6 w=1.4
+ as=0.406 ad=0.406 ps=3.38 pd=3.38
X$56 \$150 \$168 \$168 sky130_gnd sky130_fd_pr__nfet_01v8_lvt l=0.6 w=1.4
+ as=0.406 ad=0.406 ps=3.38 pd=3.38
X$57 \$150 \$168 \$168 sky130_gnd sky130_fd_pr__nfet_01v8_lvt l=0.6 w=1.4
+ as=0.406 ad=0.406 ps=3.38 pd=3.38
X$58 \$150 \$168 \$168 sky130_gnd sky130_fd_pr__nfet_01v8_lvt l=0.6 w=1.4
+ as=0.406 ad=0.406 ps=3.38 pd=3.38
X$59 \$150 \$168 \$168 sky130_gnd sky130_fd_pr__nfet_01v8_lvt l=0.6 w=1.4
+ as=0.406 ad=0.406 ps=3.38 pd=3.38
X$60 \$150 \$168 \$168 sky130_gnd sky130_fd_pr__nfet_01v8_lvt l=0.6 w=1.4
+ as=0.406 ad=0.406 ps=3.38 pd=3.38
X$61 \$150 \$168 \$168 sky130_gnd sky130_fd_pr__nfet_01v8_lvt l=0.6 w=1.4
+ as=0.406 ad=0.406 ps=3.38 pd=3.38
X$62 \$150 \$168 \$168 sky130_gnd sky130_fd_pr__nfet_01v8_lvt l=0.6 w=1.4
+ as=0.406 ad=0.406 ps=3.38 pd=3.38
X$63 \$150 \$168 \$168 sky130_gnd sky130_fd_pr__nfet_01v8_lvt l=0.6 w=1.4
+ as=0.406 ad=0.406 ps=3.38 pd=3.38
X$64 \$150 \$168 \$168 sky130_gnd sky130_fd_pr__nfet_01v8_lvt l=0.6 w=1.4
+ as=0.406 ad=0.406 ps=3.38 pd=3.38
X$65 \$168 \$168 \$168 sky130_gnd sky130_fd_pr__nfet_01v8_lvt l=0.6 w=1.4
+ as=0.406 ad=0.406 ps=3.38 pd=3.38
X$66 \$168 \$168 \$168 sky130_gnd sky130_fd_pr__nfet_01v8_lvt l=0.6 w=1.4
+ as=0.406 ad=0.406 ps=3.38 pd=3.38
X$67 \$168 \$168 \$168 sky130_gnd sky130_fd_pr__nfet_01v8_lvt l=0.6 w=1.4
+ as=0.406 ad=0.406 ps=3.38 pd=3.38
X$68 \$168 \$168 \$168 sky130_gnd sky130_fd_pr__nfet_01v8_lvt l=0.6 w=1.4
+ as=0.406 ad=0.406 ps=3.38 pd=3.38
X$69 \$168 \$168 \$168 sky130_gnd sky130_fd_pr__nfet_01v8_lvt l=0.6 w=1.4
+ as=0.406 ad=0.406 ps=3.38 pd=3.38
X$70 \$168 \$168 \$168 sky130_gnd sky130_fd_pr__nfet_01v8_lvt l=0.6 w=1.4
+ as=0.406 ad=0.406 ps=3.38 pd=3.38
X$71 \$168 \$168 \$168 sky130_gnd sky130_fd_pr__nfet_01v8_lvt l=0.6 w=1.4
+ as=0.406 ad=0.406 ps=3.38 pd=3.38
X$72 \$168 \$168 \$168 sky130_gnd sky130_fd_pr__nfet_01v8_lvt l=0.6 w=1.4
+ as=0.406 ad=0.406 ps=3.38 pd=3.38
X$73 \$150 \$150 \$150 sky130_gnd sky130_fd_pr__nfet_01v8_lvt l=0.6 w=1.4
+ as=0.406 ad=0.406 ps=3.38 pd=3.38
X$74 \$150 \$150 \$150 sky130_gnd sky130_fd_pr__nfet_01v8_lvt l=0.6 w=1.4
+ as=0.406 ad=0.406 ps=3.38 pd=3.38
X$75 \$150 \$150 \$150 sky130_gnd sky130_fd_pr__nfet_01v8_lvt l=0.6 w=1.4
+ as=0.406 ad=0.406 ps=3.38 pd=3.38
X$76 \$150 \$150 \$150 sky130_gnd sky130_fd_pr__nfet_01v8_lvt l=0.6 w=1.4
+ as=0.406 ad=0.406 ps=3.38 pd=3.38
X$77 \$150 \$150 \$150 sky130_gnd sky130_fd_pr__nfet_01v8_lvt l=0.6 w=1.4
+ as=0.406 ad=0.406 ps=3.38 pd=3.38
X$78 \$150 \$150 \$150 sky130_gnd sky130_fd_pr__nfet_01v8_lvt l=0.6 w=1.4
+ as=0.406 ad=0.406 ps=3.38 pd=3.38
X$79 \$150 \$150 \$150 sky130_gnd sky130_fd_pr__nfet_01v8_lvt l=0.6 w=1.4
+ as=0.406 ad=0.406 ps=3.38 pd=3.38
X$80 \$150 \$150 \$150 sky130_gnd sky130_fd_pr__nfet_01v8_lvt l=0.6 w=1.4
+ as=0.406 ad=0.406 ps=3.38 pd=3.38
X$81 \$157 in \$203 sky130_gnd sky130_fd_pr__nfet_01v8_lvt l=0.2 w=1.2 as=0.348
+ ad=0.348 ps=2.98 pd=2.98
X$82 \$157 in \$203 sky130_gnd sky130_fd_pr__nfet_01v8_lvt l=0.2 w=1.2 as=0.348
+ ad=0.348 ps=2.98 pd=2.98
X$83 \$157 in \$203 sky130_gnd sky130_fd_pr__nfet_01v8_lvt l=0.2 w=1.2 as=0.348
+ ad=0.348 ps=2.98 pd=2.98
X$84 \$157 in \$203 sky130_gnd sky130_fd_pr__nfet_01v8_lvt l=0.2 w=1.2 as=0.348
+ ad=0.348 ps=2.98 pd=2.98
X$85 \$157 in \$203 sky130_gnd sky130_fd_pr__nfet_01v8_lvt l=0.2 w=1.2 as=0.348
+ ad=0.348 ps=2.98 pd=2.98
X$86 \$157 in \$203 sky130_gnd sky130_fd_pr__nfet_01v8_lvt l=0.2 w=1.2 as=0.348
+ ad=0.348 ps=2.98 pd=2.98
X$87 \$157 ip \$202 sky130_gnd sky130_fd_pr__nfet_01v8_lvt l=0.2 w=1.2 as=0.348
+ ad=0.348 ps=2.98 pd=2.98
X$88 \$157 ip \$202 sky130_gnd sky130_fd_pr__nfet_01v8_lvt l=0.2 w=1.2 as=0.348
+ ad=0.348 ps=2.98 pd=2.98
X$89 \$157 ip \$202 sky130_gnd sky130_fd_pr__nfet_01v8_lvt l=0.2 w=1.2 as=0.348
+ ad=0.348 ps=2.98 pd=2.98
X$90 \$157 ip \$202 sky130_gnd sky130_fd_pr__nfet_01v8_lvt l=0.2 w=1.2 as=0.348
+ ad=0.348 ps=2.98 pd=2.98
X$91 \$157 ip \$202 sky130_gnd sky130_fd_pr__nfet_01v8_lvt l=0.2 w=1.2 as=0.348
+ ad=0.348 ps=2.98 pd=2.98
X$92 \$157 ip \$202 sky130_gnd sky130_fd_pr__nfet_01v8_lvt l=0.2 w=1.2 as=0.348
+ ad=0.348 ps=2.98 pd=2.98
X$93 \$203 \$203 \$203 sky130_gnd sky130_fd_pr__nfet_01v8_lvt l=0.2 w=1.2
+ as=0.348 ad=0.348 ps=2.98 pd=2.98
X$94 \$203 \$203 \$203 sky130_gnd sky130_fd_pr__nfet_01v8_lvt l=0.2 w=1.2
+ as=0.348 ad=0.348 ps=2.98 pd=2.98
X$95 \$202 \$202 \$202 sky130_gnd sky130_fd_pr__nfet_01v8_lvt l=0.2 w=1.2
+ as=0.348 ad=0.348 ps=2.98 pd=2.98
X$96 \$202 \$202 \$202 sky130_gnd sky130_fd_pr__nfet_01v8_lvt l=0.2 w=1.2
+ as=0.348 ad=0.348 ps=2.98 pd=2.98
X$97 VDD VDD on VDD sky130_fd_pr__pfet_01v8 l=0.6 w=1.4 as=0.406 ad=0.406
+ ps=3.38 pd=3.38
X$98 VDD VDD on VDD sky130_fd_pr__pfet_01v8 l=0.6 w=1.4 as=0.406 ad=0.406
+ ps=3.38 pd=3.38
X$99 VDD VDD op VDD sky130_fd_pr__pfet_01v8 l=0.6 w=1.4 as=0.406 ad=0.406
+ ps=3.38 pd=3.38
X$100 VDD VDD op VDD sky130_fd_pr__pfet_01v8 l=0.6 w=1.4 as=0.406 ad=0.406
+ ps=3.38 pd=3.38
X$101 VDD VDD on VDD sky130_fd_pr__pfet_01v8 l=0.6 w=1.4 as=0.406 ad=0.406
+ ps=3.38 pd=3.38
X$102 VDD VDD on VDD sky130_fd_pr__pfet_01v8 l=0.6 w=1.4 as=0.406 ad=0.406
+ ps=3.38 pd=3.38
X$103 VDD VDD op VDD sky130_fd_pr__pfet_01v8 l=0.6 w=1.4 as=0.406 ad=0.406
+ ps=3.38 pd=3.38
X$104 VDD VDD op VDD sky130_fd_pr__pfet_01v8 l=0.6 w=1.4 as=0.406 ad=0.406
+ ps=3.38 pd=3.38
X$105 VDD \$168 \$278 VDD sky130_fd_pr__pfet_01v8_lvt l=0.6 w=1.4 as=0.406
+ ad=0.406 ps=3.38 pd=3.38
X$106 VDD \$168 \$279 VDD sky130_fd_pr__pfet_01v8_lvt l=0.6 w=1.4 as=0.406
+ ad=0.406 ps=3.38 pd=3.38
X$107 VDD \$168 \$279 VDD sky130_fd_pr__pfet_01v8_lvt l=0.6 w=1.4 as=0.406
+ ad=0.406 ps=3.38 pd=3.38
X$108 VDD \$168 \$271 VDD sky130_fd_pr__pfet_01v8_lvt l=0.6 w=1.4 as=0.406
+ ad=0.406 ps=3.38 pd=3.38
X$109 VDD \$168 \$271 VDD sky130_fd_pr__pfet_01v8_lvt l=0.6 w=1.4 as=0.406
+ ad=0.406 ps=3.38 pd=3.38
X$110 VDD \$168 \$279 VDD sky130_fd_pr__pfet_01v8_lvt l=0.6 w=1.4 as=0.406
+ ad=0.406 ps=3.38 pd=3.38
X$111 VDD \$168 \$271 VDD sky130_fd_pr__pfet_01v8_lvt l=0.6 w=1.4 as=0.406
+ ad=0.406 ps=3.38 pd=3.38
X$112 VDD \$168 \$278 VDD sky130_fd_pr__pfet_01v8_lvt l=0.6 w=1.4 as=0.406
+ ad=0.406 ps=3.38 pd=3.38
X$113 VDD \$168 \$278 VDD sky130_fd_pr__pfet_01v8_lvt l=0.6 w=1.4 as=0.406
+ ad=0.406 ps=3.38 pd=3.38
X$114 VDD \$168 \$271 VDD sky130_fd_pr__pfet_01v8_lvt l=0.6 w=1.4 as=0.406
+ ad=0.406 ps=3.38 pd=3.38
X$115 VDD \$168 \$278 VDD sky130_fd_pr__pfet_01v8_lvt l=0.6 w=1.4 as=0.406
+ ad=0.406 ps=3.38 pd=3.38
X$116 VDD \$168 \$271 VDD sky130_fd_pr__pfet_01v8_lvt l=0.6 w=1.4 as=0.406
+ ad=0.406 ps=3.38 pd=3.38
X$117 VDD \$168 \$279 VDD sky130_fd_pr__pfet_01v8_lvt l=0.6 w=1.4 as=0.406
+ ad=0.406 ps=3.38 pd=3.38
X$118 VDD \$168 \$279 VDD sky130_fd_pr__pfet_01v8_lvt l=0.6 w=1.4 as=0.406
+ ad=0.406 ps=3.38 pd=3.38
X$119 VDD \$168 \$271 VDD sky130_fd_pr__pfet_01v8_lvt l=0.6 w=1.4 as=0.406
+ ad=0.406 ps=3.38 pd=3.38
X$120 VDD \$168 \$278 VDD sky130_fd_pr__pfet_01v8_lvt l=0.6 w=1.4 as=0.406
+ ad=0.406 ps=3.38 pd=3.38
X$121 VDD \$168 \$279 VDD sky130_fd_pr__pfet_01v8_lvt l=0.6 w=1.4 as=0.406
+ ad=0.406 ps=3.38 pd=3.38
X$122 VDD \$168 \$278 VDD sky130_fd_pr__pfet_01v8_lvt l=0.6 w=1.4 as=0.406
+ ad=0.406 ps=3.38 pd=3.38
X$123 VDD \$168 \$202 VDD sky130_fd_pr__pfet_01v8_lvt l=0.6 w=1.4 as=0.406
+ ad=0.406 ps=3.38 pd=3.38
X$124 VDD \$168 \$202 VDD sky130_fd_pr__pfet_01v8_lvt l=0.6 w=1.4 as=0.406
+ ad=0.406 ps=3.38 pd=3.38
X$125 VDD \$168 \$203 VDD sky130_fd_pr__pfet_01v8_lvt l=0.6 w=1.4 as=0.406
+ ad=0.406 ps=3.38 pd=3.38
X$126 VDD \$168 \$202 VDD sky130_fd_pr__pfet_01v8_lvt l=0.6 w=1.4 as=0.406
+ ad=0.406 ps=3.38 pd=3.38
X$127 VDD \$168 \$203 VDD sky130_fd_pr__pfet_01v8_lvt l=0.6 w=1.4 as=0.406
+ ad=0.406 ps=3.38 pd=3.38
X$128 VDD \$168 \$203 VDD sky130_fd_pr__pfet_01v8_lvt l=0.6 w=1.4 as=0.406
+ ad=0.406 ps=3.38 pd=3.38
X$129 VDD \$168 \$202 VDD sky130_fd_pr__pfet_01v8_lvt l=0.6 w=1.4 as=0.406
+ ad=0.406 ps=3.38 pd=3.38
X$130 VDD \$168 \$203 VDD sky130_fd_pr__pfet_01v8_lvt l=0.6 w=1.4 as=0.406
+ ad=0.406 ps=3.38 pd=3.38
X$131 VDD \$168 \$202 VDD sky130_fd_pr__pfet_01v8_lvt l=0.6 w=1.4 as=0.406
+ ad=0.406 ps=3.38 pd=3.38
X$132 VDD \$168 \$203 VDD sky130_fd_pr__pfet_01v8_lvt l=0.6 w=1.4 as=0.406
+ ad=0.406 ps=3.38 pd=3.38
X$133 VDD \$168 \$202 VDD sky130_fd_pr__pfet_01v8_lvt l=0.6 w=1.4 as=0.406
+ ad=0.406 ps=3.38 pd=3.38
X$134 VDD \$168 \$203 VDD sky130_fd_pr__pfet_01v8_lvt l=0.6 w=1.4 as=0.406
+ ad=0.406 ps=3.38 pd=3.38
X$135 VDD \$168 \$202 VDD sky130_fd_pr__pfet_01v8_lvt l=0.6 w=1.4 as=0.406
+ ad=0.406 ps=3.38 pd=3.38
X$136 VDD \$168 \$202 VDD sky130_fd_pr__pfet_01v8_lvt l=0.6 w=1.4 as=0.406
+ ad=0.406 ps=3.38 pd=3.38
X$137 VDD \$168 \$203 VDD sky130_fd_pr__pfet_01v8_lvt l=0.6 w=1.4 as=0.406
+ ad=0.406 ps=3.38 pd=3.38
X$138 VDD \$168 \$202 VDD sky130_fd_pr__pfet_01v8_lvt l=0.6 w=1.4 as=0.406
+ ad=0.406 ps=3.38 pd=3.38
X$139 VDD \$168 \$202 VDD sky130_fd_pr__pfet_01v8_lvt l=0.6 w=1.4 as=0.406
+ ad=0.406 ps=3.38 pd=3.38
X$140 VDD \$168 \$203 VDD sky130_fd_pr__pfet_01v8_lvt l=0.6 w=1.4 as=0.406
+ ad=0.406 ps=3.38 pd=3.38
X$141 VDD \$168 \$202 VDD sky130_fd_pr__pfet_01v8_lvt l=0.6 w=1.4 as=0.406
+ ad=0.406 ps=3.38 pd=3.38
X$142 VDD \$168 \$203 VDD sky130_fd_pr__pfet_01v8_lvt l=0.6 w=1.4 as=0.406
+ ad=0.406 ps=3.38 pd=3.38
X$143 VDD \$168 \$203 VDD sky130_fd_pr__pfet_01v8_lvt l=0.6 w=1.4 as=0.406
+ ad=0.406 ps=3.38 pd=3.38
X$144 VDD \$168 \$203 VDD sky130_fd_pr__pfet_01v8_lvt l=0.6 w=1.4 as=0.406
+ ad=0.406 ps=3.38 pd=3.38
X$145 VDD \$168 \$203 VDD sky130_fd_pr__pfet_01v8_lvt l=0.6 w=1.4 as=0.406
+ ad=0.406 ps=3.38 pd=3.38
X$146 VDD \$168 \$202 VDD sky130_fd_pr__pfet_01v8_lvt l=0.6 w=1.4 as=0.406
+ ad=0.406 ps=3.38 pd=3.38
X$147 VDD \$168 \$202 VDD sky130_fd_pr__pfet_01v8_lvt l=0.6 w=1.4 as=0.406
+ ad=0.406 ps=3.38 pd=3.38
X$148 VDD \$168 \$203 VDD sky130_fd_pr__pfet_01v8_lvt l=0.6 w=1.4 as=0.406
+ ad=0.406 ps=3.38 pd=3.38
X$149 VDD \$168 \$203 VDD sky130_fd_pr__pfet_01v8_lvt l=0.6 w=1.4 as=0.406
+ ad=0.406 ps=3.38 pd=3.38
X$150 VDD \$168 \$203 VDD sky130_fd_pr__pfet_01v8_lvt l=0.6 w=1.4 as=0.406
+ ad=0.406 ps=3.38 pd=3.38
X$151 VDD \$168 \$202 VDD sky130_fd_pr__pfet_01v8_lvt l=0.6 w=1.4 as=0.406
+ ad=0.406 ps=3.38 pd=3.38
X$152 VDD \$168 \$203 VDD sky130_fd_pr__pfet_01v8_lvt l=0.6 w=1.4 as=0.406
+ ad=0.406 ps=3.38 pd=3.38
X$153 VDD \$168 \$202 VDD sky130_fd_pr__pfet_01v8_lvt l=0.6 w=1.4 as=0.406
+ ad=0.406 ps=3.38 pd=3.38
X$154 VDD \$168 \$202 VDD sky130_fd_pr__pfet_01v8_lvt l=0.6 w=1.4 as=0.406
+ ad=0.406 ps=3.38 pd=3.38
X$155 VDD \$168 \$203 VDD sky130_fd_pr__pfet_01v8_lvt l=0.6 w=1.4 as=0.406
+ ad=0.406 ps=3.38 pd=3.38
X$156 VDD \$168 \$202 VDD sky130_fd_pr__pfet_01v8_lvt l=0.6 w=1.4 as=0.406
+ ad=0.406 ps=3.38 pd=3.38
X$157 VDD \$168 \$203 VDD sky130_fd_pr__pfet_01v8_lvt l=0.6 w=1.4 as=0.406
+ ad=0.406 ps=3.38 pd=3.38
X$158 VDD \$168 \$202 VDD sky130_fd_pr__pfet_01v8_lvt l=0.6 w=1.4 as=0.406
+ ad=0.406 ps=3.38 pd=3.38
X$159 VDD \$168 \$203 VDD sky130_fd_pr__pfet_01v8_lvt l=0.6 w=1.4 as=0.406
+ ad=0.406 ps=3.38 pd=3.38
X$160 VDD \$168 \$203 VDD sky130_fd_pr__pfet_01v8_lvt l=0.6 w=1.4 as=0.406
+ ad=0.406 ps=3.38 pd=3.38
X$161 VDD \$168 \$202 VDD sky130_fd_pr__pfet_01v8_lvt l=0.6 w=1.4 as=0.406
+ ad=0.406 ps=3.38 pd=3.38
X$162 VDD \$168 \$203 VDD sky130_fd_pr__pfet_01v8_lvt l=0.6 w=1.4 as=0.406
+ ad=0.406 ps=3.38 pd=3.38
X$163 VDD \$168 \$202 VDD sky130_fd_pr__pfet_01v8_lvt l=0.6 w=1.4 as=0.406
+ ad=0.406 ps=3.38 pd=3.38
X$164 VDD \$168 \$202 VDD sky130_fd_pr__pfet_01v8_lvt l=0.6 w=1.4 as=0.406
+ ad=0.406 ps=3.38 pd=3.38
X$165 VDD \$168 \$203 VDD sky130_fd_pr__pfet_01v8_lvt l=0.6 w=1.4 as=0.406
+ ad=0.406 ps=3.38 pd=3.38
X$166 VDD \$168 \$202 VDD sky130_fd_pr__pfet_01v8_lvt l=0.6 w=1.4 as=0.406
+ ad=0.406 ps=3.38 pd=3.38
X$167 VDD \$168 \$203 VDD sky130_fd_pr__pfet_01v8_lvt l=0.6 w=1.4 as=0.406
+ ad=0.406 ps=3.38 pd=3.38
X$168 VDD \$168 \$202 VDD sky130_fd_pr__pfet_01v8_lvt l=0.6 w=1.4 as=0.406
+ ad=0.406 ps=3.38 pd=3.38
X$169 VDD \$168 \$203 VDD sky130_fd_pr__pfet_01v8_lvt l=0.6 w=1.4 as=0.406
+ ad=0.406 ps=3.38 pd=3.38
X$170 VDD \$168 \$202 VDD sky130_fd_pr__pfet_01v8_lvt l=0.6 w=1.4 as=0.406
+ ad=0.406 ps=3.38 pd=3.38
X$171 VDD VDD \$279 VDD sky130_fd_pr__pfet_01v8 l=0.6 w=1.4 as=0.406 ad=0.406
+ ps=3.38 pd=3.38
X$172 \$278 \$278 \$278 VDD sky130_fd_pr__pfet_01v8 l=0.6 w=1.4 as=0.406
+ ad=0.406 ps=3.38 pd=3.38
X$173 \$278 \$278 \$278 VDD sky130_fd_pr__pfet_01v8 l=0.6 w=1.4 as=0.406
+ ad=0.406 ps=3.38 pd=3.38
X$174 \$271 \$271 \$271 VDD sky130_fd_pr__pfet_01v8 l=0.6 w=1.4 as=0.406
+ ad=0.406 ps=3.38 pd=3.38
X$175 \$271 \$271 \$271 VDD sky130_fd_pr__pfet_01v8 l=0.6 w=1.4 as=0.406
+ ad=0.406 ps=3.38 pd=3.38
X$176 VDD VDD \$279 VDD sky130_fd_pr__pfet_01v8 l=0.6 w=1.4 as=0.406 ad=0.406
+ ps=3.38 pd=3.38
X$177 VDD VDD \$45 VDD sky130_fd_pr__pfet_01v8 l=0.6 w=1.4 as=0.406 ad=0.406
+ ps=3.38 pd=3.38
X$178 VDD VDD \$168 VDD sky130_fd_pr__pfet_01v8 l=0.6 w=1.4 as=0.406 ad=0.406
+ ps=3.38 pd=3.38
X$179 VDD VDD cm VDD sky130_fd_pr__pfet_01v8 l=0.6 w=1.4 as=0.406 ad=0.406
+ ps=3.38 pd=3.38
X$180 VDD VDD \$45 VDD sky130_fd_pr__pfet_01v8 l=0.6 w=1.4 as=0.406 ad=0.406
+ ps=3.38 pd=3.38
X$181 VDD VDD \$168 VDD sky130_fd_pr__pfet_01v8 l=0.6 w=1.4 as=0.406 ad=0.406
+ ps=3.38 pd=3.38
X$182 VDD VDD cm VDD sky130_fd_pr__pfet_01v8 l=0.6 w=1.4 as=0.406 ad=0.406
+ ps=3.38 pd=3.38
X$183 VDD VDD \$203 VDD sky130_fd_pr__pfet_01v8 l=0.6 w=1.4 as=0.406 ad=0.406
+ ps=3.38 pd=3.38
X$184 VDD VDD \$202 VDD sky130_fd_pr__pfet_01v8 l=0.6 w=1.4 as=0.406 ad=0.406
+ ps=3.38 pd=3.38
X$185 VDD VDD \$202 VDD sky130_fd_pr__pfet_01v8 l=0.6 w=1.4 as=0.406 ad=0.406
+ ps=3.38 pd=3.38
X$186 VDD VDD \$203 VDD sky130_fd_pr__pfet_01v8 l=0.6 w=1.4 as=0.406 ad=0.406
+ ps=3.38 pd=3.38
X$187 \$203 \$203 \$203 VDD sky130_fd_pr__pfet_01v8 l=0.6 w=1.4 as=0.406
+ ad=0.406 ps=3.38 pd=3.38
X$188 \$202 \$202 \$202 VDD sky130_fd_pr__pfet_01v8 l=0.6 w=1.4 as=0.406
+ ad=0.406 ps=3.38 pd=3.38
X$189 \$202 \$202 \$202 VDD sky130_fd_pr__pfet_01v8 l=0.6 w=1.4 as=0.406
+ ad=0.406 ps=3.38 pd=3.38
X$190 \$203 \$203 \$203 VDD sky130_fd_pr__pfet_01v8 l=0.6 w=1.4 as=0.406
+ ad=0.406 ps=3.38 pd=3.38
X$191 \$279 \$279 \$279 VDD sky130_fd_pr__pfet_01v8_lvt l=0.6 w=1.4 as=0.406
+ ad=0.406 ps=3.38 pd=3.38
X$192 \$278 \$278 \$278 VDD sky130_fd_pr__pfet_01v8_lvt l=0.6 w=1.4 as=0.406
+ ad=0.406 ps=3.38 pd=3.38
X$193 \$278 \$278 \$278 VDD sky130_fd_pr__pfet_01v8_lvt l=0.6 w=1.4 as=0.406
+ ad=0.406 ps=3.38 pd=3.38
X$194 \$271 \$271 \$271 VDD sky130_fd_pr__pfet_01v8_lvt l=0.6 w=1.4 as=0.406
+ ad=0.406 ps=3.38 pd=3.38
X$195 \$271 \$271 \$271 VDD sky130_fd_pr__pfet_01v8_lvt l=0.6 w=1.4 as=0.406
+ ad=0.406 ps=3.38 pd=3.38
X$196 \$279 \$279 \$279 VDD sky130_fd_pr__pfet_01v8_lvt l=0.6 w=1.4 as=0.406
+ ad=0.406 ps=3.38 pd=3.38
X$197 VDD VDD VDD VDD sky130_fd_pr__pfet_01v8_lvt l=0.6 w=1.4 as=0.406 ad=0.406
+ ps=3.38 pd=3.38
X$198 VDD VDD VDD VDD sky130_fd_pr__pfet_01v8_lvt l=0.6 w=1.4 as=0.406 ad=0.406
+ ps=3.38 pd=3.38
X$199 VDD VDD VDD VDD sky130_fd_pr__pfet_01v8_lvt l=0.6 w=1.4 as=0.406 ad=0.406
+ ps=3.38 pd=3.38
X$200 VDD VDD VDD VDD sky130_fd_pr__pfet_01v8_lvt l=0.6 w=1.4 as=0.406 ad=0.406
+ ps=3.38 pd=3.38
X$201 VDD VDD VDD VDD sky130_fd_pr__pfet_01v8_lvt l=0.6 w=1.4 as=0.406 ad=0.406
+ ps=3.38 pd=3.38
X$202 VDD VDD VDD VDD sky130_fd_pr__pfet_01v8_lvt l=0.6 w=1.4 as=0.406 ad=0.406
+ ps=3.38 pd=3.38
X$203 VDD VDD VDD VDD sky130_fd_pr__pfet_01v8_lvt l=0.6 w=1.4 as=0.406 ad=0.406
+ ps=3.38 pd=3.38
X$204 VDD VDD VDD VDD sky130_fd_pr__pfet_01v8_lvt l=0.6 w=1.4 as=0.406 ad=0.406
+ ps=3.38 pd=3.38
X$205 VDD VDD VDD VDD sky130_fd_pr__pfet_01v8_lvt l=0.6 w=1.4 as=0.406 ad=0.406
+ ps=3.38 pd=3.38
X$206 VDD VDD VDD VDD sky130_fd_pr__pfet_01v8_lvt l=0.6 w=1.4 as=0.406 ad=0.406
+ ps=3.38 pd=3.38
X$207 \$203 \$150 op VDD sky130_fd_pr__pfet_01v8 l=0.6 w=1.4 as=0.406 ad=0.406
+ ps=3.38 pd=3.38
X$208 \$202 \$150 on VDD sky130_fd_pr__pfet_01v8 l=0.6 w=1.4 as=0.406 ad=0.406
+ ps=3.38 pd=3.38
X$209 \$203 \$150 op VDD sky130_fd_pr__pfet_01v8 l=0.6 w=1.4 as=0.406 ad=0.406
+ ps=3.38 pd=3.38
X$210 \$202 \$150 on VDD sky130_fd_pr__pfet_01v8 l=0.6 w=1.4 as=0.406 ad=0.406
+ ps=3.38 pd=3.38
X$211 \$203 \$150 op VDD sky130_fd_pr__pfet_01v8 l=0.6 w=1.4 as=0.406 ad=0.406
+ ps=3.38 pd=3.38
X$212 \$202 \$150 on VDD sky130_fd_pr__pfet_01v8 l=0.6 w=1.4 as=0.406 ad=0.406
+ ps=3.38 pd=3.38
X$213 \$203 \$150 op VDD sky130_fd_pr__pfet_01v8 l=0.6 w=1.4 as=0.406 ad=0.406
+ ps=3.38 pd=3.38
X$214 \$202 \$150 on VDD sky130_fd_pr__pfet_01v8 l=0.6 w=1.4 as=0.406 ad=0.406
+ ps=3.38 pd=3.38
X$215 \$203 \$150 op VDD sky130_fd_pr__pfet_01v8 l=0.6 w=1.4 as=0.406 ad=0.406
+ ps=3.38 pd=3.38
X$216 \$202 \$150 on VDD sky130_fd_pr__pfet_01v8 l=0.6 w=1.4 as=0.406 ad=0.406
+ ps=3.38 pd=3.38
X$217 \$203 \$150 op VDD sky130_fd_pr__pfet_01v8 l=0.6 w=1.4 as=0.406 ad=0.406
+ ps=3.38 pd=3.38
X$218 \$203 \$150 op VDD sky130_fd_pr__pfet_01v8 l=0.6 w=1.4 as=0.406 ad=0.406
+ ps=3.38 pd=3.38
X$219 \$202 \$150 on VDD sky130_fd_pr__pfet_01v8 l=0.6 w=1.4 as=0.406 ad=0.406
+ ps=3.38 pd=3.38
X$220 \$203 \$150 op VDD sky130_fd_pr__pfet_01v8 l=0.6 w=1.4 as=0.406 ad=0.406
+ ps=3.38 pd=3.38
X$221 \$202 \$150 on VDD sky130_fd_pr__pfet_01v8 l=0.6 w=1.4 as=0.406 ad=0.406
+ ps=3.38 pd=3.38
X$222 \$203 \$150 op VDD sky130_fd_pr__pfet_01v8 l=0.6 w=1.4 as=0.406 ad=0.406
+ ps=3.38 pd=3.38
X$223 \$202 \$150 on VDD sky130_fd_pr__pfet_01v8 l=0.6 w=1.4 as=0.406 ad=0.406
+ ps=3.38 pd=3.38
X$224 \$203 \$150 op VDD sky130_fd_pr__pfet_01v8 l=0.6 w=1.4 as=0.406 ad=0.406
+ ps=3.38 pd=3.38
X$225 \$202 \$150 on VDD sky130_fd_pr__pfet_01v8 l=0.6 w=1.4 as=0.406 ad=0.406
+ ps=3.38 pd=3.38
X$226 \$202 \$150 on VDD sky130_fd_pr__pfet_01v8 l=0.6 w=1.4 as=0.406 ad=0.406
+ ps=3.38 pd=3.38
X$227 \$203 \$150 op VDD sky130_fd_pr__pfet_01v8 l=0.6 w=1.4 as=0.406 ad=0.406
+ ps=3.38 pd=3.38
X$228 \$202 \$150 on VDD sky130_fd_pr__pfet_01v8 l=0.6 w=1.4 as=0.406 ad=0.406
+ ps=3.38 pd=3.38
X$229 \$203 \$150 op VDD sky130_fd_pr__pfet_01v8 l=0.6 w=1.4 as=0.406 ad=0.406
+ ps=3.38 pd=3.38
X$230 \$202 \$150 on VDD sky130_fd_pr__pfet_01v8 l=0.6 w=1.4 as=0.406 ad=0.406
+ ps=3.38 pd=3.38
X$231 \$202 \$150 on VDD sky130_fd_pr__pfet_01v8 l=0.6 w=1.4 as=0.406 ad=0.406
+ ps=3.38 pd=3.38
X$232 \$202 \$150 on VDD sky130_fd_pr__pfet_01v8 l=0.6 w=1.4 as=0.406 ad=0.406
+ ps=3.38 pd=3.38
X$233 \$203 \$150 op VDD sky130_fd_pr__pfet_01v8 l=0.6 w=1.4 as=0.406 ad=0.406
+ ps=3.38 pd=3.38
X$234 \$202 \$150 on VDD sky130_fd_pr__pfet_01v8 l=0.6 w=1.4 as=0.406 ad=0.406
+ ps=3.38 pd=3.38
X$235 \$203 \$150 op VDD sky130_fd_pr__pfet_01v8 l=0.6 w=1.4 as=0.406 ad=0.406
+ ps=3.38 pd=3.38
X$236 \$203 \$150 op VDD sky130_fd_pr__pfet_01v8 l=0.6 w=1.4 as=0.406 ad=0.406
+ ps=3.38 pd=3.38
X$237 \$203 \$150 op VDD sky130_fd_pr__pfet_01v8 l=0.6 w=1.4 as=0.406 ad=0.406
+ ps=3.38 pd=3.38
X$238 \$203 \$150 op VDD sky130_fd_pr__pfet_01v8 l=0.6 w=1.4 as=0.406 ad=0.406
+ ps=3.38 pd=3.38
X$239 \$202 \$150 on VDD sky130_fd_pr__pfet_01v8 l=0.6 w=1.4 as=0.406 ad=0.406
+ ps=3.38 pd=3.38
X$240 \$203 \$150 op VDD sky130_fd_pr__pfet_01v8 l=0.6 w=1.4 as=0.406 ad=0.406
+ ps=3.38 pd=3.38
X$241 \$202 \$150 on VDD sky130_fd_pr__pfet_01v8 l=0.6 w=1.4 as=0.406 ad=0.406
+ ps=3.38 pd=3.38
X$242 \$203 \$150 op VDD sky130_fd_pr__pfet_01v8 l=0.6 w=1.4 as=0.406 ad=0.406
+ ps=3.38 pd=3.38
X$243 \$202 \$150 on VDD sky130_fd_pr__pfet_01v8 l=0.6 w=1.4 as=0.406 ad=0.406
+ ps=3.38 pd=3.38
X$244 \$203 \$150 op VDD sky130_fd_pr__pfet_01v8 l=0.6 w=1.4 as=0.406 ad=0.406
+ ps=3.38 pd=3.38
X$245 \$202 \$150 on VDD sky130_fd_pr__pfet_01v8 l=0.6 w=1.4 as=0.406 ad=0.406
+ ps=3.38 pd=3.38
X$246 \$202 \$150 on VDD sky130_fd_pr__pfet_01v8 l=0.6 w=1.4 as=0.406 ad=0.406
+ ps=3.38 pd=3.38
X$247 \$271 \$150 \$45 VDD sky130_fd_pr__pfet_01v8 l=0.6 w=1.4 as=0.406
+ ad=0.406 ps=3.38 pd=3.38
X$248 \$279 \$150 cm VDD sky130_fd_pr__pfet_01v8 l=0.6 w=1.4 as=0.406 ad=0.406
+ ps=3.38 pd=3.38
X$249 \$278 \$150 \$168 VDD sky130_fd_pr__pfet_01v8 l=0.6 w=1.4 as=0.406
+ ad=0.406 ps=3.38 pd=3.38
X$250 \$271 \$150 \$45 VDD sky130_fd_pr__pfet_01v8 l=0.6 w=1.4 as=0.406
+ ad=0.406 ps=3.38 pd=3.38
X$251 \$279 \$150 cm VDD sky130_fd_pr__pfet_01v8 l=0.6 w=1.4 as=0.406 ad=0.406
+ ps=3.38 pd=3.38
X$252 \$271 \$150 \$45 VDD sky130_fd_pr__pfet_01v8 l=0.6 w=1.4 as=0.406
+ ad=0.406 ps=3.38 pd=3.38
X$253 \$279 \$150 cm VDD sky130_fd_pr__pfet_01v8 l=0.6 w=1.4 as=0.406 ad=0.406
+ ps=3.38 pd=3.38
X$254 \$278 \$150 \$168 VDD sky130_fd_pr__pfet_01v8 l=0.6 w=1.4 as=0.406
+ ad=0.406 ps=3.38 pd=3.38
X$255 \$279 \$150 cm VDD sky130_fd_pr__pfet_01v8 l=0.6 w=1.4 as=0.406 ad=0.406
+ ps=3.38 pd=3.38
X$256 \$271 \$150 \$45 VDD sky130_fd_pr__pfet_01v8 l=0.6 w=1.4 as=0.406
+ ad=0.406 ps=3.38 pd=3.38
X$257 \$278 \$150 \$168 VDD sky130_fd_pr__pfet_01v8 l=0.6 w=1.4 as=0.406
+ ad=0.406 ps=3.38 pd=3.38
X$258 \$279 \$150 cm VDD sky130_fd_pr__pfet_01v8 l=0.6 w=1.4 as=0.406 ad=0.406
+ ps=3.38 pd=3.38
X$259 \$271 \$150 \$45 VDD sky130_fd_pr__pfet_01v8 l=0.6 w=1.4 as=0.406
+ ad=0.406 ps=3.38 pd=3.38
X$260 \$278 \$150 \$168 VDD sky130_fd_pr__pfet_01v8 l=0.6 w=1.4 as=0.406
+ ad=0.406 ps=3.38 pd=3.38
X$261 \$279 \$150 cm VDD sky130_fd_pr__pfet_01v8 l=0.6 w=1.4 as=0.406 ad=0.406
+ ps=3.38 pd=3.38
X$262 \$271 \$150 \$45 VDD sky130_fd_pr__pfet_01v8 l=0.6 w=1.4 as=0.406
+ ad=0.406 ps=3.38 pd=3.38
X$263 \$278 \$150 \$168 VDD sky130_fd_pr__pfet_01v8 l=0.6 w=1.4 as=0.406
+ ad=0.406 ps=3.38 pd=3.38
X$264 \$278 \$150 \$168 VDD sky130_fd_pr__pfet_01v8 l=0.6 w=1.4 as=0.406
+ ad=0.406 ps=3.38 pd=3.38
X$265 VDD VDD VDD VDD sky130_fd_pr__pfet_01v8 l=0.6 w=1.4 as=0.406 ad=0.406
+ ps=3.38 pd=3.38
X$266 VDD VDD VDD VDD sky130_fd_pr__pfet_01v8 l=0.6 w=1.4 as=0.406 ad=0.406
+ ps=3.38 pd=3.38
X$267 VDD VDD VDD VDD sky130_fd_pr__pfet_01v8 l=0.6 w=1.4 as=0.406 ad=0.406
+ ps=3.38 pd=3.38
X$268 VDD VDD VDD VDD sky130_fd_pr__pfet_01v8 l=0.6 w=1.4 as=0.406 ad=0.406
+ ps=3.38 pd=3.38
X$269 VDD VDD VDD VDD sky130_fd_pr__pfet_01v8 l=0.6 w=1.4 as=0.406 ad=0.406
+ ps=3.38 pd=3.38
X$270 VDD VDD VDD VDD sky130_fd_pr__pfet_01v8 l=0.6 w=1.4 as=0.406 ad=0.406
+ ps=3.38 pd=3.38
X$271 VDD VDD VDD VDD sky130_fd_pr__pfet_01v8 l=0.6 w=1.4 as=0.406 ad=0.406
+ ps=3.38 pd=3.38
X$272 VDD VDD VDD VDD sky130_fd_pr__pfet_01v8 l=0.6 w=1.4 as=0.406 ad=0.406
+ ps=3.38 pd=3.38
X$273 VDD VDD VDD VDD sky130_fd_pr__pfet_01v8 l=0.6 w=1.4 as=0.406 ad=0.406
+ ps=3.38 pd=3.38
X$274 VDD VDD VDD VDD sky130_fd_pr__pfet_01v8 l=0.6 w=1.4 as=0.406 ad=0.406
+ ps=3.38 pd=3.38
X$275 VDD VDD VDD VDD sky130_fd_pr__pfet_01v8 l=0.6 w=1.4 as=0.406 ad=0.406
+ ps=3.38 pd=3.38
X$276 VDD VDD VDD VDD sky130_fd_pr__pfet_01v8 l=0.6 w=1.4 as=0.406 ad=0.406
+ ps=3.38 pd=3.38
X$277 VSS VSS VSS sky130_gnd sky130_fd_pr__nfet_01v8 l=0.6 w=1.4 as=0.406
+ ad=0.406 ps=3.38 pd=3.38
X$278 VSS VSS VSS sky130_gnd sky130_fd_pr__nfet_01v8 l=0.6 w=1.4 as=0.406
+ ad=0.406 ps=3.38 pd=3.38
X$279 VSS VSS VSS sky130_gnd sky130_fd_pr__nfet_01v8 l=0.6 w=1.4 as=0.406
+ ad=0.406 ps=3.38 pd=3.38
X$280 VSS VSS VSS sky130_gnd sky130_fd_pr__nfet_01v8 l=0.6 w=1.4 as=0.406
+ ad=0.406 ps=3.38 pd=3.38
X$281 VSS VSS VSS sky130_gnd sky130_fd_pr__nfet_01v8 l=0.6 w=1.4 as=0.406
+ ad=0.406 ps=3.38 pd=3.38
X$282 VSS VSS VSS sky130_gnd sky130_fd_pr__nfet_01v8 l=0.6 w=1.4 as=0.406
+ ad=0.406 ps=3.38 pd=3.38
X$283 VSS VSS VSS sky130_gnd sky130_fd_pr__nfet_01v8 l=0.6 w=1.4 as=0.406
+ ad=0.406 ps=3.38 pd=3.38
X$284 VSS VSS VSS sky130_gnd sky130_fd_pr__nfet_01v8 l=0.6 w=1.4 as=0.406
+ ad=0.406 ps=3.38 pd=3.38
X$285 VSS VSS VSS sky130_gnd sky130_fd_pr__nfet_01v8 l=0.6 w=1.4 as=0.406
+ ad=0.406 ps=3.38 pd=3.38
X$286 VSS VSS VSS sky130_gnd sky130_fd_pr__nfet_01v8 l=0.6 w=1.4 as=0.406
+ ad=0.406 ps=3.38 pd=3.38
X$287 VSS VSS VSS sky130_gnd sky130_fd_pr__nfet_01v8 l=0.6 w=1.4 as=0.406
+ ad=0.406 ps=3.38 pd=3.38
X$288 VSS VSS VSS sky130_gnd sky130_fd_pr__nfet_01v8 l=0.6 w=1.4 as=0.406
+ ad=0.406 ps=3.38 pd=3.38
X$289 VSS VSS VSS sky130_gnd sky130_fd_pr__nfet_01v8 l=0.6 w=1.4 as=0.406
+ ad=0.406 ps=3.38 pd=3.38
X$290 VSS VSS VSS sky130_gnd sky130_fd_pr__nfet_01v8 l=0.6 w=1.4 as=0.406
+ ad=0.406 ps=3.38 pd=3.38
X$291 VSS VSS VSS sky130_gnd sky130_fd_pr__nfet_01v8 l=0.6 w=1.4 as=0.406
+ ad=0.406 ps=3.38 pd=3.38
X$292 VSS VSS VSS sky130_gnd sky130_fd_pr__nfet_01v8 l=0.6 w=1.4 as=0.406
+ ad=0.406 ps=3.38 pd=3.38
X$293 VSS VSS VSS sky130_gnd sky130_fd_pr__nfet_01v8 l=0.6 w=1.4 as=0.406
+ ad=0.406 ps=3.38 pd=3.38
X$294 VSS VSS VSS sky130_gnd sky130_fd_pr__nfet_01v8 l=0.6 w=1.4 as=0.406
+ ad=0.406 ps=3.38 pd=3.38
X$295 VSS VSS VSS sky130_gnd sky130_fd_pr__nfet_01v8 l=0.6 w=1.4 as=0.406
+ ad=0.406 ps=3.38 pd=3.38
X$296 VSS VSS VSS sky130_gnd sky130_fd_pr__nfet_01v8 l=0.6 w=1.4 as=0.406
+ ad=0.406 ps=3.38 pd=3.38
X$297 VSS VSS VSS sky130_gnd sky130_fd_pr__nfet_01v8 l=0.6 w=1.4 as=0.406
+ ad=0.406 ps=3.38 pd=3.38
X$298 VSS VSS VSS sky130_gnd sky130_fd_pr__nfet_01v8 l=0.6 w=1.4 as=0.406
+ ad=0.406 ps=3.38 pd=3.38
X$299 VSS VSS VSS sky130_gnd sky130_fd_pr__nfet_01v8 l=0.6 w=1.4 as=0.406
+ ad=0.406 ps=3.38 pd=3.38
X$300 VSS VSS VSS sky130_gnd sky130_fd_pr__nfet_01v8 l=0.6 w=1.4 as=0.406
+ ad=0.406 ps=3.38 pd=3.38
X$301 VSS VSS VSS sky130_gnd sky130_fd_pr__nfet_01v8 l=0.6 w=1.4 as=0.406
+ ad=0.406 ps=3.38 pd=3.38
X$302 bias_a bias_a bias_a sky130_gnd sky130_fd_pr__nfet_01v8 l=0.6 w=1.4
+ as=0.406 ad=0.406 ps=3.38 pd=3.38
X$303 bias_a bias_a bias_a sky130_gnd sky130_fd_pr__nfet_01v8 l=0.6 w=1.4
+ as=0.406 ad=0.406 ps=3.38 pd=3.38
X$304 bias_a bias_a bias_a sky130_gnd sky130_fd_pr__nfet_01v8 l=0.6 w=1.4
+ as=0.406 ad=0.406 ps=3.38 pd=3.38
X$305 bias_a bias_a bias_a sky130_gnd sky130_fd_pr__nfet_01v8 l=0.6 w=1.4
+ as=0.406 ad=0.406 ps=3.38 pd=3.38
X$306 VSS VSS \$77 sky130_gnd sky130_fd_pr__nfet_01v8 l=0.6 w=1.4 as=0.406
+ ad=0.406 ps=3.38 pd=3.38
X$307 VSS VSS \$77 sky130_gnd sky130_fd_pr__nfet_01v8 l=0.6 w=1.4 as=0.406
+ ad=0.406 ps=3.38 pd=3.38
X$308 VSS VSS \$77 sky130_gnd sky130_fd_pr__nfet_01v8 l=0.6 w=1.4 as=0.406
+ ad=0.406 ps=3.38 pd=3.38
X$309 VSS VSS \$77 sky130_gnd sky130_fd_pr__nfet_01v8 l=0.6 w=1.4 as=0.406
+ ad=0.406 ps=3.38 pd=3.38
X$310 VSS VSS \$77 sky130_gnd sky130_fd_pr__nfet_01v8 l=0.6 w=1.4 as=0.406
+ ad=0.406 ps=3.38 pd=3.38
X$311 VSS VSS \$77 sky130_gnd sky130_fd_pr__nfet_01v8 l=0.6 w=1.4 as=0.406
+ ad=0.406 ps=3.38 pd=3.38
X$312 \$157 \$157 \$157 sky130_gnd sky130_fd_pr__nfet_01v8 l=0.6 w=1.4 as=0.406
+ ad=0.406 ps=3.38 pd=3.38
X$313 \$157 \$157 \$157 sky130_gnd sky130_fd_pr__nfet_01v8 l=0.6 w=1.4 as=0.406
+ ad=0.406 ps=3.38 pd=3.38
X$314 \$157 \$157 \$157 sky130_gnd sky130_fd_pr__nfet_01v8 l=0.6 w=1.4 as=0.406
+ ad=0.406 ps=3.38 pd=3.38
X$315 \$157 \$157 \$157 sky130_gnd sky130_fd_pr__nfet_01v8 l=0.6 w=1.4 as=0.406
+ ad=0.406 ps=3.38 pd=3.38
X$316 \$157 \$157 \$157 sky130_gnd sky130_fd_pr__nfet_01v8 l=0.6 w=1.4 as=0.406
+ ad=0.406 ps=3.38 pd=3.38
X$317 \$157 \$157 \$157 sky130_gnd sky130_fd_pr__nfet_01v8 l=0.6 w=1.4 as=0.406
+ ad=0.406 ps=3.38 pd=3.38
X$318 VSS VSS VSS sky130_gnd sky130_fd_pr__nfet_01v8 l=0.6 w=1.4 as=0.406
+ ad=0.406 ps=3.38 pd=3.38
X$319 VSS VSS VSS sky130_gnd sky130_fd_pr__nfet_01v8 l=0.6 w=1.4 as=0.406
+ ad=0.406 ps=3.38 pd=3.38
X$320 VSS VSS \$1 sky130_gnd sky130_fd_pr__nfet_01v8 l=0.6 w=1.4 as=0.406
+ ad=0.406 ps=3.38 pd=3.38
X$321 VSS VSS \$1 sky130_gnd sky130_fd_pr__nfet_01v8 l=0.6 w=1.4 as=0.406
+ ad=0.406 ps=3.38 pd=3.38
X$322 VSS VSS \$1 sky130_gnd sky130_fd_pr__nfet_01v8 l=0.6 w=1.4 as=0.406
+ ad=0.406 ps=3.38 pd=3.38
X$323 VSS VSS \$1 sky130_gnd sky130_fd_pr__nfet_01v8 l=0.6 w=1.4 as=0.406
+ ad=0.406 ps=3.38 pd=3.38
X$324 VSS VSS \$1 sky130_gnd sky130_fd_pr__nfet_01v8 l=0.6 w=1.4 as=0.406
+ ad=0.406 ps=3.38 pd=3.38
X$325 VSS VSS \$1 sky130_gnd sky130_fd_pr__nfet_01v8 l=0.6 w=1.4 as=0.406
+ ad=0.406 ps=3.38 pd=3.38
X$326 \$1 \$1 \$1 sky130_gnd sky130_fd_pr__nfet_01v8 l=0.6 w=1.4 as=0.406
+ ad=0.406 ps=3.38 pd=3.38
X$327 \$1 \$1 \$1 sky130_gnd sky130_fd_pr__nfet_01v8 l=0.6 w=1.4 as=0.406
+ ad=0.406 ps=3.38 pd=3.38
X$328 \$1 \$1 \$1 sky130_gnd sky130_fd_pr__nfet_01v8 l=0.6 w=1.4 as=0.406
+ ad=0.406 ps=3.38 pd=3.38
X$329 \$1 \$1 \$1 sky130_gnd sky130_fd_pr__nfet_01v8 l=0.6 w=1.4 as=0.406
+ ad=0.406 ps=3.38 pd=3.38
X$330 \$1 \$1 \$1 sky130_gnd sky130_fd_pr__nfet_01v8 l=0.6 w=1.4 as=0.406
+ ad=0.406 ps=3.38 pd=3.38
X$331 \$1 \$1 \$1 sky130_gnd sky130_fd_pr__nfet_01v8 l=0.6 w=1.4 as=0.406
+ ad=0.406 ps=3.38 pd=3.38
X$332 cm cm cm sky130_gnd sky130_fd_pr__nfet_01v8 l=0.6 w=1.4 as=0.406 ad=0.406
+ ps=3.38 pd=3.38
X$333 cm cm cm sky130_gnd sky130_fd_pr__nfet_01v8 l=0.6 w=1.4 as=0.406 ad=0.406
+ ps=3.38 pd=3.38
X$334 cm cm cm sky130_gnd sky130_fd_pr__nfet_01v8 l=0.6 w=1.4 as=0.406 ad=0.406
+ ps=3.38 pd=3.38
X$335 cm cm cm sky130_gnd sky130_fd_pr__nfet_01v8 l=0.6 w=1.4 as=0.406 ad=0.406
+ ps=3.38 pd=3.38
X$336 cm cm cm sky130_gnd sky130_fd_pr__nfet_01v8 l=0.6 w=1.4 as=0.406 ad=0.406
+ ps=3.38 pd=3.38
X$337 cm cm cm sky130_gnd sky130_fd_pr__nfet_01v8 l=0.6 w=1.4 as=0.406 ad=0.406
+ ps=3.38 pd=3.38
X$338 cm cm cm sky130_gnd sky130_fd_pr__nfet_01v8 l=0.6 w=1.4 as=0.406 ad=0.406
+ ps=3.38 pd=3.38
X$339 cm cm cm sky130_gnd sky130_fd_pr__nfet_01v8 l=0.6 w=1.4 as=0.406 ad=0.406
+ ps=3.38 pd=3.38
X$340 VSS VSS \$76 sky130_gnd sky130_fd_pr__nfet_01v8 l=0.6 w=1.4 as=0.406
+ ad=0.406 ps=3.38 pd=3.38
X$341 VSS VSS \$76 sky130_gnd sky130_fd_pr__nfet_01v8 l=0.6 w=1.4 as=0.406
+ ad=0.406 ps=3.38 pd=3.38
X$342 VSS VSS \$76 sky130_gnd sky130_fd_pr__nfet_01v8 l=0.6 w=1.4 as=0.406
+ ad=0.406 ps=3.38 pd=3.38
X$343 VSS VSS \$76 sky130_gnd sky130_fd_pr__nfet_01v8 l=0.6 w=1.4 as=0.406
+ ad=0.406 ps=3.38 pd=3.38
X$344 VSS VSS \$76 sky130_gnd sky130_fd_pr__nfet_01v8 l=0.6 w=1.4 as=0.406
+ ad=0.406 ps=3.38 pd=3.38
X$345 VSS VSS \$76 sky130_gnd sky130_fd_pr__nfet_01v8 l=0.6 w=1.4 as=0.406
+ ad=0.406 ps=3.38 pd=3.38
X$346 VSS VSS \$76 sky130_gnd sky130_fd_pr__nfet_01v8 l=0.6 w=1.4 as=0.406
+ ad=0.406 ps=3.38 pd=3.38
X$347 VSS VSS \$76 sky130_gnd sky130_fd_pr__nfet_01v8 l=0.6 w=1.4 as=0.406
+ ad=0.406 ps=3.38 pd=3.38
X$348 \$11 \$11 \$11 sky130_gnd sky130_fd_pr__nfet_01v8 l=0.6 w=1.4 as=0.406
+ ad=0.406 ps=3.38 pd=3.38
X$349 \$11 \$11 \$11 sky130_gnd sky130_fd_pr__nfet_01v8 l=0.6 w=1.4 as=0.406
+ ad=0.406 ps=3.38 pd=3.38
X$350 \$11 \$11 \$11 sky130_gnd sky130_fd_pr__nfet_01v8 l=0.6 w=1.4 as=0.406
+ ad=0.406 ps=3.38 pd=3.38
X$351 \$11 \$11 \$11 sky130_gnd sky130_fd_pr__nfet_01v8 l=0.6 w=1.4 as=0.406
+ ad=0.406 ps=3.38 pd=3.38
X$352 \$11 \$11 \$11 sky130_gnd sky130_fd_pr__nfet_01v8 l=0.6 w=1.4 as=0.406
+ ad=0.406 ps=3.38 pd=3.38
X$353 \$11 \$11 \$11 sky130_gnd sky130_fd_pr__nfet_01v8 l=0.6 w=1.4 as=0.406
+ ad=0.406 ps=3.38 pd=3.38
X$354 \$11 \$11 \$11 sky130_gnd sky130_fd_pr__nfet_01v8 l=0.6 w=1.4 as=0.406
+ ad=0.406 ps=3.38 pd=3.38
X$355 \$11 \$11 \$11 sky130_gnd sky130_fd_pr__nfet_01v8 l=0.6 w=1.4 as=0.406
+ ad=0.406 ps=3.38 pd=3.38
X$356 VSS cm \$11.x1_net12 sky130_gnd sky130_fd_pr__nfet_01v8 l=0.6 w=1.4
+ as=0.406 ad=0.406 ps=3.38 pd=3.38
X$357 VSS cm \$11.x1_net9 sky130_gnd sky130_fd_pr__nfet_01v8 l=0.6 w=1.4
+ as=0.406 ad=0.406 ps=3.38 pd=3.38
X$358 VSS cm \$11.x1_net6 sky130_gnd sky130_fd_pr__nfet_01v8 l=0.6 w=1.4
+ as=0.406 ad=0.406 ps=3.38 pd=3.38
X$359 VSS cm \$11.x1_net3 sky130_gnd sky130_fd_pr__nfet_01v8 l=0.6 w=1.4
+ as=0.406 ad=0.406 ps=3.38 pd=3.38
X$360 VSS cm \$11.x1_net15 sky130_gnd sky130_fd_pr__nfet_01v8 l=0.6 w=1.4
+ as=0.406 ad=0.406 ps=3.38 pd=3.38
X$361 \$11.x1_net2 cm \$11.x1_net1 sky130_gnd sky130_fd_pr__nfet_01v8 l=0.6
+ w=1.4 as=0.406 ad=0.406 ps=3.38 pd=3.38
X$362 \$11.x1_net3 cm \$11.x1_net2 sky130_gnd sky130_fd_pr__nfet_01v8 l=0.6
+ w=1.4 as=0.406 ad=0.406 ps=3.38 pd=3.38
X$363 \$11.x1_net14 cm \$11.x1_net13 sky130_gnd sky130_fd_pr__nfet_01v8 l=0.6
+ w=1.4 as=0.406 ad=0.406 ps=3.38 pd=3.38
X$364 \$11.x1_net15 cm \$11.x1_net14 sky130_gnd sky130_fd_pr__nfet_01v8 l=0.6
+ w=1.4 as=0.406 ad=0.406 ps=3.38 pd=3.38
X$365 \$11.x1_net5 cm \$11.x1_net4 sky130_gnd sky130_fd_pr__nfet_01v8 l=0.6
+ w=1.4 as=0.406 ad=0.406 ps=3.38 pd=3.38
X$366 \$11.x1_net6 cm \$11.x1_net5 sky130_gnd sky130_fd_pr__nfet_01v8 l=0.6
+ w=1.4 as=0.406 ad=0.406 ps=3.38 pd=3.38
X$367 \$11.x1_net8 cm \$11.x1_net7 sky130_gnd sky130_fd_pr__nfet_01v8 l=0.6
+ w=1.4 as=0.406 ad=0.406 ps=3.38 pd=3.38
X$368 \$11.x1_net9 cm \$11.x1_net8 sky130_gnd sky130_fd_pr__nfet_01v8 l=0.6
+ w=1.4 as=0.406 ad=0.406 ps=3.38 pd=3.38
X$369 \$11.x1_net11 cm \$11.x1_net10 sky130_gnd sky130_fd_pr__nfet_01v8 l=0.6
+ w=1.4 as=0.406 ad=0.406 ps=3.38 pd=3.38
X$370 \$11.x1_net12 cm \$11.x1_net11 sky130_gnd sky130_fd_pr__nfet_01v8 l=0.6
+ w=1.4 as=0.406 ad=0.406 ps=3.38 pd=3.38
X$371 \$11.x1_net1 cm cm sky130_gnd sky130_fd_pr__nfet_01v8 l=0.6 w=1.4
+ as=0.406 ad=0.406 ps=3.38 pd=3.38
X$372 \$11.x1_net13 cm cm sky130_gnd sky130_fd_pr__nfet_01v8 l=0.6 w=1.4
+ as=0.406 ad=0.406 ps=3.38 pd=3.38
X$373 \$11.x1_net4 cm cm sky130_gnd sky130_fd_pr__nfet_01v8 l=0.6 w=1.4
+ as=0.406 ad=0.406 ps=3.38 pd=3.38
X$374 \$11.x1_net7 cm cm sky130_gnd sky130_fd_pr__nfet_01v8 l=0.6 w=1.4
+ as=0.406 ad=0.406 ps=3.38 pd=3.38
X$375 \$11.x1_net10 cm cm sky130_gnd sky130_fd_pr__nfet_01v8 l=0.6 w=1.4
+ as=0.406 ad=0.406 ps=3.38 pd=3.38
X$376 VSS cmc \$157 sky130_gnd sky130_fd_pr__nfet_01v8 l=0.6 w=1.4 as=0.406
+ ad=0.406 ps=3.38 pd=3.38
X$377 VSS bias_a \$157 sky130_gnd sky130_fd_pr__nfet_01v8 l=0.6 w=1.4 as=0.406
+ ad=0.406 ps=3.38 pd=3.38
X$378 VSS bias_a \$157 sky130_gnd sky130_fd_pr__nfet_01v8 l=0.6 w=1.4 as=0.406
+ ad=0.406 ps=3.38 pd=3.38
X$379 VSS bias_a \$157 sky130_gnd sky130_fd_pr__nfet_01v8 l=0.6 w=1.4 as=0.406
+ ad=0.406 ps=3.38 pd=3.38
X$380 VSS cmc \$157 sky130_gnd sky130_fd_pr__nfet_01v8 l=0.6 w=1.4 as=0.406
+ ad=0.406 ps=3.38 pd=3.38
X$381 VSS cmc \$157 sky130_gnd sky130_fd_pr__nfet_01v8 l=0.6 w=1.4 as=0.406
+ ad=0.406 ps=3.38 pd=3.38
X$382 VSS bias_a \$157 sky130_gnd sky130_fd_pr__nfet_01v8 l=0.6 w=1.4 as=0.406
+ ad=0.406 ps=3.38 pd=3.38
X$383 VSS bias_a \$157 sky130_gnd sky130_fd_pr__nfet_01v8 l=0.6 w=1.4 as=0.406
+ ad=0.406 ps=3.38 pd=3.38
X$384 VSS cmc \$157 sky130_gnd sky130_fd_pr__nfet_01v8 l=0.6 w=1.4 as=0.406
+ ad=0.406 ps=3.38 pd=3.38
X$385 VSS cmc \$157 sky130_gnd sky130_fd_pr__nfet_01v8 l=0.6 w=1.4 as=0.406
+ ad=0.406 ps=3.38 pd=3.38
X$386 VSS bias_a \$157 sky130_gnd sky130_fd_pr__nfet_01v8 l=0.6 w=1.4 as=0.406
+ ad=0.406 ps=3.38 pd=3.38
X$387 VSS bias_a \$157 sky130_gnd sky130_fd_pr__nfet_01v8 l=0.6 w=1.4 as=0.406
+ ad=0.406 ps=3.38 pd=3.38
X$388 VSS cmc \$157 sky130_gnd sky130_fd_pr__nfet_01v8 l=0.6 w=1.4 as=0.406
+ ad=0.406 ps=3.38 pd=3.38
X$389 VSS cmc \$157 sky130_gnd sky130_fd_pr__nfet_01v8 l=0.6 w=1.4 as=0.406
+ ad=0.406 ps=3.38 pd=3.38
X$390 VSS bias_a \$157 sky130_gnd sky130_fd_pr__nfet_01v8 l=0.6 w=1.4 as=0.406
+ ad=0.406 ps=3.38 pd=3.38
X$391 VSS bias_a \$157 sky130_gnd sky130_fd_pr__nfet_01v8 l=0.6 w=1.4 as=0.406
+ ad=0.406 ps=3.38 pd=3.38
X$392 VSS cmc \$157 sky130_gnd sky130_fd_pr__nfet_01v8 l=0.6 w=1.4 as=0.406
+ ad=0.406 ps=3.38 pd=3.38
X$393 VSS cmc \$157 sky130_gnd sky130_fd_pr__nfet_01v8 l=0.6 w=1.4 as=0.406
+ ad=0.406 ps=3.38 pd=3.38
X$394 VSS bias_a \$157 sky130_gnd sky130_fd_pr__nfet_01v8 l=0.6 w=1.4 as=0.406
+ ad=0.406 ps=3.38 pd=3.38
X$395 VSS bias_a \$157 sky130_gnd sky130_fd_pr__nfet_01v8 l=0.6 w=1.4 as=0.406
+ ad=0.406 ps=3.38 pd=3.38
X$396 VSS cmc \$157 sky130_gnd sky130_fd_pr__nfet_01v8 l=0.6 w=1.4 as=0.406
+ ad=0.406 ps=3.38 pd=3.38
X$397 VSS bias_a \$157 sky130_gnd sky130_fd_pr__nfet_01v8 l=0.6 w=1.4 as=0.406
+ ad=0.406 ps=3.38 pd=3.38
X$398 VSS cmc \$157 sky130_gnd sky130_fd_pr__nfet_01v8 l=0.6 w=1.4 as=0.406
+ ad=0.406 ps=3.38 pd=3.38
X$399 VSS bias_a \$157 sky130_gnd sky130_fd_pr__nfet_01v8 l=0.6 w=1.4 as=0.406
+ ad=0.406 ps=3.38 pd=3.38
X$400 VSS cmc \$157 sky130_gnd sky130_fd_pr__nfet_01v8 l=0.6 w=1.4 as=0.406
+ ad=0.406 ps=3.38 pd=3.38
X$401 VSS cmc \$157 sky130_gnd sky130_fd_pr__nfet_01v8 l=0.6 w=1.4 as=0.406
+ ad=0.406 ps=3.38 pd=3.38
X$402 VSS bias_a \$157 sky130_gnd sky130_fd_pr__nfet_01v8 l=0.6 w=1.4 as=0.406
+ ad=0.406 ps=3.38 pd=3.38
X$403 VSS cmc \$157 sky130_gnd sky130_fd_pr__nfet_01v8 l=0.6 w=1.4 as=0.406
+ ad=0.406 ps=3.38 pd=3.38
X$404 VSS cmc \$157 sky130_gnd sky130_fd_pr__nfet_01v8 l=0.6 w=1.4 as=0.406
+ ad=0.406 ps=3.38 pd=3.38
X$405 VSS bias_a \$157 sky130_gnd sky130_fd_pr__nfet_01v8 l=0.6 w=1.4 as=0.406
+ ad=0.406 ps=3.38 pd=3.38
X$406 VSS cmc \$157 sky130_gnd sky130_fd_pr__nfet_01v8 l=0.6 w=1.4 as=0.406
+ ad=0.406 ps=3.38 pd=3.38
X$407 VSS bias_a \$157 sky130_gnd sky130_fd_pr__nfet_01v8 l=0.6 w=1.4 as=0.406
+ ad=0.406 ps=3.38 pd=3.38
X$408 VSS cmc \$157 sky130_gnd sky130_fd_pr__nfet_01v8 l=0.6 w=1.4 as=0.406
+ ad=0.406 ps=3.38 pd=3.38
X$409 VSS bias_a \$157 sky130_gnd sky130_fd_pr__nfet_01v8 l=0.6 w=1.4 as=0.406
+ ad=0.406 ps=3.38 pd=3.38
X$410 VSS cmc \$157 sky130_gnd sky130_fd_pr__nfet_01v8 l=0.6 w=1.4 as=0.406
+ ad=0.406 ps=3.38 pd=3.38
X$411 VSS bias_a \$157 sky130_gnd sky130_fd_pr__nfet_01v8 l=0.6 w=1.4 as=0.406
+ ad=0.406 ps=3.38 pd=3.38
X$412 VSS bias_a \$157 sky130_gnd sky130_fd_pr__nfet_01v8 l=0.6 w=1.4 as=0.406
+ ad=0.406 ps=3.38 pd=3.38
X$413 VSS bias_a \$157 sky130_gnd sky130_fd_pr__nfet_01v8 l=0.6 w=1.4 as=0.406
+ ad=0.406 ps=3.38 pd=3.38
X$414 VSS cmc \$157 sky130_gnd sky130_fd_pr__nfet_01v8 l=0.6 w=1.4 as=0.406
+ ad=0.406 ps=3.38 pd=3.38
X$415 VSS bias_a \$157 sky130_gnd sky130_fd_pr__nfet_01v8 l=0.6 w=1.4 as=0.406
+ ad=0.406 ps=3.38 pd=3.38
X$416 VSS cmc \$157 sky130_gnd sky130_fd_pr__nfet_01v8 l=0.6 w=1.4 as=0.406
+ ad=0.406 ps=3.38 pd=3.38
X$417 VSS bias_a \$157 sky130_gnd sky130_fd_pr__nfet_01v8 l=0.6 w=1.4 as=0.406
+ ad=0.406 ps=3.38 pd=3.38
X$418 VSS cmc \$157 sky130_gnd sky130_fd_pr__nfet_01v8 l=0.6 w=1.4 as=0.406
+ ad=0.406 ps=3.38 pd=3.38
X$419 VSS bias_a \$157 sky130_gnd sky130_fd_pr__nfet_01v8 l=0.6 w=1.4 as=0.406
+ ad=0.406 ps=3.38 pd=3.38
X$420 VSS cmc \$157 sky130_gnd sky130_fd_pr__nfet_01v8 l=0.6 w=1.4 as=0.406
+ ad=0.406 ps=3.38 pd=3.38
X$421 VSS bias_a \$157 sky130_gnd sky130_fd_pr__nfet_01v8 l=0.6 w=1.4 as=0.406
+ ad=0.406 ps=3.38 pd=3.38
X$422 VSS cmc \$157 sky130_gnd sky130_fd_pr__nfet_01v8 l=0.6 w=1.4 as=0.406
+ ad=0.406 ps=3.38 pd=3.38
X$423 VSS bias_a \$157 sky130_gnd sky130_fd_pr__nfet_01v8 l=0.6 w=1.4 as=0.406
+ ad=0.406 ps=3.38 pd=3.38
X$424 VSS cmc \$157 sky130_gnd sky130_fd_pr__nfet_01v8 l=0.6 w=1.4 as=0.406
+ ad=0.406 ps=3.38 pd=3.38
X$425 VSS cmc \$157 sky130_gnd sky130_fd_pr__nfet_01v8 l=0.6 w=1.4 as=0.406
+ ad=0.406 ps=3.38 pd=3.38
X$426 VSS cmc \$157 sky130_gnd sky130_fd_pr__nfet_01v8 l=0.6 w=1.4 as=0.406
+ ad=0.406 ps=3.38 pd=3.38
X$427 VSS bias_a \$157 sky130_gnd sky130_fd_pr__nfet_01v8 l=0.6 w=1.4 as=0.406
+ ad=0.406 ps=3.38 pd=3.38
X$428 VSS bias_a \$157 sky130_gnd sky130_fd_pr__nfet_01v8 l=0.6 w=1.4 as=0.406
+ ad=0.406 ps=3.38 pd=3.38
X$429 VSS cmc \$157 sky130_gnd sky130_fd_pr__nfet_01v8 l=0.6 w=1.4 as=0.406
+ ad=0.406 ps=3.38 pd=3.38
X$430 VSS bias_a \$157 sky130_gnd sky130_fd_pr__nfet_01v8 l=0.6 w=1.4 as=0.406
+ ad=0.406 ps=3.38 pd=3.38
X$431 VSS cmc \$157 sky130_gnd sky130_fd_pr__nfet_01v8 l=0.6 w=1.4 as=0.406
+ ad=0.406 ps=3.38 pd=3.38
X$432 VSS bias_a \$157 sky130_gnd sky130_fd_pr__nfet_01v8 l=0.6 w=1.4 as=0.406
+ ad=0.406 ps=3.38 pd=3.38
X$433 VSS cmc \$157 sky130_gnd sky130_fd_pr__nfet_01v8 l=0.6 w=1.4 as=0.406
+ ad=0.406 ps=3.38 pd=3.38
X$434 VSS bias_a \$157 sky130_gnd sky130_fd_pr__nfet_01v8 l=0.6 w=1.4 as=0.406
+ ad=0.406 ps=3.38 pd=3.38
X$435 VSS cmc \$157 sky130_gnd sky130_fd_pr__nfet_01v8 l=0.6 w=1.4 as=0.406
+ ad=0.406 ps=3.38 pd=3.38
X$436 VSS bias_a \$157 sky130_gnd sky130_fd_pr__nfet_01v8 l=0.6 w=1.4 as=0.406
+ ad=0.406 ps=3.38 pd=3.38
X$437 VSS cmc \$157 sky130_gnd sky130_fd_pr__nfet_01v8 l=0.6 w=1.4 as=0.406
+ ad=0.406 ps=3.38 pd=3.38
X$438 VSS bias_a \$157 sky130_gnd sky130_fd_pr__nfet_01v8 l=0.6 w=1.4 as=0.406
+ ad=0.406 ps=3.38 pd=3.38
X$439 VSS cmc \$157 sky130_gnd sky130_fd_pr__nfet_01v8 l=0.6 w=1.4 as=0.406
+ ad=0.406 ps=3.38 pd=3.38
X$440 VSS bias_a \$157 sky130_gnd sky130_fd_pr__nfet_01v8 l=0.6 w=1.4 as=0.406
+ ad=0.406 ps=3.38 pd=3.38
X$441 VSS cmc \$157 sky130_gnd sky130_fd_pr__nfet_01v8 l=0.6 w=1.4 as=0.406
+ ad=0.406 ps=3.38 pd=3.38
X$442 VSS bias_a \$157 sky130_gnd sky130_fd_pr__nfet_01v8 l=0.6 w=1.4 as=0.406
+ ad=0.406 ps=3.38 pd=3.38
X$443 VSS cmc \$157 sky130_gnd sky130_fd_pr__nfet_01v8 l=0.6 w=1.4 as=0.406
+ ad=0.406 ps=3.38 pd=3.38
X$444 VSS bias_a \$157 sky130_gnd sky130_fd_pr__nfet_01v8 l=0.6 w=1.4 as=0.406
+ ad=0.406 ps=3.38 pd=3.38
X$445 VSS cmc \$157 sky130_gnd sky130_fd_pr__nfet_01v8 l=0.6 w=1.4 as=0.406
+ ad=0.406 ps=3.38 pd=3.38
X$446 VSS bias_a \$157 sky130_gnd sky130_fd_pr__nfet_01v8 l=0.6 w=1.4 as=0.406
+ ad=0.406 ps=3.38 pd=3.38
X$447 VSS cmc \$157 sky130_gnd sky130_fd_pr__nfet_01v8 l=0.6 w=1.4 as=0.406
+ ad=0.406 ps=3.38 pd=3.38
X$448 VSS bias_a \$157 sky130_gnd sky130_fd_pr__nfet_01v8 l=0.6 w=1.4 as=0.406
+ ad=0.406 ps=3.38 pd=3.38
X$449 VSS cmc \$157 sky130_gnd sky130_fd_pr__nfet_01v8 l=0.6 w=1.4 as=0.406
+ ad=0.406 ps=3.38 pd=3.38
X$450 VSS cmc \$157 sky130_gnd sky130_fd_pr__nfet_01v8 l=0.6 w=1.4 as=0.406
+ ad=0.406 ps=3.38 pd=3.38
X$451 VSS cmc \$157 sky130_gnd sky130_fd_pr__nfet_01v8 l=0.6 w=1.4 as=0.406
+ ad=0.406 ps=3.38 pd=3.38
X$452 VSS bias_a \$157 sky130_gnd sky130_fd_pr__nfet_01v8 l=0.6 w=1.4 as=0.406
+ ad=0.406 ps=3.38 pd=3.38
X$453 VSS bias_a \$157 sky130_gnd sky130_fd_pr__nfet_01v8 l=0.6 w=1.4 as=0.406
+ ad=0.406 ps=3.38 pd=3.38
X$454 VSS bias_a \$157 sky130_gnd sky130_fd_pr__nfet_01v8 l=0.6 w=1.4 as=0.406
+ ad=0.406 ps=3.38 pd=3.38
X$455 VSS cmc \$157 sky130_gnd sky130_fd_pr__nfet_01v8 l=0.6 w=1.4 as=0.406
+ ad=0.406 ps=3.38 pd=3.38
X$456 VSS cmc \$157 sky130_gnd sky130_fd_pr__nfet_01v8 l=0.6 w=1.4 as=0.406
+ ad=0.406 ps=3.38 pd=3.38
X$457 VSS cmc \$157 sky130_gnd sky130_fd_pr__nfet_01v8 l=0.6 w=1.4 as=0.406
+ ad=0.406 ps=3.38 pd=3.38
X$458 VSS cmc \$157 sky130_gnd sky130_fd_pr__nfet_01v8 l=0.6 w=1.4 as=0.406
+ ad=0.406 ps=3.38 pd=3.38
X$459 VSS bias_a \$157 sky130_gnd sky130_fd_pr__nfet_01v8 l=0.6 w=1.4 as=0.406
+ ad=0.406 ps=3.38 pd=3.38
X$460 VSS bias_a \$157 sky130_gnd sky130_fd_pr__nfet_01v8 l=0.6 w=1.4 as=0.406
+ ad=0.406 ps=3.38 pd=3.38
X$461 VSS cmc \$157 sky130_gnd sky130_fd_pr__nfet_01v8 l=0.6 w=1.4 as=0.406
+ ad=0.406 ps=3.38 pd=3.38
X$462 VSS bias_a \$157 sky130_gnd sky130_fd_pr__nfet_01v8 l=0.6 w=1.4 as=0.406
+ ad=0.406 ps=3.38 pd=3.38
X$463 VSS bias_a \$157 sky130_gnd sky130_fd_pr__nfet_01v8 l=0.6 w=1.4 as=0.406
+ ad=0.406 ps=3.38 pd=3.38
X$464 VSS bias_a \$157 sky130_gnd sky130_fd_pr__nfet_01v8 l=0.6 w=1.4 as=0.406
+ ad=0.406 ps=3.38 pd=3.38
X$465 VSS cmc \$157 sky130_gnd sky130_fd_pr__nfet_01v8 l=0.6 w=1.4 as=0.406
+ ad=0.406 ps=3.38 pd=3.38
X$466 VSS bias_a \$157 sky130_gnd sky130_fd_pr__nfet_01v8 l=0.6 w=1.4 as=0.406
+ ad=0.406 ps=3.38 pd=3.38
X$467 VSS bias_a \$157 sky130_gnd sky130_fd_pr__nfet_01v8 l=0.6 w=1.4 as=0.406
+ ad=0.406 ps=3.38 pd=3.38
X$468 VSS bias_a \$157 sky130_gnd sky130_fd_pr__nfet_01v8 l=0.6 w=1.4 as=0.406
+ ad=0.406 ps=3.38 pd=3.38
X$469 VSS cmc \$157 sky130_gnd sky130_fd_pr__nfet_01v8 l=0.6 w=1.4 as=0.406
+ ad=0.406 ps=3.38 pd=3.38
X$470 VSS cmc \$157 sky130_gnd sky130_fd_pr__nfet_01v8 l=0.6 w=1.4 as=0.406
+ ad=0.406 ps=3.38 pd=3.38
X$471 VSS cmc \$157 sky130_gnd sky130_fd_pr__nfet_01v8 l=0.6 w=1.4 as=0.406
+ ad=0.406 ps=3.38 pd=3.38
X$472 VSS cmc \$157 sky130_gnd sky130_fd_pr__nfet_01v8 l=0.6 w=1.4 as=0.406
+ ad=0.406 ps=3.38 pd=3.38
X$473 VSS bias_a \$157 sky130_gnd sky130_fd_pr__nfet_01v8 l=0.6 w=1.4 as=0.406
+ ad=0.406 ps=3.38 pd=3.38
X$474 VSS bias_a \$157 sky130_gnd sky130_fd_pr__nfet_01v8 l=0.6 w=1.4 as=0.406
+ ad=0.406 ps=3.38 pd=3.38
X$475 VSS cmc \$157 sky130_gnd sky130_fd_pr__nfet_01v8 l=0.6 w=1.4 as=0.406
+ ad=0.406 ps=3.38 pd=3.38
X$476 VSS cmc \$157 sky130_gnd sky130_fd_pr__nfet_01v8 l=0.6 w=1.4 as=0.406
+ ad=0.406 ps=3.38 pd=3.38
X$477 VSS cmc \$157 sky130_gnd sky130_fd_pr__nfet_01v8 l=0.6 w=1.4 as=0.406
+ ad=0.406 ps=3.38 pd=3.38
X$478 VSS cmc \$157 sky130_gnd sky130_fd_pr__nfet_01v8 l=0.6 w=1.4 as=0.406
+ ad=0.406 ps=3.38 pd=3.38
X$479 VSS bias_a \$157 sky130_gnd sky130_fd_pr__nfet_01v8 l=0.6 w=1.4 as=0.406
+ ad=0.406 ps=3.38 pd=3.38
X$480 VSS bias_a \$157 sky130_gnd sky130_fd_pr__nfet_01v8 l=0.6 w=1.4 as=0.406
+ ad=0.406 ps=3.38 pd=3.38
X$481 VSS cmc \$157 sky130_gnd sky130_fd_pr__nfet_01v8 l=0.6 w=1.4 as=0.406
+ ad=0.406 ps=3.38 pd=3.38
X$482 VSS cmc \$157 sky130_gnd sky130_fd_pr__nfet_01v8 l=0.6 w=1.4 as=0.406
+ ad=0.406 ps=3.38 pd=3.38
X$483 VSS bias_a \$157 sky130_gnd sky130_fd_pr__nfet_01v8 l=0.6 w=1.4 as=0.406
+ ad=0.406 ps=3.38 pd=3.38
X$484 VSS cmc \$157 sky130_gnd sky130_fd_pr__nfet_01v8 l=0.6 w=1.4 as=0.406
+ ad=0.406 ps=3.38 pd=3.38
X$485 VSS bias_a \$157 sky130_gnd sky130_fd_pr__nfet_01v8 l=0.6 w=1.4 as=0.406
+ ad=0.406 ps=3.38 pd=3.38
X$486 VSS cmc \$157 sky130_gnd sky130_fd_pr__nfet_01v8 l=0.6 w=1.4 as=0.406
+ ad=0.406 ps=3.38 pd=3.38
X$487 VSS bias_a \$157 sky130_gnd sky130_fd_pr__nfet_01v8 l=0.6 w=1.4 as=0.406
+ ad=0.406 ps=3.38 pd=3.38
X$488 VSS bias_a \$157 sky130_gnd sky130_fd_pr__nfet_01v8 l=0.6 w=1.4 as=0.406
+ ad=0.406 ps=3.38 pd=3.38
X$489 VSS bias_a \$157 sky130_gnd sky130_fd_pr__nfet_01v8 l=0.6 w=1.4 as=0.406
+ ad=0.406 ps=3.38 pd=3.38
X$490 VSS cmc \$157 sky130_gnd sky130_fd_pr__nfet_01v8 l=0.6 w=1.4 as=0.406
+ ad=0.406 ps=3.38 pd=3.38
X$491 VSS bias_a \$157 sky130_gnd sky130_fd_pr__nfet_01v8 l=0.6 w=1.4 as=0.406
+ ad=0.406 ps=3.38 pd=3.38
X$492 VSS cmc \$157 sky130_gnd sky130_fd_pr__nfet_01v8 l=0.6 w=1.4 as=0.406
+ ad=0.406 ps=3.38 pd=3.38
X$493 VSS cmc \$157 sky130_gnd sky130_fd_pr__nfet_01v8 l=0.6 w=1.4 as=0.406
+ ad=0.406 ps=3.38 pd=3.38
X$494 VSS bias_a \$157 sky130_gnd sky130_fd_pr__nfet_01v8 l=0.6 w=1.4 as=0.406
+ ad=0.406 ps=3.38 pd=3.38
X$495 VSS bias_a \$157 sky130_gnd sky130_fd_pr__nfet_01v8 l=0.6 w=1.4 as=0.406
+ ad=0.406 ps=3.38 pd=3.38
X$496 VSS cmc \$157 sky130_gnd sky130_fd_pr__nfet_01v8 l=0.6 w=1.4 as=0.406
+ ad=0.406 ps=3.38 pd=3.38
X$497 VSS cmc \$157 sky130_gnd sky130_fd_pr__nfet_01v8 l=0.6 w=1.4 as=0.406
+ ad=0.406 ps=3.38 pd=3.38
X$498 VSS bias_a \$157 sky130_gnd sky130_fd_pr__nfet_01v8 l=0.6 w=1.4 as=0.406
+ ad=0.406 ps=3.38 pd=3.38
X$499 VSS bias_a \$157 sky130_gnd sky130_fd_pr__nfet_01v8 l=0.6 w=1.4 as=0.406
+ ad=0.406 ps=3.38 pd=3.38
X$500 VSS cmc \$157 sky130_gnd sky130_fd_pr__nfet_01v8 l=0.6 w=1.4 as=0.406
+ ad=0.406 ps=3.38 pd=3.38
X$501 VSS cmc \$157 sky130_gnd sky130_fd_pr__nfet_01v8 l=0.6 w=1.4 as=0.406
+ ad=0.406 ps=3.38 pd=3.38
X$502 VSS bias_a \$157 sky130_gnd sky130_fd_pr__nfet_01v8 l=0.6 w=1.4 as=0.406
+ ad=0.406 ps=3.38 pd=3.38
X$503 VSS bias_a \$157 sky130_gnd sky130_fd_pr__nfet_01v8 l=0.6 w=1.4 as=0.406
+ ad=0.406 ps=3.38 pd=3.38
X$504 VSS cmc \$157 sky130_gnd sky130_fd_pr__nfet_01v8 l=0.6 w=1.4 as=0.406
+ ad=0.406 ps=3.38 pd=3.38
X$505 VSS cmc \$157 sky130_gnd sky130_fd_pr__nfet_01v8 l=0.6 w=1.4 as=0.406
+ ad=0.406 ps=3.38 pd=3.38
X$506 VSS bias_a \$157 sky130_gnd sky130_fd_pr__nfet_01v8 l=0.6 w=1.4 as=0.406
+ ad=0.406 ps=3.38 pd=3.38
X$507 VSS bias_a \$157 sky130_gnd sky130_fd_pr__nfet_01v8 l=0.6 w=1.4 as=0.406
+ ad=0.406 ps=3.38 pd=3.38
X$508 VSS cmc \$157 sky130_gnd sky130_fd_pr__nfet_01v8 l=0.6 w=1.4 as=0.406
+ ad=0.406 ps=3.38 pd=3.38
X$509 VSS bias_a \$157 sky130_gnd sky130_fd_pr__nfet_01v8 l=0.6 w=1.4 as=0.406
+ ad=0.406 ps=3.38 pd=3.38
X$510 VSS cmc \$157 sky130_gnd sky130_fd_pr__nfet_01v8 l=0.6 w=1.4 as=0.406
+ ad=0.406 ps=3.38 pd=3.38
X$511 VSS bias_a \$157 sky130_gnd sky130_fd_pr__nfet_01v8 l=0.6 w=1.4 as=0.406
+ ad=0.406 ps=3.38 pd=3.38
X$512 VSS cmc \$157 sky130_gnd sky130_fd_pr__nfet_01v8 l=0.6 w=1.4 as=0.406
+ ad=0.406 ps=3.38 pd=3.38
X$513 VSS bias_a \$157 sky130_gnd sky130_fd_pr__nfet_01v8 l=0.6 w=1.4 as=0.406
+ ad=0.406 ps=3.38 pd=3.38
X$514 VSS cmc \$157 sky130_gnd sky130_fd_pr__nfet_01v8 l=0.6 w=1.4 as=0.406
+ ad=0.406 ps=3.38 pd=3.38
X$515 VSS bias_a \$157 sky130_gnd sky130_fd_pr__nfet_01v8 l=0.6 w=1.4 as=0.406
+ ad=0.406 ps=3.38 pd=3.38
X$516 VSS cmc \$157 sky130_gnd sky130_fd_pr__nfet_01v8 l=0.6 w=1.4 as=0.406
+ ad=0.406 ps=3.38 pd=3.38
X$517 VSS cmc \$157 sky130_gnd sky130_fd_pr__nfet_01v8 l=0.6 w=1.4 as=0.406
+ ad=0.406 ps=3.38 pd=3.38
X$518 VSS bias_a \$157 sky130_gnd sky130_fd_pr__nfet_01v8 l=0.6 w=1.4 as=0.406
+ ad=0.406 ps=3.38 pd=3.38
X$519 VSS bias_a \$157 sky130_gnd sky130_fd_pr__nfet_01v8 l=0.6 w=1.4 as=0.406
+ ad=0.406 ps=3.38 pd=3.38
X$520 VSS bias_a \$157 sky130_gnd sky130_fd_pr__nfet_01v8 l=0.6 w=1.4 as=0.406
+ ad=0.406 ps=3.38 pd=3.38
X$521 VSS cmc \$157 sky130_gnd sky130_fd_pr__nfet_01v8 l=0.6 w=1.4 as=0.406
+ ad=0.406 ps=3.38 pd=3.38
X$522 VSS bias_a \$157 sky130_gnd sky130_fd_pr__nfet_01v8 l=0.6 w=1.4 as=0.406
+ ad=0.406 ps=3.38 pd=3.38
X$523 VSS cmc \$157 sky130_gnd sky130_fd_pr__nfet_01v8 l=0.6 w=1.4 as=0.406
+ ad=0.406 ps=3.38 pd=3.38
X$524 VSS bias_a \$157 sky130_gnd sky130_fd_pr__nfet_01v8 l=0.6 w=1.4 as=0.406
+ ad=0.406 ps=3.38 pd=3.38
X$525 VSS cmc \$157 sky130_gnd sky130_fd_pr__nfet_01v8 l=0.6 w=1.4 as=0.406
+ ad=0.406 ps=3.38 pd=3.38
X$526 VSS bias_a \$157 sky130_gnd sky130_fd_pr__nfet_01v8 l=0.6 w=1.4 as=0.406
+ ad=0.406 ps=3.38 pd=3.38
X$527 VSS cmc \$157 sky130_gnd sky130_fd_pr__nfet_01v8 l=0.6 w=1.4 as=0.406
+ ad=0.406 ps=3.38 pd=3.38
X$528 VSS bias_a \$157 sky130_gnd sky130_fd_pr__nfet_01v8 l=0.6 w=1.4 as=0.406
+ ad=0.406 ps=3.38 pd=3.38
X$529 VSS cmc \$157 sky130_gnd sky130_fd_pr__nfet_01v8 l=0.6 w=1.4 as=0.406
+ ad=0.406 ps=3.38 pd=3.38
X$530 VSS bias_a \$157 sky130_gnd sky130_fd_pr__nfet_01v8 l=0.6 w=1.4 as=0.406
+ ad=0.406 ps=3.38 pd=3.38
X$531 VSS cmc \$157 sky130_gnd sky130_fd_pr__nfet_01v8 l=0.6 w=1.4 as=0.406
+ ad=0.406 ps=3.38 pd=3.38
X$532 VSS bias_a \$157 sky130_gnd sky130_fd_pr__nfet_01v8 l=0.6 w=1.4 as=0.406
+ ad=0.406 ps=3.38 pd=3.38
X$533 VSS cmc \$157 sky130_gnd sky130_fd_pr__nfet_01v8 l=0.6 w=1.4 as=0.406
+ ad=0.406 ps=3.38 pd=3.38
X$534 VSS bias_a \$157 sky130_gnd sky130_fd_pr__nfet_01v8 l=0.6 w=1.4 as=0.406
+ ad=0.406 ps=3.38 pd=3.38
X$535 VSS cmc \$157 sky130_gnd sky130_fd_pr__nfet_01v8 l=0.6 w=1.4 as=0.406
+ ad=0.406 ps=3.38 pd=3.38
X$536 VSS bias_a \$157 sky130_gnd sky130_fd_pr__nfet_01v8 l=0.6 w=1.4 as=0.406
+ ad=0.406 ps=3.38 pd=3.38
X$537 VSS cmc \$157 sky130_gnd sky130_fd_pr__nfet_01v8 l=0.6 w=1.4 as=0.406
+ ad=0.406 ps=3.38 pd=3.38
X$538 VSS bias_a \$157 sky130_gnd sky130_fd_pr__nfet_01v8 l=0.6 w=1.4 as=0.406
+ ad=0.406 ps=3.38 pd=3.38
X$539 VSS cmc \$157 sky130_gnd sky130_fd_pr__nfet_01v8 l=0.6 w=1.4 as=0.406
+ ad=0.406 ps=3.38 pd=3.38
X$540 VSS bias_a \$157 sky130_gnd sky130_fd_pr__nfet_01v8 l=0.6 w=1.4 as=0.406
+ ad=0.406 ps=3.38 pd=3.38
X$541 VSS cmc \$157 sky130_gnd sky130_fd_pr__nfet_01v8 l=0.6 w=1.4 as=0.406
+ ad=0.406 ps=3.38 pd=3.38
X$542 VSS bias_a \$157 sky130_gnd sky130_fd_pr__nfet_01v8 l=0.6 w=1.4 as=0.406
+ ad=0.406 ps=3.38 pd=3.38
X$543 VSS cmc \$157 sky130_gnd sky130_fd_pr__nfet_01v8 l=0.6 w=1.4 as=0.406
+ ad=0.406 ps=3.38 pd=3.38
X$544 VSS cmc \$157 sky130_gnd sky130_fd_pr__nfet_01v8 l=0.6 w=1.4 as=0.406
+ ad=0.406 ps=3.38 pd=3.38
X$545 VSS bias_a \$157 sky130_gnd sky130_fd_pr__nfet_01v8 l=0.6 w=1.4 as=0.406
+ ad=0.406 ps=3.38 pd=3.38
X$546 VSS cmc \$157 sky130_gnd sky130_fd_pr__nfet_01v8 l=0.6 w=1.4 as=0.406
+ ad=0.406 ps=3.38 pd=3.38
X$547 VSS bias_a \$157 sky130_gnd sky130_fd_pr__nfet_01v8 l=0.6 w=1.4 as=0.406
+ ad=0.406 ps=3.38 pd=3.38
X$548 VSS cmc \$157 sky130_gnd sky130_fd_pr__nfet_01v8 l=0.6 w=1.4 as=0.406
+ ad=0.406 ps=3.38 pd=3.38
X$549 VSS bias_a \$157 sky130_gnd sky130_fd_pr__nfet_01v8 l=0.6 w=1.4 as=0.406
+ ad=0.406 ps=3.38 pd=3.38
X$550 VSS cmc \$157 sky130_gnd sky130_fd_pr__nfet_01v8 l=0.6 w=1.4 as=0.406
+ ad=0.406 ps=3.38 pd=3.38
X$551 VSS bias_a \$157 sky130_gnd sky130_fd_pr__nfet_01v8 l=0.6 w=1.4 as=0.406
+ ad=0.406 ps=3.38 pd=3.38
X$552 VSS cmc \$157 sky130_gnd sky130_fd_pr__nfet_01v8 l=0.6 w=1.4 as=0.406
+ ad=0.406 ps=3.38 pd=3.38
X$553 VSS bias_a \$157 sky130_gnd sky130_fd_pr__nfet_01v8 l=0.6 w=1.4 as=0.406
+ ad=0.406 ps=3.38 pd=3.38
X$554 VSS bias_a \$157 sky130_gnd sky130_fd_pr__nfet_01v8 l=0.6 w=1.4 as=0.406
+ ad=0.406 ps=3.38 pd=3.38
X$555 VSS cmc \$157 sky130_gnd sky130_fd_pr__nfet_01v8 l=0.6 w=1.4 as=0.406
+ ad=0.406 ps=3.38 pd=3.38
X$556 VSS cmc \$157 sky130_gnd sky130_fd_pr__nfet_01v8 l=0.6 w=1.4 as=0.406
+ ad=0.406 ps=3.38 pd=3.38
X$557 VSS bias_a \$157 sky130_gnd sky130_fd_pr__nfet_01v8 l=0.6 w=1.4 as=0.406
+ ad=0.406 ps=3.38 pd=3.38
X$558 VSS cmc \$157 sky130_gnd sky130_fd_pr__nfet_01v8 l=0.6 w=1.4 as=0.406
+ ad=0.406 ps=3.38 pd=3.38
X$559 VSS bias_a \$157 sky130_gnd sky130_fd_pr__nfet_01v8 l=0.6 w=1.4 as=0.406
+ ad=0.406 ps=3.38 pd=3.38
X$560 VSS cmc \$157 sky130_gnd sky130_fd_pr__nfet_01v8 l=0.6 w=1.4 as=0.406
+ ad=0.406 ps=3.38 pd=3.38
X$561 VSS bias_a \$157 sky130_gnd sky130_fd_pr__nfet_01v8 l=0.6 w=1.4 as=0.406
+ ad=0.406 ps=3.38 pd=3.38
X$562 VSS cmc \$157 sky130_gnd sky130_fd_pr__nfet_01v8 l=0.6 w=1.4 as=0.406
+ ad=0.406 ps=3.38 pd=3.38
X$563 VSS bias_a \$157 sky130_gnd sky130_fd_pr__nfet_01v8 l=0.6 w=1.4 as=0.406
+ ad=0.406 ps=3.38 pd=3.38
X$564 VSS cmc \$157 sky130_gnd sky130_fd_pr__nfet_01v8 l=0.6 w=1.4 as=0.406
+ ad=0.406 ps=3.38 pd=3.38
X$565 VSS bias_a \$157 sky130_gnd sky130_fd_pr__nfet_01v8 l=0.6 w=1.4 as=0.406
+ ad=0.406 ps=3.38 pd=3.38
X$566 VSS bias_a \$157 sky130_gnd sky130_fd_pr__nfet_01v8 l=0.6 w=1.4 as=0.406
+ ad=0.406 ps=3.38 pd=3.38
X$567 VSS cmc \$157 sky130_gnd sky130_fd_pr__nfet_01v8 l=0.6 w=1.4 as=0.406
+ ad=0.406 ps=3.38 pd=3.38
X$568 VSS IBIAS \$150 sky130_gnd sky130_fd_pr__nfet_01v8 l=0.6 w=1.4 as=0.406
+ ad=0.406 ps=3.38 pd=3.38
X$569 VSS IBIAS \$150 sky130_gnd sky130_fd_pr__nfet_01v8 l=0.6 w=1.4 as=0.406
+ ad=0.406 ps=3.38 pd=3.38
X$570 VSS IBIAS \$150 sky130_gnd sky130_fd_pr__nfet_01v8 l=0.6 w=1.4 as=0.406
+ ad=0.406 ps=3.38 pd=3.38
X$571 VSS IBIAS \$150 sky130_gnd sky130_fd_pr__nfet_01v8 l=0.6 w=1.4 as=0.406
+ ad=0.406 ps=3.38 pd=3.38
X$572 VSS IBIAS \$150 sky130_gnd sky130_fd_pr__nfet_01v8 l=0.6 w=1.4 as=0.406
+ ad=0.406 ps=3.38 pd=3.38
X$573 VSS IBIAS \$150 sky130_gnd sky130_fd_pr__nfet_01v8 l=0.6 w=1.4 as=0.406
+ ad=0.406 ps=3.38 pd=3.38
X$574 VSS IBIAS \$150 sky130_gnd sky130_fd_pr__nfet_01v8 l=0.6 w=1.4 as=0.406
+ ad=0.406 ps=3.38 pd=3.38
X$575 VSS IBIAS \$150 sky130_gnd sky130_fd_pr__nfet_01v8 l=0.6 w=1.4 as=0.406
+ ad=0.406 ps=3.38 pd=3.38
X$576 VSS IBIAS \$150 sky130_gnd sky130_fd_pr__nfet_01v8 l=0.6 w=1.4 as=0.406
+ ad=0.406 ps=3.38 pd=3.38
X$577 VSS IBIAS \$150 sky130_gnd sky130_fd_pr__nfet_01v8 l=0.6 w=1.4 as=0.406
+ ad=0.406 ps=3.38 pd=3.38
X$578 VSS IBIAS \$150 sky130_gnd sky130_fd_pr__nfet_01v8 l=0.6 w=1.4 as=0.406
+ ad=0.406 ps=3.38 pd=3.38
X$579 VSS IBIAS \$150 sky130_gnd sky130_fd_pr__nfet_01v8 l=0.6 w=1.4 as=0.406
+ ad=0.406 ps=3.38 pd=3.38
X$580 VSS IBIAS \$150 sky130_gnd sky130_fd_pr__nfet_01v8 l=0.6 w=1.4 as=0.406
+ ad=0.406 ps=3.38 pd=3.38
X$581 VSS IBIAS \$150 sky130_gnd sky130_fd_pr__nfet_01v8 l=0.6 w=1.4 as=0.406
+ ad=0.406 ps=3.38 pd=3.38
X$582 VSS IBIAS \$150 sky130_gnd sky130_fd_pr__nfet_01v8 l=0.6 w=1.4 as=0.406
+ ad=0.406 ps=3.38 pd=3.38
X$583 VSS IBIAS \$150 sky130_gnd sky130_fd_pr__nfet_01v8 l=0.6 w=1.4 as=0.406
+ ad=0.406 ps=3.38 pd=3.38
X$584 VSS IBIAS \$150 sky130_gnd sky130_fd_pr__nfet_01v8 l=0.6 w=1.4 as=0.406
+ ad=0.406 ps=3.38 pd=3.38
X$585 VSS IBIAS \$150 sky130_gnd sky130_fd_pr__nfet_01v8 l=0.6 w=1.4 as=0.406
+ ad=0.406 ps=3.38 pd=3.38
X$586 VSS IBIAS IBIAS sky130_gnd sky130_fd_pr__nfet_01v8 l=0.6 w=1.4 as=0.406
+ ad=0.406 ps=3.38 pd=3.38
X$587 VSS IBIAS IBIAS sky130_gnd sky130_fd_pr__nfet_01v8 l=0.6 w=1.4 as=0.406
+ ad=0.406 ps=3.38 pd=3.38
X$588 VSS IBIAS IBIAS sky130_gnd sky130_fd_pr__nfet_01v8 l=0.6 w=1.4 as=0.406
+ ad=0.406 ps=3.38 pd=3.38
X$589 VSS IBIAS IBIAS sky130_gnd sky130_fd_pr__nfet_01v8 l=0.6 w=1.4 as=0.406
+ ad=0.406 ps=3.38 pd=3.38
X$590 VSS IBIAS IBIAS sky130_gnd sky130_fd_pr__nfet_01v8 l=0.6 w=1.4 as=0.406
+ ad=0.406 ps=3.38 pd=3.38
X$591 VSS IBIAS IBIAS sky130_gnd sky130_fd_pr__nfet_01v8 l=0.6 w=1.4 as=0.406
+ ad=0.406 ps=3.38 pd=3.38
X$592 VSS IBIAS IBIAS sky130_gnd sky130_fd_pr__nfet_01v8 l=0.6 w=1.4 as=0.406
+ ad=0.406 ps=3.38 pd=3.38
X$593 VSS IBIAS IBIAS sky130_gnd sky130_fd_pr__nfet_01v8 l=0.6 w=1.4 as=0.406
+ ad=0.406 ps=3.38 pd=3.38
X$594 VSS IBIAS IBIAS sky130_gnd sky130_fd_pr__nfet_01v8 l=0.6 w=1.4 as=0.406
+ ad=0.406 ps=3.38 pd=3.38
X$595 VSS IBIAS IBIAS sky130_gnd sky130_fd_pr__nfet_01v8 l=0.6 w=1.4 as=0.406
+ ad=0.406 ps=3.38 pd=3.38
X$596 VSS IBIAS IBIAS sky130_gnd sky130_fd_pr__nfet_01v8 l=0.6 w=1.4 as=0.406
+ ad=0.406 ps=3.38 pd=3.38
X$597 VSS IBIAS IBIAS sky130_gnd sky130_fd_pr__nfet_01v8 l=0.6 w=1.4 as=0.406
+ ad=0.406 ps=3.38 pd=3.38
X$598 VSS IBIAS IBIAS sky130_gnd sky130_fd_pr__nfet_01v8 l=0.6 w=1.4 as=0.406
+ ad=0.406 ps=3.38 pd=3.38
X$599 VSS IBIAS IBIAS sky130_gnd sky130_fd_pr__nfet_01v8 l=0.6 w=1.4 as=0.406
+ ad=0.406 ps=3.38 pd=3.38
X$600 VSS IBIAS IBIAS sky130_gnd sky130_fd_pr__nfet_01v8 l=0.6 w=1.4 as=0.406
+ ad=0.406 ps=3.38 pd=3.38
X$601 VSS IBIAS IBIAS sky130_gnd sky130_fd_pr__nfet_01v8 l=0.6 w=1.4 as=0.406
+ ad=0.406 ps=3.38 pd=3.38
X$602 VSS IBIAS IBIAS sky130_gnd sky130_fd_pr__nfet_01v8 l=0.6 w=1.4 as=0.406
+ ad=0.406 ps=3.38 pd=3.38
X$603 VSS IBIAS IBIAS sky130_gnd sky130_fd_pr__nfet_01v8 l=0.6 w=1.4 as=0.406
+ ad=0.406 ps=3.38 pd=3.38
X$604 \$1 \$11 bias_a sky130_gnd sky130_fd_pr__nfet_01v8 l=0.6 w=1.4 as=0.406
+ ad=0.406 ps=3.38 pd=3.38
X$605 \$1 \$11 bias_a sky130_gnd sky130_fd_pr__nfet_01v8 l=0.6 w=1.4 as=0.406
+ ad=0.406 ps=3.38 pd=3.38
X$606 \$1 \$11 bias_a sky130_gnd sky130_fd_pr__nfet_01v8 l=0.6 w=1.4 as=0.406
+ ad=0.406 ps=3.38 pd=3.38
X$607 \$1 \$11 bias_a sky130_gnd sky130_fd_pr__nfet_01v8 l=0.6 w=1.4 as=0.406
+ ad=0.406 ps=3.38 pd=3.38
X$608 \$1 \$11 bias_a sky130_gnd sky130_fd_pr__nfet_01v8 l=0.6 w=1.4 as=0.406
+ ad=0.406 ps=3.38 pd=3.38
X$609 \$1 \$11 bias_a sky130_gnd sky130_fd_pr__nfet_01v8 l=0.6 w=1.4 as=0.406
+ ad=0.406 ps=3.38 pd=3.38
X$610 \$1 \$11 bias_a sky130_gnd sky130_fd_pr__nfet_01v8 l=0.6 w=1.4 as=0.406
+ ad=0.406 ps=3.38 pd=3.38
X$611 \$1 \$11 bias_a sky130_gnd sky130_fd_pr__nfet_01v8 l=0.6 w=1.4 as=0.406
+ ad=0.406 ps=3.38 pd=3.38
X$612 \$1 \$11 bias_a sky130_gnd sky130_fd_pr__nfet_01v8 l=0.6 w=1.4 as=0.406
+ ad=0.406 ps=3.38 pd=3.38
X$613 \$1 \$11 bias_a sky130_gnd sky130_fd_pr__nfet_01v8 l=0.6 w=1.4 as=0.406
+ ad=0.406 ps=3.38 pd=3.38
X$614 \$1 \$11 bias_a sky130_gnd sky130_fd_pr__nfet_01v8 l=0.6 w=1.4 as=0.406
+ ad=0.406 ps=3.38 pd=3.38
X$615 \$1 \$11 bias_a sky130_gnd sky130_fd_pr__nfet_01v8 l=0.6 w=1.4 as=0.406
+ ad=0.406 ps=3.38 pd=3.38
X$616 \$1 \$11 bias_a sky130_gnd sky130_fd_pr__nfet_01v8 l=0.6 w=1.4 as=0.406
+ ad=0.406 ps=3.38 pd=3.38
X$617 \$1 \$11 bias_a sky130_gnd sky130_fd_pr__nfet_01v8 l=0.6 w=1.4 as=0.406
+ ad=0.406 ps=3.38 pd=3.38
X$618 \$1 \$11 bias_a sky130_gnd sky130_fd_pr__nfet_01v8 l=0.6 w=1.4 as=0.406
+ ad=0.406 ps=3.38 pd=3.38
X$619 \$1 \$11 bias_a sky130_gnd sky130_fd_pr__nfet_01v8 l=0.6 w=1.4 as=0.406
+ ad=0.406 ps=3.38 pd=3.38
X$620 \$1 \$11 bias_a sky130_gnd sky130_fd_pr__nfet_01v8 l=0.6 w=1.4 as=0.406
+ ad=0.406 ps=3.38 pd=3.38
X$621 \$1 \$11 bias_a sky130_gnd sky130_fd_pr__nfet_01v8 l=0.6 w=1.4 as=0.406
+ ad=0.406 ps=3.38 pd=3.38
X$622 VSS bias_a \$1 sky130_gnd sky130_fd_pr__nfet_01v8 l=0.6 w=1.4 as=0.406
+ ad=0.406 ps=3.38 pd=3.38
X$623 VSS bias_a \$1 sky130_gnd sky130_fd_pr__nfet_01v8 l=0.6 w=1.4 as=0.406
+ ad=0.406 ps=3.38 pd=3.38
X$624 VSS bias_a \$1 sky130_gnd sky130_fd_pr__nfet_01v8 l=0.6 w=1.4 as=0.406
+ ad=0.406 ps=3.38 pd=3.38
X$625 VSS bias_a \$1 sky130_gnd sky130_fd_pr__nfet_01v8 l=0.6 w=1.4 as=0.406
+ ad=0.406 ps=3.38 pd=3.38
X$626 VSS bias_a \$1 sky130_gnd sky130_fd_pr__nfet_01v8 l=0.6 w=1.4 as=0.406
+ ad=0.406 ps=3.38 pd=3.38
X$627 VSS bias_a \$1 sky130_gnd sky130_fd_pr__nfet_01v8 l=0.6 w=1.4 as=0.406
+ ad=0.406 ps=3.38 pd=3.38
X$628 VSS bias_a \$1 sky130_gnd sky130_fd_pr__nfet_01v8 l=0.6 w=1.4 as=0.406
+ ad=0.406 ps=3.38 pd=3.38
X$629 VSS bias_a \$1 sky130_gnd sky130_fd_pr__nfet_01v8 l=0.6 w=1.4 as=0.406
+ ad=0.406 ps=3.38 pd=3.38
X$630 VSS bias_a \$1 sky130_gnd sky130_fd_pr__nfet_01v8 l=0.6 w=1.4 as=0.406
+ ad=0.406 ps=3.38 pd=3.38
X$631 VSS bias_a \$1 sky130_gnd sky130_fd_pr__nfet_01v8 l=0.6 w=1.4 as=0.406
+ ad=0.406 ps=3.38 pd=3.38
X$632 VSS bias_a \$1 sky130_gnd sky130_fd_pr__nfet_01v8 l=0.6 w=1.4 as=0.406
+ ad=0.406 ps=3.38 pd=3.38
X$633 VSS bias_a \$1 sky130_gnd sky130_fd_pr__nfet_01v8 l=0.6 w=1.4 as=0.406
+ ad=0.406 ps=3.38 pd=3.38
X$634 VSS bias_a \$1 sky130_gnd sky130_fd_pr__nfet_01v8 l=0.6 w=1.4 as=0.406
+ ad=0.406 ps=3.38 pd=3.38
X$635 VSS bias_a \$1 sky130_gnd sky130_fd_pr__nfet_01v8 l=0.6 w=1.4 as=0.406
+ ad=0.406 ps=3.38 pd=3.38
X$636 VSS bias_a \$1 sky130_gnd sky130_fd_pr__nfet_01v8 l=0.6 w=1.4 as=0.406
+ ad=0.406 ps=3.38 pd=3.38
X$637 VSS bias_a \$1 sky130_gnd sky130_fd_pr__nfet_01v8 l=0.6 w=1.4 as=0.406
+ ad=0.406 ps=3.38 pd=3.38
X$638 VSS bias_a \$1 sky130_gnd sky130_fd_pr__nfet_01v8 l=0.6 w=1.4 as=0.406
+ ad=0.406 ps=3.38 pd=3.38
X$639 VSS bias_a \$1 sky130_gnd sky130_fd_pr__nfet_01v8 l=0.6 w=1.4 as=0.406
+ ad=0.406 ps=3.38 pd=3.38
X$640 VSS bias_a \$77 sky130_gnd sky130_fd_pr__nfet_01v8 l=0.6 w=1.4 as=0.406
+ ad=0.406 ps=3.38 pd=3.38
X$641 VSS bias_a \$77 sky130_gnd sky130_fd_pr__nfet_01v8 l=0.6 w=1.4 as=0.406
+ ad=0.406 ps=3.38 pd=3.38
X$642 VSS bias_a \$77 sky130_gnd sky130_fd_pr__nfet_01v8 l=0.6 w=1.4 as=0.406
+ ad=0.406 ps=3.38 pd=3.38
X$643 VSS bias_a \$77 sky130_gnd sky130_fd_pr__nfet_01v8 l=0.6 w=1.4 as=0.406
+ ad=0.406 ps=3.38 pd=3.38
X$644 VSS bias_a \$77 sky130_gnd sky130_fd_pr__nfet_01v8 l=0.6 w=1.4 as=0.406
+ ad=0.406 ps=3.38 pd=3.38
X$645 VSS bias_a \$77 sky130_gnd sky130_fd_pr__nfet_01v8 l=0.6 w=1.4 as=0.406
+ ad=0.406 ps=3.38 pd=3.38
X$646 VSS bias_a \$77 sky130_gnd sky130_fd_pr__nfet_01v8 l=0.6 w=1.4 as=0.406
+ ad=0.406 ps=3.38 pd=3.38
X$647 VSS bias_a \$77 sky130_gnd sky130_fd_pr__nfet_01v8 l=0.6 w=1.4 as=0.406
+ ad=0.406 ps=3.38 pd=3.38
X$648 VSS bias_a \$77 sky130_gnd sky130_fd_pr__nfet_01v8 l=0.6 w=1.4 as=0.406
+ ad=0.406 ps=3.38 pd=3.38
X$649 VSS bias_a \$77 sky130_gnd sky130_fd_pr__nfet_01v8 l=0.6 w=1.4 as=0.406
+ ad=0.406 ps=3.38 pd=3.38
X$650 VSS bias_a \$77 sky130_gnd sky130_fd_pr__nfet_01v8 l=0.6 w=1.4 as=0.406
+ ad=0.406 ps=3.38 pd=3.38
X$651 VSS bias_a \$77 sky130_gnd sky130_fd_pr__nfet_01v8 l=0.6 w=1.4 as=0.406
+ ad=0.406 ps=3.38 pd=3.38
X$652 VSS bias_a \$77 sky130_gnd sky130_fd_pr__nfet_01v8 l=0.6 w=1.4 as=0.406
+ ad=0.406 ps=3.38 pd=3.38
X$653 VSS bias_a \$77 sky130_gnd sky130_fd_pr__nfet_01v8 l=0.6 w=1.4 as=0.406
+ ad=0.406 ps=3.38 pd=3.38
X$654 VSS bias_a \$77 sky130_gnd sky130_fd_pr__nfet_01v8 l=0.6 w=1.4 as=0.406
+ ad=0.406 ps=3.38 pd=3.38
X$655 VSS bias_a \$77 sky130_gnd sky130_fd_pr__nfet_01v8 l=0.6 w=1.4 as=0.406
+ ad=0.406 ps=3.38 pd=3.38
X$656 VSS bias_a \$77 sky130_gnd sky130_fd_pr__nfet_01v8 l=0.6 w=1.4 as=0.406
+ ad=0.406 ps=3.38 pd=3.38
X$657 VSS bias_a \$77 sky130_gnd sky130_fd_pr__nfet_01v8 l=0.6 w=1.4 as=0.406
+ ad=0.406 ps=3.38 pd=3.38
X$658 VSS bias_a \$77 sky130_gnd sky130_fd_pr__nfet_01v8 l=0.6 w=1.4 as=0.406
+ ad=0.406 ps=3.38 pd=3.38
X$659 VSS bias_a \$77 sky130_gnd sky130_fd_pr__nfet_01v8 l=0.6 w=1.4 as=0.406
+ ad=0.406 ps=3.38 pd=3.38
X$660 VSS bias_a \$77 sky130_gnd sky130_fd_pr__nfet_01v8 l=0.6 w=1.4 as=0.406
+ ad=0.406 ps=3.38 pd=3.38
X$661 VSS bias_a \$77 sky130_gnd sky130_fd_pr__nfet_01v8 l=0.6 w=1.4 as=0.406
+ ad=0.406 ps=3.38 pd=3.38
X$662 VSS bias_a \$77 sky130_gnd sky130_fd_pr__nfet_01v8 l=0.6 w=1.4 as=0.406
+ ad=0.406 ps=3.38 pd=3.38
X$663 VSS bias_a \$77 sky130_gnd sky130_fd_pr__nfet_01v8 l=0.6 w=1.4 as=0.406
+ ad=0.406 ps=3.38 pd=3.38
X$664 VSS bias_a \$77 sky130_gnd sky130_fd_pr__nfet_01v8 l=0.6 w=1.4 as=0.406
+ ad=0.406 ps=3.38 pd=3.38
X$665 VSS bias_a \$77 sky130_gnd sky130_fd_pr__nfet_01v8 l=0.6 w=1.4 as=0.406
+ ad=0.406 ps=3.38 pd=3.38
X$666 VSS bias_a \$77 sky130_gnd sky130_fd_pr__nfet_01v8 l=0.6 w=1.4 as=0.406
+ ad=0.406 ps=3.38 pd=3.38
X$667 VSS bias_a \$77 sky130_gnd sky130_fd_pr__nfet_01v8 l=0.6 w=1.4 as=0.406
+ ad=0.406 ps=3.38 pd=3.38
X$668 VSS bias_a \$77 sky130_gnd sky130_fd_pr__nfet_01v8 l=0.6 w=1.4 as=0.406
+ ad=0.406 ps=3.38 pd=3.38
X$669 VSS bias_a \$77 sky130_gnd sky130_fd_pr__nfet_01v8 l=0.6 w=1.4 as=0.406
+ ad=0.406 ps=3.38 pd=3.38
X$670 VSS bias_a \$77 sky130_gnd sky130_fd_pr__nfet_01v8 l=0.6 w=1.4 as=0.406
+ ad=0.406 ps=3.38 pd=3.38
X$671 VSS bias_a \$77 sky130_gnd sky130_fd_pr__nfet_01v8 l=0.6 w=1.4 as=0.406
+ ad=0.406 ps=3.38 pd=3.38
X$672 VSS bias_a \$77 sky130_gnd sky130_fd_pr__nfet_01v8 l=0.6 w=1.4 as=0.406
+ ad=0.406 ps=3.38 pd=3.38
X$673 VSS bias_a \$77 sky130_gnd sky130_fd_pr__nfet_01v8 l=0.6 w=1.4 as=0.406
+ ad=0.406 ps=3.38 pd=3.38
X$674 VSS bias_a \$77 sky130_gnd sky130_fd_pr__nfet_01v8 l=0.6 w=1.4 as=0.406
+ ad=0.406 ps=3.38 pd=3.38
X$675 VSS bias_a \$77 sky130_gnd sky130_fd_pr__nfet_01v8 l=0.6 w=1.4 as=0.406
+ ad=0.406 ps=3.38 pd=3.38
X$676 VSS bias_a \$76 sky130_gnd sky130_fd_pr__nfet_01v8 l=0.6 w=1.4 as=0.406
+ ad=0.406 ps=3.38 pd=3.38
X$677 VSS bias_a \$76 sky130_gnd sky130_fd_pr__nfet_01v8 l=0.6 w=1.4 as=0.406
+ ad=0.406 ps=3.38 pd=3.38
X$678 VSS bias_a \$76 sky130_gnd sky130_fd_pr__nfet_01v8 l=0.6 w=1.4 as=0.406
+ ad=0.406 ps=3.38 pd=3.38
X$679 VSS bias_a \$76 sky130_gnd sky130_fd_pr__nfet_01v8 l=0.6 w=1.4 as=0.406
+ ad=0.406 ps=3.38 pd=3.38
X$680 VSS bias_a \$76 sky130_gnd sky130_fd_pr__nfet_01v8 l=0.6 w=1.4 as=0.406
+ ad=0.406 ps=3.38 pd=3.38
X$681 VSS bias_a \$76 sky130_gnd sky130_fd_pr__nfet_01v8 l=0.6 w=1.4 as=0.406
+ ad=0.406 ps=3.38 pd=3.38
X$682 VSS bias_a \$76 sky130_gnd sky130_fd_pr__nfet_01v8 l=0.6 w=1.4 as=0.406
+ ad=0.406 ps=3.38 pd=3.38
X$683 VSS bias_a \$76 sky130_gnd sky130_fd_pr__nfet_01v8 l=0.6 w=1.4 as=0.406
+ ad=0.406 ps=3.38 pd=3.38
X$684 VSS bias_a \$76 sky130_gnd sky130_fd_pr__nfet_01v8 l=0.6 w=1.4 as=0.406
+ ad=0.406 ps=3.38 pd=3.38
X$685 VSS bias_a \$76 sky130_gnd sky130_fd_pr__nfet_01v8 l=0.6 w=1.4 as=0.406
+ ad=0.406 ps=3.38 pd=3.38
X$686 VSS bias_a \$76 sky130_gnd sky130_fd_pr__nfet_01v8 l=0.6 w=1.4 as=0.406
+ ad=0.406 ps=3.38 pd=3.38
X$687 VSS bias_a \$76 sky130_gnd sky130_fd_pr__nfet_01v8 l=0.6 w=1.4 as=0.406
+ ad=0.406 ps=3.38 pd=3.38
X$688 VSS bias_a \$76 sky130_gnd sky130_fd_pr__nfet_01v8 l=0.6 w=1.4 as=0.406
+ ad=0.406 ps=3.38 pd=3.38
X$689 VSS bias_a \$76 sky130_gnd sky130_fd_pr__nfet_01v8 l=0.6 w=1.4 as=0.406
+ ad=0.406 ps=3.38 pd=3.38
X$690 VSS bias_a \$76 sky130_gnd sky130_fd_pr__nfet_01v8 l=0.6 w=1.4 as=0.406
+ ad=0.406 ps=3.38 pd=3.38
X$691 VSS bias_a \$76 sky130_gnd sky130_fd_pr__nfet_01v8 l=0.6 w=1.4 as=0.406
+ ad=0.406 ps=3.38 pd=3.38
X$692 VSS bias_a \$76 sky130_gnd sky130_fd_pr__nfet_01v8 l=0.6 w=1.4 as=0.406
+ ad=0.406 ps=3.38 pd=3.38
X$693 VSS bias_a \$76 sky130_gnd sky130_fd_pr__nfet_01v8 l=0.6 w=1.4 as=0.406
+ ad=0.406 ps=3.38 pd=3.38
X$694 VSS bias_a \$76 sky130_gnd sky130_fd_pr__nfet_01v8 l=0.6 w=1.4 as=0.406
+ ad=0.406 ps=3.38 pd=3.38
X$695 VSS bias_a \$76 sky130_gnd sky130_fd_pr__nfet_01v8 l=0.6 w=1.4 as=0.406
+ ad=0.406 ps=3.38 pd=3.38
X$696 VSS bias_a \$76 sky130_gnd sky130_fd_pr__nfet_01v8 l=0.6 w=1.4 as=0.406
+ ad=0.406 ps=3.38 pd=3.38
X$697 VSS bias_a \$76 sky130_gnd sky130_fd_pr__nfet_01v8 l=0.6 w=1.4 as=0.406
+ ad=0.406 ps=3.38 pd=3.38
X$698 VSS bias_a \$76 sky130_gnd sky130_fd_pr__nfet_01v8 l=0.6 w=1.4 as=0.406
+ ad=0.406 ps=3.38 pd=3.38
X$699 VSS bias_a \$76 sky130_gnd sky130_fd_pr__nfet_01v8 l=0.6 w=1.4 as=0.406
+ ad=0.406 ps=3.38 pd=3.38
X$700 VSS bias_a \$76 sky130_gnd sky130_fd_pr__nfet_01v8 l=0.6 w=1.4 as=0.406
+ ad=0.406 ps=3.38 pd=3.38
X$701 VSS bias_a \$76 sky130_gnd sky130_fd_pr__nfet_01v8 l=0.6 w=1.4 as=0.406
+ ad=0.406 ps=3.38 pd=3.38
X$702 VSS bias_a \$76 sky130_gnd sky130_fd_pr__nfet_01v8 l=0.6 w=1.4 as=0.406
+ ad=0.406 ps=3.38 pd=3.38
X$703 VSS bias_a \$76 sky130_gnd sky130_fd_pr__nfet_01v8 l=0.6 w=1.4 as=0.406
+ ad=0.406 ps=3.38 pd=3.38
X$704 VSS bias_a \$76 sky130_gnd sky130_fd_pr__nfet_01v8 l=0.6 w=1.4 as=0.406
+ ad=0.406 ps=3.38 pd=3.38
X$705 VSS bias_a \$76 sky130_gnd sky130_fd_pr__nfet_01v8 l=0.6 w=1.4 as=0.406
+ ad=0.406 ps=3.38 pd=3.38
X$706 VSS bias_a \$76 sky130_gnd sky130_fd_pr__nfet_01v8 l=0.6 w=1.4 as=0.406
+ ad=0.406 ps=3.38 pd=3.38
X$707 VSS bias_a \$76 sky130_gnd sky130_fd_pr__nfet_01v8 l=0.6 w=1.4 as=0.406
+ ad=0.406 ps=3.38 pd=3.38
X$708 VSS bias_a \$76 sky130_gnd sky130_fd_pr__nfet_01v8 l=0.6 w=1.4 as=0.406
+ ad=0.406 ps=3.38 pd=3.38
X$709 VSS bias_a \$76 sky130_gnd sky130_fd_pr__nfet_01v8 l=0.6 w=1.4 as=0.406
+ ad=0.406 ps=3.38 pd=3.38
X$710 VSS bias_a \$76 sky130_gnd sky130_fd_pr__nfet_01v8 l=0.6 w=1.4 as=0.406
+ ad=0.406 ps=3.38 pd=3.38
X$711 VSS bias_a \$76 sky130_gnd sky130_fd_pr__nfet_01v8 l=0.6 w=1.4 as=0.406
+ ad=0.406 ps=3.38 pd=3.38
X$712 \$77 \$11 op sky130_gnd sky130_fd_pr__nfet_01v8 l=0.6 w=1.4 as=0.406
+ ad=0.406 ps=3.38 pd=3.38
X$713 \$77 \$11 op sky130_gnd sky130_fd_pr__nfet_01v8 l=0.6 w=1.4 as=0.406
+ ad=0.406 ps=3.38 pd=3.38
X$714 \$77 \$11 op sky130_gnd sky130_fd_pr__nfet_01v8 l=0.6 w=1.4 as=0.406
+ ad=0.406 ps=3.38 pd=3.38
X$715 \$77 \$11 op sky130_gnd sky130_fd_pr__nfet_01v8 l=0.6 w=1.4 as=0.406
+ ad=0.406 ps=3.38 pd=3.38
X$716 \$77 \$11 op sky130_gnd sky130_fd_pr__nfet_01v8 l=0.6 w=1.4 as=0.406
+ ad=0.406 ps=3.38 pd=3.38
X$717 \$77 \$11 op sky130_gnd sky130_fd_pr__nfet_01v8 l=0.6 w=1.4 as=0.406
+ ad=0.406 ps=3.38 pd=3.38
X$718 \$77 \$11 op sky130_gnd sky130_fd_pr__nfet_01v8 l=0.6 w=1.4 as=0.406
+ ad=0.406 ps=3.38 pd=3.38
X$719 \$77 \$11 op sky130_gnd sky130_fd_pr__nfet_01v8 l=0.6 w=1.4 as=0.406
+ ad=0.406 ps=3.38 pd=3.38
X$720 \$77 \$11 op sky130_gnd sky130_fd_pr__nfet_01v8 l=0.6 w=1.4 as=0.406
+ ad=0.406 ps=3.38 pd=3.38
X$721 \$77 \$11 op sky130_gnd sky130_fd_pr__nfet_01v8 l=0.6 w=1.4 as=0.406
+ ad=0.406 ps=3.38 pd=3.38
X$722 \$77 \$11 op sky130_gnd sky130_fd_pr__nfet_01v8 l=0.6 w=1.4 as=0.406
+ ad=0.406 ps=3.38 pd=3.38
X$723 \$77 \$11 op sky130_gnd sky130_fd_pr__nfet_01v8 l=0.6 w=1.4 as=0.406
+ ad=0.406 ps=3.38 pd=3.38
X$724 \$77 \$11 op sky130_gnd sky130_fd_pr__nfet_01v8 l=0.6 w=1.4 as=0.406
+ ad=0.406 ps=3.38 pd=3.38
X$725 \$77 \$11 op sky130_gnd sky130_fd_pr__nfet_01v8 l=0.6 w=1.4 as=0.406
+ ad=0.406 ps=3.38 pd=3.38
X$726 \$77 \$11 op sky130_gnd sky130_fd_pr__nfet_01v8 l=0.6 w=1.4 as=0.406
+ ad=0.406 ps=3.38 pd=3.38
X$727 \$77 \$11 op sky130_gnd sky130_fd_pr__nfet_01v8 l=0.6 w=1.4 as=0.406
+ ad=0.406 ps=3.38 pd=3.38
X$728 \$77 \$11 op sky130_gnd sky130_fd_pr__nfet_01v8 l=0.6 w=1.4 as=0.406
+ ad=0.406 ps=3.38 pd=3.38
X$729 \$77 \$11 op sky130_gnd sky130_fd_pr__nfet_01v8 l=0.6 w=1.4 as=0.406
+ ad=0.406 ps=3.38 pd=3.38
X$730 \$77 \$11 op sky130_gnd sky130_fd_pr__nfet_01v8 l=0.6 w=1.4 as=0.406
+ ad=0.406 ps=3.38 pd=3.38
X$731 \$77 \$11 op sky130_gnd sky130_fd_pr__nfet_01v8 l=0.6 w=1.4 as=0.406
+ ad=0.406 ps=3.38 pd=3.38
X$732 \$77 \$11 op sky130_gnd sky130_fd_pr__nfet_01v8 l=0.6 w=1.4 as=0.406
+ ad=0.406 ps=3.38 pd=3.38
X$733 \$77 \$11 op sky130_gnd sky130_fd_pr__nfet_01v8 l=0.6 w=1.4 as=0.406
+ ad=0.406 ps=3.38 pd=3.38
X$734 \$77 \$11 op sky130_gnd sky130_fd_pr__nfet_01v8 l=0.6 w=1.4 as=0.406
+ ad=0.406 ps=3.38 pd=3.38
X$735 \$77 \$11 op sky130_gnd sky130_fd_pr__nfet_01v8 l=0.6 w=1.4 as=0.406
+ ad=0.406 ps=3.38 pd=3.38
X$736 \$77 \$11 op sky130_gnd sky130_fd_pr__nfet_01v8 l=0.6 w=1.4 as=0.406
+ ad=0.406 ps=3.38 pd=3.38
X$737 \$77 \$11 op sky130_gnd sky130_fd_pr__nfet_01v8 l=0.6 w=1.4 as=0.406
+ ad=0.406 ps=3.38 pd=3.38
X$738 \$77 \$11 op sky130_gnd sky130_fd_pr__nfet_01v8 l=0.6 w=1.4 as=0.406
+ ad=0.406 ps=3.38 pd=3.38
X$739 \$77 \$11 op sky130_gnd sky130_fd_pr__nfet_01v8 l=0.6 w=1.4 as=0.406
+ ad=0.406 ps=3.38 pd=3.38
X$740 \$77 \$11 op sky130_gnd sky130_fd_pr__nfet_01v8 l=0.6 w=1.4 as=0.406
+ ad=0.406 ps=3.38 pd=3.38
X$741 \$77 \$11 op sky130_gnd sky130_fd_pr__nfet_01v8 l=0.6 w=1.4 as=0.406
+ ad=0.406 ps=3.38 pd=3.38
X$742 \$77 \$11 op sky130_gnd sky130_fd_pr__nfet_01v8 l=0.6 w=1.4 as=0.406
+ ad=0.406 ps=3.38 pd=3.38
X$743 \$77 \$11 op sky130_gnd sky130_fd_pr__nfet_01v8 l=0.6 w=1.4 as=0.406
+ ad=0.406 ps=3.38 pd=3.38
X$744 \$77 \$11 op sky130_gnd sky130_fd_pr__nfet_01v8 l=0.6 w=1.4 as=0.406
+ ad=0.406 ps=3.38 pd=3.38
X$745 \$77 \$11 op sky130_gnd sky130_fd_pr__nfet_01v8 l=0.6 w=1.4 as=0.406
+ ad=0.406 ps=3.38 pd=3.38
X$746 \$77 \$11 op sky130_gnd sky130_fd_pr__nfet_01v8 l=0.6 w=1.4 as=0.406
+ ad=0.406 ps=3.38 pd=3.38
X$747 \$77 \$11 op sky130_gnd sky130_fd_pr__nfet_01v8 l=0.6 w=1.4 as=0.406
+ ad=0.406 ps=3.38 pd=3.38
X$748 \$76 \$11 on sky130_gnd sky130_fd_pr__nfet_01v8 l=0.6 w=1.4 as=0.406
+ ad=0.406 ps=3.38 pd=3.38
X$749 \$76 \$11 on sky130_gnd sky130_fd_pr__nfet_01v8 l=0.6 w=1.4 as=0.406
+ ad=0.406 ps=3.38 pd=3.38
X$750 \$76 \$11 on sky130_gnd sky130_fd_pr__nfet_01v8 l=0.6 w=1.4 as=0.406
+ ad=0.406 ps=3.38 pd=3.38
X$751 \$76 \$11 on sky130_gnd sky130_fd_pr__nfet_01v8 l=0.6 w=1.4 as=0.406
+ ad=0.406 ps=3.38 pd=3.38
X$752 \$76 \$11 on sky130_gnd sky130_fd_pr__nfet_01v8 l=0.6 w=1.4 as=0.406
+ ad=0.406 ps=3.38 pd=3.38
X$753 \$76 \$11 on sky130_gnd sky130_fd_pr__nfet_01v8 l=0.6 w=1.4 as=0.406
+ ad=0.406 ps=3.38 pd=3.38
X$754 \$76 \$11 on sky130_gnd sky130_fd_pr__nfet_01v8 l=0.6 w=1.4 as=0.406
+ ad=0.406 ps=3.38 pd=3.38
X$755 \$76 \$11 on sky130_gnd sky130_fd_pr__nfet_01v8 l=0.6 w=1.4 as=0.406
+ ad=0.406 ps=3.38 pd=3.38
X$756 \$76 \$11 on sky130_gnd sky130_fd_pr__nfet_01v8 l=0.6 w=1.4 as=0.406
+ ad=0.406 ps=3.38 pd=3.38
X$757 \$76 \$11 on sky130_gnd sky130_fd_pr__nfet_01v8 l=0.6 w=1.4 as=0.406
+ ad=0.406 ps=3.38 pd=3.38
X$758 \$76 \$11 on sky130_gnd sky130_fd_pr__nfet_01v8 l=0.6 w=1.4 as=0.406
+ ad=0.406 ps=3.38 pd=3.38
X$759 \$76 \$11 on sky130_gnd sky130_fd_pr__nfet_01v8 l=0.6 w=1.4 as=0.406
+ ad=0.406 ps=3.38 pd=3.38
X$760 \$76 \$11 on sky130_gnd sky130_fd_pr__nfet_01v8 l=0.6 w=1.4 as=0.406
+ ad=0.406 ps=3.38 pd=3.38
X$761 \$76 \$11 on sky130_gnd sky130_fd_pr__nfet_01v8 l=0.6 w=1.4 as=0.406
+ ad=0.406 ps=3.38 pd=3.38
X$762 \$76 \$11 on sky130_gnd sky130_fd_pr__nfet_01v8 l=0.6 w=1.4 as=0.406
+ ad=0.406 ps=3.38 pd=3.38
X$763 \$76 \$11 on sky130_gnd sky130_fd_pr__nfet_01v8 l=0.6 w=1.4 as=0.406
+ ad=0.406 ps=3.38 pd=3.38
X$764 \$76 \$11 on sky130_gnd sky130_fd_pr__nfet_01v8 l=0.6 w=1.4 as=0.406
+ ad=0.406 ps=3.38 pd=3.38
X$765 \$76 \$11 on sky130_gnd sky130_fd_pr__nfet_01v8 l=0.6 w=1.4 as=0.406
+ ad=0.406 ps=3.38 pd=3.38
X$766 \$76 \$11 on sky130_gnd sky130_fd_pr__nfet_01v8 l=0.6 w=1.4 as=0.406
+ ad=0.406 ps=3.38 pd=3.38
X$767 \$76 \$11 on sky130_gnd sky130_fd_pr__nfet_01v8 l=0.6 w=1.4 as=0.406
+ ad=0.406 ps=3.38 pd=3.38
X$768 \$76 \$11 on sky130_gnd sky130_fd_pr__nfet_01v8 l=0.6 w=1.4 as=0.406
+ ad=0.406 ps=3.38 pd=3.38
X$769 \$76 \$11 on sky130_gnd sky130_fd_pr__nfet_01v8 l=0.6 w=1.4 as=0.406
+ ad=0.406 ps=3.38 pd=3.38
X$770 \$76 \$11 on sky130_gnd sky130_fd_pr__nfet_01v8 l=0.6 w=1.4 as=0.406
+ ad=0.406 ps=3.38 pd=3.38
X$771 \$76 \$11 on sky130_gnd sky130_fd_pr__nfet_01v8 l=0.6 w=1.4 as=0.406
+ ad=0.406 ps=3.38 pd=3.38
X$772 \$76 \$11 on sky130_gnd sky130_fd_pr__nfet_01v8 l=0.6 w=1.4 as=0.406
+ ad=0.406 ps=3.38 pd=3.38
X$773 \$76 \$11 on sky130_gnd sky130_fd_pr__nfet_01v8 l=0.6 w=1.4 as=0.406
+ ad=0.406 ps=3.38 pd=3.38
X$774 \$76 \$11 on sky130_gnd sky130_fd_pr__nfet_01v8 l=0.6 w=1.4 as=0.406
+ ad=0.406 ps=3.38 pd=3.38
X$775 \$76 \$11 on sky130_gnd sky130_fd_pr__nfet_01v8 l=0.6 w=1.4 as=0.406
+ ad=0.406 ps=3.38 pd=3.38
X$776 \$76 \$11 on sky130_gnd sky130_fd_pr__nfet_01v8 l=0.6 w=1.4 as=0.406
+ ad=0.406 ps=3.38 pd=3.38
X$777 \$76 \$11 on sky130_gnd sky130_fd_pr__nfet_01v8 l=0.6 w=1.4 as=0.406
+ ad=0.406 ps=3.38 pd=3.38
X$778 \$76 \$11 on sky130_gnd sky130_fd_pr__nfet_01v8 l=0.6 w=1.4 as=0.406
+ ad=0.406 ps=3.38 pd=3.38
X$779 \$76 \$11 on sky130_gnd sky130_fd_pr__nfet_01v8 l=0.6 w=1.4 as=0.406
+ ad=0.406 ps=3.38 pd=3.38
X$780 \$76 \$11 on sky130_gnd sky130_fd_pr__nfet_01v8 l=0.6 w=1.4 as=0.406
+ ad=0.406 ps=3.38 pd=3.38
X$781 \$76 \$11 on sky130_gnd sky130_fd_pr__nfet_01v8 l=0.6 w=1.4 as=0.406
+ ad=0.406 ps=3.38 pd=3.38
X$782 \$76 \$11 on sky130_gnd sky130_fd_pr__nfet_01v8 l=0.6 w=1.4 as=0.406
+ ad=0.406 ps=3.38 pd=3.38
X$783 \$76 \$11 on sky130_gnd sky130_fd_pr__nfet_01v8 l=0.6 w=1.4 as=0.406
+ ad=0.406 ps=3.38 pd=3.38
X$784 VSS VSS VSS sky130_gnd sky130_fd_pr__nfet_01v8 l=0.6 w=1.4 as=0.406
+ ad=0.406 ps=3.38 pd=3.38
X$785 VSS VSS VSS sky130_gnd sky130_fd_pr__nfet_01v8 l=0.6 w=1.4 as=0.406
+ ad=0.406 ps=3.38 pd=3.38
X$786 VSS VSS VSS sky130_gnd sky130_fd_pr__nfet_01v8 l=0.6 w=1.4 as=0.406
+ ad=0.406 ps=3.38 pd=3.38
X$787 VSS VSS VSS sky130_gnd sky130_fd_pr__nfet_01v8 l=0.6 w=1.4 as=0.406
+ ad=0.406 ps=3.38 pd=3.38
X$788 \$11 \$45 \$45 sky130_gnd sky130_fd_pr__nfet_01v8 l=0.6 w=1.4 as=0.406
+ ad=0.406 ps=3.38 pd=3.38
X$789 \$11 \$45 \$45 sky130_gnd sky130_fd_pr__nfet_01v8 l=0.6 w=1.4 as=0.406
+ ad=0.406 ps=3.38 pd=3.38
X$790 \$11 \$45 \$45 sky130_gnd sky130_fd_pr__nfet_01v8 l=0.6 w=1.4 as=0.406
+ ad=0.406 ps=3.38 pd=3.38
X$791 \$11 \$45 \$45 sky130_gnd sky130_fd_pr__nfet_01v8 l=0.6 w=1.4 as=0.406
+ ad=0.406 ps=3.38 pd=3.38
X$792 \$11 \$45 \$45 sky130_gnd sky130_fd_pr__nfet_01v8 l=0.6 w=1.4 as=0.406
+ ad=0.406 ps=3.38 pd=3.38
X$793 \$11 \$45 \$45 sky130_gnd sky130_fd_pr__nfet_01v8 l=0.6 w=1.4 as=0.406
+ ad=0.406 ps=3.38 pd=3.38
X$794 \$11 \$45 \$45 sky130_gnd sky130_fd_pr__nfet_01v8 l=0.6 w=1.4 as=0.406
+ ad=0.406 ps=3.38 pd=3.38
X$795 \$11 \$45 \$45 sky130_gnd sky130_fd_pr__nfet_01v8 l=0.6 w=1.4 as=0.406
+ ad=0.406 ps=3.38 pd=3.38
X$796 \$11 \$45 \$45 sky130_gnd sky130_fd_pr__nfet_01v8 l=0.6 w=1.4 as=0.406
+ ad=0.406 ps=3.38 pd=3.38
X$797 \$11 \$45 \$45 sky130_gnd sky130_fd_pr__nfet_01v8 l=0.6 w=1.4 as=0.406
+ ad=0.406 ps=3.38 pd=3.38
X$798 \$11 \$45 \$45 sky130_gnd sky130_fd_pr__nfet_01v8 l=0.6 w=1.4 as=0.406
+ ad=0.406 ps=3.38 pd=3.38
X$799 \$11 \$45 \$45 sky130_gnd sky130_fd_pr__nfet_01v8 l=0.6 w=1.4 as=0.406
+ ad=0.406 ps=3.38 pd=3.38
X$800 \$11 \$45 \$45 sky130_gnd sky130_fd_pr__nfet_01v8 l=0.6 w=1.4 as=0.406
+ ad=0.406 ps=3.38 pd=3.38
X$801 \$11 \$45 \$45 sky130_gnd sky130_fd_pr__nfet_01v8 l=0.6 w=1.4 as=0.406
+ ad=0.406 ps=3.38 pd=3.38
X$802 \$11 \$45 \$45 sky130_gnd sky130_fd_pr__nfet_01v8 l=0.6 w=1.4 as=0.406
+ ad=0.406 ps=3.38 pd=3.38
X$803 \$11 \$45 \$45 sky130_gnd sky130_fd_pr__nfet_01v8 l=0.6 w=1.4 as=0.406
+ ad=0.406 ps=3.38 pd=3.38
X$804 \$11 \$45 \$45 sky130_gnd sky130_fd_pr__nfet_01v8 l=0.6 w=1.4 as=0.406
+ ad=0.406 ps=3.38 pd=3.38
X$805 \$11 \$45 \$45 sky130_gnd sky130_fd_pr__nfet_01v8 l=0.6 w=1.4 as=0.406
+ ad=0.406 ps=3.38 pd=3.38
X$806 \$11 \$45 \$45 sky130_gnd sky130_fd_pr__nfet_01v8 l=0.6 w=1.4 as=0.406
+ ad=0.406 ps=3.38 pd=3.38
X$807 \$11 \$45 \$45 sky130_gnd sky130_fd_pr__nfet_01v8 l=0.6 w=1.4 as=0.406
+ ad=0.406 ps=3.38 pd=3.38
X$808 \$11 \$45 \$45 sky130_gnd sky130_fd_pr__nfet_01v8 l=0.6 w=1.4 as=0.406
+ ad=0.406 ps=3.38 pd=3.38
X$809 \$11 \$45 \$45 sky130_gnd sky130_fd_pr__nfet_01v8 l=0.6 w=1.4 as=0.406
+ ad=0.406 ps=3.38 pd=3.38
X$810 \$11 \$45 \$45 sky130_gnd sky130_fd_pr__nfet_01v8 l=0.6 w=1.4 as=0.406
+ ad=0.406 ps=3.38 pd=3.38
X$811 \$11 \$45 \$45 sky130_gnd sky130_fd_pr__nfet_01v8 l=0.6 w=1.4 as=0.406
+ ad=0.406 ps=3.38 pd=3.38
X$812 \$11 \$45 \$45 sky130_gnd sky130_fd_pr__nfet_01v8 l=0.6 w=1.4 as=0.406
+ ad=0.406 ps=3.38 pd=3.38
X$813 \$11 \$45 \$45 sky130_gnd sky130_fd_pr__nfet_01v8 l=0.6 w=1.4 as=0.406
+ ad=0.406 ps=3.38 pd=3.38
X$814 \$11 \$45 \$45 sky130_gnd sky130_fd_pr__nfet_01v8 l=0.6 w=1.4 as=0.406
+ ad=0.406 ps=3.38 pd=3.38
X$815 \$11 \$45 \$45 sky130_gnd sky130_fd_pr__nfet_01v8 l=0.6 w=1.4 as=0.406
+ ad=0.406 ps=3.38 pd=3.38
X$816 \$11 \$45 \$45 sky130_gnd sky130_fd_pr__nfet_01v8 l=0.6 w=1.4 as=0.406
+ ad=0.406 ps=3.38 pd=3.38
X$817 \$11 \$45 \$45 sky130_gnd sky130_fd_pr__nfet_01v8 l=0.6 w=1.4 as=0.406
+ ad=0.406 ps=3.38 pd=3.38
X$818 \$11 \$45 \$45 sky130_gnd sky130_fd_pr__nfet_01v8 l=0.6 w=1.4 as=0.406
+ ad=0.406 ps=3.38 pd=3.38
X$819 \$11 \$45 \$45 sky130_gnd sky130_fd_pr__nfet_01v8 l=0.6 w=1.4 as=0.406
+ ad=0.406 ps=3.38 pd=3.38
X$820 \$11 \$45 \$45 sky130_gnd sky130_fd_pr__nfet_01v8 l=0.6 w=1.4 as=0.406
+ ad=0.406 ps=3.38 pd=3.38
X$821 \$11 \$45 \$45 sky130_gnd sky130_fd_pr__nfet_01v8 l=0.6 w=1.4 as=0.406
+ ad=0.406 ps=3.38 pd=3.38
X$822 \$11 \$45 \$45 sky130_gnd sky130_fd_pr__nfet_01v8 l=0.6 w=1.4 as=0.406
+ ad=0.406 ps=3.38 pd=3.38
X$823 \$11 \$45 \$45 sky130_gnd sky130_fd_pr__nfet_01v8 l=0.6 w=1.4 as=0.406
+ ad=0.406 ps=3.38 pd=3.38
X$824 \$11 \$45 \$45 sky130_gnd sky130_fd_pr__nfet_01v8 l=0.6 w=1.4 as=0.406
+ ad=0.406 ps=3.38 pd=3.38
X$825 \$11 \$45 \$45 sky130_gnd sky130_fd_pr__nfet_01v8 l=0.6 w=1.4 as=0.406
+ ad=0.406 ps=3.38 pd=3.38
X$826 \$11 \$45 \$45 sky130_gnd sky130_fd_pr__nfet_01v8 l=0.6 w=1.4 as=0.406
+ ad=0.406 ps=3.38 pd=3.38
X$827 \$11 \$45 \$45 sky130_gnd sky130_fd_pr__nfet_01v8 l=0.6 w=1.4 as=0.406
+ ad=0.406 ps=3.38 pd=3.38
X$828 \$11 \$45 \$45 sky130_gnd sky130_fd_pr__nfet_01v8 l=0.6 w=1.4 as=0.406
+ ad=0.406 ps=3.38 pd=3.38
X$829 \$11 \$45 \$45 sky130_gnd sky130_fd_pr__nfet_01v8 l=0.6 w=1.4 as=0.406
+ ad=0.406 ps=3.38 pd=3.38
X$830 \$11 \$45 \$45 sky130_gnd sky130_fd_pr__nfet_01v8 l=0.6 w=1.4 as=0.406
+ ad=0.406 ps=3.38 pd=3.38
X$831 \$11 \$45 \$45 sky130_gnd sky130_fd_pr__nfet_01v8 l=0.6 w=1.4 as=0.406
+ ad=0.406 ps=3.38 pd=3.38
X$832 \$11 \$45 \$45 sky130_gnd sky130_fd_pr__nfet_01v8 l=0.6 w=1.4 as=0.406
+ ad=0.406 ps=3.38 pd=3.38
X$833 \$11 \$45 \$45 sky130_gnd sky130_fd_pr__nfet_01v8 l=0.6 w=1.4 as=0.406
+ ad=0.406 ps=3.38 pd=3.38
X$834 \$11 \$45 \$45 sky130_gnd sky130_fd_pr__nfet_01v8 l=0.6 w=1.4 as=0.406
+ ad=0.406 ps=3.38 pd=3.38
X$835 \$11 \$45 \$45 sky130_gnd sky130_fd_pr__nfet_01v8 l=0.6 w=1.4 as=0.406
+ ad=0.406 ps=3.38 pd=3.38
X$836 \$11 \$45 \$45 sky130_gnd sky130_fd_pr__nfet_01v8 l=0.6 w=1.4 as=0.406
+ ad=0.406 ps=3.38 pd=3.38
X$837 \$11 \$45 \$45 sky130_gnd sky130_fd_pr__nfet_01v8 l=0.6 w=1.4 as=0.406
+ ad=0.406 ps=3.38 pd=3.38
X$838 VSS VSS VSS sky130_gnd sky130_fd_pr__nfet_01v8 l=0.6 w=1.4 as=0.406
+ ad=0.406 ps=3.38 pd=3.38
X$839 VSS VSS VSS sky130_gnd sky130_fd_pr__nfet_01v8 l=0.6 w=1.4 as=0.406
+ ad=0.406 ps=3.38 pd=3.38
X$840 VSS VSS VSS sky130_gnd sky130_fd_pr__nfet_01v8 l=0.6 w=1.4 as=0.406
+ ad=0.406 ps=3.38 pd=3.38
X$841 VSS VSS VSS sky130_gnd sky130_fd_pr__nfet_01v8 l=0.6 w=1.4 as=0.406
+ ad=0.406 ps=3.38 pd=3.38
X$842 VSS VSS VSS sky130_gnd sky130_fd_pr__nfet_01v8 l=0.6 w=1.4 as=0.406
+ ad=0.406 ps=3.38 pd=3.38
X$843 VSS VSS VSS sky130_gnd sky130_fd_pr__nfet_01v8 l=0.6 w=1.4 as=0.406
+ ad=0.406 ps=3.38 pd=3.38
X$844 VSS VSS VSS sky130_gnd sky130_fd_pr__nfet_01v8 l=0.6 w=1.4 as=0.406
+ ad=0.406 ps=3.38 pd=3.38
X$845 VSS VSS VSS sky130_gnd sky130_fd_pr__nfet_01v8 l=0.6 w=1.4 as=0.406
+ ad=0.406 ps=3.38 pd=3.38
X$846 \$150 \$150 \$150 sky130_gnd sky130_fd_pr__nfet_01v8 l=0.6 w=1.4 as=0.406
+ ad=0.406 ps=3.38 pd=3.38
X$847 \$150 \$150 \$150 sky130_gnd sky130_fd_pr__nfet_01v8 l=0.6 w=1.4 as=0.406
+ ad=0.406 ps=3.38 pd=3.38
X$848 IBIAS IBIAS IBIAS sky130_gnd sky130_fd_pr__nfet_01v8 l=0.6 w=1.4 as=0.406
+ ad=0.406 ps=3.38 pd=3.38
X$849 IBIAS IBIAS IBIAS sky130_gnd sky130_fd_pr__nfet_01v8 l=0.6 w=1.4 as=0.406
+ ad=0.406 ps=3.38 pd=3.38
X$850 VSS VSS \$157 sky130_gnd sky130_fd_pr__nfet_01v8 l=0.6 w=1.4 as=0.406
+ ad=0.406 ps=3.38 pd=3.38
X$851 VSS VSS \$157 sky130_gnd sky130_fd_pr__nfet_01v8 l=0.6 w=1.4 as=0.406
+ ad=0.406 ps=3.38 pd=3.38
X$852 bias_a \$45 \$11 sky130_gnd sky130_fd_pr__nfet_01v8 l=0.6 w=1.4 as=0.406
+ ad=0.406 ps=3.38 pd=3.38
X$853 bias_a \$45 \$11 sky130_gnd sky130_fd_pr__nfet_01v8 l=0.6 w=1.4 as=0.406
+ ad=0.406 ps=3.38 pd=3.38
X$854 on on on sky130_gnd sky130_fd_pr__nfet_01v8 l=0.6 w=1.4 as=0.406 ad=0.406
+ ps=3.38 pd=3.38
X$855 on on on sky130_gnd sky130_fd_pr__nfet_01v8 l=0.6 w=1.4 as=0.406 ad=0.406
+ ps=3.38 pd=3.38
X$856 VSS VSS on sky130_gnd sky130_fd_pr__nfet_01v8 l=0.6 w=1.4 as=0.406
+ ad=0.406 ps=3.38 pd=3.38
X$857 VSS VSS on sky130_gnd sky130_fd_pr__nfet_01v8 l=0.6 w=1.4 as=0.406
+ ad=0.406 ps=3.38 pd=3.38
X$858 op op op sky130_gnd sky130_fd_pr__nfet_01v8 l=0.6 w=1.4 as=0.406 ad=0.406
+ ps=3.38 pd=3.38
X$859 op op op sky130_gnd sky130_fd_pr__nfet_01v8 l=0.6 w=1.4 as=0.406 ad=0.406
+ ps=3.38 pd=3.38
X$860 VSS VSS op sky130_gnd sky130_fd_pr__nfet_01v8 l=0.6 w=1.4 as=0.406
+ ad=0.406 ps=3.38 pd=3.38
X$861 VSS VSS op sky130_gnd sky130_fd_pr__nfet_01v8 l=0.6 w=1.4 as=0.406
+ ad=0.406 ps=3.38 pd=3.38
X$862 \$45 \$45 \$45 sky130_gnd sky130_fd_pr__nfet_01v8 l=0.6 w=1.4 as=0.406
+ ad=0.406 ps=3.38 pd=3.38
X$863 \$45 \$45 \$45 sky130_gnd sky130_fd_pr__nfet_01v8 l=0.6 w=1.4 as=0.406
+ ad=0.406 ps=3.38 pd=3.38
Cext_1 \$1 \$11 2.20549f
Cext_2 \$1 \$45 0.620859a
Cext_3 \$1 bias_a 11.8785f
Cext_4 \$1 VSS 14.2049f
Cext_5 \$1 sky130_gnd 12.368f
Cext_6 \$11 \$157 21.1613a
Cext_7 \$11 \$45 32.6085f
Cext_8 \$11 \$76 3.74347f
Cext_9 \$11 \$77 9.46502f
Cext_10 \$11 bias_a 6.85518f
Cext_11 \$11 cmc 3.50362a
Cext_12 \$11 on 6.10712f
Cext_13 \$11 op 7.59597f
Cext_14 \$11 VSS 16.1774f
Cext_15 \$11 sky130_gnd 52.6632f
Cext_16 \$11.x1_net1 \$11.x1_net2 119.836a
Cext_17 \$11.x1_net1 \$11.x1_net3 8.36158a
Cext_18 \$11.x1_net1 cm 380.305a
Cext_19 \$11.x1_net1 VDD 0.12392a
Cext_20 \$11.x1_net1 VSS 7.9302a
Cext_21 \$11.x1_net1 sky130_gnd 236.168a
Cext_22 \$11.x1_net10 \$11.x1_net11 249.701a
Cext_23 \$11.x1_net10 \$11.x1_net12 172.223a
Cext_24 \$11.x1_net10 \$11.x1_net7 5.01695a
Cext_25 \$11.x1_net10 \$11.x1_net8 0.774573a
Cext_26 \$11.x1_net10 \$11.x1_net9 182.587a
Cext_27 \$11.x1_net10 cm 445.427a
Cext_28 \$11.x1_net10 IBIAS 0.812352a
Cext_29 \$11.x1_net10 VDD 0.12392a
Cext_30 \$11.x1_net10 VSS 10.3472a
Cext_31 \$11.x1_net10 sky130_gnd 263.394a
Cext_32 \$11.x1_net11 \$11.x1_net12 285.156a
Cext_33 \$11.x1_net11 \$11.x1_net8 5.01695a
Cext_34 \$11.x1_net11 \$11.x1_net9 0.774573a
Cext_35 \$11.x1_net11 cm 465.671a
Cext_36 \$11.x1_net11 IBIAS 0.962138a
Cext_37 \$11.x1_net11 VDD 0.24784a
Cext_38 \$11.x1_net11 VSS 206.713a
Cext_39 \$11.x1_net11 sky130_gnd 279.354a
Cext_40 \$11.x1_net12 \$11.x1_net9 5.01695a
Cext_41 \$11.x1_net12 \$45 1.58439a
Cext_42 \$11.x1_net12 cm 623.824a
Cext_43 \$11.x1_net12 IBIAS 1.08618a
Cext_44 \$11.x1_net12 on 0.112012a
Cext_45 \$11.x1_net12 VDD 0.24784a
Cext_46 \$11.x1_net12 VSS 214.65a
Cext_47 \$11.x1_net12 sky130_gnd 323.19a
Cext_48 \$11.x1_net13 \$11.x1_net14 120.266a
Cext_49 \$11.x1_net13 \$11.x1_net15 8.36158a
Cext_50 \$11.x1_net13 \$11.x1_net3 8.36158a
Cext_51 \$11.x1_net13 cm 377.46a
Cext_52 \$11.x1_net13 on 0.247426a
Cext_53 \$11.x1_net13 VDD 0.12392a
Cext_54 \$11.x1_net13 VSS 9.70428a
Cext_55 \$11.x1_net13 sky130_gnd 227.614a
Cext_56 \$11.x1_net14 \$11.x1_net15 120.266a
Cext_57 \$11.x1_net14 \$11.x1_net2 3.12896a
Cext_58 \$11.x1_net14 \$11.x1_net5 3.12896a
Cext_59 \$11.x1_net14 cm 274.616a
Cext_60 \$11.x1_net14 on 0.348779a
Cext_61 \$11.x1_net14 VDD 0.113707a
Cext_62 \$11.x1_net14 VSS 18.0314a
Cext_63 \$11.x1_net14 sky130_gnd 285.021a
Cext_64 \$11.x1_net15 \$11.x1_net4 8.36158a
Cext_65 \$11.x1_net15 cm 267.362a
Cext_66 \$11.x1_net15 on 0.247426a
Cext_67 \$11.x1_net15 VSS 121.076a
Cext_68 \$11.x1_net15 sky130_gnd 228.712a
Cext_69 \$11.x1_net2 \$11.x1_net3 119.836a
Cext_70 \$11.x1_net2 cm 273.773a
Cext_71 \$11.x1_net2 VDD 0.12392a
Cext_72 \$11.x1_net2 VSS 17.8837a
Cext_73 \$11.x1_net2 sky130_gnd 286.497a
Cext_74 \$11.x1_net3 cm 265.839a
Cext_75 \$11.x1_net3 VDD 0.233261a
Cext_76 \$11.x1_net3 VSS 120.618a
Cext_77 \$11.x1_net3 sky130_gnd 227.521a
Cext_78 \$11.x1_net4 \$11.x1_net5 119.156a
Cext_79 \$11.x1_net4 \$11.x1_net6 1.85498a
Cext_80 \$11.x1_net4 \$11.x1_net7 3.85417a
Cext_81 \$11.x1_net4 \$150 0.684485a
Cext_82 \$11.x1_net4 cm 378.804a
Cext_83 \$11.x1_net4 IBIAS 0.269681a
Cext_84 \$11.x1_net4 VDD 2.0733a
Cext_85 \$11.x1_net4 VSS 9.63743a
Cext_86 \$11.x1_net4 sky130_gnd 231.268a
Cext_87 \$11.x1_net5 \$11.x1_net6 453.017a
Cext_88 \$11.x1_net5 \$11.x1_net7 0.999238a
Cext_89 \$11.x1_net5 \$11.x1_net8 5.01695a
Cext_90 \$11.x1_net5 \$150 0.55777a
Cext_91 \$11.x1_net5 cm 267.402a
Cext_92 \$11.x1_net5 on 0.200548a
Cext_93 \$11.x1_net5 VDD 0.24784a
Cext_94 \$11.x1_net5 VSS 207.406a
Cext_95 \$11.x1_net5 sky130_gnd 281.926a
Cext_96 \$11.x1_net6 \$11.x1_net7 183.34a
Cext_97 \$11.x1_net6 \$11.x1_net8 0.774573a
Cext_98 \$11.x1_net6 \$11.x1_net9 5.01695a
Cext_99 \$11.x1_net6 \$150 0.912252a
Cext_100 \$11.x1_net6 cm 429.223a
Cext_101 \$11.x1_net6 on 0.112012a
Cext_102 \$11.x1_net6 VDD 0.24784a
Cext_103 \$11.x1_net6 VSS 215.031a
Cext_104 \$11.x1_net6 sky130_gnd 322.011a
Cext_105 \$11.x1_net7 \$11.x1_net8 250.134a
Cext_106 \$11.x1_net7 \$11.x1_net9 172.837a
Cext_107 \$11.x1_net7 \$150 0.440026a
Cext_108 \$11.x1_net7 cm 447.12a
Cext_109 \$11.x1_net7 IBIAS 0.278622a
Cext_110 \$11.x1_net7 VDD 0.12392a
Cext_111 \$11.x1_net7 VSS 10.4783a
Cext_112 \$11.x1_net7 sky130_gnd 259.788a
Cext_113 \$11.x1_net8 \$11.x1_net9 285.589a
Cext_114 \$11.x1_net8 \$150 0.537059a
Cext_115 \$11.x1_net8 cm 466.198a
Cext_116 \$11.x1_net8 IBIAS 0.319782a
Cext_117 \$11.x1_net8 VDD 0.24784a
Cext_118 \$11.x1_net8 VSS 207.202a
Cext_119 \$11.x1_net8 sky130_gnd 274.243a
Cext_120 \$11.x1_net9 cm 431.759a
Cext_121 \$11.x1_net9 IBIAS 1.08618a
Cext_122 \$11.x1_net9 on 0.112012a
Cext_123 \$11.x1_net9 VDD 0.24784a
Cext_124 \$11.x1_net9 VSS 214.103a
Cext_125 \$11.x1_net9 sky130_gnd 314.908a
Cext_126 \$150 \$157 674.122a
Cext_127 \$150 \$168 34.8754f
Cext_128 \$150 \$202 2.35947f
Cext_129 \$150 \$203 2.16592f
Cext_130 \$150 \$271 843.581a
Cext_131 \$150 \$278 761.632a
Cext_132 \$150 \$279 941.967a
Cext_133 \$150 \$45 841.148a
Cext_134 \$150 cm 639.253a
Cext_135 \$150 cmc 2.46611a
Cext_136 \$150 IBIAS 14.5401f
Cext_137 \$150 in 6.86548a
Cext_138 \$150 ip 3.03528a
Cext_139 \$150 on 2.68331f
Cext_140 \$150 op 2.76153f
Cext_141 \$150 VDD 33.6509f
Cext_142 \$150 VSS 7.92194f
Cext_143 \$150 sky130_gnd 23.978f
Cext_144 \$157 \$168 11.974a
Cext_145 \$157 \$202 2.17323f
Cext_146 \$157 \$203 3.75709f
Cext_147 \$157 \$45 0.136289a
Cext_148 \$157 \$76 19.7789f
Cext_149 \$157 \$77 14.6733f
Cext_150 \$157 bias_a 20.4655f
Cext_151 \$157 cm 1.059a
Cext_152 \$157 cmc 16.4251f
Cext_153 \$157 IBIAS 566.719a
Cext_154 \$157 in 399.868a
Cext_155 \$157 ip 398.087a
Cext_156 \$157 on 33.3281a
Cext_157 \$157 op 232.025a
Cext_158 \$157 VSS 81.8074f
Cext_159 \$157 sky130_gnd 39.8842f
Cext_160 \$168 \$202 5.44009f
Cext_161 \$168 \$203 7.20877f
Cext_162 \$168 \$271 3.98787f
Cext_163 \$168 \$278 3.98914f
Cext_164 \$168 \$279 3.65534f
Cext_165 \$168 \$45 2.4228f
Cext_166 \$168 cm 1.00892f
Cext_167 \$168 IBIAS 39.1748a
Cext_168 \$168 in 246.273a
Cext_169 \$168 ip 11.0128a
Cext_170 \$168 on 132.069a
Cext_171 \$168 op 40.7952a
Cext_172 \$168 VDD 49.7298f
Cext_173 \$168 VSS 1.19939f
Cext_174 \$168 sky130_gnd 37.1944f
Cext_175 \$202 \$203 14.935f
Cext_176 \$202 \$271 0.663298a
Cext_177 \$202 \$279 0.853123a
Cext_178 \$202 \$45 224.827a
Cext_179 \$202 cm 323.387a
Cext_180 \$202 IBIAS 7.75024a
Cext_181 \$202 in 437.182a
Cext_182 \$202 ip 853.018a
Cext_183 \$202 on 8.69175f
Cext_184 \$202 op 3.93919f
Cext_185 \$202 VDD 25.1362f
Cext_186 \$202 VSS 157.61a
Cext_187 \$202 sky130_gnd 4.02166f
Cext_188 \$203 \$271 0.663298a
Cext_189 \$203 \$279 0.732729a
Cext_190 \$203 \$45 820.524a
Cext_191 \$203 cm 170.734a
Cext_192 \$203 IBIAS 18.6413a
Cext_193 \$203 in 689.114a
Cext_194 \$203 ip 1.39533f
Cext_195 \$203 on 4.72077f
Cext_196 \$203 op 3.13078f
Cext_197 \$203 VDD 25.7508f
Cext_198 \$203 VSS 170.608a
Cext_199 \$203 sky130_gnd 5.7145f
Cext_200 \$271 \$278 5.78285f
Cext_201 \$271 \$279 4.6355f
Cext_202 \$271 \$45 1.16388f
Cext_203 \$271 cm 1.60656f
Cext_204 \$271 VDD 10.1112f
Cext_205 \$271 sky130_gnd 741.782a
Cext_206 \$278 \$279 1.88101f
Cext_207 \$278 \$45 1.5057f
Cext_208 \$278 cm 2.29788f
Cext_209 \$278 VDD 11.2044f
Cext_210 \$278 sky130_gnd 697.973a
Cext_211 \$279 \$45 346.732a
Cext_212 \$279 cm 1.2911f
Cext_213 \$279 VDD 12.4306f
Cext_214 \$279 sky130_gnd 1.95943f
Cext_215 \$45 \$76 22.3219a
Cext_216 \$45 \$77 7.2242a
Cext_217 \$45 bias_a 244.623a
Cext_218 \$45 cm 2.60936f
Cext_219 \$45 cmc 386.101a
Cext_220 \$45 IBIAS 799.588a
Cext_221 \$45 in 0.296876a
Cext_222 \$45 ip 0.277161a
Cext_223 \$45 on 1.67023f
Cext_224 \$45 op 22.2077a
Cext_225 \$45 VDD 5.1114f
Cext_226 \$45 VSS 21.4111f
Cext_227 \$45 sky130_gnd 34.062f
Cext_228 \$76 \$77 12.6984f
Cext_229 \$76 bias_a 7.69028f
Cext_230 \$76 cmc 965.58a
Cext_231 \$76 on 13.3678f
Cext_232 \$76 op 13.8467f
Cext_233 \$76 VSS 43.8204f
Cext_234 \$76 sky130_gnd 20.4487f
Cext_235 \$77 bias_a 15.6877f
Cext_236 \$77 cmc 1.274f
Cext_237 \$77 on 6.28236f
Cext_238 \$77 op 11.9775f
Cext_239 \$77 VSS 42.1225f
Cext_240 \$77 sky130_gnd 20.6391f
Cext_241 bias_a cmc 45.5475f
Cext_242 bias_a on 2.87184a
Cext_243 bias_a op 4.31127a
Cext_244 cm in 0.677966a
Cext_245 cm ip 7.68035a
Cext_246 cm on 14.1883a
Cext_247 cmc on 201.238f
Cext_248 cmc op 201.162f
Cext_249 IBIAS cm 9.10753a
Cext_250 IBIAS cmc 7.1184a
Cext_251 IBIAS in 4.75988a
Cext_252 IBIAS ip 3.74754a
Cext_253 IBIAS on 61.4575a
Cext_254 IBIAS op 0.534535a
Cext_255 IBIAS VSS 15.0884f
Cext_256 IBIAS sky130_gnd 18.6914f
Cext_257 in ip 2.18333f
Cext_258 in on 15.0794a
Cext_259 ip on 15.9687a
Cext_260 on op 6.54656f
Cext_261 VDD cm 4.97934f
Cext_262 VDD in 8.39172a
Cext_263 VDD ip 5.04976a
Cext_264 VDD on 9.98182f
Cext_265 VDD op 9.72332f
Cext_266 VDD VSS 378.235a
Cext_267 VDD sky130_gnd 30.6552f
Cext_268 VSS bias_a 38.1162f
Cext_269 VSS cm 4.41962f
Cext_270 VSS cmc 41.1202f
Cext_271 VSS in 121.746a
Cext_272 VSS ip 66.7331a
Cext_273 VSS on 9.59036f
Cext_274 VSS op 3.97502f
Cext_275 VSS sky130_gnd 201.421f
Cext_276 sky130_gnd bias_a 95.7477f
Cext_277 sky130_gnd cm 16.7806f
Cext_278 sky130_gnd cmc 65.298f
Cext_279 sky130_gnd in 2.39025f
Cext_280 sky130_gnd ip 1.95285f
Cext_281 sky130_gnd on 16.7786f
Cext_282 sky130_gnd op 17.3951f
.ENDS iadc_ota_v2_routed
