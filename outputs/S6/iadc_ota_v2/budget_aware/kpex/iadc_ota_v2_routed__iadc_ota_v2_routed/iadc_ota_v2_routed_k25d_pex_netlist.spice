*********************************************************
*** NGSPICE file created by KLayout-PEX 0.6.8
*** -----------------------------------------------------
***     Extraction Engine: KPEX/2.5D
***     Technology: sky130a
***     Date: 2026-11-05 17:20:44
*********************************************************

.SUBCKT iadc_ota_v2_routed \$10.x1_net1 \$10.x1_net10 \$10.x1_net11
+ \$10.x1_net12 \$10.x1_net13 \$10.x1_net14 \$10.x1_net15 \$10.x1_net2
+ \$10.x1_net3 \$10.x1_net4 \$10.x1_net5 \$10.x1_net6 \$10.x1_net7 \$10.x1_net8
+ \$10.x1_net9 IBIAS VDD VSS bias_a cm cmc in ip on op sky130_gnd
X$9 \$177 \$109 \$109 sky130_gnd sky130_fd_pr__nfet_01v8_lvt l=0.6 w=1.4
+ as=0.406 ad=0.406 ps=3.38 pd=3.38
X$10 \$177 \$109 \$109 sky130_gnd sky130_fd_pr__nfet_01v8_lvt l=0.6 w=1.4
+ as=0.406 ad=0.406 ps=3.38 pd=3.38
X$11 \$177 \$109 \$109 sky130_gnd sky130_fd_pr__nfet_01v8_lvt l=0.6 w=1.4
+ as=0.406 ad=0.406 ps=3.38 pd=3.38
X$12 \$177 \$109 \$109 sky130_gnd sky130_fd_pr__nfet_01v8_lvt l=0.6 w=1.4
+ as=0.406 ad=0.406 ps=3.38 pd=3.38
X$13 \$177 \$109 \$109 sky130_gnd sky130_fd_pr__nfet_01v8_lvt l=0.6 w=1.4
+ as=0.406 ad=0.406 ps=3.38 pd=3.38
X$14 \$177 \$109 \$109 sky130_gnd sky130_fd_pr__nfet_01v8_lvt l=0.6 w=1.4
+ as=0.406 ad=0.406 ps=3.38 pd=3.38
X$15 \$177 \$109 \$109 sky130_gnd sky130_fd_pr__nfet_01v8_lvt l=0.6 w=1.4
+ as=0.406 ad=0.406 ps=3.38 pd=3.38
X$16 \$177 \$109 \$109 sky130_gnd sky130_fd_pr__nfet_01v8_lvt l=0.6 w=1.4
+ as=0.406 ad=0.406 ps=3.38 pd=3.38
X$17 \$177 \$109 \$109 sky130_gnd sky130_fd_pr__nfet_01v8_lvt l=0.6 w=1.4
+ as=0.406 ad=0.406 ps=3.38 pd=3.38
X$18 \$177 \$109 \$109 sky130_gnd sky130_fd_pr__nfet_01v8_lvt l=0.6 w=1.4
+ as=0.406 ad=0.406 ps=3.38 pd=3.38
X$19 \$177 \$109 \$109 sky130_gnd sky130_fd_pr__nfet_01v8_lvt l=0.6 w=1.4
+ as=0.406 ad=0.406 ps=3.38 pd=3.38
X$20 \$177 \$109 \$109 sky130_gnd sky130_fd_pr__nfet_01v8_lvt l=0.6 w=1.4
+ as=0.406 ad=0.406 ps=3.38 pd=3.38
X$21 \$177 \$109 \$109 sky130_gnd sky130_fd_pr__nfet_01v8_lvt l=0.6 w=1.4
+ as=0.406 ad=0.406 ps=3.38 pd=3.38
X$22 \$177 \$109 \$109 sky130_gnd sky130_fd_pr__nfet_01v8_lvt l=0.6 w=1.4
+ as=0.406 ad=0.406 ps=3.38 pd=3.38
X$23 \$177 \$109 \$109 sky130_gnd sky130_fd_pr__nfet_01v8_lvt l=0.6 w=1.4
+ as=0.406 ad=0.406 ps=3.38 pd=3.38
X$24 \$177 \$109 \$109 sky130_gnd sky130_fd_pr__nfet_01v8_lvt l=0.6 w=1.4
+ as=0.406 ad=0.406 ps=3.38 pd=3.38
X$25 \$177 \$109 \$109 sky130_gnd sky130_fd_pr__nfet_01v8_lvt l=0.6 w=1.4
+ as=0.406 ad=0.406 ps=3.38 pd=3.38
X$26 \$177 \$109 \$109 sky130_gnd sky130_fd_pr__nfet_01v8_lvt l=0.6 w=1.4
+ as=0.406 ad=0.406 ps=3.38 pd=3.38
X$27 \$177 \$109 \$109 sky130_gnd sky130_fd_pr__nfet_01v8_lvt l=0.6 w=1.4
+ as=0.406 ad=0.406 ps=3.38 pd=3.38
X$28 \$177 \$109 \$109 sky130_gnd sky130_fd_pr__nfet_01v8_lvt l=0.6 w=1.4
+ as=0.406 ad=0.406 ps=3.38 pd=3.38
X$29 \$177 \$109 \$109 sky130_gnd sky130_fd_pr__nfet_01v8_lvt l=0.6 w=1.4
+ as=0.406 ad=0.406 ps=3.38 pd=3.38
X$30 \$177 \$109 \$109 sky130_gnd sky130_fd_pr__nfet_01v8_lvt l=0.6 w=1.4
+ as=0.406 ad=0.406 ps=3.38 pd=3.38
X$31 \$177 \$109 \$109 sky130_gnd sky130_fd_pr__nfet_01v8_lvt l=0.6 w=1.4
+ as=0.406 ad=0.406 ps=3.38 pd=3.38
X$32 \$177 \$109 \$109 sky130_gnd sky130_fd_pr__nfet_01v8_lvt l=0.6 w=1.4
+ as=0.406 ad=0.406 ps=3.38 pd=3.38
X$33 \$177 \$109 \$109 sky130_gnd sky130_fd_pr__nfet_01v8_lvt l=0.6 w=1.4
+ as=0.406 ad=0.406 ps=3.38 pd=3.38
X$34 \$177 \$109 \$109 sky130_gnd sky130_fd_pr__nfet_01v8_lvt l=0.6 w=1.4
+ as=0.406 ad=0.406 ps=3.38 pd=3.38
X$35 \$177 \$109 \$109 sky130_gnd sky130_fd_pr__nfet_01v8_lvt l=0.6 w=1.4
+ as=0.406 ad=0.406 ps=3.38 pd=3.38
X$36 \$177 \$109 \$109 sky130_gnd sky130_fd_pr__nfet_01v8_lvt l=0.6 w=1.4
+ as=0.406 ad=0.406 ps=3.38 pd=3.38
X$37 \$177 \$109 \$109 sky130_gnd sky130_fd_pr__nfet_01v8_lvt l=0.6 w=1.4
+ as=0.406 ad=0.406 ps=3.38 pd=3.38
X$38 \$177 \$109 \$109 sky130_gnd sky130_fd_pr__nfet_01v8_lvt l=0.6 w=1.4
+ as=0.406 ad=0.406 ps=3.38 pd=3.38
X$39 \$177 \$109 \$109 sky130_gnd sky130_fd_pr__nfet_01v8_lvt l=0.6 w=1.4
+ as=0.406 ad=0.406 ps=3.38 pd=3.38
X$40 \$177 \$109 \$109 sky130_gnd sky130_fd_pr__nfet_01v8_lvt l=0.6 w=1.4
+ as=0.406 ad=0.406 ps=3.38 pd=3.38
X$41 \$177 \$109 \$109 sky130_gnd sky130_fd_pr__nfet_01v8_lvt l=0.6 w=1.4
+ as=0.406 ad=0.406 ps=3.38 pd=3.38
X$42 \$177 \$109 \$109 sky130_gnd sky130_fd_pr__nfet_01v8_lvt l=0.6 w=1.4
+ as=0.406 ad=0.406 ps=3.38 pd=3.38
X$43 \$177 \$109 \$109 sky130_gnd sky130_fd_pr__nfet_01v8_lvt l=0.6 w=1.4
+ as=0.406 ad=0.406 ps=3.38 pd=3.38
X$44 \$177 \$109 \$109 sky130_gnd sky130_fd_pr__nfet_01v8_lvt l=0.6 w=1.4
+ as=0.406 ad=0.406 ps=3.38 pd=3.38
X$45 \$177 \$109 \$109 sky130_gnd sky130_fd_pr__nfet_01v8_lvt l=0.6 w=1.4
+ as=0.406 ad=0.406 ps=3.38 pd=3.38
X$46 \$177 \$109 \$109 sky130_gnd sky130_fd_pr__nfet_01v8_lvt l=0.6 w=1.4
+ as=0.406 ad=0.406 ps=3.38 pd=3.38
X$47 \$177 \$109 \$109 sky130_gnd sky130_fd_pr__nfet_01v8_lvt l=0.6 w=1.4
+ as=0.406 ad=0.406 ps=3.38 pd=3.38
X$48 \$177 \$109 \$109 sky130_gnd sky130_fd_pr__nfet_01v8_lvt l=0.6 w=1.4
+ as=0.406 ad=0.406 ps=3.38 pd=3.38
X$49 \$177 \$109 \$109 sky130_gnd sky130_fd_pr__nfet_01v8_lvt l=0.6 w=1.4
+ as=0.406 ad=0.406 ps=3.38 pd=3.38
X$50 \$177 \$109 \$109 sky130_gnd sky130_fd_pr__nfet_01v8_lvt l=0.6 w=1.4
+ as=0.406 ad=0.406 ps=3.38 pd=3.38
X$51 \$177 \$109 \$109 sky130_gnd sky130_fd_pr__nfet_01v8_lvt l=0.6 w=1.4
+ as=0.406 ad=0.406 ps=3.38 pd=3.38
X$52 \$177 \$109 \$109 sky130_gnd sky130_fd_pr__nfet_01v8_lvt l=0.6 w=1.4
+ as=0.406 ad=0.406 ps=3.38 pd=3.38
X$53 \$177 \$109 \$109 sky130_gnd sky130_fd_pr__nfet_01v8_lvt l=0.6 w=1.4
+ as=0.406 ad=0.406 ps=3.38 pd=3.38
X$54 \$177 \$109 \$109 sky130_gnd sky130_fd_pr__nfet_01v8_lvt l=0.6 w=1.4
+ as=0.406 ad=0.406 ps=3.38 pd=3.38
X$55 \$177 \$109 \$109 sky130_gnd sky130_fd_pr__nfet_01v8_lvt l=0.6 w=1.4
+ as=0.406 ad=0.406 ps=3.38 pd=3.38
X$56 \$177 \$109 \$109 sky130_gnd sky130_fd_pr__nfet_01v8_lvt l=0.6 w=1.4
+ as=0.406 ad=0.406 ps=3.38 pd=3.38
X$57 \$177 \$109 \$109 sky130_gnd sky130_fd_pr__nfet_01v8_lvt l=0.6 w=1.4
+ as=0.406 ad=0.406 ps=3.38 pd=3.38
X$58 \$177 \$109 \$109 sky130_gnd sky130_fd_pr__nfet_01v8_lvt l=0.6 w=1.4
+ as=0.406 ad=0.406 ps=3.38 pd=3.38
X$59 \$177 \$109 \$109 sky130_gnd sky130_fd_pr__nfet_01v8_lvt l=0.6 w=1.4
+ as=0.406 ad=0.406 ps=3.38 pd=3.38
X$60 \$177 \$109 \$109 sky130_gnd sky130_fd_pr__nfet_01v8_lvt l=0.6 w=1.4
+ as=0.406 ad=0.406 ps=3.38 pd=3.38
X$61 \$177 \$109 \$109 sky130_gnd sky130_fd_pr__nfet_01v8_lvt l=0.6 w=1.4
+ as=0.406 ad=0.406 ps=3.38 pd=3.38
X$62 \$177 \$109 \$109 sky130_gnd sky130_fd_pr__nfet_01v8_lvt l=0.6 w=1.4
+ as=0.406 ad=0.406 ps=3.38 pd=3.38
X$63 \$177 \$109 \$109 sky130_gnd sky130_fd_pr__nfet_01v8_lvt l=0.6 w=1.4
+ as=0.406 ad=0.406 ps=3.38 pd=3.38
X$64 \$177 \$109 \$109 sky130_gnd sky130_fd_pr__nfet_01v8_lvt l=0.6 w=1.4
+ as=0.406 ad=0.406 ps=3.38 pd=3.38
X$65 \$177 \$177 \$177 sky130_gnd sky130_fd_pr__nfet_01v8_lvt l=0.6 w=1.4
+ as=0.406 ad=0.406 ps=3.38 pd=3.38
X$66 \$177 \$177 \$177 sky130_gnd sky130_fd_pr__nfet_01v8_lvt l=0.6 w=1.4
+ as=0.406 ad=0.406 ps=3.38 pd=3.38
X$67 \$177 \$177 \$177 sky130_gnd sky130_fd_pr__nfet_01v8_lvt l=0.6 w=1.4
+ as=0.406 ad=0.406 ps=3.38 pd=3.38
X$68 \$177 \$177 \$177 sky130_gnd sky130_fd_pr__nfet_01v8_lvt l=0.6 w=1.4
+ as=0.406 ad=0.406 ps=3.38 pd=3.38
X$69 \$177 \$177 \$177 sky130_gnd sky130_fd_pr__nfet_01v8_lvt l=0.6 w=1.4
+ as=0.406 ad=0.406 ps=3.38 pd=3.38
X$70 \$177 \$177 \$177 sky130_gnd sky130_fd_pr__nfet_01v8_lvt l=0.6 w=1.4
+ as=0.406 ad=0.406 ps=3.38 pd=3.38
X$71 \$177 \$177 \$177 sky130_gnd sky130_fd_pr__nfet_01v8_lvt l=0.6 w=1.4
+ as=0.406 ad=0.406 ps=3.38 pd=3.38
X$72 \$177 \$177 \$177 sky130_gnd sky130_fd_pr__nfet_01v8_lvt l=0.6 w=1.4
+ as=0.406 ad=0.406 ps=3.38 pd=3.38
X$73 \$109 \$109 \$109 sky130_gnd sky130_fd_pr__nfet_01v8_lvt l=0.6 w=1.4
+ as=0.406 ad=0.406 ps=3.38 pd=3.38
X$74 \$109 \$109 \$109 sky130_gnd sky130_fd_pr__nfet_01v8_lvt l=0.6 w=1.4
+ as=0.406 ad=0.406 ps=3.38 pd=3.38
X$75 \$109 \$109 \$109 sky130_gnd sky130_fd_pr__nfet_01v8_lvt l=0.6 w=1.4
+ as=0.406 ad=0.406 ps=3.38 pd=3.38
X$76 \$109 \$109 \$109 sky130_gnd sky130_fd_pr__nfet_01v8_lvt l=0.6 w=1.4
+ as=0.406 ad=0.406 ps=3.38 pd=3.38
X$77 \$109 \$109 \$109 sky130_gnd sky130_fd_pr__nfet_01v8_lvt l=0.6 w=1.4
+ as=0.406 ad=0.406 ps=3.38 pd=3.38
X$78 \$109 \$109 \$109 sky130_gnd sky130_fd_pr__nfet_01v8_lvt l=0.6 w=1.4
+ as=0.406 ad=0.406 ps=3.38 pd=3.38
X$79 \$109 \$109 \$109 sky130_gnd sky130_fd_pr__nfet_01v8_lvt l=0.6 w=1.4
+ as=0.406 ad=0.406 ps=3.38 pd=3.38
X$80 \$109 \$109 \$109 sky130_gnd sky130_fd_pr__nfet_01v8_lvt l=0.6 w=1.4
+ as=0.406 ad=0.406 ps=3.38 pd=3.38
X$81 VDD VDD VDD VDD sky130_fd_pr__pfet_01v8_lvt l=0.6 w=1.4 as=0.406 ad=0.406
+ ps=3.38 pd=3.38
X$82 VDD VDD VDD VDD sky130_fd_pr__pfet_01v8_lvt l=0.6 w=1.4 as=0.406 ad=0.406
+ ps=3.38 pd=3.38
X$83 VDD VDD VDD VDD sky130_fd_pr__pfet_01v8_lvt l=0.6 w=1.4 as=0.406 ad=0.406
+ ps=3.38 pd=3.38
X$84 VDD VDD VDD VDD sky130_fd_pr__pfet_01v8_lvt l=0.6 w=1.4 as=0.406 ad=0.406
+ ps=3.38 pd=3.38
X$85 VDD VDD VDD VDD sky130_fd_pr__pfet_01v8_lvt l=0.6 w=1.4 as=0.406 ad=0.406
+ ps=3.38 pd=3.38
X$86 VDD VDD VDD VDD sky130_fd_pr__pfet_01v8_lvt l=0.6 w=1.4 as=0.406 ad=0.406
+ ps=3.38 pd=3.38
X$87 VDD VDD VDD VDD sky130_fd_pr__pfet_01v8_lvt l=0.6 w=1.4 as=0.406 ad=0.406
+ ps=3.38 pd=3.38
X$88 VDD VDD VDD VDD sky130_fd_pr__pfet_01v8_lvt l=0.6 w=1.4 as=0.406 ad=0.406
+ ps=3.38 pd=3.38
X$89 VDD VDD VDD VDD sky130_fd_pr__pfet_01v8_lvt l=0.6 w=1.4 as=0.406 ad=0.406
+ ps=3.38 pd=3.38
X$90 VDD VDD VDD VDD sky130_fd_pr__pfet_01v8_lvt l=0.6 w=1.4 as=0.406 ad=0.406
+ ps=3.38 pd=3.38
X$91 \$265 \$265 \$265 VDD sky130_fd_pr__pfet_01v8_lvt l=0.6 w=1.4 as=0.406
+ ad=0.406 ps=3.38 pd=3.38
X$92 \$265 \$265 \$265 VDD sky130_fd_pr__pfet_01v8_lvt l=0.6 w=1.4 as=0.406
+ ad=0.406 ps=3.38 pd=3.38
X$93 \$261 \$261 \$261 VDD sky130_fd_pr__pfet_01v8_lvt l=0.6 w=1.4 as=0.406
+ ad=0.406 ps=3.38 pd=3.38
X$94 \$261 \$261 \$261 VDD sky130_fd_pr__pfet_01v8_lvt l=0.6 w=1.4 as=0.406
+ ad=0.406 ps=3.38 pd=3.38
X$95 \$266 \$266 \$266 VDD sky130_fd_pr__pfet_01v8_lvt l=0.6 w=1.4 as=0.406
+ ad=0.406 ps=3.38 pd=3.38
X$96 \$266 \$266 \$266 VDD sky130_fd_pr__pfet_01v8_lvt l=0.6 w=1.4 as=0.406
+ ad=0.406 ps=3.38 pd=3.38
X$97 \$16 ip \$51 sky130_gnd sky130_fd_pr__nfet_01v8_lvt l=0.2 w=1.2 as=0.348
+ ad=0.348 ps=2.98 pd=2.98
X$98 \$16 ip \$51 sky130_gnd sky130_fd_pr__nfet_01v8_lvt l=0.2 w=1.2 as=0.348
+ ad=0.348 ps=2.98 pd=2.98
X$99 \$16 in \$50 sky130_gnd sky130_fd_pr__nfet_01v8_lvt l=0.2 w=1.2 as=0.348
+ ad=0.348 ps=2.98 pd=2.98
X$100 \$16 ip \$51 sky130_gnd sky130_fd_pr__nfet_01v8_lvt l=0.2 w=1.2 as=0.348
+ ad=0.348 ps=2.98 pd=2.98
X$101 \$16 in \$50 sky130_gnd sky130_fd_pr__nfet_01v8_lvt l=0.2 w=1.2 as=0.348
+ ad=0.348 ps=2.98 pd=2.98
X$102 \$16 ip \$51 sky130_gnd sky130_fd_pr__nfet_01v8_lvt l=0.2 w=1.2 as=0.348
+ ad=0.348 ps=2.98 pd=2.98
X$103 \$16 in \$50 sky130_gnd sky130_fd_pr__nfet_01v8_lvt l=0.2 w=1.2 as=0.348
+ ad=0.348 ps=2.98 pd=2.98
X$104 \$16 in \$50 sky130_gnd sky130_fd_pr__nfet_01v8_lvt l=0.2 w=1.2 as=0.348
+ ad=0.348 ps=2.98 pd=2.98
X$105 \$16 ip \$51 sky130_gnd sky130_fd_pr__nfet_01v8_lvt l=0.2 w=1.2 as=0.348
+ ad=0.348 ps=2.98 pd=2.98
X$106 \$16 in \$50 sky130_gnd sky130_fd_pr__nfet_01v8_lvt l=0.2 w=1.2 as=0.348
+ ad=0.348 ps=2.98 pd=2.98
X$107 \$16 ip \$51 sky130_gnd sky130_fd_pr__nfet_01v8_lvt l=0.2 w=1.2 as=0.348
+ ad=0.348 ps=2.98 pd=2.98
X$108 \$16 in \$50 sky130_gnd sky130_fd_pr__nfet_01v8_lvt l=0.2 w=1.2 as=0.348
+ ad=0.348 ps=2.98 pd=2.98
X$109 \$50 \$50 \$50 sky130_gnd sky130_fd_pr__nfet_01v8_lvt l=0.2 w=1.2
+ as=0.348 ad=0.348 ps=2.98 pd=2.98
X$110 \$50 \$50 \$50 sky130_gnd sky130_fd_pr__nfet_01v8_lvt l=0.2 w=1.2
+ as=0.348 ad=0.348 ps=2.98 pd=2.98
X$111 \$51 \$51 \$51 sky130_gnd sky130_fd_pr__nfet_01v8_lvt l=0.2 w=1.2
+ as=0.348 ad=0.348 ps=2.98 pd=2.98
X$112 \$51 \$51 \$51 sky130_gnd sky130_fd_pr__nfet_01v8_lvt l=0.2 w=1.2
+ as=0.348 ad=0.348 ps=2.98 pd=2.98
X$113 VDD VDD VDD VDD sky130_fd_pr__pfet_01v8 l=0.6 w=1.4 as=0.406 ad=0.406
+ ps=3.38 pd=3.38
X$114 VDD VDD VDD VDD sky130_fd_pr__pfet_01v8 l=0.6 w=1.4 as=0.406 ad=0.406
+ ps=3.38 pd=3.38
X$115 VDD VDD VDD VDD sky130_fd_pr__pfet_01v8 l=0.6 w=1.4 as=0.406 ad=0.406
+ ps=3.38 pd=3.38
X$116 VDD VDD VDD VDD sky130_fd_pr__pfet_01v8 l=0.6 w=1.4 as=0.406 ad=0.406
+ ps=3.38 pd=3.38
X$117 VDD VDD VDD VDD sky130_fd_pr__pfet_01v8 l=0.6 w=1.4 as=0.406 ad=0.406
+ ps=3.38 pd=3.38
X$118 VDD VDD VDD VDD sky130_fd_pr__pfet_01v8 l=0.6 w=1.4 as=0.406 ad=0.406
+ ps=3.38 pd=3.38
X$119 VDD VDD VDD VDD sky130_fd_pr__pfet_01v8 l=0.6 w=1.4 as=0.406 ad=0.406
+ ps=3.38 pd=3.38
X$120 VDD VDD VDD VDD sky130_fd_pr__pfet_01v8 l=0.6 w=1.4 as=0.406 ad=0.406
+ ps=3.38 pd=3.38
X$121 \$265 \$177 \$109 VDD sky130_fd_pr__pfet_01v8 l=0.6 w=1.4 as=0.406
+ ad=0.406 ps=3.38 pd=3.38
X$122 \$261 \$177 \$162 VDD sky130_fd_pr__pfet_01v8 l=0.6 w=1.4 as=0.406
+ ad=0.406 ps=3.38 pd=3.38
X$123 \$266 \$177 cm VDD sky130_fd_pr__pfet_01v8 l=0.6 w=1.4 as=0.406 ad=0.406
+ ps=3.38 pd=3.38
X$124 \$265 \$177 \$109 VDD sky130_fd_pr__pfet_01v8 l=0.6 w=1.4 as=0.406
+ ad=0.406 ps=3.38 pd=3.38
X$125 \$261 \$177 \$162 VDD sky130_fd_pr__pfet_01v8 l=0.6 w=1.4 as=0.406
+ ad=0.406 ps=3.38 pd=3.38
X$126 \$266 \$177 cm VDD sky130_fd_pr__pfet_01v8 l=0.6 w=1.4 as=0.406 ad=0.406
+ ps=3.38 pd=3.38
X$127 \$265 \$177 \$109 VDD sky130_fd_pr__pfet_01v8 l=0.6 w=1.4 as=0.406
+ ad=0.406 ps=3.38 pd=3.38
X$128 \$261 \$177 \$162 VDD sky130_fd_pr__pfet_01v8 l=0.6 w=1.4 as=0.406
+ ad=0.406 ps=3.38 pd=3.38
X$129 \$266 \$177 cm VDD sky130_fd_pr__pfet_01v8 l=0.6 w=1.4 as=0.406 ad=0.406
+ ps=3.38 pd=3.38
X$130 \$266 \$177 cm VDD sky130_fd_pr__pfet_01v8 l=0.6 w=1.4 as=0.406 ad=0.406
+ ps=3.38 pd=3.38
X$131 \$261 \$177 \$162 VDD sky130_fd_pr__pfet_01v8 l=0.6 w=1.4 as=0.406
+ ad=0.406 ps=3.38 pd=3.38
X$132 \$265 \$177 \$109 VDD sky130_fd_pr__pfet_01v8 l=0.6 w=1.4 as=0.406
+ ad=0.406 ps=3.38 pd=3.38
X$133 \$266 \$177 cm VDD sky130_fd_pr__pfet_01v8 l=0.6 w=1.4 as=0.406 ad=0.406
+ ps=3.38 pd=3.38
X$134 \$261 \$177 \$162 VDD sky130_fd_pr__pfet_01v8 l=0.6 w=1.4 as=0.406
+ ad=0.406 ps=3.38 pd=3.38
X$135 \$265 \$177 \$109 VDD sky130_fd_pr__pfet_01v8 l=0.6 w=1.4 as=0.406
+ ad=0.406 ps=3.38 pd=3.38
X$136 \$266 \$177 cm VDD sky130_fd_pr__pfet_01v8 l=0.6 w=1.4 as=0.406 ad=0.406
+ ps=3.38 pd=3.38
X$137 \$261 \$177 \$162 VDD sky130_fd_pr__pfet_01v8 l=0.6 w=1.4 as=0.406
+ ad=0.406 ps=3.38 pd=3.38
X$138 \$265 \$177 \$109 VDD sky130_fd_pr__pfet_01v8 l=0.6 w=1.4 as=0.406
+ ad=0.406 ps=3.38 pd=3.38
X$139 \$50 \$177 op VDD sky130_fd_pr__pfet_01v8 l=0.6 w=1.4 as=0.406 ad=0.406
+ ps=3.38 pd=3.38
X$140 \$51 \$177 on VDD sky130_fd_pr__pfet_01v8 l=0.6 w=1.4 as=0.406 ad=0.406
+ ps=3.38 pd=3.38
X$141 \$50 \$177 op VDD sky130_fd_pr__pfet_01v8 l=0.6 w=1.4 as=0.406 ad=0.406
+ ps=3.38 pd=3.38
X$142 \$51 \$177 on VDD sky130_fd_pr__pfet_01v8 l=0.6 w=1.4 as=0.406 ad=0.406
+ ps=3.38 pd=3.38
X$143 \$50 \$177 op VDD sky130_fd_pr__pfet_01v8 l=0.6 w=1.4 as=0.406 ad=0.406
+ ps=3.38 pd=3.38
X$144 \$50 \$177 op VDD sky130_fd_pr__pfet_01v8 l=0.6 w=1.4 as=0.406 ad=0.406
+ ps=3.38 pd=3.38
X$145 \$51 \$177 on VDD sky130_fd_pr__pfet_01v8 l=0.6 w=1.4 as=0.406 ad=0.406
+ ps=3.38 pd=3.38
X$146 \$50 \$177 op VDD sky130_fd_pr__pfet_01v8 l=0.6 w=1.4 as=0.406 ad=0.406
+ ps=3.38 pd=3.38
X$147 \$51 \$177 on VDD sky130_fd_pr__pfet_01v8 l=0.6 w=1.4 as=0.406 ad=0.406
+ ps=3.38 pd=3.38
X$148 \$51 \$177 on VDD sky130_fd_pr__pfet_01v8 l=0.6 w=1.4 as=0.406 ad=0.406
+ ps=3.38 pd=3.38
X$149 \$51 \$177 on VDD sky130_fd_pr__pfet_01v8 l=0.6 w=1.4 as=0.406 ad=0.406
+ ps=3.38 pd=3.38
X$150 \$50 \$177 op VDD sky130_fd_pr__pfet_01v8 l=0.6 w=1.4 as=0.406 ad=0.406
+ ps=3.38 pd=3.38
X$151 \$51 \$177 on VDD sky130_fd_pr__pfet_01v8 l=0.6 w=1.4 as=0.406 ad=0.406
+ ps=3.38 pd=3.38
X$152 \$50 \$177 op VDD sky130_fd_pr__pfet_01v8 l=0.6 w=1.4 as=0.406 ad=0.406
+ ps=3.38 pd=3.38
X$153 \$51 \$177 on VDD sky130_fd_pr__pfet_01v8 l=0.6 w=1.4 as=0.406 ad=0.406
+ ps=3.38 pd=3.38
X$154 \$50 \$177 op VDD sky130_fd_pr__pfet_01v8 l=0.6 w=1.4 as=0.406 ad=0.406
+ ps=3.38 pd=3.38
X$155 \$51 \$177 on VDD sky130_fd_pr__pfet_01v8 l=0.6 w=1.4 as=0.406 ad=0.406
+ ps=3.38 pd=3.38
X$156 \$50 \$177 op VDD sky130_fd_pr__pfet_01v8 l=0.6 w=1.4 as=0.406 ad=0.406
+ ps=3.38 pd=3.38
X$157 \$51 \$177 on VDD sky130_fd_pr__pfet_01v8 l=0.6 w=1.4 as=0.406 ad=0.406
+ ps=3.38 pd=3.38
X$158 \$50 \$177 op VDD sky130_fd_pr__pfet_01v8 l=0.6 w=1.4 as=0.406 ad=0.406
+ ps=3.38 pd=3.38
X$159 \$50 \$177 op VDD sky130_fd_pr__pfet_01v8 l=0.6 w=1.4 as=0.406 ad=0.406
+ ps=3.38 pd=3.38
X$160 \$51 \$177 on VDD sky130_fd_pr__pfet_01v8 l=0.6 w=1.4 as=0.406 ad=0.406
+ ps=3.38 pd=3.38
X$161 \$50 \$177 op VDD sky130_fd_pr__pfet_01v8 l=0.6 w=1.4 as=0.406 ad=0.406
+ ps=3.38 pd=3.38
X$162 \$51 \$177 on VDD sky130_fd_pr__pfet_01v8 l=0.6 w=1.4 as=0.406 ad=0.406
+ ps=3.38 pd=3.38
X$163 \$51 \$177 on VDD sky130_fd_pr__pfet_01v8 l=0.6 w=1.4 as=0.406 ad=0.406
+ ps=3.38 pd=3.38
X$164 \$50 \$177 op VDD sky130_fd_pr__pfet_01v8 l=0.6 w=1.4 as=0.406 ad=0.406
+ ps=3.38 pd=3.38
X$165 \$51 \$177 on VDD sky130_fd_pr__pfet_01v8 l=0.6 w=1.4 as=0.406 ad=0.406
+ ps=3.38 pd=3.38
X$166 \$50 \$177 op VDD sky130_fd_pr__pfet_01v8 l=0.6 w=1.4 as=0.406 ad=0.406
+ ps=3.38 pd=3.38
X$167 \$51 \$177 on VDD sky130_fd_pr__pfet_01v8 l=0.6 w=1.4 as=0.406 ad=0.406
+ ps=3.38 pd=3.38
X$168 \$50 \$177 op VDD sky130_fd_pr__pfet_01v8 l=0.6 w=1.4 as=0.406 ad=0.406
+ ps=3.38 pd=3.38
X$169 \$51 \$177 on VDD sky130_fd_pr__pfet_01v8 l=0.6 w=1.4 as=0.406 ad=0.406
+ ps=3.38 pd=3.38
X$170 \$50 \$177 op VDD sky130_fd_pr__pfet_01v8 l=0.6 w=1.4 as=0.406 ad=0.406
+ ps=3.38 pd=3.38
X$171 \$51 \$177 on VDD sky130_fd_pr__pfet_01v8 l=0.6 w=1.4 as=0.406 ad=0.406
+ ps=3.38 pd=3.38
X$172 \$50 \$177 op VDD sky130_fd_pr__pfet_01v8 l=0.6 w=1.4 as=0.406 ad=0.406
+ ps=3.38 pd=3.38
X$173 \$51 \$177 on VDD sky130_fd_pr__pfet_01v8 l=0.6 w=1.4 as=0.406 ad=0.406
+ ps=3.38 pd=3.38
X$174 \$50 \$177 op VDD sky130_fd_pr__pfet_01v8 l=0.6 w=1.4 as=0.406 ad=0.406
+ ps=3.38 pd=3.38
X$175 \$51 \$177 on VDD sky130_fd_pr__pfet_01v8 l=0.6 w=1.4 as=0.406 ad=0.406
+ ps=3.38 pd=3.38
X$176 \$50 \$177 op VDD sky130_fd_pr__pfet_01v8 l=0.6 w=1.4 as=0.406 ad=0.406
+ ps=3.38 pd=3.38
X$177 \$50 \$177 op VDD sky130_fd_pr__pfet_01v8 l=0.6 w=1.4 as=0.406 ad=0.406
+ ps=3.38 pd=3.38
X$178 \$51 \$177 on VDD sky130_fd_pr__pfet_01v8 l=0.6 w=1.4 as=0.406 ad=0.406
+ ps=3.38 pd=3.38
X$179 VDD VDD on VDD sky130_fd_pr__pfet_01v8 l=0.6 w=1.4 as=0.406 ad=0.406
+ ps=3.38 pd=3.38
X$180 VDD VDD op VDD sky130_fd_pr__pfet_01v8 l=0.6 w=1.4 as=0.406 ad=0.406
+ ps=3.38 pd=3.38
X$181 VDD VDD op VDD sky130_fd_pr__pfet_01v8 l=0.6 w=1.4 as=0.406 ad=0.406
+ ps=3.38 pd=3.38
X$182 VDD VDD on VDD sky130_fd_pr__pfet_01v8 l=0.6 w=1.4 as=0.406 ad=0.406
+ ps=3.38 pd=3.38
X$183 VDD VDD on VDD sky130_fd_pr__pfet_01v8 l=0.6 w=1.4 as=0.406 ad=0.406
+ ps=3.38 pd=3.38
X$184 VDD VDD op VDD sky130_fd_pr__pfet_01v8 l=0.6 w=1.4 as=0.406 ad=0.406
+ ps=3.38 pd=3.38
X$185 VDD VDD on VDD sky130_fd_pr__pfet_01v8 l=0.6 w=1.4 as=0.406 ad=0.406
+ ps=3.38 pd=3.38
X$186 VDD VDD op VDD sky130_fd_pr__pfet_01v8 l=0.6 w=1.4 as=0.406 ad=0.406
+ ps=3.38 pd=3.38
X$187 VDD \$109 \$265 VDD sky130_fd_pr__pfet_01v8_lvt l=0.6 w=1.4 as=0.406
+ ad=0.406 ps=3.38 pd=3.38
X$188 VDD \$109 \$266 VDD sky130_fd_pr__pfet_01v8_lvt l=0.6 w=1.4 as=0.406
+ ad=0.406 ps=3.38 pd=3.38
X$189 VDD \$109 \$266 VDD sky130_fd_pr__pfet_01v8_lvt l=0.6 w=1.4 as=0.406
+ ad=0.406 ps=3.38 pd=3.38
X$190 VDD \$109 \$261 VDD sky130_fd_pr__pfet_01v8_lvt l=0.6 w=1.4 as=0.406
+ ad=0.406 ps=3.38 pd=3.38
X$191 VDD \$109 \$261 VDD sky130_fd_pr__pfet_01v8_lvt l=0.6 w=1.4 as=0.406
+ ad=0.406 ps=3.38 pd=3.38
X$192 VDD \$109 \$266 VDD sky130_fd_pr__pfet_01v8_lvt l=0.6 w=1.4 as=0.406
+ ad=0.406 ps=3.38 pd=3.38
X$193 VDD \$109 \$261 VDD sky130_fd_pr__pfet_01v8_lvt l=0.6 w=1.4 as=0.406
+ ad=0.406 ps=3.38 pd=3.38
X$194 VDD \$109 \$265 VDD sky130_fd_pr__pfet_01v8_lvt l=0.6 w=1.4 as=0.406
+ ad=0.406 ps=3.38 pd=3.38
X$195 VDD \$109 \$265 VDD sky130_fd_pr__pfet_01v8_lvt l=0.6 w=1.4 as=0.406
+ ad=0.406 ps=3.38 pd=3.38
X$196 VDD \$109 \$261 VDD sky130_fd_pr__pfet_01v8_lvt l=0.6 w=1.4 as=0.406
+ ad=0.406 ps=3.38 pd=3.38
X$197 VDD \$109 \$265 VDD sky130_fd_pr__pfet_01v8_lvt l=0.6 w=1.4 as=0.406
+ ad=0.406 ps=3.38 pd=3.38
X$198 VDD \$109 \$261 VDD sky130_fd_pr__pfet_01v8_lvt l=0.6 w=1.4 as=0.406
+ ad=0.406 ps=3.38 pd=3.38
X$199 VDD \$109 \$266 VDD sky130_fd_pr__pfet_01v8_lvt l=0.6 w=1.4 as=0.406
+ ad=0.406 ps=3.38 pd=3.38
X$200 VDD \$109 \$266 VDD sky130_fd_pr__pfet_01v8_lvt l=0.6 w=1.4 as=0.406
+ ad=0.406 ps=3.38 pd=3.38
X$201 VDD \$109 \$261 VDD sky130_fd_pr__pfet_01v8_lvt l=0.6 w=1.4 as=0.406
+ ad=0.406 ps=3.38 pd=3.38
X$202 VDD \$109 \$265 VDD sky130_fd_pr__pfet_01v8_lvt l=0.6 w=1.4 as=0.406
+ ad=0.406 ps=3.38 pd=3.38
X$203 VDD \$109 \$266 VDD sky130_fd_pr__pfet_01v8_lvt l=0.6 w=1.4 as=0.406
+ ad=0.406 ps=3.38 pd=3.38
X$204 VDD \$109 \$265 VDD sky130_fd_pr__pfet_01v8_lvt l=0.6 w=1.4 as=0.406
+ ad=0.406 ps=3.38 pd=3.38
X$205 VDD \$109 \$50 VDD sky130_fd_pr__pfet_01v8_lvt l=0.6 w=1.4 as=0.406
+ ad=0.406 ps=3.38 pd=3.38
X$206 VDD \$109 \$51 VDD sky130_fd_pr__pfet_01v8_lvt l=0.6 w=1.4 as=0.406
+ ad=0.406 ps=3.38 pd=3.38
X$207 VDD \$109 \$50 VDD sky130_fd_pr__pfet_01v8_lvt l=0.6 w=1.4 as=0.406
+ ad=0.406 ps=3.38 pd=3.38
X$208 VDD \$109 \$51 VDD sky130_fd_pr__pfet_01v8_lvt l=0.6 w=1.4 as=0.406
+ ad=0.406 ps=3.38 pd=3.38
X$209 VDD \$109 \$50 VDD sky130_fd_pr__pfet_01v8_lvt l=0.6 w=1.4 as=0.406
+ ad=0.406 ps=3.38 pd=3.38
X$210 VDD \$109 \$51 VDD sky130_fd_pr__pfet_01v8_lvt l=0.6 w=1.4 as=0.406
+ ad=0.406 ps=3.38 pd=3.38
X$211 VDD \$109 \$50 VDD sky130_fd_pr__pfet_01v8_lvt l=0.6 w=1.4 as=0.406
+ ad=0.406 ps=3.38 pd=3.38
X$212 VDD \$109 \$50 VDD sky130_fd_pr__pfet_01v8_lvt l=0.6 w=1.4 as=0.406
+ ad=0.406 ps=3.38 pd=3.38
X$213 VDD \$109 \$51 VDD sky130_fd_pr__pfet_01v8_lvt l=0.6 w=1.4 as=0.406
+ ad=0.406 ps=3.38 pd=3.38
X$214 VDD \$109 \$50 VDD sky130_fd_pr__pfet_01v8_lvt l=0.6 w=1.4 as=0.406
+ ad=0.406 ps=3.38 pd=3.38
X$215 VDD \$109 \$51 VDD sky130_fd_pr__pfet_01v8_lvt l=0.6 w=1.4 as=0.406
+ ad=0.406 ps=3.38 pd=3.38
X$216 VDD \$109 \$50 VDD sky130_fd_pr__pfet_01v8_lvt l=0.6 w=1.4 as=0.406
+ ad=0.406 ps=3.38 pd=3.38
X$217 VDD \$109 \$51 VDD sky130_fd_pr__pfet_01v8_lvt l=0.6 w=1.4 as=0.406
+ ad=0.406 ps=3.38 pd=3.38
X$218 VDD \$109 \$50 VDD sky130_fd_pr__pfet_01v8_lvt l=0.6 w=1.4 as=0.406
+ ad=0.406 ps=3.38 pd=3.38
X$219 VDD \$109 \$51 VDD sky130_fd_pr__pfet_01v8_lvt l=0.6 w=1.4 as=0.406
+ ad=0.406 ps=3.38 pd=3.38
X$220 VDD \$109 \$51 VDD sky130_fd_pr__pfet_01v8_lvt l=0.6 w=1.4 as=0.406
+ ad=0.406 ps=3.38 pd=3.38
X$221 VDD \$109 \$51 VDD sky130_fd_pr__pfet_01v8_lvt l=0.6 w=1.4 as=0.406
+ ad=0.406 ps=3.38 pd=3.38
X$222 VDD \$109 \$50 VDD sky130_fd_pr__pfet_01v8_lvt l=0.6 w=1.4 as=0.406
+ ad=0.406 ps=3.38 pd=3.38
X$223 VDD \$109 \$51 VDD sky130_fd_pr__pfet_01v8_lvt l=0.6 w=1.4 as=0.406
+ ad=0.406 ps=3.38 pd=3.38
X$224 VDD \$109 \$50 VDD sky130_fd_pr__pfet_01v8_lvt l=0.6 w=1.4 as=0.406
+ ad=0.406 ps=3.38 pd=3.38
X$225 VDD \$109 \$51 VDD sky130_fd_pr__pfet_01v8_lvt l=0.6 w=1.4 as=0.406
+ ad=0.406 ps=3.38 pd=3.38
X$226 VDD \$109 \$50 VDD sky130_fd_pr__pfet_01v8_lvt l=0.6 w=1.4 as=0.406
+ ad=0.406 ps=3.38 pd=3.38
X$227 VDD \$109 \$51 VDD sky130_fd_pr__pfet_01v8_lvt l=0.6 w=1.4 as=0.406
+ ad=0.406 ps=3.38 pd=3.38
X$228 VDD \$109 \$50 VDD sky130_fd_pr__pfet_01v8_lvt l=0.6 w=1.4 as=0.406
+ ad=0.406 ps=3.38 pd=3.38
X$229 VDD \$109 \$51 VDD sky130_fd_pr__pfet_01v8_lvt l=0.6 w=1.4 as=0.406
+ ad=0.406 ps=3.38 pd=3.38
X$230 VDD \$109 \$51 VDD sky130_fd_pr__pfet_01v8_lvt l=0.6 w=1.4 as=0.406
+ ad=0.406 ps=3.38 pd=3.38
X$231 VDD \$109 \$50 VDD sky130_fd_pr__pfet_01v8_lvt l=0.6 w=1.4 as=0.406
+ ad=0.406 ps=3.38 pd=3.38
X$232 VDD \$109 \$51 VDD sky130_fd_pr__pfet_01v8_lvt l=0.6 w=1.4 as=0.406
+ ad=0.406 ps=3.38 pd=3.38
X$233 VDD \$109 \$50 VDD sky130_fd_pr__pfet_01v8_lvt l=0.6 w=1.4 as=0.406
+ ad=0.406 ps=3.38 pd=3.38
X$234 VDD \$109 \$51 VDD sky130_fd_pr__pfet_01v8_lvt l=0.6 w=1.4 as=0.406
+ ad=0.406 ps=3.38 pd=3.38
X$235 VDD \$109 \$50 VDD sky130_fd_pr__pfet_01v8_lvt l=0.6 w=1.4 as=0.406
+ ad=0.406 ps=3.38 pd=3.38
X$236 VDD \$109 \$50 VDD sky130_fd_pr__pfet_01v8_lvt l=0.6 w=1.4 as=0.406
+ ad=0.406 ps=3.38 pd=3.38
X$237 VDD \$109 \$50 VDD sky130_fd_pr__pfet_01v8_lvt l=0.6 w=1.4 as=0.406
+ ad=0.406 ps=3.38 pd=3.38
X$238 VDD \$109 \$51 VDD sky130_fd_pr__pfet_01v8_lvt l=0.6 w=1.4 as=0.406
+ ad=0.406 ps=3.38 pd=3.38
X$239 VDD \$109 \$50 VDD sky130_fd_pr__pfet_01v8_lvt l=0.6 w=1.4 as=0.406
+ ad=0.406 ps=3.38 pd=3.38
X$240 VDD \$109 \$50 VDD sky130_fd_pr__pfet_01v8_lvt l=0.6 w=1.4 as=0.406
+ ad=0.406 ps=3.38 pd=3.38
X$241 VDD \$109 \$51 VDD sky130_fd_pr__pfet_01v8_lvt l=0.6 w=1.4 as=0.406
+ ad=0.406 ps=3.38 pd=3.38
X$242 VDD \$109 \$50 VDD sky130_fd_pr__pfet_01v8_lvt l=0.6 w=1.4 as=0.406
+ ad=0.406 ps=3.38 pd=3.38
X$243 VDD \$109 \$51 VDD sky130_fd_pr__pfet_01v8_lvt l=0.6 w=1.4 as=0.406
+ ad=0.406 ps=3.38 pd=3.38
X$244 VDD \$109 \$50 VDD sky130_fd_pr__pfet_01v8_lvt l=0.6 w=1.4 as=0.406
+ ad=0.406 ps=3.38 pd=3.38
X$245 VDD \$109 \$51 VDD sky130_fd_pr__pfet_01v8_lvt l=0.6 w=1.4 as=0.406
+ ad=0.406 ps=3.38 pd=3.38
X$246 VDD \$109 \$50 VDD sky130_fd_pr__pfet_01v8_lvt l=0.6 w=1.4 as=0.406
+ ad=0.406 ps=3.38 pd=3.38
X$247 VDD \$109 \$51 VDD sky130_fd_pr__pfet_01v8_lvt l=0.6 w=1.4 as=0.406
+ ad=0.406 ps=3.38 pd=3.38
X$248 VDD \$109 \$50 VDD sky130_fd_pr__pfet_01v8_lvt l=0.6 w=1.4 as=0.406
+ ad=0.406 ps=3.38 pd=3.38
X$249 VDD \$109 \$51 VDD sky130_fd_pr__pfet_01v8_lvt l=0.6 w=1.4 as=0.406
+ ad=0.406 ps=3.38 pd=3.38
X$250 VDD \$109 \$50 VDD sky130_fd_pr__pfet_01v8_lvt l=0.6 w=1.4 as=0.406
+ ad=0.406 ps=3.38 pd=3.38
X$251 VDD \$109 \$51 VDD sky130_fd_pr__pfet_01v8_lvt l=0.6 w=1.4 as=0.406
+ ad=0.406 ps=3.38 pd=3.38
X$252 VDD \$109 \$51 VDD sky130_fd_pr__pfet_01v8_lvt l=0.6 w=1.4 as=0.406
+ ad=0.406 ps=3.38 pd=3.38
X$253 VDD VDD \$109 VDD sky130_fd_pr__pfet_01v8 l=0.6 w=1.4 as=0.406 ad=0.406
+ ps=3.38 pd=3.38
X$254 VDD VDD \$162 VDD sky130_fd_pr__pfet_01v8 l=0.6 w=1.4 as=0.406 ad=0.406
+ ps=3.38 pd=3.38
X$255 VDD VDD cm VDD sky130_fd_pr__pfet_01v8 l=0.6 w=1.4 as=0.406 ad=0.406
+ ps=3.38 pd=3.38
X$256 VDD VDD \$109 VDD sky130_fd_pr__pfet_01v8 l=0.6 w=1.4 as=0.406 ad=0.406
+ ps=3.38 pd=3.38
X$257 VDD VDD \$162 VDD sky130_fd_pr__pfet_01v8 l=0.6 w=1.4 as=0.406 ad=0.406
+ ps=3.38 pd=3.38
X$258 VDD VDD cm VDD sky130_fd_pr__pfet_01v8 l=0.6 w=1.4 as=0.406 ad=0.406
+ ps=3.38 pd=3.38
X$259 VDD VDD \$266 VDD sky130_fd_pr__pfet_01v8 l=0.6 w=1.4 as=0.406 ad=0.406
+ ps=3.38 pd=3.38
X$260 \$265 \$265 \$265 VDD sky130_fd_pr__pfet_01v8 l=0.6 w=1.4 as=0.406
+ ad=0.406 ps=3.38 pd=3.38
X$261 \$265 \$265 \$265 VDD sky130_fd_pr__pfet_01v8 l=0.6 w=1.4 as=0.406
+ ad=0.406 ps=3.38 pd=3.38
X$262 \$261 \$261 \$261 VDD sky130_fd_pr__pfet_01v8 l=0.6 w=1.4 as=0.406
+ ad=0.406 ps=3.38 pd=3.38
X$263 \$261 \$261 \$261 VDD sky130_fd_pr__pfet_01v8 l=0.6 w=1.4 as=0.406
+ ad=0.406 ps=3.38 pd=3.38
X$264 VDD VDD \$266 VDD sky130_fd_pr__pfet_01v8 l=0.6 w=1.4 as=0.406 ad=0.406
+ ps=3.38 pd=3.38
X$265 VDD VDD \$50 VDD sky130_fd_pr__pfet_01v8 l=0.6 w=1.4 as=0.406 ad=0.406
+ ps=3.38 pd=3.38
X$266 VDD VDD \$50 VDD sky130_fd_pr__pfet_01v8 l=0.6 w=1.4 as=0.406 ad=0.406
+ ps=3.38 pd=3.38
X$267 \$51 \$51 \$51 VDD sky130_fd_pr__pfet_01v8 l=0.6 w=1.4 as=0.406 ad=0.406
+ ps=3.38 pd=3.38
X$268 VDD VDD VDD VDD sky130_fd_pr__pfet_01v8 l=0.6 w=1.4 as=0.406 ad=0.406
+ ps=3.38 pd=3.38
X$269 VDD VDD \$51 VDD sky130_fd_pr__pfet_01v8 l=0.6 w=1.4 as=0.406 ad=0.406
+ ps=3.38 pd=3.38
X$270 VDD VDD \$51 VDD sky130_fd_pr__pfet_01v8 l=0.6 w=1.4 as=0.406 ad=0.406
+ ps=3.38 pd=3.38
X$271 VDD VDD VDD VDD sky130_fd_pr__pfet_01v8 l=0.6 w=1.4 as=0.406 ad=0.406
+ ps=3.38 pd=3.38
X$272 VDD VDD VDD VDD sky130_fd_pr__pfet_01v8 l=0.6 w=1.4 as=0.406 ad=0.406
+ ps=3.38 pd=3.38
X$273 \$50 \$50 \$50 VDD sky130_fd_pr__pfet_01v8 l=0.6 w=1.4 as=0.406 ad=0.406
+ ps=3.38 pd=3.38
X$274 \$50 \$50 \$50 VDD sky130_fd_pr__pfet_01v8 l=0.6 w=1.4 as=0.406 ad=0.406
+ ps=3.38 pd=3.38
X$275 VDD VDD VDD VDD sky130_fd_pr__pfet_01v8 l=0.6 w=1.4 as=0.406 ad=0.406
+ ps=3.38 pd=3.38
X$276 \$51 \$51 \$51 VDD sky130_fd_pr__pfet_01v8 l=0.6 w=1.4 as=0.406 ad=0.406
+ ps=3.38 pd=3.38
X$277 VSS VSS VSS sky130_gnd sky130_fd_pr__nfet_01v8 l=0.6 w=1.4 as=0.406
+ ad=0.406 ps=3.38 pd=3.38
X$278 VSS VSS VSS sky130_gnd sky130_fd_pr__nfet_01v8 l=0.6 w=1.4 as=0.406
+ ad=0.406 ps=3.38 pd=3.38
X$279 VSS VSS VSS sky130_gnd sky130_fd_pr__nfet_01v8 l=0.6 w=1.4 as=0.406
+ ad=0.406 ps=3.38 pd=3.38
X$280 VSS VSS VSS sky130_gnd sky130_fd_pr__nfet_01v8 l=0.6 w=1.4 as=0.406
+ ad=0.406 ps=3.38 pd=3.38
X$281 VSS VSS VSS sky130_gnd sky130_fd_pr__nfet_01v8 l=0.6 w=1.4 as=0.406
+ ad=0.406 ps=3.38 pd=3.38
X$282 VSS VSS VSS sky130_gnd sky130_fd_pr__nfet_01v8 l=0.6 w=1.4 as=0.406
+ ad=0.406 ps=3.38 pd=3.38
X$283 VSS VSS VSS sky130_gnd sky130_fd_pr__nfet_01v8 l=0.6 w=1.4 as=0.406
+ ad=0.406 ps=3.38 pd=3.38
X$284 VSS VSS VSS sky130_gnd sky130_fd_pr__nfet_01v8 l=0.6 w=1.4 as=0.406
+ ad=0.406 ps=3.38 pd=3.38
X$285 VSS VSS VSS sky130_gnd sky130_fd_pr__nfet_01v8 l=0.6 w=1.4 as=0.406
+ ad=0.406 ps=3.38 pd=3.38
X$286 VSS VSS VSS sky130_gnd sky130_fd_pr__nfet_01v8 l=0.6 w=1.4 as=0.406
+ ad=0.406 ps=3.38 pd=3.38
X$287 VSS VSS VSS sky130_gnd sky130_fd_pr__nfet_01v8 l=0.6 w=1.4 as=0.406
+ ad=0.406 ps=3.38 pd=3.38
X$288 VSS VSS VSS sky130_gnd sky130_fd_pr__nfet_01v8 l=0.6 w=1.4 as=0.406
+ ad=0.406 ps=3.38 pd=3.38
X$289 VSS VSS VSS sky130_gnd sky130_fd_pr__nfet_01v8 l=0.6 w=1.4 as=0.406
+ ad=0.406 ps=3.38 pd=3.38
X$290 VSS VSS VSS sky130_gnd sky130_fd_pr__nfet_01v8 l=0.6 w=1.4 as=0.406
+ ad=0.406 ps=3.38 pd=3.38
X$291 VSS VSS VSS sky130_gnd sky130_fd_pr__nfet_01v8 l=0.6 w=1.4 as=0.406
+ ad=0.406 ps=3.38 pd=3.38
X$292 VSS VSS VSS sky130_gnd sky130_fd_pr__nfet_01v8 l=0.6 w=1.4 as=0.406
+ ad=0.406 ps=3.38 pd=3.38
X$293 VSS VSS VSS sky130_gnd sky130_fd_pr__nfet_01v8 l=0.6 w=1.4 as=0.406
+ ad=0.406 ps=3.38 pd=3.38
X$294 VSS VSS VSS sky130_gnd sky130_fd_pr__nfet_01v8 l=0.6 w=1.4 as=0.406
+ ad=0.406 ps=3.38 pd=3.38
X$295 VSS VSS VSS sky130_gnd sky130_fd_pr__nfet_01v8 l=0.6 w=1.4 as=0.406
+ ad=0.406 ps=3.38 pd=3.38
X$296 VSS VSS VSS sky130_gnd sky130_fd_pr__nfet_01v8 l=0.6 w=1.4 as=0.406
+ ad=0.406 ps=3.38 pd=3.38
X$297 VSS VSS VSS sky130_gnd sky130_fd_pr__nfet_01v8 l=0.6 w=1.4 as=0.406
+ ad=0.406 ps=3.38 pd=3.38
X$298 VSS VSS VSS sky130_gnd sky130_fd_pr__nfet_01v8 l=0.6 w=1.4 as=0.406
+ ad=0.406 ps=3.38 pd=3.38
X$299 VSS VSS VSS sky130_gnd sky130_fd_pr__nfet_01v8 l=0.6 w=1.4 as=0.406
+ ad=0.406 ps=3.38 pd=3.38
X$300 VSS VSS VSS sky130_gnd sky130_fd_pr__nfet_01v8 l=0.6 w=1.4 as=0.406
+ ad=0.406 ps=3.38 pd=3.38
X$301 VSS VSS VSS sky130_gnd sky130_fd_pr__nfet_01v8 l=0.6 w=1.4 as=0.406
+ ad=0.406 ps=3.38 pd=3.38
X$302 bias_a bias_a bias_a sky130_gnd sky130_fd_pr__nfet_01v8 l=0.6 w=1.4
+ as=0.406 ad=0.406 ps=3.38 pd=3.38
X$303 bias_a bias_a bias_a sky130_gnd sky130_fd_pr__nfet_01v8 l=0.6 w=1.4
+ as=0.406 ad=0.406 ps=3.38 pd=3.38
X$304 bias_a bias_a bias_a sky130_gnd sky130_fd_pr__nfet_01v8 l=0.6 w=1.4
+ as=0.406 ad=0.406 ps=3.38 pd=3.38
X$305 bias_a bias_a bias_a sky130_gnd sky130_fd_pr__nfet_01v8 l=0.6 w=1.4
+ as=0.406 ad=0.406 ps=3.38 pd=3.38
X$306 \$121 \$121 \$121 sky130_gnd sky130_fd_pr__nfet_01v8 l=0.6 w=1.4 as=0.406
+ ad=0.406 ps=3.38 pd=3.38
X$307 \$121 \$121 \$121 sky130_gnd sky130_fd_pr__nfet_01v8 l=0.6 w=1.4 as=0.406
+ ad=0.406 ps=3.38 pd=3.38
X$308 \$121 \$121 \$121 sky130_gnd sky130_fd_pr__nfet_01v8 l=0.6 w=1.4 as=0.406
+ ad=0.406 ps=3.38 pd=3.38
X$309 \$121 \$121 \$121 sky130_gnd sky130_fd_pr__nfet_01v8 l=0.6 w=1.4 as=0.406
+ ad=0.406 ps=3.38 pd=3.38
X$310 \$121 \$121 \$121 sky130_gnd sky130_fd_pr__nfet_01v8 l=0.6 w=1.4 as=0.406
+ ad=0.406 ps=3.38 pd=3.38
X$311 \$121 \$121 \$121 sky130_gnd sky130_fd_pr__nfet_01v8 l=0.6 w=1.4 as=0.406
+ ad=0.406 ps=3.38 pd=3.38
X$312 VSS VSS \$121 sky130_gnd sky130_fd_pr__nfet_01v8 l=0.6 w=1.4 as=0.406
+ ad=0.406 ps=3.38 pd=3.38
X$313 VSS VSS \$121 sky130_gnd sky130_fd_pr__nfet_01v8 l=0.6 w=1.4 as=0.406
+ ad=0.406 ps=3.38 pd=3.38
X$314 VSS VSS \$121 sky130_gnd sky130_fd_pr__nfet_01v8 l=0.6 w=1.4 as=0.406
+ ad=0.406 ps=3.38 pd=3.38
X$315 VSS VSS \$121 sky130_gnd sky130_fd_pr__nfet_01v8 l=0.6 w=1.4 as=0.406
+ ad=0.406 ps=3.38 pd=3.38
X$316 VSS VSS \$121 sky130_gnd sky130_fd_pr__nfet_01v8 l=0.6 w=1.4 as=0.406
+ ad=0.406 ps=3.38 pd=3.38
X$317 VSS VSS \$121 sky130_gnd sky130_fd_pr__nfet_01v8 l=0.6 w=1.4 as=0.406
+ ad=0.406 ps=3.38 pd=3.38
X$318 VSS VSS \$18 sky130_gnd sky130_fd_pr__nfet_01v8 l=0.6 w=1.4 as=0.406
+ ad=0.406 ps=3.38 pd=3.38
X$319 VSS VSS \$18 sky130_gnd sky130_fd_pr__nfet_01v8 l=0.6 w=1.4 as=0.406
+ ad=0.406 ps=3.38 pd=3.38
X$320 VSS VSS \$18 sky130_gnd sky130_fd_pr__nfet_01v8 l=0.6 w=1.4 as=0.406
+ ad=0.406 ps=3.38 pd=3.38
X$321 VSS VSS \$18 sky130_gnd sky130_fd_pr__nfet_01v8 l=0.6 w=1.4 as=0.406
+ ad=0.406 ps=3.38 pd=3.38
X$322 VSS VSS \$18 sky130_gnd sky130_fd_pr__nfet_01v8 l=0.6 w=1.4 as=0.406
+ ad=0.406 ps=3.38 pd=3.38
X$323 VSS VSS \$18 sky130_gnd sky130_fd_pr__nfet_01v8 l=0.6 w=1.4 as=0.406
+ ad=0.406 ps=3.38 pd=3.38
X$324 VSS VSS VSS sky130_gnd sky130_fd_pr__nfet_01v8 l=0.6 w=1.4 as=0.406
+ ad=0.406 ps=3.38 pd=3.38
X$325 VSS VSS VSS sky130_gnd sky130_fd_pr__nfet_01v8 l=0.6 w=1.4 as=0.406
+ ad=0.406 ps=3.38 pd=3.38
X$326 \$16 \$16 \$16 sky130_gnd sky130_fd_pr__nfet_01v8 l=0.6 w=1.4 as=0.406
+ ad=0.406 ps=3.38 pd=3.38
X$327 \$16 \$16 \$16 sky130_gnd sky130_fd_pr__nfet_01v8 l=0.6 w=1.4 as=0.406
+ ad=0.406 ps=3.38 pd=3.38
X$328 \$16 \$16 \$16 sky130_gnd sky130_fd_pr__nfet_01v8 l=0.6 w=1.4 as=0.406
+ ad=0.406 ps=3.38 pd=3.38
X$329 \$16 \$16 \$16 sky130_gnd sky130_fd_pr__nfet_01v8 l=0.6 w=1.4 as=0.406
+ ad=0.406 ps=3.38 pd=3.38
X$330 \$16 \$16 \$16 sky130_gnd sky130_fd_pr__nfet_01v8 l=0.6 w=1.4 as=0.406
+ ad=0.406 ps=3.38 pd=3.38
X$331 \$16 \$16 \$16 sky130_gnd sky130_fd_pr__nfet_01v8 l=0.6 w=1.4 as=0.406
+ ad=0.406 ps=3.38 pd=3.38
X$332 cm cm cm sky130_gnd sky130_fd_pr__nfet_01v8 l=0.6 w=1.4 as=0.406 ad=0.406
+ ps=3.38 pd=3.38
X$333 cm cm cm sky130_gnd sky130_fd_pr__nfet_01v8 l=0.6 w=1.4 as=0.406 ad=0.406
+ ps=3.38 pd=3.38
X$334 cm cm cm sky130_gnd sky130_fd_pr__nfet_01v8 l=0.6 w=1.4 as=0.406 ad=0.406
+ ps=3.38 pd=3.38
X$335 cm cm cm sky130_gnd sky130_fd_pr__nfet_01v8 l=0.6 w=1.4 as=0.406 ad=0.406
+ ps=3.38 pd=3.38
X$336 cm cm cm sky130_gnd sky130_fd_pr__nfet_01v8 l=0.6 w=1.4 as=0.406 ad=0.406
+ ps=3.38 pd=3.38
X$337 cm cm cm sky130_gnd sky130_fd_pr__nfet_01v8 l=0.6 w=1.4 as=0.406 ad=0.406
+ ps=3.38 pd=3.38
X$338 cm cm cm sky130_gnd sky130_fd_pr__nfet_01v8 l=0.6 w=1.4 as=0.406 ad=0.406
+ ps=3.38 pd=3.38
X$339 cm cm cm sky130_gnd sky130_fd_pr__nfet_01v8 l=0.6 w=1.4 as=0.406 ad=0.406
+ ps=3.38 pd=3.38
X$340 \$73 \$73 \$73 sky130_gnd sky130_fd_pr__nfet_01v8 l=0.6 w=1.4 as=0.406
+ ad=0.406 ps=3.38 pd=3.38
X$341 \$73 \$73 \$73 sky130_gnd sky130_fd_pr__nfet_01v8 l=0.6 w=1.4 as=0.406
+ ad=0.406 ps=3.38 pd=3.38
X$342 \$73 \$73 \$73 sky130_gnd sky130_fd_pr__nfet_01v8 l=0.6 w=1.4 as=0.406
+ ad=0.406 ps=3.38 pd=3.38
X$343 \$73 \$73 \$73 sky130_gnd sky130_fd_pr__nfet_01v8 l=0.6 w=1.4 as=0.406
+ ad=0.406 ps=3.38 pd=3.38
X$344 \$73 \$73 \$73 sky130_gnd sky130_fd_pr__nfet_01v8 l=0.6 w=1.4 as=0.406
+ ad=0.406 ps=3.38 pd=3.38
X$345 \$73 \$73 \$73 sky130_gnd sky130_fd_pr__nfet_01v8 l=0.6 w=1.4 as=0.406
+ ad=0.406 ps=3.38 pd=3.38
X$346 \$73 \$73 \$73 sky130_gnd sky130_fd_pr__nfet_01v8 l=0.6 w=1.4 as=0.406
+ ad=0.406 ps=3.38 pd=3.38
X$347 \$73 \$73 \$73 sky130_gnd sky130_fd_pr__nfet_01v8 l=0.6 w=1.4 as=0.406
+ ad=0.406 ps=3.38 pd=3.38
X$348 VSS VSS \$17 sky130_gnd sky130_fd_pr__nfet_01v8 l=0.6 w=1.4 as=0.406
+ ad=0.406 ps=3.38 pd=3.38
X$349 VSS VSS \$17 sky130_gnd sky130_fd_pr__nfet_01v8 l=0.6 w=1.4 as=0.406
+ ad=0.406 ps=3.38 pd=3.38
X$350 VSS VSS \$17 sky130_gnd sky130_fd_pr__nfet_01v8 l=0.6 w=1.4 as=0.406
+ ad=0.406 ps=3.38 pd=3.38
X$351 VSS VSS \$17 sky130_gnd sky130_fd_pr__nfet_01v8 l=0.6 w=1.4 as=0.406
+ ad=0.406 ps=3.38 pd=3.38
X$352 VSS VSS \$17 sky130_gnd sky130_fd_pr__nfet_01v8 l=0.6 w=1.4 as=0.406
+ ad=0.406 ps=3.38 pd=3.38
X$353 VSS VSS \$17 sky130_gnd sky130_fd_pr__nfet_01v8 l=0.6 w=1.4 as=0.406
+ ad=0.406 ps=3.38 pd=3.38
X$354 VSS VSS \$17 sky130_gnd sky130_fd_pr__nfet_01v8 l=0.6 w=1.4 as=0.406
+ ad=0.406 ps=3.38 pd=3.38
X$355 VSS VSS \$17 sky130_gnd sky130_fd_pr__nfet_01v8 l=0.6 w=1.4 as=0.406
+ ad=0.406 ps=3.38 pd=3.38
X$356 \$121 \$73 bias_a sky130_gnd sky130_fd_pr__nfet_01v8 l=0.6 w=1.4 as=0.406
+ ad=0.406 ps=3.38 pd=3.38
X$357 \$121 \$73 bias_a sky130_gnd sky130_fd_pr__nfet_01v8 l=0.6 w=1.4 as=0.406
+ ad=0.406 ps=3.38 pd=3.38
X$358 \$121 \$73 bias_a sky130_gnd sky130_fd_pr__nfet_01v8 l=0.6 w=1.4 as=0.406
+ ad=0.406 ps=3.38 pd=3.38
X$359 \$121 \$73 bias_a sky130_gnd sky130_fd_pr__nfet_01v8 l=0.6 w=1.4 as=0.406
+ ad=0.406 ps=3.38 pd=3.38
X$360 \$121 \$73 bias_a sky130_gnd sky130_fd_pr__nfet_01v8 l=0.6 w=1.4 as=0.406
+ ad=0.406 ps=3.38 pd=3.38
X$361 \$121 \$73 bias_a sky130_gnd sky130_fd_pr__nfet_01v8 l=0.6 w=1.4 as=0.406
+ ad=0.406 ps=3.38 pd=3.38
X$362 \$121 \$73 bias_a sky130_gnd sky130_fd_pr__nfet_01v8 l=0.6 w=1.4 as=0.406
+ ad=0.406 ps=3.38 pd=3.38
X$363 \$121 \$73 bias_a sky130_gnd sky130_fd_pr__nfet_01v8 l=0.6 w=1.4 as=0.406
+ ad=0.406 ps=3.38 pd=3.38
X$364 \$121 \$73 bias_a sky130_gnd sky130_fd_pr__nfet_01v8 l=0.6 w=1.4 as=0.406
+ ad=0.406 ps=3.38 pd=3.38
X$365 \$121 \$73 bias_a sky130_gnd sky130_fd_pr__nfet_01v8 l=0.6 w=1.4 as=0.406
+ ad=0.406 ps=3.38 pd=3.38
X$366 \$121 \$73 bias_a sky130_gnd sky130_fd_pr__nfet_01v8 l=0.6 w=1.4 as=0.406
+ ad=0.406 ps=3.38 pd=3.38
X$367 \$121 \$73 bias_a sky130_gnd sky130_fd_pr__nfet_01v8 l=0.6 w=1.4 as=0.406
+ ad=0.406 ps=3.38 pd=3.38
X$368 \$121 \$73 bias_a sky130_gnd sky130_fd_pr__nfet_01v8 l=0.6 w=1.4 as=0.406
+ ad=0.406 ps=3.38 pd=3.38
X$369 \$121 \$73 bias_a sky130_gnd sky130_fd_pr__nfet_01v8 l=0.6 w=1.4 as=0.406
+ ad=0.406 ps=3.38 pd=3.38
X$370 \$121 \$73 bias_a sky130_gnd sky130_fd_pr__nfet_01v8 l=0.6 w=1.4 as=0.406
+ ad=0.406 ps=3.38 pd=3.38
X$371 \$121 \$73 bias_a sky130_gnd sky130_fd_pr__nfet_01v8 l=0.6 w=1.4 as=0.406
+ ad=0.406 ps=3.38 pd=3.38
X$372 \$121 \$73 bias_a sky130_gnd sky130_fd_pr__nfet_01v8 l=0.6 w=1.4 as=0.406
+ ad=0.406 ps=3.38 pd=3.38
X$373 \$121 \$73 bias_a sky130_gnd sky130_fd_pr__nfet_01v8 l=0.6 w=1.4 as=0.406
+ ad=0.406 ps=3.38 pd=3.38
X$374 VSS IBIAS \$177 sky130_gnd sky130_fd_pr__nfet_01v8 l=0.6 w=1.4 as=0.406
+ ad=0.406 ps=3.38 pd=3.38
X$375 VSS IBIAS \$177 sky130_gnd sky130_fd_pr__nfet_01v8 l=0.6 w=1.4 as=0.406
+ ad=0.406 ps=3.38 pd=3.38
X$376 VSS IBIAS IBIAS sky130_gnd sky130_fd_pr__nfet_01v8 l=0.6 w=1.4 as=0.406
+ ad=0.406 ps=3.38 pd=3.38
X$377 VSS IBIAS \$177 sky130_gnd sky130_fd_pr__nfet_01v8 l=0.6 w=1.4 as=0.406
+ ad=0.406 ps=3.38 pd=3.38
X$378 VSS IBIAS IBIAS sky130_gnd sky130_fd_pr__nfet_01v8 l=0.6 w=1.4 as=0.406
+ ad=0.406 ps=3.38 pd=3.38
X$379 VSS IBIAS \$177 sky130_gnd sky130_fd_pr__nfet_01v8 l=0.6 w=1.4 as=0.406
+ ad=0.406 ps=3.38 pd=3.38
X$380 VSS IBIAS IBIAS sky130_gnd sky130_fd_pr__nfet_01v8 l=0.6 w=1.4 as=0.406
+ ad=0.406 ps=3.38 pd=3.38
X$381 VSS IBIAS IBIAS sky130_gnd sky130_fd_pr__nfet_01v8 l=0.6 w=1.4 as=0.406
+ ad=0.406 ps=3.38 pd=3.38
X$382 VSS IBIAS IBIAS sky130_gnd sky130_fd_pr__nfet_01v8 l=0.6 w=1.4 as=0.406
+ ad=0.406 ps=3.38 pd=3.38
X$383 VSS IBIAS IBIAS sky130_gnd sky130_fd_pr__nfet_01v8 l=0.6 w=1.4 as=0.406
+ ad=0.406 ps=3.38 pd=3.38
X$384 VSS IBIAS \$177 sky130_gnd sky130_fd_pr__nfet_01v8 l=0.6 w=1.4 as=0.406
+ ad=0.406 ps=3.38 pd=3.38
X$385 VSS IBIAS \$177 sky130_gnd sky130_fd_pr__nfet_01v8 l=0.6 w=1.4 as=0.406
+ ad=0.406 ps=3.38 pd=3.38
X$386 VSS IBIAS IBIAS sky130_gnd sky130_fd_pr__nfet_01v8 l=0.6 w=1.4 as=0.406
+ ad=0.406 ps=3.38 pd=3.38
X$387 VSS IBIAS \$177 sky130_gnd sky130_fd_pr__nfet_01v8 l=0.6 w=1.4 as=0.406
+ ad=0.406 ps=3.38 pd=3.38
X$388 VSS IBIAS IBIAS sky130_gnd sky130_fd_pr__nfet_01v8 l=0.6 w=1.4 as=0.406
+ ad=0.406 ps=3.38 pd=3.38
X$389 VSS IBIAS \$177 sky130_gnd sky130_fd_pr__nfet_01v8 l=0.6 w=1.4 as=0.406
+ ad=0.406 ps=3.38 pd=3.38
X$390 VSS IBIAS IBIAS sky130_gnd sky130_fd_pr__nfet_01v8 l=0.6 w=1.4 as=0.406
+ ad=0.406 ps=3.38 pd=3.38
X$391 VSS IBIAS \$177 sky130_gnd sky130_fd_pr__nfet_01v8 l=0.6 w=1.4 as=0.406
+ ad=0.406 ps=3.38 pd=3.38
X$392 VSS IBIAS \$177 sky130_gnd sky130_fd_pr__nfet_01v8 l=0.6 w=1.4 as=0.406
+ ad=0.406 ps=3.38 pd=3.38
X$393 VSS IBIAS IBIAS sky130_gnd sky130_fd_pr__nfet_01v8 l=0.6 w=1.4 as=0.406
+ ad=0.406 ps=3.38 pd=3.38
X$394 VSS IBIAS \$177 sky130_gnd sky130_fd_pr__nfet_01v8 l=0.6 w=1.4 as=0.406
+ ad=0.406 ps=3.38 pd=3.38
X$395 VSS IBIAS IBIAS sky130_gnd sky130_fd_pr__nfet_01v8 l=0.6 w=1.4 as=0.406
+ ad=0.406 ps=3.38 pd=3.38
X$396 VSS IBIAS \$177 sky130_gnd sky130_fd_pr__nfet_01v8 l=0.6 w=1.4 as=0.406
+ ad=0.406 ps=3.38 pd=3.38
X$397 VSS IBIAS IBIAS sky130_gnd sky130_fd_pr__nfet_01v8 l=0.6 w=1.4 as=0.406
+ ad=0.406 ps=3.38 pd=3.38
X$398 VSS IBIAS \$177 sky130_gnd sky130_fd_pr__nfet_01v8 l=0.6 w=1.4 as=0.406
+ ad=0.406 ps=3.38 pd=3.38
X$399 VSS IBIAS IBIAS sky130_gnd sky130_fd_pr__nfet_01v8 l=0.6 w=1.4 as=0.406
+ ad=0.406 ps=3.38 pd=3.38
X$400 VSS IBIAS IBIAS sky130_gnd sky130_fd_pr__nfet_01v8 l=0.6 w=1.4 as=0.406
+ ad=0.406 ps=3.38 pd=3.38
X$401 VSS IBIAS \$177 sky130_gnd sky130_fd_pr__nfet_01v8 l=0.6 w=1.4 as=0.406
+ ad=0.406 ps=3.38 pd=3.38
X$402 VSS IBIAS IBIAS sky130_gnd sky130_fd_pr__nfet_01v8 l=0.6 w=1.4 as=0.406
+ ad=0.406 ps=3.38 pd=3.38
X$403 VSS IBIAS \$177 sky130_gnd sky130_fd_pr__nfet_01v8 l=0.6 w=1.4 as=0.406
+ ad=0.406 ps=3.38 pd=3.38
X$404 VSS IBIAS IBIAS sky130_gnd sky130_fd_pr__nfet_01v8 l=0.6 w=1.4 as=0.406
+ ad=0.406 ps=3.38 pd=3.38
X$405 VSS IBIAS \$177 sky130_gnd sky130_fd_pr__nfet_01v8 l=0.6 w=1.4 as=0.406
+ ad=0.406 ps=3.38 pd=3.38
X$406 VSS IBIAS IBIAS sky130_gnd sky130_fd_pr__nfet_01v8 l=0.6 w=1.4 as=0.406
+ ad=0.406 ps=3.38 pd=3.38
X$407 VSS IBIAS \$177 sky130_gnd sky130_fd_pr__nfet_01v8 l=0.6 w=1.4 as=0.406
+ ad=0.406 ps=3.38 pd=3.38
X$408 VSS IBIAS IBIAS sky130_gnd sky130_fd_pr__nfet_01v8 l=0.6 w=1.4 as=0.406
+ ad=0.406 ps=3.38 pd=3.38
X$409 VSS IBIAS \$177 sky130_gnd sky130_fd_pr__nfet_01v8 l=0.6 w=1.4 as=0.406
+ ad=0.406 ps=3.38 pd=3.38
X$410 VSS bias_a \$121 sky130_gnd sky130_fd_pr__nfet_01v8 l=0.6 w=1.4 as=0.406
+ ad=0.406 ps=3.38 pd=3.38
X$411 VSS bias_a \$121 sky130_gnd sky130_fd_pr__nfet_01v8 l=0.6 w=1.4 as=0.406
+ ad=0.406 ps=3.38 pd=3.38
X$412 VSS bias_a \$121 sky130_gnd sky130_fd_pr__nfet_01v8 l=0.6 w=1.4 as=0.406
+ ad=0.406 ps=3.38 pd=3.38
X$413 VSS bias_a \$121 sky130_gnd sky130_fd_pr__nfet_01v8 l=0.6 w=1.4 as=0.406
+ ad=0.406 ps=3.38 pd=3.38
X$414 VSS bias_a \$121 sky130_gnd sky130_fd_pr__nfet_01v8 l=0.6 w=1.4 as=0.406
+ ad=0.406 ps=3.38 pd=3.38
X$415 VSS bias_a \$121 sky130_gnd sky130_fd_pr__nfet_01v8 l=0.6 w=1.4 as=0.406
+ ad=0.406 ps=3.38 pd=3.38
X$416 VSS bias_a \$121 sky130_gnd sky130_fd_pr__nfet_01v8 l=0.6 w=1.4 as=0.406
+ ad=0.406 ps=3.38 pd=3.38
X$417 VSS bias_a \$121 sky130_gnd sky130_fd_pr__nfet_01v8 l=0.6 w=1.4 as=0.406
+ ad=0.406 ps=3.38 pd=3.38
X$418 VSS bias_a \$121 sky130_gnd sky130_fd_pr__nfet_01v8 l=0.6 w=1.4 as=0.406
+ ad=0.406 ps=3.38 pd=3.38
X$419 VSS bias_a \$121 sky130_gnd sky130_fd_pr__nfet_01v8 l=0.6 w=1.4 as=0.406
+ ad=0.406 ps=3.38 pd=3.38
X$420 VSS bias_a \$121 sky130_gnd sky130_fd_pr__nfet_01v8 l=0.6 w=1.4 as=0.406
+ ad=0.406 ps=3.38 pd=3.38
X$421 VSS bias_a \$121 sky130_gnd sky130_fd_pr__nfet_01v8 l=0.6 w=1.4 as=0.406
+ ad=0.406 ps=3.38 pd=3.38
X$422 VSS bias_a \$121 sky130_gnd sky130_fd_pr__nfet_01v8 l=0.6 w=1.4 as=0.406
+ ad=0.406 ps=3.38 pd=3.38
X$423 VSS bias_a \$121 sky130_gnd sky130_fd_pr__nfet_01v8 l=0.6 w=1.4 as=0.406
+ ad=0.406 ps=3.38 pd=3.38
X$424 VSS bias_a \$121 sky130_gnd sky130_fd_pr__nfet_01v8 l=0.6 w=1.4 as=0.406
+ ad=0.406 ps=3.38 pd=3.38
X$425 VSS bias_a \$121 sky130_gnd sky130_fd_pr__nfet_01v8 l=0.6 w=1.4 as=0.406
+ ad=0.406 ps=3.38 pd=3.38
X$426 VSS bias_a \$121 sky130_gnd sky130_fd_pr__nfet_01v8 l=0.6 w=1.4 as=0.406
+ ad=0.406 ps=3.38 pd=3.38
X$427 VSS bias_a \$121 sky130_gnd sky130_fd_pr__nfet_01v8 l=0.6 w=1.4 as=0.406
+ ad=0.406 ps=3.38 pd=3.38
X$428 VSS cm \$10.x1_net12 sky130_gnd sky130_fd_pr__nfet_01v8 l=0.6 w=1.4
+ as=0.406 ad=0.406 ps=3.38 pd=3.38
X$429 VSS cm \$10.x1_net9 sky130_gnd sky130_fd_pr__nfet_01v8 l=0.6 w=1.4
+ as=0.406 ad=0.406 ps=3.38 pd=3.38
X$430 VSS cm \$10.x1_net6 sky130_gnd sky130_fd_pr__nfet_01v8 l=0.6 w=1.4
+ as=0.406 ad=0.406 ps=3.38 pd=3.38
X$431 VSS cm \$10.x1_net3 sky130_gnd sky130_fd_pr__nfet_01v8 l=0.6 w=1.4
+ as=0.406 ad=0.406 ps=3.38 pd=3.38
X$432 VSS cm \$10.x1_net15 sky130_gnd sky130_fd_pr__nfet_01v8 l=0.6 w=1.4
+ as=0.406 ad=0.406 ps=3.38 pd=3.38
X$433 \$10.x1_net2 cm \$10.x1_net1 sky130_gnd sky130_fd_pr__nfet_01v8 l=0.6
+ w=1.4 as=0.406 ad=0.406 ps=3.38 pd=3.38
X$434 \$10.x1_net3 cm \$10.x1_net2 sky130_gnd sky130_fd_pr__nfet_01v8 l=0.6
+ w=1.4 as=0.406 ad=0.406 ps=3.38 pd=3.38
X$435 \$10.x1_net14 cm \$10.x1_net13 sky130_gnd sky130_fd_pr__nfet_01v8 l=0.6
+ w=1.4 as=0.406 ad=0.406 ps=3.38 pd=3.38
X$436 \$10.x1_net15 cm \$10.x1_net14 sky130_gnd sky130_fd_pr__nfet_01v8 l=0.6
+ w=1.4 as=0.406 ad=0.406 ps=3.38 pd=3.38
X$437 \$10.x1_net5 cm \$10.x1_net4 sky130_gnd sky130_fd_pr__nfet_01v8 l=0.6
+ w=1.4 as=0.406 ad=0.406 ps=3.38 pd=3.38
X$438 \$10.x1_net6 cm \$10.x1_net5 sky130_gnd sky130_fd_pr__nfet_01v8 l=0.6
+ w=1.4 as=0.406 ad=0.406 ps=3.38 pd=3.38
X$439 \$10.x1_net8 cm \$10.x1_net7 sky130_gnd sky130_fd_pr__nfet_01v8 l=0.6
+ w=1.4 as=0.406 ad=0.406 ps=3.38 pd=3.38
X$440 \$10.x1_net9 cm \$10.x1_net8 sky130_gnd sky130_fd_pr__nfet_01v8 l=0.6
+ w=1.4 as=0.406 ad=0.406 ps=3.38 pd=3.38
X$441 \$10.x1_net11 cm \$10.x1_net10 sky130_gnd sky130_fd_pr__nfet_01v8 l=0.6
+ w=1.4 as=0.406 ad=0.406 ps=3.38 pd=3.38
X$442 \$10.x1_net12 cm \$10.x1_net11 sky130_gnd sky130_fd_pr__nfet_01v8 l=0.6
+ w=1.4 as=0.406 ad=0.406 ps=3.38 pd=3.38
X$443 \$10.x1_net1 cm cm sky130_gnd sky130_fd_pr__nfet_01v8 l=0.6 w=1.4
+ as=0.406 ad=0.406 ps=3.38 pd=3.38
X$444 \$10.x1_net13 cm cm sky130_gnd sky130_fd_pr__nfet_01v8 l=0.6 w=1.4
+ as=0.406 ad=0.406 ps=3.38 pd=3.38
X$445 \$10.x1_net4 cm cm sky130_gnd sky130_fd_pr__nfet_01v8 l=0.6 w=1.4
+ as=0.406 ad=0.406 ps=3.38 pd=3.38
X$446 \$10.x1_net7 cm cm sky130_gnd sky130_fd_pr__nfet_01v8 l=0.6 w=1.4
+ as=0.406 ad=0.406 ps=3.38 pd=3.38
X$447 \$10.x1_net10 cm cm sky130_gnd sky130_fd_pr__nfet_01v8 l=0.6 w=1.4
+ as=0.406 ad=0.406 ps=3.38 pd=3.38
X$448 \$73 \$162 \$162 sky130_gnd sky130_fd_pr__nfet_01v8 l=0.6 w=1.4 as=0.406
+ ad=0.406 ps=3.38 pd=3.38
X$449 \$73 \$162 \$162 sky130_gnd sky130_fd_pr__nfet_01v8 l=0.6 w=1.4 as=0.406
+ ad=0.406 ps=3.38 pd=3.38
X$450 \$73 \$162 \$162 sky130_gnd sky130_fd_pr__nfet_01v8 l=0.6 w=1.4 as=0.406
+ ad=0.406 ps=3.38 pd=3.38
X$451 \$73 \$162 \$162 sky130_gnd sky130_fd_pr__nfet_01v8 l=0.6 w=1.4 as=0.406
+ ad=0.406 ps=3.38 pd=3.38
X$452 \$73 \$162 \$162 sky130_gnd sky130_fd_pr__nfet_01v8 l=0.6 w=1.4 as=0.406
+ ad=0.406 ps=3.38 pd=3.38
X$453 \$73 \$162 \$162 sky130_gnd sky130_fd_pr__nfet_01v8 l=0.6 w=1.4 as=0.406
+ ad=0.406 ps=3.38 pd=3.38
X$454 \$73 \$162 \$162 sky130_gnd sky130_fd_pr__nfet_01v8 l=0.6 w=1.4 as=0.406
+ ad=0.406 ps=3.38 pd=3.38
X$455 \$73 \$162 \$162 sky130_gnd sky130_fd_pr__nfet_01v8 l=0.6 w=1.4 as=0.406
+ ad=0.406 ps=3.38 pd=3.38
X$456 \$73 \$162 \$162 sky130_gnd sky130_fd_pr__nfet_01v8 l=0.6 w=1.4 as=0.406
+ ad=0.406 ps=3.38 pd=3.38
X$457 \$73 \$162 \$162 sky130_gnd sky130_fd_pr__nfet_01v8 l=0.6 w=1.4 as=0.406
+ ad=0.406 ps=3.38 pd=3.38
X$458 \$73 \$162 \$162 sky130_gnd sky130_fd_pr__nfet_01v8 l=0.6 w=1.4 as=0.406
+ ad=0.406 ps=3.38 pd=3.38
X$459 \$73 \$162 \$162 sky130_gnd sky130_fd_pr__nfet_01v8 l=0.6 w=1.4 as=0.406
+ ad=0.406 ps=3.38 pd=3.38
X$460 \$73 \$162 \$162 sky130_gnd sky130_fd_pr__nfet_01v8 l=0.6 w=1.4 as=0.406
+ ad=0.406 ps=3.38 pd=3.38
X$461 \$73 \$162 \$162 sky130_gnd sky130_fd_pr__nfet_01v8 l=0.6 w=1.4 as=0.406
+ ad=0.406 ps=3.38 pd=3.38
X$462 \$73 \$162 \$162 sky130_gnd sky130_fd_pr__nfet_01v8 l=0.6 w=1.4 as=0.406
+ ad=0.406 ps=3.38 pd=3.38
X$463 \$73 \$162 \$162 sky130_gnd sky130_fd_pr__nfet_01v8 l=0.6 w=1.4 as=0.406
+ ad=0.406 ps=3.38 pd=3.38
X$464 \$73 \$162 \$162 sky130_gnd sky130_fd_pr__nfet_01v8 l=0.6 w=1.4 as=0.406
+ ad=0.406 ps=3.38 pd=3.38
X$465 \$73 \$162 \$162 sky130_gnd sky130_fd_pr__nfet_01v8 l=0.6 w=1.4 as=0.406
+ ad=0.406 ps=3.38 pd=3.38
X$466 \$73 \$162 \$162 sky130_gnd sky130_fd_pr__nfet_01v8 l=0.6 w=1.4 as=0.406
+ ad=0.406 ps=3.38 pd=3.38
X$467 \$73 \$162 \$162 sky130_gnd sky130_fd_pr__nfet_01v8 l=0.6 w=1.4 as=0.406
+ ad=0.406 ps=3.38 pd=3.38
X$468 \$73 \$162 \$162 sky130_gnd sky130_fd_pr__nfet_01v8 l=0.6 w=1.4 as=0.406
+ ad=0.406 ps=3.38 pd=3.38
X$469 \$73 \$162 \$162 sky130_gnd sky130_fd_pr__nfet_01v8 l=0.6 w=1.4 as=0.406
+ ad=0.406 ps=3.38 pd=3.38
X$470 \$73 \$162 \$162 sky130_gnd sky130_fd_pr__nfet_01v8 l=0.6 w=1.4 as=0.406
+ ad=0.406 ps=3.38 pd=3.38
X$471 \$73 \$162 \$162 sky130_gnd sky130_fd_pr__nfet_01v8 l=0.6 w=1.4 as=0.406
+ ad=0.406 ps=3.38 pd=3.38
X$472 \$73 \$162 \$162 sky130_gnd sky130_fd_pr__nfet_01v8 l=0.6 w=1.4 as=0.406
+ ad=0.406 ps=3.38 pd=3.38
X$473 \$73 \$162 \$162 sky130_gnd sky130_fd_pr__nfet_01v8 l=0.6 w=1.4 as=0.406
+ ad=0.406 ps=3.38 pd=3.38
X$474 \$73 \$162 \$162 sky130_gnd sky130_fd_pr__nfet_01v8 l=0.6 w=1.4 as=0.406
+ ad=0.406 ps=3.38 pd=3.38
X$475 \$73 \$162 \$162 sky130_gnd sky130_fd_pr__nfet_01v8 l=0.6 w=1.4 as=0.406
+ ad=0.406 ps=3.38 pd=3.38
X$476 \$73 \$162 \$162 sky130_gnd sky130_fd_pr__nfet_01v8 l=0.6 w=1.4 as=0.406
+ ad=0.406 ps=3.38 pd=3.38
X$477 \$73 \$162 \$162 sky130_gnd sky130_fd_pr__nfet_01v8 l=0.6 w=1.4 as=0.406
+ ad=0.406 ps=3.38 pd=3.38
X$478 \$73 \$162 \$162 sky130_gnd sky130_fd_pr__nfet_01v8 l=0.6 w=1.4 as=0.406
+ ad=0.406 ps=3.38 pd=3.38
X$479 \$73 \$162 \$162 sky130_gnd sky130_fd_pr__nfet_01v8 l=0.6 w=1.4 as=0.406
+ ad=0.406 ps=3.38 pd=3.38
X$480 \$73 \$162 \$162 sky130_gnd sky130_fd_pr__nfet_01v8 l=0.6 w=1.4 as=0.406
+ ad=0.406 ps=3.38 pd=3.38
X$481 \$73 \$162 \$162 sky130_gnd sky130_fd_pr__nfet_01v8 l=0.6 w=1.4 as=0.406
+ ad=0.406 ps=3.38 pd=3.38
X$482 \$73 \$162 \$162 sky130_gnd sky130_fd_pr__nfet_01v8 l=0.6 w=1.4 as=0.406
+ ad=0.406 ps=3.38 pd=3.38
X$483 \$73 \$162 \$162 sky130_gnd sky130_fd_pr__nfet_01v8 l=0.6 w=1.4 as=0.406
+ ad=0.406 ps=3.38 pd=3.38
X$484 \$73 \$162 \$162 sky130_gnd sky130_fd_pr__nfet_01v8 l=0.6 w=1.4 as=0.406
+ ad=0.406 ps=3.38 pd=3.38
X$485 \$73 \$162 \$162 sky130_gnd sky130_fd_pr__nfet_01v8 l=0.6 w=1.4 as=0.406
+ ad=0.406 ps=3.38 pd=3.38
X$486 \$73 \$162 \$162 sky130_gnd sky130_fd_pr__nfet_01v8 l=0.6 w=1.4 as=0.406
+ ad=0.406 ps=3.38 pd=3.38
X$487 \$73 \$162 \$162 sky130_gnd sky130_fd_pr__nfet_01v8 l=0.6 w=1.4 as=0.406
+ ad=0.406 ps=3.38 pd=3.38
X$488 \$73 \$162 \$162 sky130_gnd sky130_fd_pr__nfet_01v8 l=0.6 w=1.4 as=0.406
+ ad=0.406 ps=3.38 pd=3.38
X$489 \$73 \$162 \$162 sky130_gnd sky130_fd_pr__nfet_01v8 l=0.6 w=1.4 as=0.406
+ ad=0.406 ps=3.38 pd=3.38
X$490 \$73 \$162 \$162 sky130_gnd sky130_fd_pr__nfet_01v8 l=0.6 w=1.4 as=0.406
+ ad=0.406 ps=3.38 pd=3.38
X$491 \$73 \$162 \$162 sky130_gnd sky130_fd_pr__nfet_01v8 l=0.6 w=1.4 as=0.406
+ ad=0.406 ps=3.38 pd=3.38
X$492 \$73 \$162 \$162 sky130_gnd sky130_fd_pr__nfet_01v8 l=0.6 w=1.4 as=0.406
+ ad=0.406 ps=3.38 pd=3.38
X$493 \$73 \$162 \$162 sky130_gnd sky130_fd_pr__nfet_01v8 l=0.6 w=1.4 as=0.406
+ ad=0.406 ps=3.38 pd=3.38
X$494 \$73 \$162 \$162 sky130_gnd sky130_fd_pr__nfet_01v8 l=0.6 w=1.4 as=0.406
+ ad=0.406 ps=3.38 pd=3.38
X$495 \$73 \$162 \$162 sky130_gnd sky130_fd_pr__nfet_01v8 l=0.6 w=1.4 as=0.406
+ ad=0.406 ps=3.38 pd=3.38
X$496 \$73 \$162 \$162 sky130_gnd sky130_fd_pr__nfet_01v8 l=0.6 w=1.4 as=0.406
+ ad=0.406 ps=3.38 pd=3.38
X$497 \$73 \$162 \$162 sky130_gnd sky130_fd_pr__nfet_01v8 l=0.6 w=1.4 as=0.406
+ ad=0.406 ps=3.38 pd=3.38
X$498 VSS cmc \$16 sky130_gnd sky130_fd_pr__nfet_01v8 l=0.6 w=1.4 as=0.406
+ ad=0.406 ps=3.38 pd=3.38
X$499 VSS bias_a \$16 sky130_gnd sky130_fd_pr__nfet_01v8 l=0.6 w=1.4 as=0.406
+ ad=0.406 ps=3.38 pd=3.38
X$500 VSS cmc \$16 sky130_gnd sky130_fd_pr__nfet_01v8 l=0.6 w=1.4 as=0.406
+ ad=0.406 ps=3.38 pd=3.38
X$501 VSS bias_a \$16 sky130_gnd sky130_fd_pr__nfet_01v8 l=0.6 w=1.4 as=0.406
+ ad=0.406 ps=3.38 pd=3.38
X$502 VSS cmc \$16 sky130_gnd sky130_fd_pr__nfet_01v8 l=0.6 w=1.4 as=0.406
+ ad=0.406 ps=3.38 pd=3.38
X$503 VSS bias_a \$16 sky130_gnd sky130_fd_pr__nfet_01v8 l=0.6 w=1.4 as=0.406
+ ad=0.406 ps=3.38 pd=3.38
X$504 VSS cmc \$16 sky130_gnd sky130_fd_pr__nfet_01v8 l=0.6 w=1.4 as=0.406
+ ad=0.406 ps=3.38 pd=3.38
X$505 VSS bias_a \$16 sky130_gnd sky130_fd_pr__nfet_01v8 l=0.6 w=1.4 as=0.406
+ ad=0.406 ps=3.38 pd=3.38
X$506 VSS cmc \$16 sky130_gnd sky130_fd_pr__nfet_01v8 l=0.6 w=1.4 as=0.406
+ ad=0.406 ps=3.38 pd=3.38
X$507 VSS bias_a \$16 sky130_gnd sky130_fd_pr__nfet_01v8 l=0.6 w=1.4 as=0.406
+ ad=0.406 ps=3.38 pd=3.38
X$508 VSS bias_a \$16 sky130_gnd sky130_fd_pr__nfet_01v8 l=0.6 w=1.4 as=0.406
+ ad=0.406 ps=3.38 pd=3.38
X$509 VSS bias_a \$16 sky130_gnd sky130_fd_pr__nfet_01v8 l=0.6 w=1.4 as=0.406
+ ad=0.406 ps=3.38 pd=3.38
X$510 VSS cmc \$16 sky130_gnd sky130_fd_pr__nfet_01v8 l=0.6 w=1.4 as=0.406
+ ad=0.406 ps=3.38 pd=3.38
X$511 VSS bias_a \$16 sky130_gnd sky130_fd_pr__nfet_01v8 l=0.6 w=1.4 as=0.406
+ ad=0.406 ps=3.38 pd=3.38
X$512 VSS cmc \$16 sky130_gnd sky130_fd_pr__nfet_01v8 l=0.6 w=1.4 as=0.406
+ ad=0.406 ps=3.38 pd=3.38
X$513 VSS bias_a \$16 sky130_gnd sky130_fd_pr__nfet_01v8 l=0.6 w=1.4 as=0.406
+ ad=0.406 ps=3.38 pd=3.38
X$514 VSS cmc \$16 sky130_gnd sky130_fd_pr__nfet_01v8 l=0.6 w=1.4 as=0.406
+ ad=0.406 ps=3.38 pd=3.38
X$515 VSS bias_a \$16 sky130_gnd sky130_fd_pr__nfet_01v8 l=0.6 w=1.4 as=0.406
+ ad=0.406 ps=3.38 pd=3.38
X$516 VSS cmc \$16 sky130_gnd sky130_fd_pr__nfet_01v8 l=0.6 w=1.4 as=0.406
+ ad=0.406 ps=3.38 pd=3.38
X$517 VSS cmc \$16 sky130_gnd sky130_fd_pr__nfet_01v8 l=0.6 w=1.4 as=0.406
+ ad=0.406 ps=3.38 pd=3.38
X$518 VSS bias_a \$16 sky130_gnd sky130_fd_pr__nfet_01v8 l=0.6 w=1.4 as=0.406
+ ad=0.406 ps=3.38 pd=3.38
X$519 VSS cmc \$16 sky130_gnd sky130_fd_pr__nfet_01v8 l=0.6 w=1.4 as=0.406
+ ad=0.406 ps=3.38 pd=3.38
X$520 VSS bias_a \$16 sky130_gnd sky130_fd_pr__nfet_01v8 l=0.6 w=1.4 as=0.406
+ ad=0.406 ps=3.38 pd=3.38
X$521 VSS cmc \$16 sky130_gnd sky130_fd_pr__nfet_01v8 l=0.6 w=1.4 as=0.406
+ ad=0.406 ps=3.38 pd=3.38
X$522 VSS bias_a \$16 sky130_gnd sky130_fd_pr__nfet_01v8 l=0.6 w=1.4 as=0.406
+ ad=0.406 ps=3.38 pd=3.38
X$523 VSS cmc \$16 sky130_gnd sky130_fd_pr__nfet_01v8 l=0.6 w=1.4 as=0.406
+ ad=0.406 ps=3.38 pd=3.38
X$524 VSS bias_a \$16 sky130_gnd sky130_fd_pr__nfet_01v8 l=0.6 w=1.4 as=0.406
+ ad=0.406 ps=3.38 pd=3.38
X$525 VSS cmc \$16 sky130_gnd sky130_fd_pr__nfet_01v8 l=0.6 w=1.4 as=0.406
+ ad=0.406 ps=3.38 pd=3.38
X$526 VSS bias_a \$16 sky130_gnd sky130_fd_pr__nfet_01v8 l=0.6 w=1.4 as=0.406
+ ad=0.406 ps=3.38 pd=3.38
X$527 VSS cmc \$16 sky130_gnd sky130_fd_pr__nfet_01v8 l=0.6 w=1.4 as=0.406
+ ad=0.406 ps=3.38 pd=3.38
X$528 VSS cmc \$16 sky130_gnd sky130_fd_pr__nfet_01v8 l=0.6 w=1.4 as=0.406
+ ad=0.406 ps=3.38 pd=3.38
X$529 VSS bias_a \$16 sky130_gnd sky130_fd_pr__nfet_01v8 l=0.6 w=1.4 as=0.406
+ ad=0.406 ps=3.38 pd=3.38
X$530 VSS cmc \$16 sky130_gnd sky130_fd_pr__nfet_01v8 l=0.6 w=1.4 as=0.406
+ ad=0.406 ps=3.38 pd=3.38
X$531 VSS bias_a \$16 sky130_gnd sky130_fd_pr__nfet_01v8 l=0.6 w=1.4 as=0.406
+ ad=0.406 ps=3.38 pd=3.38
X$532 VSS bias_a \$16 sky130_gnd sky130_fd_pr__nfet_01v8 l=0.6 w=1.4 as=0.406
+ ad=0.406 ps=3.38 pd=3.38
X$533 VSS cmc \$16 sky130_gnd sky130_fd_pr__nfet_01v8 l=0.6 w=1.4 as=0.406
+ ad=0.406 ps=3.38 pd=3.38
X$534 VSS cmc \$16 sky130_gnd sky130_fd_pr__nfet_01v8 l=0.6 w=1.4 as=0.406
+ ad=0.406 ps=3.38 pd=3.38
X$535 VSS bias_a \$16 sky130_gnd sky130_fd_pr__nfet_01v8 l=0.6 w=1.4 as=0.406
+ ad=0.406 ps=3.38 pd=3.38
X$536 VSS cmc \$16 sky130_gnd sky130_fd_pr__nfet_01v8 l=0.6 w=1.4 as=0.406
+ ad=0.406 ps=3.38 pd=3.38
X$537 VSS bias_a \$16 sky130_gnd sky130_fd_pr__nfet_01v8 l=0.6 w=1.4 as=0.406
+ ad=0.406 ps=3.38 pd=3.38
X$538 VSS cmc \$16 sky130_gnd sky130_fd_pr__nfet_01v8 l=0.6 w=1.4 as=0.406
+ ad=0.406 ps=3.38 pd=3.38
X$539 VSS bias_a \$16 sky130_gnd sky130_fd_pr__nfet_01v8 l=0.6 w=1.4 as=0.406
+ ad=0.406 ps=3.38 pd=3.38
X$540 VSS cmc \$16 sky130_gnd sky130_fd_pr__nfet_01v8 l=0.6 w=1.4 as=0.406
+ ad=0.406 ps=3.38 pd=3.38
X$541 VSS bias_a \$16 sky130_gnd sky130_fd_pr__nfet_01v8 l=0.6 w=1.4 as=0.406
+ ad=0.406 ps=3.38 pd=3.38
X$542 VSS cmc \$16 sky130_gnd sky130_fd_pr__nfet_01v8 l=0.6 w=1.4 as=0.406
+ ad=0.406 ps=3.38 pd=3.38
X$543 VSS bias_a \$16 sky130_gnd sky130_fd_pr__nfet_01v8 l=0.6 w=1.4 as=0.406
+ ad=0.406 ps=3.38 pd=3.38
X$544 VSS cmc \$16 sky130_gnd sky130_fd_pr__nfet_01v8 l=0.6 w=1.4 as=0.406
+ ad=0.406 ps=3.38 pd=3.38
X$545 VSS bias_a \$16 sky130_gnd sky130_fd_pr__nfet_01v8 l=0.6 w=1.4 as=0.406
+ ad=0.406 ps=3.38 pd=3.38
X$546 VSS cmc \$16 sky130_gnd sky130_fd_pr__nfet_01v8 l=0.6 w=1.4 as=0.406
+ ad=0.406 ps=3.38 pd=3.38
X$547 VSS bias_a \$16 sky130_gnd sky130_fd_pr__nfet_01v8 l=0.6 w=1.4 as=0.406
+ ad=0.406 ps=3.38 pd=3.38
X$548 VSS cmc \$16 sky130_gnd sky130_fd_pr__nfet_01v8 l=0.6 w=1.4 as=0.406
+ ad=0.406 ps=3.38 pd=3.38
X$549 VSS bias_a \$16 sky130_gnd sky130_fd_pr__nfet_01v8 l=0.6 w=1.4 as=0.406
+ ad=0.406 ps=3.38 pd=3.38
X$550 VSS bias_a \$16 sky130_gnd sky130_fd_pr__nfet_01v8 l=0.6 w=1.4 as=0.406
+ ad=0.406 ps=3.38 pd=3.38
X$551 VSS cmc \$16 sky130_gnd sky130_fd_pr__nfet_01v8 l=0.6 w=1.4 as=0.406
+ ad=0.406 ps=3.38 pd=3.38
X$552 VSS cmc \$16 sky130_gnd sky130_fd_pr__nfet_01v8 l=0.6 w=1.4 as=0.406
+ ad=0.406 ps=3.38 pd=3.38
X$553 VSS cmc \$16 sky130_gnd sky130_fd_pr__nfet_01v8 l=0.6 w=1.4 as=0.406
+ ad=0.406 ps=3.38 pd=3.38
X$554 VSS bias_a \$16 sky130_gnd sky130_fd_pr__nfet_01v8 l=0.6 w=1.4 as=0.406
+ ad=0.406 ps=3.38 pd=3.38
X$555 VSS cmc \$16 sky130_gnd sky130_fd_pr__nfet_01v8 l=0.6 w=1.4 as=0.406
+ ad=0.406 ps=3.38 pd=3.38
X$556 VSS bias_a \$16 sky130_gnd sky130_fd_pr__nfet_01v8 l=0.6 w=1.4 as=0.406
+ ad=0.406 ps=3.38 pd=3.38
X$557 VSS cmc \$16 sky130_gnd sky130_fd_pr__nfet_01v8 l=0.6 w=1.4 as=0.406
+ ad=0.406 ps=3.38 pd=3.38
X$558 VSS bias_a \$16 sky130_gnd sky130_fd_pr__nfet_01v8 l=0.6 w=1.4 as=0.406
+ ad=0.406 ps=3.38 pd=3.38
X$559 VSS cmc \$16 sky130_gnd sky130_fd_pr__nfet_01v8 l=0.6 w=1.4 as=0.406
+ ad=0.406 ps=3.38 pd=3.38
X$560 VSS cmc \$16 sky130_gnd sky130_fd_pr__nfet_01v8 l=0.6 w=1.4 as=0.406
+ ad=0.406 ps=3.38 pd=3.38
X$561 VSS bias_a \$16 sky130_gnd sky130_fd_pr__nfet_01v8 l=0.6 w=1.4 as=0.406
+ ad=0.406 ps=3.38 pd=3.38
X$562 VSS bias_a \$16 sky130_gnd sky130_fd_pr__nfet_01v8 l=0.6 w=1.4 as=0.406
+ ad=0.406 ps=3.38 pd=3.38
X$563 VSS cmc \$16 sky130_gnd sky130_fd_pr__nfet_01v8 l=0.6 w=1.4 as=0.406
+ ad=0.406 ps=3.38 pd=3.38
X$564 VSS cmc \$16 sky130_gnd sky130_fd_pr__nfet_01v8 l=0.6 w=1.4 as=0.406
+ ad=0.406 ps=3.38 pd=3.38
X$565 VSS bias_a \$16 sky130_gnd sky130_fd_pr__nfet_01v8 l=0.6 w=1.4 as=0.406
+ ad=0.406 ps=3.38 pd=3.38
X$566 VSS bias_a \$16 sky130_gnd sky130_fd_pr__nfet_01v8 l=0.6 w=1.4 as=0.406
+ ad=0.406 ps=3.38 pd=3.38
X$567 VSS cmc \$16 sky130_gnd sky130_fd_pr__nfet_01v8 l=0.6 w=1.4 as=0.406
+ ad=0.406 ps=3.38 pd=3.38
X$568 VSS bias_a \$16 sky130_gnd sky130_fd_pr__nfet_01v8 l=0.6 w=1.4 as=0.406
+ ad=0.406 ps=3.38 pd=3.38
X$569 VSS bias_a \$16 sky130_gnd sky130_fd_pr__nfet_01v8 l=0.6 w=1.4 as=0.406
+ ad=0.406 ps=3.38 pd=3.38
X$570 VSS cmc \$16 sky130_gnd sky130_fd_pr__nfet_01v8 l=0.6 w=1.4 as=0.406
+ ad=0.406 ps=3.38 pd=3.38
X$571 VSS bias_a \$16 sky130_gnd sky130_fd_pr__nfet_01v8 l=0.6 w=1.4 as=0.406
+ ad=0.406 ps=3.38 pd=3.38
X$572 VSS cmc \$16 sky130_gnd sky130_fd_pr__nfet_01v8 l=0.6 w=1.4 as=0.406
+ ad=0.406 ps=3.38 pd=3.38
X$573 VSS cmc \$16 sky130_gnd sky130_fd_pr__nfet_01v8 l=0.6 w=1.4 as=0.406
+ ad=0.406 ps=3.38 pd=3.38
X$574 VSS bias_a \$16 sky130_gnd sky130_fd_pr__nfet_01v8 l=0.6 w=1.4 as=0.406
+ ad=0.406 ps=3.38 pd=3.38
X$575 VSS cmc \$16 sky130_gnd sky130_fd_pr__nfet_01v8 l=0.6 w=1.4 as=0.406
+ ad=0.406 ps=3.38 pd=3.38
X$576 VSS bias_a \$16 sky130_gnd sky130_fd_pr__nfet_01v8 l=0.6 w=1.4 as=0.406
+ ad=0.406 ps=3.38 pd=3.38
X$577 VSS cmc \$16 sky130_gnd sky130_fd_pr__nfet_01v8 l=0.6 w=1.4 as=0.406
+ ad=0.406 ps=3.38 pd=3.38
X$578 VSS bias_a \$16 sky130_gnd sky130_fd_pr__nfet_01v8 l=0.6 w=1.4 as=0.406
+ ad=0.406 ps=3.38 pd=3.38
X$579 VSS cmc \$16 sky130_gnd sky130_fd_pr__nfet_01v8 l=0.6 w=1.4 as=0.406
+ ad=0.406 ps=3.38 pd=3.38
X$580 VSS bias_a \$16 sky130_gnd sky130_fd_pr__nfet_01v8 l=0.6 w=1.4 as=0.406
+ ad=0.406 ps=3.38 pd=3.38
X$581 VSS cmc \$16 sky130_gnd sky130_fd_pr__nfet_01v8 l=0.6 w=1.4 as=0.406
+ ad=0.406 ps=3.38 pd=3.38
X$582 VSS bias_a \$16 sky130_gnd sky130_fd_pr__nfet_01v8 l=0.6 w=1.4 as=0.406
+ ad=0.406 ps=3.38 pd=3.38
X$583 VSS cmc \$16 sky130_gnd sky130_fd_pr__nfet_01v8 l=0.6 w=1.4 as=0.406
+ ad=0.406 ps=3.38 pd=3.38
X$584 VSS bias_a \$16 sky130_gnd sky130_fd_pr__nfet_01v8 l=0.6 w=1.4 as=0.406
+ ad=0.406 ps=3.38 pd=3.38
X$585 VSS cmc \$16 sky130_gnd sky130_fd_pr__nfet_01v8 l=0.6 w=1.4 as=0.406
+ ad=0.406 ps=3.38 pd=3.38
X$586 VSS bias_a \$16 sky130_gnd sky130_fd_pr__nfet_01v8 l=0.6 w=1.4 as=0.406
+ ad=0.406 ps=3.38 pd=3.38
X$587 VSS cmc \$16 sky130_gnd sky130_fd_pr__nfet_01v8 l=0.6 w=1.4 as=0.406
+ ad=0.406 ps=3.38 pd=3.38
X$588 VSS bias_a \$16 sky130_gnd sky130_fd_pr__nfet_01v8 l=0.6 w=1.4 as=0.406
+ ad=0.406 ps=3.38 pd=3.38
X$589 VSS cmc \$16 sky130_gnd sky130_fd_pr__nfet_01v8 l=0.6 w=1.4 as=0.406
+ ad=0.406 ps=3.38 pd=3.38
X$590 VSS bias_a \$16 sky130_gnd sky130_fd_pr__nfet_01v8 l=0.6 w=1.4 as=0.406
+ ad=0.406 ps=3.38 pd=3.38
X$591 VSS cmc \$16 sky130_gnd sky130_fd_pr__nfet_01v8 l=0.6 w=1.4 as=0.406
+ ad=0.406 ps=3.38 pd=3.38
X$592 VSS bias_a \$16 sky130_gnd sky130_fd_pr__nfet_01v8 l=0.6 w=1.4 as=0.406
+ ad=0.406 ps=3.38 pd=3.38
X$593 VSS bias_a \$16 sky130_gnd sky130_fd_pr__nfet_01v8 l=0.6 w=1.4 as=0.406
+ ad=0.406 ps=3.38 pd=3.38
X$594 VSS cmc \$16 sky130_gnd sky130_fd_pr__nfet_01v8 l=0.6 w=1.4 as=0.406
+ ad=0.406 ps=3.38 pd=3.38
X$595 VSS cmc \$16 sky130_gnd sky130_fd_pr__nfet_01v8 l=0.6 w=1.4 as=0.406
+ ad=0.406 ps=3.38 pd=3.38
X$596 VSS cmc \$16 sky130_gnd sky130_fd_pr__nfet_01v8 l=0.6 w=1.4 as=0.406
+ ad=0.406 ps=3.38 pd=3.38
X$597 VSS bias_a \$16 sky130_gnd sky130_fd_pr__nfet_01v8 l=0.6 w=1.4 as=0.406
+ ad=0.406 ps=3.38 pd=3.38
X$598 VSS cmc \$16 sky130_gnd sky130_fd_pr__nfet_01v8 l=0.6 w=1.4 as=0.406
+ ad=0.406 ps=3.38 pd=3.38
X$599 VSS bias_a \$16 sky130_gnd sky130_fd_pr__nfet_01v8 l=0.6 w=1.4 as=0.406
+ ad=0.406 ps=3.38 pd=3.38
X$600 VSS cmc \$16 sky130_gnd sky130_fd_pr__nfet_01v8 l=0.6 w=1.4 as=0.406
+ ad=0.406 ps=3.38 pd=3.38
X$601 VSS cmc \$16 sky130_gnd sky130_fd_pr__nfet_01v8 l=0.6 w=1.4 as=0.406
+ ad=0.406 ps=3.38 pd=3.38
X$602 VSS cmc \$16 sky130_gnd sky130_fd_pr__nfet_01v8 l=0.6 w=1.4 as=0.406
+ ad=0.406 ps=3.38 pd=3.38
X$603 VSS bias_a \$16 sky130_gnd sky130_fd_pr__nfet_01v8 l=0.6 w=1.4 as=0.406
+ ad=0.406 ps=3.38 pd=3.38
X$604 VSS cmc \$16 sky130_gnd sky130_fd_pr__nfet_01v8 l=0.6 w=1.4 as=0.406
+ ad=0.406 ps=3.38 pd=3.38
X$605 VSS bias_a \$16 sky130_gnd sky130_fd_pr__nfet_01v8 l=0.6 w=1.4 as=0.406
+ ad=0.406 ps=3.38 pd=3.38
X$606 VSS cmc \$16 sky130_gnd sky130_fd_pr__nfet_01v8 l=0.6 w=1.4 as=0.406
+ ad=0.406 ps=3.38 pd=3.38
X$607 VSS bias_a \$16 sky130_gnd sky130_fd_pr__nfet_01v8 l=0.6 w=1.4 as=0.406
+ ad=0.406 ps=3.38 pd=3.38
X$608 VSS cmc \$16 sky130_gnd sky130_fd_pr__nfet_01v8 l=0.6 w=1.4 as=0.406
+ ad=0.406 ps=3.38 pd=3.38
X$609 VSS bias_a \$16 sky130_gnd sky130_fd_pr__nfet_01v8 l=0.6 w=1.4 as=0.406
+ ad=0.406 ps=3.38 pd=3.38
X$610 VSS cmc \$16 sky130_gnd sky130_fd_pr__nfet_01v8 l=0.6 w=1.4 as=0.406
+ ad=0.406 ps=3.38 pd=3.38
X$611 VSS bias_a \$16 sky130_gnd sky130_fd_pr__nfet_01v8 l=0.6 w=1.4 as=0.406
+ ad=0.406 ps=3.38 pd=3.38
X$612 VSS cmc \$16 sky130_gnd sky130_fd_pr__nfet_01v8 l=0.6 w=1.4 as=0.406
+ ad=0.406 ps=3.38 pd=3.38
X$613 VSS bias_a \$16 sky130_gnd sky130_fd_pr__nfet_01v8 l=0.6 w=1.4 as=0.406
+ ad=0.406 ps=3.38 pd=3.38
X$614 VSS cmc \$16 sky130_gnd sky130_fd_pr__nfet_01v8 l=0.6 w=1.4 as=0.406
+ ad=0.406 ps=3.38 pd=3.38
X$615 VSS bias_a \$16 sky130_gnd sky130_fd_pr__nfet_01v8 l=0.6 w=1.4 as=0.406
+ ad=0.406 ps=3.38 pd=3.38
X$616 VSS cmc \$16 sky130_gnd sky130_fd_pr__nfet_01v8 l=0.6 w=1.4 as=0.406
+ ad=0.406 ps=3.38 pd=3.38
X$617 VSS bias_a \$16 sky130_gnd sky130_fd_pr__nfet_01v8 l=0.6 w=1.4 as=0.406
+ ad=0.406 ps=3.38 pd=3.38
X$618 VSS cmc \$16 sky130_gnd sky130_fd_pr__nfet_01v8 l=0.6 w=1.4 as=0.406
+ ad=0.406 ps=3.38 pd=3.38
X$619 VSS bias_a \$16 sky130_gnd sky130_fd_pr__nfet_01v8 l=0.6 w=1.4 as=0.406
+ ad=0.406 ps=3.38 pd=3.38
X$620 VSS cmc \$16 sky130_gnd sky130_fd_pr__nfet_01v8 l=0.6 w=1.4 as=0.406
+ ad=0.406 ps=3.38 pd=3.38
X$621 VSS bias_a \$16 sky130_gnd sky130_fd_pr__nfet_01v8 l=0.6 w=1.4 as=0.406
+ ad=0.406 ps=3.38 pd=3.38
X$622 VSS cmc \$16 sky130_gnd sky130_fd_pr__nfet_01v8 l=0.6 w=1.4 as=0.406
+ ad=0.406 ps=3.38 pd=3.38
X$623 VSS bias_a \$16 sky130_gnd sky130_fd_pr__nfet_01v8 l=0.6 w=1.4 as=0.406
+ ad=0.406 ps=3.38 pd=3.38
X$624 VSS cmc \$16 sky130_gnd sky130_fd_pr__nfet_01v8 l=0.6 w=1.4 as=0.406
+ ad=0.406 ps=3.38 pd=3.38
X$625 VSS bias_a \$16 sky130_gnd sky130_fd_pr__nfet_01v8 l=0.6 w=1.4 as=0.406
+ ad=0.406 ps=3.38 pd=3.38
X$626 VSS cmc \$16 sky130_gnd sky130_fd_pr__nfet_01v8 l=0.6 w=1.4 as=0.406
+ ad=0.406 ps=3.38 pd=3.38
X$627 VSS bias_a \$16 sky130_gnd sky130_fd_pr__nfet_01v8 l=0.6 w=1.4 as=0.406
+ ad=0.406 ps=3.38 pd=3.38
X$628 VSS cmc \$16 sky130_gnd sky130_fd_pr__nfet_01v8 l=0.6 w=1.4 as=0.406
+ ad=0.406 ps=3.38 pd=3.38
X$629 VSS bias_a \$16 sky130_gnd sky130_fd_pr__nfet_01v8 l=0.6 w=1.4 as=0.406
+ ad=0.406 ps=3.38 pd=3.38
X$630 VSS cmc \$16 sky130_gnd sky130_fd_pr__nfet_01v8 l=0.6 w=1.4 as=0.406
+ ad=0.406 ps=3.38 pd=3.38
X$631 VSS bias_a \$16 sky130_gnd sky130_fd_pr__nfet_01v8 l=0.6 w=1.4 as=0.406
+ ad=0.406 ps=3.38 pd=3.38
X$632 VSS cmc \$16 sky130_gnd sky130_fd_pr__nfet_01v8 l=0.6 w=1.4 as=0.406
+ ad=0.406 ps=3.38 pd=3.38
X$633 VSS bias_a \$16 sky130_gnd sky130_fd_pr__nfet_01v8 l=0.6 w=1.4 as=0.406
+ ad=0.406 ps=3.38 pd=3.38
X$634 VSS cmc \$16 sky130_gnd sky130_fd_pr__nfet_01v8 l=0.6 w=1.4 as=0.406
+ ad=0.406 ps=3.38 pd=3.38
X$635 VSS bias_a \$16 sky130_gnd sky130_fd_pr__nfet_01v8 l=0.6 w=1.4 as=0.406
+ ad=0.406 ps=3.38 pd=3.38
X$636 VSS cmc \$16 sky130_gnd sky130_fd_pr__nfet_01v8 l=0.6 w=1.4 as=0.406
+ ad=0.406 ps=3.38 pd=3.38
X$637 VSS bias_a \$16 sky130_gnd sky130_fd_pr__nfet_01v8 l=0.6 w=1.4 as=0.406
+ ad=0.406 ps=3.38 pd=3.38
X$638 VSS cmc \$16 sky130_gnd sky130_fd_pr__nfet_01v8 l=0.6 w=1.4 as=0.406
+ ad=0.406 ps=3.38 pd=3.38
X$639 VSS bias_a \$16 sky130_gnd sky130_fd_pr__nfet_01v8 l=0.6 w=1.4 as=0.406
+ ad=0.406 ps=3.38 pd=3.38
X$640 VSS bias_a \$16 sky130_gnd sky130_fd_pr__nfet_01v8 l=0.6 w=1.4 as=0.406
+ ad=0.406 ps=3.38 pd=3.38
X$641 VSS bias_a \$16 sky130_gnd sky130_fd_pr__nfet_01v8 l=0.6 w=1.4 as=0.406
+ ad=0.406 ps=3.38 pd=3.38
X$642 VSS cmc \$16 sky130_gnd sky130_fd_pr__nfet_01v8 l=0.6 w=1.4 as=0.406
+ ad=0.406 ps=3.38 pd=3.38
X$643 VSS bias_a \$16 sky130_gnd sky130_fd_pr__nfet_01v8 l=0.6 w=1.4 as=0.406
+ ad=0.406 ps=3.38 pd=3.38
X$644 VSS cmc \$16 sky130_gnd sky130_fd_pr__nfet_01v8 l=0.6 w=1.4 as=0.406
+ ad=0.406 ps=3.38 pd=3.38
X$645 VSS bias_a \$16 sky130_gnd sky130_fd_pr__nfet_01v8 l=0.6 w=1.4 as=0.406
+ ad=0.406 ps=3.38 pd=3.38
X$646 VSS cmc \$16 sky130_gnd sky130_fd_pr__nfet_01v8 l=0.6 w=1.4 as=0.406
+ ad=0.406 ps=3.38 pd=3.38
X$647 VSS bias_a \$16 sky130_gnd sky130_fd_pr__nfet_01v8 l=0.6 w=1.4 as=0.406
+ ad=0.406 ps=3.38 pd=3.38
X$648 VSS bias_a \$16 sky130_gnd sky130_fd_pr__nfet_01v8 l=0.6 w=1.4 as=0.406
+ ad=0.406 ps=3.38 pd=3.38
X$649 VSS bias_a \$16 sky130_gnd sky130_fd_pr__nfet_01v8 l=0.6 w=1.4 as=0.406
+ ad=0.406 ps=3.38 pd=3.38
X$650 VSS cmc \$16 sky130_gnd sky130_fd_pr__nfet_01v8 l=0.6 w=1.4 as=0.406
+ ad=0.406 ps=3.38 pd=3.38
X$651 VSS bias_a \$16 sky130_gnd sky130_fd_pr__nfet_01v8 l=0.6 w=1.4 as=0.406
+ ad=0.406 ps=3.38 pd=3.38
X$652 VSS cmc \$16 sky130_gnd sky130_fd_pr__nfet_01v8 l=0.6 w=1.4 as=0.406
+ ad=0.406 ps=3.38 pd=3.38
X$653 VSS bias_a \$16 sky130_gnd sky130_fd_pr__nfet_01v8 l=0.6 w=1.4 as=0.406
+ ad=0.406 ps=3.38 pd=3.38
X$654 VSS cmc \$16 sky130_gnd sky130_fd_pr__nfet_01v8 l=0.6 w=1.4 as=0.406
+ ad=0.406 ps=3.38 pd=3.38
X$655 VSS bias_a \$16 sky130_gnd sky130_fd_pr__nfet_01v8 l=0.6 w=1.4 as=0.406
+ ad=0.406 ps=3.38 pd=3.38
X$656 VSS cmc \$16 sky130_gnd sky130_fd_pr__nfet_01v8 l=0.6 w=1.4 as=0.406
+ ad=0.406 ps=3.38 pd=3.38
X$657 VSS cmc \$16 sky130_gnd sky130_fd_pr__nfet_01v8 l=0.6 w=1.4 as=0.406
+ ad=0.406 ps=3.38 pd=3.38
X$658 VSS cmc \$16 sky130_gnd sky130_fd_pr__nfet_01v8 l=0.6 w=1.4 as=0.406
+ ad=0.406 ps=3.38 pd=3.38
X$659 VSS bias_a \$16 sky130_gnd sky130_fd_pr__nfet_01v8 l=0.6 w=1.4 as=0.406
+ ad=0.406 ps=3.38 pd=3.38
X$660 VSS cmc \$16 sky130_gnd sky130_fd_pr__nfet_01v8 l=0.6 w=1.4 as=0.406
+ ad=0.406 ps=3.38 pd=3.38
X$661 VSS bias_a \$16 sky130_gnd sky130_fd_pr__nfet_01v8 l=0.6 w=1.4 as=0.406
+ ad=0.406 ps=3.38 pd=3.38
X$662 VSS cmc \$16 sky130_gnd sky130_fd_pr__nfet_01v8 l=0.6 w=1.4 as=0.406
+ ad=0.406 ps=3.38 pd=3.38
X$663 VSS bias_a \$16 sky130_gnd sky130_fd_pr__nfet_01v8 l=0.6 w=1.4 as=0.406
+ ad=0.406 ps=3.38 pd=3.38
X$664 VSS cmc \$16 sky130_gnd sky130_fd_pr__nfet_01v8 l=0.6 w=1.4 as=0.406
+ ad=0.406 ps=3.38 pd=3.38
X$665 VSS cmc \$16 sky130_gnd sky130_fd_pr__nfet_01v8 l=0.6 w=1.4 as=0.406
+ ad=0.406 ps=3.38 pd=3.38
X$666 VSS cmc \$16 sky130_gnd sky130_fd_pr__nfet_01v8 l=0.6 w=1.4 as=0.406
+ ad=0.406 ps=3.38 pd=3.38
X$667 VSS bias_a \$16 sky130_gnd sky130_fd_pr__nfet_01v8 l=0.6 w=1.4 as=0.406
+ ad=0.406 ps=3.38 pd=3.38
X$668 VSS cmc \$16 sky130_gnd sky130_fd_pr__nfet_01v8 l=0.6 w=1.4 as=0.406
+ ad=0.406 ps=3.38 pd=3.38
X$669 VSS bias_a \$16 sky130_gnd sky130_fd_pr__nfet_01v8 l=0.6 w=1.4 as=0.406
+ ad=0.406 ps=3.38 pd=3.38
X$670 VSS bias_a \$16 sky130_gnd sky130_fd_pr__nfet_01v8 l=0.6 w=1.4 as=0.406
+ ad=0.406 ps=3.38 pd=3.38
X$671 VSS cmc \$16 sky130_gnd sky130_fd_pr__nfet_01v8 l=0.6 w=1.4 as=0.406
+ ad=0.406 ps=3.38 pd=3.38
X$672 VSS bias_a \$16 sky130_gnd sky130_fd_pr__nfet_01v8 l=0.6 w=1.4 as=0.406
+ ad=0.406 ps=3.38 pd=3.38
X$673 VSS bias_a \$16 sky130_gnd sky130_fd_pr__nfet_01v8 l=0.6 w=1.4 as=0.406
+ ad=0.406 ps=3.38 pd=3.38
X$674 VSS bias_a \$16 sky130_gnd sky130_fd_pr__nfet_01v8 l=0.6 w=1.4 as=0.406
+ ad=0.406 ps=3.38 pd=3.38
X$675 VSS cmc \$16 sky130_gnd sky130_fd_pr__nfet_01v8 l=0.6 w=1.4 as=0.406
+ ad=0.406 ps=3.38 pd=3.38
X$676 VSS bias_a \$16 sky130_gnd sky130_fd_pr__nfet_01v8 l=0.6 w=1.4 as=0.406
+ ad=0.406 ps=3.38 pd=3.38
X$677 VSS cmc \$16 sky130_gnd sky130_fd_pr__nfet_01v8 l=0.6 w=1.4 as=0.406
+ ad=0.406 ps=3.38 pd=3.38
X$678 VSS bias_a \$16 sky130_gnd sky130_fd_pr__nfet_01v8 l=0.6 w=1.4 as=0.406
+ ad=0.406 ps=3.38 pd=3.38
X$679 VSS cmc \$16 sky130_gnd sky130_fd_pr__nfet_01v8 l=0.6 w=1.4 as=0.406
+ ad=0.406 ps=3.38 pd=3.38
X$680 VSS bias_a \$16 sky130_gnd sky130_fd_pr__nfet_01v8 l=0.6 w=1.4 as=0.406
+ ad=0.406 ps=3.38 pd=3.38
X$681 VSS cmc \$16 sky130_gnd sky130_fd_pr__nfet_01v8 l=0.6 w=1.4 as=0.406
+ ad=0.406 ps=3.38 pd=3.38
X$682 VSS bias_a \$16 sky130_gnd sky130_fd_pr__nfet_01v8 l=0.6 w=1.4 as=0.406
+ ad=0.406 ps=3.38 pd=3.38
X$683 VSS cmc \$16 sky130_gnd sky130_fd_pr__nfet_01v8 l=0.6 w=1.4 as=0.406
+ ad=0.406 ps=3.38 pd=3.38
X$684 VSS bias_a \$16 sky130_gnd sky130_fd_pr__nfet_01v8 l=0.6 w=1.4 as=0.406
+ ad=0.406 ps=3.38 pd=3.38
X$685 VSS cmc \$16 sky130_gnd sky130_fd_pr__nfet_01v8 l=0.6 w=1.4 as=0.406
+ ad=0.406 ps=3.38 pd=3.38
X$686 VSS bias_a \$16 sky130_gnd sky130_fd_pr__nfet_01v8 l=0.6 w=1.4 as=0.406
+ ad=0.406 ps=3.38 pd=3.38
X$687 VSS cmc \$16 sky130_gnd sky130_fd_pr__nfet_01v8 l=0.6 w=1.4 as=0.406
+ ad=0.406 ps=3.38 pd=3.38
X$688 VSS bias_a \$16 sky130_gnd sky130_fd_pr__nfet_01v8 l=0.6 w=1.4 as=0.406
+ ad=0.406 ps=3.38 pd=3.38
X$689 VSS bias_a \$16 sky130_gnd sky130_fd_pr__nfet_01v8 l=0.6 w=1.4 as=0.406
+ ad=0.406 ps=3.38 pd=3.38
X$690 \$18 \$73 op sky130_gnd sky130_fd_pr__nfet_01v8 l=0.6 w=1.4 as=0.406
+ ad=0.406 ps=3.38 pd=3.38
X$691 \$18 \$73 op sky130_gnd sky130_fd_pr__nfet_01v8 l=0.6 w=1.4 as=0.406
+ ad=0.406 ps=3.38 pd=3.38
X$692 \$18 \$73 op sky130_gnd sky130_fd_pr__nfet_01v8 l=0.6 w=1.4 as=0.406
+ ad=0.406 ps=3.38 pd=3.38
X$693 \$18 \$73 op sky130_gnd sky130_fd_pr__nfet_01v8 l=0.6 w=1.4 as=0.406
+ ad=0.406 ps=3.38 pd=3.38
X$694 \$18 \$73 op sky130_gnd sky130_fd_pr__nfet_01v8 l=0.6 w=1.4 as=0.406
+ ad=0.406 ps=3.38 pd=3.38
X$695 \$18 \$73 op sky130_gnd sky130_fd_pr__nfet_01v8 l=0.6 w=1.4 as=0.406
+ ad=0.406 ps=3.38 pd=3.38
X$696 \$18 \$73 op sky130_gnd sky130_fd_pr__nfet_01v8 l=0.6 w=1.4 as=0.406
+ ad=0.406 ps=3.38 pd=3.38
X$697 \$18 \$73 op sky130_gnd sky130_fd_pr__nfet_01v8 l=0.6 w=1.4 as=0.406
+ ad=0.406 ps=3.38 pd=3.38
X$698 \$18 \$73 op sky130_gnd sky130_fd_pr__nfet_01v8 l=0.6 w=1.4 as=0.406
+ ad=0.406 ps=3.38 pd=3.38
X$699 \$18 \$73 op sky130_gnd sky130_fd_pr__nfet_01v8 l=0.6 w=1.4 as=0.406
+ ad=0.406 ps=3.38 pd=3.38
X$700 \$18 \$73 op sky130_gnd sky130_fd_pr__nfet_01v8 l=0.6 w=1.4 as=0.406
+ ad=0.406 ps=3.38 pd=3.38
X$701 \$18 \$73 op sky130_gnd sky130_fd_pr__nfet_01v8 l=0.6 w=1.4 as=0.406
+ ad=0.406 ps=3.38 pd=3.38
X$702 \$18 \$73 op sky130_gnd sky130_fd_pr__nfet_01v8 l=0.6 w=1.4 as=0.406
+ ad=0.406 ps=3.38 pd=3.38
X$703 \$18 \$73 op sky130_gnd sky130_fd_pr__nfet_01v8 l=0.6 w=1.4 as=0.406
+ ad=0.406 ps=3.38 pd=3.38
X$704 \$18 \$73 op sky130_gnd sky130_fd_pr__nfet_01v8 l=0.6 w=1.4 as=0.406
+ ad=0.406 ps=3.38 pd=3.38
X$705 \$18 \$73 op sky130_gnd sky130_fd_pr__nfet_01v8 l=0.6 w=1.4 as=0.406
+ ad=0.406 ps=3.38 pd=3.38
X$706 \$18 \$73 op sky130_gnd sky130_fd_pr__nfet_01v8 l=0.6 w=1.4 as=0.406
+ ad=0.406 ps=3.38 pd=3.38
X$707 \$18 \$73 op sky130_gnd sky130_fd_pr__nfet_01v8 l=0.6 w=1.4 as=0.406
+ ad=0.406 ps=3.38 pd=3.38
X$708 \$18 \$73 op sky130_gnd sky130_fd_pr__nfet_01v8 l=0.6 w=1.4 as=0.406
+ ad=0.406 ps=3.38 pd=3.38
X$709 \$18 \$73 op sky130_gnd sky130_fd_pr__nfet_01v8 l=0.6 w=1.4 as=0.406
+ ad=0.406 ps=3.38 pd=3.38
X$710 \$18 \$73 op sky130_gnd sky130_fd_pr__nfet_01v8 l=0.6 w=1.4 as=0.406
+ ad=0.406 ps=3.38 pd=3.38
X$711 \$18 \$73 op sky130_gnd sky130_fd_pr__nfet_01v8 l=0.6 w=1.4 as=0.406
+ ad=0.406 ps=3.38 pd=3.38
X$712 \$18 \$73 op sky130_gnd sky130_fd_pr__nfet_01v8 l=0.6 w=1.4 as=0.406
+ ad=0.406 ps=3.38 pd=3.38
X$713 \$18 \$73 op sky130_gnd sky130_fd_pr__nfet_01v8 l=0.6 w=1.4 as=0.406
+ ad=0.406 ps=3.38 pd=3.38
X$714 \$18 \$73 op sky130_gnd sky130_fd_pr__nfet_01v8 l=0.6 w=1.4 as=0.406
+ ad=0.406 ps=3.38 pd=3.38
X$715 \$18 \$73 op sky130_gnd sky130_fd_pr__nfet_01v8 l=0.6 w=1.4 as=0.406
+ ad=0.406 ps=3.38 pd=3.38
X$716 \$18 \$73 op sky130_gnd sky130_fd_pr__nfet_01v8 l=0.6 w=1.4 as=0.406
+ ad=0.406 ps=3.38 pd=3.38
X$717 \$18 \$73 op sky130_gnd sky130_fd_pr__nfet_01v8 l=0.6 w=1.4 as=0.406
+ ad=0.406 ps=3.38 pd=3.38
X$718 \$18 \$73 op sky130_gnd sky130_fd_pr__nfet_01v8 l=0.6 w=1.4 as=0.406
+ ad=0.406 ps=3.38 pd=3.38
X$719 \$18 \$73 op sky130_gnd sky130_fd_pr__nfet_01v8 l=0.6 w=1.4 as=0.406
+ ad=0.406 ps=3.38 pd=3.38
X$720 \$18 \$73 op sky130_gnd sky130_fd_pr__nfet_01v8 l=0.6 w=1.4 as=0.406
+ ad=0.406 ps=3.38 pd=3.38
X$721 \$18 \$73 op sky130_gnd sky130_fd_pr__nfet_01v8 l=0.6 w=1.4 as=0.406
+ ad=0.406 ps=3.38 pd=3.38
X$722 \$18 \$73 op sky130_gnd sky130_fd_pr__nfet_01v8 l=0.6 w=1.4 as=0.406
+ ad=0.406 ps=3.38 pd=3.38
X$723 \$18 \$73 op sky130_gnd sky130_fd_pr__nfet_01v8 l=0.6 w=1.4 as=0.406
+ ad=0.406 ps=3.38 pd=3.38
X$724 \$18 \$73 op sky130_gnd sky130_fd_pr__nfet_01v8 l=0.6 w=1.4 as=0.406
+ ad=0.406 ps=3.38 pd=3.38
X$725 \$18 \$73 op sky130_gnd sky130_fd_pr__nfet_01v8 l=0.6 w=1.4 as=0.406
+ ad=0.406 ps=3.38 pd=3.38
X$726 \$17 \$73 on sky130_gnd sky130_fd_pr__nfet_01v8 l=0.6 w=1.4 as=0.406
+ ad=0.406 ps=3.38 pd=3.38
X$727 \$17 \$73 on sky130_gnd sky130_fd_pr__nfet_01v8 l=0.6 w=1.4 as=0.406
+ ad=0.406 ps=3.38 pd=3.38
X$728 \$17 \$73 on sky130_gnd sky130_fd_pr__nfet_01v8 l=0.6 w=1.4 as=0.406
+ ad=0.406 ps=3.38 pd=3.38
X$729 \$17 \$73 on sky130_gnd sky130_fd_pr__nfet_01v8 l=0.6 w=1.4 as=0.406
+ ad=0.406 ps=3.38 pd=3.38
X$730 \$17 \$73 on sky130_gnd sky130_fd_pr__nfet_01v8 l=0.6 w=1.4 as=0.406
+ ad=0.406 ps=3.38 pd=3.38
X$731 \$17 \$73 on sky130_gnd sky130_fd_pr__nfet_01v8 l=0.6 w=1.4 as=0.406
+ ad=0.406 ps=3.38 pd=3.38
X$732 \$17 \$73 on sky130_gnd sky130_fd_pr__nfet_01v8 l=0.6 w=1.4 as=0.406
+ ad=0.406 ps=3.38 pd=3.38
X$733 \$17 \$73 on sky130_gnd sky130_fd_pr__nfet_01v8 l=0.6 w=1.4 as=0.406
+ ad=0.406 ps=3.38 pd=3.38
X$734 \$17 \$73 on sky130_gnd sky130_fd_pr__nfet_01v8 l=0.6 w=1.4 as=0.406
+ ad=0.406 ps=3.38 pd=3.38
X$735 \$17 \$73 on sky130_gnd sky130_fd_pr__nfet_01v8 l=0.6 w=1.4 as=0.406
+ ad=0.406 ps=3.38 pd=3.38
X$736 \$17 \$73 on sky130_gnd sky130_fd_pr__nfet_01v8 l=0.6 w=1.4 as=0.406
+ ad=0.406 ps=3.38 pd=3.38
X$737 \$17 \$73 on sky130_gnd sky130_fd_pr__nfet_01v8 l=0.6 w=1.4 as=0.406
+ ad=0.406 ps=3.38 pd=3.38
X$738 \$17 \$73 on sky130_gnd sky130_fd_pr__nfet_01v8 l=0.6 w=1.4 as=0.406
+ ad=0.406 ps=3.38 pd=3.38
X$739 \$17 \$73 on sky130_gnd sky130_fd_pr__nfet_01v8 l=0.6 w=1.4 as=0.406
+ ad=0.406 ps=3.38 pd=3.38
X$740 \$17 \$73 on sky130_gnd sky130_fd_pr__nfet_01v8 l=0.6 w=1.4 as=0.406
+ ad=0.406 ps=3.38 pd=3.38
X$741 \$17 \$73 on sky130_gnd sky130_fd_pr__nfet_01v8 l=0.6 w=1.4 as=0.406
+ ad=0.406 ps=3.38 pd=3.38
X$742 \$17 \$73 on sky130_gnd sky130_fd_pr__nfet_01v8 l=0.6 w=1.4 as=0.406
+ ad=0.406 ps=3.38 pd=3.38
X$743 \$17 \$73 on sky130_gnd sky130_fd_pr__nfet_01v8 l=0.6 w=1.4 as=0.406
+ ad=0.406 ps=3.38 pd=3.38
X$744 \$17 \$73 on sky130_gnd sky130_fd_pr__nfet_01v8 l=0.6 w=1.4 as=0.406
+ ad=0.406 ps=3.38 pd=3.38
X$745 \$17 \$73 on sky130_gnd sky130_fd_pr__nfet_01v8 l=0.6 w=1.4 as=0.406
+ ad=0.406 ps=3.38 pd=3.38
X$746 \$17 \$73 on sky130_gnd sky130_fd_pr__nfet_01v8 l=0.6 w=1.4 as=0.406
+ ad=0.406 ps=3.38 pd=3.38
X$747 \$17 \$73 on sky130_gnd sky130_fd_pr__nfet_01v8 l=0.6 w=1.4 as=0.406
+ ad=0.406 ps=3.38 pd=3.38
X$748 \$17 \$73 on sky130_gnd sky130_fd_pr__nfet_01v8 l=0.6 w=1.4 as=0.406
+ ad=0.406 ps=3.38 pd=3.38
X$749 \$17 \$73 on sky130_gnd sky130_fd_pr__nfet_01v8 l=0.6 w=1.4 as=0.406
+ ad=0.406 ps=3.38 pd=3.38
X$750 \$17 \$73 on sky130_gnd sky130_fd_pr__nfet_01v8 l=0.6 w=1.4 as=0.406
+ ad=0.406 ps=3.38 pd=3.38
X$751 \$17 \$73 on sky130_gnd sky130_fd_pr__nfet_01v8 l=0.6 w=1.4 as=0.406
+ ad=0.406 ps=3.38 pd=3.38
X$752 \$17 \$73 on sky130_gnd sky130_fd_pr__nfet_01v8 l=0.6 w=1.4 as=0.406
+ ad=0.406 ps=3.38 pd=3.38
X$753 \$17 \$73 on sky130_gnd sky130_fd_pr__nfet_01v8 l=0.6 w=1.4 as=0.406
+ ad=0.406 ps=3.38 pd=3.38
X$754 \$17 \$73 on sky130_gnd sky130_fd_pr__nfet_01v8 l=0.6 w=1.4 as=0.406
+ ad=0.406 ps=3.38 pd=3.38
X$755 \$17 \$73 on sky130_gnd sky130_fd_pr__nfet_01v8 l=0.6 w=1.4 as=0.406
+ ad=0.406 ps=3.38 pd=3.38
X$756 \$17 \$73 on sky130_gnd sky130_fd_pr__nfet_01v8 l=0.6 w=1.4 as=0.406
+ ad=0.406 ps=3.38 pd=3.38
X$757 \$17 \$73 on sky130_gnd sky130_fd_pr__nfet_01v8 l=0.6 w=1.4 as=0.406
+ ad=0.406 ps=3.38 pd=3.38
X$758 \$17 \$73 on sky130_gnd sky130_fd_pr__nfet_01v8 l=0.6 w=1.4 as=0.406
+ ad=0.406 ps=3.38 pd=3.38
X$759 \$17 \$73 on sky130_gnd sky130_fd_pr__nfet_01v8 l=0.6 w=1.4 as=0.406
+ ad=0.406 ps=3.38 pd=3.38
X$760 \$17 \$73 on sky130_gnd sky130_fd_pr__nfet_01v8 l=0.6 w=1.4 as=0.406
+ ad=0.406 ps=3.38 pd=3.38
X$761 \$17 \$73 on sky130_gnd sky130_fd_pr__nfet_01v8 l=0.6 w=1.4 as=0.406
+ ad=0.406 ps=3.38 pd=3.38
X$762 VSS VSS VSS sky130_gnd sky130_fd_pr__nfet_01v8 l=0.6 w=1.4 as=0.406
+ ad=0.406 ps=3.38 pd=3.38
X$763 VSS VSS VSS sky130_gnd sky130_fd_pr__nfet_01v8 l=0.6 w=1.4 as=0.406
+ ad=0.406 ps=3.38 pd=3.38
X$764 VSS VSS VSS sky130_gnd sky130_fd_pr__nfet_01v8 l=0.6 w=1.4 as=0.406
+ ad=0.406 ps=3.38 pd=3.38
X$765 VSS VSS VSS sky130_gnd sky130_fd_pr__nfet_01v8 l=0.6 w=1.4 as=0.406
+ ad=0.406 ps=3.38 pd=3.38
X$766 VSS bias_a \$18 sky130_gnd sky130_fd_pr__nfet_01v8 l=0.6 w=1.4 as=0.406
+ ad=0.406 ps=3.38 pd=3.38
X$767 VSS bias_a \$18 sky130_gnd sky130_fd_pr__nfet_01v8 l=0.6 w=1.4 as=0.406
+ ad=0.406 ps=3.38 pd=3.38
X$768 VSS bias_a \$18 sky130_gnd sky130_fd_pr__nfet_01v8 l=0.6 w=1.4 as=0.406
+ ad=0.406 ps=3.38 pd=3.38
X$769 VSS bias_a \$18 sky130_gnd sky130_fd_pr__nfet_01v8 l=0.6 w=1.4 as=0.406
+ ad=0.406 ps=3.38 pd=3.38
X$770 VSS bias_a \$18 sky130_gnd sky130_fd_pr__nfet_01v8 l=0.6 w=1.4 as=0.406
+ ad=0.406 ps=3.38 pd=3.38
X$771 VSS bias_a \$18 sky130_gnd sky130_fd_pr__nfet_01v8 l=0.6 w=1.4 as=0.406
+ ad=0.406 ps=3.38 pd=3.38
X$772 VSS bias_a \$18 sky130_gnd sky130_fd_pr__nfet_01v8 l=0.6 w=1.4 as=0.406
+ ad=0.406 ps=3.38 pd=3.38
X$773 VSS bias_a \$18 sky130_gnd sky130_fd_pr__nfet_01v8 l=0.6 w=1.4 as=0.406
+ ad=0.406 ps=3.38 pd=3.38
X$774 VSS bias_a \$18 sky130_gnd sky130_fd_pr__nfet_01v8 l=0.6 w=1.4 as=0.406
+ ad=0.406 ps=3.38 pd=3.38
X$775 VSS bias_a \$18 sky130_gnd sky130_fd_pr__nfet_01v8 l=0.6 w=1.4 as=0.406
+ ad=0.406 ps=3.38 pd=3.38
X$776 VSS bias_a \$18 sky130_gnd sky130_fd_pr__nfet_01v8 l=0.6 w=1.4 as=0.406
+ ad=0.406 ps=3.38 pd=3.38
X$777 VSS bias_a \$18 sky130_gnd sky130_fd_pr__nfet_01v8 l=0.6 w=1.4 as=0.406
+ ad=0.406 ps=3.38 pd=3.38
X$778 VSS bias_a \$18 sky130_gnd sky130_fd_pr__nfet_01v8 l=0.6 w=1.4 as=0.406
+ ad=0.406 ps=3.38 pd=3.38
X$779 VSS bias_a \$18 sky130_gnd sky130_fd_pr__nfet_01v8 l=0.6 w=1.4 as=0.406
+ ad=0.406 ps=3.38 pd=3.38
X$780 VSS bias_a \$18 sky130_gnd sky130_fd_pr__nfet_01v8 l=0.6 w=1.4 as=0.406
+ ad=0.406 ps=3.38 pd=3.38
X$781 VSS bias_a \$18 sky130_gnd sky130_fd_pr__nfet_01v8 l=0.6 w=1.4 as=0.406
+ ad=0.406 ps=3.38 pd=3.38
X$782 VSS bias_a \$18 sky130_gnd sky130_fd_pr__nfet_01v8 l=0.6 w=1.4 as=0.406
+ ad=0.406 ps=3.38 pd=3.38
X$783 VSS bias_a \$18 sky130_gnd sky130_fd_pr__nfet_01v8 l=0.6 w=1.4 as=0.406
+ ad=0.406 ps=3.38 pd=3.38
X$784 VSS bias_a \$18 sky130_gnd sky130_fd_pr__nfet_01v8 l=0.6 w=1.4 as=0.406
+ ad=0.406 ps=3.38 pd=3.38
X$785 VSS bias_a \$18 sky130_gnd sky130_fd_pr__nfet_01v8 l=0.6 w=1.4 as=0.406
+ ad=0.406 ps=3.38 pd=3.38
X$786 VSS bias_a \$18 sky130_gnd sky130_fd_pr__nfet_01v8 l=0.6 w=1.4 as=0.406
+ ad=0.406 ps=3.38 pd=3.38
X$787 VSS bias_a \$18 sky130_gnd sky130_fd_pr__nfet_01v8 l=0.6 w=1.4 as=0.406
+ ad=0.406 ps=3.38 pd=3.38
X$788 VSS bias_a \$18 sky130_gnd sky130_fd_pr__nfet_01v8 l=0.6 w=1.4 as=0.406
+ ad=0.406 ps=3.38 pd=3.38
X$789 VSS bias_a \$18 sky130_gnd sky130_fd_pr__nfet_01v8 l=0.6 w=1.4 as=0.406
+ ad=0.406 ps=3.38 pd=3.38
X$790 VSS bias_a \$18 sky130_gnd sky130_fd_pr__nfet_01v8 l=0.6 w=1.4 as=0.406
+ ad=0.406 ps=3.38 pd=3.38
X$791 VSS bias_a \$18 sky130_gnd sky130_fd_pr__nfet_01v8 l=0.6 w=1.4 as=0.406
+ ad=0.406 ps=3.38 pd=3.38
X$792 VSS bias_a \$18 sky130_gnd sky130_fd_pr__nfet_01v8 l=0.6 w=1.4 as=0.406
+ ad=0.406 ps=3.38 pd=3.38
X$793 VSS bias_a \$18 sky130_gnd sky130_fd_pr__nfet_01v8 l=0.6 w=1.4 as=0.406
+ ad=0.406 ps=3.38 pd=3.38
X$794 VSS bias_a \$18 sky130_gnd sky130_fd_pr__nfet_01v8 l=0.6 w=1.4 as=0.406
+ ad=0.406 ps=3.38 pd=3.38
X$795 VSS bias_a \$18 sky130_gnd sky130_fd_pr__nfet_01v8 l=0.6 w=1.4 as=0.406
+ ad=0.406 ps=3.38 pd=3.38
X$796 VSS bias_a \$18 sky130_gnd sky130_fd_pr__nfet_01v8 l=0.6 w=1.4 as=0.406
+ ad=0.406 ps=3.38 pd=3.38
X$797 VSS bias_a \$18 sky130_gnd sky130_fd_pr__nfet_01v8 l=0.6 w=1.4 as=0.406
+ ad=0.406 ps=3.38 pd=3.38
X$798 VSS bias_a \$18 sky130_gnd sky130_fd_pr__nfet_01v8 l=0.6 w=1.4 as=0.406
+ ad=0.406 ps=3.38 pd=3.38
X$799 VSS bias_a \$18 sky130_gnd sky130_fd_pr__nfet_01v8 l=0.6 w=1.4 as=0.406
+ ad=0.406 ps=3.38 pd=3.38
X$800 VSS bias_a \$18 sky130_gnd sky130_fd_pr__nfet_01v8 l=0.6 w=1.4 as=0.406
+ ad=0.406 ps=3.38 pd=3.38
X$801 VSS bias_a \$18 sky130_gnd sky130_fd_pr__nfet_01v8 l=0.6 w=1.4 as=0.406
+ ad=0.406 ps=3.38 pd=3.38
X$802 VSS bias_a \$17 sky130_gnd sky130_fd_pr__nfet_01v8 l=0.6 w=1.4 as=0.406
+ ad=0.406 ps=3.38 pd=3.38
X$803 VSS bias_a \$17 sky130_gnd sky130_fd_pr__nfet_01v8 l=0.6 w=1.4 as=0.406
+ ad=0.406 ps=3.38 pd=3.38
X$804 VSS bias_a \$17 sky130_gnd sky130_fd_pr__nfet_01v8 l=0.6 w=1.4 as=0.406
+ ad=0.406 ps=3.38 pd=3.38
X$805 VSS bias_a \$17 sky130_gnd sky130_fd_pr__nfet_01v8 l=0.6 w=1.4 as=0.406
+ ad=0.406 ps=3.38 pd=3.38
X$806 VSS bias_a \$17 sky130_gnd sky130_fd_pr__nfet_01v8 l=0.6 w=1.4 as=0.406
+ ad=0.406 ps=3.38 pd=3.38
X$807 VSS bias_a \$17 sky130_gnd sky130_fd_pr__nfet_01v8 l=0.6 w=1.4 as=0.406
+ ad=0.406 ps=3.38 pd=3.38
X$808 VSS bias_a \$17 sky130_gnd sky130_fd_pr__nfet_01v8 l=0.6 w=1.4 as=0.406
+ ad=0.406 ps=3.38 pd=3.38
X$809 VSS bias_a \$17 sky130_gnd sky130_fd_pr__nfet_01v8 l=0.6 w=1.4 as=0.406
+ ad=0.406 ps=3.38 pd=3.38
X$810 VSS bias_a \$17 sky130_gnd sky130_fd_pr__nfet_01v8 l=0.6 w=1.4 as=0.406
+ ad=0.406 ps=3.38 pd=3.38
X$811 VSS bias_a \$17 sky130_gnd sky130_fd_pr__nfet_01v8 l=0.6 w=1.4 as=0.406
+ ad=0.406 ps=3.38 pd=3.38
X$812 VSS bias_a \$17 sky130_gnd sky130_fd_pr__nfet_01v8 l=0.6 w=1.4 as=0.406
+ ad=0.406 ps=3.38 pd=3.38
X$813 VSS bias_a \$17 sky130_gnd sky130_fd_pr__nfet_01v8 l=0.6 w=1.4 as=0.406
+ ad=0.406 ps=3.38 pd=3.38
X$814 VSS bias_a \$17 sky130_gnd sky130_fd_pr__nfet_01v8 l=0.6 w=1.4 as=0.406
+ ad=0.406 ps=3.38 pd=3.38
X$815 VSS bias_a \$17 sky130_gnd sky130_fd_pr__nfet_01v8 l=0.6 w=1.4 as=0.406
+ ad=0.406 ps=3.38 pd=3.38
X$816 VSS bias_a \$17 sky130_gnd sky130_fd_pr__nfet_01v8 l=0.6 w=1.4 as=0.406
+ ad=0.406 ps=3.38 pd=3.38
X$817 VSS bias_a \$17 sky130_gnd sky130_fd_pr__nfet_01v8 l=0.6 w=1.4 as=0.406
+ ad=0.406 ps=3.38 pd=3.38
X$818 VSS bias_a \$17 sky130_gnd sky130_fd_pr__nfet_01v8 l=0.6 w=1.4 as=0.406
+ ad=0.406 ps=3.38 pd=3.38
X$819 VSS bias_a \$17 sky130_gnd sky130_fd_pr__nfet_01v8 l=0.6 w=1.4 as=0.406
+ ad=0.406 ps=3.38 pd=3.38
X$820 VSS bias_a \$17 sky130_gnd sky130_fd_pr__nfet_01v8 l=0.6 w=1.4 as=0.406
+ ad=0.406 ps=3.38 pd=3.38
X$821 VSS bias_a \$17 sky130_gnd sky130_fd_pr__nfet_01v8 l=0.6 w=1.4 as=0.406
+ ad=0.406 ps=3.38 pd=3.38
X$822 VSS bias_a \$17 sky130_gnd sky130_fd_pr__nfet_01v8 l=0.6 w=1.4 as=0.406
+ ad=0.406 ps=3.38 pd=3.38
X$823 VSS bias_a \$17 sky130_gnd sky130_fd_pr__nfet_01v8 l=0.6 w=1.4 as=0.406
+ ad=0.406 ps=3.38 pd=3.38
X$824 VSS bias_a \$17 sky130_gnd sky130_fd_pr__nfet_01v8 l=0.6 w=1.4 as=0.406
+ ad=0.406 ps=3.38 pd=3.38
X$825 VSS bias_a \$17 sky130_gnd sky130_fd_pr__nfet_01v8 l=0.6 w=1.4 as=0.406
+ ad=0.406 ps=3.38 pd=3.38
X$826 VSS bias_a \$17 sky130_gnd sky130_fd_pr__nfet_01v8 l=0.6 w=1.4 as=0.406
+ ad=0.406 ps=3.38 pd=3.38
X$827 VSS bias_a \$17 sky130_gnd sky130_fd_pr__nfet_01v8 l=0.6 w=1.4 as=0.406
+ ad=0.406 ps=3.38 pd=3.38
X$828 VSS bias_a \$17 sky130_gnd sky130_fd_pr__nfet_01v8 l=0.6 w=1.4 as=0.406
+ ad=0.406 ps=3.38 pd=3.38
X$829 VSS bias_a \$17 sky130_gnd sky130_fd_pr__nfet_01v8 l=0.6 w=1.4 as=0.406
+ ad=0.406 ps=3.38 pd=3.38
X$830 VSS bias_a \$17 sky130_gnd sky130_fd_pr__nfet_01v8 l=0.6 w=1.4 as=0.406
+ ad=0.406 ps=3.38 pd=3.38
X$831 VSS bias_a \$17 sky130_gnd sky130_fd_pr__nfet_01v8 l=0.6 w=1.4 as=0.406
+ ad=0.406 ps=3.38 pd=3.38
X$832 VSS bias_a \$17 sky130_gnd sky130_fd_pr__nfet_01v8 l=0.6 w=1.4 as=0.406
+ ad=0.406 ps=3.38 pd=3.38
X$833 VSS bias_a \$17 sky130_gnd sky130_fd_pr__nfet_01v8 l=0.6 w=1.4 as=0.406
+ ad=0.406 ps=3.38 pd=3.38
X$834 VSS bias_a \$17 sky130_gnd sky130_fd_pr__nfet_01v8 l=0.6 w=1.4 as=0.406
+ ad=0.406 ps=3.38 pd=3.38
X$835 VSS bias_a \$17 sky130_gnd sky130_fd_pr__nfet_01v8 l=0.6 w=1.4 as=0.406
+ ad=0.406 ps=3.38 pd=3.38
X$836 VSS bias_a \$17 sky130_gnd sky130_fd_pr__nfet_01v8 l=0.6 w=1.4 as=0.406
+ ad=0.406 ps=3.38 pd=3.38
X$837 VSS bias_a \$17 sky130_gnd sky130_fd_pr__nfet_01v8 l=0.6 w=1.4 as=0.406
+ ad=0.406 ps=3.38 pd=3.38
X$838 \$177 \$177 \$177 sky130_gnd sky130_fd_pr__nfet_01v8 l=0.6 w=1.4 as=0.406
+ ad=0.406 ps=3.38 pd=3.38
X$839 \$177 \$177 \$177 sky130_gnd sky130_fd_pr__nfet_01v8 l=0.6 w=1.4 as=0.406
+ ad=0.406 ps=3.38 pd=3.38
X$840 IBIAS IBIAS IBIAS sky130_gnd sky130_fd_pr__nfet_01v8 l=0.6 w=1.4 as=0.406
+ ad=0.406 ps=3.38 pd=3.38
X$841 IBIAS IBIAS IBIAS sky130_gnd sky130_fd_pr__nfet_01v8 l=0.6 w=1.4 as=0.406
+ ad=0.406 ps=3.38 pd=3.38
X$842 bias_a \$162 \$73 sky130_gnd sky130_fd_pr__nfet_01v8 l=0.6 w=1.4 as=0.406
+ ad=0.406 ps=3.38 pd=3.38
X$843 bias_a \$162 \$73 sky130_gnd sky130_fd_pr__nfet_01v8 l=0.6 w=1.4 as=0.406
+ ad=0.406 ps=3.38 pd=3.38
X$844 \$162 \$162 \$162 sky130_gnd sky130_fd_pr__nfet_01v8 l=0.6 w=1.4 as=0.406
+ ad=0.406 ps=3.38 pd=3.38
X$845 \$162 \$162 \$162 sky130_gnd sky130_fd_pr__nfet_01v8 l=0.6 w=1.4 as=0.406
+ ad=0.406 ps=3.38 pd=3.38
X$846 on on on sky130_gnd sky130_fd_pr__nfet_01v8 l=0.6 w=1.4 as=0.406 ad=0.406
+ ps=3.38 pd=3.38
X$847 on on on sky130_gnd sky130_fd_pr__nfet_01v8 l=0.6 w=1.4 as=0.406 ad=0.406
+ ps=3.38 pd=3.38
X$848 VSS VSS on sky130_gnd sky130_fd_pr__nfet_01v8 l=0.6 w=1.4 as=0.406
+ ad=0.406 ps=3.38 pd=3.38
X$849 VSS VSS on sky130_gnd sky130_fd_pr__nfet_01v8 l=0.6 w=1.4 as=0.406
+ ad=0.406 ps=3.38 pd=3.38
X$850 op op op sky130_gnd sky130_fd_pr__nfet_01v8 l=0.6 w=1.4 as=0.406 ad=0.406
+ ps=3.38 pd=3.38
X$851 op op op sky130_gnd sky130_fd_pr__nfet_01v8 l=0.6 w=1.4 as=0.406 ad=0.406
+ ps=3.38 pd=3.38
X$852 VSS VSS op sky130_gnd sky130_fd_pr__nfet_01v8 l=0.6 w=1.4 as=0.406
+ ad=0.406 ps=3.38 pd=3.38
X$853 VSS VSS op sky130_gnd sky130_fd_pr__nfet_01v8 l=0.6 w=1.4 as=0.406
+ ad=0.406 ps=3.38 pd=3.38
X$854 VSS VSS \$16 sky130_gnd sky130_fd_pr__nfet_01v8 l=0.6 w=1.4 as=0.406
+ ad=0.406 ps=3.38 pd=3.38
X$855 VSS VSS \$16 sky130_gnd sky130_fd_pr__nfet_01v8 l=0.6 w=1.4 as=0.406
+ ad=0.406 ps=3.38 pd=3.38
Cext_1 \$10.x1_net1 \$10.x1_net2 119.836a
Cext_2 \$10.x1_net1 \$10.x1_net3 8.36158a
Cext_3 \$10.x1_net1 \$162 2.47315a
Cext_4 \$10.x1_net1 \$73 0.30769a
Cext_5 \$10.x1_net1 cm 378.616a
Cext_6 \$10.x1_net1 VSS 7.78942a
Cext_7 \$10.x1_net1 sky130_gnd 228.798a
Cext_8 \$10.x1_net10 \$10.x1_net11 249.501a
Cext_9 \$10.x1_net10 \$10.x1_net12 172.156a
Cext_10 \$10.x1_net10 \$10.x1_net7 5.01695a
Cext_11 \$10.x1_net10 \$10.x1_net8 0.774573a
Cext_12 \$10.x1_net10 \$10.x1_net9 182.321a
Cext_13 \$10.x1_net10 \$162 2.47315a
Cext_14 \$10.x1_net10 \$73 0.30769a
Cext_15 \$10.x1_net10 cm 442.865a
Cext_16 \$10.x1_net10 VSS 10.1874a
Cext_17 \$10.x1_net10 sky130_gnd 256.741a
Cext_18 \$10.x1_net11 \$10.x1_net12 285.211a
Cext_19 \$10.x1_net11 \$10.x1_net8 5.01695a
Cext_20 \$10.x1_net11 \$10.x1_net9 0.774573a
Cext_21 \$10.x1_net11 \$162 2.44328a
Cext_22 \$10.x1_net11 \$73 0.30769a
Cext_23 \$10.x1_net11 cm 465.273a
Cext_24 \$10.x1_net11 VSS 207.474a
Cext_25 \$10.x1_net11 sky130_gnd 278.587a
Cext_26 \$10.x1_net12 \$10.x1_net9 5.01695a
Cext_27 \$10.x1_net12 \$162 2.16695a
Cext_28 \$10.x1_net12 \$73 0.30769a
Cext_29 \$10.x1_net12 cm 623.319a
Cext_30 \$10.x1_net12 VSS 215.201a
Cext_31 \$10.x1_net12 sky130_gnd 324.945a
Cext_32 \$10.x1_net13 \$10.x1_net14 120.266a
Cext_33 \$10.x1_net13 \$10.x1_net15 8.36158a
Cext_34 \$10.x1_net13 \$10.x1_net3 8.36158a
Cext_35 \$10.x1_net13 \$162 2.47315a
Cext_36 \$10.x1_net13 \$73 0.30769a
Cext_37 \$10.x1_net13 cm 376.054a
Cext_38 \$10.x1_net13 VSS 9.20518a
Cext_39 \$10.x1_net13 sky130_gnd 220.72a
Cext_40 \$10.x1_net14 \$10.x1_net15 120.266a
Cext_41 \$10.x1_net14 \$10.x1_net2 3.12896a
Cext_42 \$10.x1_net14 \$10.x1_net5 3.12896a
Cext_43 \$10.x1_net14 \$162 2.44328a
Cext_44 \$10.x1_net14 \$73 0.30769a
Cext_45 \$10.x1_net14 cm 274.266a
Cext_46 \$10.x1_net14 VSS 17.8392a
Cext_47 \$10.x1_net14 sky130_gnd 280.932a
Cext_48 \$10.x1_net15 \$10.x1_net4 8.36158a
Cext_49 \$10.x1_net15 \$162 2.47315a
Cext_50 \$10.x1_net15 \$73 0.30769a
Cext_51 \$10.x1_net15 cm 266.007a
Cext_52 \$10.x1_net15 VSS 120.692a
Cext_53 \$10.x1_net15 sky130_gnd 221.228a
Cext_54 \$10.x1_net2 \$10.x1_net3 119.836a
Cext_55 \$10.x1_net2 \$162 2.44328a
Cext_56 \$10.x1_net2 \$73 0.30769a
Cext_57 \$10.x1_net2 cm 273.149a
Cext_58 \$10.x1_net2 VSS 17.6238a
Cext_59 \$10.x1_net2 sky130_gnd 282.258a
Cext_60 \$10.x1_net3 \$162 2.47315a
Cext_61 \$10.x1_net3 \$73 0.30769a
Cext_62 \$10.x1_net3 cm 264.242a
Cext_63 \$10.x1_net3 VSS 120.261a
Cext_64 \$10.x1_net3 sky130_gnd 220.627a
Cext_65 \$10.x1_net4 \$10.x1_net5 119.156a
Cext_66 \$10.x1_net4 \$10.x1_net6 1.85498a
Cext_67 \$10.x1_net4 \$10.x1_net7 3.85417a
Cext_68 \$10.x1_net4 \$162 2.47315a
Cext_69 \$10.x1_net4 \$73 0.30769a
Cext_70 \$10.x1_net4 cm 377.494a
Cext_71 \$10.x1_net4 VSS 9.54434a
Cext_72 \$10.x1_net4 sky130_gnd 225.295a
Cext_73 \$10.x1_net5 \$10.x1_net6 453.126a
Cext_74 \$10.x1_net5 \$10.x1_net7 0.999238a
Cext_75 \$10.x1_net5 \$10.x1_net8 5.01695a
Cext_76 \$10.x1_net5 \$162 4.61053a
Cext_77 \$10.x1_net5 \$73 0.220828a
Cext_78 \$10.x1_net5 cm 266.494a
Cext_79 \$10.x1_net5 VSS 207.217a
Cext_80 \$10.x1_net5 sky130_gnd 277.472a
Cext_81 \$10.x1_net6 \$10.x1_net7 182.968a
Cext_82 \$10.x1_net6 \$10.x1_net8 0.774573a
Cext_83 \$10.x1_net6 \$10.x1_net9 5.01695a
Cext_84 \$10.x1_net6 \$162 2.16695a
Cext_85 \$10.x1_net6 \$73 0.30769a
Cext_86 \$10.x1_net6 cm 428.564a
Cext_87 \$10.x1_net6 VSS 215.477a
Cext_88 \$10.x1_net6 sky130_gnd 323.136a
Cext_89 \$10.x1_net7 \$10.x1_net8 249.933a
Cext_90 \$10.x1_net7 \$10.x1_net9 172.77a
Cext_91 \$10.x1_net7 \$162 2.47315a
Cext_92 \$10.x1_net7 \$73 0.30769a
Cext_93 \$10.x1_net7 cm 444.502a
Cext_94 \$10.x1_net7 VSS 10.1874a
Cext_95 \$10.x1_net7 sky130_gnd 252.976a
Cext_96 \$10.x1_net8 \$10.x1_net9 285.644a
Cext_97 \$10.x1_net8 \$162 2.44328a
Cext_98 \$10.x1_net8 \$73 0.30769a
Cext_99 \$10.x1_net8 cm 465.777a
Cext_100 \$10.x1_net8 VSS 207.858a
Cext_101 \$10.x1_net8 sky130_gnd 273.418a
Cext_102 \$10.x1_net9 \$162 2.16695a
Cext_103 \$10.x1_net9 \$73 0.30769a
Cext_104 \$10.x1_net9 cm 431.123a
Cext_105 \$10.x1_net9 VSS 214.654a
Cext_106 \$10.x1_net9 sky130_gnd 316.663a
Cext_107 \$109 \$121 1.22081f
Cext_108 \$109 \$16 5.85238a
Cext_109 \$109 \$162 489.969a
Cext_110 \$109 \$177 34.6133f
Cext_111 \$109 \$261 3.42959f
Cext_112 \$109 \$265 3.68914f
Cext_113 \$109 \$266 3.2915f
Cext_114 \$109 \$50 7.65365f
Cext_115 \$109 \$51 6.58705f
Cext_116 \$109 \$73 942.305a
Cext_117 \$109 bias_a 385.019a
Cext_118 \$109 cm 463.488a
Cext_119 \$109 cmc 3.09126a
Cext_120 \$109 IBIAS 31.9656a
Cext_121 \$109 on 5.64459a
Cext_122 \$109 op 12.2638a
Cext_123 \$109 VDD 50.2204f
Cext_124 \$109 VSS 2.3557f
Cext_125 \$109 sky130_gnd 44.8714f
Cext_126 \$121 \$162 19.8007a
Cext_127 \$121 \$177 91.1754a
Cext_128 \$121 \$50 2.35301a
Cext_129 \$121 \$73 2.21518f
Cext_130 \$121 bias_a 10.8001f
Cext_131 \$121 cm 84.2354a
Cext_132 \$121 cmc 2.06947a
Cext_133 \$121 IBIAS 0.145008a
Cext_134 \$121 on 3.45604a
Cext_135 \$121 op 1.79982a
Cext_136 \$121 VDD 368.333a
Cext_137 \$121 VSS 14.3229f
Cext_138 \$121 sky130_gnd 11.0449f
Cext_139 \$16 \$17 19.7632f
Cext_140 \$16 \$18 14.6347f
Cext_141 \$16 \$50 3.98128f
Cext_142 \$16 \$51 2.52388f
Cext_143 \$16 \$73 98.4488a
Cext_144 \$16 bias_a 22.6417f
Cext_145 \$16 cmc 15.0898f
Cext_146 \$16 in 401.744a
Cext_147 \$16 ip 397.557a
Cext_148 \$16 on 86.582a
Cext_149 \$16 op 56.7679a
Cext_150 \$16 VDD 208.033a
Cext_151 \$16 VSS 81.3461f
Cext_152 \$16 sky130_gnd 37.9976f
Cext_153 \$162 \$177 2.82994f
Cext_154 \$162 \$261 1.16679f
Cext_155 \$162 \$265 1.50806f
Cext_156 \$162 \$266 337.755a
Cext_157 \$162 \$73 26.0098f
Cext_158 \$162 bias_a 626.577a
Cext_159 \$162 cm 4.71758f
Cext_160 \$162 cmc 2.17327a
Cext_161 \$162 IBIAS 202.514a
Cext_162 \$162 VDD 4.54758f
Cext_163 \$162 VSS 2.14276f
Cext_164 \$162 sky130_gnd 27.514f
Cext_165 \$17 \$18 12.6121f
Cext_166 \$17 \$73 4.14305f
Cext_167 \$17 bias_a 8.08486f
Cext_168 \$17 cmc 428.767a
Cext_169 \$17 on 13.3543f
Cext_170 \$17 op 13.1015f
Cext_171 \$17 VSS 44.5923f
Cext_172 \$17 sky130_gnd 20.8583f
Cext_173 \$177 \$261 715.577a
Cext_174 \$177 \$265 777.632a
Cext_175 \$177 \$266 963.202a
Cext_176 \$177 \$50 3.95689f
Cext_177 \$177 \$51 1.99828f
Cext_178 \$177 \$73 2.08913f
Cext_179 \$177 bias_a 137.107a
Cext_180 \$177 cm 1.36547f
Cext_181 \$177 cmc 185.218a
Cext_182 \$177 IBIAS 16.7927f
Cext_183 \$177 on 2.13168f
Cext_184 \$177 op 2.92595f
Cext_185 \$177 VDD 36.1538f
Cext_186 \$177 VSS 9.11203f
Cext_187 \$177 sky130_gnd 25.4699f
Cext_188 \$18 \$73 10.003f
Cext_189 \$18 bias_a 16.3878f
Cext_190 \$18 cmc 717.548a
Cext_191 \$18 in 88.439a
Cext_192 \$18 on 6.27042f
Cext_193 \$18 op 11.5422f
Cext_194 \$18 VSS 42.5547f
Cext_195 \$18 sky130_gnd 20.5718f
Cext_196 \$261 \$265 5.78306f
Cext_197 \$261 \$266 4.66627f
Cext_198 \$261 cm 1.64393f
Cext_199 \$261 IBIAS 364.044a
Cext_200 \$261 VDD 10.0431f
Cext_201 \$261 VSS 46.3237a
Cext_202 \$261 sky130_gnd 870.947a
Cext_203 \$265 \$266 1.87291f
Cext_204 \$265 cm 2.32822f
Cext_205 \$265 IBIAS 20.1252a
Cext_206 \$265 VDD 11.6214f
Cext_207 \$265 VSS 11.6681a
Cext_208 \$265 sky130_gnd 699.495a
Cext_209 \$266 cm 1.30978f
Cext_210 \$266 IBIAS 157.228a
Cext_211 \$266 VDD 12.349f
Cext_212 \$266 VSS 26.3048a
Cext_213 \$266 sky130_gnd 2.00951f
Cext_214 \$50 \$51 15.8815f
Cext_215 \$50 \$73 447.492a
Cext_216 \$50 bias_a 141.3a
Cext_217 \$50 cmc 63.0731a
Cext_218 \$50 in 640.269a
Cext_219 \$50 ip 1.34638f
Cext_220 \$50 on 4.29179f
Cext_221 \$50 op 3.24398f
Cext_222 \$50 VDD 28.1879f
Cext_223 \$50 VSS 639.904a
Cext_224 \$50 sky130_gnd 3.94627f
Cext_225 \$51 \$73 126.667a
Cext_226 \$51 bias_a 299.066a
Cext_227 \$51 cmc 52.5562a
Cext_228 \$51 in 348.1a
Cext_229 \$51 ip 780.512a
Cext_230 \$51 on 8.47994f
Cext_231 \$51 op 4.03701f
Cext_232 \$51 VDD 26.4694f
Cext_233 \$51 VSS 448.412a
Cext_234 \$51 sky130_gnd 3.61038f
Cext_235 \$73 bias_a 8.28637f
Cext_236 \$73 cm 748.663a
Cext_237 \$73 cmc 826.892a
Cext_238 \$73 IBIAS 5.32737a
Cext_239 \$73 in 4.49985a
Cext_240 \$73 ip 4.75076a
Cext_241 \$73 on 6.78899f
Cext_242 \$73 op 9.23953f
Cext_243 \$73 VDD 949.811a
Cext_244 \$73 VSS 16.9718f
Cext_245 \$73 sky130_gnd 51.3025f
Cext_246 bias_a cm 1.10282f
Cext_247 bias_a cmc 45.7938f
Cext_248 bias_a in 5.18846a
Cext_249 bias_a ip 4.74765a
Cext_250 bias_a on 67.9894a
Cext_251 bias_a op 61.0895a
Cext_252 cmc on 201.829f
Cext_253 cmc op 201.849f
Cext_254 IBIAS bias_a 4.07219a
Cext_255 IBIAS cm 4.64271a
Cext_256 IBIAS VDD 174.419a
Cext_257 IBIAS VSS 16.8732f
Cext_258 IBIAS sky130_gnd 18.5548f
Cext_259 in ip 2.18843f
Cext_260 in on 78.4439a
Cext_261 in op 48.1657a
Cext_262 ip on 68.7268a
Cext_263 ip op 37.3358a
Cext_264 on op 9.87229f
Cext_265 VDD bias_a 674.533a
Cext_266 VDD cm 2.75299f
Cext_267 VDD cmc 1.40495f
Cext_268 VDD in 2.61881a
Cext_269 VDD ip 2.67429a
Cext_270 VDD on 11.8781f
Cext_271 VDD op 11.7826f
Cext_272 VDD VSS 3.23477f
Cext_273 VDD sky130_gnd 31.959f
Cext_274 VSS bias_a 35.4619f
Cext_275 VSS cm 5.48665f
Cext_276 VSS cmc 38.7663f
Cext_277 VSS in 148.557a
Cext_278 VSS ip 69.6352a
Cext_279 VSS on 8.5399f
Cext_280 VSS op 4.44968f
Cext_281 VSS sky130_gnd 193.146f
Cext_282 sky130_gnd bias_a 97.0175f
Cext_283 sky130_gnd cm 17.5644f
Cext_284 sky130_gnd cmc 66.5096f
Cext_285 sky130_gnd in 2.78778f
Cext_286 sky130_gnd ip 2.01337f
Cext_287 sky130_gnd on 12.8304f
Cext_288 sky130_gnd op 13.8475f
.ENDS iadc_ota_v2_routed
