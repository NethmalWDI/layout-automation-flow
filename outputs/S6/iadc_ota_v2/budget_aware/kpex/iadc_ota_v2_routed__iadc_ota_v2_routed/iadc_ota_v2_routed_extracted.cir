* Extracted by KLayout with SKY130 LVS runset on : 05/11/2026 19:52

.SUBCKT iadc_ota_v2_routed \$11.x1_net1 \$11.x1_net10 \$11.x1_net11
+ \$11.x1_net12 \$11.x1_net13 \$11.x1_net14 \$11.x1_net15 \$11.x1_net2
+ \$11.x1_net3 \$11.x1_net4 \$11.x1_net5 \$11.x1_net6 \$11.x1_net7 \$11.x1_net8
+ \$11.x1_net9 IBIAS VDD VSS bias_a cm cmc in ip on op sky130_gnd
C$1 cmc op sky130_fd_pr__model__cap_mim C=4.608e-14 A=23.04 P=19.2
C$2 cmc op sky130_fd_pr__model__cap_mim C=4.608e-14 A=23.04 P=19.2
C$3 cmc op sky130_fd_pr__model__cap_mim C=4.608e-14 A=23.04 P=19.2
C$4 cmc op sky130_fd_pr__model__cap_mim C=4.608e-14 A=23.04 P=19.2
C$5 cmc on sky130_fd_pr__model__cap_mim C=4.608e-14 A=23.04 P=19.2
C$6 cmc on sky130_fd_pr__model__cap_mim C=4.608e-14 A=23.04 P=19.2
C$7 cmc on sky130_fd_pr__model__cap_mim C=4.608e-14 A=23.04 P=19.2
C$8 cmc on sky130_fd_pr__model__cap_mim C=4.608e-14 A=23.04 P=19.2
M$9 \$168 \$168 \$150 sky130_gnd sky130_fd_pr__nfet_01v8_lvt L=0.6 W=1.4
+ AS=0.406 AD=0.406 PS=3.38 PD=3.38
M$10 \$168 \$168 \$150 sky130_gnd sky130_fd_pr__nfet_01v8_lvt L=0.6 W=1.4
+ AS=0.406 AD=0.406 PS=3.38 PD=3.38
M$11 \$168 \$168 \$150 sky130_gnd sky130_fd_pr__nfet_01v8_lvt L=0.6 W=1.4
+ AS=0.406 AD=0.406 PS=3.38 PD=3.38
M$12 \$168 \$168 \$150 sky130_gnd sky130_fd_pr__nfet_01v8_lvt L=0.6 W=1.4
+ AS=0.406 AD=0.406 PS=3.38 PD=3.38
M$13 \$168 \$168 \$150 sky130_gnd sky130_fd_pr__nfet_01v8_lvt L=0.6 W=1.4
+ AS=0.406 AD=0.406 PS=3.38 PD=3.38
M$14 \$168 \$168 \$150 sky130_gnd sky130_fd_pr__nfet_01v8_lvt L=0.6 W=1.4
+ AS=0.406 AD=0.406 PS=3.38 PD=3.38
M$15 \$168 \$168 \$150 sky130_gnd sky130_fd_pr__nfet_01v8_lvt L=0.6 W=1.4
+ AS=0.406 AD=0.406 PS=3.38 PD=3.38
M$16 \$168 \$168 \$150 sky130_gnd sky130_fd_pr__nfet_01v8_lvt L=0.6 W=1.4
+ AS=0.406 AD=0.406 PS=3.38 PD=3.38
M$17 \$168 \$168 \$150 sky130_gnd sky130_fd_pr__nfet_01v8_lvt L=0.6 W=1.4
+ AS=0.406 AD=0.406 PS=3.38 PD=3.38
M$18 \$168 \$168 \$150 sky130_gnd sky130_fd_pr__nfet_01v8_lvt L=0.6 W=1.4
+ AS=0.406 AD=0.406 PS=3.38 PD=3.38
M$19 \$168 \$168 \$150 sky130_gnd sky130_fd_pr__nfet_01v8_lvt L=0.6 W=1.4
+ AS=0.406 AD=0.406 PS=3.38 PD=3.38
M$20 \$168 \$168 \$150 sky130_gnd sky130_fd_pr__nfet_01v8_lvt L=0.6 W=1.4
+ AS=0.406 AD=0.406 PS=3.38 PD=3.38
M$21 \$168 \$168 \$150 sky130_gnd sky130_fd_pr__nfet_01v8_lvt L=0.6 W=1.4
+ AS=0.406 AD=0.406 PS=3.38 PD=3.38
M$22 \$168 \$168 \$150 sky130_gnd sky130_fd_pr__nfet_01v8_lvt L=0.6 W=1.4
+ AS=0.406 AD=0.406 PS=3.38 PD=3.38
M$23 \$168 \$168 \$150 sky130_gnd sky130_fd_pr__nfet_01v8_lvt L=0.6 W=1.4
+ AS=0.406 AD=0.406 PS=3.38 PD=3.38
M$24 \$168 \$168 \$150 sky130_gnd sky130_fd_pr__nfet_01v8_lvt L=0.6 W=1.4
+ AS=0.406 AD=0.406 PS=3.38 PD=3.38
M$25 \$168 \$168 \$150 sky130_gnd sky130_fd_pr__nfet_01v8_lvt L=0.6 W=1.4
+ AS=0.406 AD=0.406 PS=3.38 PD=3.38
M$26 \$168 \$168 \$150 sky130_gnd sky130_fd_pr__nfet_01v8_lvt L=0.6 W=1.4
+ AS=0.406 AD=0.406 PS=3.38 PD=3.38
M$27 \$168 \$168 \$150 sky130_gnd sky130_fd_pr__nfet_01v8_lvt L=0.6 W=1.4
+ AS=0.406 AD=0.406 PS=3.38 PD=3.38
M$28 \$168 \$168 \$150 sky130_gnd sky130_fd_pr__nfet_01v8_lvt L=0.6 W=1.4
+ AS=0.406 AD=0.406 PS=3.38 PD=3.38
M$29 \$168 \$168 \$150 sky130_gnd sky130_fd_pr__nfet_01v8_lvt L=0.6 W=1.4
+ AS=0.406 AD=0.406 PS=3.38 PD=3.38
M$30 \$168 \$168 \$150 sky130_gnd sky130_fd_pr__nfet_01v8_lvt L=0.6 W=1.4
+ AS=0.406 AD=0.406 PS=3.38 PD=3.38
M$31 \$168 \$168 \$150 sky130_gnd sky130_fd_pr__nfet_01v8_lvt L=0.6 W=1.4
+ AS=0.406 AD=0.406 PS=3.38 PD=3.38
M$32 \$168 \$168 \$150 sky130_gnd sky130_fd_pr__nfet_01v8_lvt L=0.6 W=1.4
+ AS=0.406 AD=0.406 PS=3.38 PD=3.38
M$33 \$168 \$168 \$150 sky130_gnd sky130_fd_pr__nfet_01v8_lvt L=0.6 W=1.4
+ AS=0.406 AD=0.406 PS=3.38 PD=3.38
M$34 \$168 \$168 \$150 sky130_gnd sky130_fd_pr__nfet_01v8_lvt L=0.6 W=1.4
+ AS=0.406 AD=0.406 PS=3.38 PD=3.38
M$35 \$168 \$168 \$150 sky130_gnd sky130_fd_pr__nfet_01v8_lvt L=0.6 W=1.4
+ AS=0.406 AD=0.406 PS=3.38 PD=3.38
M$36 \$168 \$168 \$150 sky130_gnd sky130_fd_pr__nfet_01v8_lvt L=0.6 W=1.4
+ AS=0.406 AD=0.406 PS=3.38 PD=3.38
M$37 \$168 \$168 \$150 sky130_gnd sky130_fd_pr__nfet_01v8_lvt L=0.6 W=1.4
+ AS=0.406 AD=0.406 PS=3.38 PD=3.38
M$38 \$168 \$168 \$150 sky130_gnd sky130_fd_pr__nfet_01v8_lvt L=0.6 W=1.4
+ AS=0.406 AD=0.406 PS=3.38 PD=3.38
M$39 \$168 \$168 \$150 sky130_gnd sky130_fd_pr__nfet_01v8_lvt L=0.6 W=1.4
+ AS=0.406 AD=0.406 PS=3.38 PD=3.38
M$40 \$168 \$168 \$150 sky130_gnd sky130_fd_pr__nfet_01v8_lvt L=0.6 W=1.4
+ AS=0.406 AD=0.406 PS=3.38 PD=3.38
M$41 \$168 \$168 \$150 sky130_gnd sky130_fd_pr__nfet_01v8_lvt L=0.6 W=1.4
+ AS=0.406 AD=0.406 PS=3.38 PD=3.38
M$42 \$168 \$168 \$150 sky130_gnd sky130_fd_pr__nfet_01v8_lvt L=0.6 W=1.4
+ AS=0.406 AD=0.406 PS=3.38 PD=3.38
M$43 \$168 \$168 \$150 sky130_gnd sky130_fd_pr__nfet_01v8_lvt L=0.6 W=1.4
+ AS=0.406 AD=0.406 PS=3.38 PD=3.38
M$44 \$168 \$168 \$150 sky130_gnd sky130_fd_pr__nfet_01v8_lvt L=0.6 W=1.4
+ AS=0.406 AD=0.406 PS=3.38 PD=3.38
M$45 \$168 \$168 \$150 sky130_gnd sky130_fd_pr__nfet_01v8_lvt L=0.6 W=1.4
+ AS=0.406 AD=0.406 PS=3.38 PD=3.38
M$46 \$168 \$168 \$150 sky130_gnd sky130_fd_pr__nfet_01v8_lvt L=0.6 W=1.4
+ AS=0.406 AD=0.406 PS=3.38 PD=3.38
M$47 \$168 \$168 \$150 sky130_gnd sky130_fd_pr__nfet_01v8_lvt L=0.6 W=1.4
+ AS=0.406 AD=0.406 PS=3.38 PD=3.38
M$48 \$168 \$168 \$150 sky130_gnd sky130_fd_pr__nfet_01v8_lvt L=0.6 W=1.4
+ AS=0.406 AD=0.406 PS=3.38 PD=3.38
M$49 \$168 \$168 \$150 sky130_gnd sky130_fd_pr__nfet_01v8_lvt L=0.6 W=1.4
+ AS=0.406 AD=0.406 PS=3.38 PD=3.38
M$50 \$168 \$168 \$150 sky130_gnd sky130_fd_pr__nfet_01v8_lvt L=0.6 W=1.4
+ AS=0.406 AD=0.406 PS=3.38 PD=3.38
M$51 \$168 \$168 \$150 sky130_gnd sky130_fd_pr__nfet_01v8_lvt L=0.6 W=1.4
+ AS=0.406 AD=0.406 PS=3.38 PD=3.38
M$52 \$168 \$168 \$150 sky130_gnd sky130_fd_pr__nfet_01v8_lvt L=0.6 W=1.4
+ AS=0.406 AD=0.406 PS=3.38 PD=3.38
M$53 \$168 \$168 \$150 sky130_gnd sky130_fd_pr__nfet_01v8_lvt L=0.6 W=1.4
+ AS=0.406 AD=0.406 PS=3.38 PD=3.38
M$54 \$168 \$168 \$150 sky130_gnd sky130_fd_pr__nfet_01v8_lvt L=0.6 W=1.4
+ AS=0.406 AD=0.406 PS=3.38 PD=3.38
M$55 \$168 \$168 \$150 sky130_gnd sky130_fd_pr__nfet_01v8_lvt L=0.6 W=1.4
+ AS=0.406 AD=0.406 PS=3.38 PD=3.38
M$56 \$168 \$168 \$150 sky130_gnd sky130_fd_pr__nfet_01v8_lvt L=0.6 W=1.4
+ AS=0.406 AD=0.406 PS=3.38 PD=3.38
M$57 \$168 \$168 \$150 sky130_gnd sky130_fd_pr__nfet_01v8_lvt L=0.6 W=1.4
+ AS=0.406 AD=0.406 PS=3.38 PD=3.38
M$58 \$168 \$168 \$150 sky130_gnd sky130_fd_pr__nfet_01v8_lvt L=0.6 W=1.4
+ AS=0.406 AD=0.406 PS=3.38 PD=3.38
M$59 \$168 \$168 \$150 sky130_gnd sky130_fd_pr__nfet_01v8_lvt L=0.6 W=1.4
+ AS=0.406 AD=0.406 PS=3.38 PD=3.38
M$60 \$168 \$168 \$150 sky130_gnd sky130_fd_pr__nfet_01v8_lvt L=0.6 W=1.4
+ AS=0.406 AD=0.406 PS=3.38 PD=3.38
M$61 \$168 \$168 \$150 sky130_gnd sky130_fd_pr__nfet_01v8_lvt L=0.6 W=1.4
+ AS=0.406 AD=0.406 PS=3.38 PD=3.38
M$62 \$168 \$168 \$150 sky130_gnd sky130_fd_pr__nfet_01v8_lvt L=0.6 W=1.4
+ AS=0.406 AD=0.406 PS=3.38 PD=3.38
M$63 \$168 \$168 \$150 sky130_gnd sky130_fd_pr__nfet_01v8_lvt L=0.6 W=1.4
+ AS=0.406 AD=0.406 PS=3.38 PD=3.38
M$64 \$168 \$168 \$150 sky130_gnd sky130_fd_pr__nfet_01v8_lvt L=0.6 W=1.4
+ AS=0.406 AD=0.406 PS=3.38 PD=3.38
M$65 \$168 \$168 \$168 sky130_gnd sky130_fd_pr__nfet_01v8_lvt L=0.6 W=1.4
+ AS=0.406 AD=0.406 PS=3.38 PD=3.38
M$66 \$168 \$168 \$168 sky130_gnd sky130_fd_pr__nfet_01v8_lvt L=0.6 W=1.4
+ AS=0.406 AD=0.406 PS=3.38 PD=3.38
M$67 \$168 \$168 \$168 sky130_gnd sky130_fd_pr__nfet_01v8_lvt L=0.6 W=1.4
+ AS=0.406 AD=0.406 PS=3.38 PD=3.38
M$68 \$168 \$168 \$168 sky130_gnd sky130_fd_pr__nfet_01v8_lvt L=0.6 W=1.4
+ AS=0.406 AD=0.406 PS=3.38 PD=3.38
M$69 \$168 \$168 \$168 sky130_gnd sky130_fd_pr__nfet_01v8_lvt L=0.6 W=1.4
+ AS=0.406 AD=0.406 PS=3.38 PD=3.38
M$70 \$168 \$168 \$168 sky130_gnd sky130_fd_pr__nfet_01v8_lvt L=0.6 W=1.4
+ AS=0.406 AD=0.406 PS=3.38 PD=3.38
M$71 \$168 \$168 \$168 sky130_gnd sky130_fd_pr__nfet_01v8_lvt L=0.6 W=1.4
+ AS=0.406 AD=0.406 PS=3.38 PD=3.38
M$72 \$168 \$168 \$168 sky130_gnd sky130_fd_pr__nfet_01v8_lvt L=0.6 W=1.4
+ AS=0.406 AD=0.406 PS=3.38 PD=3.38
M$73 \$150 \$150 \$150 sky130_gnd sky130_fd_pr__nfet_01v8_lvt L=0.6 W=1.4
+ AS=0.406 AD=0.406 PS=3.38 PD=3.38
M$74 \$150 \$150 \$150 sky130_gnd sky130_fd_pr__nfet_01v8_lvt L=0.6 W=1.4
+ AS=0.406 AD=0.406 PS=3.38 PD=3.38
M$75 \$150 \$150 \$150 sky130_gnd sky130_fd_pr__nfet_01v8_lvt L=0.6 W=1.4
+ AS=0.406 AD=0.406 PS=3.38 PD=3.38
M$76 \$150 \$150 \$150 sky130_gnd sky130_fd_pr__nfet_01v8_lvt L=0.6 W=1.4
+ AS=0.406 AD=0.406 PS=3.38 PD=3.38
M$77 \$150 \$150 \$150 sky130_gnd sky130_fd_pr__nfet_01v8_lvt L=0.6 W=1.4
+ AS=0.406 AD=0.406 PS=3.38 PD=3.38
M$78 \$150 \$150 \$150 sky130_gnd sky130_fd_pr__nfet_01v8_lvt L=0.6 W=1.4
+ AS=0.406 AD=0.406 PS=3.38 PD=3.38
M$79 \$150 \$150 \$150 sky130_gnd sky130_fd_pr__nfet_01v8_lvt L=0.6 W=1.4
+ AS=0.406 AD=0.406 PS=3.38 PD=3.38
M$80 \$150 \$150 \$150 sky130_gnd sky130_fd_pr__nfet_01v8_lvt L=0.6 W=1.4
+ AS=0.406 AD=0.406 PS=3.38 PD=3.38
M$81 \$203 in \$157 sky130_gnd sky130_fd_pr__nfet_01v8_lvt L=0.2 W=1.2 AS=0.348
+ AD=0.348 PS=2.98 PD=2.98
M$82 \$203 in \$157 sky130_gnd sky130_fd_pr__nfet_01v8_lvt L=0.2 W=1.2 AS=0.348
+ AD=0.348 PS=2.98 PD=2.98
M$83 \$203 in \$157 sky130_gnd sky130_fd_pr__nfet_01v8_lvt L=0.2 W=1.2 AS=0.348
+ AD=0.348 PS=2.98 PD=2.98
M$84 \$203 in \$157 sky130_gnd sky130_fd_pr__nfet_01v8_lvt L=0.2 W=1.2 AS=0.348
+ AD=0.348 PS=2.98 PD=2.98
M$85 \$203 in \$157 sky130_gnd sky130_fd_pr__nfet_01v8_lvt L=0.2 W=1.2 AS=0.348
+ AD=0.348 PS=2.98 PD=2.98
M$86 \$203 in \$157 sky130_gnd sky130_fd_pr__nfet_01v8_lvt L=0.2 W=1.2 AS=0.348
+ AD=0.348 PS=2.98 PD=2.98
M$87 \$202 ip \$157 sky130_gnd sky130_fd_pr__nfet_01v8_lvt L=0.2 W=1.2 AS=0.348
+ AD=0.348 PS=2.98 PD=2.98
M$88 \$202 ip \$157 sky130_gnd sky130_fd_pr__nfet_01v8_lvt L=0.2 W=1.2 AS=0.348
+ AD=0.348 PS=2.98 PD=2.98
M$89 \$202 ip \$157 sky130_gnd sky130_fd_pr__nfet_01v8_lvt L=0.2 W=1.2 AS=0.348
+ AD=0.348 PS=2.98 PD=2.98
M$90 \$202 ip \$157 sky130_gnd sky130_fd_pr__nfet_01v8_lvt L=0.2 W=1.2 AS=0.348
+ AD=0.348 PS=2.98 PD=2.98
M$91 \$202 ip \$157 sky130_gnd sky130_fd_pr__nfet_01v8_lvt L=0.2 W=1.2 AS=0.348
+ AD=0.348 PS=2.98 PD=2.98
M$92 \$202 ip \$157 sky130_gnd sky130_fd_pr__nfet_01v8_lvt L=0.2 W=1.2 AS=0.348
+ AD=0.348 PS=2.98 PD=2.98
M$93 \$203 \$203 \$203 sky130_gnd sky130_fd_pr__nfet_01v8_lvt L=0.2 W=1.2
+ AS=0.348 AD=0.348 PS=2.98 PD=2.98
M$94 \$203 \$203 \$203 sky130_gnd sky130_fd_pr__nfet_01v8_lvt L=0.2 W=1.2
+ AS=0.348 AD=0.348 PS=2.98 PD=2.98
M$95 \$202 \$202 \$202 sky130_gnd sky130_fd_pr__nfet_01v8_lvt L=0.2 W=1.2
+ AS=0.348 AD=0.348 PS=2.98 PD=2.98
M$96 \$202 \$202 \$202 sky130_gnd sky130_fd_pr__nfet_01v8_lvt L=0.2 W=1.2
+ AS=0.348 AD=0.348 PS=2.98 PD=2.98
M$97 on VDD VDD VDD sky130_fd_pr__pfet_01v8 L=0.6 W=1.4 AS=0.406 AD=0.406
+ PS=3.38 PD=3.38
M$98 on VDD VDD VDD sky130_fd_pr__pfet_01v8 L=0.6 W=1.4 AS=0.406 AD=0.406
+ PS=3.38 PD=3.38
M$99 op VDD VDD VDD sky130_fd_pr__pfet_01v8 L=0.6 W=1.4 AS=0.406 AD=0.406
+ PS=3.38 PD=3.38
M$100 op VDD VDD VDD sky130_fd_pr__pfet_01v8 L=0.6 W=1.4 AS=0.406 AD=0.406
+ PS=3.38 PD=3.38
M$101 on VDD VDD VDD sky130_fd_pr__pfet_01v8 L=0.6 W=1.4 AS=0.406 AD=0.406
+ PS=3.38 PD=3.38
M$102 on VDD VDD VDD sky130_fd_pr__pfet_01v8 L=0.6 W=1.4 AS=0.406 AD=0.406
+ PS=3.38 PD=3.38
M$103 op VDD VDD VDD sky130_fd_pr__pfet_01v8 L=0.6 W=1.4 AS=0.406 AD=0.406
+ PS=3.38 PD=3.38
M$104 op VDD VDD VDD sky130_fd_pr__pfet_01v8 L=0.6 W=1.4 AS=0.406 AD=0.406
+ PS=3.38 PD=3.38
M$105 \$278 \$168 VDD VDD sky130_fd_pr__pfet_01v8_lvt L=0.6 W=1.4 AS=0.406
+ AD=0.406 PS=3.38 PD=3.38
M$106 \$279 \$168 VDD VDD sky130_fd_pr__pfet_01v8_lvt L=0.6 W=1.4 AS=0.406
+ AD=0.406 PS=3.38 PD=3.38
M$107 \$279 \$168 VDD VDD sky130_fd_pr__pfet_01v8_lvt L=0.6 W=1.4 AS=0.406
+ AD=0.406 PS=3.38 PD=3.38
M$108 \$271 \$168 VDD VDD sky130_fd_pr__pfet_01v8_lvt L=0.6 W=1.4 AS=0.406
+ AD=0.406 PS=3.38 PD=3.38
M$109 \$271 \$168 VDD VDD sky130_fd_pr__pfet_01v8_lvt L=0.6 W=1.4 AS=0.406
+ AD=0.406 PS=3.38 PD=3.38
M$110 \$279 \$168 VDD VDD sky130_fd_pr__pfet_01v8_lvt L=0.6 W=1.4 AS=0.406
+ AD=0.406 PS=3.38 PD=3.38
M$111 \$271 \$168 VDD VDD sky130_fd_pr__pfet_01v8_lvt L=0.6 W=1.4 AS=0.406
+ AD=0.406 PS=3.38 PD=3.38
M$112 \$278 \$168 VDD VDD sky130_fd_pr__pfet_01v8_lvt L=0.6 W=1.4 AS=0.406
+ AD=0.406 PS=3.38 PD=3.38
M$113 \$278 \$168 VDD VDD sky130_fd_pr__pfet_01v8_lvt L=0.6 W=1.4 AS=0.406
+ AD=0.406 PS=3.38 PD=3.38
M$114 \$271 \$168 VDD VDD sky130_fd_pr__pfet_01v8_lvt L=0.6 W=1.4 AS=0.406
+ AD=0.406 PS=3.38 PD=3.38
M$115 \$278 \$168 VDD VDD sky130_fd_pr__pfet_01v8_lvt L=0.6 W=1.4 AS=0.406
+ AD=0.406 PS=3.38 PD=3.38
M$116 \$271 \$168 VDD VDD sky130_fd_pr__pfet_01v8_lvt L=0.6 W=1.4 AS=0.406
+ AD=0.406 PS=3.38 PD=3.38
M$117 \$279 \$168 VDD VDD sky130_fd_pr__pfet_01v8_lvt L=0.6 W=1.4 AS=0.406
+ AD=0.406 PS=3.38 PD=3.38
M$118 \$279 \$168 VDD VDD sky130_fd_pr__pfet_01v8_lvt L=0.6 W=1.4 AS=0.406
+ AD=0.406 PS=3.38 PD=3.38
M$119 \$271 \$168 VDD VDD sky130_fd_pr__pfet_01v8_lvt L=0.6 W=1.4 AS=0.406
+ AD=0.406 PS=3.38 PD=3.38
M$120 \$278 \$168 VDD VDD sky130_fd_pr__pfet_01v8_lvt L=0.6 W=1.4 AS=0.406
+ AD=0.406 PS=3.38 PD=3.38
M$121 \$279 \$168 VDD VDD sky130_fd_pr__pfet_01v8_lvt L=0.6 W=1.4 AS=0.406
+ AD=0.406 PS=3.38 PD=3.38
M$122 \$278 \$168 VDD VDD sky130_fd_pr__pfet_01v8_lvt L=0.6 W=1.4 AS=0.406
+ AD=0.406 PS=3.38 PD=3.38
M$123 \$202 \$168 VDD VDD sky130_fd_pr__pfet_01v8_lvt L=0.6 W=1.4 AS=0.406
+ AD=0.406 PS=3.38 PD=3.38
M$124 \$202 \$168 VDD VDD sky130_fd_pr__pfet_01v8_lvt L=0.6 W=1.4 AS=0.406
+ AD=0.406 PS=3.38 PD=3.38
M$125 \$203 \$168 VDD VDD sky130_fd_pr__pfet_01v8_lvt L=0.6 W=1.4 AS=0.406
+ AD=0.406 PS=3.38 PD=3.38
M$126 \$202 \$168 VDD VDD sky130_fd_pr__pfet_01v8_lvt L=0.6 W=1.4 AS=0.406
+ AD=0.406 PS=3.38 PD=3.38
M$127 \$203 \$168 VDD VDD sky130_fd_pr__pfet_01v8_lvt L=0.6 W=1.4 AS=0.406
+ AD=0.406 PS=3.38 PD=3.38
M$128 \$203 \$168 VDD VDD sky130_fd_pr__pfet_01v8_lvt L=0.6 W=1.4 AS=0.406
+ AD=0.406 PS=3.38 PD=3.38
M$129 \$202 \$168 VDD VDD sky130_fd_pr__pfet_01v8_lvt L=0.6 W=1.4 AS=0.406
+ AD=0.406 PS=3.38 PD=3.38
M$130 \$203 \$168 VDD VDD sky130_fd_pr__pfet_01v8_lvt L=0.6 W=1.4 AS=0.406
+ AD=0.406 PS=3.38 PD=3.38
M$131 \$202 \$168 VDD VDD sky130_fd_pr__pfet_01v8_lvt L=0.6 W=1.4 AS=0.406
+ AD=0.406 PS=3.38 PD=3.38
M$132 \$203 \$168 VDD VDD sky130_fd_pr__pfet_01v8_lvt L=0.6 W=1.4 AS=0.406
+ AD=0.406 PS=3.38 PD=3.38
M$133 \$202 \$168 VDD VDD sky130_fd_pr__pfet_01v8_lvt L=0.6 W=1.4 AS=0.406
+ AD=0.406 PS=3.38 PD=3.38
M$134 \$203 \$168 VDD VDD sky130_fd_pr__pfet_01v8_lvt L=0.6 W=1.4 AS=0.406
+ AD=0.406 PS=3.38 PD=3.38
M$135 \$202 \$168 VDD VDD sky130_fd_pr__pfet_01v8_lvt L=0.6 W=1.4 AS=0.406
+ AD=0.406 PS=3.38 PD=3.38
M$136 \$202 \$168 VDD VDD sky130_fd_pr__pfet_01v8_lvt L=0.6 W=1.4 AS=0.406
+ AD=0.406 PS=3.38 PD=3.38
M$137 \$203 \$168 VDD VDD sky130_fd_pr__pfet_01v8_lvt L=0.6 W=1.4 AS=0.406
+ AD=0.406 PS=3.38 PD=3.38
M$138 \$202 \$168 VDD VDD sky130_fd_pr__pfet_01v8_lvt L=0.6 W=1.4 AS=0.406
+ AD=0.406 PS=3.38 PD=3.38
M$139 \$202 \$168 VDD VDD sky130_fd_pr__pfet_01v8_lvt L=0.6 W=1.4 AS=0.406
+ AD=0.406 PS=3.38 PD=3.38
M$140 \$203 \$168 VDD VDD sky130_fd_pr__pfet_01v8_lvt L=0.6 W=1.4 AS=0.406
+ AD=0.406 PS=3.38 PD=3.38
M$141 \$202 \$168 VDD VDD sky130_fd_pr__pfet_01v8_lvt L=0.6 W=1.4 AS=0.406
+ AD=0.406 PS=3.38 PD=3.38
M$142 \$203 \$168 VDD VDD sky130_fd_pr__pfet_01v8_lvt L=0.6 W=1.4 AS=0.406
+ AD=0.406 PS=3.38 PD=3.38
M$143 \$203 \$168 VDD VDD sky130_fd_pr__pfet_01v8_lvt L=0.6 W=1.4 AS=0.406
+ AD=0.406 PS=3.38 PD=3.38
M$144 \$203 \$168 VDD VDD sky130_fd_pr__pfet_01v8_lvt L=0.6 W=1.4 AS=0.406
+ AD=0.406 PS=3.38 PD=3.38
M$145 \$203 \$168 VDD VDD sky130_fd_pr__pfet_01v8_lvt L=0.6 W=1.4 AS=0.406
+ AD=0.406 PS=3.38 PD=3.38
M$146 \$202 \$168 VDD VDD sky130_fd_pr__pfet_01v8_lvt L=0.6 W=1.4 AS=0.406
+ AD=0.406 PS=3.38 PD=3.38
M$147 \$202 \$168 VDD VDD sky130_fd_pr__pfet_01v8_lvt L=0.6 W=1.4 AS=0.406
+ AD=0.406 PS=3.38 PD=3.38
M$148 \$203 \$168 VDD VDD sky130_fd_pr__pfet_01v8_lvt L=0.6 W=1.4 AS=0.406
+ AD=0.406 PS=3.38 PD=3.38
M$149 \$203 \$168 VDD VDD sky130_fd_pr__pfet_01v8_lvt L=0.6 W=1.4 AS=0.406
+ AD=0.406 PS=3.38 PD=3.38
M$150 \$203 \$168 VDD VDD sky130_fd_pr__pfet_01v8_lvt L=0.6 W=1.4 AS=0.406
+ AD=0.406 PS=3.38 PD=3.38
M$151 \$202 \$168 VDD VDD sky130_fd_pr__pfet_01v8_lvt L=0.6 W=1.4 AS=0.406
+ AD=0.406 PS=3.38 PD=3.38
M$152 \$203 \$168 VDD VDD sky130_fd_pr__pfet_01v8_lvt L=0.6 W=1.4 AS=0.406
+ AD=0.406 PS=3.38 PD=3.38
M$153 \$202 \$168 VDD VDD sky130_fd_pr__pfet_01v8_lvt L=0.6 W=1.4 AS=0.406
+ AD=0.406 PS=3.38 PD=3.38
M$154 \$202 \$168 VDD VDD sky130_fd_pr__pfet_01v8_lvt L=0.6 W=1.4 AS=0.406
+ AD=0.406 PS=3.38 PD=3.38
M$155 \$203 \$168 VDD VDD sky130_fd_pr__pfet_01v8_lvt L=0.6 W=1.4 AS=0.406
+ AD=0.406 PS=3.38 PD=3.38
M$156 \$202 \$168 VDD VDD sky130_fd_pr__pfet_01v8_lvt L=0.6 W=1.4 AS=0.406
+ AD=0.406 PS=3.38 PD=3.38
M$157 \$203 \$168 VDD VDD sky130_fd_pr__pfet_01v8_lvt L=0.6 W=1.4 AS=0.406
+ AD=0.406 PS=3.38 PD=3.38
M$158 \$202 \$168 VDD VDD sky130_fd_pr__pfet_01v8_lvt L=0.6 W=1.4 AS=0.406
+ AD=0.406 PS=3.38 PD=3.38
M$159 \$203 \$168 VDD VDD sky130_fd_pr__pfet_01v8_lvt L=0.6 W=1.4 AS=0.406
+ AD=0.406 PS=3.38 PD=3.38
M$160 \$203 \$168 VDD VDD sky130_fd_pr__pfet_01v8_lvt L=0.6 W=1.4 AS=0.406
+ AD=0.406 PS=3.38 PD=3.38
M$161 \$202 \$168 VDD VDD sky130_fd_pr__pfet_01v8_lvt L=0.6 W=1.4 AS=0.406
+ AD=0.406 PS=3.38 PD=3.38
M$162 \$203 \$168 VDD VDD sky130_fd_pr__pfet_01v8_lvt L=0.6 W=1.4 AS=0.406
+ AD=0.406 PS=3.38 PD=3.38
M$163 \$202 \$168 VDD VDD sky130_fd_pr__pfet_01v8_lvt L=0.6 W=1.4 AS=0.406
+ AD=0.406 PS=3.38 PD=3.38
M$164 \$202 \$168 VDD VDD sky130_fd_pr__pfet_01v8_lvt L=0.6 W=1.4 AS=0.406
+ AD=0.406 PS=3.38 PD=3.38
M$165 \$203 \$168 VDD VDD sky130_fd_pr__pfet_01v8_lvt L=0.6 W=1.4 AS=0.406
+ AD=0.406 PS=3.38 PD=3.38
M$166 \$202 \$168 VDD VDD sky130_fd_pr__pfet_01v8_lvt L=0.6 W=1.4 AS=0.406
+ AD=0.406 PS=3.38 PD=3.38
M$167 \$203 \$168 VDD VDD sky130_fd_pr__pfet_01v8_lvt L=0.6 W=1.4 AS=0.406
+ AD=0.406 PS=3.38 PD=3.38
M$168 \$202 \$168 VDD VDD sky130_fd_pr__pfet_01v8_lvt L=0.6 W=1.4 AS=0.406
+ AD=0.406 PS=3.38 PD=3.38
M$169 \$203 \$168 VDD VDD sky130_fd_pr__pfet_01v8_lvt L=0.6 W=1.4 AS=0.406
+ AD=0.406 PS=3.38 PD=3.38
M$170 \$202 \$168 VDD VDD sky130_fd_pr__pfet_01v8_lvt L=0.6 W=1.4 AS=0.406
+ AD=0.406 PS=3.38 PD=3.38
M$171 \$279 VDD VDD VDD sky130_fd_pr__pfet_01v8 L=0.6 W=1.4 AS=0.406 AD=0.406
+ PS=3.38 PD=3.38
M$172 \$278 \$278 \$278 VDD sky130_fd_pr__pfet_01v8 L=0.6 W=1.4 AS=0.406
+ AD=0.406 PS=3.38 PD=3.38
M$173 \$278 \$278 \$278 VDD sky130_fd_pr__pfet_01v8 L=0.6 W=1.4 AS=0.406
+ AD=0.406 PS=3.38 PD=3.38
M$174 \$271 \$271 \$271 VDD sky130_fd_pr__pfet_01v8 L=0.6 W=1.4 AS=0.406
+ AD=0.406 PS=3.38 PD=3.38
M$175 \$271 \$271 \$271 VDD sky130_fd_pr__pfet_01v8 L=0.6 W=1.4 AS=0.406
+ AD=0.406 PS=3.38 PD=3.38
M$176 \$279 VDD VDD VDD sky130_fd_pr__pfet_01v8 L=0.6 W=1.4 AS=0.406 AD=0.406
+ PS=3.38 PD=3.38
M$177 \$45 VDD VDD VDD sky130_fd_pr__pfet_01v8 L=0.6 W=1.4 AS=0.406 AD=0.406
+ PS=3.38 PD=3.38
M$178 \$168 VDD VDD VDD sky130_fd_pr__pfet_01v8 L=0.6 W=1.4 AS=0.406 AD=0.406
+ PS=3.38 PD=3.38
M$179 cm VDD VDD VDD sky130_fd_pr__pfet_01v8 L=0.6 W=1.4 AS=0.406 AD=0.406
+ PS=3.38 PD=3.38
M$180 \$45 VDD VDD VDD sky130_fd_pr__pfet_01v8 L=0.6 W=1.4 AS=0.406 AD=0.406
+ PS=3.38 PD=3.38
M$181 \$168 VDD VDD VDD sky130_fd_pr__pfet_01v8 L=0.6 W=1.4 AS=0.406 AD=0.406
+ PS=3.38 PD=3.38
M$182 cm VDD VDD VDD sky130_fd_pr__pfet_01v8 L=0.6 W=1.4 AS=0.406 AD=0.406
+ PS=3.38 PD=3.38
M$183 \$203 VDD VDD VDD sky130_fd_pr__pfet_01v8 L=0.6 W=1.4 AS=0.406 AD=0.406
+ PS=3.38 PD=3.38
M$184 \$202 VDD VDD VDD sky130_fd_pr__pfet_01v8 L=0.6 W=1.4 AS=0.406 AD=0.406
+ PS=3.38 PD=3.38
M$185 \$202 VDD VDD VDD sky130_fd_pr__pfet_01v8 L=0.6 W=1.4 AS=0.406 AD=0.406
+ PS=3.38 PD=3.38
M$186 \$203 VDD VDD VDD sky130_fd_pr__pfet_01v8 L=0.6 W=1.4 AS=0.406 AD=0.406
+ PS=3.38 PD=3.38
M$187 \$203 \$203 \$203 VDD sky130_fd_pr__pfet_01v8 L=0.6 W=1.4 AS=0.406
+ AD=0.406 PS=3.38 PD=3.38
M$188 \$202 \$202 \$202 VDD sky130_fd_pr__pfet_01v8 L=0.6 W=1.4 AS=0.406
+ AD=0.406 PS=3.38 PD=3.38
M$189 \$202 \$202 \$202 VDD sky130_fd_pr__pfet_01v8 L=0.6 W=1.4 AS=0.406
+ AD=0.406 PS=3.38 PD=3.38
M$190 \$203 \$203 \$203 VDD sky130_fd_pr__pfet_01v8 L=0.6 W=1.4 AS=0.406
+ AD=0.406 PS=3.38 PD=3.38
M$191 \$279 \$279 \$279 VDD sky130_fd_pr__pfet_01v8_lvt L=0.6 W=1.4 AS=0.406
+ AD=0.406 PS=3.38 PD=3.38
M$192 \$278 \$278 \$278 VDD sky130_fd_pr__pfet_01v8_lvt L=0.6 W=1.4 AS=0.406
+ AD=0.406 PS=3.38 PD=3.38
M$193 \$278 \$278 \$278 VDD sky130_fd_pr__pfet_01v8_lvt L=0.6 W=1.4 AS=0.406
+ AD=0.406 PS=3.38 PD=3.38
M$194 \$271 \$271 \$271 VDD sky130_fd_pr__pfet_01v8_lvt L=0.6 W=1.4 AS=0.406
+ AD=0.406 PS=3.38 PD=3.38
M$195 \$271 \$271 \$271 VDD sky130_fd_pr__pfet_01v8_lvt L=0.6 W=1.4 AS=0.406
+ AD=0.406 PS=3.38 PD=3.38
M$196 \$279 \$279 \$279 VDD sky130_fd_pr__pfet_01v8_lvt L=0.6 W=1.4 AS=0.406
+ AD=0.406 PS=3.38 PD=3.38
M$197 VDD VDD VDD VDD sky130_fd_pr__pfet_01v8_lvt L=0.6 W=1.4 AS=0.406 AD=0.406
+ PS=3.38 PD=3.38
M$198 VDD VDD VDD VDD sky130_fd_pr__pfet_01v8_lvt L=0.6 W=1.4 AS=0.406 AD=0.406
+ PS=3.38 PD=3.38
M$199 VDD VDD VDD VDD sky130_fd_pr__pfet_01v8_lvt L=0.6 W=1.4 AS=0.406 AD=0.406
+ PS=3.38 PD=3.38
M$200 VDD VDD VDD VDD sky130_fd_pr__pfet_01v8_lvt L=0.6 W=1.4 AS=0.406 AD=0.406
+ PS=3.38 PD=3.38
M$201 VDD VDD VDD VDD sky130_fd_pr__pfet_01v8_lvt L=0.6 W=1.4 AS=0.406 AD=0.406
+ PS=3.38 PD=3.38
M$202 VDD VDD VDD VDD sky130_fd_pr__pfet_01v8_lvt L=0.6 W=1.4 AS=0.406 AD=0.406
+ PS=3.38 PD=3.38
M$203 VDD VDD VDD VDD sky130_fd_pr__pfet_01v8_lvt L=0.6 W=1.4 AS=0.406 AD=0.406
+ PS=3.38 PD=3.38
M$204 VDD VDD VDD VDD sky130_fd_pr__pfet_01v8_lvt L=0.6 W=1.4 AS=0.406 AD=0.406
+ PS=3.38 PD=3.38
M$205 VDD VDD VDD VDD sky130_fd_pr__pfet_01v8_lvt L=0.6 W=1.4 AS=0.406 AD=0.406
+ PS=3.38 PD=3.38
M$206 VDD VDD VDD VDD sky130_fd_pr__pfet_01v8_lvt L=0.6 W=1.4 AS=0.406 AD=0.406
+ PS=3.38 PD=3.38
M$207 op \$150 \$203 VDD sky130_fd_pr__pfet_01v8 L=0.6 W=1.4 AS=0.406 AD=0.406
+ PS=3.38 PD=3.38
M$208 on \$150 \$202 VDD sky130_fd_pr__pfet_01v8 L=0.6 W=1.4 AS=0.406 AD=0.406
+ PS=3.38 PD=3.38
M$209 op \$150 \$203 VDD sky130_fd_pr__pfet_01v8 L=0.6 W=1.4 AS=0.406 AD=0.406
+ PS=3.38 PD=3.38
M$210 on \$150 \$202 VDD sky130_fd_pr__pfet_01v8 L=0.6 W=1.4 AS=0.406 AD=0.406
+ PS=3.38 PD=3.38
M$211 op \$150 \$203 VDD sky130_fd_pr__pfet_01v8 L=0.6 W=1.4 AS=0.406 AD=0.406
+ PS=3.38 PD=3.38
M$212 on \$150 \$202 VDD sky130_fd_pr__pfet_01v8 L=0.6 W=1.4 AS=0.406 AD=0.406
+ PS=3.38 PD=3.38
M$213 op \$150 \$203 VDD sky130_fd_pr__pfet_01v8 L=0.6 W=1.4 AS=0.406 AD=0.406
+ PS=3.38 PD=3.38
M$214 on \$150 \$202 VDD sky130_fd_pr__pfet_01v8 L=0.6 W=1.4 AS=0.406 AD=0.406
+ PS=3.38 PD=3.38
M$215 op \$150 \$203 VDD sky130_fd_pr__pfet_01v8 L=0.6 W=1.4 AS=0.406 AD=0.406
+ PS=3.38 PD=3.38
M$216 on \$150 \$202 VDD sky130_fd_pr__pfet_01v8 L=0.6 W=1.4 AS=0.406 AD=0.406
+ PS=3.38 PD=3.38
M$217 op \$150 \$203 VDD sky130_fd_pr__pfet_01v8 L=0.6 W=1.4 AS=0.406 AD=0.406
+ PS=3.38 PD=3.38
M$218 op \$150 \$203 VDD sky130_fd_pr__pfet_01v8 L=0.6 W=1.4 AS=0.406 AD=0.406
+ PS=3.38 PD=3.38
M$219 on \$150 \$202 VDD sky130_fd_pr__pfet_01v8 L=0.6 W=1.4 AS=0.406 AD=0.406
+ PS=3.38 PD=3.38
M$220 op \$150 \$203 VDD sky130_fd_pr__pfet_01v8 L=0.6 W=1.4 AS=0.406 AD=0.406
+ PS=3.38 PD=3.38
M$221 on \$150 \$202 VDD sky130_fd_pr__pfet_01v8 L=0.6 W=1.4 AS=0.406 AD=0.406
+ PS=3.38 PD=3.38
M$222 op \$150 \$203 VDD sky130_fd_pr__pfet_01v8 L=0.6 W=1.4 AS=0.406 AD=0.406
+ PS=3.38 PD=3.38
M$223 on \$150 \$202 VDD sky130_fd_pr__pfet_01v8 L=0.6 W=1.4 AS=0.406 AD=0.406
+ PS=3.38 PD=3.38
M$224 op \$150 \$203 VDD sky130_fd_pr__pfet_01v8 L=0.6 W=1.4 AS=0.406 AD=0.406
+ PS=3.38 PD=3.38
M$225 on \$150 \$202 VDD sky130_fd_pr__pfet_01v8 L=0.6 W=1.4 AS=0.406 AD=0.406
+ PS=3.38 PD=3.38
M$226 on \$150 \$202 VDD sky130_fd_pr__pfet_01v8 L=0.6 W=1.4 AS=0.406 AD=0.406
+ PS=3.38 PD=3.38
M$227 op \$150 \$203 VDD sky130_fd_pr__pfet_01v8 L=0.6 W=1.4 AS=0.406 AD=0.406
+ PS=3.38 PD=3.38
M$228 on \$150 \$202 VDD sky130_fd_pr__pfet_01v8 L=0.6 W=1.4 AS=0.406 AD=0.406
+ PS=3.38 PD=3.38
M$229 op \$150 \$203 VDD sky130_fd_pr__pfet_01v8 L=0.6 W=1.4 AS=0.406 AD=0.406
+ PS=3.38 PD=3.38
M$230 on \$150 \$202 VDD sky130_fd_pr__pfet_01v8 L=0.6 W=1.4 AS=0.406 AD=0.406
+ PS=3.38 PD=3.38
M$231 on \$150 \$202 VDD sky130_fd_pr__pfet_01v8 L=0.6 W=1.4 AS=0.406 AD=0.406
+ PS=3.38 PD=3.38
M$232 on \$150 \$202 VDD sky130_fd_pr__pfet_01v8 L=0.6 W=1.4 AS=0.406 AD=0.406
+ PS=3.38 PD=3.38
M$233 op \$150 \$203 VDD sky130_fd_pr__pfet_01v8 L=0.6 W=1.4 AS=0.406 AD=0.406
+ PS=3.38 PD=3.38
M$234 on \$150 \$202 VDD sky130_fd_pr__pfet_01v8 L=0.6 W=1.4 AS=0.406 AD=0.406
+ PS=3.38 PD=3.38
M$235 op \$150 \$203 VDD sky130_fd_pr__pfet_01v8 L=0.6 W=1.4 AS=0.406 AD=0.406
+ PS=3.38 PD=3.38
M$236 op \$150 \$203 VDD sky130_fd_pr__pfet_01v8 L=0.6 W=1.4 AS=0.406 AD=0.406
+ PS=3.38 PD=3.38
M$237 op \$150 \$203 VDD sky130_fd_pr__pfet_01v8 L=0.6 W=1.4 AS=0.406 AD=0.406
+ PS=3.38 PD=3.38
M$238 op \$150 \$203 VDD sky130_fd_pr__pfet_01v8 L=0.6 W=1.4 AS=0.406 AD=0.406
+ PS=3.38 PD=3.38
M$239 on \$150 \$202 VDD sky130_fd_pr__pfet_01v8 L=0.6 W=1.4 AS=0.406 AD=0.406
+ PS=3.38 PD=3.38
M$240 op \$150 \$203 VDD sky130_fd_pr__pfet_01v8 L=0.6 W=1.4 AS=0.406 AD=0.406
+ PS=3.38 PD=3.38
M$241 on \$150 \$202 VDD sky130_fd_pr__pfet_01v8 L=0.6 W=1.4 AS=0.406 AD=0.406
+ PS=3.38 PD=3.38
M$242 op \$150 \$203 VDD sky130_fd_pr__pfet_01v8 L=0.6 W=1.4 AS=0.406 AD=0.406
+ PS=3.38 PD=3.38
M$243 on \$150 \$202 VDD sky130_fd_pr__pfet_01v8 L=0.6 W=1.4 AS=0.406 AD=0.406
+ PS=3.38 PD=3.38
M$244 op \$150 \$203 VDD sky130_fd_pr__pfet_01v8 L=0.6 W=1.4 AS=0.406 AD=0.406
+ PS=3.38 PD=3.38
M$245 on \$150 \$202 VDD sky130_fd_pr__pfet_01v8 L=0.6 W=1.4 AS=0.406 AD=0.406
+ PS=3.38 PD=3.38
M$246 on \$150 \$202 VDD sky130_fd_pr__pfet_01v8 L=0.6 W=1.4 AS=0.406 AD=0.406
+ PS=3.38 PD=3.38
M$247 \$45 \$150 \$271 VDD sky130_fd_pr__pfet_01v8 L=0.6 W=1.4 AS=0.406
+ AD=0.406 PS=3.38 PD=3.38
M$248 cm \$150 \$279 VDD sky130_fd_pr__pfet_01v8 L=0.6 W=1.4 AS=0.406 AD=0.406
+ PS=3.38 PD=3.38
M$249 \$168 \$150 \$278 VDD sky130_fd_pr__pfet_01v8 L=0.6 W=1.4 AS=0.406
+ AD=0.406 PS=3.38 PD=3.38
M$250 \$45 \$150 \$271 VDD sky130_fd_pr__pfet_01v8 L=0.6 W=1.4 AS=0.406
+ AD=0.406 PS=3.38 PD=3.38
M$251 cm \$150 \$279 VDD sky130_fd_pr__pfet_01v8 L=0.6 W=1.4 AS=0.406 AD=0.406
+ PS=3.38 PD=3.38
M$252 \$45 \$150 \$271 VDD sky130_fd_pr__pfet_01v8 L=0.6 W=1.4 AS=0.406
+ AD=0.406 PS=3.38 PD=3.38
M$253 cm \$150 \$279 VDD sky130_fd_pr__pfet_01v8 L=0.6 W=1.4 AS=0.406 AD=0.406
+ PS=3.38 PD=3.38
M$254 \$168 \$150 \$278 VDD sky130_fd_pr__pfet_01v8 L=0.6 W=1.4 AS=0.406
+ AD=0.406 PS=3.38 PD=3.38
M$255 cm \$150 \$279 VDD sky130_fd_pr__pfet_01v8 L=0.6 W=1.4 AS=0.406 AD=0.406
+ PS=3.38 PD=3.38
M$256 \$45 \$150 \$271 VDD sky130_fd_pr__pfet_01v8 L=0.6 W=1.4 AS=0.406
+ AD=0.406 PS=3.38 PD=3.38
M$257 \$168 \$150 \$278 VDD sky130_fd_pr__pfet_01v8 L=0.6 W=1.4 AS=0.406
+ AD=0.406 PS=3.38 PD=3.38
M$258 cm \$150 \$279 VDD sky130_fd_pr__pfet_01v8 L=0.6 W=1.4 AS=0.406 AD=0.406
+ PS=3.38 PD=3.38
M$259 \$45 \$150 \$271 VDD sky130_fd_pr__pfet_01v8 L=0.6 W=1.4 AS=0.406
+ AD=0.406 PS=3.38 PD=3.38
M$260 \$168 \$150 \$278 VDD sky130_fd_pr__pfet_01v8 L=0.6 W=1.4 AS=0.406
+ AD=0.406 PS=3.38 PD=3.38
M$261 cm \$150 \$279 VDD sky130_fd_pr__pfet_01v8 L=0.6 W=1.4 AS=0.406 AD=0.406
+ PS=3.38 PD=3.38
M$262 \$45 \$150 \$271 VDD sky130_fd_pr__pfet_01v8 L=0.6 W=1.4 AS=0.406
+ AD=0.406 PS=3.38 PD=3.38
M$263 \$168 \$150 \$278 VDD sky130_fd_pr__pfet_01v8 L=0.6 W=1.4 AS=0.406
+ AD=0.406 PS=3.38 PD=3.38
M$264 \$168 \$150 \$278 VDD sky130_fd_pr__pfet_01v8 L=0.6 W=1.4 AS=0.406
+ AD=0.406 PS=3.38 PD=3.38
M$265 VDD VDD VDD VDD sky130_fd_pr__pfet_01v8 L=0.6 W=1.4 AS=0.406 AD=0.406
+ PS=3.38 PD=3.38
M$266 VDD VDD VDD VDD sky130_fd_pr__pfet_01v8 L=0.6 W=1.4 AS=0.406 AD=0.406
+ PS=3.38 PD=3.38
M$267 VDD VDD VDD VDD sky130_fd_pr__pfet_01v8 L=0.6 W=1.4 AS=0.406 AD=0.406
+ PS=3.38 PD=3.38
M$268 VDD VDD VDD VDD sky130_fd_pr__pfet_01v8 L=0.6 W=1.4 AS=0.406 AD=0.406
+ PS=3.38 PD=3.38
M$269 VDD VDD VDD VDD sky130_fd_pr__pfet_01v8 L=0.6 W=1.4 AS=0.406 AD=0.406
+ PS=3.38 PD=3.38
M$270 VDD VDD VDD VDD sky130_fd_pr__pfet_01v8 L=0.6 W=1.4 AS=0.406 AD=0.406
+ PS=3.38 PD=3.38
M$271 VDD VDD VDD VDD sky130_fd_pr__pfet_01v8 L=0.6 W=1.4 AS=0.406 AD=0.406
+ PS=3.38 PD=3.38
M$272 VDD VDD VDD VDD sky130_fd_pr__pfet_01v8 L=0.6 W=1.4 AS=0.406 AD=0.406
+ PS=3.38 PD=3.38
M$273 VDD VDD VDD VDD sky130_fd_pr__pfet_01v8 L=0.6 W=1.4 AS=0.406 AD=0.406
+ PS=3.38 PD=3.38
M$274 VDD VDD VDD VDD sky130_fd_pr__pfet_01v8 L=0.6 W=1.4 AS=0.406 AD=0.406
+ PS=3.38 PD=3.38
M$275 VDD VDD VDD VDD sky130_fd_pr__pfet_01v8 L=0.6 W=1.4 AS=0.406 AD=0.406
+ PS=3.38 PD=3.38
M$276 VDD VDD VDD VDD sky130_fd_pr__pfet_01v8 L=0.6 W=1.4 AS=0.406 AD=0.406
+ PS=3.38 PD=3.38
M$277 VSS VSS VSS sky130_gnd sky130_fd_pr__nfet_01v8 L=0.6 W=1.4 AS=0.406
+ AD=0.406 PS=3.38 PD=3.38
M$278 VSS VSS VSS sky130_gnd sky130_fd_pr__nfet_01v8 L=0.6 W=1.4 AS=0.406
+ AD=0.406 PS=3.38 PD=3.38
M$279 VSS VSS VSS sky130_gnd sky130_fd_pr__nfet_01v8 L=0.6 W=1.4 AS=0.406
+ AD=0.406 PS=3.38 PD=3.38
M$280 VSS VSS VSS sky130_gnd sky130_fd_pr__nfet_01v8 L=0.6 W=1.4 AS=0.406
+ AD=0.406 PS=3.38 PD=3.38
M$281 VSS VSS VSS sky130_gnd sky130_fd_pr__nfet_01v8 L=0.6 W=1.4 AS=0.406
+ AD=0.406 PS=3.38 PD=3.38
M$282 VSS VSS VSS sky130_gnd sky130_fd_pr__nfet_01v8 L=0.6 W=1.4 AS=0.406
+ AD=0.406 PS=3.38 PD=3.38
M$283 VSS VSS VSS sky130_gnd sky130_fd_pr__nfet_01v8 L=0.6 W=1.4 AS=0.406
+ AD=0.406 PS=3.38 PD=3.38
M$284 VSS VSS VSS sky130_gnd sky130_fd_pr__nfet_01v8 L=0.6 W=1.4 AS=0.406
+ AD=0.406 PS=3.38 PD=3.38
M$285 VSS VSS VSS sky130_gnd sky130_fd_pr__nfet_01v8 L=0.6 W=1.4 AS=0.406
+ AD=0.406 PS=3.38 PD=3.38
M$286 VSS VSS VSS sky130_gnd sky130_fd_pr__nfet_01v8 L=0.6 W=1.4 AS=0.406
+ AD=0.406 PS=3.38 PD=3.38
M$287 VSS VSS VSS sky130_gnd sky130_fd_pr__nfet_01v8 L=0.6 W=1.4 AS=0.406
+ AD=0.406 PS=3.38 PD=3.38
M$288 VSS VSS VSS sky130_gnd sky130_fd_pr__nfet_01v8 L=0.6 W=1.4 AS=0.406
+ AD=0.406 PS=3.38 PD=3.38
M$289 VSS VSS VSS sky130_gnd sky130_fd_pr__nfet_01v8 L=0.6 W=1.4 AS=0.406
+ AD=0.406 PS=3.38 PD=3.38
M$290 VSS VSS VSS sky130_gnd sky130_fd_pr__nfet_01v8 L=0.6 W=1.4 AS=0.406
+ AD=0.406 PS=3.38 PD=3.38
M$291 VSS VSS VSS sky130_gnd sky130_fd_pr__nfet_01v8 L=0.6 W=1.4 AS=0.406
+ AD=0.406 PS=3.38 PD=3.38
M$292 VSS VSS VSS sky130_gnd sky130_fd_pr__nfet_01v8 L=0.6 W=1.4 AS=0.406
+ AD=0.406 PS=3.38 PD=3.38
M$293 VSS VSS VSS sky130_gnd sky130_fd_pr__nfet_01v8 L=0.6 W=1.4 AS=0.406
+ AD=0.406 PS=3.38 PD=3.38
M$294 VSS VSS VSS sky130_gnd sky130_fd_pr__nfet_01v8 L=0.6 W=1.4 AS=0.406
+ AD=0.406 PS=3.38 PD=3.38
M$295 VSS VSS VSS sky130_gnd sky130_fd_pr__nfet_01v8 L=0.6 W=1.4 AS=0.406
+ AD=0.406 PS=3.38 PD=3.38
M$296 VSS VSS VSS sky130_gnd sky130_fd_pr__nfet_01v8 L=0.6 W=1.4 AS=0.406
+ AD=0.406 PS=3.38 PD=3.38
M$297 VSS VSS VSS sky130_gnd sky130_fd_pr__nfet_01v8 L=0.6 W=1.4 AS=0.406
+ AD=0.406 PS=3.38 PD=3.38
M$298 VSS VSS VSS sky130_gnd sky130_fd_pr__nfet_01v8 L=0.6 W=1.4 AS=0.406
+ AD=0.406 PS=3.38 PD=3.38
M$299 VSS VSS VSS sky130_gnd sky130_fd_pr__nfet_01v8 L=0.6 W=1.4 AS=0.406
+ AD=0.406 PS=3.38 PD=3.38
M$300 VSS VSS VSS sky130_gnd sky130_fd_pr__nfet_01v8 L=0.6 W=1.4 AS=0.406
+ AD=0.406 PS=3.38 PD=3.38
M$301 VSS VSS VSS sky130_gnd sky130_fd_pr__nfet_01v8 L=0.6 W=1.4 AS=0.406
+ AD=0.406 PS=3.38 PD=3.38
M$302 bias_a bias_a bias_a sky130_gnd sky130_fd_pr__nfet_01v8 L=0.6 W=1.4
+ AS=0.406 AD=0.406 PS=3.38 PD=3.38
M$303 bias_a bias_a bias_a sky130_gnd sky130_fd_pr__nfet_01v8 L=0.6 W=1.4
+ AS=0.406 AD=0.406 PS=3.38 PD=3.38
M$304 bias_a bias_a bias_a sky130_gnd sky130_fd_pr__nfet_01v8 L=0.6 W=1.4
+ AS=0.406 AD=0.406 PS=3.38 PD=3.38
M$305 bias_a bias_a bias_a sky130_gnd sky130_fd_pr__nfet_01v8 L=0.6 W=1.4
+ AS=0.406 AD=0.406 PS=3.38 PD=3.38
M$306 \$77 VSS VSS sky130_gnd sky130_fd_pr__nfet_01v8 L=0.6 W=1.4 AS=0.406
+ AD=0.406 PS=3.38 PD=3.38
M$307 \$77 VSS VSS sky130_gnd sky130_fd_pr__nfet_01v8 L=0.6 W=1.4 AS=0.406
+ AD=0.406 PS=3.38 PD=3.38
M$308 \$77 VSS VSS sky130_gnd sky130_fd_pr__nfet_01v8 L=0.6 W=1.4 AS=0.406
+ AD=0.406 PS=3.38 PD=3.38
M$309 \$77 VSS VSS sky130_gnd sky130_fd_pr__nfet_01v8 L=0.6 W=1.4 AS=0.406
+ AD=0.406 PS=3.38 PD=3.38
M$310 \$77 VSS VSS sky130_gnd sky130_fd_pr__nfet_01v8 L=0.6 W=1.4 AS=0.406
+ AD=0.406 PS=3.38 PD=3.38
M$311 \$77 VSS VSS sky130_gnd sky130_fd_pr__nfet_01v8 L=0.6 W=1.4 AS=0.406
+ AD=0.406 PS=3.38 PD=3.38
M$312 \$157 \$157 \$157 sky130_gnd sky130_fd_pr__nfet_01v8 L=0.6 W=1.4 AS=0.406
+ AD=0.406 PS=3.38 PD=3.38
M$313 \$157 \$157 \$157 sky130_gnd sky130_fd_pr__nfet_01v8 L=0.6 W=1.4 AS=0.406
+ AD=0.406 PS=3.38 PD=3.38
M$314 \$157 \$157 \$157 sky130_gnd sky130_fd_pr__nfet_01v8 L=0.6 W=1.4 AS=0.406
+ AD=0.406 PS=3.38 PD=3.38
M$315 \$157 \$157 \$157 sky130_gnd sky130_fd_pr__nfet_01v8 L=0.6 W=1.4 AS=0.406
+ AD=0.406 PS=3.38 PD=3.38
M$316 \$157 \$157 \$157 sky130_gnd sky130_fd_pr__nfet_01v8 L=0.6 W=1.4 AS=0.406
+ AD=0.406 PS=3.38 PD=3.38
M$317 \$157 \$157 \$157 sky130_gnd sky130_fd_pr__nfet_01v8 L=0.6 W=1.4 AS=0.406
+ AD=0.406 PS=3.38 PD=3.38
M$318 VSS VSS VSS sky130_gnd sky130_fd_pr__nfet_01v8 L=0.6 W=1.4 AS=0.406
+ AD=0.406 PS=3.38 PD=3.38
M$319 VSS VSS VSS sky130_gnd sky130_fd_pr__nfet_01v8 L=0.6 W=1.4 AS=0.406
+ AD=0.406 PS=3.38 PD=3.38
M$320 \$1 VSS VSS sky130_gnd sky130_fd_pr__nfet_01v8 L=0.6 W=1.4 AS=0.406
+ AD=0.406 PS=3.38 PD=3.38
M$321 \$1 VSS VSS sky130_gnd sky130_fd_pr__nfet_01v8 L=0.6 W=1.4 AS=0.406
+ AD=0.406 PS=3.38 PD=3.38
M$322 \$1 VSS VSS sky130_gnd sky130_fd_pr__nfet_01v8 L=0.6 W=1.4 AS=0.406
+ AD=0.406 PS=3.38 PD=3.38
M$323 \$1 VSS VSS sky130_gnd sky130_fd_pr__nfet_01v8 L=0.6 W=1.4 AS=0.406
+ AD=0.406 PS=3.38 PD=3.38
M$324 \$1 VSS VSS sky130_gnd sky130_fd_pr__nfet_01v8 L=0.6 W=1.4 AS=0.406
+ AD=0.406 PS=3.38 PD=3.38
M$325 \$1 VSS VSS sky130_gnd sky130_fd_pr__nfet_01v8 L=0.6 W=1.4 AS=0.406
+ AD=0.406 PS=3.38 PD=3.38
M$326 \$1 \$1 \$1 sky130_gnd sky130_fd_pr__nfet_01v8 L=0.6 W=1.4 AS=0.406
+ AD=0.406 PS=3.38 PD=3.38
M$327 \$1 \$1 \$1 sky130_gnd sky130_fd_pr__nfet_01v8 L=0.6 W=1.4 AS=0.406
+ AD=0.406 PS=3.38 PD=3.38
M$328 \$1 \$1 \$1 sky130_gnd sky130_fd_pr__nfet_01v8 L=0.6 W=1.4 AS=0.406
+ AD=0.406 PS=3.38 PD=3.38
M$329 \$1 \$1 \$1 sky130_gnd sky130_fd_pr__nfet_01v8 L=0.6 W=1.4 AS=0.406
+ AD=0.406 PS=3.38 PD=3.38
M$330 \$1 \$1 \$1 sky130_gnd sky130_fd_pr__nfet_01v8 L=0.6 W=1.4 AS=0.406
+ AD=0.406 PS=3.38 PD=3.38
M$331 \$1 \$1 \$1 sky130_gnd sky130_fd_pr__nfet_01v8 L=0.6 W=1.4 AS=0.406
+ AD=0.406 PS=3.38 PD=3.38
M$332 cm cm cm sky130_gnd sky130_fd_pr__nfet_01v8 L=0.6 W=1.4 AS=0.406 AD=0.406
+ PS=3.38 PD=3.38
M$333 cm cm cm sky130_gnd sky130_fd_pr__nfet_01v8 L=0.6 W=1.4 AS=0.406 AD=0.406
+ PS=3.38 PD=3.38
M$334 cm cm cm sky130_gnd sky130_fd_pr__nfet_01v8 L=0.6 W=1.4 AS=0.406 AD=0.406
+ PS=3.38 PD=3.38
M$335 cm cm cm sky130_gnd sky130_fd_pr__nfet_01v8 L=0.6 W=1.4 AS=0.406 AD=0.406
+ PS=3.38 PD=3.38
M$336 cm cm cm sky130_gnd sky130_fd_pr__nfet_01v8 L=0.6 W=1.4 AS=0.406 AD=0.406
+ PS=3.38 PD=3.38
M$337 cm cm cm sky130_gnd sky130_fd_pr__nfet_01v8 L=0.6 W=1.4 AS=0.406 AD=0.406
+ PS=3.38 PD=3.38
M$338 cm cm cm sky130_gnd sky130_fd_pr__nfet_01v8 L=0.6 W=1.4 AS=0.406 AD=0.406
+ PS=3.38 PD=3.38
M$339 cm cm cm sky130_gnd sky130_fd_pr__nfet_01v8 L=0.6 W=1.4 AS=0.406 AD=0.406
+ PS=3.38 PD=3.38
M$340 \$76 VSS VSS sky130_gnd sky130_fd_pr__nfet_01v8 L=0.6 W=1.4 AS=0.406
+ AD=0.406 PS=3.38 PD=3.38
M$341 \$76 VSS VSS sky130_gnd sky130_fd_pr__nfet_01v8 L=0.6 W=1.4 AS=0.406
+ AD=0.406 PS=3.38 PD=3.38
M$342 \$76 VSS VSS sky130_gnd sky130_fd_pr__nfet_01v8 L=0.6 W=1.4 AS=0.406
+ AD=0.406 PS=3.38 PD=3.38
M$343 \$76 VSS VSS sky130_gnd sky130_fd_pr__nfet_01v8 L=0.6 W=1.4 AS=0.406
+ AD=0.406 PS=3.38 PD=3.38
M$344 \$76 VSS VSS sky130_gnd sky130_fd_pr__nfet_01v8 L=0.6 W=1.4 AS=0.406
+ AD=0.406 PS=3.38 PD=3.38
M$345 \$76 VSS VSS sky130_gnd sky130_fd_pr__nfet_01v8 L=0.6 W=1.4 AS=0.406
+ AD=0.406 PS=3.38 PD=3.38
M$346 \$76 VSS VSS sky130_gnd sky130_fd_pr__nfet_01v8 L=0.6 W=1.4 AS=0.406
+ AD=0.406 PS=3.38 PD=3.38
M$347 \$76 VSS VSS sky130_gnd sky130_fd_pr__nfet_01v8 L=0.6 W=1.4 AS=0.406
+ AD=0.406 PS=3.38 PD=3.38
M$348 \$11 \$11 \$11 sky130_gnd sky130_fd_pr__nfet_01v8 L=0.6 W=1.4 AS=0.406
+ AD=0.406 PS=3.38 PD=3.38
M$349 \$11 \$11 \$11 sky130_gnd sky130_fd_pr__nfet_01v8 L=0.6 W=1.4 AS=0.406
+ AD=0.406 PS=3.38 PD=3.38
M$350 \$11 \$11 \$11 sky130_gnd sky130_fd_pr__nfet_01v8 L=0.6 W=1.4 AS=0.406
+ AD=0.406 PS=3.38 PD=3.38
M$351 \$11 \$11 \$11 sky130_gnd sky130_fd_pr__nfet_01v8 L=0.6 W=1.4 AS=0.406
+ AD=0.406 PS=3.38 PD=3.38
M$352 \$11 \$11 \$11 sky130_gnd sky130_fd_pr__nfet_01v8 L=0.6 W=1.4 AS=0.406
+ AD=0.406 PS=3.38 PD=3.38
M$353 \$11 \$11 \$11 sky130_gnd sky130_fd_pr__nfet_01v8 L=0.6 W=1.4 AS=0.406
+ AD=0.406 PS=3.38 PD=3.38
M$354 \$11 \$11 \$11 sky130_gnd sky130_fd_pr__nfet_01v8 L=0.6 W=1.4 AS=0.406
+ AD=0.406 PS=3.38 PD=3.38
M$355 \$11 \$11 \$11 sky130_gnd sky130_fd_pr__nfet_01v8 L=0.6 W=1.4 AS=0.406
+ AD=0.406 PS=3.38 PD=3.38
M$356 \$11.x1_net12 cm VSS sky130_gnd sky130_fd_pr__nfet_01v8 L=0.6 W=1.4
+ AS=0.406 AD=0.406 PS=3.38 PD=3.38
M$357 \$11.x1_net9 cm VSS sky130_gnd sky130_fd_pr__nfet_01v8 L=0.6 W=1.4
+ AS=0.406 AD=0.406 PS=3.38 PD=3.38
M$358 \$11.x1_net6 cm VSS sky130_gnd sky130_fd_pr__nfet_01v8 L=0.6 W=1.4
+ AS=0.406 AD=0.406 PS=3.38 PD=3.38
M$359 \$11.x1_net3 cm VSS sky130_gnd sky130_fd_pr__nfet_01v8 L=0.6 W=1.4
+ AS=0.406 AD=0.406 PS=3.38 PD=3.38
M$360 \$11.x1_net15 cm VSS sky130_gnd sky130_fd_pr__nfet_01v8 L=0.6 W=1.4
+ AS=0.406 AD=0.406 PS=3.38 PD=3.38
M$361 \$11.x1_net1 cm \$11.x1_net2 sky130_gnd sky130_fd_pr__nfet_01v8 L=0.6
+ W=1.4 AS=0.406 AD=0.406 PS=3.38 PD=3.38
M$362 \$11.x1_net2 cm \$11.x1_net3 sky130_gnd sky130_fd_pr__nfet_01v8 L=0.6
+ W=1.4 AS=0.406 AD=0.406 PS=3.38 PD=3.38
M$363 \$11.x1_net13 cm \$11.x1_net14 sky130_gnd sky130_fd_pr__nfet_01v8 L=0.6
+ W=1.4 AS=0.406 AD=0.406 PS=3.38 PD=3.38
M$364 \$11.x1_net14 cm \$11.x1_net15 sky130_gnd sky130_fd_pr__nfet_01v8 L=0.6
+ W=1.4 AS=0.406 AD=0.406 PS=3.38 PD=3.38
M$365 \$11.x1_net4 cm \$11.x1_net5 sky130_gnd sky130_fd_pr__nfet_01v8 L=0.6
+ W=1.4 AS=0.406 AD=0.406 PS=3.38 PD=3.38
M$366 \$11.x1_net5 cm \$11.x1_net6 sky130_gnd sky130_fd_pr__nfet_01v8 L=0.6
+ W=1.4 AS=0.406 AD=0.406 PS=3.38 PD=3.38
M$367 \$11.x1_net7 cm \$11.x1_net8 sky130_gnd sky130_fd_pr__nfet_01v8 L=0.6
+ W=1.4 AS=0.406 AD=0.406 PS=3.38 PD=3.38
M$368 \$11.x1_net8 cm \$11.x1_net9 sky130_gnd sky130_fd_pr__nfet_01v8 L=0.6
+ W=1.4 AS=0.406 AD=0.406 PS=3.38 PD=3.38
M$369 \$11.x1_net10 cm \$11.x1_net11 sky130_gnd sky130_fd_pr__nfet_01v8 L=0.6
+ W=1.4 AS=0.406 AD=0.406 PS=3.38 PD=3.38
M$370 \$11.x1_net11 cm \$11.x1_net12 sky130_gnd sky130_fd_pr__nfet_01v8 L=0.6
+ W=1.4 AS=0.406 AD=0.406 PS=3.38 PD=3.38
M$371 cm cm \$11.x1_net1 sky130_gnd sky130_fd_pr__nfet_01v8 L=0.6 W=1.4
+ AS=0.406 AD=0.406 PS=3.38 PD=3.38
M$372 cm cm \$11.x1_net13 sky130_gnd sky130_fd_pr__nfet_01v8 L=0.6 W=1.4
+ AS=0.406 AD=0.406 PS=3.38 PD=3.38
M$373 cm cm \$11.x1_net4 sky130_gnd sky130_fd_pr__nfet_01v8 L=0.6 W=1.4
+ AS=0.406 AD=0.406 PS=3.38 PD=3.38
M$374 cm cm \$11.x1_net7 sky130_gnd sky130_fd_pr__nfet_01v8 L=0.6 W=1.4
+ AS=0.406 AD=0.406 PS=3.38 PD=3.38
M$375 cm cm \$11.x1_net10 sky130_gnd sky130_fd_pr__nfet_01v8 L=0.6 W=1.4
+ AS=0.406 AD=0.406 PS=3.38 PD=3.38
M$376 \$157 cmc VSS sky130_gnd sky130_fd_pr__nfet_01v8 L=0.6 W=1.4 AS=0.406
+ AD=0.406 PS=3.38 PD=3.38
M$377 \$157 bias_a VSS sky130_gnd sky130_fd_pr__nfet_01v8 L=0.6 W=1.4 AS=0.406
+ AD=0.406 PS=3.38 PD=3.38
M$378 \$157 bias_a VSS sky130_gnd sky130_fd_pr__nfet_01v8 L=0.6 W=1.4 AS=0.406
+ AD=0.406 PS=3.38 PD=3.38
M$379 \$157 bias_a VSS sky130_gnd sky130_fd_pr__nfet_01v8 L=0.6 W=1.4 AS=0.406
+ AD=0.406 PS=3.38 PD=3.38
M$380 \$157 cmc VSS sky130_gnd sky130_fd_pr__nfet_01v8 L=0.6 W=1.4 AS=0.406
+ AD=0.406 PS=3.38 PD=3.38
M$381 \$157 cmc VSS sky130_gnd sky130_fd_pr__nfet_01v8 L=0.6 W=1.4 AS=0.406
+ AD=0.406 PS=3.38 PD=3.38
M$382 \$157 bias_a VSS sky130_gnd sky130_fd_pr__nfet_01v8 L=0.6 W=1.4 AS=0.406
+ AD=0.406 PS=3.38 PD=3.38
M$383 \$157 bias_a VSS sky130_gnd sky130_fd_pr__nfet_01v8 L=0.6 W=1.4 AS=0.406
+ AD=0.406 PS=3.38 PD=3.38
M$384 \$157 cmc VSS sky130_gnd sky130_fd_pr__nfet_01v8 L=0.6 W=1.4 AS=0.406
+ AD=0.406 PS=3.38 PD=3.38
M$385 \$157 cmc VSS sky130_gnd sky130_fd_pr__nfet_01v8 L=0.6 W=1.4 AS=0.406
+ AD=0.406 PS=3.38 PD=3.38
M$386 \$157 bias_a VSS sky130_gnd sky130_fd_pr__nfet_01v8 L=0.6 W=1.4 AS=0.406
+ AD=0.406 PS=3.38 PD=3.38
M$387 \$157 bias_a VSS sky130_gnd sky130_fd_pr__nfet_01v8 L=0.6 W=1.4 AS=0.406
+ AD=0.406 PS=3.38 PD=3.38
M$388 \$157 cmc VSS sky130_gnd sky130_fd_pr__nfet_01v8 L=0.6 W=1.4 AS=0.406
+ AD=0.406 PS=3.38 PD=3.38
M$389 \$157 cmc VSS sky130_gnd sky130_fd_pr__nfet_01v8 L=0.6 W=1.4 AS=0.406
+ AD=0.406 PS=3.38 PD=3.38
M$390 \$157 bias_a VSS sky130_gnd sky130_fd_pr__nfet_01v8 L=0.6 W=1.4 AS=0.406
+ AD=0.406 PS=3.38 PD=3.38
M$391 \$157 bias_a VSS sky130_gnd sky130_fd_pr__nfet_01v8 L=0.6 W=1.4 AS=0.406
+ AD=0.406 PS=3.38 PD=3.38
M$392 \$157 cmc VSS sky130_gnd sky130_fd_pr__nfet_01v8 L=0.6 W=1.4 AS=0.406
+ AD=0.406 PS=3.38 PD=3.38
M$393 \$157 cmc VSS sky130_gnd sky130_fd_pr__nfet_01v8 L=0.6 W=1.4 AS=0.406
+ AD=0.406 PS=3.38 PD=3.38
M$394 \$157 bias_a VSS sky130_gnd sky130_fd_pr__nfet_01v8 L=0.6 W=1.4 AS=0.406
+ AD=0.406 PS=3.38 PD=3.38
M$395 \$157 bias_a VSS sky130_gnd sky130_fd_pr__nfet_01v8 L=0.6 W=1.4 AS=0.406
+ AD=0.406 PS=3.38 PD=3.38
M$396 \$157 cmc VSS sky130_gnd sky130_fd_pr__nfet_01v8 L=0.6 W=1.4 AS=0.406
+ AD=0.406 PS=3.38 PD=3.38
M$397 \$157 bias_a VSS sky130_gnd sky130_fd_pr__nfet_01v8 L=0.6 W=1.4 AS=0.406
+ AD=0.406 PS=3.38 PD=3.38
M$398 \$157 cmc VSS sky130_gnd sky130_fd_pr__nfet_01v8 L=0.6 W=1.4 AS=0.406
+ AD=0.406 PS=3.38 PD=3.38
M$399 \$157 bias_a VSS sky130_gnd sky130_fd_pr__nfet_01v8 L=0.6 W=1.4 AS=0.406
+ AD=0.406 PS=3.38 PD=3.38
M$400 \$157 cmc VSS sky130_gnd sky130_fd_pr__nfet_01v8 L=0.6 W=1.4 AS=0.406
+ AD=0.406 PS=3.38 PD=3.38
M$401 \$157 cmc VSS sky130_gnd sky130_fd_pr__nfet_01v8 L=0.6 W=1.4 AS=0.406
+ AD=0.406 PS=3.38 PD=3.38
M$402 \$157 bias_a VSS sky130_gnd sky130_fd_pr__nfet_01v8 L=0.6 W=1.4 AS=0.406
+ AD=0.406 PS=3.38 PD=3.38
M$403 \$157 cmc VSS sky130_gnd sky130_fd_pr__nfet_01v8 L=0.6 W=1.4 AS=0.406
+ AD=0.406 PS=3.38 PD=3.38
M$404 \$157 cmc VSS sky130_gnd sky130_fd_pr__nfet_01v8 L=0.6 W=1.4 AS=0.406
+ AD=0.406 PS=3.38 PD=3.38
M$405 \$157 bias_a VSS sky130_gnd sky130_fd_pr__nfet_01v8 L=0.6 W=1.4 AS=0.406
+ AD=0.406 PS=3.38 PD=3.38
M$406 \$157 cmc VSS sky130_gnd sky130_fd_pr__nfet_01v8 L=0.6 W=1.4 AS=0.406
+ AD=0.406 PS=3.38 PD=3.38
M$407 \$157 bias_a VSS sky130_gnd sky130_fd_pr__nfet_01v8 L=0.6 W=1.4 AS=0.406
+ AD=0.406 PS=3.38 PD=3.38
M$408 \$157 cmc VSS sky130_gnd sky130_fd_pr__nfet_01v8 L=0.6 W=1.4 AS=0.406
+ AD=0.406 PS=3.38 PD=3.38
M$409 \$157 bias_a VSS sky130_gnd sky130_fd_pr__nfet_01v8 L=0.6 W=1.4 AS=0.406
+ AD=0.406 PS=3.38 PD=3.38
M$410 \$157 cmc VSS sky130_gnd sky130_fd_pr__nfet_01v8 L=0.6 W=1.4 AS=0.406
+ AD=0.406 PS=3.38 PD=3.38
M$411 \$157 bias_a VSS sky130_gnd sky130_fd_pr__nfet_01v8 L=0.6 W=1.4 AS=0.406
+ AD=0.406 PS=3.38 PD=3.38
M$412 \$157 bias_a VSS sky130_gnd sky130_fd_pr__nfet_01v8 L=0.6 W=1.4 AS=0.406
+ AD=0.406 PS=3.38 PD=3.38
M$413 \$157 bias_a VSS sky130_gnd sky130_fd_pr__nfet_01v8 L=0.6 W=1.4 AS=0.406
+ AD=0.406 PS=3.38 PD=3.38
M$414 \$157 cmc VSS sky130_gnd sky130_fd_pr__nfet_01v8 L=0.6 W=1.4 AS=0.406
+ AD=0.406 PS=3.38 PD=3.38
M$415 \$157 bias_a VSS sky130_gnd sky130_fd_pr__nfet_01v8 L=0.6 W=1.4 AS=0.406
+ AD=0.406 PS=3.38 PD=3.38
M$416 \$157 cmc VSS sky130_gnd sky130_fd_pr__nfet_01v8 L=0.6 W=1.4 AS=0.406
+ AD=0.406 PS=3.38 PD=3.38
M$417 \$157 bias_a VSS sky130_gnd sky130_fd_pr__nfet_01v8 L=0.6 W=1.4 AS=0.406
+ AD=0.406 PS=3.38 PD=3.38
M$418 \$157 cmc VSS sky130_gnd sky130_fd_pr__nfet_01v8 L=0.6 W=1.4 AS=0.406
+ AD=0.406 PS=3.38 PD=3.38
M$419 \$157 bias_a VSS sky130_gnd sky130_fd_pr__nfet_01v8 L=0.6 W=1.4 AS=0.406
+ AD=0.406 PS=3.38 PD=3.38
M$420 \$157 cmc VSS sky130_gnd sky130_fd_pr__nfet_01v8 L=0.6 W=1.4 AS=0.406
+ AD=0.406 PS=3.38 PD=3.38
M$421 \$157 bias_a VSS sky130_gnd sky130_fd_pr__nfet_01v8 L=0.6 W=1.4 AS=0.406
+ AD=0.406 PS=3.38 PD=3.38
M$422 \$157 cmc VSS sky130_gnd sky130_fd_pr__nfet_01v8 L=0.6 W=1.4 AS=0.406
+ AD=0.406 PS=3.38 PD=3.38
M$423 \$157 bias_a VSS sky130_gnd sky130_fd_pr__nfet_01v8 L=0.6 W=1.4 AS=0.406
+ AD=0.406 PS=3.38 PD=3.38
M$424 \$157 cmc VSS sky130_gnd sky130_fd_pr__nfet_01v8 L=0.6 W=1.4 AS=0.406
+ AD=0.406 PS=3.38 PD=3.38
M$425 \$157 cmc VSS sky130_gnd sky130_fd_pr__nfet_01v8 L=0.6 W=1.4 AS=0.406
+ AD=0.406 PS=3.38 PD=3.38
M$426 \$157 cmc VSS sky130_gnd sky130_fd_pr__nfet_01v8 L=0.6 W=1.4 AS=0.406
+ AD=0.406 PS=3.38 PD=3.38
M$427 \$157 bias_a VSS sky130_gnd sky130_fd_pr__nfet_01v8 L=0.6 W=1.4 AS=0.406
+ AD=0.406 PS=3.38 PD=3.38
M$428 \$157 bias_a VSS sky130_gnd sky130_fd_pr__nfet_01v8 L=0.6 W=1.4 AS=0.406
+ AD=0.406 PS=3.38 PD=3.38
M$429 \$157 cmc VSS sky130_gnd sky130_fd_pr__nfet_01v8 L=0.6 W=1.4 AS=0.406
+ AD=0.406 PS=3.38 PD=3.38
M$430 \$157 bias_a VSS sky130_gnd sky130_fd_pr__nfet_01v8 L=0.6 W=1.4 AS=0.406
+ AD=0.406 PS=3.38 PD=3.38
M$431 \$157 cmc VSS sky130_gnd sky130_fd_pr__nfet_01v8 L=0.6 W=1.4 AS=0.406
+ AD=0.406 PS=3.38 PD=3.38
M$432 \$157 bias_a VSS sky130_gnd sky130_fd_pr__nfet_01v8 L=0.6 W=1.4 AS=0.406
+ AD=0.406 PS=3.38 PD=3.38
M$433 \$157 cmc VSS sky130_gnd sky130_fd_pr__nfet_01v8 L=0.6 W=1.4 AS=0.406
+ AD=0.406 PS=3.38 PD=3.38
M$434 \$157 bias_a VSS sky130_gnd sky130_fd_pr__nfet_01v8 L=0.6 W=1.4 AS=0.406
+ AD=0.406 PS=3.38 PD=3.38
M$435 \$157 cmc VSS sky130_gnd sky130_fd_pr__nfet_01v8 L=0.6 W=1.4 AS=0.406
+ AD=0.406 PS=3.38 PD=3.38
M$436 \$157 bias_a VSS sky130_gnd sky130_fd_pr__nfet_01v8 L=0.6 W=1.4 AS=0.406
+ AD=0.406 PS=3.38 PD=3.38
M$437 \$157 cmc VSS sky130_gnd sky130_fd_pr__nfet_01v8 L=0.6 W=1.4 AS=0.406
+ AD=0.406 PS=3.38 PD=3.38
M$438 \$157 bias_a VSS sky130_gnd sky130_fd_pr__nfet_01v8 L=0.6 W=1.4 AS=0.406
+ AD=0.406 PS=3.38 PD=3.38
M$439 \$157 cmc VSS sky130_gnd sky130_fd_pr__nfet_01v8 L=0.6 W=1.4 AS=0.406
+ AD=0.406 PS=3.38 PD=3.38
M$440 \$157 bias_a VSS sky130_gnd sky130_fd_pr__nfet_01v8 L=0.6 W=1.4 AS=0.406
+ AD=0.406 PS=3.38 PD=3.38
M$441 \$157 cmc VSS sky130_gnd sky130_fd_pr__nfet_01v8 L=0.6 W=1.4 AS=0.406
+ AD=0.406 PS=3.38 PD=3.38
M$442 \$157 bias_a VSS sky130_gnd sky130_fd_pr__nfet_01v8 L=0.6 W=1.4 AS=0.406
+ AD=0.406 PS=3.38 PD=3.38
M$443 \$157 cmc VSS sky130_gnd sky130_fd_pr__nfet_01v8 L=0.6 W=1.4 AS=0.406
+ AD=0.406 PS=3.38 PD=3.38
M$444 \$157 bias_a VSS sky130_gnd sky130_fd_pr__nfet_01v8 L=0.6 W=1.4 AS=0.406
+ AD=0.406 PS=3.38 PD=3.38
M$445 \$157 cmc VSS sky130_gnd sky130_fd_pr__nfet_01v8 L=0.6 W=1.4 AS=0.406
+ AD=0.406 PS=3.38 PD=3.38
M$446 \$157 bias_a VSS sky130_gnd sky130_fd_pr__nfet_01v8 L=0.6 W=1.4 AS=0.406
+ AD=0.406 PS=3.38 PD=3.38
M$447 \$157 cmc VSS sky130_gnd sky130_fd_pr__nfet_01v8 L=0.6 W=1.4 AS=0.406
+ AD=0.406 PS=3.38 PD=3.38
M$448 \$157 bias_a VSS sky130_gnd sky130_fd_pr__nfet_01v8 L=0.6 W=1.4 AS=0.406
+ AD=0.406 PS=3.38 PD=3.38
M$449 \$157 cmc VSS sky130_gnd sky130_fd_pr__nfet_01v8 L=0.6 W=1.4 AS=0.406
+ AD=0.406 PS=3.38 PD=3.38
M$450 \$157 cmc VSS sky130_gnd sky130_fd_pr__nfet_01v8 L=0.6 W=1.4 AS=0.406
+ AD=0.406 PS=3.38 PD=3.38
M$451 \$157 cmc VSS sky130_gnd sky130_fd_pr__nfet_01v8 L=0.6 W=1.4 AS=0.406
+ AD=0.406 PS=3.38 PD=3.38
M$452 \$157 bias_a VSS sky130_gnd sky130_fd_pr__nfet_01v8 L=0.6 W=1.4 AS=0.406
+ AD=0.406 PS=3.38 PD=3.38
M$453 \$157 bias_a VSS sky130_gnd sky130_fd_pr__nfet_01v8 L=0.6 W=1.4 AS=0.406
+ AD=0.406 PS=3.38 PD=3.38
M$454 \$157 bias_a VSS sky130_gnd sky130_fd_pr__nfet_01v8 L=0.6 W=1.4 AS=0.406
+ AD=0.406 PS=3.38 PD=3.38
M$455 \$157 cmc VSS sky130_gnd sky130_fd_pr__nfet_01v8 L=0.6 W=1.4 AS=0.406
+ AD=0.406 PS=3.38 PD=3.38
M$456 \$157 cmc VSS sky130_gnd sky130_fd_pr__nfet_01v8 L=0.6 W=1.4 AS=0.406
+ AD=0.406 PS=3.38 PD=3.38
M$457 \$157 cmc VSS sky130_gnd sky130_fd_pr__nfet_01v8 L=0.6 W=1.4 AS=0.406
+ AD=0.406 PS=3.38 PD=3.38
M$458 \$157 cmc VSS sky130_gnd sky130_fd_pr__nfet_01v8 L=0.6 W=1.4 AS=0.406
+ AD=0.406 PS=3.38 PD=3.38
M$459 \$157 bias_a VSS sky130_gnd sky130_fd_pr__nfet_01v8 L=0.6 W=1.4 AS=0.406
+ AD=0.406 PS=3.38 PD=3.38
M$460 \$157 bias_a VSS sky130_gnd sky130_fd_pr__nfet_01v8 L=0.6 W=1.4 AS=0.406
+ AD=0.406 PS=3.38 PD=3.38
M$461 \$157 cmc VSS sky130_gnd sky130_fd_pr__nfet_01v8 L=0.6 W=1.4 AS=0.406
+ AD=0.406 PS=3.38 PD=3.38
M$462 \$157 bias_a VSS sky130_gnd sky130_fd_pr__nfet_01v8 L=0.6 W=1.4 AS=0.406
+ AD=0.406 PS=3.38 PD=3.38
M$463 \$157 bias_a VSS sky130_gnd sky130_fd_pr__nfet_01v8 L=0.6 W=1.4 AS=0.406
+ AD=0.406 PS=3.38 PD=3.38
M$464 \$157 bias_a VSS sky130_gnd sky130_fd_pr__nfet_01v8 L=0.6 W=1.4 AS=0.406
+ AD=0.406 PS=3.38 PD=3.38
M$465 \$157 cmc VSS sky130_gnd sky130_fd_pr__nfet_01v8 L=0.6 W=1.4 AS=0.406
+ AD=0.406 PS=3.38 PD=3.38
M$466 \$157 bias_a VSS sky130_gnd sky130_fd_pr__nfet_01v8 L=0.6 W=1.4 AS=0.406
+ AD=0.406 PS=3.38 PD=3.38
M$467 \$157 bias_a VSS sky130_gnd sky130_fd_pr__nfet_01v8 L=0.6 W=1.4 AS=0.406
+ AD=0.406 PS=3.38 PD=3.38
M$468 \$157 bias_a VSS sky130_gnd sky130_fd_pr__nfet_01v8 L=0.6 W=1.4 AS=0.406
+ AD=0.406 PS=3.38 PD=3.38
M$469 \$157 cmc VSS sky130_gnd sky130_fd_pr__nfet_01v8 L=0.6 W=1.4 AS=0.406
+ AD=0.406 PS=3.38 PD=3.38
M$470 \$157 cmc VSS sky130_gnd sky130_fd_pr__nfet_01v8 L=0.6 W=1.4 AS=0.406
+ AD=0.406 PS=3.38 PD=3.38
M$471 \$157 cmc VSS sky130_gnd sky130_fd_pr__nfet_01v8 L=0.6 W=1.4 AS=0.406
+ AD=0.406 PS=3.38 PD=3.38
M$472 \$157 cmc VSS sky130_gnd sky130_fd_pr__nfet_01v8 L=0.6 W=1.4 AS=0.406
+ AD=0.406 PS=3.38 PD=3.38
M$473 \$157 bias_a VSS sky130_gnd sky130_fd_pr__nfet_01v8 L=0.6 W=1.4 AS=0.406
+ AD=0.406 PS=3.38 PD=3.38
M$474 \$157 bias_a VSS sky130_gnd sky130_fd_pr__nfet_01v8 L=0.6 W=1.4 AS=0.406
+ AD=0.406 PS=3.38 PD=3.38
M$475 \$157 cmc VSS sky130_gnd sky130_fd_pr__nfet_01v8 L=0.6 W=1.4 AS=0.406
+ AD=0.406 PS=3.38 PD=3.38
M$476 \$157 cmc VSS sky130_gnd sky130_fd_pr__nfet_01v8 L=0.6 W=1.4 AS=0.406
+ AD=0.406 PS=3.38 PD=3.38
M$477 \$157 cmc VSS sky130_gnd sky130_fd_pr__nfet_01v8 L=0.6 W=1.4 AS=0.406
+ AD=0.406 PS=3.38 PD=3.38
M$478 \$157 cmc VSS sky130_gnd sky130_fd_pr__nfet_01v8 L=0.6 W=1.4 AS=0.406
+ AD=0.406 PS=3.38 PD=3.38
M$479 \$157 bias_a VSS sky130_gnd sky130_fd_pr__nfet_01v8 L=0.6 W=1.4 AS=0.406
+ AD=0.406 PS=3.38 PD=3.38
M$480 \$157 bias_a VSS sky130_gnd sky130_fd_pr__nfet_01v8 L=0.6 W=1.4 AS=0.406
+ AD=0.406 PS=3.38 PD=3.38
M$481 \$157 cmc VSS sky130_gnd sky130_fd_pr__nfet_01v8 L=0.6 W=1.4 AS=0.406
+ AD=0.406 PS=3.38 PD=3.38
M$482 \$157 cmc VSS sky130_gnd sky130_fd_pr__nfet_01v8 L=0.6 W=1.4 AS=0.406
+ AD=0.406 PS=3.38 PD=3.38
M$483 \$157 bias_a VSS sky130_gnd sky130_fd_pr__nfet_01v8 L=0.6 W=1.4 AS=0.406
+ AD=0.406 PS=3.38 PD=3.38
M$484 \$157 cmc VSS sky130_gnd sky130_fd_pr__nfet_01v8 L=0.6 W=1.4 AS=0.406
+ AD=0.406 PS=3.38 PD=3.38
M$485 \$157 bias_a VSS sky130_gnd sky130_fd_pr__nfet_01v8 L=0.6 W=1.4 AS=0.406
+ AD=0.406 PS=3.38 PD=3.38
M$486 \$157 cmc VSS sky130_gnd sky130_fd_pr__nfet_01v8 L=0.6 W=1.4 AS=0.406
+ AD=0.406 PS=3.38 PD=3.38
M$487 \$157 bias_a VSS sky130_gnd sky130_fd_pr__nfet_01v8 L=0.6 W=1.4 AS=0.406
+ AD=0.406 PS=3.38 PD=3.38
M$488 \$157 bias_a VSS sky130_gnd sky130_fd_pr__nfet_01v8 L=0.6 W=1.4 AS=0.406
+ AD=0.406 PS=3.38 PD=3.38
M$489 \$157 bias_a VSS sky130_gnd sky130_fd_pr__nfet_01v8 L=0.6 W=1.4 AS=0.406
+ AD=0.406 PS=3.38 PD=3.38
M$490 \$157 cmc VSS sky130_gnd sky130_fd_pr__nfet_01v8 L=0.6 W=1.4 AS=0.406
+ AD=0.406 PS=3.38 PD=3.38
M$491 \$157 bias_a VSS sky130_gnd sky130_fd_pr__nfet_01v8 L=0.6 W=1.4 AS=0.406
+ AD=0.406 PS=3.38 PD=3.38
M$492 \$157 cmc VSS sky130_gnd sky130_fd_pr__nfet_01v8 L=0.6 W=1.4 AS=0.406
+ AD=0.406 PS=3.38 PD=3.38
M$493 \$157 cmc VSS sky130_gnd sky130_fd_pr__nfet_01v8 L=0.6 W=1.4 AS=0.406
+ AD=0.406 PS=3.38 PD=3.38
M$494 \$157 bias_a VSS sky130_gnd sky130_fd_pr__nfet_01v8 L=0.6 W=1.4 AS=0.406
+ AD=0.406 PS=3.38 PD=3.38
M$495 \$157 bias_a VSS sky130_gnd sky130_fd_pr__nfet_01v8 L=0.6 W=1.4 AS=0.406
+ AD=0.406 PS=3.38 PD=3.38
M$496 \$157 cmc VSS sky130_gnd sky130_fd_pr__nfet_01v8 L=0.6 W=1.4 AS=0.406
+ AD=0.406 PS=3.38 PD=3.38
M$497 \$157 cmc VSS sky130_gnd sky130_fd_pr__nfet_01v8 L=0.6 W=1.4 AS=0.406
+ AD=0.406 PS=3.38 PD=3.38
M$498 \$157 bias_a VSS sky130_gnd sky130_fd_pr__nfet_01v8 L=0.6 W=1.4 AS=0.406
+ AD=0.406 PS=3.38 PD=3.38
M$499 \$157 bias_a VSS sky130_gnd sky130_fd_pr__nfet_01v8 L=0.6 W=1.4 AS=0.406
+ AD=0.406 PS=3.38 PD=3.38
M$500 \$157 cmc VSS sky130_gnd sky130_fd_pr__nfet_01v8 L=0.6 W=1.4 AS=0.406
+ AD=0.406 PS=3.38 PD=3.38
M$501 \$157 cmc VSS sky130_gnd sky130_fd_pr__nfet_01v8 L=0.6 W=1.4 AS=0.406
+ AD=0.406 PS=3.38 PD=3.38
M$502 \$157 bias_a VSS sky130_gnd sky130_fd_pr__nfet_01v8 L=0.6 W=1.4 AS=0.406
+ AD=0.406 PS=3.38 PD=3.38
M$503 \$157 bias_a VSS sky130_gnd sky130_fd_pr__nfet_01v8 L=0.6 W=1.4 AS=0.406
+ AD=0.406 PS=3.38 PD=3.38
M$504 \$157 cmc VSS sky130_gnd sky130_fd_pr__nfet_01v8 L=0.6 W=1.4 AS=0.406
+ AD=0.406 PS=3.38 PD=3.38
M$505 \$157 cmc VSS sky130_gnd sky130_fd_pr__nfet_01v8 L=0.6 W=1.4 AS=0.406
+ AD=0.406 PS=3.38 PD=3.38
M$506 \$157 bias_a VSS sky130_gnd sky130_fd_pr__nfet_01v8 L=0.6 W=1.4 AS=0.406
+ AD=0.406 PS=3.38 PD=3.38
M$507 \$157 bias_a VSS sky130_gnd sky130_fd_pr__nfet_01v8 L=0.6 W=1.4 AS=0.406
+ AD=0.406 PS=3.38 PD=3.38
M$508 \$157 cmc VSS sky130_gnd sky130_fd_pr__nfet_01v8 L=0.6 W=1.4 AS=0.406
+ AD=0.406 PS=3.38 PD=3.38
M$509 \$157 bias_a VSS sky130_gnd sky130_fd_pr__nfet_01v8 L=0.6 W=1.4 AS=0.406
+ AD=0.406 PS=3.38 PD=3.38
M$510 \$157 cmc VSS sky130_gnd sky130_fd_pr__nfet_01v8 L=0.6 W=1.4 AS=0.406
+ AD=0.406 PS=3.38 PD=3.38
M$511 \$157 bias_a VSS sky130_gnd sky130_fd_pr__nfet_01v8 L=0.6 W=1.4 AS=0.406
+ AD=0.406 PS=3.38 PD=3.38
M$512 \$157 cmc VSS sky130_gnd sky130_fd_pr__nfet_01v8 L=0.6 W=1.4 AS=0.406
+ AD=0.406 PS=3.38 PD=3.38
M$513 \$157 bias_a VSS sky130_gnd sky130_fd_pr__nfet_01v8 L=0.6 W=1.4 AS=0.406
+ AD=0.406 PS=3.38 PD=3.38
M$514 \$157 cmc VSS sky130_gnd sky130_fd_pr__nfet_01v8 L=0.6 W=1.4 AS=0.406
+ AD=0.406 PS=3.38 PD=3.38
M$515 \$157 bias_a VSS sky130_gnd sky130_fd_pr__nfet_01v8 L=0.6 W=1.4 AS=0.406
+ AD=0.406 PS=3.38 PD=3.38
M$516 \$157 cmc VSS sky130_gnd sky130_fd_pr__nfet_01v8 L=0.6 W=1.4 AS=0.406
+ AD=0.406 PS=3.38 PD=3.38
M$517 \$157 cmc VSS sky130_gnd sky130_fd_pr__nfet_01v8 L=0.6 W=1.4 AS=0.406
+ AD=0.406 PS=3.38 PD=3.38
M$518 \$157 bias_a VSS sky130_gnd sky130_fd_pr__nfet_01v8 L=0.6 W=1.4 AS=0.406
+ AD=0.406 PS=3.38 PD=3.38
M$519 \$157 bias_a VSS sky130_gnd sky130_fd_pr__nfet_01v8 L=0.6 W=1.4 AS=0.406
+ AD=0.406 PS=3.38 PD=3.38
M$520 \$157 bias_a VSS sky130_gnd sky130_fd_pr__nfet_01v8 L=0.6 W=1.4 AS=0.406
+ AD=0.406 PS=3.38 PD=3.38
M$521 \$157 cmc VSS sky130_gnd sky130_fd_pr__nfet_01v8 L=0.6 W=1.4 AS=0.406
+ AD=0.406 PS=3.38 PD=3.38
M$522 \$157 bias_a VSS sky130_gnd sky130_fd_pr__nfet_01v8 L=0.6 W=1.4 AS=0.406
+ AD=0.406 PS=3.38 PD=3.38
M$523 \$157 cmc VSS sky130_gnd sky130_fd_pr__nfet_01v8 L=0.6 W=1.4 AS=0.406
+ AD=0.406 PS=3.38 PD=3.38
M$524 \$157 bias_a VSS sky130_gnd sky130_fd_pr__nfet_01v8 L=0.6 W=1.4 AS=0.406
+ AD=0.406 PS=3.38 PD=3.38
M$525 \$157 cmc VSS sky130_gnd sky130_fd_pr__nfet_01v8 L=0.6 W=1.4 AS=0.406
+ AD=0.406 PS=3.38 PD=3.38
M$526 \$157 bias_a VSS sky130_gnd sky130_fd_pr__nfet_01v8 L=0.6 W=1.4 AS=0.406
+ AD=0.406 PS=3.38 PD=3.38
M$527 \$157 cmc VSS sky130_gnd sky130_fd_pr__nfet_01v8 L=0.6 W=1.4 AS=0.406
+ AD=0.406 PS=3.38 PD=3.38
M$528 \$157 bias_a VSS sky130_gnd sky130_fd_pr__nfet_01v8 L=0.6 W=1.4 AS=0.406
+ AD=0.406 PS=3.38 PD=3.38
M$529 \$157 cmc VSS sky130_gnd sky130_fd_pr__nfet_01v8 L=0.6 W=1.4 AS=0.406
+ AD=0.406 PS=3.38 PD=3.38
M$530 \$157 bias_a VSS sky130_gnd sky130_fd_pr__nfet_01v8 L=0.6 W=1.4 AS=0.406
+ AD=0.406 PS=3.38 PD=3.38
M$531 \$157 cmc VSS sky130_gnd sky130_fd_pr__nfet_01v8 L=0.6 W=1.4 AS=0.406
+ AD=0.406 PS=3.38 PD=3.38
M$532 \$157 bias_a VSS sky130_gnd sky130_fd_pr__nfet_01v8 L=0.6 W=1.4 AS=0.406
+ AD=0.406 PS=3.38 PD=3.38
M$533 \$157 cmc VSS sky130_gnd sky130_fd_pr__nfet_01v8 L=0.6 W=1.4 AS=0.406
+ AD=0.406 PS=3.38 PD=3.38
M$534 \$157 bias_a VSS sky130_gnd sky130_fd_pr__nfet_01v8 L=0.6 W=1.4 AS=0.406
+ AD=0.406 PS=3.38 PD=3.38
M$535 \$157 cmc VSS sky130_gnd sky130_fd_pr__nfet_01v8 L=0.6 W=1.4 AS=0.406
+ AD=0.406 PS=3.38 PD=3.38
M$536 \$157 bias_a VSS sky130_gnd sky130_fd_pr__nfet_01v8 L=0.6 W=1.4 AS=0.406
+ AD=0.406 PS=3.38 PD=3.38
M$537 \$157 cmc VSS sky130_gnd sky130_fd_pr__nfet_01v8 L=0.6 W=1.4 AS=0.406
+ AD=0.406 PS=3.38 PD=3.38
M$538 \$157 bias_a VSS sky130_gnd sky130_fd_pr__nfet_01v8 L=0.6 W=1.4 AS=0.406
+ AD=0.406 PS=3.38 PD=3.38
M$539 \$157 cmc VSS sky130_gnd sky130_fd_pr__nfet_01v8 L=0.6 W=1.4 AS=0.406
+ AD=0.406 PS=3.38 PD=3.38
M$540 \$157 bias_a VSS sky130_gnd sky130_fd_pr__nfet_01v8 L=0.6 W=1.4 AS=0.406
+ AD=0.406 PS=3.38 PD=3.38
M$541 \$157 cmc VSS sky130_gnd sky130_fd_pr__nfet_01v8 L=0.6 W=1.4 AS=0.406
+ AD=0.406 PS=3.38 PD=3.38
M$542 \$157 bias_a VSS sky130_gnd sky130_fd_pr__nfet_01v8 L=0.6 W=1.4 AS=0.406
+ AD=0.406 PS=3.38 PD=3.38
M$543 \$157 cmc VSS sky130_gnd sky130_fd_pr__nfet_01v8 L=0.6 W=1.4 AS=0.406
+ AD=0.406 PS=3.38 PD=3.38
M$544 \$157 cmc VSS sky130_gnd sky130_fd_pr__nfet_01v8 L=0.6 W=1.4 AS=0.406
+ AD=0.406 PS=3.38 PD=3.38
M$545 \$157 bias_a VSS sky130_gnd sky130_fd_pr__nfet_01v8 L=0.6 W=1.4 AS=0.406
+ AD=0.406 PS=3.38 PD=3.38
M$546 \$157 cmc VSS sky130_gnd sky130_fd_pr__nfet_01v8 L=0.6 W=1.4 AS=0.406
+ AD=0.406 PS=3.38 PD=3.38
M$547 \$157 bias_a VSS sky130_gnd sky130_fd_pr__nfet_01v8 L=0.6 W=1.4 AS=0.406
+ AD=0.406 PS=3.38 PD=3.38
M$548 \$157 cmc VSS sky130_gnd sky130_fd_pr__nfet_01v8 L=0.6 W=1.4 AS=0.406
+ AD=0.406 PS=3.38 PD=3.38
M$549 \$157 bias_a VSS sky130_gnd sky130_fd_pr__nfet_01v8 L=0.6 W=1.4 AS=0.406
+ AD=0.406 PS=3.38 PD=3.38
M$550 \$157 cmc VSS sky130_gnd sky130_fd_pr__nfet_01v8 L=0.6 W=1.4 AS=0.406
+ AD=0.406 PS=3.38 PD=3.38
M$551 \$157 bias_a VSS sky130_gnd sky130_fd_pr__nfet_01v8 L=0.6 W=1.4 AS=0.406
+ AD=0.406 PS=3.38 PD=3.38
M$552 \$157 cmc VSS sky130_gnd sky130_fd_pr__nfet_01v8 L=0.6 W=1.4 AS=0.406
+ AD=0.406 PS=3.38 PD=3.38
M$553 \$157 bias_a VSS sky130_gnd sky130_fd_pr__nfet_01v8 L=0.6 W=1.4 AS=0.406
+ AD=0.406 PS=3.38 PD=3.38
M$554 \$157 bias_a VSS sky130_gnd sky130_fd_pr__nfet_01v8 L=0.6 W=1.4 AS=0.406
+ AD=0.406 PS=3.38 PD=3.38
M$555 \$157 cmc VSS sky130_gnd sky130_fd_pr__nfet_01v8 L=0.6 W=1.4 AS=0.406
+ AD=0.406 PS=3.38 PD=3.38
M$556 \$157 cmc VSS sky130_gnd sky130_fd_pr__nfet_01v8 L=0.6 W=1.4 AS=0.406
+ AD=0.406 PS=3.38 PD=3.38
M$557 \$157 bias_a VSS sky130_gnd sky130_fd_pr__nfet_01v8 L=0.6 W=1.4 AS=0.406
+ AD=0.406 PS=3.38 PD=3.38
M$558 \$157 cmc VSS sky130_gnd sky130_fd_pr__nfet_01v8 L=0.6 W=1.4 AS=0.406
+ AD=0.406 PS=3.38 PD=3.38
M$559 \$157 bias_a VSS sky130_gnd sky130_fd_pr__nfet_01v8 L=0.6 W=1.4 AS=0.406
+ AD=0.406 PS=3.38 PD=3.38
M$560 \$157 cmc VSS sky130_gnd sky130_fd_pr__nfet_01v8 L=0.6 W=1.4 AS=0.406
+ AD=0.406 PS=3.38 PD=3.38
M$561 \$157 bias_a VSS sky130_gnd sky130_fd_pr__nfet_01v8 L=0.6 W=1.4 AS=0.406
+ AD=0.406 PS=3.38 PD=3.38
M$562 \$157 cmc VSS sky130_gnd sky130_fd_pr__nfet_01v8 L=0.6 W=1.4 AS=0.406
+ AD=0.406 PS=3.38 PD=3.38
M$563 \$157 bias_a VSS sky130_gnd sky130_fd_pr__nfet_01v8 L=0.6 W=1.4 AS=0.406
+ AD=0.406 PS=3.38 PD=3.38
M$564 \$157 cmc VSS sky130_gnd sky130_fd_pr__nfet_01v8 L=0.6 W=1.4 AS=0.406
+ AD=0.406 PS=3.38 PD=3.38
M$565 \$157 bias_a VSS sky130_gnd sky130_fd_pr__nfet_01v8 L=0.6 W=1.4 AS=0.406
+ AD=0.406 PS=3.38 PD=3.38
M$566 \$157 bias_a VSS sky130_gnd sky130_fd_pr__nfet_01v8 L=0.6 W=1.4 AS=0.406
+ AD=0.406 PS=3.38 PD=3.38
M$567 \$157 cmc VSS sky130_gnd sky130_fd_pr__nfet_01v8 L=0.6 W=1.4 AS=0.406
+ AD=0.406 PS=3.38 PD=3.38
M$568 \$150 IBIAS VSS sky130_gnd sky130_fd_pr__nfet_01v8 L=0.6 W=1.4 AS=0.406
+ AD=0.406 PS=3.38 PD=3.38
M$569 \$150 IBIAS VSS sky130_gnd sky130_fd_pr__nfet_01v8 L=0.6 W=1.4 AS=0.406
+ AD=0.406 PS=3.38 PD=3.38
M$570 \$150 IBIAS VSS sky130_gnd sky130_fd_pr__nfet_01v8 L=0.6 W=1.4 AS=0.406
+ AD=0.406 PS=3.38 PD=3.38
M$571 \$150 IBIAS VSS sky130_gnd sky130_fd_pr__nfet_01v8 L=0.6 W=1.4 AS=0.406
+ AD=0.406 PS=3.38 PD=3.38
M$572 \$150 IBIAS VSS sky130_gnd sky130_fd_pr__nfet_01v8 L=0.6 W=1.4 AS=0.406
+ AD=0.406 PS=3.38 PD=3.38
M$573 \$150 IBIAS VSS sky130_gnd sky130_fd_pr__nfet_01v8 L=0.6 W=1.4 AS=0.406
+ AD=0.406 PS=3.38 PD=3.38
M$574 \$150 IBIAS VSS sky130_gnd sky130_fd_pr__nfet_01v8 L=0.6 W=1.4 AS=0.406
+ AD=0.406 PS=3.38 PD=3.38
M$575 \$150 IBIAS VSS sky130_gnd sky130_fd_pr__nfet_01v8 L=0.6 W=1.4 AS=0.406
+ AD=0.406 PS=3.38 PD=3.38
M$576 \$150 IBIAS VSS sky130_gnd sky130_fd_pr__nfet_01v8 L=0.6 W=1.4 AS=0.406
+ AD=0.406 PS=3.38 PD=3.38
M$577 \$150 IBIAS VSS sky130_gnd sky130_fd_pr__nfet_01v8 L=0.6 W=1.4 AS=0.406
+ AD=0.406 PS=3.38 PD=3.38
M$578 \$150 IBIAS VSS sky130_gnd sky130_fd_pr__nfet_01v8 L=0.6 W=1.4 AS=0.406
+ AD=0.406 PS=3.38 PD=3.38
M$579 \$150 IBIAS VSS sky130_gnd sky130_fd_pr__nfet_01v8 L=0.6 W=1.4 AS=0.406
+ AD=0.406 PS=3.38 PD=3.38
M$580 \$150 IBIAS VSS sky130_gnd sky130_fd_pr__nfet_01v8 L=0.6 W=1.4 AS=0.406
+ AD=0.406 PS=3.38 PD=3.38
M$581 \$150 IBIAS VSS sky130_gnd sky130_fd_pr__nfet_01v8 L=0.6 W=1.4 AS=0.406
+ AD=0.406 PS=3.38 PD=3.38
M$582 \$150 IBIAS VSS sky130_gnd sky130_fd_pr__nfet_01v8 L=0.6 W=1.4 AS=0.406
+ AD=0.406 PS=3.38 PD=3.38
M$583 \$150 IBIAS VSS sky130_gnd sky130_fd_pr__nfet_01v8 L=0.6 W=1.4 AS=0.406
+ AD=0.406 PS=3.38 PD=3.38
M$584 \$150 IBIAS VSS sky130_gnd sky130_fd_pr__nfet_01v8 L=0.6 W=1.4 AS=0.406
+ AD=0.406 PS=3.38 PD=3.38
M$585 \$150 IBIAS VSS sky130_gnd sky130_fd_pr__nfet_01v8 L=0.6 W=1.4 AS=0.406
+ AD=0.406 PS=3.38 PD=3.38
M$586 IBIAS IBIAS VSS sky130_gnd sky130_fd_pr__nfet_01v8 L=0.6 W=1.4 AS=0.406
+ AD=0.406 PS=3.38 PD=3.38
M$587 IBIAS IBIAS VSS sky130_gnd sky130_fd_pr__nfet_01v8 L=0.6 W=1.4 AS=0.406
+ AD=0.406 PS=3.38 PD=3.38
M$588 IBIAS IBIAS VSS sky130_gnd sky130_fd_pr__nfet_01v8 L=0.6 W=1.4 AS=0.406
+ AD=0.406 PS=3.38 PD=3.38
M$589 IBIAS IBIAS VSS sky130_gnd sky130_fd_pr__nfet_01v8 L=0.6 W=1.4 AS=0.406
+ AD=0.406 PS=3.38 PD=3.38
M$590 IBIAS IBIAS VSS sky130_gnd sky130_fd_pr__nfet_01v8 L=0.6 W=1.4 AS=0.406
+ AD=0.406 PS=3.38 PD=3.38
M$591 IBIAS IBIAS VSS sky130_gnd sky130_fd_pr__nfet_01v8 L=0.6 W=1.4 AS=0.406
+ AD=0.406 PS=3.38 PD=3.38
M$592 IBIAS IBIAS VSS sky130_gnd sky130_fd_pr__nfet_01v8 L=0.6 W=1.4 AS=0.406
+ AD=0.406 PS=3.38 PD=3.38
M$593 IBIAS IBIAS VSS sky130_gnd sky130_fd_pr__nfet_01v8 L=0.6 W=1.4 AS=0.406
+ AD=0.406 PS=3.38 PD=3.38
M$594 IBIAS IBIAS VSS sky130_gnd sky130_fd_pr__nfet_01v8 L=0.6 W=1.4 AS=0.406
+ AD=0.406 PS=3.38 PD=3.38
M$595 IBIAS IBIAS VSS sky130_gnd sky130_fd_pr__nfet_01v8 L=0.6 W=1.4 AS=0.406
+ AD=0.406 PS=3.38 PD=3.38
M$596 IBIAS IBIAS VSS sky130_gnd sky130_fd_pr__nfet_01v8 L=0.6 W=1.4 AS=0.406
+ AD=0.406 PS=3.38 PD=3.38
M$597 IBIAS IBIAS VSS sky130_gnd sky130_fd_pr__nfet_01v8 L=0.6 W=1.4 AS=0.406
+ AD=0.406 PS=3.38 PD=3.38
M$598 IBIAS IBIAS VSS sky130_gnd sky130_fd_pr__nfet_01v8 L=0.6 W=1.4 AS=0.406
+ AD=0.406 PS=3.38 PD=3.38
M$599 IBIAS IBIAS VSS sky130_gnd sky130_fd_pr__nfet_01v8 L=0.6 W=1.4 AS=0.406
+ AD=0.406 PS=3.38 PD=3.38
M$600 IBIAS IBIAS VSS sky130_gnd sky130_fd_pr__nfet_01v8 L=0.6 W=1.4 AS=0.406
+ AD=0.406 PS=3.38 PD=3.38
M$601 IBIAS IBIAS VSS sky130_gnd sky130_fd_pr__nfet_01v8 L=0.6 W=1.4 AS=0.406
+ AD=0.406 PS=3.38 PD=3.38
M$602 IBIAS IBIAS VSS sky130_gnd sky130_fd_pr__nfet_01v8 L=0.6 W=1.4 AS=0.406
+ AD=0.406 PS=3.38 PD=3.38
M$603 IBIAS IBIAS VSS sky130_gnd sky130_fd_pr__nfet_01v8 L=0.6 W=1.4 AS=0.406
+ AD=0.406 PS=3.38 PD=3.38
M$604 bias_a \$11 \$1 sky130_gnd sky130_fd_pr__nfet_01v8 L=0.6 W=1.4 AS=0.406
+ AD=0.406 PS=3.38 PD=3.38
M$605 bias_a \$11 \$1 sky130_gnd sky130_fd_pr__nfet_01v8 L=0.6 W=1.4 AS=0.406
+ AD=0.406 PS=3.38 PD=3.38
M$606 bias_a \$11 \$1 sky130_gnd sky130_fd_pr__nfet_01v8 L=0.6 W=1.4 AS=0.406
+ AD=0.406 PS=3.38 PD=3.38
M$607 bias_a \$11 \$1 sky130_gnd sky130_fd_pr__nfet_01v8 L=0.6 W=1.4 AS=0.406
+ AD=0.406 PS=3.38 PD=3.38
M$608 bias_a \$11 \$1 sky130_gnd sky130_fd_pr__nfet_01v8 L=0.6 W=1.4 AS=0.406
+ AD=0.406 PS=3.38 PD=3.38
M$609 bias_a \$11 \$1 sky130_gnd sky130_fd_pr__nfet_01v8 L=0.6 W=1.4 AS=0.406
+ AD=0.406 PS=3.38 PD=3.38
M$610 bias_a \$11 \$1 sky130_gnd sky130_fd_pr__nfet_01v8 L=0.6 W=1.4 AS=0.406
+ AD=0.406 PS=3.38 PD=3.38
M$611 bias_a \$11 \$1 sky130_gnd sky130_fd_pr__nfet_01v8 L=0.6 W=1.4 AS=0.406
+ AD=0.406 PS=3.38 PD=3.38
M$612 bias_a \$11 \$1 sky130_gnd sky130_fd_pr__nfet_01v8 L=0.6 W=1.4 AS=0.406
+ AD=0.406 PS=3.38 PD=3.38
M$613 bias_a \$11 \$1 sky130_gnd sky130_fd_pr__nfet_01v8 L=0.6 W=1.4 AS=0.406
+ AD=0.406 PS=3.38 PD=3.38
M$614 bias_a \$11 \$1 sky130_gnd sky130_fd_pr__nfet_01v8 L=0.6 W=1.4 AS=0.406
+ AD=0.406 PS=3.38 PD=3.38
M$615 bias_a \$11 \$1 sky130_gnd sky130_fd_pr__nfet_01v8 L=0.6 W=1.4 AS=0.406
+ AD=0.406 PS=3.38 PD=3.38
M$616 bias_a \$11 \$1 sky130_gnd sky130_fd_pr__nfet_01v8 L=0.6 W=1.4 AS=0.406
+ AD=0.406 PS=3.38 PD=3.38
M$617 bias_a \$11 \$1 sky130_gnd sky130_fd_pr__nfet_01v8 L=0.6 W=1.4 AS=0.406
+ AD=0.406 PS=3.38 PD=3.38
M$618 bias_a \$11 \$1 sky130_gnd sky130_fd_pr__nfet_01v8 L=0.6 W=1.4 AS=0.406
+ AD=0.406 PS=3.38 PD=3.38
M$619 bias_a \$11 \$1 sky130_gnd sky130_fd_pr__nfet_01v8 L=0.6 W=1.4 AS=0.406
+ AD=0.406 PS=3.38 PD=3.38
M$620 bias_a \$11 \$1 sky130_gnd sky130_fd_pr__nfet_01v8 L=0.6 W=1.4 AS=0.406
+ AD=0.406 PS=3.38 PD=3.38
M$621 bias_a \$11 \$1 sky130_gnd sky130_fd_pr__nfet_01v8 L=0.6 W=1.4 AS=0.406
+ AD=0.406 PS=3.38 PD=3.38
M$622 \$1 bias_a VSS sky130_gnd sky130_fd_pr__nfet_01v8 L=0.6 W=1.4 AS=0.406
+ AD=0.406 PS=3.38 PD=3.38
M$623 \$1 bias_a VSS sky130_gnd sky130_fd_pr__nfet_01v8 L=0.6 W=1.4 AS=0.406
+ AD=0.406 PS=3.38 PD=3.38
M$624 \$1 bias_a VSS sky130_gnd sky130_fd_pr__nfet_01v8 L=0.6 W=1.4 AS=0.406
+ AD=0.406 PS=3.38 PD=3.38
M$625 \$1 bias_a VSS sky130_gnd sky130_fd_pr__nfet_01v8 L=0.6 W=1.4 AS=0.406
+ AD=0.406 PS=3.38 PD=3.38
M$626 \$1 bias_a VSS sky130_gnd sky130_fd_pr__nfet_01v8 L=0.6 W=1.4 AS=0.406
+ AD=0.406 PS=3.38 PD=3.38
M$627 \$1 bias_a VSS sky130_gnd sky130_fd_pr__nfet_01v8 L=0.6 W=1.4 AS=0.406
+ AD=0.406 PS=3.38 PD=3.38
M$628 \$1 bias_a VSS sky130_gnd sky130_fd_pr__nfet_01v8 L=0.6 W=1.4 AS=0.406
+ AD=0.406 PS=3.38 PD=3.38
M$629 \$1 bias_a VSS sky130_gnd sky130_fd_pr__nfet_01v8 L=0.6 W=1.4 AS=0.406
+ AD=0.406 PS=3.38 PD=3.38
M$630 \$1 bias_a VSS sky130_gnd sky130_fd_pr__nfet_01v8 L=0.6 W=1.4 AS=0.406
+ AD=0.406 PS=3.38 PD=3.38
M$631 \$1 bias_a VSS sky130_gnd sky130_fd_pr__nfet_01v8 L=0.6 W=1.4 AS=0.406
+ AD=0.406 PS=3.38 PD=3.38
M$632 \$1 bias_a VSS sky130_gnd sky130_fd_pr__nfet_01v8 L=0.6 W=1.4 AS=0.406
+ AD=0.406 PS=3.38 PD=3.38
M$633 \$1 bias_a VSS sky130_gnd sky130_fd_pr__nfet_01v8 L=0.6 W=1.4 AS=0.406
+ AD=0.406 PS=3.38 PD=3.38
M$634 \$1 bias_a VSS sky130_gnd sky130_fd_pr__nfet_01v8 L=0.6 W=1.4 AS=0.406
+ AD=0.406 PS=3.38 PD=3.38
M$635 \$1 bias_a VSS sky130_gnd sky130_fd_pr__nfet_01v8 L=0.6 W=1.4 AS=0.406
+ AD=0.406 PS=3.38 PD=3.38
M$636 \$1 bias_a VSS sky130_gnd sky130_fd_pr__nfet_01v8 L=0.6 W=1.4 AS=0.406
+ AD=0.406 PS=3.38 PD=3.38
M$637 \$1 bias_a VSS sky130_gnd sky130_fd_pr__nfet_01v8 L=0.6 W=1.4 AS=0.406
+ AD=0.406 PS=3.38 PD=3.38
M$638 \$1 bias_a VSS sky130_gnd sky130_fd_pr__nfet_01v8 L=0.6 W=1.4 AS=0.406
+ AD=0.406 PS=3.38 PD=3.38
M$639 \$1 bias_a VSS sky130_gnd sky130_fd_pr__nfet_01v8 L=0.6 W=1.4 AS=0.406
+ AD=0.406 PS=3.38 PD=3.38
M$640 \$77 bias_a VSS sky130_gnd sky130_fd_pr__nfet_01v8 L=0.6 W=1.4 AS=0.406
+ AD=0.406 PS=3.38 PD=3.38
M$641 \$77 bias_a VSS sky130_gnd sky130_fd_pr__nfet_01v8 L=0.6 W=1.4 AS=0.406
+ AD=0.406 PS=3.38 PD=3.38
M$642 \$77 bias_a VSS sky130_gnd sky130_fd_pr__nfet_01v8 L=0.6 W=1.4 AS=0.406
+ AD=0.406 PS=3.38 PD=3.38
M$643 \$77 bias_a VSS sky130_gnd sky130_fd_pr__nfet_01v8 L=0.6 W=1.4 AS=0.406
+ AD=0.406 PS=3.38 PD=3.38
M$644 \$77 bias_a VSS sky130_gnd sky130_fd_pr__nfet_01v8 L=0.6 W=1.4 AS=0.406
+ AD=0.406 PS=3.38 PD=3.38
M$645 \$77 bias_a VSS sky130_gnd sky130_fd_pr__nfet_01v8 L=0.6 W=1.4 AS=0.406
+ AD=0.406 PS=3.38 PD=3.38
M$646 \$77 bias_a VSS sky130_gnd sky130_fd_pr__nfet_01v8 L=0.6 W=1.4 AS=0.406
+ AD=0.406 PS=3.38 PD=3.38
M$647 \$77 bias_a VSS sky130_gnd sky130_fd_pr__nfet_01v8 L=0.6 W=1.4 AS=0.406
+ AD=0.406 PS=3.38 PD=3.38
M$648 \$77 bias_a VSS sky130_gnd sky130_fd_pr__nfet_01v8 L=0.6 W=1.4 AS=0.406
+ AD=0.406 PS=3.38 PD=3.38
M$649 \$77 bias_a VSS sky130_gnd sky130_fd_pr__nfet_01v8 L=0.6 W=1.4 AS=0.406
+ AD=0.406 PS=3.38 PD=3.38
M$650 \$77 bias_a VSS sky130_gnd sky130_fd_pr__nfet_01v8 L=0.6 W=1.4 AS=0.406
+ AD=0.406 PS=3.38 PD=3.38
M$651 \$77 bias_a VSS sky130_gnd sky130_fd_pr__nfet_01v8 L=0.6 W=1.4 AS=0.406
+ AD=0.406 PS=3.38 PD=3.38
M$652 \$77 bias_a VSS sky130_gnd sky130_fd_pr__nfet_01v8 L=0.6 W=1.4 AS=0.406
+ AD=0.406 PS=3.38 PD=3.38
M$653 \$77 bias_a VSS sky130_gnd sky130_fd_pr__nfet_01v8 L=0.6 W=1.4 AS=0.406
+ AD=0.406 PS=3.38 PD=3.38
M$654 \$77 bias_a VSS sky130_gnd sky130_fd_pr__nfet_01v8 L=0.6 W=1.4 AS=0.406
+ AD=0.406 PS=3.38 PD=3.38
M$655 \$77 bias_a VSS sky130_gnd sky130_fd_pr__nfet_01v8 L=0.6 W=1.4 AS=0.406
+ AD=0.406 PS=3.38 PD=3.38
M$656 \$77 bias_a VSS sky130_gnd sky130_fd_pr__nfet_01v8 L=0.6 W=1.4 AS=0.406
+ AD=0.406 PS=3.38 PD=3.38
M$657 \$77 bias_a VSS sky130_gnd sky130_fd_pr__nfet_01v8 L=0.6 W=1.4 AS=0.406
+ AD=0.406 PS=3.38 PD=3.38
M$658 \$77 bias_a VSS sky130_gnd sky130_fd_pr__nfet_01v8 L=0.6 W=1.4 AS=0.406
+ AD=0.406 PS=3.38 PD=3.38
M$659 \$77 bias_a VSS sky130_gnd sky130_fd_pr__nfet_01v8 L=0.6 W=1.4 AS=0.406
+ AD=0.406 PS=3.38 PD=3.38
M$660 \$77 bias_a VSS sky130_gnd sky130_fd_pr__nfet_01v8 L=0.6 W=1.4 AS=0.406
+ AD=0.406 PS=3.38 PD=3.38
M$661 \$77 bias_a VSS sky130_gnd sky130_fd_pr__nfet_01v8 L=0.6 W=1.4 AS=0.406
+ AD=0.406 PS=3.38 PD=3.38
M$662 \$77 bias_a VSS sky130_gnd sky130_fd_pr__nfet_01v8 L=0.6 W=1.4 AS=0.406
+ AD=0.406 PS=3.38 PD=3.38
M$663 \$77 bias_a VSS sky130_gnd sky130_fd_pr__nfet_01v8 L=0.6 W=1.4 AS=0.406
+ AD=0.406 PS=3.38 PD=3.38
M$664 \$77 bias_a VSS sky130_gnd sky130_fd_pr__nfet_01v8 L=0.6 W=1.4 AS=0.406
+ AD=0.406 PS=3.38 PD=3.38
M$665 \$77 bias_a VSS sky130_gnd sky130_fd_pr__nfet_01v8 L=0.6 W=1.4 AS=0.406
+ AD=0.406 PS=3.38 PD=3.38
M$666 \$77 bias_a VSS sky130_gnd sky130_fd_pr__nfet_01v8 L=0.6 W=1.4 AS=0.406
+ AD=0.406 PS=3.38 PD=3.38
M$667 \$77 bias_a VSS sky130_gnd sky130_fd_pr__nfet_01v8 L=0.6 W=1.4 AS=0.406
+ AD=0.406 PS=3.38 PD=3.38
M$668 \$77 bias_a VSS sky130_gnd sky130_fd_pr__nfet_01v8 L=0.6 W=1.4 AS=0.406
+ AD=0.406 PS=3.38 PD=3.38
M$669 \$77 bias_a VSS sky130_gnd sky130_fd_pr__nfet_01v8 L=0.6 W=1.4 AS=0.406
+ AD=0.406 PS=3.38 PD=3.38
M$670 \$77 bias_a VSS sky130_gnd sky130_fd_pr__nfet_01v8 L=0.6 W=1.4 AS=0.406
+ AD=0.406 PS=3.38 PD=3.38
M$671 \$77 bias_a VSS sky130_gnd sky130_fd_pr__nfet_01v8 L=0.6 W=1.4 AS=0.406
+ AD=0.406 PS=3.38 PD=3.38
M$672 \$77 bias_a VSS sky130_gnd sky130_fd_pr__nfet_01v8 L=0.6 W=1.4 AS=0.406
+ AD=0.406 PS=3.38 PD=3.38
M$673 \$77 bias_a VSS sky130_gnd sky130_fd_pr__nfet_01v8 L=0.6 W=1.4 AS=0.406
+ AD=0.406 PS=3.38 PD=3.38
M$674 \$77 bias_a VSS sky130_gnd sky130_fd_pr__nfet_01v8 L=0.6 W=1.4 AS=0.406
+ AD=0.406 PS=3.38 PD=3.38
M$675 \$77 bias_a VSS sky130_gnd sky130_fd_pr__nfet_01v8 L=0.6 W=1.4 AS=0.406
+ AD=0.406 PS=3.38 PD=3.38
M$676 \$76 bias_a VSS sky130_gnd sky130_fd_pr__nfet_01v8 L=0.6 W=1.4 AS=0.406
+ AD=0.406 PS=3.38 PD=3.38
M$677 \$76 bias_a VSS sky130_gnd sky130_fd_pr__nfet_01v8 L=0.6 W=1.4 AS=0.406
+ AD=0.406 PS=3.38 PD=3.38
M$678 \$76 bias_a VSS sky130_gnd sky130_fd_pr__nfet_01v8 L=0.6 W=1.4 AS=0.406
+ AD=0.406 PS=3.38 PD=3.38
M$679 \$76 bias_a VSS sky130_gnd sky130_fd_pr__nfet_01v8 L=0.6 W=1.4 AS=0.406
+ AD=0.406 PS=3.38 PD=3.38
M$680 \$76 bias_a VSS sky130_gnd sky130_fd_pr__nfet_01v8 L=0.6 W=1.4 AS=0.406
+ AD=0.406 PS=3.38 PD=3.38
M$681 \$76 bias_a VSS sky130_gnd sky130_fd_pr__nfet_01v8 L=0.6 W=1.4 AS=0.406
+ AD=0.406 PS=3.38 PD=3.38
M$682 \$76 bias_a VSS sky130_gnd sky130_fd_pr__nfet_01v8 L=0.6 W=1.4 AS=0.406
+ AD=0.406 PS=3.38 PD=3.38
M$683 \$76 bias_a VSS sky130_gnd sky130_fd_pr__nfet_01v8 L=0.6 W=1.4 AS=0.406
+ AD=0.406 PS=3.38 PD=3.38
M$684 \$76 bias_a VSS sky130_gnd sky130_fd_pr__nfet_01v8 L=0.6 W=1.4 AS=0.406
+ AD=0.406 PS=3.38 PD=3.38
M$685 \$76 bias_a VSS sky130_gnd sky130_fd_pr__nfet_01v8 L=0.6 W=1.4 AS=0.406
+ AD=0.406 PS=3.38 PD=3.38
M$686 \$76 bias_a VSS sky130_gnd sky130_fd_pr__nfet_01v8 L=0.6 W=1.4 AS=0.406
+ AD=0.406 PS=3.38 PD=3.38
M$687 \$76 bias_a VSS sky130_gnd sky130_fd_pr__nfet_01v8 L=0.6 W=1.4 AS=0.406
+ AD=0.406 PS=3.38 PD=3.38
M$688 \$76 bias_a VSS sky130_gnd sky130_fd_pr__nfet_01v8 L=0.6 W=1.4 AS=0.406
+ AD=0.406 PS=3.38 PD=3.38
M$689 \$76 bias_a VSS sky130_gnd sky130_fd_pr__nfet_01v8 L=0.6 W=1.4 AS=0.406
+ AD=0.406 PS=3.38 PD=3.38
M$690 \$76 bias_a VSS sky130_gnd sky130_fd_pr__nfet_01v8 L=0.6 W=1.4 AS=0.406
+ AD=0.406 PS=3.38 PD=3.38
M$691 \$76 bias_a VSS sky130_gnd sky130_fd_pr__nfet_01v8 L=0.6 W=1.4 AS=0.406
+ AD=0.406 PS=3.38 PD=3.38
M$692 \$76 bias_a VSS sky130_gnd sky130_fd_pr__nfet_01v8 L=0.6 W=1.4 AS=0.406
+ AD=0.406 PS=3.38 PD=3.38
M$693 \$76 bias_a VSS sky130_gnd sky130_fd_pr__nfet_01v8 L=0.6 W=1.4 AS=0.406
+ AD=0.406 PS=3.38 PD=3.38
M$694 \$76 bias_a VSS sky130_gnd sky130_fd_pr__nfet_01v8 L=0.6 W=1.4 AS=0.406
+ AD=0.406 PS=3.38 PD=3.38
M$695 \$76 bias_a VSS sky130_gnd sky130_fd_pr__nfet_01v8 L=0.6 W=1.4 AS=0.406
+ AD=0.406 PS=3.38 PD=3.38
M$696 \$76 bias_a VSS sky130_gnd sky130_fd_pr__nfet_01v8 L=0.6 W=1.4 AS=0.406
+ AD=0.406 PS=3.38 PD=3.38
M$697 \$76 bias_a VSS sky130_gnd sky130_fd_pr__nfet_01v8 L=0.6 W=1.4 AS=0.406
+ AD=0.406 PS=3.38 PD=3.38
M$698 \$76 bias_a VSS sky130_gnd sky130_fd_pr__nfet_01v8 L=0.6 W=1.4 AS=0.406
+ AD=0.406 PS=3.38 PD=3.38
M$699 \$76 bias_a VSS sky130_gnd sky130_fd_pr__nfet_01v8 L=0.6 W=1.4 AS=0.406
+ AD=0.406 PS=3.38 PD=3.38
M$700 \$76 bias_a VSS sky130_gnd sky130_fd_pr__nfet_01v8 L=0.6 W=1.4 AS=0.406
+ AD=0.406 PS=3.38 PD=3.38
M$701 \$76 bias_a VSS sky130_gnd sky130_fd_pr__nfet_01v8 L=0.6 W=1.4 AS=0.406
+ AD=0.406 PS=3.38 PD=3.38
M$702 \$76 bias_a VSS sky130_gnd sky130_fd_pr__nfet_01v8 L=0.6 W=1.4 AS=0.406
+ AD=0.406 PS=3.38 PD=3.38
M$703 \$76 bias_a VSS sky130_gnd sky130_fd_pr__nfet_01v8 L=0.6 W=1.4 AS=0.406
+ AD=0.406 PS=3.38 PD=3.38
M$704 \$76 bias_a VSS sky130_gnd sky130_fd_pr__nfet_01v8 L=0.6 W=1.4 AS=0.406
+ AD=0.406 PS=3.38 PD=3.38
M$705 \$76 bias_a VSS sky130_gnd sky130_fd_pr__nfet_01v8 L=0.6 W=1.4 AS=0.406
+ AD=0.406 PS=3.38 PD=3.38
M$706 \$76 bias_a VSS sky130_gnd sky130_fd_pr__nfet_01v8 L=0.6 W=1.4 AS=0.406
+ AD=0.406 PS=3.38 PD=3.38
M$707 \$76 bias_a VSS sky130_gnd sky130_fd_pr__nfet_01v8 L=0.6 W=1.4 AS=0.406
+ AD=0.406 PS=3.38 PD=3.38
M$708 \$76 bias_a VSS sky130_gnd sky130_fd_pr__nfet_01v8 L=0.6 W=1.4 AS=0.406
+ AD=0.406 PS=3.38 PD=3.38
M$709 \$76 bias_a VSS sky130_gnd sky130_fd_pr__nfet_01v8 L=0.6 W=1.4 AS=0.406
+ AD=0.406 PS=3.38 PD=3.38
M$710 \$76 bias_a VSS sky130_gnd sky130_fd_pr__nfet_01v8 L=0.6 W=1.4 AS=0.406
+ AD=0.406 PS=3.38 PD=3.38
M$711 \$76 bias_a VSS sky130_gnd sky130_fd_pr__nfet_01v8 L=0.6 W=1.4 AS=0.406
+ AD=0.406 PS=3.38 PD=3.38
M$712 op \$11 \$77 sky130_gnd sky130_fd_pr__nfet_01v8 L=0.6 W=1.4 AS=0.406
+ AD=0.406 PS=3.38 PD=3.38
M$713 op \$11 \$77 sky130_gnd sky130_fd_pr__nfet_01v8 L=0.6 W=1.4 AS=0.406
+ AD=0.406 PS=3.38 PD=3.38
M$714 op \$11 \$77 sky130_gnd sky130_fd_pr__nfet_01v8 L=0.6 W=1.4 AS=0.406
+ AD=0.406 PS=3.38 PD=3.38
M$715 op \$11 \$77 sky130_gnd sky130_fd_pr__nfet_01v8 L=0.6 W=1.4 AS=0.406
+ AD=0.406 PS=3.38 PD=3.38
M$716 op \$11 \$77 sky130_gnd sky130_fd_pr__nfet_01v8 L=0.6 W=1.4 AS=0.406
+ AD=0.406 PS=3.38 PD=3.38
M$717 op \$11 \$77 sky130_gnd sky130_fd_pr__nfet_01v8 L=0.6 W=1.4 AS=0.406
+ AD=0.406 PS=3.38 PD=3.38
M$718 op \$11 \$77 sky130_gnd sky130_fd_pr__nfet_01v8 L=0.6 W=1.4 AS=0.406
+ AD=0.406 PS=3.38 PD=3.38
M$719 op \$11 \$77 sky130_gnd sky130_fd_pr__nfet_01v8 L=0.6 W=1.4 AS=0.406
+ AD=0.406 PS=3.38 PD=3.38
M$720 op \$11 \$77 sky130_gnd sky130_fd_pr__nfet_01v8 L=0.6 W=1.4 AS=0.406
+ AD=0.406 PS=3.38 PD=3.38
M$721 op \$11 \$77 sky130_gnd sky130_fd_pr__nfet_01v8 L=0.6 W=1.4 AS=0.406
+ AD=0.406 PS=3.38 PD=3.38
M$722 op \$11 \$77 sky130_gnd sky130_fd_pr__nfet_01v8 L=0.6 W=1.4 AS=0.406
+ AD=0.406 PS=3.38 PD=3.38
M$723 op \$11 \$77 sky130_gnd sky130_fd_pr__nfet_01v8 L=0.6 W=1.4 AS=0.406
+ AD=0.406 PS=3.38 PD=3.38
M$724 op \$11 \$77 sky130_gnd sky130_fd_pr__nfet_01v8 L=0.6 W=1.4 AS=0.406
+ AD=0.406 PS=3.38 PD=3.38
M$725 op \$11 \$77 sky130_gnd sky130_fd_pr__nfet_01v8 L=0.6 W=1.4 AS=0.406
+ AD=0.406 PS=3.38 PD=3.38
M$726 op \$11 \$77 sky130_gnd sky130_fd_pr__nfet_01v8 L=0.6 W=1.4 AS=0.406
+ AD=0.406 PS=3.38 PD=3.38
M$727 op \$11 \$77 sky130_gnd sky130_fd_pr__nfet_01v8 L=0.6 W=1.4 AS=0.406
+ AD=0.406 PS=3.38 PD=3.38
M$728 op \$11 \$77 sky130_gnd sky130_fd_pr__nfet_01v8 L=0.6 W=1.4 AS=0.406
+ AD=0.406 PS=3.38 PD=3.38
M$729 op \$11 \$77 sky130_gnd sky130_fd_pr__nfet_01v8 L=0.6 W=1.4 AS=0.406
+ AD=0.406 PS=3.38 PD=3.38
M$730 op \$11 \$77 sky130_gnd sky130_fd_pr__nfet_01v8 L=0.6 W=1.4 AS=0.406
+ AD=0.406 PS=3.38 PD=3.38
M$731 op \$11 \$77 sky130_gnd sky130_fd_pr__nfet_01v8 L=0.6 W=1.4 AS=0.406
+ AD=0.406 PS=3.38 PD=3.38
M$732 op \$11 \$77 sky130_gnd sky130_fd_pr__nfet_01v8 L=0.6 W=1.4 AS=0.406
+ AD=0.406 PS=3.38 PD=3.38
M$733 op \$11 \$77 sky130_gnd sky130_fd_pr__nfet_01v8 L=0.6 W=1.4 AS=0.406
+ AD=0.406 PS=3.38 PD=3.38
M$734 op \$11 \$77 sky130_gnd sky130_fd_pr__nfet_01v8 L=0.6 W=1.4 AS=0.406
+ AD=0.406 PS=3.38 PD=3.38
M$735 op \$11 \$77 sky130_gnd sky130_fd_pr__nfet_01v8 L=0.6 W=1.4 AS=0.406
+ AD=0.406 PS=3.38 PD=3.38
M$736 op \$11 \$77 sky130_gnd sky130_fd_pr__nfet_01v8 L=0.6 W=1.4 AS=0.406
+ AD=0.406 PS=3.38 PD=3.38
M$737 op \$11 \$77 sky130_gnd sky130_fd_pr__nfet_01v8 L=0.6 W=1.4 AS=0.406
+ AD=0.406 PS=3.38 PD=3.38
M$738 op \$11 \$77 sky130_gnd sky130_fd_pr__nfet_01v8 L=0.6 W=1.4 AS=0.406
+ AD=0.406 PS=3.38 PD=3.38
M$739 op \$11 \$77 sky130_gnd sky130_fd_pr__nfet_01v8 L=0.6 W=1.4 AS=0.406
+ AD=0.406 PS=3.38 PD=3.38
M$740 op \$11 \$77 sky130_gnd sky130_fd_pr__nfet_01v8 L=0.6 W=1.4 AS=0.406
+ AD=0.406 PS=3.38 PD=3.38
M$741 op \$11 \$77 sky130_gnd sky130_fd_pr__nfet_01v8 L=0.6 W=1.4 AS=0.406
+ AD=0.406 PS=3.38 PD=3.38
M$742 op \$11 \$77 sky130_gnd sky130_fd_pr__nfet_01v8 L=0.6 W=1.4 AS=0.406
+ AD=0.406 PS=3.38 PD=3.38
M$743 op \$11 \$77 sky130_gnd sky130_fd_pr__nfet_01v8 L=0.6 W=1.4 AS=0.406
+ AD=0.406 PS=3.38 PD=3.38
M$744 op \$11 \$77 sky130_gnd sky130_fd_pr__nfet_01v8 L=0.6 W=1.4 AS=0.406
+ AD=0.406 PS=3.38 PD=3.38
M$745 op \$11 \$77 sky130_gnd sky130_fd_pr__nfet_01v8 L=0.6 W=1.4 AS=0.406
+ AD=0.406 PS=3.38 PD=3.38
M$746 op \$11 \$77 sky130_gnd sky130_fd_pr__nfet_01v8 L=0.6 W=1.4 AS=0.406
+ AD=0.406 PS=3.38 PD=3.38
M$747 op \$11 \$77 sky130_gnd sky130_fd_pr__nfet_01v8 L=0.6 W=1.4 AS=0.406
+ AD=0.406 PS=3.38 PD=3.38
M$748 on \$11 \$76 sky130_gnd sky130_fd_pr__nfet_01v8 L=0.6 W=1.4 AS=0.406
+ AD=0.406 PS=3.38 PD=3.38
M$749 on \$11 \$76 sky130_gnd sky130_fd_pr__nfet_01v8 L=0.6 W=1.4 AS=0.406
+ AD=0.406 PS=3.38 PD=3.38
M$750 on \$11 \$76 sky130_gnd sky130_fd_pr__nfet_01v8 L=0.6 W=1.4 AS=0.406
+ AD=0.406 PS=3.38 PD=3.38
M$751 on \$11 \$76 sky130_gnd sky130_fd_pr__nfet_01v8 L=0.6 W=1.4 AS=0.406
+ AD=0.406 PS=3.38 PD=3.38
M$752 on \$11 \$76 sky130_gnd sky130_fd_pr__nfet_01v8 L=0.6 W=1.4 AS=0.406
+ AD=0.406 PS=3.38 PD=3.38
M$753 on \$11 \$76 sky130_gnd sky130_fd_pr__nfet_01v8 L=0.6 W=1.4 AS=0.406
+ AD=0.406 PS=3.38 PD=3.38
M$754 on \$11 \$76 sky130_gnd sky130_fd_pr__nfet_01v8 L=0.6 W=1.4 AS=0.406
+ AD=0.406 PS=3.38 PD=3.38
M$755 on \$11 \$76 sky130_gnd sky130_fd_pr__nfet_01v8 L=0.6 W=1.4 AS=0.406
+ AD=0.406 PS=3.38 PD=3.38
M$756 on \$11 \$76 sky130_gnd sky130_fd_pr__nfet_01v8 L=0.6 W=1.4 AS=0.406
+ AD=0.406 PS=3.38 PD=3.38
M$757 on \$11 \$76 sky130_gnd sky130_fd_pr__nfet_01v8 L=0.6 W=1.4 AS=0.406
+ AD=0.406 PS=3.38 PD=3.38
M$758 on \$11 \$76 sky130_gnd sky130_fd_pr__nfet_01v8 L=0.6 W=1.4 AS=0.406
+ AD=0.406 PS=3.38 PD=3.38
M$759 on \$11 \$76 sky130_gnd sky130_fd_pr__nfet_01v8 L=0.6 W=1.4 AS=0.406
+ AD=0.406 PS=3.38 PD=3.38
M$760 on \$11 \$76 sky130_gnd sky130_fd_pr__nfet_01v8 L=0.6 W=1.4 AS=0.406
+ AD=0.406 PS=3.38 PD=3.38
M$761 on \$11 \$76 sky130_gnd sky130_fd_pr__nfet_01v8 L=0.6 W=1.4 AS=0.406
+ AD=0.406 PS=3.38 PD=3.38
M$762 on \$11 \$76 sky130_gnd sky130_fd_pr__nfet_01v8 L=0.6 W=1.4 AS=0.406
+ AD=0.406 PS=3.38 PD=3.38
M$763 on \$11 \$76 sky130_gnd sky130_fd_pr__nfet_01v8 L=0.6 W=1.4 AS=0.406
+ AD=0.406 PS=3.38 PD=3.38
M$764 on \$11 \$76 sky130_gnd sky130_fd_pr__nfet_01v8 L=0.6 W=1.4 AS=0.406
+ AD=0.406 PS=3.38 PD=3.38
M$765 on \$11 \$76 sky130_gnd sky130_fd_pr__nfet_01v8 L=0.6 W=1.4 AS=0.406
+ AD=0.406 PS=3.38 PD=3.38
M$766 on \$11 \$76 sky130_gnd sky130_fd_pr__nfet_01v8 L=0.6 W=1.4 AS=0.406
+ AD=0.406 PS=3.38 PD=3.38
M$767 on \$11 \$76 sky130_gnd sky130_fd_pr__nfet_01v8 L=0.6 W=1.4 AS=0.406
+ AD=0.406 PS=3.38 PD=3.38
M$768 on \$11 \$76 sky130_gnd sky130_fd_pr__nfet_01v8 L=0.6 W=1.4 AS=0.406
+ AD=0.406 PS=3.38 PD=3.38
M$769 on \$11 \$76 sky130_gnd sky130_fd_pr__nfet_01v8 L=0.6 W=1.4 AS=0.406
+ AD=0.406 PS=3.38 PD=3.38
M$770 on \$11 \$76 sky130_gnd sky130_fd_pr__nfet_01v8 L=0.6 W=1.4 AS=0.406
+ AD=0.406 PS=3.38 PD=3.38
M$771 on \$11 \$76 sky130_gnd sky130_fd_pr__nfet_01v8 L=0.6 W=1.4 AS=0.406
+ AD=0.406 PS=3.38 PD=3.38
M$772 on \$11 \$76 sky130_gnd sky130_fd_pr__nfet_01v8 L=0.6 W=1.4 AS=0.406
+ AD=0.406 PS=3.38 PD=3.38
M$773 on \$11 \$76 sky130_gnd sky130_fd_pr__nfet_01v8 L=0.6 W=1.4 AS=0.406
+ AD=0.406 PS=3.38 PD=3.38
M$774 on \$11 \$76 sky130_gnd sky130_fd_pr__nfet_01v8 L=0.6 W=1.4 AS=0.406
+ AD=0.406 PS=3.38 PD=3.38
M$775 on \$11 \$76 sky130_gnd sky130_fd_pr__nfet_01v8 L=0.6 W=1.4 AS=0.406
+ AD=0.406 PS=3.38 PD=3.38
M$776 on \$11 \$76 sky130_gnd sky130_fd_pr__nfet_01v8 L=0.6 W=1.4 AS=0.406
+ AD=0.406 PS=3.38 PD=3.38
M$777 on \$11 \$76 sky130_gnd sky130_fd_pr__nfet_01v8 L=0.6 W=1.4 AS=0.406
+ AD=0.406 PS=3.38 PD=3.38
M$778 on \$11 \$76 sky130_gnd sky130_fd_pr__nfet_01v8 L=0.6 W=1.4 AS=0.406
+ AD=0.406 PS=3.38 PD=3.38
M$779 on \$11 \$76 sky130_gnd sky130_fd_pr__nfet_01v8 L=0.6 W=1.4 AS=0.406
+ AD=0.406 PS=3.38 PD=3.38
M$780 on \$11 \$76 sky130_gnd sky130_fd_pr__nfet_01v8 L=0.6 W=1.4 AS=0.406
+ AD=0.406 PS=3.38 PD=3.38
M$781 on \$11 \$76 sky130_gnd sky130_fd_pr__nfet_01v8 L=0.6 W=1.4 AS=0.406
+ AD=0.406 PS=3.38 PD=3.38
M$782 on \$11 \$76 sky130_gnd sky130_fd_pr__nfet_01v8 L=0.6 W=1.4 AS=0.406
+ AD=0.406 PS=3.38 PD=3.38
M$783 on \$11 \$76 sky130_gnd sky130_fd_pr__nfet_01v8 L=0.6 W=1.4 AS=0.406
+ AD=0.406 PS=3.38 PD=3.38
M$784 VSS VSS VSS sky130_gnd sky130_fd_pr__nfet_01v8 L=0.6 W=1.4 AS=0.406
+ AD=0.406 PS=3.38 PD=3.38
M$785 VSS VSS VSS sky130_gnd sky130_fd_pr__nfet_01v8 L=0.6 W=1.4 AS=0.406
+ AD=0.406 PS=3.38 PD=3.38
M$786 VSS VSS VSS sky130_gnd sky130_fd_pr__nfet_01v8 L=0.6 W=1.4 AS=0.406
+ AD=0.406 PS=3.38 PD=3.38
M$787 VSS VSS VSS sky130_gnd sky130_fd_pr__nfet_01v8 L=0.6 W=1.4 AS=0.406
+ AD=0.406 PS=3.38 PD=3.38
M$788 \$45 \$45 \$11 sky130_gnd sky130_fd_pr__nfet_01v8 L=0.6 W=1.4 AS=0.406
+ AD=0.406 PS=3.38 PD=3.38
M$789 \$45 \$45 \$11 sky130_gnd sky130_fd_pr__nfet_01v8 L=0.6 W=1.4 AS=0.406
+ AD=0.406 PS=3.38 PD=3.38
M$790 \$45 \$45 \$11 sky130_gnd sky130_fd_pr__nfet_01v8 L=0.6 W=1.4 AS=0.406
+ AD=0.406 PS=3.38 PD=3.38
M$791 \$45 \$45 \$11 sky130_gnd sky130_fd_pr__nfet_01v8 L=0.6 W=1.4 AS=0.406
+ AD=0.406 PS=3.38 PD=3.38
M$792 \$45 \$45 \$11 sky130_gnd sky130_fd_pr__nfet_01v8 L=0.6 W=1.4 AS=0.406
+ AD=0.406 PS=3.38 PD=3.38
M$793 \$45 \$45 \$11 sky130_gnd sky130_fd_pr__nfet_01v8 L=0.6 W=1.4 AS=0.406
+ AD=0.406 PS=3.38 PD=3.38
M$794 \$45 \$45 \$11 sky130_gnd sky130_fd_pr__nfet_01v8 L=0.6 W=1.4 AS=0.406
+ AD=0.406 PS=3.38 PD=3.38
M$795 \$45 \$45 \$11 sky130_gnd sky130_fd_pr__nfet_01v8 L=0.6 W=1.4 AS=0.406
+ AD=0.406 PS=3.38 PD=3.38
M$796 \$45 \$45 \$11 sky130_gnd sky130_fd_pr__nfet_01v8 L=0.6 W=1.4 AS=0.406
+ AD=0.406 PS=3.38 PD=3.38
M$797 \$45 \$45 \$11 sky130_gnd sky130_fd_pr__nfet_01v8 L=0.6 W=1.4 AS=0.406
+ AD=0.406 PS=3.38 PD=3.38
M$798 \$45 \$45 \$11 sky130_gnd sky130_fd_pr__nfet_01v8 L=0.6 W=1.4 AS=0.406
+ AD=0.406 PS=3.38 PD=3.38
M$799 \$45 \$45 \$11 sky130_gnd sky130_fd_pr__nfet_01v8 L=0.6 W=1.4 AS=0.406
+ AD=0.406 PS=3.38 PD=3.38
M$800 \$45 \$45 \$11 sky130_gnd sky130_fd_pr__nfet_01v8 L=0.6 W=1.4 AS=0.406
+ AD=0.406 PS=3.38 PD=3.38
M$801 \$45 \$45 \$11 sky130_gnd sky130_fd_pr__nfet_01v8 L=0.6 W=1.4 AS=0.406
+ AD=0.406 PS=3.38 PD=3.38
M$802 \$45 \$45 \$11 sky130_gnd sky130_fd_pr__nfet_01v8 L=0.6 W=1.4 AS=0.406
+ AD=0.406 PS=3.38 PD=3.38
M$803 \$45 \$45 \$11 sky130_gnd sky130_fd_pr__nfet_01v8 L=0.6 W=1.4 AS=0.406
+ AD=0.406 PS=3.38 PD=3.38
M$804 \$45 \$45 \$11 sky130_gnd sky130_fd_pr__nfet_01v8 L=0.6 W=1.4 AS=0.406
+ AD=0.406 PS=3.38 PD=3.38
M$805 \$45 \$45 \$11 sky130_gnd sky130_fd_pr__nfet_01v8 L=0.6 W=1.4 AS=0.406
+ AD=0.406 PS=3.38 PD=3.38
M$806 \$45 \$45 \$11 sky130_gnd sky130_fd_pr__nfet_01v8 L=0.6 W=1.4 AS=0.406
+ AD=0.406 PS=3.38 PD=3.38
M$807 \$45 \$45 \$11 sky130_gnd sky130_fd_pr__nfet_01v8 L=0.6 W=1.4 AS=0.406
+ AD=0.406 PS=3.38 PD=3.38
M$808 \$45 \$45 \$11 sky130_gnd sky130_fd_pr__nfet_01v8 L=0.6 W=1.4 AS=0.406
+ AD=0.406 PS=3.38 PD=3.38
M$809 \$45 \$45 \$11 sky130_gnd sky130_fd_pr__nfet_01v8 L=0.6 W=1.4 AS=0.406
+ AD=0.406 PS=3.38 PD=3.38
M$810 \$45 \$45 \$11 sky130_gnd sky130_fd_pr__nfet_01v8 L=0.6 W=1.4 AS=0.406
+ AD=0.406 PS=3.38 PD=3.38
M$811 \$45 \$45 \$11 sky130_gnd sky130_fd_pr__nfet_01v8 L=0.6 W=1.4 AS=0.406
+ AD=0.406 PS=3.38 PD=3.38
M$812 \$45 \$45 \$11 sky130_gnd sky130_fd_pr__nfet_01v8 L=0.6 W=1.4 AS=0.406
+ AD=0.406 PS=3.38 PD=3.38
M$813 \$45 \$45 \$11 sky130_gnd sky130_fd_pr__nfet_01v8 L=0.6 W=1.4 AS=0.406
+ AD=0.406 PS=3.38 PD=3.38
M$814 \$45 \$45 \$11 sky130_gnd sky130_fd_pr__nfet_01v8 L=0.6 W=1.4 AS=0.406
+ AD=0.406 PS=3.38 PD=3.38
M$815 \$45 \$45 \$11 sky130_gnd sky130_fd_pr__nfet_01v8 L=0.6 W=1.4 AS=0.406
+ AD=0.406 PS=3.38 PD=3.38
M$816 \$45 \$45 \$11 sky130_gnd sky130_fd_pr__nfet_01v8 L=0.6 W=1.4 AS=0.406
+ AD=0.406 PS=3.38 PD=3.38
M$817 \$45 \$45 \$11 sky130_gnd sky130_fd_pr__nfet_01v8 L=0.6 W=1.4 AS=0.406
+ AD=0.406 PS=3.38 PD=3.38
M$818 \$45 \$45 \$11 sky130_gnd sky130_fd_pr__nfet_01v8 L=0.6 W=1.4 AS=0.406
+ AD=0.406 PS=3.38 PD=3.38
M$819 \$45 \$45 \$11 sky130_gnd sky130_fd_pr__nfet_01v8 L=0.6 W=1.4 AS=0.406
+ AD=0.406 PS=3.38 PD=3.38
M$820 \$45 \$45 \$11 sky130_gnd sky130_fd_pr__nfet_01v8 L=0.6 W=1.4 AS=0.406
+ AD=0.406 PS=3.38 PD=3.38
M$821 \$45 \$45 \$11 sky130_gnd sky130_fd_pr__nfet_01v8 L=0.6 W=1.4 AS=0.406
+ AD=0.406 PS=3.38 PD=3.38
M$822 \$45 \$45 \$11 sky130_gnd sky130_fd_pr__nfet_01v8 L=0.6 W=1.4 AS=0.406
+ AD=0.406 PS=3.38 PD=3.38
M$823 \$45 \$45 \$11 sky130_gnd sky130_fd_pr__nfet_01v8 L=0.6 W=1.4 AS=0.406
+ AD=0.406 PS=3.38 PD=3.38
M$824 \$45 \$45 \$11 sky130_gnd sky130_fd_pr__nfet_01v8 L=0.6 W=1.4 AS=0.406
+ AD=0.406 PS=3.38 PD=3.38
M$825 \$45 \$45 \$11 sky130_gnd sky130_fd_pr__nfet_01v8 L=0.6 W=1.4 AS=0.406
+ AD=0.406 PS=3.38 PD=3.38
M$826 \$45 \$45 \$11 sky130_gnd sky130_fd_pr__nfet_01v8 L=0.6 W=1.4 AS=0.406
+ AD=0.406 PS=3.38 PD=3.38
M$827 \$45 \$45 \$11 sky130_gnd sky130_fd_pr__nfet_01v8 L=0.6 W=1.4 AS=0.406
+ AD=0.406 PS=3.38 PD=3.38
M$828 \$45 \$45 \$11 sky130_gnd sky130_fd_pr__nfet_01v8 L=0.6 W=1.4 AS=0.406
+ AD=0.406 PS=3.38 PD=3.38
M$829 \$45 \$45 \$11 sky130_gnd sky130_fd_pr__nfet_01v8 L=0.6 W=1.4 AS=0.406
+ AD=0.406 PS=3.38 PD=3.38
M$830 \$45 \$45 \$11 sky130_gnd sky130_fd_pr__nfet_01v8 L=0.6 W=1.4 AS=0.406
+ AD=0.406 PS=3.38 PD=3.38
M$831 \$45 \$45 \$11 sky130_gnd sky130_fd_pr__nfet_01v8 L=0.6 W=1.4 AS=0.406
+ AD=0.406 PS=3.38 PD=3.38
M$832 \$45 \$45 \$11 sky130_gnd sky130_fd_pr__nfet_01v8 L=0.6 W=1.4 AS=0.406
+ AD=0.406 PS=3.38 PD=3.38
M$833 \$45 \$45 \$11 sky130_gnd sky130_fd_pr__nfet_01v8 L=0.6 W=1.4 AS=0.406
+ AD=0.406 PS=3.38 PD=3.38
M$834 \$45 \$45 \$11 sky130_gnd sky130_fd_pr__nfet_01v8 L=0.6 W=1.4 AS=0.406
+ AD=0.406 PS=3.38 PD=3.38
M$835 \$45 \$45 \$11 sky130_gnd sky130_fd_pr__nfet_01v8 L=0.6 W=1.4 AS=0.406
+ AD=0.406 PS=3.38 PD=3.38
M$836 \$45 \$45 \$11 sky130_gnd sky130_fd_pr__nfet_01v8 L=0.6 W=1.4 AS=0.406
+ AD=0.406 PS=3.38 PD=3.38
M$837 \$45 \$45 \$11 sky130_gnd sky130_fd_pr__nfet_01v8 L=0.6 W=1.4 AS=0.406
+ AD=0.406 PS=3.38 PD=3.38
M$838 VSS VSS VSS sky130_gnd sky130_fd_pr__nfet_01v8 L=0.6 W=1.4 AS=0.406
+ AD=0.406 PS=3.38 PD=3.38
M$839 VSS VSS VSS sky130_gnd sky130_fd_pr__nfet_01v8 L=0.6 W=1.4 AS=0.406
+ AD=0.406 PS=3.38 PD=3.38
M$840 VSS VSS VSS sky130_gnd sky130_fd_pr__nfet_01v8 L=0.6 W=1.4 AS=0.406
+ AD=0.406 PS=3.38 PD=3.38
M$841 VSS VSS VSS sky130_gnd sky130_fd_pr__nfet_01v8 L=0.6 W=1.4 AS=0.406
+ AD=0.406 PS=3.38 PD=3.38
M$842 VSS VSS VSS sky130_gnd sky130_fd_pr__nfet_01v8 L=0.6 W=1.4 AS=0.406
+ AD=0.406 PS=3.38 PD=3.38
M$843 VSS VSS VSS sky130_gnd sky130_fd_pr__nfet_01v8 L=0.6 W=1.4 AS=0.406
+ AD=0.406 PS=3.38 PD=3.38
M$844 VSS VSS VSS sky130_gnd sky130_fd_pr__nfet_01v8 L=0.6 W=1.4 AS=0.406
+ AD=0.406 PS=3.38 PD=3.38
M$845 VSS VSS VSS sky130_gnd sky130_fd_pr__nfet_01v8 L=0.6 W=1.4 AS=0.406
+ AD=0.406 PS=3.38 PD=3.38
M$846 \$150 \$150 \$150 sky130_gnd sky130_fd_pr__nfet_01v8 L=0.6 W=1.4 AS=0.406
+ AD=0.406 PS=3.38 PD=3.38
M$847 \$150 \$150 \$150 sky130_gnd sky130_fd_pr__nfet_01v8 L=0.6 W=1.4 AS=0.406
+ AD=0.406 PS=3.38 PD=3.38
M$848 IBIAS IBIAS IBIAS sky130_gnd sky130_fd_pr__nfet_01v8 L=0.6 W=1.4 AS=0.406
+ AD=0.406 PS=3.38 PD=3.38
M$849 IBIAS IBIAS IBIAS sky130_gnd sky130_fd_pr__nfet_01v8 L=0.6 W=1.4 AS=0.406
+ AD=0.406 PS=3.38 PD=3.38
M$850 \$157 VSS VSS sky130_gnd sky130_fd_pr__nfet_01v8 L=0.6 W=1.4 AS=0.406
+ AD=0.406 PS=3.38 PD=3.38
M$851 \$157 VSS VSS sky130_gnd sky130_fd_pr__nfet_01v8 L=0.6 W=1.4 AS=0.406
+ AD=0.406 PS=3.38 PD=3.38
M$852 \$11 \$45 bias_a sky130_gnd sky130_fd_pr__nfet_01v8 L=0.6 W=1.4 AS=0.406
+ AD=0.406 PS=3.38 PD=3.38
M$853 \$11 \$45 bias_a sky130_gnd sky130_fd_pr__nfet_01v8 L=0.6 W=1.4 AS=0.406
+ AD=0.406 PS=3.38 PD=3.38
M$854 on on on sky130_gnd sky130_fd_pr__nfet_01v8 L=0.6 W=1.4 AS=0.406 AD=0.406
+ PS=3.38 PD=3.38
M$855 on on on sky130_gnd sky130_fd_pr__nfet_01v8 L=0.6 W=1.4 AS=0.406 AD=0.406
+ PS=3.38 PD=3.38
M$856 on VSS VSS sky130_gnd sky130_fd_pr__nfet_01v8 L=0.6 W=1.4 AS=0.406
+ AD=0.406 PS=3.38 PD=3.38
M$857 on VSS VSS sky130_gnd sky130_fd_pr__nfet_01v8 L=0.6 W=1.4 AS=0.406
+ AD=0.406 PS=3.38 PD=3.38
M$858 op op op sky130_gnd sky130_fd_pr__nfet_01v8 L=0.6 W=1.4 AS=0.406 AD=0.406
+ PS=3.38 PD=3.38
M$859 op op op sky130_gnd sky130_fd_pr__nfet_01v8 L=0.6 W=1.4 AS=0.406 AD=0.406
+ PS=3.38 PD=3.38
M$860 op VSS VSS sky130_gnd sky130_fd_pr__nfet_01v8 L=0.6 W=1.4 AS=0.406
+ AD=0.406 PS=3.38 PD=3.38
M$861 op VSS VSS sky130_gnd sky130_fd_pr__nfet_01v8 L=0.6 W=1.4 AS=0.406
+ AD=0.406 PS=3.38 PD=3.38
M$862 \$45 \$45 \$45 sky130_gnd sky130_fd_pr__nfet_01v8 L=0.6 W=1.4 AS=0.406
+ AD=0.406 PS=3.38 PD=3.38
M$863 \$45 \$45 \$45 sky130_gnd sky130_fd_pr__nfet_01v8 L=0.6 W=1.4 AS=0.406
+ AD=0.406 PS=3.38 PD=3.38
.ENDS iadc_ota_v2_routed
