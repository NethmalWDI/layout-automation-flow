* Extracted by KLayout with SKY130 LVS runset on : 05/11/2026 17:10

.SUBCKT iadc_ota_v2_routed \$10.x1_net1 \$10.x1_net10 \$10.x1_net11
+ \$10.x1_net12 \$10.x1_net13 \$10.x1_net14 \$10.x1_net15 \$10.x1_net2
+ \$10.x1_net3 \$10.x1_net4 \$10.x1_net5 \$10.x1_net6 \$10.x1_net7 \$10.x1_net8
+ \$10.x1_net9 IBIAS VDD VSS bias_a cm cmc in ip on op sky130_gnd
C$1 cmc op sky130_fd_pr__model__cap_mim C=4.608e-14 A=23.04 P=19.2
C$2 cmc op sky130_fd_pr__model__cap_mim C=4.608e-14 A=23.04 P=19.2
C$3 cmc op sky130_fd_pr__model__cap_mim C=4.608e-14 A=23.04 P=19.2
C$4 cmc op sky130_fd_pr__model__cap_mim C=4.608e-14 A=23.04 P=19.2
C$5 cmc on sky130_fd_pr__model__cap_mim C=4.608e-14 A=23.04 P=19.2
C$6 cmc on sky130_fd_pr__model__cap_mim C=4.608e-14 A=23.04 P=19.2
C$7 cmc on sky130_fd_pr__model__cap_mim C=4.608e-14 A=23.04 P=19.2
C$8 cmc on sky130_fd_pr__model__cap_mim C=4.608e-14 A=23.04 P=19.2
M$9 \$109 \$109 \$177 sky130_gnd sky130_fd_pr__nfet_01v8_lvt L=0.6 W=1.4
+ AS=0.406 AD=0.406 PS=3.38 PD=3.38
M$10 \$109 \$109 \$177 sky130_gnd sky130_fd_pr__nfet_01v8_lvt L=0.6 W=1.4
+ AS=0.406 AD=0.406 PS=3.38 PD=3.38
M$11 \$109 \$109 \$177 sky130_gnd sky130_fd_pr__nfet_01v8_lvt L=0.6 W=1.4
+ AS=0.406 AD=0.406 PS=3.38 PD=3.38
M$12 \$109 \$109 \$177 sky130_gnd sky130_fd_pr__nfet_01v8_lvt L=0.6 W=1.4
+ AS=0.406 AD=0.406 PS=3.38 PD=3.38
M$13 \$109 \$109 \$177 sky130_gnd sky130_fd_pr__nfet_01v8_lvt L=0.6 W=1.4
+ AS=0.406 AD=0.406 PS=3.38 PD=3.38
M$14 \$109 \$109 \$177 sky130_gnd sky130_fd_pr__nfet_01v8_lvt L=0.6 W=1.4
+ AS=0.406 AD=0.406 PS=3.38 PD=3.38
M$15 \$109 \$109 \$177 sky130_gnd sky130_fd_pr__nfet_01v8_lvt L=0.6 W=1.4
+ AS=0.406 AD=0.406 PS=3.38 PD=3.38
M$16 \$109 \$109 \$177 sky130_gnd sky130_fd_pr__nfet_01v8_lvt L=0.6 W=1.4
+ AS=0.406 AD=0.406 PS=3.38 PD=3.38
M$17 \$109 \$109 \$177 sky130_gnd sky130_fd_pr__nfet_01v8_lvt L=0.6 W=1.4
+ AS=0.406 AD=0.406 PS=3.38 PD=3.38
M$18 \$109 \$109 \$177 sky130_gnd sky130_fd_pr__nfet_01v8_lvt L=0.6 W=1.4
+ AS=0.406 AD=0.406 PS=3.38 PD=3.38
M$19 \$109 \$109 \$177 sky130_gnd sky130_fd_pr__nfet_01v8_lvt L=0.6 W=1.4
+ AS=0.406 AD=0.406 PS=3.38 PD=3.38
M$20 \$109 \$109 \$177 sky130_gnd sky130_fd_pr__nfet_01v8_lvt L=0.6 W=1.4
+ AS=0.406 AD=0.406 PS=3.38 PD=3.38
M$21 \$109 \$109 \$177 sky130_gnd sky130_fd_pr__nfet_01v8_lvt L=0.6 W=1.4
+ AS=0.406 AD=0.406 PS=3.38 PD=3.38
M$22 \$109 \$109 \$177 sky130_gnd sky130_fd_pr__nfet_01v8_lvt L=0.6 W=1.4
+ AS=0.406 AD=0.406 PS=3.38 PD=3.38
M$23 \$109 \$109 \$177 sky130_gnd sky130_fd_pr__nfet_01v8_lvt L=0.6 W=1.4
+ AS=0.406 AD=0.406 PS=3.38 PD=3.38
M$24 \$109 \$109 \$177 sky130_gnd sky130_fd_pr__nfet_01v8_lvt L=0.6 W=1.4
+ AS=0.406 AD=0.406 PS=3.38 PD=3.38
M$25 \$109 \$109 \$177 sky130_gnd sky130_fd_pr__nfet_01v8_lvt L=0.6 W=1.4
+ AS=0.406 AD=0.406 PS=3.38 PD=3.38
M$26 \$109 \$109 \$177 sky130_gnd sky130_fd_pr__nfet_01v8_lvt L=0.6 W=1.4
+ AS=0.406 AD=0.406 PS=3.38 PD=3.38
M$27 \$109 \$109 \$177 sky130_gnd sky130_fd_pr__nfet_01v8_lvt L=0.6 W=1.4
+ AS=0.406 AD=0.406 PS=3.38 PD=3.38
M$28 \$109 \$109 \$177 sky130_gnd sky130_fd_pr__nfet_01v8_lvt L=0.6 W=1.4
+ AS=0.406 AD=0.406 PS=3.38 PD=3.38
M$29 \$109 \$109 \$177 sky130_gnd sky130_fd_pr__nfet_01v8_lvt L=0.6 W=1.4
+ AS=0.406 AD=0.406 PS=3.38 PD=3.38
M$30 \$109 \$109 \$177 sky130_gnd sky130_fd_pr__nfet_01v8_lvt L=0.6 W=1.4
+ AS=0.406 AD=0.406 PS=3.38 PD=3.38
M$31 \$109 \$109 \$177 sky130_gnd sky130_fd_pr__nfet_01v8_lvt L=0.6 W=1.4
+ AS=0.406 AD=0.406 PS=3.38 PD=3.38
M$32 \$109 \$109 \$177 sky130_gnd sky130_fd_pr__nfet_01v8_lvt L=0.6 W=1.4
+ AS=0.406 AD=0.406 PS=3.38 PD=3.38
M$33 \$109 \$109 \$177 sky130_gnd sky130_fd_pr__nfet_01v8_lvt L=0.6 W=1.4
+ AS=0.406 AD=0.406 PS=3.38 PD=3.38
M$34 \$109 \$109 \$177 sky130_gnd sky130_fd_pr__nfet_01v8_lvt L=0.6 W=1.4
+ AS=0.406 AD=0.406 PS=3.38 PD=3.38
M$35 \$109 \$109 \$177 sky130_gnd sky130_fd_pr__nfet_01v8_lvt L=0.6 W=1.4
+ AS=0.406 AD=0.406 PS=3.38 PD=3.38
M$36 \$109 \$109 \$177 sky130_gnd sky130_fd_pr__nfet_01v8_lvt L=0.6 W=1.4
+ AS=0.406 AD=0.406 PS=3.38 PD=3.38
M$37 \$109 \$109 \$177 sky130_gnd sky130_fd_pr__nfet_01v8_lvt L=0.6 W=1.4
+ AS=0.406 AD=0.406 PS=3.38 PD=3.38
M$38 \$109 \$109 \$177 sky130_gnd sky130_fd_pr__nfet_01v8_lvt L=0.6 W=1.4
+ AS=0.406 AD=0.406 PS=3.38 PD=3.38
M$39 \$109 \$109 \$177 sky130_gnd sky130_fd_pr__nfet_01v8_lvt L=0.6 W=1.4
+ AS=0.406 AD=0.406 PS=3.38 PD=3.38
M$40 \$109 \$109 \$177 sky130_gnd sky130_fd_pr__nfet_01v8_lvt L=0.6 W=1.4
+ AS=0.406 AD=0.406 PS=3.38 PD=3.38
M$41 \$109 \$109 \$177 sky130_gnd sky130_fd_pr__nfet_01v8_lvt L=0.6 W=1.4
+ AS=0.406 AD=0.406 PS=3.38 PD=3.38
M$42 \$109 \$109 \$177 sky130_gnd sky130_fd_pr__nfet_01v8_lvt L=0.6 W=1.4
+ AS=0.406 AD=0.406 PS=3.38 PD=3.38
M$43 \$109 \$109 \$177 sky130_gnd sky130_fd_pr__nfet_01v8_lvt L=0.6 W=1.4
+ AS=0.406 AD=0.406 PS=3.38 PD=3.38
M$44 \$109 \$109 \$177 sky130_gnd sky130_fd_pr__nfet_01v8_lvt L=0.6 W=1.4
+ AS=0.406 AD=0.406 PS=3.38 PD=3.38
M$45 \$109 \$109 \$177 sky130_gnd sky130_fd_pr__nfet_01v8_lvt L=0.6 W=1.4
+ AS=0.406 AD=0.406 PS=3.38 PD=3.38
M$46 \$109 \$109 \$177 sky130_gnd sky130_fd_pr__nfet_01v8_lvt L=0.6 W=1.4
+ AS=0.406 AD=0.406 PS=3.38 PD=3.38
M$47 \$109 \$109 \$177 sky130_gnd sky130_fd_pr__nfet_01v8_lvt L=0.6 W=1.4
+ AS=0.406 AD=0.406 PS=3.38 PD=3.38
M$48 \$109 \$109 \$177 sky130_gnd sky130_fd_pr__nfet_01v8_lvt L=0.6 W=1.4
+ AS=0.406 AD=0.406 PS=3.38 PD=3.38
M$49 \$109 \$109 \$177 sky130_gnd sky130_fd_pr__nfet_01v8_lvt L=0.6 W=1.4
+ AS=0.406 AD=0.406 PS=3.38 PD=3.38
M$50 \$109 \$109 \$177 sky130_gnd sky130_fd_pr__nfet_01v8_lvt L=0.6 W=1.4
+ AS=0.406 AD=0.406 PS=3.38 PD=3.38
M$51 \$109 \$109 \$177 sky130_gnd sky130_fd_pr__nfet_01v8_lvt L=0.6 W=1.4
+ AS=0.406 AD=0.406 PS=3.38 PD=3.38
M$52 \$109 \$109 \$177 sky130_gnd sky130_fd_pr__nfet_01v8_lvt L=0.6 W=1.4
+ AS=0.406 AD=0.406 PS=3.38 PD=3.38
M$53 \$109 \$109 \$177 sky130_gnd sky130_fd_pr__nfet_01v8_lvt L=0.6 W=1.4
+ AS=0.406 AD=0.406 PS=3.38 PD=3.38
M$54 \$109 \$109 \$177 sky130_gnd sky130_fd_pr__nfet_01v8_lvt L=0.6 W=1.4
+ AS=0.406 AD=0.406 PS=3.38 PD=3.38
M$55 \$109 \$109 \$177 sky130_gnd sky130_fd_pr__nfet_01v8_lvt L=0.6 W=1.4
+ AS=0.406 AD=0.406 PS=3.38 PD=3.38
M$56 \$109 \$109 \$177 sky130_gnd sky130_fd_pr__nfet_01v8_lvt L=0.6 W=1.4
+ AS=0.406 AD=0.406 PS=3.38 PD=3.38
M$57 \$109 \$109 \$177 sky130_gnd sky130_fd_pr__nfet_01v8_lvt L=0.6 W=1.4
+ AS=0.406 AD=0.406 PS=3.38 PD=3.38
M$58 \$109 \$109 \$177 sky130_gnd sky130_fd_pr__nfet_01v8_lvt L=0.6 W=1.4
+ AS=0.406 AD=0.406 PS=3.38 PD=3.38
M$59 \$109 \$109 \$177 sky130_gnd sky130_fd_pr__nfet_01v8_lvt L=0.6 W=1.4
+ AS=0.406 AD=0.406 PS=3.38 PD=3.38
M$60 \$109 \$109 \$177 sky130_gnd sky130_fd_pr__nfet_01v8_lvt L=0.6 W=1.4
+ AS=0.406 AD=0.406 PS=3.38 PD=3.38
M$61 \$109 \$109 \$177 sky130_gnd sky130_fd_pr__nfet_01v8_lvt L=0.6 W=1.4
+ AS=0.406 AD=0.406 PS=3.38 PD=3.38
M$62 \$109 \$109 \$177 sky130_gnd sky130_fd_pr__nfet_01v8_lvt L=0.6 W=1.4
+ AS=0.406 AD=0.406 PS=3.38 PD=3.38
M$63 \$109 \$109 \$177 sky130_gnd sky130_fd_pr__nfet_01v8_lvt L=0.6 W=1.4
+ AS=0.406 AD=0.406 PS=3.38 PD=3.38
M$64 \$109 \$109 \$177 sky130_gnd sky130_fd_pr__nfet_01v8_lvt L=0.6 W=1.4
+ AS=0.406 AD=0.406 PS=3.38 PD=3.38
M$65 \$177 \$177 \$177 sky130_gnd sky130_fd_pr__nfet_01v8_lvt L=0.6 W=1.4
+ AS=0.406 AD=0.406 PS=3.38 PD=3.38
M$66 \$177 \$177 \$177 sky130_gnd sky130_fd_pr__nfet_01v8_lvt L=0.6 W=1.4
+ AS=0.406 AD=0.406 PS=3.38 PD=3.38
M$67 \$177 \$177 \$177 sky130_gnd sky130_fd_pr__nfet_01v8_lvt L=0.6 W=1.4
+ AS=0.406 AD=0.406 PS=3.38 PD=3.38
M$68 \$177 \$177 \$177 sky130_gnd sky130_fd_pr__nfet_01v8_lvt L=0.6 W=1.4
+ AS=0.406 AD=0.406 PS=3.38 PD=3.38
M$69 \$177 \$177 \$177 sky130_gnd sky130_fd_pr__nfet_01v8_lvt L=0.6 W=1.4
+ AS=0.406 AD=0.406 PS=3.38 PD=3.38
M$70 \$177 \$177 \$177 sky130_gnd sky130_fd_pr__nfet_01v8_lvt L=0.6 W=1.4
+ AS=0.406 AD=0.406 PS=3.38 PD=3.38
M$71 \$177 \$177 \$177 sky130_gnd sky130_fd_pr__nfet_01v8_lvt L=0.6 W=1.4
+ AS=0.406 AD=0.406 PS=3.38 PD=3.38
M$72 \$177 \$177 \$177 sky130_gnd sky130_fd_pr__nfet_01v8_lvt L=0.6 W=1.4
+ AS=0.406 AD=0.406 PS=3.38 PD=3.38
M$73 \$109 \$109 \$109 sky130_gnd sky130_fd_pr__nfet_01v8_lvt L=0.6 W=1.4
+ AS=0.406 AD=0.406 PS=3.38 PD=3.38
M$74 \$109 \$109 \$109 sky130_gnd sky130_fd_pr__nfet_01v8_lvt L=0.6 W=1.4
+ AS=0.406 AD=0.406 PS=3.38 PD=3.38
M$75 \$109 \$109 \$109 sky130_gnd sky130_fd_pr__nfet_01v8_lvt L=0.6 W=1.4
+ AS=0.406 AD=0.406 PS=3.38 PD=3.38
M$76 \$109 \$109 \$109 sky130_gnd sky130_fd_pr__nfet_01v8_lvt L=0.6 W=1.4
+ AS=0.406 AD=0.406 PS=3.38 PD=3.38
M$77 \$109 \$109 \$109 sky130_gnd sky130_fd_pr__nfet_01v8_lvt L=0.6 W=1.4
+ AS=0.406 AD=0.406 PS=3.38 PD=3.38
M$78 \$109 \$109 \$109 sky130_gnd sky130_fd_pr__nfet_01v8_lvt L=0.6 W=1.4
+ AS=0.406 AD=0.406 PS=3.38 PD=3.38
M$79 \$109 \$109 \$109 sky130_gnd sky130_fd_pr__nfet_01v8_lvt L=0.6 W=1.4
+ AS=0.406 AD=0.406 PS=3.38 PD=3.38
M$80 \$109 \$109 \$109 sky130_gnd sky130_fd_pr__nfet_01v8_lvt L=0.6 W=1.4
+ AS=0.406 AD=0.406 PS=3.38 PD=3.38
M$81 VDD VDD VDD VDD sky130_fd_pr__pfet_01v8_lvt L=0.6 W=1.4 AS=0.406 AD=0.406
+ PS=3.38 PD=3.38
M$82 VDD VDD VDD VDD sky130_fd_pr__pfet_01v8_lvt L=0.6 W=1.4 AS=0.406 AD=0.406
+ PS=3.38 PD=3.38
M$83 VDD VDD VDD VDD sky130_fd_pr__pfet_01v8_lvt L=0.6 W=1.4 AS=0.406 AD=0.406
+ PS=3.38 PD=3.38
M$84 VDD VDD VDD VDD sky130_fd_pr__pfet_01v8_lvt L=0.6 W=1.4 AS=0.406 AD=0.406
+ PS=3.38 PD=3.38
M$85 VDD VDD VDD VDD sky130_fd_pr__pfet_01v8_lvt L=0.6 W=1.4 AS=0.406 AD=0.406
+ PS=3.38 PD=3.38
M$86 VDD VDD VDD VDD sky130_fd_pr__pfet_01v8_lvt L=0.6 W=1.4 AS=0.406 AD=0.406
+ PS=3.38 PD=3.38
M$87 VDD VDD VDD VDD sky130_fd_pr__pfet_01v8_lvt L=0.6 W=1.4 AS=0.406 AD=0.406
+ PS=3.38 PD=3.38
M$88 VDD VDD VDD VDD sky130_fd_pr__pfet_01v8_lvt L=0.6 W=1.4 AS=0.406 AD=0.406
+ PS=3.38 PD=3.38
M$89 VDD VDD VDD VDD sky130_fd_pr__pfet_01v8_lvt L=0.6 W=1.4 AS=0.406 AD=0.406
+ PS=3.38 PD=3.38
M$90 VDD VDD VDD VDD sky130_fd_pr__pfet_01v8_lvt L=0.6 W=1.4 AS=0.406 AD=0.406
+ PS=3.38 PD=3.38
M$91 \$265 \$265 \$265 VDD sky130_fd_pr__pfet_01v8_lvt L=0.6 W=1.4 AS=0.406
+ AD=0.406 PS=3.38 PD=3.38
M$92 \$265 \$265 \$265 VDD sky130_fd_pr__pfet_01v8_lvt L=0.6 W=1.4 AS=0.406
+ AD=0.406 PS=3.38 PD=3.38
M$93 \$261 \$261 \$261 VDD sky130_fd_pr__pfet_01v8_lvt L=0.6 W=1.4 AS=0.406
+ AD=0.406 PS=3.38 PD=3.38
M$94 \$261 \$261 \$261 VDD sky130_fd_pr__pfet_01v8_lvt L=0.6 W=1.4 AS=0.406
+ AD=0.406 PS=3.38 PD=3.38
M$95 \$266 \$266 \$266 VDD sky130_fd_pr__pfet_01v8_lvt L=0.6 W=1.4 AS=0.406
+ AD=0.406 PS=3.38 PD=3.38
M$96 \$266 \$266 \$266 VDD sky130_fd_pr__pfet_01v8_lvt L=0.6 W=1.4 AS=0.406
+ AD=0.406 PS=3.38 PD=3.38
M$97 \$51 ip \$16 sky130_gnd sky130_fd_pr__nfet_01v8_lvt L=0.2 W=1.2 AS=0.348
+ AD=0.348 PS=2.98 PD=2.98
M$98 \$51 ip \$16 sky130_gnd sky130_fd_pr__nfet_01v8_lvt L=0.2 W=1.2 AS=0.348
+ AD=0.348 PS=2.98 PD=2.98
M$99 \$50 in \$16 sky130_gnd sky130_fd_pr__nfet_01v8_lvt L=0.2 W=1.2 AS=0.348
+ AD=0.348 PS=2.98 PD=2.98
M$100 \$51 ip \$16 sky130_gnd sky130_fd_pr__nfet_01v8_lvt L=0.2 W=1.2 AS=0.348
+ AD=0.348 PS=2.98 PD=2.98
M$101 \$50 in \$16 sky130_gnd sky130_fd_pr__nfet_01v8_lvt L=0.2 W=1.2 AS=0.348
+ AD=0.348 PS=2.98 PD=2.98
M$102 \$51 ip \$16 sky130_gnd sky130_fd_pr__nfet_01v8_lvt L=0.2 W=1.2 AS=0.348
+ AD=0.348 PS=2.98 PD=2.98
M$103 \$50 in \$16 sky130_gnd sky130_fd_pr__nfet_01v8_lvt L=0.2 W=1.2 AS=0.348
+ AD=0.348 PS=2.98 PD=2.98
M$104 \$50 in \$16 sky130_gnd sky130_fd_pr__nfet_01v8_lvt L=0.2 W=1.2 AS=0.348
+ AD=0.348 PS=2.98 PD=2.98
M$105 \$51 ip \$16 sky130_gnd sky130_fd_pr__nfet_01v8_lvt L=0.2 W=1.2 AS=0.348
+ AD=0.348 PS=2.98 PD=2.98
M$106 \$50 in \$16 sky130_gnd sky130_fd_pr__nfet_01v8_lvt L=0.2 W=1.2 AS=0.348
+ AD=0.348 PS=2.98 PD=2.98
M$107 \$51 ip \$16 sky130_gnd sky130_fd_pr__nfet_01v8_lvt L=0.2 W=1.2 AS=0.348
+ AD=0.348 PS=2.98 PD=2.98
M$108 \$50 in \$16 sky130_gnd sky130_fd_pr__nfet_01v8_lvt L=0.2 W=1.2 AS=0.348
+ AD=0.348 PS=2.98 PD=2.98
M$109 \$50 \$50 \$50 sky130_gnd sky130_fd_pr__nfet_01v8_lvt L=0.2 W=1.2
+ AS=0.348 AD=0.348 PS=2.98 PD=2.98
M$110 \$50 \$50 \$50 sky130_gnd sky130_fd_pr__nfet_01v8_lvt L=0.2 W=1.2
+ AS=0.348 AD=0.348 PS=2.98 PD=2.98
M$111 \$51 \$51 \$51 sky130_gnd sky130_fd_pr__nfet_01v8_lvt L=0.2 W=1.2
+ AS=0.348 AD=0.348 PS=2.98 PD=2.98
M$112 \$51 \$51 \$51 sky130_gnd sky130_fd_pr__nfet_01v8_lvt L=0.2 W=1.2
+ AS=0.348 AD=0.348 PS=2.98 PD=2.98
M$113 VDD VDD VDD VDD sky130_fd_pr__pfet_01v8 L=0.6 W=1.4 AS=0.406 AD=0.406
+ PS=3.38 PD=3.38
M$114 VDD VDD VDD VDD sky130_fd_pr__pfet_01v8 L=0.6 W=1.4 AS=0.406 AD=0.406
+ PS=3.38 PD=3.38
M$115 VDD VDD VDD VDD sky130_fd_pr__pfet_01v8 L=0.6 W=1.4 AS=0.406 AD=0.406
+ PS=3.38 PD=3.38
M$116 VDD VDD VDD VDD sky130_fd_pr__pfet_01v8 L=0.6 W=1.4 AS=0.406 AD=0.406
+ PS=3.38 PD=3.38
M$117 VDD VDD VDD VDD sky130_fd_pr__pfet_01v8 L=0.6 W=1.4 AS=0.406 AD=0.406
+ PS=3.38 PD=3.38
M$118 VDD VDD VDD VDD sky130_fd_pr__pfet_01v8 L=0.6 W=1.4 AS=0.406 AD=0.406
+ PS=3.38 PD=3.38
M$119 VDD VDD VDD VDD sky130_fd_pr__pfet_01v8 L=0.6 W=1.4 AS=0.406 AD=0.406
+ PS=3.38 PD=3.38
M$120 VDD VDD VDD VDD sky130_fd_pr__pfet_01v8 L=0.6 W=1.4 AS=0.406 AD=0.406
+ PS=3.38 PD=3.38
M$121 \$109 \$177 \$265 VDD sky130_fd_pr__pfet_01v8 L=0.6 W=1.4 AS=0.406
+ AD=0.406 PS=3.38 PD=3.38
M$122 \$162 \$177 \$261 VDD sky130_fd_pr__pfet_01v8 L=0.6 W=1.4 AS=0.406
+ AD=0.406 PS=3.38 PD=3.38
M$123 cm \$177 \$266 VDD sky130_fd_pr__pfet_01v8 L=0.6 W=1.4 AS=0.406 AD=0.406
+ PS=3.38 PD=3.38
M$124 \$109 \$177 \$265 VDD sky130_fd_pr__pfet_01v8 L=0.6 W=1.4 AS=0.406
+ AD=0.406 PS=3.38 PD=3.38
M$125 \$162 \$177 \$261 VDD sky130_fd_pr__pfet_01v8 L=0.6 W=1.4 AS=0.406
+ AD=0.406 PS=3.38 PD=3.38
M$126 cm \$177 \$266 VDD sky130_fd_pr__pfet_01v8 L=0.6 W=1.4 AS=0.406 AD=0.406
+ PS=3.38 PD=3.38
M$127 \$109 \$177 \$265 VDD sky130_fd_pr__pfet_01v8 L=0.6 W=1.4 AS=0.406
+ AD=0.406 PS=3.38 PD=3.38
M$128 \$162 \$177 \$261 VDD sky130_fd_pr__pfet_01v8 L=0.6 W=1.4 AS=0.406
+ AD=0.406 PS=3.38 PD=3.38
M$129 cm \$177 \$266 VDD sky130_fd_pr__pfet_01v8 L=0.6 W=1.4 AS=0.406 AD=0.406
+ PS=3.38 PD=3.38
M$130 cm \$177 \$266 VDD sky130_fd_pr__pfet_01v8 L=0.6 W=1.4 AS=0.406 AD=0.406
+ PS=3.38 PD=3.38
M$131 \$162 \$177 \$261 VDD sky130_fd_pr__pfet_01v8 L=0.6 W=1.4 AS=0.406
+ AD=0.406 PS=3.38 PD=3.38
M$132 \$109 \$177 \$265 VDD sky130_fd_pr__pfet_01v8 L=0.6 W=1.4 AS=0.406
+ AD=0.406 PS=3.38 PD=3.38
M$133 cm \$177 \$266 VDD sky130_fd_pr__pfet_01v8 L=0.6 W=1.4 AS=0.406 AD=0.406
+ PS=3.38 PD=3.38
M$134 \$162 \$177 \$261 VDD sky130_fd_pr__pfet_01v8 L=0.6 W=1.4 AS=0.406
+ AD=0.406 PS=3.38 PD=3.38
M$135 \$109 \$177 \$265 VDD sky130_fd_pr__pfet_01v8 L=0.6 W=1.4 AS=0.406
+ AD=0.406 PS=3.38 PD=3.38
M$136 cm \$177 \$266 VDD sky130_fd_pr__pfet_01v8 L=0.6 W=1.4 AS=0.406 AD=0.406
+ PS=3.38 PD=3.38
M$137 \$162 \$177 \$261 VDD sky130_fd_pr__pfet_01v8 L=0.6 W=1.4 AS=0.406
+ AD=0.406 PS=3.38 PD=3.38
M$138 \$109 \$177 \$265 VDD sky130_fd_pr__pfet_01v8 L=0.6 W=1.4 AS=0.406
+ AD=0.406 PS=3.38 PD=3.38
M$139 op \$177 \$50 VDD sky130_fd_pr__pfet_01v8 L=0.6 W=1.4 AS=0.406 AD=0.406
+ PS=3.38 PD=3.38
M$140 on \$177 \$51 VDD sky130_fd_pr__pfet_01v8 L=0.6 W=1.4 AS=0.406 AD=0.406
+ PS=3.38 PD=3.38
M$141 op \$177 \$50 VDD sky130_fd_pr__pfet_01v8 L=0.6 W=1.4 AS=0.406 AD=0.406
+ PS=3.38 PD=3.38
M$142 on \$177 \$51 VDD sky130_fd_pr__pfet_01v8 L=0.6 W=1.4 AS=0.406 AD=0.406
+ PS=3.38 PD=3.38
M$143 op \$177 \$50 VDD sky130_fd_pr__pfet_01v8 L=0.6 W=1.4 AS=0.406 AD=0.406
+ PS=3.38 PD=3.38
M$144 op \$177 \$50 VDD sky130_fd_pr__pfet_01v8 L=0.6 W=1.4 AS=0.406 AD=0.406
+ PS=3.38 PD=3.38
M$145 on \$177 \$51 VDD sky130_fd_pr__pfet_01v8 L=0.6 W=1.4 AS=0.406 AD=0.406
+ PS=3.38 PD=3.38
M$146 op \$177 \$50 VDD sky130_fd_pr__pfet_01v8 L=0.6 W=1.4 AS=0.406 AD=0.406
+ PS=3.38 PD=3.38
M$147 on \$177 \$51 VDD sky130_fd_pr__pfet_01v8 L=0.6 W=1.4 AS=0.406 AD=0.406
+ PS=3.38 PD=3.38
M$148 on \$177 \$51 VDD sky130_fd_pr__pfet_01v8 L=0.6 W=1.4 AS=0.406 AD=0.406
+ PS=3.38 PD=3.38
M$149 on \$177 \$51 VDD sky130_fd_pr__pfet_01v8 L=0.6 W=1.4 AS=0.406 AD=0.406
+ PS=3.38 PD=3.38
M$150 op \$177 \$50 VDD sky130_fd_pr__pfet_01v8 L=0.6 W=1.4 AS=0.406 AD=0.406
+ PS=3.38 PD=3.38
M$151 on \$177 \$51 VDD sky130_fd_pr__pfet_01v8 L=0.6 W=1.4 AS=0.406 AD=0.406
+ PS=3.38 PD=3.38
M$152 op \$177 \$50 VDD sky130_fd_pr__pfet_01v8 L=0.6 W=1.4 AS=0.406 AD=0.406
+ PS=3.38 PD=3.38
M$153 on \$177 \$51 VDD sky130_fd_pr__pfet_01v8 L=0.6 W=1.4 AS=0.406 AD=0.406
+ PS=3.38 PD=3.38
M$154 op \$177 \$50 VDD sky130_fd_pr__pfet_01v8 L=0.6 W=1.4 AS=0.406 AD=0.406
+ PS=3.38 PD=3.38
M$155 on \$177 \$51 VDD sky130_fd_pr__pfet_01v8 L=0.6 W=1.4 AS=0.406 AD=0.406
+ PS=3.38 PD=3.38
M$156 op \$177 \$50 VDD sky130_fd_pr__pfet_01v8 L=0.6 W=1.4 AS=0.406 AD=0.406
+ PS=3.38 PD=3.38
M$157 on \$177 \$51 VDD sky130_fd_pr__pfet_01v8 L=0.6 W=1.4 AS=0.406 AD=0.406
+ PS=3.38 PD=3.38
M$158 op \$177 \$50 VDD sky130_fd_pr__pfet_01v8 L=0.6 W=1.4 AS=0.406 AD=0.406
+ PS=3.38 PD=3.38
M$159 op \$177 \$50 VDD sky130_fd_pr__pfet_01v8 L=0.6 W=1.4 AS=0.406 AD=0.406
+ PS=3.38 PD=3.38
M$160 on \$177 \$51 VDD sky130_fd_pr__pfet_01v8 L=0.6 W=1.4 AS=0.406 AD=0.406
+ PS=3.38 PD=3.38
M$161 op \$177 \$50 VDD sky130_fd_pr__pfet_01v8 L=0.6 W=1.4 AS=0.406 AD=0.406
+ PS=3.38 PD=3.38
M$162 on \$177 \$51 VDD sky130_fd_pr__pfet_01v8 L=0.6 W=1.4 AS=0.406 AD=0.406
+ PS=3.38 PD=3.38
M$163 on \$177 \$51 VDD sky130_fd_pr__pfet_01v8 L=0.6 W=1.4 AS=0.406 AD=0.406
+ PS=3.38 PD=3.38
M$164 op \$177 \$50 VDD sky130_fd_pr__pfet_01v8 L=0.6 W=1.4 AS=0.406 AD=0.406
+ PS=3.38 PD=3.38
M$165 on \$177 \$51 VDD sky130_fd_pr__pfet_01v8 L=0.6 W=1.4 AS=0.406 AD=0.406
+ PS=3.38 PD=3.38
M$166 op \$177 \$50 VDD sky130_fd_pr__pfet_01v8 L=0.6 W=1.4 AS=0.406 AD=0.406
+ PS=3.38 PD=3.38
M$167 on \$177 \$51 VDD sky130_fd_pr__pfet_01v8 L=0.6 W=1.4 AS=0.406 AD=0.406
+ PS=3.38 PD=3.38
M$168 op \$177 \$50 VDD sky130_fd_pr__pfet_01v8 L=0.6 W=1.4 AS=0.406 AD=0.406
+ PS=3.38 PD=3.38
M$169 on \$177 \$51 VDD sky130_fd_pr__pfet_01v8 L=0.6 W=1.4 AS=0.406 AD=0.406
+ PS=3.38 PD=3.38
M$170 op \$177 \$50 VDD sky130_fd_pr__pfet_01v8 L=0.6 W=1.4 AS=0.406 AD=0.406
+ PS=3.38 PD=3.38
M$171 on \$177 \$51 VDD sky130_fd_pr__pfet_01v8 L=0.6 W=1.4 AS=0.406 AD=0.406
+ PS=3.38 PD=3.38
M$172 op \$177 \$50 VDD sky130_fd_pr__pfet_01v8 L=0.6 W=1.4 AS=0.406 AD=0.406
+ PS=3.38 PD=3.38
M$173 on \$177 \$51 VDD sky130_fd_pr__pfet_01v8 L=0.6 W=1.4 AS=0.406 AD=0.406
+ PS=3.38 PD=3.38
M$174 op \$177 \$50 VDD sky130_fd_pr__pfet_01v8 L=0.6 W=1.4 AS=0.406 AD=0.406
+ PS=3.38 PD=3.38
M$175 on \$177 \$51 VDD sky130_fd_pr__pfet_01v8 L=0.6 W=1.4 AS=0.406 AD=0.406
+ PS=3.38 PD=3.38
M$176 op \$177 \$50 VDD sky130_fd_pr__pfet_01v8 L=0.6 W=1.4 AS=0.406 AD=0.406
+ PS=3.38 PD=3.38
M$177 op \$177 \$50 VDD sky130_fd_pr__pfet_01v8 L=0.6 W=1.4 AS=0.406 AD=0.406
+ PS=3.38 PD=3.38
M$178 on \$177 \$51 VDD sky130_fd_pr__pfet_01v8 L=0.6 W=1.4 AS=0.406 AD=0.406
+ PS=3.38 PD=3.38
M$179 on VDD VDD VDD sky130_fd_pr__pfet_01v8 L=0.6 W=1.4 AS=0.406 AD=0.406
+ PS=3.38 PD=3.38
M$180 op VDD VDD VDD sky130_fd_pr__pfet_01v8 L=0.6 W=1.4 AS=0.406 AD=0.406
+ PS=3.38 PD=3.38
M$181 op VDD VDD VDD sky130_fd_pr__pfet_01v8 L=0.6 W=1.4 AS=0.406 AD=0.406
+ PS=3.38 PD=3.38
M$182 on VDD VDD VDD sky130_fd_pr__pfet_01v8 L=0.6 W=1.4 AS=0.406 AD=0.406
+ PS=3.38 PD=3.38
M$183 on VDD VDD VDD sky130_fd_pr__pfet_01v8 L=0.6 W=1.4 AS=0.406 AD=0.406
+ PS=3.38 PD=3.38
M$184 op VDD VDD VDD sky130_fd_pr__pfet_01v8 L=0.6 W=1.4 AS=0.406 AD=0.406
+ PS=3.38 PD=3.38
M$185 on VDD VDD VDD sky130_fd_pr__pfet_01v8 L=0.6 W=1.4 AS=0.406 AD=0.406
+ PS=3.38 PD=3.38
M$186 op VDD VDD VDD sky130_fd_pr__pfet_01v8 L=0.6 W=1.4 AS=0.406 AD=0.406
+ PS=3.38 PD=3.38
M$187 \$265 \$109 VDD VDD sky130_fd_pr__pfet_01v8_lvt L=0.6 W=1.4 AS=0.406
+ AD=0.406 PS=3.38 PD=3.38
M$188 \$266 \$109 VDD VDD sky130_fd_pr__pfet_01v8_lvt L=0.6 W=1.4 AS=0.406
+ AD=0.406 PS=3.38 PD=3.38
M$189 \$266 \$109 VDD VDD sky130_fd_pr__pfet_01v8_lvt L=0.6 W=1.4 AS=0.406
+ AD=0.406 PS=3.38 PD=3.38
M$190 \$261 \$109 VDD VDD sky130_fd_pr__pfet_01v8_lvt L=0.6 W=1.4 AS=0.406
+ AD=0.406 PS=3.38 PD=3.38
M$191 \$261 \$109 VDD VDD sky130_fd_pr__pfet_01v8_lvt L=0.6 W=1.4 AS=0.406
+ AD=0.406 PS=3.38 PD=3.38
M$192 \$266 \$109 VDD VDD sky130_fd_pr__pfet_01v8_lvt L=0.6 W=1.4 AS=0.406
+ AD=0.406 PS=3.38 PD=3.38
M$193 \$261 \$109 VDD VDD sky130_fd_pr__pfet_01v8_lvt L=0.6 W=1.4 AS=0.406
+ AD=0.406 PS=3.38 PD=3.38
M$194 \$265 \$109 VDD VDD sky130_fd_pr__pfet_01v8_lvt L=0.6 W=1.4 AS=0.406
+ AD=0.406 PS=3.38 PD=3.38
M$195 \$265 \$109 VDD VDD sky130_fd_pr__pfet_01v8_lvt L=0.6 W=1.4 AS=0.406
+ AD=0.406 PS=3.38 PD=3.38
M$196 \$261 \$109 VDD VDD sky130_fd_pr__pfet_01v8_lvt L=0.6 W=1.4 AS=0.406
+ AD=0.406 PS=3.38 PD=3.38
M$197 \$265 \$109 VDD VDD sky130_fd_pr__pfet_01v8_lvt L=0.6 W=1.4 AS=0.406
+ AD=0.406 PS=3.38 PD=3.38
M$198 \$261 \$109 VDD VDD sky130_fd_pr__pfet_01v8_lvt L=0.6 W=1.4 AS=0.406
+ AD=0.406 PS=3.38 PD=3.38
M$199 \$266 \$109 VDD VDD sky130_fd_pr__pfet_01v8_lvt L=0.6 W=1.4 AS=0.406
+ AD=0.406 PS=3.38 PD=3.38
M$200 \$266 \$109 VDD VDD sky130_fd_pr__pfet_01v8_lvt L=0.6 W=1.4 AS=0.406
+ AD=0.406 PS=3.38 PD=3.38
M$201 \$261 \$109 VDD VDD sky130_fd_pr__pfet_01v8_lvt L=0.6 W=1.4 AS=0.406
+ AD=0.406 PS=3.38 PD=3.38
M$202 \$265 \$109 VDD VDD sky130_fd_pr__pfet_01v8_lvt L=0.6 W=1.4 AS=0.406
+ AD=0.406 PS=3.38 PD=3.38
M$203 \$266 \$109 VDD VDD sky130_fd_pr__pfet_01v8_lvt L=0.6 W=1.4 AS=0.406
+ AD=0.406 PS=3.38 PD=3.38
M$204 \$265 \$109 VDD VDD sky130_fd_pr__pfet_01v8_lvt L=0.6 W=1.4 AS=0.406
+ AD=0.406 PS=3.38 PD=3.38
M$205 \$50 \$109 VDD VDD sky130_fd_pr__pfet_01v8_lvt L=0.6 W=1.4 AS=0.406
+ AD=0.406 PS=3.38 PD=3.38
M$206 \$51 \$109 VDD VDD sky130_fd_pr__pfet_01v8_lvt L=0.6 W=1.4 AS=0.406
+ AD=0.406 PS=3.38 PD=3.38
M$207 \$50 \$109 VDD VDD sky130_fd_pr__pfet_01v8_lvt L=0.6 W=1.4 AS=0.406
+ AD=0.406 PS=3.38 PD=3.38
M$208 \$51 \$109 VDD VDD sky130_fd_pr__pfet_01v8_lvt L=0.6 W=1.4 AS=0.406
+ AD=0.406 PS=3.38 PD=3.38
M$209 \$50 \$109 VDD VDD sky130_fd_pr__pfet_01v8_lvt L=0.6 W=1.4 AS=0.406
+ AD=0.406 PS=3.38 PD=3.38
M$210 \$51 \$109 VDD VDD sky130_fd_pr__pfet_01v8_lvt L=0.6 W=1.4 AS=0.406
+ AD=0.406 PS=3.38 PD=3.38
M$211 \$50 \$109 VDD VDD sky130_fd_pr__pfet_01v8_lvt L=0.6 W=1.4 AS=0.406
+ AD=0.406 PS=3.38 PD=3.38
M$212 \$50 \$109 VDD VDD sky130_fd_pr__pfet_01v8_lvt L=0.6 W=1.4 AS=0.406
+ AD=0.406 PS=3.38 PD=3.38
M$213 \$51 \$109 VDD VDD sky130_fd_pr__pfet_01v8_lvt L=0.6 W=1.4 AS=0.406
+ AD=0.406 PS=3.38 PD=3.38
M$214 \$50 \$109 VDD VDD sky130_fd_pr__pfet_01v8_lvt L=0.6 W=1.4 AS=0.406
+ AD=0.406 PS=3.38 PD=3.38
M$215 \$51 \$109 VDD VDD sky130_fd_pr__pfet_01v8_lvt L=0.6 W=1.4 AS=0.406
+ AD=0.406 PS=3.38 PD=3.38
M$216 \$50 \$109 VDD VDD sky130_fd_pr__pfet_01v8_lvt L=0.6 W=1.4 AS=0.406
+ AD=0.406 PS=3.38 PD=3.38
M$217 \$51 \$109 VDD VDD sky130_fd_pr__pfet_01v8_lvt L=0.6 W=1.4 AS=0.406
+ AD=0.406 PS=3.38 PD=3.38
M$218 \$50 \$109 VDD VDD sky130_fd_pr__pfet_01v8_lvt L=0.6 W=1.4 AS=0.406
+ AD=0.406 PS=3.38 PD=3.38
M$219 \$51 \$109 VDD VDD sky130_fd_pr__pfet_01v8_lvt L=0.6 W=1.4 AS=0.406
+ AD=0.406 PS=3.38 PD=3.38
M$220 \$51 \$109 VDD VDD sky130_fd_pr__pfet_01v8_lvt L=0.6 W=1.4 AS=0.406
+ AD=0.406 PS=3.38 PD=3.38
M$221 \$51 \$109 VDD VDD sky130_fd_pr__pfet_01v8_lvt L=0.6 W=1.4 AS=0.406
+ AD=0.406 PS=3.38 PD=3.38
M$222 \$50 \$109 VDD VDD sky130_fd_pr__pfet_01v8_lvt L=0.6 W=1.4 AS=0.406
+ AD=0.406 PS=3.38 PD=3.38
M$223 \$51 \$109 VDD VDD sky130_fd_pr__pfet_01v8_lvt L=0.6 W=1.4 AS=0.406
+ AD=0.406 PS=3.38 PD=3.38
M$224 \$50 \$109 VDD VDD sky130_fd_pr__pfet_01v8_lvt L=0.6 W=1.4 AS=0.406
+ AD=0.406 PS=3.38 PD=3.38
M$225 \$51 \$109 VDD VDD sky130_fd_pr__pfet_01v8_lvt L=0.6 W=1.4 AS=0.406
+ AD=0.406 PS=3.38 PD=3.38
M$226 \$50 \$109 VDD VDD sky130_fd_pr__pfet_01v8_lvt L=0.6 W=1.4 AS=0.406
+ AD=0.406 PS=3.38 PD=3.38
M$227 \$51 \$109 VDD VDD sky130_fd_pr__pfet_01v8_lvt L=0.6 W=1.4 AS=0.406
+ AD=0.406 PS=3.38 PD=3.38
M$228 \$50 \$109 VDD VDD sky130_fd_pr__pfet_01v8_lvt L=0.6 W=1.4 AS=0.406
+ AD=0.406 PS=3.38 PD=3.38
M$229 \$51 \$109 VDD VDD sky130_fd_pr__pfet_01v8_lvt L=0.6 W=1.4 AS=0.406
+ AD=0.406 PS=3.38 PD=3.38
M$230 \$51 \$109 VDD VDD sky130_fd_pr__pfet_01v8_lvt L=0.6 W=1.4 AS=0.406
+ AD=0.406 PS=3.38 PD=3.38
M$231 \$50 \$109 VDD VDD sky130_fd_pr__pfet_01v8_lvt L=0.6 W=1.4 AS=0.406
+ AD=0.406 PS=3.38 PD=3.38
M$232 \$51 \$109 VDD VDD sky130_fd_pr__pfet_01v8_lvt L=0.6 W=1.4 AS=0.406
+ AD=0.406 PS=3.38 PD=3.38
M$233 \$50 \$109 VDD VDD sky130_fd_pr__pfet_01v8_lvt L=0.6 W=1.4 AS=0.406
+ AD=0.406 PS=3.38 PD=3.38
M$234 \$51 \$109 VDD VDD sky130_fd_pr__pfet_01v8_lvt L=0.6 W=1.4 AS=0.406
+ AD=0.406 PS=3.38 PD=3.38
M$235 \$50 \$109 VDD VDD sky130_fd_pr__pfet_01v8_lvt L=0.6 W=1.4 AS=0.406
+ AD=0.406 PS=3.38 PD=3.38
M$236 \$50 \$109 VDD VDD sky130_fd_pr__pfet_01v8_lvt L=0.6 W=1.4 AS=0.406
+ AD=0.406 PS=3.38 PD=3.38
M$237 \$50 \$109 VDD VDD sky130_fd_pr__pfet_01v8_lvt L=0.6 W=1.4 AS=0.406
+ AD=0.406 PS=3.38 PD=3.38
M$238 \$51 \$109 VDD VDD sky130_fd_pr__pfet_01v8_lvt L=0.6 W=1.4 AS=0.406
+ AD=0.406 PS=3.38 PD=3.38
M$239 \$50 \$109 VDD VDD sky130_fd_pr__pfet_01v8_lvt L=0.6 W=1.4 AS=0.406
+ AD=0.406 PS=3.38 PD=3.38
M$240 \$50 \$109 VDD VDD sky130_fd_pr__pfet_01v8_lvt L=0.6 W=1.4 AS=0.406
+ AD=0.406 PS=3.38 PD=3.38
M$241 \$51 \$109 VDD VDD sky130_fd_pr__pfet_01v8_lvt L=0.6 W=1.4 AS=0.406
+ AD=0.406 PS=3.38 PD=3.38
M$242 \$50 \$109 VDD VDD sky130_fd_pr__pfet_01v8_lvt L=0.6 W=1.4 AS=0.406
+ AD=0.406 PS=3.38 PD=3.38
M$243 \$51 \$109 VDD VDD sky130_fd_pr__pfet_01v8_lvt L=0.6 W=1.4 AS=0.406
+ AD=0.406 PS=3.38 PD=3.38
M$244 \$50 \$109 VDD VDD sky130_fd_pr__pfet_01v8_lvt L=0.6 W=1.4 AS=0.406
+ AD=0.406 PS=3.38 PD=3.38
M$245 \$51 \$109 VDD VDD sky130_fd_pr__pfet_01v8_lvt L=0.6 W=1.4 AS=0.406
+ AD=0.406 PS=3.38 PD=3.38
M$246 \$50 \$109 VDD VDD sky130_fd_pr__pfet_01v8_lvt L=0.6 W=1.4 AS=0.406
+ AD=0.406 PS=3.38 PD=3.38
M$247 \$51 \$109 VDD VDD sky130_fd_pr__pfet_01v8_lvt L=0.6 W=1.4 AS=0.406
+ AD=0.406 PS=3.38 PD=3.38
M$248 \$50 \$109 VDD VDD sky130_fd_pr__pfet_01v8_lvt L=0.6 W=1.4 AS=0.406
+ AD=0.406 PS=3.38 PD=3.38
M$249 \$51 \$109 VDD VDD sky130_fd_pr__pfet_01v8_lvt L=0.6 W=1.4 AS=0.406
+ AD=0.406 PS=3.38 PD=3.38
M$250 \$50 \$109 VDD VDD sky130_fd_pr__pfet_01v8_lvt L=0.6 W=1.4 AS=0.406
+ AD=0.406 PS=3.38 PD=3.38
M$251 \$51 \$109 VDD VDD sky130_fd_pr__pfet_01v8_lvt L=0.6 W=1.4 AS=0.406
+ AD=0.406 PS=3.38 PD=3.38
M$252 \$51 \$109 VDD VDD sky130_fd_pr__pfet_01v8_lvt L=0.6 W=1.4 AS=0.406
+ AD=0.406 PS=3.38 PD=3.38
M$253 \$109 VDD VDD VDD sky130_fd_pr__pfet_01v8 L=0.6 W=1.4 AS=0.406 AD=0.406
+ PS=3.38 PD=3.38
M$254 \$162 VDD VDD VDD sky130_fd_pr__pfet_01v8 L=0.6 W=1.4 AS=0.406 AD=0.406
+ PS=3.38 PD=3.38
M$255 cm VDD VDD VDD sky130_fd_pr__pfet_01v8 L=0.6 W=1.4 AS=0.406 AD=0.406
+ PS=3.38 PD=3.38
M$256 \$109 VDD VDD VDD sky130_fd_pr__pfet_01v8 L=0.6 W=1.4 AS=0.406 AD=0.406
+ PS=3.38 PD=3.38
M$257 \$162 VDD VDD VDD sky130_fd_pr__pfet_01v8 L=0.6 W=1.4 AS=0.406 AD=0.406
+ PS=3.38 PD=3.38
M$258 cm VDD VDD VDD sky130_fd_pr__pfet_01v8 L=0.6 W=1.4 AS=0.406 AD=0.406
+ PS=3.38 PD=3.38
M$259 \$266 VDD VDD VDD sky130_fd_pr__pfet_01v8 L=0.6 W=1.4 AS=0.406 AD=0.406
+ PS=3.38 PD=3.38
M$260 \$265 \$265 \$265 VDD sky130_fd_pr__pfet_01v8 L=0.6 W=1.4 AS=0.406
+ AD=0.406 PS=3.38 PD=3.38
M$261 \$265 \$265 \$265 VDD sky130_fd_pr__pfet_01v8 L=0.6 W=1.4 AS=0.406
+ AD=0.406 PS=3.38 PD=3.38
M$262 \$261 \$261 \$261 VDD sky130_fd_pr__pfet_01v8 L=0.6 W=1.4 AS=0.406
+ AD=0.406 PS=3.38 PD=3.38
M$263 \$261 \$261 \$261 VDD sky130_fd_pr__pfet_01v8 L=0.6 W=1.4 AS=0.406
+ AD=0.406 PS=3.38 PD=3.38
M$264 \$266 VDD VDD VDD sky130_fd_pr__pfet_01v8 L=0.6 W=1.4 AS=0.406 AD=0.406
+ PS=3.38 PD=3.38
M$265 \$50 VDD VDD VDD sky130_fd_pr__pfet_01v8 L=0.6 W=1.4 AS=0.406 AD=0.406
+ PS=3.38 PD=3.38
M$266 \$50 VDD VDD VDD sky130_fd_pr__pfet_01v8 L=0.6 W=1.4 AS=0.406 AD=0.406
+ PS=3.38 PD=3.38
M$267 \$51 \$51 \$51 VDD sky130_fd_pr__pfet_01v8 L=0.6 W=1.4 AS=0.406 AD=0.406
+ PS=3.38 PD=3.38
M$268 VDD VDD VDD VDD sky130_fd_pr__pfet_01v8 L=0.6 W=1.4 AS=0.406 AD=0.406
+ PS=3.38 PD=3.38
M$269 \$51 VDD VDD VDD sky130_fd_pr__pfet_01v8 L=0.6 W=1.4 AS=0.406 AD=0.406
+ PS=3.38 PD=3.38
M$270 \$51 VDD VDD VDD sky130_fd_pr__pfet_01v8 L=0.6 W=1.4 AS=0.406 AD=0.406
+ PS=3.38 PD=3.38
M$271 VDD VDD VDD VDD sky130_fd_pr__pfet_01v8 L=0.6 W=1.4 AS=0.406 AD=0.406
+ PS=3.38 PD=3.38
M$272 VDD VDD VDD VDD sky130_fd_pr__pfet_01v8 L=0.6 W=1.4 AS=0.406 AD=0.406
+ PS=3.38 PD=3.38
M$273 \$50 \$50 \$50 VDD sky130_fd_pr__pfet_01v8 L=0.6 W=1.4 AS=0.406 AD=0.406
+ PS=3.38 PD=3.38
M$274 \$50 \$50 \$50 VDD sky130_fd_pr__pfet_01v8 L=0.6 W=1.4 AS=0.406 AD=0.406
+ PS=3.38 PD=3.38
M$275 VDD VDD VDD VDD sky130_fd_pr__pfet_01v8 L=0.6 W=1.4 AS=0.406 AD=0.406
+ PS=3.38 PD=3.38
M$276 \$51 \$51 \$51 VDD sky130_fd_pr__pfet_01v8 L=0.6 W=1.4 AS=0.406 AD=0.406
+ PS=3.38 PD=3.38
M$277 VSS VSS VSS sky130_gnd sky130_fd_pr__nfet_01v8 L=0.6 W=1.4 AS=0.406
+ AD=0.406 PS=3.38 PD=3.38
M$278 VSS VSS VSS sky130_gnd sky130_fd_pr__nfet_01v8 L=0.6 W=1.4 AS=0.406
+ AD=0.406 PS=3.38 PD=3.38
M$279 VSS VSS VSS sky130_gnd sky130_fd_pr__nfet_01v8 L=0.6 W=1.4 AS=0.406
+ AD=0.406 PS=3.38 PD=3.38
M$280 VSS VSS VSS sky130_gnd sky130_fd_pr__nfet_01v8 L=0.6 W=1.4 AS=0.406
+ AD=0.406 PS=3.38 PD=3.38
M$281 VSS VSS VSS sky130_gnd sky130_fd_pr__nfet_01v8 L=0.6 W=1.4 AS=0.406
+ AD=0.406 PS=3.38 PD=3.38
M$282 VSS VSS VSS sky130_gnd sky130_fd_pr__nfet_01v8 L=0.6 W=1.4 AS=0.406
+ AD=0.406 PS=3.38 PD=3.38
M$283 VSS VSS VSS sky130_gnd sky130_fd_pr__nfet_01v8 L=0.6 W=1.4 AS=0.406
+ AD=0.406 PS=3.38 PD=3.38
M$284 VSS VSS VSS sky130_gnd sky130_fd_pr__nfet_01v8 L=0.6 W=1.4 AS=0.406
+ AD=0.406 PS=3.38 PD=3.38
M$285 VSS VSS VSS sky130_gnd sky130_fd_pr__nfet_01v8 L=0.6 W=1.4 AS=0.406
+ AD=0.406 PS=3.38 PD=3.38
M$286 VSS VSS VSS sky130_gnd sky130_fd_pr__nfet_01v8 L=0.6 W=1.4 AS=0.406
+ AD=0.406 PS=3.38 PD=3.38
M$287 VSS VSS VSS sky130_gnd sky130_fd_pr__nfet_01v8 L=0.6 W=1.4 AS=0.406
+ AD=0.406 PS=3.38 PD=3.38
M$288 VSS VSS VSS sky130_gnd sky130_fd_pr__nfet_01v8 L=0.6 W=1.4 AS=0.406
+ AD=0.406 PS=3.38 PD=3.38
M$289 VSS VSS VSS sky130_gnd sky130_fd_pr__nfet_01v8 L=0.6 W=1.4 AS=0.406
+ AD=0.406 PS=3.38 PD=3.38
M$290 VSS VSS VSS sky130_gnd sky130_fd_pr__nfet_01v8 L=0.6 W=1.4 AS=0.406
+ AD=0.406 PS=3.38 PD=3.38
M$291 VSS VSS VSS sky130_gnd sky130_fd_pr__nfet_01v8 L=0.6 W=1.4 AS=0.406
+ AD=0.406 PS=3.38 PD=3.38
M$292 VSS VSS VSS sky130_gnd sky130_fd_pr__nfet_01v8 L=0.6 W=1.4 AS=0.406
+ AD=0.406 PS=3.38 PD=3.38
M$293 VSS VSS VSS sky130_gnd sky130_fd_pr__nfet_01v8 L=0.6 W=1.4 AS=0.406
+ AD=0.406 PS=3.38 PD=3.38
M$294 VSS VSS VSS sky130_gnd sky130_fd_pr__nfet_01v8 L=0.6 W=1.4 AS=0.406
+ AD=0.406 PS=3.38 PD=3.38
M$295 VSS VSS VSS sky130_gnd sky130_fd_pr__nfet_01v8 L=0.6 W=1.4 AS=0.406
+ AD=0.406 PS=3.38 PD=3.38
M$296 VSS VSS VSS sky130_gnd sky130_fd_pr__nfet_01v8 L=0.6 W=1.4 AS=0.406
+ AD=0.406 PS=3.38 PD=3.38
M$297 VSS VSS VSS sky130_gnd sky130_fd_pr__nfet_01v8 L=0.6 W=1.4 AS=0.406
+ AD=0.406 PS=3.38 PD=3.38
M$298 VSS VSS VSS sky130_gnd sky130_fd_pr__nfet_01v8 L=0.6 W=1.4 AS=0.406
+ AD=0.406 PS=3.38 PD=3.38
M$299 VSS VSS VSS sky130_gnd sky130_fd_pr__nfet_01v8 L=0.6 W=1.4 AS=0.406
+ AD=0.406 PS=3.38 PD=3.38
M$300 VSS VSS VSS sky130_gnd sky130_fd_pr__nfet_01v8 L=0.6 W=1.4 AS=0.406
+ AD=0.406 PS=3.38 PD=3.38
M$301 VSS VSS VSS sky130_gnd sky130_fd_pr__nfet_01v8 L=0.6 W=1.4 AS=0.406
+ AD=0.406 PS=3.38 PD=3.38
M$302 bias_a bias_a bias_a sky130_gnd sky130_fd_pr__nfet_01v8 L=0.6 W=1.4
+ AS=0.406 AD=0.406 PS=3.38 PD=3.38
M$303 bias_a bias_a bias_a sky130_gnd sky130_fd_pr__nfet_01v8 L=0.6 W=1.4
+ AS=0.406 AD=0.406 PS=3.38 PD=3.38
M$304 bias_a bias_a bias_a sky130_gnd sky130_fd_pr__nfet_01v8 L=0.6 W=1.4
+ AS=0.406 AD=0.406 PS=3.38 PD=3.38
M$305 bias_a bias_a bias_a sky130_gnd sky130_fd_pr__nfet_01v8 L=0.6 W=1.4
+ AS=0.406 AD=0.406 PS=3.38 PD=3.38
M$306 \$121 \$121 \$121 sky130_gnd sky130_fd_pr__nfet_01v8 L=0.6 W=1.4 AS=0.406
+ AD=0.406 PS=3.38 PD=3.38
M$307 \$121 \$121 \$121 sky130_gnd sky130_fd_pr__nfet_01v8 L=0.6 W=1.4 AS=0.406
+ AD=0.406 PS=3.38 PD=3.38
M$308 \$121 \$121 \$121 sky130_gnd sky130_fd_pr__nfet_01v8 L=0.6 W=1.4 AS=0.406
+ AD=0.406 PS=3.38 PD=3.38
M$309 \$121 \$121 \$121 sky130_gnd sky130_fd_pr__nfet_01v8 L=0.6 W=1.4 AS=0.406
+ AD=0.406 PS=3.38 PD=3.38
M$310 \$121 \$121 \$121 sky130_gnd sky130_fd_pr__nfet_01v8 L=0.6 W=1.4 AS=0.406
+ AD=0.406 PS=3.38 PD=3.38
M$311 \$121 \$121 \$121 sky130_gnd sky130_fd_pr__nfet_01v8 L=0.6 W=1.4 AS=0.406
+ AD=0.406 PS=3.38 PD=3.38
M$312 \$121 VSS VSS sky130_gnd sky130_fd_pr__nfet_01v8 L=0.6 W=1.4 AS=0.406
+ AD=0.406 PS=3.38 PD=3.38
M$313 \$121 VSS VSS sky130_gnd sky130_fd_pr__nfet_01v8 L=0.6 W=1.4 AS=0.406
+ AD=0.406 PS=3.38 PD=3.38
M$314 \$121 VSS VSS sky130_gnd sky130_fd_pr__nfet_01v8 L=0.6 W=1.4 AS=0.406
+ AD=0.406 PS=3.38 PD=3.38
M$315 \$121 VSS VSS sky130_gnd sky130_fd_pr__nfet_01v8 L=0.6 W=1.4 AS=0.406
+ AD=0.406 PS=3.38 PD=3.38
M$316 \$121 VSS VSS sky130_gnd sky130_fd_pr__nfet_01v8 L=0.6 W=1.4 AS=0.406
+ AD=0.406 PS=3.38 PD=3.38
M$317 \$121 VSS VSS sky130_gnd sky130_fd_pr__nfet_01v8 L=0.6 W=1.4 AS=0.406
+ AD=0.406 PS=3.38 PD=3.38
M$318 \$18 VSS VSS sky130_gnd sky130_fd_pr__nfet_01v8 L=0.6 W=1.4 AS=0.406
+ AD=0.406 PS=3.38 PD=3.38
M$319 \$18 VSS VSS sky130_gnd sky130_fd_pr__nfet_01v8 L=0.6 W=1.4 AS=0.406
+ AD=0.406 PS=3.38 PD=3.38
M$320 \$18 VSS VSS sky130_gnd sky130_fd_pr__nfet_01v8 L=0.6 W=1.4 AS=0.406
+ AD=0.406 PS=3.38 PD=3.38
M$321 \$18 VSS VSS sky130_gnd sky130_fd_pr__nfet_01v8 L=0.6 W=1.4 AS=0.406
+ AD=0.406 PS=3.38 PD=3.38
M$322 \$18 VSS VSS sky130_gnd sky130_fd_pr__nfet_01v8 L=0.6 W=1.4 AS=0.406
+ AD=0.406 PS=3.38 PD=3.38
M$323 \$18 VSS VSS sky130_gnd sky130_fd_pr__nfet_01v8 L=0.6 W=1.4 AS=0.406
+ AD=0.406 PS=3.38 PD=3.38
M$324 VSS VSS VSS sky130_gnd sky130_fd_pr__nfet_01v8 L=0.6 W=1.4 AS=0.406
+ AD=0.406 PS=3.38 PD=3.38
M$325 VSS VSS VSS sky130_gnd sky130_fd_pr__nfet_01v8 L=0.6 W=1.4 AS=0.406
+ AD=0.406 PS=3.38 PD=3.38
M$326 \$16 \$16 \$16 sky130_gnd sky130_fd_pr__nfet_01v8 L=0.6 W=1.4 AS=0.406
+ AD=0.406 PS=3.38 PD=3.38
M$327 \$16 \$16 \$16 sky130_gnd sky130_fd_pr__nfet_01v8 L=0.6 W=1.4 AS=0.406
+ AD=0.406 PS=3.38 PD=3.38
M$328 \$16 \$16 \$16 sky130_gnd sky130_fd_pr__nfet_01v8 L=0.6 W=1.4 AS=0.406
+ AD=0.406 PS=3.38 PD=3.38
M$329 \$16 \$16 \$16 sky130_gnd sky130_fd_pr__nfet_01v8 L=0.6 W=1.4 AS=0.406
+ AD=0.406 PS=3.38 PD=3.38
M$330 \$16 \$16 \$16 sky130_gnd sky130_fd_pr__nfet_01v8 L=0.6 W=1.4 AS=0.406
+ AD=0.406 PS=3.38 PD=3.38
M$331 \$16 \$16 \$16 sky130_gnd sky130_fd_pr__nfet_01v8 L=0.6 W=1.4 AS=0.406
+ AD=0.406 PS=3.38 PD=3.38
M$332 cm cm cm sky130_gnd sky130_fd_pr__nfet_01v8 L=0.6 W=1.4 AS=0.406 AD=0.406
+ PS=3.38 PD=3.38
M$333 cm cm cm sky130_gnd sky130_fd_pr__nfet_01v8 L=0.6 W=1.4 AS=0.406 AD=0.406
+ PS=3.38 PD=3.38
M$334 cm cm cm sky130_gnd sky130_fd_pr__nfet_01v8 L=0.6 W=1.4 AS=0.406 AD=0.406
+ PS=3.38 PD=3.38
M$335 cm cm cm sky130_gnd sky130_fd_pr__nfet_01v8 L=0.6 W=1.4 AS=0.406 AD=0.406
+ PS=3.38 PD=3.38
M$336 cm cm cm sky130_gnd sky130_fd_pr__nfet_01v8 L=0.6 W=1.4 AS=0.406 AD=0.406
+ PS=3.38 PD=3.38
M$337 cm cm cm sky130_gnd sky130_fd_pr__nfet_01v8 L=0.6 W=1.4 AS=0.406 AD=0.406
+ PS=3.38 PD=3.38
M$338 cm cm cm sky130_gnd sky130_fd_pr__nfet_01v8 L=0.6 W=1.4 AS=0.406 AD=0.406
+ PS=3.38 PD=3.38
M$339 cm cm cm sky130_gnd sky130_fd_pr__nfet_01v8 L=0.6 W=1.4 AS=0.406 AD=0.406
+ PS=3.38 PD=3.38
M$340 \$73 \$73 \$73 sky130_gnd sky130_fd_pr__nfet_01v8 L=0.6 W=1.4 AS=0.406
+ AD=0.406 PS=3.38 PD=3.38
M$341 \$73 \$73 \$73 sky130_gnd sky130_fd_pr__nfet_01v8 L=0.6 W=1.4 AS=0.406
+ AD=0.406 PS=3.38 PD=3.38
M$342 \$73 \$73 \$73 sky130_gnd sky130_fd_pr__nfet_01v8 L=0.6 W=1.4 AS=0.406
+ AD=0.406 PS=3.38 PD=3.38
M$343 \$73 \$73 \$73 sky130_gnd sky130_fd_pr__nfet_01v8 L=0.6 W=1.4 AS=0.406
+ AD=0.406 PS=3.38 PD=3.38
M$344 \$73 \$73 \$73 sky130_gnd sky130_fd_pr__nfet_01v8 L=0.6 W=1.4 AS=0.406
+ AD=0.406 PS=3.38 PD=3.38
M$345 \$73 \$73 \$73 sky130_gnd sky130_fd_pr__nfet_01v8 L=0.6 W=1.4 AS=0.406
+ AD=0.406 PS=3.38 PD=3.38
M$346 \$73 \$73 \$73 sky130_gnd sky130_fd_pr__nfet_01v8 L=0.6 W=1.4 AS=0.406
+ AD=0.406 PS=3.38 PD=3.38
M$347 \$73 \$73 \$73 sky130_gnd sky130_fd_pr__nfet_01v8 L=0.6 W=1.4 AS=0.406
+ AD=0.406 PS=3.38 PD=3.38
M$348 \$17 VSS VSS sky130_gnd sky130_fd_pr__nfet_01v8 L=0.6 W=1.4 AS=0.406
+ AD=0.406 PS=3.38 PD=3.38
M$349 \$17 VSS VSS sky130_gnd sky130_fd_pr__nfet_01v8 L=0.6 W=1.4 AS=0.406
+ AD=0.406 PS=3.38 PD=3.38
M$350 \$17 VSS VSS sky130_gnd sky130_fd_pr__nfet_01v8 L=0.6 W=1.4 AS=0.406
+ AD=0.406 PS=3.38 PD=3.38
M$351 \$17 VSS VSS sky130_gnd sky130_fd_pr__nfet_01v8 L=0.6 W=1.4 AS=0.406
+ AD=0.406 PS=3.38 PD=3.38
M$352 \$17 VSS VSS sky130_gnd sky130_fd_pr__nfet_01v8 L=0.6 W=1.4 AS=0.406
+ AD=0.406 PS=3.38 PD=3.38
M$353 \$17 VSS VSS sky130_gnd sky130_fd_pr__nfet_01v8 L=0.6 W=1.4 AS=0.406
+ AD=0.406 PS=3.38 PD=3.38
M$354 \$17 VSS VSS sky130_gnd sky130_fd_pr__nfet_01v8 L=0.6 W=1.4 AS=0.406
+ AD=0.406 PS=3.38 PD=3.38
M$355 \$17 VSS VSS sky130_gnd sky130_fd_pr__nfet_01v8 L=0.6 W=1.4 AS=0.406
+ AD=0.406 PS=3.38 PD=3.38
M$356 bias_a \$73 \$121 sky130_gnd sky130_fd_pr__nfet_01v8 L=0.6 W=1.4 AS=0.406
+ AD=0.406 PS=3.38 PD=3.38
M$357 bias_a \$73 \$121 sky130_gnd sky130_fd_pr__nfet_01v8 L=0.6 W=1.4 AS=0.406
+ AD=0.406 PS=3.38 PD=3.38
M$358 bias_a \$73 \$121 sky130_gnd sky130_fd_pr__nfet_01v8 L=0.6 W=1.4 AS=0.406
+ AD=0.406 PS=3.38 PD=3.38
M$359 bias_a \$73 \$121 sky130_gnd sky130_fd_pr__nfet_01v8 L=0.6 W=1.4 AS=0.406
+ AD=0.406 PS=3.38 PD=3.38
M$360 bias_a \$73 \$121 sky130_gnd sky130_fd_pr__nfet_01v8 L=0.6 W=1.4 AS=0.406
+ AD=0.406 PS=3.38 PD=3.38
M$361 bias_a \$73 \$121 sky130_gnd sky130_fd_pr__nfet_01v8 L=0.6 W=1.4 AS=0.406
+ AD=0.406 PS=3.38 PD=3.38
M$362 bias_a \$73 \$121 sky130_gnd sky130_fd_pr__nfet_01v8 L=0.6 W=1.4 AS=0.406
+ AD=0.406 PS=3.38 PD=3.38
M$363 bias_a \$73 \$121 sky130_gnd sky130_fd_pr__nfet_01v8 L=0.6 W=1.4 AS=0.406
+ AD=0.406 PS=3.38 PD=3.38
M$364 bias_a \$73 \$121 sky130_gnd sky130_fd_pr__nfet_01v8 L=0.6 W=1.4 AS=0.406
+ AD=0.406 PS=3.38 PD=3.38
M$365 bias_a \$73 \$121 sky130_gnd sky130_fd_pr__nfet_01v8 L=0.6 W=1.4 AS=0.406
+ AD=0.406 PS=3.38 PD=3.38
M$366 bias_a \$73 \$121 sky130_gnd sky130_fd_pr__nfet_01v8 L=0.6 W=1.4 AS=0.406
+ AD=0.406 PS=3.38 PD=3.38
M$367 bias_a \$73 \$121 sky130_gnd sky130_fd_pr__nfet_01v8 L=0.6 W=1.4 AS=0.406
+ AD=0.406 PS=3.38 PD=3.38
M$368 bias_a \$73 \$121 sky130_gnd sky130_fd_pr__nfet_01v8 L=0.6 W=1.4 AS=0.406
+ AD=0.406 PS=3.38 PD=3.38
M$369 bias_a \$73 \$121 sky130_gnd sky130_fd_pr__nfet_01v8 L=0.6 W=1.4 AS=0.406
+ AD=0.406 PS=3.38 PD=3.38
M$370 bias_a \$73 \$121 sky130_gnd sky130_fd_pr__nfet_01v8 L=0.6 W=1.4 AS=0.406
+ AD=0.406 PS=3.38 PD=3.38
M$371 bias_a \$73 \$121 sky130_gnd sky130_fd_pr__nfet_01v8 L=0.6 W=1.4 AS=0.406
+ AD=0.406 PS=3.38 PD=3.38
M$372 bias_a \$73 \$121 sky130_gnd sky130_fd_pr__nfet_01v8 L=0.6 W=1.4 AS=0.406
+ AD=0.406 PS=3.38 PD=3.38
M$373 bias_a \$73 \$121 sky130_gnd sky130_fd_pr__nfet_01v8 L=0.6 W=1.4 AS=0.406
+ AD=0.406 PS=3.38 PD=3.38
M$374 \$177 IBIAS VSS sky130_gnd sky130_fd_pr__nfet_01v8 L=0.6 W=1.4 AS=0.406
+ AD=0.406 PS=3.38 PD=3.38
M$375 \$177 IBIAS VSS sky130_gnd sky130_fd_pr__nfet_01v8 L=0.6 W=1.4 AS=0.406
+ AD=0.406 PS=3.38 PD=3.38
M$376 IBIAS IBIAS VSS sky130_gnd sky130_fd_pr__nfet_01v8 L=0.6 W=1.4 AS=0.406
+ AD=0.406 PS=3.38 PD=3.38
M$377 \$177 IBIAS VSS sky130_gnd sky130_fd_pr__nfet_01v8 L=0.6 W=1.4 AS=0.406
+ AD=0.406 PS=3.38 PD=3.38
M$378 IBIAS IBIAS VSS sky130_gnd sky130_fd_pr__nfet_01v8 L=0.6 W=1.4 AS=0.406
+ AD=0.406 PS=3.38 PD=3.38
M$379 \$177 IBIAS VSS sky130_gnd sky130_fd_pr__nfet_01v8 L=0.6 W=1.4 AS=0.406
+ AD=0.406 PS=3.38 PD=3.38
M$380 IBIAS IBIAS VSS sky130_gnd sky130_fd_pr__nfet_01v8 L=0.6 W=1.4 AS=0.406
+ AD=0.406 PS=3.38 PD=3.38
M$381 IBIAS IBIAS VSS sky130_gnd sky130_fd_pr__nfet_01v8 L=0.6 W=1.4 AS=0.406
+ AD=0.406 PS=3.38 PD=3.38
M$382 IBIAS IBIAS VSS sky130_gnd sky130_fd_pr__nfet_01v8 L=0.6 W=1.4 AS=0.406
+ AD=0.406 PS=3.38 PD=3.38
M$383 IBIAS IBIAS VSS sky130_gnd sky130_fd_pr__nfet_01v8 L=0.6 W=1.4 AS=0.406
+ AD=0.406 PS=3.38 PD=3.38
M$384 \$177 IBIAS VSS sky130_gnd sky130_fd_pr__nfet_01v8 L=0.6 W=1.4 AS=0.406
+ AD=0.406 PS=3.38 PD=3.38
M$385 \$177 IBIAS VSS sky130_gnd sky130_fd_pr__nfet_01v8 L=0.6 W=1.4 AS=0.406
+ AD=0.406 PS=3.38 PD=3.38
M$386 IBIAS IBIAS VSS sky130_gnd sky130_fd_pr__nfet_01v8 L=0.6 W=1.4 AS=0.406
+ AD=0.406 PS=3.38 PD=3.38
M$387 \$177 IBIAS VSS sky130_gnd sky130_fd_pr__nfet_01v8 L=0.6 W=1.4 AS=0.406
+ AD=0.406 PS=3.38 PD=3.38
M$388 IBIAS IBIAS VSS sky130_gnd sky130_fd_pr__nfet_01v8 L=0.6 W=1.4 AS=0.406
+ AD=0.406 PS=3.38 PD=3.38
M$389 \$177 IBIAS VSS sky130_gnd sky130_fd_pr__nfet_01v8 L=0.6 W=1.4 AS=0.406
+ AD=0.406 PS=3.38 PD=3.38
M$390 IBIAS IBIAS VSS sky130_gnd sky130_fd_pr__nfet_01v8 L=0.6 W=1.4 AS=0.406
+ AD=0.406 PS=3.38 PD=3.38
M$391 \$177 IBIAS VSS sky130_gnd sky130_fd_pr__nfet_01v8 L=0.6 W=1.4 AS=0.406
+ AD=0.406 PS=3.38 PD=3.38
M$392 \$177 IBIAS VSS sky130_gnd sky130_fd_pr__nfet_01v8 L=0.6 W=1.4 AS=0.406
+ AD=0.406 PS=3.38 PD=3.38
M$393 IBIAS IBIAS VSS sky130_gnd sky130_fd_pr__nfet_01v8 L=0.6 W=1.4 AS=0.406
+ AD=0.406 PS=3.38 PD=3.38
M$394 \$177 IBIAS VSS sky130_gnd sky130_fd_pr__nfet_01v8 L=0.6 W=1.4 AS=0.406
+ AD=0.406 PS=3.38 PD=3.38
M$395 IBIAS IBIAS VSS sky130_gnd sky130_fd_pr__nfet_01v8 L=0.6 W=1.4 AS=0.406
+ AD=0.406 PS=3.38 PD=3.38
M$396 \$177 IBIAS VSS sky130_gnd sky130_fd_pr__nfet_01v8 L=0.6 W=1.4 AS=0.406
+ AD=0.406 PS=3.38 PD=3.38
M$397 IBIAS IBIAS VSS sky130_gnd sky130_fd_pr__nfet_01v8 L=0.6 W=1.4 AS=0.406
+ AD=0.406 PS=3.38 PD=3.38
M$398 \$177 IBIAS VSS sky130_gnd sky130_fd_pr__nfet_01v8 L=0.6 W=1.4 AS=0.406
+ AD=0.406 PS=3.38 PD=3.38
M$399 IBIAS IBIAS VSS sky130_gnd sky130_fd_pr__nfet_01v8 L=0.6 W=1.4 AS=0.406
+ AD=0.406 PS=3.38 PD=3.38
M$400 IBIAS IBIAS VSS sky130_gnd sky130_fd_pr__nfet_01v8 L=0.6 W=1.4 AS=0.406
+ AD=0.406 PS=3.38 PD=3.38
M$401 \$177 IBIAS VSS sky130_gnd sky130_fd_pr__nfet_01v8 L=0.6 W=1.4 AS=0.406
+ AD=0.406 PS=3.38 PD=3.38
M$402 IBIAS IBIAS VSS sky130_gnd sky130_fd_pr__nfet_01v8 L=0.6 W=1.4 AS=0.406
+ AD=0.406 PS=3.38 PD=3.38
M$403 \$177 IBIAS VSS sky130_gnd sky130_fd_pr__nfet_01v8 L=0.6 W=1.4 AS=0.406
+ AD=0.406 PS=3.38 PD=3.38
M$404 IBIAS IBIAS VSS sky130_gnd sky130_fd_pr__nfet_01v8 L=0.6 W=1.4 AS=0.406
+ AD=0.406 PS=3.38 PD=3.38
M$405 \$177 IBIAS VSS sky130_gnd sky130_fd_pr__nfet_01v8 L=0.6 W=1.4 AS=0.406
+ AD=0.406 PS=3.38 PD=3.38
M$406 IBIAS IBIAS VSS sky130_gnd sky130_fd_pr__nfet_01v8 L=0.6 W=1.4 AS=0.406
+ AD=0.406 PS=3.38 PD=3.38
M$407 \$177 IBIAS VSS sky130_gnd sky130_fd_pr__nfet_01v8 L=0.6 W=1.4 AS=0.406
+ AD=0.406 PS=3.38 PD=3.38
M$408 IBIAS IBIAS VSS sky130_gnd sky130_fd_pr__nfet_01v8 L=0.6 W=1.4 AS=0.406
+ AD=0.406 PS=3.38 PD=3.38
M$409 \$177 IBIAS VSS sky130_gnd sky130_fd_pr__nfet_01v8 L=0.6 W=1.4 AS=0.406
+ AD=0.406 PS=3.38 PD=3.38
M$410 \$121 bias_a VSS sky130_gnd sky130_fd_pr__nfet_01v8 L=0.6 W=1.4 AS=0.406
+ AD=0.406 PS=3.38 PD=3.38
M$411 \$121 bias_a VSS sky130_gnd sky130_fd_pr__nfet_01v8 L=0.6 W=1.4 AS=0.406
+ AD=0.406 PS=3.38 PD=3.38
M$412 \$121 bias_a VSS sky130_gnd sky130_fd_pr__nfet_01v8 L=0.6 W=1.4 AS=0.406
+ AD=0.406 PS=3.38 PD=3.38
M$413 \$121 bias_a VSS sky130_gnd sky130_fd_pr__nfet_01v8 L=0.6 W=1.4 AS=0.406
+ AD=0.406 PS=3.38 PD=3.38
M$414 \$121 bias_a VSS sky130_gnd sky130_fd_pr__nfet_01v8 L=0.6 W=1.4 AS=0.406
+ AD=0.406 PS=3.38 PD=3.38
M$415 \$121 bias_a VSS sky130_gnd sky130_fd_pr__nfet_01v8 L=0.6 W=1.4 AS=0.406
+ AD=0.406 PS=3.38 PD=3.38
M$416 \$121 bias_a VSS sky130_gnd sky130_fd_pr__nfet_01v8 L=0.6 W=1.4 AS=0.406
+ AD=0.406 PS=3.38 PD=3.38
M$417 \$121 bias_a VSS sky130_gnd sky130_fd_pr__nfet_01v8 L=0.6 W=1.4 AS=0.406
+ AD=0.406 PS=3.38 PD=3.38
M$418 \$121 bias_a VSS sky130_gnd sky130_fd_pr__nfet_01v8 L=0.6 W=1.4 AS=0.406
+ AD=0.406 PS=3.38 PD=3.38
M$419 \$121 bias_a VSS sky130_gnd sky130_fd_pr__nfet_01v8 L=0.6 W=1.4 AS=0.406
+ AD=0.406 PS=3.38 PD=3.38
M$420 \$121 bias_a VSS sky130_gnd sky130_fd_pr__nfet_01v8 L=0.6 W=1.4 AS=0.406
+ AD=0.406 PS=3.38 PD=3.38
M$421 \$121 bias_a VSS sky130_gnd sky130_fd_pr__nfet_01v8 L=0.6 W=1.4 AS=0.406
+ AD=0.406 PS=3.38 PD=3.38
M$422 \$121 bias_a VSS sky130_gnd sky130_fd_pr__nfet_01v8 L=0.6 W=1.4 AS=0.406
+ AD=0.406 PS=3.38 PD=3.38
M$423 \$121 bias_a VSS sky130_gnd sky130_fd_pr__nfet_01v8 L=0.6 W=1.4 AS=0.406
+ AD=0.406 PS=3.38 PD=3.38
M$424 \$121 bias_a VSS sky130_gnd sky130_fd_pr__nfet_01v8 L=0.6 W=1.4 AS=0.406
+ AD=0.406 PS=3.38 PD=3.38
M$425 \$121 bias_a VSS sky130_gnd sky130_fd_pr__nfet_01v8 L=0.6 W=1.4 AS=0.406
+ AD=0.406 PS=3.38 PD=3.38
M$426 \$121 bias_a VSS sky130_gnd sky130_fd_pr__nfet_01v8 L=0.6 W=1.4 AS=0.406
+ AD=0.406 PS=3.38 PD=3.38
M$427 \$121 bias_a VSS sky130_gnd sky130_fd_pr__nfet_01v8 L=0.6 W=1.4 AS=0.406
+ AD=0.406 PS=3.38 PD=3.38
M$428 \$10.x1_net12 cm VSS sky130_gnd sky130_fd_pr__nfet_01v8 L=0.6 W=1.4
+ AS=0.406 AD=0.406 PS=3.38 PD=3.38
M$429 \$10.x1_net9 cm VSS sky130_gnd sky130_fd_pr__nfet_01v8 L=0.6 W=1.4
+ AS=0.406 AD=0.406 PS=3.38 PD=3.38
M$430 \$10.x1_net6 cm VSS sky130_gnd sky130_fd_pr__nfet_01v8 L=0.6 W=1.4
+ AS=0.406 AD=0.406 PS=3.38 PD=3.38
M$431 \$10.x1_net3 cm VSS sky130_gnd sky130_fd_pr__nfet_01v8 L=0.6 W=1.4
+ AS=0.406 AD=0.406 PS=3.38 PD=3.38
M$432 \$10.x1_net15 cm VSS sky130_gnd sky130_fd_pr__nfet_01v8 L=0.6 W=1.4
+ AS=0.406 AD=0.406 PS=3.38 PD=3.38
M$433 \$10.x1_net1 cm \$10.x1_net2 sky130_gnd sky130_fd_pr__nfet_01v8 L=0.6
+ W=1.4 AS=0.406 AD=0.406 PS=3.38 PD=3.38
M$434 \$10.x1_net2 cm \$10.x1_net3 sky130_gnd sky130_fd_pr__nfet_01v8 L=0.6
+ W=1.4 AS=0.406 AD=0.406 PS=3.38 PD=3.38
M$435 \$10.x1_net13 cm \$10.x1_net14 sky130_gnd sky130_fd_pr__nfet_01v8 L=0.6
+ W=1.4 AS=0.406 AD=0.406 PS=3.38 PD=3.38
M$436 \$10.x1_net14 cm \$10.x1_net15 sky130_gnd sky130_fd_pr__nfet_01v8 L=0.6
+ W=1.4 AS=0.406 AD=0.406 PS=3.38 PD=3.38
M$437 \$10.x1_net4 cm \$10.x1_net5 sky130_gnd sky130_fd_pr__nfet_01v8 L=0.6
+ W=1.4 AS=0.406 AD=0.406 PS=3.38 PD=3.38
M$438 \$10.x1_net5 cm \$10.x1_net6 sky130_gnd sky130_fd_pr__nfet_01v8 L=0.6
+ W=1.4 AS=0.406 AD=0.406 PS=3.38 PD=3.38
M$439 \$10.x1_net7 cm \$10.x1_net8 sky130_gnd sky130_fd_pr__nfet_01v8 L=0.6
+ W=1.4 AS=0.406 AD=0.406 PS=3.38 PD=3.38
M$440 \$10.x1_net8 cm \$10.x1_net9 sky130_gnd sky130_fd_pr__nfet_01v8 L=0.6
+ W=1.4 AS=0.406 AD=0.406 PS=3.38 PD=3.38
M$441 \$10.x1_net10 cm \$10.x1_net11 sky130_gnd sky130_fd_pr__nfet_01v8 L=0.6
+ W=1.4 AS=0.406 AD=0.406 PS=3.38 PD=3.38
M$442 \$10.x1_net11 cm \$10.x1_net12 sky130_gnd sky130_fd_pr__nfet_01v8 L=0.6
+ W=1.4 AS=0.406 AD=0.406 PS=3.38 PD=3.38
M$443 cm cm \$10.x1_net1 sky130_gnd sky130_fd_pr__nfet_01v8 L=0.6 W=1.4
+ AS=0.406 AD=0.406 PS=3.38 PD=3.38
M$444 cm cm \$10.x1_net13 sky130_gnd sky130_fd_pr__nfet_01v8 L=0.6 W=1.4
+ AS=0.406 AD=0.406 PS=3.38 PD=3.38
M$445 cm cm \$10.x1_net4 sky130_gnd sky130_fd_pr__nfet_01v8 L=0.6 W=1.4
+ AS=0.406 AD=0.406 PS=3.38 PD=3.38
M$446 cm cm \$10.x1_net7 sky130_gnd sky130_fd_pr__nfet_01v8 L=0.6 W=1.4
+ AS=0.406 AD=0.406 PS=3.38 PD=3.38
M$447 cm cm \$10.x1_net10 sky130_gnd sky130_fd_pr__nfet_01v8 L=0.6 W=1.4
+ AS=0.406 AD=0.406 PS=3.38 PD=3.38
M$448 \$162 \$162 \$73 sky130_gnd sky130_fd_pr__nfet_01v8 L=0.6 W=1.4 AS=0.406
+ AD=0.406 PS=3.38 PD=3.38
M$449 \$162 \$162 \$73 sky130_gnd sky130_fd_pr__nfet_01v8 L=0.6 W=1.4 AS=0.406
+ AD=0.406 PS=3.38 PD=3.38
M$450 \$162 \$162 \$73 sky130_gnd sky130_fd_pr__nfet_01v8 L=0.6 W=1.4 AS=0.406
+ AD=0.406 PS=3.38 PD=3.38
M$451 \$162 \$162 \$73 sky130_gnd sky130_fd_pr__nfet_01v8 L=0.6 W=1.4 AS=0.406
+ AD=0.406 PS=3.38 PD=3.38
M$452 \$162 \$162 \$73 sky130_gnd sky130_fd_pr__nfet_01v8 L=0.6 W=1.4 AS=0.406
+ AD=0.406 PS=3.38 PD=3.38
M$453 \$162 \$162 \$73 sky130_gnd sky130_fd_pr__nfet_01v8 L=0.6 W=1.4 AS=0.406
+ AD=0.406 PS=3.38 PD=3.38
M$454 \$162 \$162 \$73 sky130_gnd sky130_fd_pr__nfet_01v8 L=0.6 W=1.4 AS=0.406
+ AD=0.406 PS=3.38 PD=3.38
M$455 \$162 \$162 \$73 sky130_gnd sky130_fd_pr__nfet_01v8 L=0.6 W=1.4 AS=0.406
+ AD=0.406 PS=3.38 PD=3.38
M$456 \$162 \$162 \$73 sky130_gnd sky130_fd_pr__nfet_01v8 L=0.6 W=1.4 AS=0.406
+ AD=0.406 PS=3.38 PD=3.38
M$457 \$162 \$162 \$73 sky130_gnd sky130_fd_pr__nfet_01v8 L=0.6 W=1.4 AS=0.406
+ AD=0.406 PS=3.38 PD=3.38
M$458 \$162 \$162 \$73 sky130_gnd sky130_fd_pr__nfet_01v8 L=0.6 W=1.4 AS=0.406
+ AD=0.406 PS=3.38 PD=3.38
M$459 \$162 \$162 \$73 sky130_gnd sky130_fd_pr__nfet_01v8 L=0.6 W=1.4 AS=0.406
+ AD=0.406 PS=3.38 PD=3.38
M$460 \$162 \$162 \$73 sky130_gnd sky130_fd_pr__nfet_01v8 L=0.6 W=1.4 AS=0.406
+ AD=0.406 PS=3.38 PD=3.38
M$461 \$162 \$162 \$73 sky130_gnd sky130_fd_pr__nfet_01v8 L=0.6 W=1.4 AS=0.406
+ AD=0.406 PS=3.38 PD=3.38
M$462 \$162 \$162 \$73 sky130_gnd sky130_fd_pr__nfet_01v8 L=0.6 W=1.4 AS=0.406
+ AD=0.406 PS=3.38 PD=3.38
M$463 \$162 \$162 \$73 sky130_gnd sky130_fd_pr__nfet_01v8 L=0.6 W=1.4 AS=0.406
+ AD=0.406 PS=3.38 PD=3.38
M$464 \$162 \$162 \$73 sky130_gnd sky130_fd_pr__nfet_01v8 L=0.6 W=1.4 AS=0.406
+ AD=0.406 PS=3.38 PD=3.38
M$465 \$162 \$162 \$73 sky130_gnd sky130_fd_pr__nfet_01v8 L=0.6 W=1.4 AS=0.406
+ AD=0.406 PS=3.38 PD=3.38
M$466 \$162 \$162 \$73 sky130_gnd sky130_fd_pr__nfet_01v8 L=0.6 W=1.4 AS=0.406
+ AD=0.406 PS=3.38 PD=3.38
M$467 \$162 \$162 \$73 sky130_gnd sky130_fd_pr__nfet_01v8 L=0.6 W=1.4 AS=0.406
+ AD=0.406 PS=3.38 PD=3.38
M$468 \$162 \$162 \$73 sky130_gnd sky130_fd_pr__nfet_01v8 L=0.6 W=1.4 AS=0.406
+ AD=0.406 PS=3.38 PD=3.38
M$469 \$162 \$162 \$73 sky130_gnd sky130_fd_pr__nfet_01v8 L=0.6 W=1.4 AS=0.406
+ AD=0.406 PS=3.38 PD=3.38
M$470 \$162 \$162 \$73 sky130_gnd sky130_fd_pr__nfet_01v8 L=0.6 W=1.4 AS=0.406
+ AD=0.406 PS=3.38 PD=3.38
M$471 \$162 \$162 \$73 sky130_gnd sky130_fd_pr__nfet_01v8 L=0.6 W=1.4 AS=0.406
+ AD=0.406 PS=3.38 PD=3.38
M$472 \$162 \$162 \$73 sky130_gnd sky130_fd_pr__nfet_01v8 L=0.6 W=1.4 AS=0.406
+ AD=0.406 PS=3.38 PD=3.38
M$473 \$162 \$162 \$73 sky130_gnd sky130_fd_pr__nfet_01v8 L=0.6 W=1.4 AS=0.406
+ AD=0.406 PS=3.38 PD=3.38
M$474 \$162 \$162 \$73 sky130_gnd sky130_fd_pr__nfet_01v8 L=0.6 W=1.4 AS=0.406
+ AD=0.406 PS=3.38 PD=3.38
M$475 \$162 \$162 \$73 sky130_gnd sky130_fd_pr__nfet_01v8 L=0.6 W=1.4 AS=0.406
+ AD=0.406 PS=3.38 PD=3.38
M$476 \$162 \$162 \$73 sky130_gnd sky130_fd_pr__nfet_01v8 L=0.6 W=1.4 AS=0.406
+ AD=0.406 PS=3.38 PD=3.38
M$477 \$162 \$162 \$73 sky130_gnd sky130_fd_pr__nfet_01v8 L=0.6 W=1.4 AS=0.406
+ AD=0.406 PS=3.38 PD=3.38
M$478 \$162 \$162 \$73 sky130_gnd sky130_fd_pr__nfet_01v8 L=0.6 W=1.4 AS=0.406
+ AD=0.406 PS=3.38 PD=3.38
M$479 \$162 \$162 \$73 sky130_gnd sky130_fd_pr__nfet_01v8 L=0.6 W=1.4 AS=0.406
+ AD=0.406 PS=3.38 PD=3.38
M$480 \$162 \$162 \$73 sky130_gnd sky130_fd_pr__nfet_01v8 L=0.6 W=1.4 AS=0.406
+ AD=0.406 PS=3.38 PD=3.38
M$481 \$162 \$162 \$73 sky130_gnd sky130_fd_pr__nfet_01v8 L=0.6 W=1.4 AS=0.406
+ AD=0.406 PS=3.38 PD=3.38
M$482 \$162 \$162 \$73 sky130_gnd sky130_fd_pr__nfet_01v8 L=0.6 W=1.4 AS=0.406
+ AD=0.406 PS=3.38 PD=3.38
M$483 \$162 \$162 \$73 sky130_gnd sky130_fd_pr__nfet_01v8 L=0.6 W=1.4 AS=0.406
+ AD=0.406 PS=3.38 PD=3.38
M$484 \$162 \$162 \$73 sky130_gnd sky130_fd_pr__nfet_01v8 L=0.6 W=1.4 AS=0.406
+ AD=0.406 PS=3.38 PD=3.38
M$485 \$162 \$162 \$73 sky130_gnd sky130_fd_pr__nfet_01v8 L=0.6 W=1.4 AS=0.406
+ AD=0.406 PS=3.38 PD=3.38
M$486 \$162 \$162 \$73 sky130_gnd sky130_fd_pr__nfet_01v8 L=0.6 W=1.4 AS=0.406
+ AD=0.406 PS=3.38 PD=3.38
M$487 \$162 \$162 \$73 sky130_gnd sky130_fd_pr__nfet_01v8 L=0.6 W=1.4 AS=0.406
+ AD=0.406 PS=3.38 PD=3.38
M$488 \$162 \$162 \$73 sky130_gnd sky130_fd_pr__nfet_01v8 L=0.6 W=1.4 AS=0.406
+ AD=0.406 PS=3.38 PD=3.38
M$489 \$162 \$162 \$73 sky130_gnd sky130_fd_pr__nfet_01v8 L=0.6 W=1.4 AS=0.406
+ AD=0.406 PS=3.38 PD=3.38
M$490 \$162 \$162 \$73 sky130_gnd sky130_fd_pr__nfet_01v8 L=0.6 W=1.4 AS=0.406
+ AD=0.406 PS=3.38 PD=3.38
M$491 \$162 \$162 \$73 sky130_gnd sky130_fd_pr__nfet_01v8 L=0.6 W=1.4 AS=0.406
+ AD=0.406 PS=3.38 PD=3.38
M$492 \$162 \$162 \$73 sky130_gnd sky130_fd_pr__nfet_01v8 L=0.6 W=1.4 AS=0.406
+ AD=0.406 PS=3.38 PD=3.38
M$493 \$162 \$162 \$73 sky130_gnd sky130_fd_pr__nfet_01v8 L=0.6 W=1.4 AS=0.406
+ AD=0.406 PS=3.38 PD=3.38
M$494 \$162 \$162 \$73 sky130_gnd sky130_fd_pr__nfet_01v8 L=0.6 W=1.4 AS=0.406
+ AD=0.406 PS=3.38 PD=3.38
M$495 \$162 \$162 \$73 sky130_gnd sky130_fd_pr__nfet_01v8 L=0.6 W=1.4 AS=0.406
+ AD=0.406 PS=3.38 PD=3.38
M$496 \$162 \$162 \$73 sky130_gnd sky130_fd_pr__nfet_01v8 L=0.6 W=1.4 AS=0.406
+ AD=0.406 PS=3.38 PD=3.38
M$497 \$162 \$162 \$73 sky130_gnd sky130_fd_pr__nfet_01v8 L=0.6 W=1.4 AS=0.406
+ AD=0.406 PS=3.38 PD=3.38
M$498 \$16 cmc VSS sky130_gnd sky130_fd_pr__nfet_01v8 L=0.6 W=1.4 AS=0.406
+ AD=0.406 PS=3.38 PD=3.38
M$499 \$16 bias_a VSS sky130_gnd sky130_fd_pr__nfet_01v8 L=0.6 W=1.4 AS=0.406
+ AD=0.406 PS=3.38 PD=3.38
M$500 \$16 cmc VSS sky130_gnd sky130_fd_pr__nfet_01v8 L=0.6 W=1.4 AS=0.406
+ AD=0.406 PS=3.38 PD=3.38
M$501 \$16 bias_a VSS sky130_gnd sky130_fd_pr__nfet_01v8 L=0.6 W=1.4 AS=0.406
+ AD=0.406 PS=3.38 PD=3.38
M$502 \$16 cmc VSS sky130_gnd sky130_fd_pr__nfet_01v8 L=0.6 W=1.4 AS=0.406
+ AD=0.406 PS=3.38 PD=3.38
M$503 \$16 bias_a VSS sky130_gnd sky130_fd_pr__nfet_01v8 L=0.6 W=1.4 AS=0.406
+ AD=0.406 PS=3.38 PD=3.38
M$504 \$16 cmc VSS sky130_gnd sky130_fd_pr__nfet_01v8 L=0.6 W=1.4 AS=0.406
+ AD=0.406 PS=3.38 PD=3.38
M$505 \$16 bias_a VSS sky130_gnd sky130_fd_pr__nfet_01v8 L=0.6 W=1.4 AS=0.406
+ AD=0.406 PS=3.38 PD=3.38
M$506 \$16 cmc VSS sky130_gnd sky130_fd_pr__nfet_01v8 L=0.6 W=1.4 AS=0.406
+ AD=0.406 PS=3.38 PD=3.38
M$507 \$16 bias_a VSS sky130_gnd sky130_fd_pr__nfet_01v8 L=0.6 W=1.4 AS=0.406
+ AD=0.406 PS=3.38 PD=3.38
M$508 \$16 bias_a VSS sky130_gnd sky130_fd_pr__nfet_01v8 L=0.6 W=1.4 AS=0.406
+ AD=0.406 PS=3.38 PD=3.38
M$509 \$16 bias_a VSS sky130_gnd sky130_fd_pr__nfet_01v8 L=0.6 W=1.4 AS=0.406
+ AD=0.406 PS=3.38 PD=3.38
M$510 \$16 cmc VSS sky130_gnd sky130_fd_pr__nfet_01v8 L=0.6 W=1.4 AS=0.406
+ AD=0.406 PS=3.38 PD=3.38
M$511 \$16 bias_a VSS sky130_gnd sky130_fd_pr__nfet_01v8 L=0.6 W=1.4 AS=0.406
+ AD=0.406 PS=3.38 PD=3.38
M$512 \$16 cmc VSS sky130_gnd sky130_fd_pr__nfet_01v8 L=0.6 W=1.4 AS=0.406
+ AD=0.406 PS=3.38 PD=3.38
M$513 \$16 bias_a VSS sky130_gnd sky130_fd_pr__nfet_01v8 L=0.6 W=1.4 AS=0.406
+ AD=0.406 PS=3.38 PD=3.38
M$514 \$16 cmc VSS sky130_gnd sky130_fd_pr__nfet_01v8 L=0.6 W=1.4 AS=0.406
+ AD=0.406 PS=3.38 PD=3.38
M$515 \$16 bias_a VSS sky130_gnd sky130_fd_pr__nfet_01v8 L=0.6 W=1.4 AS=0.406
+ AD=0.406 PS=3.38 PD=3.38
M$516 \$16 cmc VSS sky130_gnd sky130_fd_pr__nfet_01v8 L=0.6 W=1.4 AS=0.406
+ AD=0.406 PS=3.38 PD=3.38
M$517 \$16 cmc VSS sky130_gnd sky130_fd_pr__nfet_01v8 L=0.6 W=1.4 AS=0.406
+ AD=0.406 PS=3.38 PD=3.38
M$518 \$16 bias_a VSS sky130_gnd sky130_fd_pr__nfet_01v8 L=0.6 W=1.4 AS=0.406
+ AD=0.406 PS=3.38 PD=3.38
M$519 \$16 cmc VSS sky130_gnd sky130_fd_pr__nfet_01v8 L=0.6 W=1.4 AS=0.406
+ AD=0.406 PS=3.38 PD=3.38
M$520 \$16 bias_a VSS sky130_gnd sky130_fd_pr__nfet_01v8 L=0.6 W=1.4 AS=0.406
+ AD=0.406 PS=3.38 PD=3.38
M$521 \$16 cmc VSS sky130_gnd sky130_fd_pr__nfet_01v8 L=0.6 W=1.4 AS=0.406
+ AD=0.406 PS=3.38 PD=3.38
M$522 \$16 bias_a VSS sky130_gnd sky130_fd_pr__nfet_01v8 L=0.6 W=1.4 AS=0.406
+ AD=0.406 PS=3.38 PD=3.38
M$523 \$16 cmc VSS sky130_gnd sky130_fd_pr__nfet_01v8 L=0.6 W=1.4 AS=0.406
+ AD=0.406 PS=3.38 PD=3.38
M$524 \$16 bias_a VSS sky130_gnd sky130_fd_pr__nfet_01v8 L=0.6 W=1.4 AS=0.406
+ AD=0.406 PS=3.38 PD=3.38
M$525 \$16 cmc VSS sky130_gnd sky130_fd_pr__nfet_01v8 L=0.6 W=1.4 AS=0.406
+ AD=0.406 PS=3.38 PD=3.38
M$526 \$16 bias_a VSS sky130_gnd sky130_fd_pr__nfet_01v8 L=0.6 W=1.4 AS=0.406
+ AD=0.406 PS=3.38 PD=3.38
M$527 \$16 cmc VSS sky130_gnd sky130_fd_pr__nfet_01v8 L=0.6 W=1.4 AS=0.406
+ AD=0.406 PS=3.38 PD=3.38
M$528 \$16 cmc VSS sky130_gnd sky130_fd_pr__nfet_01v8 L=0.6 W=1.4 AS=0.406
+ AD=0.406 PS=3.38 PD=3.38
M$529 \$16 bias_a VSS sky130_gnd sky130_fd_pr__nfet_01v8 L=0.6 W=1.4 AS=0.406
+ AD=0.406 PS=3.38 PD=3.38
M$530 \$16 cmc VSS sky130_gnd sky130_fd_pr__nfet_01v8 L=0.6 W=1.4 AS=0.406
+ AD=0.406 PS=3.38 PD=3.38
M$531 \$16 bias_a VSS sky130_gnd sky130_fd_pr__nfet_01v8 L=0.6 W=1.4 AS=0.406
+ AD=0.406 PS=3.38 PD=3.38
M$532 \$16 bias_a VSS sky130_gnd sky130_fd_pr__nfet_01v8 L=0.6 W=1.4 AS=0.406
+ AD=0.406 PS=3.38 PD=3.38
M$533 \$16 cmc VSS sky130_gnd sky130_fd_pr__nfet_01v8 L=0.6 W=1.4 AS=0.406
+ AD=0.406 PS=3.38 PD=3.38
M$534 \$16 cmc VSS sky130_gnd sky130_fd_pr__nfet_01v8 L=0.6 W=1.4 AS=0.406
+ AD=0.406 PS=3.38 PD=3.38
M$535 \$16 bias_a VSS sky130_gnd sky130_fd_pr__nfet_01v8 L=0.6 W=1.4 AS=0.406
+ AD=0.406 PS=3.38 PD=3.38
M$536 \$16 cmc VSS sky130_gnd sky130_fd_pr__nfet_01v8 L=0.6 W=1.4 AS=0.406
+ AD=0.406 PS=3.38 PD=3.38
M$537 \$16 bias_a VSS sky130_gnd sky130_fd_pr__nfet_01v8 L=0.6 W=1.4 AS=0.406
+ AD=0.406 PS=3.38 PD=3.38
M$538 \$16 cmc VSS sky130_gnd sky130_fd_pr__nfet_01v8 L=0.6 W=1.4 AS=0.406
+ AD=0.406 PS=3.38 PD=3.38
M$539 \$16 bias_a VSS sky130_gnd sky130_fd_pr__nfet_01v8 L=0.6 W=1.4 AS=0.406
+ AD=0.406 PS=3.38 PD=3.38
M$540 \$16 cmc VSS sky130_gnd sky130_fd_pr__nfet_01v8 L=0.6 W=1.4 AS=0.406
+ AD=0.406 PS=3.38 PD=3.38
M$541 \$16 bias_a VSS sky130_gnd sky130_fd_pr__nfet_01v8 L=0.6 W=1.4 AS=0.406
+ AD=0.406 PS=3.38 PD=3.38
M$542 \$16 cmc VSS sky130_gnd sky130_fd_pr__nfet_01v8 L=0.6 W=1.4 AS=0.406
+ AD=0.406 PS=3.38 PD=3.38
M$543 \$16 bias_a VSS sky130_gnd sky130_fd_pr__nfet_01v8 L=0.6 W=1.4 AS=0.406
+ AD=0.406 PS=3.38 PD=3.38
M$544 \$16 cmc VSS sky130_gnd sky130_fd_pr__nfet_01v8 L=0.6 W=1.4 AS=0.406
+ AD=0.406 PS=3.38 PD=3.38
M$545 \$16 bias_a VSS sky130_gnd sky130_fd_pr__nfet_01v8 L=0.6 W=1.4 AS=0.406
+ AD=0.406 PS=3.38 PD=3.38
M$546 \$16 cmc VSS sky130_gnd sky130_fd_pr__nfet_01v8 L=0.6 W=1.4 AS=0.406
+ AD=0.406 PS=3.38 PD=3.38
M$547 \$16 bias_a VSS sky130_gnd sky130_fd_pr__nfet_01v8 L=0.6 W=1.4 AS=0.406
+ AD=0.406 PS=3.38 PD=3.38
M$548 \$16 cmc VSS sky130_gnd sky130_fd_pr__nfet_01v8 L=0.6 W=1.4 AS=0.406
+ AD=0.406 PS=3.38 PD=3.38
M$549 \$16 bias_a VSS sky130_gnd sky130_fd_pr__nfet_01v8 L=0.6 W=1.4 AS=0.406
+ AD=0.406 PS=3.38 PD=3.38
M$550 \$16 bias_a VSS sky130_gnd sky130_fd_pr__nfet_01v8 L=0.6 W=1.4 AS=0.406
+ AD=0.406 PS=3.38 PD=3.38
M$551 \$16 cmc VSS sky130_gnd sky130_fd_pr__nfet_01v8 L=0.6 W=1.4 AS=0.406
+ AD=0.406 PS=3.38 PD=3.38
M$552 \$16 cmc VSS sky130_gnd sky130_fd_pr__nfet_01v8 L=0.6 W=1.4 AS=0.406
+ AD=0.406 PS=3.38 PD=3.38
M$553 \$16 cmc VSS sky130_gnd sky130_fd_pr__nfet_01v8 L=0.6 W=1.4 AS=0.406
+ AD=0.406 PS=3.38 PD=3.38
M$554 \$16 bias_a VSS sky130_gnd sky130_fd_pr__nfet_01v8 L=0.6 W=1.4 AS=0.406
+ AD=0.406 PS=3.38 PD=3.38
M$555 \$16 cmc VSS sky130_gnd sky130_fd_pr__nfet_01v8 L=0.6 W=1.4 AS=0.406
+ AD=0.406 PS=3.38 PD=3.38
M$556 \$16 bias_a VSS sky130_gnd sky130_fd_pr__nfet_01v8 L=0.6 W=1.4 AS=0.406
+ AD=0.406 PS=3.38 PD=3.38
M$557 \$16 cmc VSS sky130_gnd sky130_fd_pr__nfet_01v8 L=0.6 W=1.4 AS=0.406
+ AD=0.406 PS=3.38 PD=3.38
M$558 \$16 bias_a VSS sky130_gnd sky130_fd_pr__nfet_01v8 L=0.6 W=1.4 AS=0.406
+ AD=0.406 PS=3.38 PD=3.38
M$559 \$16 cmc VSS sky130_gnd sky130_fd_pr__nfet_01v8 L=0.6 W=1.4 AS=0.406
+ AD=0.406 PS=3.38 PD=3.38
M$560 \$16 cmc VSS sky130_gnd sky130_fd_pr__nfet_01v8 L=0.6 W=1.4 AS=0.406
+ AD=0.406 PS=3.38 PD=3.38
M$561 \$16 bias_a VSS sky130_gnd sky130_fd_pr__nfet_01v8 L=0.6 W=1.4 AS=0.406
+ AD=0.406 PS=3.38 PD=3.38
M$562 \$16 bias_a VSS sky130_gnd sky130_fd_pr__nfet_01v8 L=0.6 W=1.4 AS=0.406
+ AD=0.406 PS=3.38 PD=3.38
M$563 \$16 cmc VSS sky130_gnd sky130_fd_pr__nfet_01v8 L=0.6 W=1.4 AS=0.406
+ AD=0.406 PS=3.38 PD=3.38
M$564 \$16 cmc VSS sky130_gnd sky130_fd_pr__nfet_01v8 L=0.6 W=1.4 AS=0.406
+ AD=0.406 PS=3.38 PD=3.38
M$565 \$16 bias_a VSS sky130_gnd sky130_fd_pr__nfet_01v8 L=0.6 W=1.4 AS=0.406
+ AD=0.406 PS=3.38 PD=3.38
M$566 \$16 bias_a VSS sky130_gnd sky130_fd_pr__nfet_01v8 L=0.6 W=1.4 AS=0.406
+ AD=0.406 PS=3.38 PD=3.38
M$567 \$16 cmc VSS sky130_gnd sky130_fd_pr__nfet_01v8 L=0.6 W=1.4 AS=0.406
+ AD=0.406 PS=3.38 PD=3.38
M$568 \$16 bias_a VSS sky130_gnd sky130_fd_pr__nfet_01v8 L=0.6 W=1.4 AS=0.406
+ AD=0.406 PS=3.38 PD=3.38
M$569 \$16 bias_a VSS sky130_gnd sky130_fd_pr__nfet_01v8 L=0.6 W=1.4 AS=0.406
+ AD=0.406 PS=3.38 PD=3.38
M$570 \$16 cmc VSS sky130_gnd sky130_fd_pr__nfet_01v8 L=0.6 W=1.4 AS=0.406
+ AD=0.406 PS=3.38 PD=3.38
M$571 \$16 bias_a VSS sky130_gnd sky130_fd_pr__nfet_01v8 L=0.6 W=1.4 AS=0.406
+ AD=0.406 PS=3.38 PD=3.38
M$572 \$16 cmc VSS sky130_gnd sky130_fd_pr__nfet_01v8 L=0.6 W=1.4 AS=0.406
+ AD=0.406 PS=3.38 PD=3.38
M$573 \$16 cmc VSS sky130_gnd sky130_fd_pr__nfet_01v8 L=0.6 W=1.4 AS=0.406
+ AD=0.406 PS=3.38 PD=3.38
M$574 \$16 bias_a VSS sky130_gnd sky130_fd_pr__nfet_01v8 L=0.6 W=1.4 AS=0.406
+ AD=0.406 PS=3.38 PD=3.38
M$575 \$16 cmc VSS sky130_gnd sky130_fd_pr__nfet_01v8 L=0.6 W=1.4 AS=0.406
+ AD=0.406 PS=3.38 PD=3.38
M$576 \$16 bias_a VSS sky130_gnd sky130_fd_pr__nfet_01v8 L=0.6 W=1.4 AS=0.406
+ AD=0.406 PS=3.38 PD=3.38
M$577 \$16 cmc VSS sky130_gnd sky130_fd_pr__nfet_01v8 L=0.6 W=1.4 AS=0.406
+ AD=0.406 PS=3.38 PD=3.38
M$578 \$16 bias_a VSS sky130_gnd sky130_fd_pr__nfet_01v8 L=0.6 W=1.4 AS=0.406
+ AD=0.406 PS=3.38 PD=3.38
M$579 \$16 cmc VSS sky130_gnd sky130_fd_pr__nfet_01v8 L=0.6 W=1.4 AS=0.406
+ AD=0.406 PS=3.38 PD=3.38
M$580 \$16 bias_a VSS sky130_gnd sky130_fd_pr__nfet_01v8 L=0.6 W=1.4 AS=0.406
+ AD=0.406 PS=3.38 PD=3.38
M$581 \$16 cmc VSS sky130_gnd sky130_fd_pr__nfet_01v8 L=0.6 W=1.4 AS=0.406
+ AD=0.406 PS=3.38 PD=3.38
M$582 \$16 bias_a VSS sky130_gnd sky130_fd_pr__nfet_01v8 L=0.6 W=1.4 AS=0.406
+ AD=0.406 PS=3.38 PD=3.38
M$583 \$16 cmc VSS sky130_gnd sky130_fd_pr__nfet_01v8 L=0.6 W=1.4 AS=0.406
+ AD=0.406 PS=3.38 PD=3.38
M$584 \$16 bias_a VSS sky130_gnd sky130_fd_pr__nfet_01v8 L=0.6 W=1.4 AS=0.406
+ AD=0.406 PS=3.38 PD=3.38
M$585 \$16 cmc VSS sky130_gnd sky130_fd_pr__nfet_01v8 L=0.6 W=1.4 AS=0.406
+ AD=0.406 PS=3.38 PD=3.38
M$586 \$16 bias_a VSS sky130_gnd sky130_fd_pr__nfet_01v8 L=0.6 W=1.4 AS=0.406
+ AD=0.406 PS=3.38 PD=3.38
M$587 \$16 cmc VSS sky130_gnd sky130_fd_pr__nfet_01v8 L=0.6 W=1.4 AS=0.406
+ AD=0.406 PS=3.38 PD=3.38
M$588 \$16 bias_a VSS sky130_gnd sky130_fd_pr__nfet_01v8 L=0.6 W=1.4 AS=0.406
+ AD=0.406 PS=3.38 PD=3.38
M$589 \$16 cmc VSS sky130_gnd sky130_fd_pr__nfet_01v8 L=0.6 W=1.4 AS=0.406
+ AD=0.406 PS=3.38 PD=3.38
M$590 \$16 bias_a VSS sky130_gnd sky130_fd_pr__nfet_01v8 L=0.6 W=1.4 AS=0.406
+ AD=0.406 PS=3.38 PD=3.38
M$591 \$16 cmc VSS sky130_gnd sky130_fd_pr__nfet_01v8 L=0.6 W=1.4 AS=0.406
+ AD=0.406 PS=3.38 PD=3.38
M$592 \$16 bias_a VSS sky130_gnd sky130_fd_pr__nfet_01v8 L=0.6 W=1.4 AS=0.406
+ AD=0.406 PS=3.38 PD=3.38
M$593 \$16 bias_a VSS sky130_gnd sky130_fd_pr__nfet_01v8 L=0.6 W=1.4 AS=0.406
+ AD=0.406 PS=3.38 PD=3.38
M$594 \$16 cmc VSS sky130_gnd sky130_fd_pr__nfet_01v8 L=0.6 W=1.4 AS=0.406
+ AD=0.406 PS=3.38 PD=3.38
M$595 \$16 cmc VSS sky130_gnd sky130_fd_pr__nfet_01v8 L=0.6 W=1.4 AS=0.406
+ AD=0.406 PS=3.38 PD=3.38
M$596 \$16 cmc VSS sky130_gnd sky130_fd_pr__nfet_01v8 L=0.6 W=1.4 AS=0.406
+ AD=0.406 PS=3.38 PD=3.38
M$597 \$16 bias_a VSS sky130_gnd sky130_fd_pr__nfet_01v8 L=0.6 W=1.4 AS=0.406
+ AD=0.406 PS=3.38 PD=3.38
M$598 \$16 cmc VSS sky130_gnd sky130_fd_pr__nfet_01v8 L=0.6 W=1.4 AS=0.406
+ AD=0.406 PS=3.38 PD=3.38
M$599 \$16 bias_a VSS sky130_gnd sky130_fd_pr__nfet_01v8 L=0.6 W=1.4 AS=0.406
+ AD=0.406 PS=3.38 PD=3.38
M$600 \$16 cmc VSS sky130_gnd sky130_fd_pr__nfet_01v8 L=0.6 W=1.4 AS=0.406
+ AD=0.406 PS=3.38 PD=3.38
M$601 \$16 cmc VSS sky130_gnd sky130_fd_pr__nfet_01v8 L=0.6 W=1.4 AS=0.406
+ AD=0.406 PS=3.38 PD=3.38
M$602 \$16 cmc VSS sky130_gnd sky130_fd_pr__nfet_01v8 L=0.6 W=1.4 AS=0.406
+ AD=0.406 PS=3.38 PD=3.38
M$603 \$16 bias_a VSS sky130_gnd sky130_fd_pr__nfet_01v8 L=0.6 W=1.4 AS=0.406
+ AD=0.406 PS=3.38 PD=3.38
M$604 \$16 cmc VSS sky130_gnd sky130_fd_pr__nfet_01v8 L=0.6 W=1.4 AS=0.406
+ AD=0.406 PS=3.38 PD=3.38
M$605 \$16 bias_a VSS sky130_gnd sky130_fd_pr__nfet_01v8 L=0.6 W=1.4 AS=0.406
+ AD=0.406 PS=3.38 PD=3.38
M$606 \$16 cmc VSS sky130_gnd sky130_fd_pr__nfet_01v8 L=0.6 W=1.4 AS=0.406
+ AD=0.406 PS=3.38 PD=3.38
M$607 \$16 bias_a VSS sky130_gnd sky130_fd_pr__nfet_01v8 L=0.6 W=1.4 AS=0.406
+ AD=0.406 PS=3.38 PD=3.38
M$608 \$16 cmc VSS sky130_gnd sky130_fd_pr__nfet_01v8 L=0.6 W=1.4 AS=0.406
+ AD=0.406 PS=3.38 PD=3.38
M$609 \$16 bias_a VSS sky130_gnd sky130_fd_pr__nfet_01v8 L=0.6 W=1.4 AS=0.406
+ AD=0.406 PS=3.38 PD=3.38
M$610 \$16 cmc VSS sky130_gnd sky130_fd_pr__nfet_01v8 L=0.6 W=1.4 AS=0.406
+ AD=0.406 PS=3.38 PD=3.38
M$611 \$16 bias_a VSS sky130_gnd sky130_fd_pr__nfet_01v8 L=0.6 W=1.4 AS=0.406
+ AD=0.406 PS=3.38 PD=3.38
M$612 \$16 cmc VSS sky130_gnd sky130_fd_pr__nfet_01v8 L=0.6 W=1.4 AS=0.406
+ AD=0.406 PS=3.38 PD=3.38
M$613 \$16 bias_a VSS sky130_gnd sky130_fd_pr__nfet_01v8 L=0.6 W=1.4 AS=0.406
+ AD=0.406 PS=3.38 PD=3.38
M$614 \$16 cmc VSS sky130_gnd sky130_fd_pr__nfet_01v8 L=0.6 W=1.4 AS=0.406
+ AD=0.406 PS=3.38 PD=3.38
M$615 \$16 bias_a VSS sky130_gnd sky130_fd_pr__nfet_01v8 L=0.6 W=1.4 AS=0.406
+ AD=0.406 PS=3.38 PD=3.38
M$616 \$16 cmc VSS sky130_gnd sky130_fd_pr__nfet_01v8 L=0.6 W=1.4 AS=0.406
+ AD=0.406 PS=3.38 PD=3.38
M$617 \$16 bias_a VSS sky130_gnd sky130_fd_pr__nfet_01v8 L=0.6 W=1.4 AS=0.406
+ AD=0.406 PS=3.38 PD=3.38
M$618 \$16 cmc VSS sky130_gnd sky130_fd_pr__nfet_01v8 L=0.6 W=1.4 AS=0.406
+ AD=0.406 PS=3.38 PD=3.38
M$619 \$16 bias_a VSS sky130_gnd sky130_fd_pr__nfet_01v8 L=0.6 W=1.4 AS=0.406
+ AD=0.406 PS=3.38 PD=3.38
M$620 \$16 cmc VSS sky130_gnd sky130_fd_pr__nfet_01v8 L=0.6 W=1.4 AS=0.406
+ AD=0.406 PS=3.38 PD=3.38
M$621 \$16 bias_a VSS sky130_gnd sky130_fd_pr__nfet_01v8 L=0.6 W=1.4 AS=0.406
+ AD=0.406 PS=3.38 PD=3.38
M$622 \$16 cmc VSS sky130_gnd sky130_fd_pr__nfet_01v8 L=0.6 W=1.4 AS=0.406
+ AD=0.406 PS=3.38 PD=3.38
M$623 \$16 bias_a VSS sky130_gnd sky130_fd_pr__nfet_01v8 L=0.6 W=1.4 AS=0.406
+ AD=0.406 PS=3.38 PD=3.38
M$624 \$16 cmc VSS sky130_gnd sky130_fd_pr__nfet_01v8 L=0.6 W=1.4 AS=0.406
+ AD=0.406 PS=3.38 PD=3.38
M$625 \$16 bias_a VSS sky130_gnd sky130_fd_pr__nfet_01v8 L=0.6 W=1.4 AS=0.406
+ AD=0.406 PS=3.38 PD=3.38
M$626 \$16 cmc VSS sky130_gnd sky130_fd_pr__nfet_01v8 L=0.6 W=1.4 AS=0.406
+ AD=0.406 PS=3.38 PD=3.38
M$627 \$16 bias_a VSS sky130_gnd sky130_fd_pr__nfet_01v8 L=0.6 W=1.4 AS=0.406
+ AD=0.406 PS=3.38 PD=3.38
M$628 \$16 cmc VSS sky130_gnd sky130_fd_pr__nfet_01v8 L=0.6 W=1.4 AS=0.406
+ AD=0.406 PS=3.38 PD=3.38
M$629 \$16 bias_a VSS sky130_gnd sky130_fd_pr__nfet_01v8 L=0.6 W=1.4 AS=0.406
+ AD=0.406 PS=3.38 PD=3.38
M$630 \$16 cmc VSS sky130_gnd sky130_fd_pr__nfet_01v8 L=0.6 W=1.4 AS=0.406
+ AD=0.406 PS=3.38 PD=3.38
M$631 \$16 bias_a VSS sky130_gnd sky130_fd_pr__nfet_01v8 L=0.6 W=1.4 AS=0.406
+ AD=0.406 PS=3.38 PD=3.38
M$632 \$16 cmc VSS sky130_gnd sky130_fd_pr__nfet_01v8 L=0.6 W=1.4 AS=0.406
+ AD=0.406 PS=3.38 PD=3.38
M$633 \$16 bias_a VSS sky130_gnd sky130_fd_pr__nfet_01v8 L=0.6 W=1.4 AS=0.406
+ AD=0.406 PS=3.38 PD=3.38
M$634 \$16 cmc VSS sky130_gnd sky130_fd_pr__nfet_01v8 L=0.6 W=1.4 AS=0.406
+ AD=0.406 PS=3.38 PD=3.38
M$635 \$16 bias_a VSS sky130_gnd sky130_fd_pr__nfet_01v8 L=0.6 W=1.4 AS=0.406
+ AD=0.406 PS=3.38 PD=3.38
M$636 \$16 cmc VSS sky130_gnd sky130_fd_pr__nfet_01v8 L=0.6 W=1.4 AS=0.406
+ AD=0.406 PS=3.38 PD=3.38
M$637 \$16 bias_a VSS sky130_gnd sky130_fd_pr__nfet_01v8 L=0.6 W=1.4 AS=0.406
+ AD=0.406 PS=3.38 PD=3.38
M$638 \$16 cmc VSS sky130_gnd sky130_fd_pr__nfet_01v8 L=0.6 W=1.4 AS=0.406
+ AD=0.406 PS=3.38 PD=3.38
M$639 \$16 bias_a VSS sky130_gnd sky130_fd_pr__nfet_01v8 L=0.6 W=1.4 AS=0.406
+ AD=0.406 PS=3.38 PD=3.38
M$640 \$16 bias_a VSS sky130_gnd sky130_fd_pr__nfet_01v8 L=0.6 W=1.4 AS=0.406
+ AD=0.406 PS=3.38 PD=3.38
M$641 \$16 bias_a VSS sky130_gnd sky130_fd_pr__nfet_01v8 L=0.6 W=1.4 AS=0.406
+ AD=0.406 PS=3.38 PD=3.38
M$642 \$16 cmc VSS sky130_gnd sky130_fd_pr__nfet_01v8 L=0.6 W=1.4 AS=0.406
+ AD=0.406 PS=3.38 PD=3.38
M$643 \$16 bias_a VSS sky130_gnd sky130_fd_pr__nfet_01v8 L=0.6 W=1.4 AS=0.406
+ AD=0.406 PS=3.38 PD=3.38
M$644 \$16 cmc VSS sky130_gnd sky130_fd_pr__nfet_01v8 L=0.6 W=1.4 AS=0.406
+ AD=0.406 PS=3.38 PD=3.38
M$645 \$16 bias_a VSS sky130_gnd sky130_fd_pr__nfet_01v8 L=0.6 W=1.4 AS=0.406
+ AD=0.406 PS=3.38 PD=3.38
M$646 \$16 cmc VSS sky130_gnd sky130_fd_pr__nfet_01v8 L=0.6 W=1.4 AS=0.406
+ AD=0.406 PS=3.38 PD=3.38
M$647 \$16 bias_a VSS sky130_gnd sky130_fd_pr__nfet_01v8 L=0.6 W=1.4 AS=0.406
+ AD=0.406 PS=3.38 PD=3.38
M$648 \$16 bias_a VSS sky130_gnd sky130_fd_pr__nfet_01v8 L=0.6 W=1.4 AS=0.406
+ AD=0.406 PS=3.38 PD=3.38
M$649 \$16 bias_a VSS sky130_gnd sky130_fd_pr__nfet_01v8 L=0.6 W=1.4 AS=0.406
+ AD=0.406 PS=3.38 PD=3.38
M$650 \$16 cmc VSS sky130_gnd sky130_fd_pr__nfet_01v8 L=0.6 W=1.4 AS=0.406
+ AD=0.406 PS=3.38 PD=3.38
M$651 \$16 bias_a VSS sky130_gnd sky130_fd_pr__nfet_01v8 L=0.6 W=1.4 AS=0.406
+ AD=0.406 PS=3.38 PD=3.38
M$652 \$16 cmc VSS sky130_gnd sky130_fd_pr__nfet_01v8 L=0.6 W=1.4 AS=0.406
+ AD=0.406 PS=3.38 PD=3.38
M$653 \$16 bias_a VSS sky130_gnd sky130_fd_pr__nfet_01v8 L=0.6 W=1.4 AS=0.406
+ AD=0.406 PS=3.38 PD=3.38
M$654 \$16 cmc VSS sky130_gnd sky130_fd_pr__nfet_01v8 L=0.6 W=1.4 AS=0.406
+ AD=0.406 PS=3.38 PD=3.38
M$655 \$16 bias_a VSS sky130_gnd sky130_fd_pr__nfet_01v8 L=0.6 W=1.4 AS=0.406
+ AD=0.406 PS=3.38 PD=3.38
M$656 \$16 cmc VSS sky130_gnd sky130_fd_pr__nfet_01v8 L=0.6 W=1.4 AS=0.406
+ AD=0.406 PS=3.38 PD=3.38
M$657 \$16 cmc VSS sky130_gnd sky130_fd_pr__nfet_01v8 L=0.6 W=1.4 AS=0.406
+ AD=0.406 PS=3.38 PD=3.38
M$658 \$16 cmc VSS sky130_gnd sky130_fd_pr__nfet_01v8 L=0.6 W=1.4 AS=0.406
+ AD=0.406 PS=3.38 PD=3.38
M$659 \$16 bias_a VSS sky130_gnd sky130_fd_pr__nfet_01v8 L=0.6 W=1.4 AS=0.406
+ AD=0.406 PS=3.38 PD=3.38
M$660 \$16 cmc VSS sky130_gnd sky130_fd_pr__nfet_01v8 L=0.6 W=1.4 AS=0.406
+ AD=0.406 PS=3.38 PD=3.38
M$661 \$16 bias_a VSS sky130_gnd sky130_fd_pr__nfet_01v8 L=0.6 W=1.4 AS=0.406
+ AD=0.406 PS=3.38 PD=3.38
M$662 \$16 cmc VSS sky130_gnd sky130_fd_pr__nfet_01v8 L=0.6 W=1.4 AS=0.406
+ AD=0.406 PS=3.38 PD=3.38
M$663 \$16 bias_a VSS sky130_gnd sky130_fd_pr__nfet_01v8 L=0.6 W=1.4 AS=0.406
+ AD=0.406 PS=3.38 PD=3.38
M$664 \$16 cmc VSS sky130_gnd sky130_fd_pr__nfet_01v8 L=0.6 W=1.4 AS=0.406
+ AD=0.406 PS=3.38 PD=3.38
M$665 \$16 cmc VSS sky130_gnd sky130_fd_pr__nfet_01v8 L=0.6 W=1.4 AS=0.406
+ AD=0.406 PS=3.38 PD=3.38
M$666 \$16 cmc VSS sky130_gnd sky130_fd_pr__nfet_01v8 L=0.6 W=1.4 AS=0.406
+ AD=0.406 PS=3.38 PD=3.38
M$667 \$16 bias_a VSS sky130_gnd sky130_fd_pr__nfet_01v8 L=0.6 W=1.4 AS=0.406
+ AD=0.406 PS=3.38 PD=3.38
M$668 \$16 cmc VSS sky130_gnd sky130_fd_pr__nfet_01v8 L=0.6 W=1.4 AS=0.406
+ AD=0.406 PS=3.38 PD=3.38
M$669 \$16 bias_a VSS sky130_gnd sky130_fd_pr__nfet_01v8 L=0.6 W=1.4 AS=0.406
+ AD=0.406 PS=3.38 PD=3.38
M$670 \$16 bias_a VSS sky130_gnd sky130_fd_pr__nfet_01v8 L=0.6 W=1.4 AS=0.406
+ AD=0.406 PS=3.38 PD=3.38
M$671 \$16 cmc VSS sky130_gnd sky130_fd_pr__nfet_01v8 L=0.6 W=1.4 AS=0.406
+ AD=0.406 PS=3.38 PD=3.38
M$672 \$16 bias_a VSS sky130_gnd sky130_fd_pr__nfet_01v8 L=0.6 W=1.4 AS=0.406
+ AD=0.406 PS=3.38 PD=3.38
M$673 \$16 bias_a VSS sky130_gnd sky130_fd_pr__nfet_01v8 L=0.6 W=1.4 AS=0.406
+ AD=0.406 PS=3.38 PD=3.38
M$674 \$16 bias_a VSS sky130_gnd sky130_fd_pr__nfet_01v8 L=0.6 W=1.4 AS=0.406
+ AD=0.406 PS=3.38 PD=3.38
M$675 \$16 cmc VSS sky130_gnd sky130_fd_pr__nfet_01v8 L=0.6 W=1.4 AS=0.406
+ AD=0.406 PS=3.38 PD=3.38
M$676 \$16 bias_a VSS sky130_gnd sky130_fd_pr__nfet_01v8 L=0.6 W=1.4 AS=0.406
+ AD=0.406 PS=3.38 PD=3.38
M$677 \$16 cmc VSS sky130_gnd sky130_fd_pr__nfet_01v8 L=0.6 W=1.4 AS=0.406
+ AD=0.406 PS=3.38 PD=3.38
M$678 \$16 bias_a VSS sky130_gnd sky130_fd_pr__nfet_01v8 L=0.6 W=1.4 AS=0.406
+ AD=0.406 PS=3.38 PD=3.38
M$679 \$16 cmc VSS sky130_gnd sky130_fd_pr__nfet_01v8 L=0.6 W=1.4 AS=0.406
+ AD=0.406 PS=3.38 PD=3.38
M$680 \$16 bias_a VSS sky130_gnd sky130_fd_pr__nfet_01v8 L=0.6 W=1.4 AS=0.406
+ AD=0.406 PS=3.38 PD=3.38
M$681 \$16 cmc VSS sky130_gnd sky130_fd_pr__nfet_01v8 L=0.6 W=1.4 AS=0.406
+ AD=0.406 PS=3.38 PD=3.38
M$682 \$16 bias_a VSS sky130_gnd sky130_fd_pr__nfet_01v8 L=0.6 W=1.4 AS=0.406
+ AD=0.406 PS=3.38 PD=3.38
M$683 \$16 cmc VSS sky130_gnd sky130_fd_pr__nfet_01v8 L=0.6 W=1.4 AS=0.406
+ AD=0.406 PS=3.38 PD=3.38
M$684 \$16 bias_a VSS sky130_gnd sky130_fd_pr__nfet_01v8 L=0.6 W=1.4 AS=0.406
+ AD=0.406 PS=3.38 PD=3.38
M$685 \$16 cmc VSS sky130_gnd sky130_fd_pr__nfet_01v8 L=0.6 W=1.4 AS=0.406
+ AD=0.406 PS=3.38 PD=3.38
M$686 \$16 bias_a VSS sky130_gnd sky130_fd_pr__nfet_01v8 L=0.6 W=1.4 AS=0.406
+ AD=0.406 PS=3.38 PD=3.38
M$687 \$16 cmc VSS sky130_gnd sky130_fd_pr__nfet_01v8 L=0.6 W=1.4 AS=0.406
+ AD=0.406 PS=3.38 PD=3.38
M$688 \$16 bias_a VSS sky130_gnd sky130_fd_pr__nfet_01v8 L=0.6 W=1.4 AS=0.406
+ AD=0.406 PS=3.38 PD=3.38
M$689 \$16 bias_a VSS sky130_gnd sky130_fd_pr__nfet_01v8 L=0.6 W=1.4 AS=0.406
+ AD=0.406 PS=3.38 PD=3.38
M$690 op \$73 \$18 sky130_gnd sky130_fd_pr__nfet_01v8 L=0.6 W=1.4 AS=0.406
+ AD=0.406 PS=3.38 PD=3.38
M$691 op \$73 \$18 sky130_gnd sky130_fd_pr__nfet_01v8 L=0.6 W=1.4 AS=0.406
+ AD=0.406 PS=3.38 PD=3.38
M$692 op \$73 \$18 sky130_gnd sky130_fd_pr__nfet_01v8 L=0.6 W=1.4 AS=0.406
+ AD=0.406 PS=3.38 PD=3.38
M$693 op \$73 \$18 sky130_gnd sky130_fd_pr__nfet_01v8 L=0.6 W=1.4 AS=0.406
+ AD=0.406 PS=3.38 PD=3.38
M$694 op \$73 \$18 sky130_gnd sky130_fd_pr__nfet_01v8 L=0.6 W=1.4 AS=0.406
+ AD=0.406 PS=3.38 PD=3.38
M$695 op \$73 \$18 sky130_gnd sky130_fd_pr__nfet_01v8 L=0.6 W=1.4 AS=0.406
+ AD=0.406 PS=3.38 PD=3.38
M$696 op \$73 \$18 sky130_gnd sky130_fd_pr__nfet_01v8 L=0.6 W=1.4 AS=0.406
+ AD=0.406 PS=3.38 PD=3.38
M$697 op \$73 \$18 sky130_gnd sky130_fd_pr__nfet_01v8 L=0.6 W=1.4 AS=0.406
+ AD=0.406 PS=3.38 PD=3.38
M$698 op \$73 \$18 sky130_gnd sky130_fd_pr__nfet_01v8 L=0.6 W=1.4 AS=0.406
+ AD=0.406 PS=3.38 PD=3.38
M$699 op \$73 \$18 sky130_gnd sky130_fd_pr__nfet_01v8 L=0.6 W=1.4 AS=0.406
+ AD=0.406 PS=3.38 PD=3.38
M$700 op \$73 \$18 sky130_gnd sky130_fd_pr__nfet_01v8 L=0.6 W=1.4 AS=0.406
+ AD=0.406 PS=3.38 PD=3.38
M$701 op \$73 \$18 sky130_gnd sky130_fd_pr__nfet_01v8 L=0.6 W=1.4 AS=0.406
+ AD=0.406 PS=3.38 PD=3.38
M$702 op \$73 \$18 sky130_gnd sky130_fd_pr__nfet_01v8 L=0.6 W=1.4 AS=0.406
+ AD=0.406 PS=3.38 PD=3.38
M$703 op \$73 \$18 sky130_gnd sky130_fd_pr__nfet_01v8 L=0.6 W=1.4 AS=0.406
+ AD=0.406 PS=3.38 PD=3.38
M$704 op \$73 \$18 sky130_gnd sky130_fd_pr__nfet_01v8 L=0.6 W=1.4 AS=0.406
+ AD=0.406 PS=3.38 PD=3.38
M$705 op \$73 \$18 sky130_gnd sky130_fd_pr__nfet_01v8 L=0.6 W=1.4 AS=0.406
+ AD=0.406 PS=3.38 PD=3.38
M$706 op \$73 \$18 sky130_gnd sky130_fd_pr__nfet_01v8 L=0.6 W=1.4 AS=0.406
+ AD=0.406 PS=3.38 PD=3.38
M$707 op \$73 \$18 sky130_gnd sky130_fd_pr__nfet_01v8 L=0.6 W=1.4 AS=0.406
+ AD=0.406 PS=3.38 PD=3.38
M$708 op \$73 \$18 sky130_gnd sky130_fd_pr__nfet_01v8 L=0.6 W=1.4 AS=0.406
+ AD=0.406 PS=3.38 PD=3.38
M$709 op \$73 \$18 sky130_gnd sky130_fd_pr__nfet_01v8 L=0.6 W=1.4 AS=0.406
+ AD=0.406 PS=3.38 PD=3.38
M$710 op \$73 \$18 sky130_gnd sky130_fd_pr__nfet_01v8 L=0.6 W=1.4 AS=0.406
+ AD=0.406 PS=3.38 PD=3.38
M$711 op \$73 \$18 sky130_gnd sky130_fd_pr__nfet_01v8 L=0.6 W=1.4 AS=0.406
+ AD=0.406 PS=3.38 PD=3.38
M$712 op \$73 \$18 sky130_gnd sky130_fd_pr__nfet_01v8 L=0.6 W=1.4 AS=0.406
+ AD=0.406 PS=3.38 PD=3.38
M$713 op \$73 \$18 sky130_gnd sky130_fd_pr__nfet_01v8 L=0.6 W=1.4 AS=0.406
+ AD=0.406 PS=3.38 PD=3.38
M$714 op \$73 \$18 sky130_gnd sky130_fd_pr__nfet_01v8 L=0.6 W=1.4 AS=0.406
+ AD=0.406 PS=3.38 PD=3.38
M$715 op \$73 \$18 sky130_gnd sky130_fd_pr__nfet_01v8 L=0.6 W=1.4 AS=0.406
+ AD=0.406 PS=3.38 PD=3.38
M$716 op \$73 \$18 sky130_gnd sky130_fd_pr__nfet_01v8 L=0.6 W=1.4 AS=0.406
+ AD=0.406 PS=3.38 PD=3.38
M$717 op \$73 \$18 sky130_gnd sky130_fd_pr__nfet_01v8 L=0.6 W=1.4 AS=0.406
+ AD=0.406 PS=3.38 PD=3.38
M$718 op \$73 \$18 sky130_gnd sky130_fd_pr__nfet_01v8 L=0.6 W=1.4 AS=0.406
+ AD=0.406 PS=3.38 PD=3.38
M$719 op \$73 \$18 sky130_gnd sky130_fd_pr__nfet_01v8 L=0.6 W=1.4 AS=0.406
+ AD=0.406 PS=3.38 PD=3.38
M$720 op \$73 \$18 sky130_gnd sky130_fd_pr__nfet_01v8 L=0.6 W=1.4 AS=0.406
+ AD=0.406 PS=3.38 PD=3.38
M$721 op \$73 \$18 sky130_gnd sky130_fd_pr__nfet_01v8 L=0.6 W=1.4 AS=0.406
+ AD=0.406 PS=3.38 PD=3.38
M$722 op \$73 \$18 sky130_gnd sky130_fd_pr__nfet_01v8 L=0.6 W=1.4 AS=0.406
+ AD=0.406 PS=3.38 PD=3.38
M$723 op \$73 \$18 sky130_gnd sky130_fd_pr__nfet_01v8 L=0.6 W=1.4 AS=0.406
+ AD=0.406 PS=3.38 PD=3.38
M$724 op \$73 \$18 sky130_gnd sky130_fd_pr__nfet_01v8 L=0.6 W=1.4 AS=0.406
+ AD=0.406 PS=3.38 PD=3.38
M$725 op \$73 \$18 sky130_gnd sky130_fd_pr__nfet_01v8 L=0.6 W=1.4 AS=0.406
+ AD=0.406 PS=3.38 PD=3.38
M$726 on \$73 \$17 sky130_gnd sky130_fd_pr__nfet_01v8 L=0.6 W=1.4 AS=0.406
+ AD=0.406 PS=3.38 PD=3.38
M$727 on \$73 \$17 sky130_gnd sky130_fd_pr__nfet_01v8 L=0.6 W=1.4 AS=0.406
+ AD=0.406 PS=3.38 PD=3.38
M$728 on \$73 \$17 sky130_gnd sky130_fd_pr__nfet_01v8 L=0.6 W=1.4 AS=0.406
+ AD=0.406 PS=3.38 PD=3.38
M$729 on \$73 \$17 sky130_gnd sky130_fd_pr__nfet_01v8 L=0.6 W=1.4 AS=0.406
+ AD=0.406 PS=3.38 PD=3.38
M$730 on \$73 \$17 sky130_gnd sky130_fd_pr__nfet_01v8 L=0.6 W=1.4 AS=0.406
+ AD=0.406 PS=3.38 PD=3.38
M$731 on \$73 \$17 sky130_gnd sky130_fd_pr__nfet_01v8 L=0.6 W=1.4 AS=0.406
+ AD=0.406 PS=3.38 PD=3.38
M$732 on \$73 \$17 sky130_gnd sky130_fd_pr__nfet_01v8 L=0.6 W=1.4 AS=0.406
+ AD=0.406 PS=3.38 PD=3.38
M$733 on \$73 \$17 sky130_gnd sky130_fd_pr__nfet_01v8 L=0.6 W=1.4 AS=0.406
+ AD=0.406 PS=3.38 PD=3.38
M$734 on \$73 \$17 sky130_gnd sky130_fd_pr__nfet_01v8 L=0.6 W=1.4 AS=0.406
+ AD=0.406 PS=3.38 PD=3.38
M$735 on \$73 \$17 sky130_gnd sky130_fd_pr__nfet_01v8 L=0.6 W=1.4 AS=0.406
+ AD=0.406 PS=3.38 PD=3.38
M$736 on \$73 \$17 sky130_gnd sky130_fd_pr__nfet_01v8 L=0.6 W=1.4 AS=0.406
+ AD=0.406 PS=3.38 PD=3.38
M$737 on \$73 \$17 sky130_gnd sky130_fd_pr__nfet_01v8 L=0.6 W=1.4 AS=0.406
+ AD=0.406 PS=3.38 PD=3.38
M$738 on \$73 \$17 sky130_gnd sky130_fd_pr__nfet_01v8 L=0.6 W=1.4 AS=0.406
+ AD=0.406 PS=3.38 PD=3.38
M$739 on \$73 \$17 sky130_gnd sky130_fd_pr__nfet_01v8 L=0.6 W=1.4 AS=0.406
+ AD=0.406 PS=3.38 PD=3.38
M$740 on \$73 \$17 sky130_gnd sky130_fd_pr__nfet_01v8 L=0.6 W=1.4 AS=0.406
+ AD=0.406 PS=3.38 PD=3.38
M$741 on \$73 \$17 sky130_gnd sky130_fd_pr__nfet_01v8 L=0.6 W=1.4 AS=0.406
+ AD=0.406 PS=3.38 PD=3.38
M$742 on \$73 \$17 sky130_gnd sky130_fd_pr__nfet_01v8 L=0.6 W=1.4 AS=0.406
+ AD=0.406 PS=3.38 PD=3.38
M$743 on \$73 \$17 sky130_gnd sky130_fd_pr__nfet_01v8 L=0.6 W=1.4 AS=0.406
+ AD=0.406 PS=3.38 PD=3.38
M$744 on \$73 \$17 sky130_gnd sky130_fd_pr__nfet_01v8 L=0.6 W=1.4 AS=0.406
+ AD=0.406 PS=3.38 PD=3.38
M$745 on \$73 \$17 sky130_gnd sky130_fd_pr__nfet_01v8 L=0.6 W=1.4 AS=0.406
+ AD=0.406 PS=3.38 PD=3.38
M$746 on \$73 \$17 sky130_gnd sky130_fd_pr__nfet_01v8 L=0.6 W=1.4 AS=0.406
+ AD=0.406 PS=3.38 PD=3.38
M$747 on \$73 \$17 sky130_gnd sky130_fd_pr__nfet_01v8 L=0.6 W=1.4 AS=0.406
+ AD=0.406 PS=3.38 PD=3.38
M$748 on \$73 \$17 sky130_gnd sky130_fd_pr__nfet_01v8 L=0.6 W=1.4 AS=0.406
+ AD=0.406 PS=3.38 PD=3.38
M$749 on \$73 \$17 sky130_gnd sky130_fd_pr__nfet_01v8 L=0.6 W=1.4 AS=0.406
+ AD=0.406 PS=3.38 PD=3.38
M$750 on \$73 \$17 sky130_gnd sky130_fd_pr__nfet_01v8 L=0.6 W=1.4 AS=0.406
+ AD=0.406 PS=3.38 PD=3.38
M$751 on \$73 \$17 sky130_gnd sky130_fd_pr__nfet_01v8 L=0.6 W=1.4 AS=0.406
+ AD=0.406 PS=3.38 PD=3.38
M$752 on \$73 \$17 sky130_gnd sky130_fd_pr__nfet_01v8 L=0.6 W=1.4 AS=0.406
+ AD=0.406 PS=3.38 PD=3.38
M$753 on \$73 \$17 sky130_gnd sky130_fd_pr__nfet_01v8 L=0.6 W=1.4 AS=0.406
+ AD=0.406 PS=3.38 PD=3.38
M$754 on \$73 \$17 sky130_gnd sky130_fd_pr__nfet_01v8 L=0.6 W=1.4 AS=0.406
+ AD=0.406 PS=3.38 PD=3.38
M$755 on \$73 \$17 sky130_gnd sky130_fd_pr__nfet_01v8 L=0.6 W=1.4 AS=0.406
+ AD=0.406 PS=3.38 PD=3.38
M$756 on \$73 \$17 sky130_gnd sky130_fd_pr__nfet_01v8 L=0.6 W=1.4 AS=0.406
+ AD=0.406 PS=3.38 PD=3.38
M$757 on \$73 \$17 sky130_gnd sky130_fd_pr__nfet_01v8 L=0.6 W=1.4 AS=0.406
+ AD=0.406 PS=3.38 PD=3.38
M$758 on \$73 \$17 sky130_gnd sky130_fd_pr__nfet_01v8 L=0.6 W=1.4 AS=0.406
+ AD=0.406 PS=3.38 PD=3.38
M$759 on \$73 \$17 sky130_gnd sky130_fd_pr__nfet_01v8 L=0.6 W=1.4 AS=0.406
+ AD=0.406 PS=3.38 PD=3.38
M$760 on \$73 \$17 sky130_gnd sky130_fd_pr__nfet_01v8 L=0.6 W=1.4 AS=0.406
+ AD=0.406 PS=3.38 PD=3.38
M$761 on \$73 \$17 sky130_gnd sky130_fd_pr__nfet_01v8 L=0.6 W=1.4 AS=0.406
+ AD=0.406 PS=3.38 PD=3.38
M$762 VSS VSS VSS sky130_gnd sky130_fd_pr__nfet_01v8 L=0.6 W=1.4 AS=0.406
+ AD=0.406 PS=3.38 PD=3.38
M$763 VSS VSS VSS sky130_gnd sky130_fd_pr__nfet_01v8 L=0.6 W=1.4 AS=0.406
+ AD=0.406 PS=3.38 PD=3.38
M$764 VSS VSS VSS sky130_gnd sky130_fd_pr__nfet_01v8 L=0.6 W=1.4 AS=0.406
+ AD=0.406 PS=3.38 PD=3.38
M$765 VSS VSS VSS sky130_gnd sky130_fd_pr__nfet_01v8 L=0.6 W=1.4 AS=0.406
+ AD=0.406 PS=3.38 PD=3.38
M$766 \$18 bias_a VSS sky130_gnd sky130_fd_pr__nfet_01v8 L=0.6 W=1.4 AS=0.406
+ AD=0.406 PS=3.38 PD=3.38
M$767 \$18 bias_a VSS sky130_gnd sky130_fd_pr__nfet_01v8 L=0.6 W=1.4 AS=0.406
+ AD=0.406 PS=3.38 PD=3.38
M$768 \$18 bias_a VSS sky130_gnd sky130_fd_pr__nfet_01v8 L=0.6 W=1.4 AS=0.406
+ AD=0.406 PS=3.38 PD=3.38
M$769 \$18 bias_a VSS sky130_gnd sky130_fd_pr__nfet_01v8 L=0.6 W=1.4 AS=0.406
+ AD=0.406 PS=3.38 PD=3.38
M$770 \$18 bias_a VSS sky130_gnd sky130_fd_pr__nfet_01v8 L=0.6 W=1.4 AS=0.406
+ AD=0.406 PS=3.38 PD=3.38
M$771 \$18 bias_a VSS sky130_gnd sky130_fd_pr__nfet_01v8 L=0.6 W=1.4 AS=0.406
+ AD=0.406 PS=3.38 PD=3.38
M$772 \$18 bias_a VSS sky130_gnd sky130_fd_pr__nfet_01v8 L=0.6 W=1.4 AS=0.406
+ AD=0.406 PS=3.38 PD=3.38
M$773 \$18 bias_a VSS sky130_gnd sky130_fd_pr__nfet_01v8 L=0.6 W=1.4 AS=0.406
+ AD=0.406 PS=3.38 PD=3.38
M$774 \$18 bias_a VSS sky130_gnd sky130_fd_pr__nfet_01v8 L=0.6 W=1.4 AS=0.406
+ AD=0.406 PS=3.38 PD=3.38
M$775 \$18 bias_a VSS sky130_gnd sky130_fd_pr__nfet_01v8 L=0.6 W=1.4 AS=0.406
+ AD=0.406 PS=3.38 PD=3.38
M$776 \$18 bias_a VSS sky130_gnd sky130_fd_pr__nfet_01v8 L=0.6 W=1.4 AS=0.406
+ AD=0.406 PS=3.38 PD=3.38
M$777 \$18 bias_a VSS sky130_gnd sky130_fd_pr__nfet_01v8 L=0.6 W=1.4 AS=0.406
+ AD=0.406 PS=3.38 PD=3.38
M$778 \$18 bias_a VSS sky130_gnd sky130_fd_pr__nfet_01v8 L=0.6 W=1.4 AS=0.406
+ AD=0.406 PS=3.38 PD=3.38
M$779 \$18 bias_a VSS sky130_gnd sky130_fd_pr__nfet_01v8 L=0.6 W=1.4 AS=0.406
+ AD=0.406 PS=3.38 PD=3.38
M$780 \$18 bias_a VSS sky130_gnd sky130_fd_pr__nfet_01v8 L=0.6 W=1.4 AS=0.406
+ AD=0.406 PS=3.38 PD=3.38
M$781 \$18 bias_a VSS sky130_gnd sky130_fd_pr__nfet_01v8 L=0.6 W=1.4 AS=0.406
+ AD=0.406 PS=3.38 PD=3.38
M$782 \$18 bias_a VSS sky130_gnd sky130_fd_pr__nfet_01v8 L=0.6 W=1.4 AS=0.406
+ AD=0.406 PS=3.38 PD=3.38
M$783 \$18 bias_a VSS sky130_gnd sky130_fd_pr__nfet_01v8 L=0.6 W=1.4 AS=0.406
+ AD=0.406 PS=3.38 PD=3.38
M$784 \$18 bias_a VSS sky130_gnd sky130_fd_pr__nfet_01v8 L=0.6 W=1.4 AS=0.406
+ AD=0.406 PS=3.38 PD=3.38
M$785 \$18 bias_a VSS sky130_gnd sky130_fd_pr__nfet_01v8 L=0.6 W=1.4 AS=0.406
+ AD=0.406 PS=3.38 PD=3.38
M$786 \$18 bias_a VSS sky130_gnd sky130_fd_pr__nfet_01v8 L=0.6 W=1.4 AS=0.406
+ AD=0.406 PS=3.38 PD=3.38
M$787 \$18 bias_a VSS sky130_gnd sky130_fd_pr__nfet_01v8 L=0.6 W=1.4 AS=0.406
+ AD=0.406 PS=3.38 PD=3.38
M$788 \$18 bias_a VSS sky130_gnd sky130_fd_pr__nfet_01v8 L=0.6 W=1.4 AS=0.406
+ AD=0.406 PS=3.38 PD=3.38
M$789 \$18 bias_a VSS sky130_gnd sky130_fd_pr__nfet_01v8 L=0.6 W=1.4 AS=0.406
+ AD=0.406 PS=3.38 PD=3.38
M$790 \$18 bias_a VSS sky130_gnd sky130_fd_pr__nfet_01v8 L=0.6 W=1.4 AS=0.406
+ AD=0.406 PS=3.38 PD=3.38
M$791 \$18 bias_a VSS sky130_gnd sky130_fd_pr__nfet_01v8 L=0.6 W=1.4 AS=0.406
+ AD=0.406 PS=3.38 PD=3.38
M$792 \$18 bias_a VSS sky130_gnd sky130_fd_pr__nfet_01v8 L=0.6 W=1.4 AS=0.406
+ AD=0.406 PS=3.38 PD=3.38
M$793 \$18 bias_a VSS sky130_gnd sky130_fd_pr__nfet_01v8 L=0.6 W=1.4 AS=0.406
+ AD=0.406 PS=3.38 PD=3.38
M$794 \$18 bias_a VSS sky130_gnd sky130_fd_pr__nfet_01v8 L=0.6 W=1.4 AS=0.406
+ AD=0.406 PS=3.38 PD=3.38
M$795 \$18 bias_a VSS sky130_gnd sky130_fd_pr__nfet_01v8 L=0.6 W=1.4 AS=0.406
+ AD=0.406 PS=3.38 PD=3.38
M$796 \$18 bias_a VSS sky130_gnd sky130_fd_pr__nfet_01v8 L=0.6 W=1.4 AS=0.406
+ AD=0.406 PS=3.38 PD=3.38
M$797 \$18 bias_a VSS sky130_gnd sky130_fd_pr__nfet_01v8 L=0.6 W=1.4 AS=0.406
+ AD=0.406 PS=3.38 PD=3.38
M$798 \$18 bias_a VSS sky130_gnd sky130_fd_pr__nfet_01v8 L=0.6 W=1.4 AS=0.406
+ AD=0.406 PS=3.38 PD=3.38
M$799 \$18 bias_a VSS sky130_gnd sky130_fd_pr__nfet_01v8 L=0.6 W=1.4 AS=0.406
+ AD=0.406 PS=3.38 PD=3.38
M$800 \$18 bias_a VSS sky130_gnd sky130_fd_pr__nfet_01v8 L=0.6 W=1.4 AS=0.406
+ AD=0.406 PS=3.38 PD=3.38
M$801 \$18 bias_a VSS sky130_gnd sky130_fd_pr__nfet_01v8 L=0.6 W=1.4 AS=0.406
+ AD=0.406 PS=3.38 PD=3.38
M$802 \$17 bias_a VSS sky130_gnd sky130_fd_pr__nfet_01v8 L=0.6 W=1.4 AS=0.406
+ AD=0.406 PS=3.38 PD=3.38
M$803 \$17 bias_a VSS sky130_gnd sky130_fd_pr__nfet_01v8 L=0.6 W=1.4 AS=0.406
+ AD=0.406 PS=3.38 PD=3.38
M$804 \$17 bias_a VSS sky130_gnd sky130_fd_pr__nfet_01v8 L=0.6 W=1.4 AS=0.406
+ AD=0.406 PS=3.38 PD=3.38
M$805 \$17 bias_a VSS sky130_gnd sky130_fd_pr__nfet_01v8 L=0.6 W=1.4 AS=0.406
+ AD=0.406 PS=3.38 PD=3.38
M$806 \$17 bias_a VSS sky130_gnd sky130_fd_pr__nfet_01v8 L=0.6 W=1.4 AS=0.406
+ AD=0.406 PS=3.38 PD=3.38
M$807 \$17 bias_a VSS sky130_gnd sky130_fd_pr__nfet_01v8 L=0.6 W=1.4 AS=0.406
+ AD=0.406 PS=3.38 PD=3.38
M$808 \$17 bias_a VSS sky130_gnd sky130_fd_pr__nfet_01v8 L=0.6 W=1.4 AS=0.406
+ AD=0.406 PS=3.38 PD=3.38
M$809 \$17 bias_a VSS sky130_gnd sky130_fd_pr__nfet_01v8 L=0.6 W=1.4 AS=0.406
+ AD=0.406 PS=3.38 PD=3.38
M$810 \$17 bias_a VSS sky130_gnd sky130_fd_pr__nfet_01v8 L=0.6 W=1.4 AS=0.406
+ AD=0.406 PS=3.38 PD=3.38
M$811 \$17 bias_a VSS sky130_gnd sky130_fd_pr__nfet_01v8 L=0.6 W=1.4 AS=0.406
+ AD=0.406 PS=3.38 PD=3.38
M$812 \$17 bias_a VSS sky130_gnd sky130_fd_pr__nfet_01v8 L=0.6 W=1.4 AS=0.406
+ AD=0.406 PS=3.38 PD=3.38
M$813 \$17 bias_a VSS sky130_gnd sky130_fd_pr__nfet_01v8 L=0.6 W=1.4 AS=0.406
+ AD=0.406 PS=3.38 PD=3.38
M$814 \$17 bias_a VSS sky130_gnd sky130_fd_pr__nfet_01v8 L=0.6 W=1.4 AS=0.406
+ AD=0.406 PS=3.38 PD=3.38
M$815 \$17 bias_a VSS sky130_gnd sky130_fd_pr__nfet_01v8 L=0.6 W=1.4 AS=0.406
+ AD=0.406 PS=3.38 PD=3.38
M$816 \$17 bias_a VSS sky130_gnd sky130_fd_pr__nfet_01v8 L=0.6 W=1.4 AS=0.406
+ AD=0.406 PS=3.38 PD=3.38
M$817 \$17 bias_a VSS sky130_gnd sky130_fd_pr__nfet_01v8 L=0.6 W=1.4 AS=0.406
+ AD=0.406 PS=3.38 PD=3.38
M$818 \$17 bias_a VSS sky130_gnd sky130_fd_pr__nfet_01v8 L=0.6 W=1.4 AS=0.406
+ AD=0.406 PS=3.38 PD=3.38
M$819 \$17 bias_a VSS sky130_gnd sky130_fd_pr__nfet_01v8 L=0.6 W=1.4 AS=0.406
+ AD=0.406 PS=3.38 PD=3.38
M$820 \$17 bias_a VSS sky130_gnd sky130_fd_pr__nfet_01v8 L=0.6 W=1.4 AS=0.406
+ AD=0.406 PS=3.38 PD=3.38
M$821 \$17 bias_a VSS sky130_gnd sky130_fd_pr__nfet_01v8 L=0.6 W=1.4 AS=0.406
+ AD=0.406 PS=3.38 PD=3.38
M$822 \$17 bias_a VSS sky130_gnd sky130_fd_pr__nfet_01v8 L=0.6 W=1.4 AS=0.406
+ AD=0.406 PS=3.38 PD=3.38
M$823 \$17 bias_a VSS sky130_gnd sky130_fd_pr__nfet_01v8 L=0.6 W=1.4 AS=0.406
+ AD=0.406 PS=3.38 PD=3.38
M$824 \$17 bias_a VSS sky130_gnd sky130_fd_pr__nfet_01v8 L=0.6 W=1.4 AS=0.406
+ AD=0.406 PS=3.38 PD=3.38
M$825 \$17 bias_a VSS sky130_gnd sky130_fd_pr__nfet_01v8 L=0.6 W=1.4 AS=0.406
+ AD=0.406 PS=3.38 PD=3.38
M$826 \$17 bias_a VSS sky130_gnd sky130_fd_pr__nfet_01v8 L=0.6 W=1.4 AS=0.406
+ AD=0.406 PS=3.38 PD=3.38
M$827 \$17 bias_a VSS sky130_gnd sky130_fd_pr__nfet_01v8 L=0.6 W=1.4 AS=0.406
+ AD=0.406 PS=3.38 PD=3.38
M$828 \$17 bias_a VSS sky130_gnd sky130_fd_pr__nfet_01v8 L=0.6 W=1.4 AS=0.406
+ AD=0.406 PS=3.38 PD=3.38
M$829 \$17 bias_a VSS sky130_gnd sky130_fd_pr__nfet_01v8 L=0.6 W=1.4 AS=0.406
+ AD=0.406 PS=3.38 PD=3.38
M$830 \$17 bias_a VSS sky130_gnd sky130_fd_pr__nfet_01v8 L=0.6 W=1.4 AS=0.406
+ AD=0.406 PS=3.38 PD=3.38
M$831 \$17 bias_a VSS sky130_gnd sky130_fd_pr__nfet_01v8 L=0.6 W=1.4 AS=0.406
+ AD=0.406 PS=3.38 PD=3.38
M$832 \$17 bias_a VSS sky130_gnd sky130_fd_pr__nfet_01v8 L=0.6 W=1.4 AS=0.406
+ AD=0.406 PS=3.38 PD=3.38
M$833 \$17 bias_a VSS sky130_gnd sky130_fd_pr__nfet_01v8 L=0.6 W=1.4 AS=0.406
+ AD=0.406 PS=3.38 PD=3.38
M$834 \$17 bias_a VSS sky130_gnd sky130_fd_pr__nfet_01v8 L=0.6 W=1.4 AS=0.406
+ AD=0.406 PS=3.38 PD=3.38
M$835 \$17 bias_a VSS sky130_gnd sky130_fd_pr__nfet_01v8 L=0.6 W=1.4 AS=0.406
+ AD=0.406 PS=3.38 PD=3.38
M$836 \$17 bias_a VSS sky130_gnd sky130_fd_pr__nfet_01v8 L=0.6 W=1.4 AS=0.406
+ AD=0.406 PS=3.38 PD=3.38
M$837 \$17 bias_a VSS sky130_gnd sky130_fd_pr__nfet_01v8 L=0.6 W=1.4 AS=0.406
+ AD=0.406 PS=3.38 PD=3.38
M$838 \$177 \$177 \$177 sky130_gnd sky130_fd_pr__nfet_01v8 L=0.6 W=1.4 AS=0.406
+ AD=0.406 PS=3.38 PD=3.38
M$839 \$177 \$177 \$177 sky130_gnd sky130_fd_pr__nfet_01v8 L=0.6 W=1.4 AS=0.406
+ AD=0.406 PS=3.38 PD=3.38
M$840 IBIAS IBIAS IBIAS sky130_gnd sky130_fd_pr__nfet_01v8 L=0.6 W=1.4 AS=0.406
+ AD=0.406 PS=3.38 PD=3.38
M$841 IBIAS IBIAS IBIAS sky130_gnd sky130_fd_pr__nfet_01v8 L=0.6 W=1.4 AS=0.406
+ AD=0.406 PS=3.38 PD=3.38
M$842 \$73 \$162 bias_a sky130_gnd sky130_fd_pr__nfet_01v8 L=0.6 W=1.4 AS=0.406
+ AD=0.406 PS=3.38 PD=3.38
M$843 \$73 \$162 bias_a sky130_gnd sky130_fd_pr__nfet_01v8 L=0.6 W=1.4 AS=0.406
+ AD=0.406 PS=3.38 PD=3.38
M$844 \$162 \$162 \$162 sky130_gnd sky130_fd_pr__nfet_01v8 L=0.6 W=1.4 AS=0.406
+ AD=0.406 PS=3.38 PD=3.38
M$845 \$162 \$162 \$162 sky130_gnd sky130_fd_pr__nfet_01v8 L=0.6 W=1.4 AS=0.406
+ AD=0.406 PS=3.38 PD=3.38
M$846 on on on sky130_gnd sky130_fd_pr__nfet_01v8 L=0.6 W=1.4 AS=0.406 AD=0.406
+ PS=3.38 PD=3.38
M$847 on on on sky130_gnd sky130_fd_pr__nfet_01v8 L=0.6 W=1.4 AS=0.406 AD=0.406
+ PS=3.38 PD=3.38
M$848 on VSS VSS sky130_gnd sky130_fd_pr__nfet_01v8 L=0.6 W=1.4 AS=0.406
+ AD=0.406 PS=3.38 PD=3.38
M$849 on VSS VSS sky130_gnd sky130_fd_pr__nfet_01v8 L=0.6 W=1.4 AS=0.406
+ AD=0.406 PS=3.38 PD=3.38
M$850 op op op sky130_gnd sky130_fd_pr__nfet_01v8 L=0.6 W=1.4 AS=0.406 AD=0.406
+ PS=3.38 PD=3.38
M$851 op op op sky130_gnd sky130_fd_pr__nfet_01v8 L=0.6 W=1.4 AS=0.406 AD=0.406
+ PS=3.38 PD=3.38
M$852 op VSS VSS sky130_gnd sky130_fd_pr__nfet_01v8 L=0.6 W=1.4 AS=0.406
+ AD=0.406 PS=3.38 PD=3.38
M$853 op VSS VSS sky130_gnd sky130_fd_pr__nfet_01v8 L=0.6 W=1.4 AS=0.406
+ AD=0.406 PS=3.38 PD=3.38
M$854 \$16 VSS VSS sky130_gnd sky130_fd_pr__nfet_01v8 L=0.6 W=1.4 AS=0.406
+ AD=0.406 PS=3.38 PD=3.38
M$855 \$16 VSS VSS sky130_gnd sky130_fd_pr__nfet_01v8 L=0.6 W=1.4 AS=0.406
+ AD=0.406 PS=3.38 PD=3.38
.ENDS iadc_ota_v2_routed
