* Extracted by KLayout with SKY130 LVS runset on : 05/11/2026 17:21

.SUBCKT iadc_ota_v2_routed \$5.x1_net1 \$5.x1_net10 \$5.x1_net11 \$5.x1_net12
+ \$5.x1_net13 \$5.x1_net14 \$5.x1_net15 \$5.x1_net2 \$5.x1_net3 \$5.x1_net4
+ \$5.x1_net5 \$5.x1_net6 \$5.x1_net7 \$5.x1_net8 \$5.x1_net9 IBIAS VDD VSS
+ bias_a cm cmc in ip on op sky130_gnd
C$1 cmc on sky130_fd_pr__model__cap_mim C=4.608e-14 A=23.04 P=19.2
C$2 cmc on sky130_fd_pr__model__cap_mim C=4.608e-14 A=23.04 P=19.2
C$3 cmc on sky130_fd_pr__model__cap_mim C=4.608e-14 A=23.04 P=19.2
C$4 cmc on sky130_fd_pr__model__cap_mim C=4.608e-14 A=23.04 P=19.2
C$5 cmc op sky130_fd_pr__model__cap_mim C=4.608e-14 A=23.04 P=19.2
C$6 cmc op sky130_fd_pr__model__cap_mim C=4.608e-14 A=23.04 P=19.2
C$7 cmc op sky130_fd_pr__model__cap_mim C=4.608e-14 A=23.04 P=19.2
C$8 cmc op sky130_fd_pr__model__cap_mim C=4.608e-14 A=23.04 P=19.2
M$9 \$268 \$268 \$268 VDD sky130_fd_pr__pfet_01v8_lvt L=0.6 W=1.4 AS=0.406
+ AD=0.406 PS=3.38 PD=3.38
M$10 \$268 \$268 \$268 VDD sky130_fd_pr__pfet_01v8_lvt L=0.6 W=1.4 AS=0.406
+ AD=0.406 PS=3.38 PD=3.38
M$11 \$318 \$318 \$318 VDD sky130_fd_pr__pfet_01v8_lvt L=0.6 W=1.4 AS=0.406
+ AD=0.406 PS=3.38 PD=3.38
M$12 \$318 \$318 \$318 VDD sky130_fd_pr__pfet_01v8_lvt L=0.6 W=1.4 AS=0.406
+ AD=0.406 PS=3.38 PD=3.38
M$13 \$284 \$284 \$284 VDD sky130_fd_pr__pfet_01v8_lvt L=0.6 W=1.4 AS=0.406
+ AD=0.406 PS=3.38 PD=3.38
M$14 \$284 \$284 \$284 VDD sky130_fd_pr__pfet_01v8_lvt L=0.6 W=1.4 AS=0.406
+ AD=0.406 PS=3.38 PD=3.38
M$15 VDD VDD VDD VDD sky130_fd_pr__pfet_01v8_lvt L=0.6 W=1.4 AS=0.406 AD=0.406
+ PS=3.38 PD=3.38
M$16 VDD VDD VDD VDD sky130_fd_pr__pfet_01v8_lvt L=0.6 W=1.4 AS=0.406 AD=0.406
+ PS=3.38 PD=3.38
M$17 VDD VDD VDD VDD sky130_fd_pr__pfet_01v8_lvt L=0.6 W=1.4 AS=0.406 AD=0.406
+ PS=3.38 PD=3.38
M$18 VDD VDD VDD VDD sky130_fd_pr__pfet_01v8_lvt L=0.6 W=1.4 AS=0.406 AD=0.406
+ PS=3.38 PD=3.38
M$19 VDD VDD VDD VDD sky130_fd_pr__pfet_01v8_lvt L=0.6 W=1.4 AS=0.406 AD=0.406
+ PS=3.38 PD=3.38
M$20 VDD VDD VDD VDD sky130_fd_pr__pfet_01v8_lvt L=0.6 W=1.4 AS=0.406 AD=0.406
+ PS=3.38 PD=3.38
M$21 VDD VDD VDD VDD sky130_fd_pr__pfet_01v8_lvt L=0.6 W=1.4 AS=0.406 AD=0.406
+ PS=3.38 PD=3.38
M$22 VDD VDD VDD VDD sky130_fd_pr__pfet_01v8_lvt L=0.6 W=1.4 AS=0.406 AD=0.406
+ PS=3.38 PD=3.38
M$23 VDD VDD VDD VDD sky130_fd_pr__pfet_01v8_lvt L=0.6 W=1.4 AS=0.406 AD=0.406
+ PS=3.38 PD=3.38
M$24 VDD VDD VDD VDD sky130_fd_pr__pfet_01v8_lvt L=0.6 W=1.4 AS=0.406 AD=0.406
+ PS=3.38 PD=3.38
M$25 \$121 \$121 \$105 sky130_gnd sky130_fd_pr__nfet_01v8_lvt L=0.6 W=1.4
+ AS=0.406 AD=0.406 PS=3.38 PD=3.38
M$26 \$121 \$121 \$105 sky130_gnd sky130_fd_pr__nfet_01v8_lvt L=0.6 W=1.4
+ AS=0.406 AD=0.406 PS=3.38 PD=3.38
M$27 \$121 \$121 \$105 sky130_gnd sky130_fd_pr__nfet_01v8_lvt L=0.6 W=1.4
+ AS=0.406 AD=0.406 PS=3.38 PD=3.38
M$28 \$121 \$121 \$105 sky130_gnd sky130_fd_pr__nfet_01v8_lvt L=0.6 W=1.4
+ AS=0.406 AD=0.406 PS=3.38 PD=3.38
M$29 \$121 \$121 \$105 sky130_gnd sky130_fd_pr__nfet_01v8_lvt L=0.6 W=1.4
+ AS=0.406 AD=0.406 PS=3.38 PD=3.38
M$30 \$121 \$121 \$105 sky130_gnd sky130_fd_pr__nfet_01v8_lvt L=0.6 W=1.4
+ AS=0.406 AD=0.406 PS=3.38 PD=3.38
M$31 \$121 \$121 \$105 sky130_gnd sky130_fd_pr__nfet_01v8_lvt L=0.6 W=1.4
+ AS=0.406 AD=0.406 PS=3.38 PD=3.38
M$32 \$121 \$121 \$105 sky130_gnd sky130_fd_pr__nfet_01v8_lvt L=0.6 W=1.4
+ AS=0.406 AD=0.406 PS=3.38 PD=3.38
M$33 \$121 \$121 \$105 sky130_gnd sky130_fd_pr__nfet_01v8_lvt L=0.6 W=1.4
+ AS=0.406 AD=0.406 PS=3.38 PD=3.38
M$34 \$121 \$121 \$105 sky130_gnd sky130_fd_pr__nfet_01v8_lvt L=0.6 W=1.4
+ AS=0.406 AD=0.406 PS=3.38 PD=3.38
M$35 \$121 \$121 \$105 sky130_gnd sky130_fd_pr__nfet_01v8_lvt L=0.6 W=1.4
+ AS=0.406 AD=0.406 PS=3.38 PD=3.38
M$36 \$121 \$121 \$105 sky130_gnd sky130_fd_pr__nfet_01v8_lvt L=0.6 W=1.4
+ AS=0.406 AD=0.406 PS=3.38 PD=3.38
M$37 \$121 \$121 \$105 sky130_gnd sky130_fd_pr__nfet_01v8_lvt L=0.6 W=1.4
+ AS=0.406 AD=0.406 PS=3.38 PD=3.38
M$38 \$121 \$121 \$105 sky130_gnd sky130_fd_pr__nfet_01v8_lvt L=0.6 W=1.4
+ AS=0.406 AD=0.406 PS=3.38 PD=3.38
M$39 \$121 \$121 \$105 sky130_gnd sky130_fd_pr__nfet_01v8_lvt L=0.6 W=1.4
+ AS=0.406 AD=0.406 PS=3.38 PD=3.38
M$40 \$121 \$121 \$105 sky130_gnd sky130_fd_pr__nfet_01v8_lvt L=0.6 W=1.4
+ AS=0.406 AD=0.406 PS=3.38 PD=3.38
M$41 \$121 \$121 \$105 sky130_gnd sky130_fd_pr__nfet_01v8_lvt L=0.6 W=1.4
+ AS=0.406 AD=0.406 PS=3.38 PD=3.38
M$42 \$121 \$121 \$105 sky130_gnd sky130_fd_pr__nfet_01v8_lvt L=0.6 W=1.4
+ AS=0.406 AD=0.406 PS=3.38 PD=3.38
M$43 \$121 \$121 \$105 sky130_gnd sky130_fd_pr__nfet_01v8_lvt L=0.6 W=1.4
+ AS=0.406 AD=0.406 PS=3.38 PD=3.38
M$44 \$121 \$121 \$105 sky130_gnd sky130_fd_pr__nfet_01v8_lvt L=0.6 W=1.4
+ AS=0.406 AD=0.406 PS=3.38 PD=3.38
M$45 \$121 \$121 \$105 sky130_gnd sky130_fd_pr__nfet_01v8_lvt L=0.6 W=1.4
+ AS=0.406 AD=0.406 PS=3.38 PD=3.38
M$46 \$121 \$121 \$105 sky130_gnd sky130_fd_pr__nfet_01v8_lvt L=0.6 W=1.4
+ AS=0.406 AD=0.406 PS=3.38 PD=3.38
M$47 \$121 \$121 \$105 sky130_gnd sky130_fd_pr__nfet_01v8_lvt L=0.6 W=1.4
+ AS=0.406 AD=0.406 PS=3.38 PD=3.38
M$48 \$121 \$121 \$105 sky130_gnd sky130_fd_pr__nfet_01v8_lvt L=0.6 W=1.4
+ AS=0.406 AD=0.406 PS=3.38 PD=3.38
M$49 \$121 \$121 \$105 sky130_gnd sky130_fd_pr__nfet_01v8_lvt L=0.6 W=1.4
+ AS=0.406 AD=0.406 PS=3.38 PD=3.38
M$50 \$121 \$121 \$105 sky130_gnd sky130_fd_pr__nfet_01v8_lvt L=0.6 W=1.4
+ AS=0.406 AD=0.406 PS=3.38 PD=3.38
M$51 \$121 \$121 \$105 sky130_gnd sky130_fd_pr__nfet_01v8_lvt L=0.6 W=1.4
+ AS=0.406 AD=0.406 PS=3.38 PD=3.38
M$52 \$121 \$121 \$105 sky130_gnd sky130_fd_pr__nfet_01v8_lvt L=0.6 W=1.4
+ AS=0.406 AD=0.406 PS=3.38 PD=3.38
M$53 \$121 \$121 \$105 sky130_gnd sky130_fd_pr__nfet_01v8_lvt L=0.6 W=1.4
+ AS=0.406 AD=0.406 PS=3.38 PD=3.38
M$54 \$121 \$121 \$105 sky130_gnd sky130_fd_pr__nfet_01v8_lvt L=0.6 W=1.4
+ AS=0.406 AD=0.406 PS=3.38 PD=3.38
M$55 \$121 \$121 \$105 sky130_gnd sky130_fd_pr__nfet_01v8_lvt L=0.6 W=1.4
+ AS=0.406 AD=0.406 PS=3.38 PD=3.38
M$56 \$121 \$121 \$105 sky130_gnd sky130_fd_pr__nfet_01v8_lvt L=0.6 W=1.4
+ AS=0.406 AD=0.406 PS=3.38 PD=3.38
M$57 \$121 \$121 \$105 sky130_gnd sky130_fd_pr__nfet_01v8_lvt L=0.6 W=1.4
+ AS=0.406 AD=0.406 PS=3.38 PD=3.38
M$58 \$121 \$121 \$105 sky130_gnd sky130_fd_pr__nfet_01v8_lvt L=0.6 W=1.4
+ AS=0.406 AD=0.406 PS=3.38 PD=3.38
M$59 \$121 \$121 \$105 sky130_gnd sky130_fd_pr__nfet_01v8_lvt L=0.6 W=1.4
+ AS=0.406 AD=0.406 PS=3.38 PD=3.38
M$60 \$121 \$121 \$105 sky130_gnd sky130_fd_pr__nfet_01v8_lvt L=0.6 W=1.4
+ AS=0.406 AD=0.406 PS=3.38 PD=3.38
M$61 \$121 \$121 \$105 sky130_gnd sky130_fd_pr__nfet_01v8_lvt L=0.6 W=1.4
+ AS=0.406 AD=0.406 PS=3.38 PD=3.38
M$62 \$121 \$121 \$105 sky130_gnd sky130_fd_pr__nfet_01v8_lvt L=0.6 W=1.4
+ AS=0.406 AD=0.406 PS=3.38 PD=3.38
M$63 \$121 \$121 \$105 sky130_gnd sky130_fd_pr__nfet_01v8_lvt L=0.6 W=1.4
+ AS=0.406 AD=0.406 PS=3.38 PD=3.38
M$64 \$121 \$121 \$105 sky130_gnd sky130_fd_pr__nfet_01v8_lvt L=0.6 W=1.4
+ AS=0.406 AD=0.406 PS=3.38 PD=3.38
M$65 \$121 \$121 \$105 sky130_gnd sky130_fd_pr__nfet_01v8_lvt L=0.6 W=1.4
+ AS=0.406 AD=0.406 PS=3.38 PD=3.38
M$66 \$121 \$121 \$105 sky130_gnd sky130_fd_pr__nfet_01v8_lvt L=0.6 W=1.4
+ AS=0.406 AD=0.406 PS=3.38 PD=3.38
M$67 \$121 \$121 \$105 sky130_gnd sky130_fd_pr__nfet_01v8_lvt L=0.6 W=1.4
+ AS=0.406 AD=0.406 PS=3.38 PD=3.38
M$68 \$121 \$121 \$105 sky130_gnd sky130_fd_pr__nfet_01v8_lvt L=0.6 W=1.4
+ AS=0.406 AD=0.406 PS=3.38 PD=3.38
M$69 \$121 \$121 \$105 sky130_gnd sky130_fd_pr__nfet_01v8_lvt L=0.6 W=1.4
+ AS=0.406 AD=0.406 PS=3.38 PD=3.38
M$70 \$121 \$121 \$105 sky130_gnd sky130_fd_pr__nfet_01v8_lvt L=0.6 W=1.4
+ AS=0.406 AD=0.406 PS=3.38 PD=3.38
M$71 \$121 \$121 \$105 sky130_gnd sky130_fd_pr__nfet_01v8_lvt L=0.6 W=1.4
+ AS=0.406 AD=0.406 PS=3.38 PD=3.38
M$72 \$121 \$121 \$105 sky130_gnd sky130_fd_pr__nfet_01v8_lvt L=0.6 W=1.4
+ AS=0.406 AD=0.406 PS=3.38 PD=3.38
M$73 \$121 \$121 \$105 sky130_gnd sky130_fd_pr__nfet_01v8_lvt L=0.6 W=1.4
+ AS=0.406 AD=0.406 PS=3.38 PD=3.38
M$74 \$121 \$121 \$105 sky130_gnd sky130_fd_pr__nfet_01v8_lvt L=0.6 W=1.4
+ AS=0.406 AD=0.406 PS=3.38 PD=3.38
M$75 \$121 \$121 \$105 sky130_gnd sky130_fd_pr__nfet_01v8_lvt L=0.6 W=1.4
+ AS=0.406 AD=0.406 PS=3.38 PD=3.38
M$76 \$121 \$121 \$105 sky130_gnd sky130_fd_pr__nfet_01v8_lvt L=0.6 W=1.4
+ AS=0.406 AD=0.406 PS=3.38 PD=3.38
M$77 \$121 \$121 \$105 sky130_gnd sky130_fd_pr__nfet_01v8_lvt L=0.6 W=1.4
+ AS=0.406 AD=0.406 PS=3.38 PD=3.38
M$78 \$121 \$121 \$105 sky130_gnd sky130_fd_pr__nfet_01v8_lvt L=0.6 W=1.4
+ AS=0.406 AD=0.406 PS=3.38 PD=3.38
M$79 \$121 \$121 \$105 sky130_gnd sky130_fd_pr__nfet_01v8_lvt L=0.6 W=1.4
+ AS=0.406 AD=0.406 PS=3.38 PD=3.38
M$80 \$121 \$121 \$105 sky130_gnd sky130_fd_pr__nfet_01v8_lvt L=0.6 W=1.4
+ AS=0.406 AD=0.406 PS=3.38 PD=3.38
M$81 \$121 \$121 \$121 sky130_gnd sky130_fd_pr__nfet_01v8_lvt L=0.6 W=1.4
+ AS=0.406 AD=0.406 PS=3.38 PD=3.38
M$82 \$121 \$121 \$121 sky130_gnd sky130_fd_pr__nfet_01v8_lvt L=0.6 W=1.4
+ AS=0.406 AD=0.406 PS=3.38 PD=3.38
M$83 \$121 \$121 \$121 sky130_gnd sky130_fd_pr__nfet_01v8_lvt L=0.6 W=1.4
+ AS=0.406 AD=0.406 PS=3.38 PD=3.38
M$84 \$121 \$121 \$121 sky130_gnd sky130_fd_pr__nfet_01v8_lvt L=0.6 W=1.4
+ AS=0.406 AD=0.406 PS=3.38 PD=3.38
M$85 \$121 \$121 \$121 sky130_gnd sky130_fd_pr__nfet_01v8_lvt L=0.6 W=1.4
+ AS=0.406 AD=0.406 PS=3.38 PD=3.38
M$86 \$121 \$121 \$121 sky130_gnd sky130_fd_pr__nfet_01v8_lvt L=0.6 W=1.4
+ AS=0.406 AD=0.406 PS=3.38 PD=3.38
M$87 \$121 \$121 \$121 sky130_gnd sky130_fd_pr__nfet_01v8_lvt L=0.6 W=1.4
+ AS=0.406 AD=0.406 PS=3.38 PD=3.38
M$88 \$121 \$121 \$121 sky130_gnd sky130_fd_pr__nfet_01v8_lvt L=0.6 W=1.4
+ AS=0.406 AD=0.406 PS=3.38 PD=3.38
M$89 \$105 \$105 \$105 sky130_gnd sky130_fd_pr__nfet_01v8_lvt L=0.6 W=1.4
+ AS=0.406 AD=0.406 PS=3.38 PD=3.38
M$90 \$105 \$105 \$105 sky130_gnd sky130_fd_pr__nfet_01v8_lvt L=0.6 W=1.4
+ AS=0.406 AD=0.406 PS=3.38 PD=3.38
M$91 \$105 \$105 \$105 sky130_gnd sky130_fd_pr__nfet_01v8_lvt L=0.6 W=1.4
+ AS=0.406 AD=0.406 PS=3.38 PD=3.38
M$92 \$105 \$105 \$105 sky130_gnd sky130_fd_pr__nfet_01v8_lvt L=0.6 W=1.4
+ AS=0.406 AD=0.406 PS=3.38 PD=3.38
M$93 \$105 \$105 \$105 sky130_gnd sky130_fd_pr__nfet_01v8_lvt L=0.6 W=1.4
+ AS=0.406 AD=0.406 PS=3.38 PD=3.38
M$94 \$105 \$105 \$105 sky130_gnd sky130_fd_pr__nfet_01v8_lvt L=0.6 W=1.4
+ AS=0.406 AD=0.406 PS=3.38 PD=3.38
M$95 \$105 \$105 \$105 sky130_gnd sky130_fd_pr__nfet_01v8_lvt L=0.6 W=1.4
+ AS=0.406 AD=0.406 PS=3.38 PD=3.38
M$96 \$105 \$105 \$105 sky130_gnd sky130_fd_pr__nfet_01v8_lvt L=0.6 W=1.4
+ AS=0.406 AD=0.406 PS=3.38 PD=3.38
M$97 \$44 ip \$1 sky130_gnd sky130_fd_pr__nfet_01v8_lvt L=0.2 W=1.2 AS=0.348
+ AD=0.348 PS=2.98 PD=2.98
M$98 \$43 in \$1 sky130_gnd sky130_fd_pr__nfet_01v8_lvt L=0.2 W=1.2 AS=0.348
+ AD=0.348 PS=2.98 PD=2.98
M$99 \$44 ip \$1 sky130_gnd sky130_fd_pr__nfet_01v8_lvt L=0.2 W=1.2 AS=0.348
+ AD=0.348 PS=2.98 PD=2.98
M$100 \$43 in \$1 sky130_gnd sky130_fd_pr__nfet_01v8_lvt L=0.2 W=1.2 AS=0.348
+ AD=0.348 PS=2.98 PD=2.98
M$101 \$44 ip \$1 sky130_gnd sky130_fd_pr__nfet_01v8_lvt L=0.2 W=1.2 AS=0.348
+ AD=0.348 PS=2.98 PD=2.98
M$102 \$43 in \$1 sky130_gnd sky130_fd_pr__nfet_01v8_lvt L=0.2 W=1.2 AS=0.348
+ AD=0.348 PS=2.98 PD=2.98
M$103 \$44 ip \$1 sky130_gnd sky130_fd_pr__nfet_01v8_lvt L=0.2 W=1.2 AS=0.348
+ AD=0.348 PS=2.98 PD=2.98
M$104 \$44 ip \$1 sky130_gnd sky130_fd_pr__nfet_01v8_lvt L=0.2 W=1.2 AS=0.348
+ AD=0.348 PS=2.98 PD=2.98
M$105 \$43 in \$1 sky130_gnd sky130_fd_pr__nfet_01v8_lvt L=0.2 W=1.2 AS=0.348
+ AD=0.348 PS=2.98 PD=2.98
M$106 \$43 in \$1 sky130_gnd sky130_fd_pr__nfet_01v8_lvt L=0.2 W=1.2 AS=0.348
+ AD=0.348 PS=2.98 PD=2.98
M$107 \$44 ip \$1 sky130_gnd sky130_fd_pr__nfet_01v8_lvt L=0.2 W=1.2 AS=0.348
+ AD=0.348 PS=2.98 PD=2.98
M$108 \$43 in \$1 sky130_gnd sky130_fd_pr__nfet_01v8_lvt L=0.2 W=1.2 AS=0.348
+ AD=0.348 PS=2.98 PD=2.98
M$109 VSS VSS VSS sky130_gnd sky130_fd_pr__nfet_01v8_lvt L=0.2 W=1.2 AS=0.348
+ AD=0.348 PS=2.98 PD=2.98
M$110 VSS VSS VSS sky130_gnd sky130_fd_pr__nfet_01v8_lvt L=0.2 W=1.2 AS=0.348
+ AD=0.348 PS=2.98 PD=2.98
M$111 \$43 \$43 \$43 sky130_gnd sky130_fd_pr__nfet_01v8_lvt L=0.2 W=1.2
+ AS=0.348 AD=0.348 PS=2.98 PD=2.98
M$112 \$43 \$43 \$43 sky130_gnd sky130_fd_pr__nfet_01v8_lvt L=0.2 W=1.2
+ AS=0.348 AD=0.348 PS=2.98 PD=2.98
M$113 \$44 \$44 \$44 sky130_gnd sky130_fd_pr__nfet_01v8_lvt L=0.2 W=1.2
+ AS=0.348 AD=0.348 PS=2.98 PD=2.98
M$114 \$44 \$44 \$44 sky130_gnd sky130_fd_pr__nfet_01v8_lvt L=0.2 W=1.2
+ AS=0.348 AD=0.348 PS=2.98 PD=2.98
M$115 \$121 \$105 \$268 VDD sky130_fd_pr__pfet_01v8 L=0.6 W=1.4 AS=0.406
+ AD=0.406 PS=3.38 PD=3.38
M$116 \$229 \$105 \$318 VDD sky130_fd_pr__pfet_01v8 L=0.6 W=1.4 AS=0.406
+ AD=0.406 PS=3.38 PD=3.38
M$117 cm \$105 \$284 VDD sky130_fd_pr__pfet_01v8 L=0.6 W=1.4 AS=0.406 AD=0.406
+ PS=3.38 PD=3.38
M$118 cm \$105 \$284 VDD sky130_fd_pr__pfet_01v8 L=0.6 W=1.4 AS=0.406 AD=0.406
+ PS=3.38 PD=3.38
M$119 \$229 \$105 \$318 VDD sky130_fd_pr__pfet_01v8 L=0.6 W=1.4 AS=0.406
+ AD=0.406 PS=3.38 PD=3.38
M$120 \$121 \$105 \$268 VDD sky130_fd_pr__pfet_01v8 L=0.6 W=1.4 AS=0.406
+ AD=0.406 PS=3.38 PD=3.38
M$121 cm \$105 \$284 VDD sky130_fd_pr__pfet_01v8 L=0.6 W=1.4 AS=0.406 AD=0.406
+ PS=3.38 PD=3.38
M$122 \$229 \$105 \$318 VDD sky130_fd_pr__pfet_01v8 L=0.6 W=1.4 AS=0.406
+ AD=0.406 PS=3.38 PD=3.38
M$123 \$121 \$105 \$268 VDD sky130_fd_pr__pfet_01v8 L=0.6 W=1.4 AS=0.406
+ AD=0.406 PS=3.38 PD=3.38
M$124 cm \$105 \$284 VDD sky130_fd_pr__pfet_01v8 L=0.6 W=1.4 AS=0.406 AD=0.406
+ PS=3.38 PD=3.38
M$125 \$229 \$105 \$318 VDD sky130_fd_pr__pfet_01v8 L=0.6 W=1.4 AS=0.406
+ AD=0.406 PS=3.38 PD=3.38
M$126 \$121 \$105 \$268 VDD sky130_fd_pr__pfet_01v8 L=0.6 W=1.4 AS=0.406
+ AD=0.406 PS=3.38 PD=3.38
M$127 cm \$105 \$284 VDD sky130_fd_pr__pfet_01v8 L=0.6 W=1.4 AS=0.406 AD=0.406
+ PS=3.38 PD=3.38
M$128 \$229 \$105 \$318 VDD sky130_fd_pr__pfet_01v8 L=0.6 W=1.4 AS=0.406
+ AD=0.406 PS=3.38 PD=3.38
M$129 \$121 \$105 \$268 VDD sky130_fd_pr__pfet_01v8 L=0.6 W=1.4 AS=0.406
+ AD=0.406 PS=3.38 PD=3.38
M$130 cm \$105 \$284 VDD sky130_fd_pr__pfet_01v8 L=0.6 W=1.4 AS=0.406 AD=0.406
+ PS=3.38 PD=3.38
M$131 \$229 \$105 \$318 VDD sky130_fd_pr__pfet_01v8 L=0.6 W=1.4 AS=0.406
+ AD=0.406 PS=3.38 PD=3.38
M$132 \$121 \$105 \$268 VDD sky130_fd_pr__pfet_01v8 L=0.6 W=1.4 AS=0.406
+ AD=0.406 PS=3.38 PD=3.38
M$133 VDD VDD VDD VDD sky130_fd_pr__pfet_01v8 L=0.6 W=1.4 AS=0.406 AD=0.406
+ PS=3.38 PD=3.38
M$134 VDD VDD VDD VDD sky130_fd_pr__pfet_01v8 L=0.6 W=1.4 AS=0.406 AD=0.406
+ PS=3.38 PD=3.38
M$135 VDD VDD VDD VDD sky130_fd_pr__pfet_01v8 L=0.6 W=1.4 AS=0.406 AD=0.406
+ PS=3.38 PD=3.38
M$136 VDD VDD VDD VDD sky130_fd_pr__pfet_01v8 L=0.6 W=1.4 AS=0.406 AD=0.406
+ PS=3.38 PD=3.38
M$137 VDD VDD VDD VDD sky130_fd_pr__pfet_01v8 L=0.6 W=1.4 AS=0.406 AD=0.406
+ PS=3.38 PD=3.38
M$138 VDD VDD VDD VDD sky130_fd_pr__pfet_01v8 L=0.6 W=1.4 AS=0.406 AD=0.406
+ PS=3.38 PD=3.38
M$139 VDD VDD VDD VDD sky130_fd_pr__pfet_01v8 L=0.6 W=1.4 AS=0.406 AD=0.406
+ PS=3.38 PD=3.38
M$140 VDD VDD VDD VDD sky130_fd_pr__pfet_01v8 L=0.6 W=1.4 AS=0.406 AD=0.406
+ PS=3.38 PD=3.38
M$141 op \$105 \$43 VDD sky130_fd_pr__pfet_01v8 L=0.6 W=1.4 AS=0.406 AD=0.406
+ PS=3.38 PD=3.38
M$142 on \$105 \$44 VDD sky130_fd_pr__pfet_01v8 L=0.6 W=1.4 AS=0.406 AD=0.406
+ PS=3.38 PD=3.38
M$143 op \$105 \$43 VDD sky130_fd_pr__pfet_01v8 L=0.6 W=1.4 AS=0.406 AD=0.406
+ PS=3.38 PD=3.38
M$144 on \$105 \$44 VDD sky130_fd_pr__pfet_01v8 L=0.6 W=1.4 AS=0.406 AD=0.406
+ PS=3.38 PD=3.38
M$145 op \$105 \$43 VDD sky130_fd_pr__pfet_01v8 L=0.6 W=1.4 AS=0.406 AD=0.406
+ PS=3.38 PD=3.38
M$146 op \$105 \$43 VDD sky130_fd_pr__pfet_01v8 L=0.6 W=1.4 AS=0.406 AD=0.406
+ PS=3.38 PD=3.38
M$147 on \$105 \$44 VDD sky130_fd_pr__pfet_01v8 L=0.6 W=1.4 AS=0.406 AD=0.406
+ PS=3.38 PD=3.38
M$148 op \$105 \$43 VDD sky130_fd_pr__pfet_01v8 L=0.6 W=1.4 AS=0.406 AD=0.406
+ PS=3.38 PD=3.38
M$149 on \$105 \$44 VDD sky130_fd_pr__pfet_01v8 L=0.6 W=1.4 AS=0.406 AD=0.406
+ PS=3.38 PD=3.38
M$150 on \$105 \$44 VDD sky130_fd_pr__pfet_01v8 L=0.6 W=1.4 AS=0.406 AD=0.406
+ PS=3.38 PD=3.38
M$151 on \$105 \$44 VDD sky130_fd_pr__pfet_01v8 L=0.6 W=1.4 AS=0.406 AD=0.406
+ PS=3.38 PD=3.38
M$152 op \$105 \$43 VDD sky130_fd_pr__pfet_01v8 L=0.6 W=1.4 AS=0.406 AD=0.406
+ PS=3.38 PD=3.38
M$153 on \$105 \$44 VDD sky130_fd_pr__pfet_01v8 L=0.6 W=1.4 AS=0.406 AD=0.406
+ PS=3.38 PD=3.38
M$154 op \$105 \$43 VDD sky130_fd_pr__pfet_01v8 L=0.6 W=1.4 AS=0.406 AD=0.406
+ PS=3.38 PD=3.38
M$155 on \$105 \$44 VDD sky130_fd_pr__pfet_01v8 L=0.6 W=1.4 AS=0.406 AD=0.406
+ PS=3.38 PD=3.38
M$156 op \$105 \$43 VDD sky130_fd_pr__pfet_01v8 L=0.6 W=1.4 AS=0.406 AD=0.406
+ PS=3.38 PD=3.38
M$157 on \$105 \$44 VDD sky130_fd_pr__pfet_01v8 L=0.6 W=1.4 AS=0.406 AD=0.406
+ PS=3.38 PD=3.38
M$158 op \$105 \$43 VDD sky130_fd_pr__pfet_01v8 L=0.6 W=1.4 AS=0.406 AD=0.406
+ PS=3.38 PD=3.38
M$159 on \$105 \$44 VDD sky130_fd_pr__pfet_01v8 L=0.6 W=1.4 AS=0.406 AD=0.406
+ PS=3.38 PD=3.38
M$160 op \$105 \$43 VDD sky130_fd_pr__pfet_01v8 L=0.6 W=1.4 AS=0.406 AD=0.406
+ PS=3.38 PD=3.38
M$161 op \$105 \$43 VDD sky130_fd_pr__pfet_01v8 L=0.6 W=1.4 AS=0.406 AD=0.406
+ PS=3.38 PD=3.38
M$162 on \$105 \$44 VDD sky130_fd_pr__pfet_01v8 L=0.6 W=1.4 AS=0.406 AD=0.406
+ PS=3.38 PD=3.38
M$163 op \$105 \$43 VDD sky130_fd_pr__pfet_01v8 L=0.6 W=1.4 AS=0.406 AD=0.406
+ PS=3.38 PD=3.38
M$164 on \$105 \$44 VDD sky130_fd_pr__pfet_01v8 L=0.6 W=1.4 AS=0.406 AD=0.406
+ PS=3.38 PD=3.38
M$165 on \$105 \$44 VDD sky130_fd_pr__pfet_01v8 L=0.6 W=1.4 AS=0.406 AD=0.406
+ PS=3.38 PD=3.38
M$166 op \$105 \$43 VDD sky130_fd_pr__pfet_01v8 L=0.6 W=1.4 AS=0.406 AD=0.406
+ PS=3.38 PD=3.38
M$167 on \$105 \$44 VDD sky130_fd_pr__pfet_01v8 L=0.6 W=1.4 AS=0.406 AD=0.406
+ PS=3.38 PD=3.38
M$168 op \$105 \$43 VDD sky130_fd_pr__pfet_01v8 L=0.6 W=1.4 AS=0.406 AD=0.406
+ PS=3.38 PD=3.38
M$169 on \$105 \$44 VDD sky130_fd_pr__pfet_01v8 L=0.6 W=1.4 AS=0.406 AD=0.406
+ PS=3.38 PD=3.38
M$170 op \$105 \$43 VDD sky130_fd_pr__pfet_01v8 L=0.6 W=1.4 AS=0.406 AD=0.406
+ PS=3.38 PD=3.38
M$171 on \$105 \$44 VDD sky130_fd_pr__pfet_01v8 L=0.6 W=1.4 AS=0.406 AD=0.406
+ PS=3.38 PD=3.38
M$172 op \$105 \$43 VDD sky130_fd_pr__pfet_01v8 L=0.6 W=1.4 AS=0.406 AD=0.406
+ PS=3.38 PD=3.38
M$173 on \$105 \$44 VDD sky130_fd_pr__pfet_01v8 L=0.6 W=1.4 AS=0.406 AD=0.406
+ PS=3.38 PD=3.38
M$174 op \$105 \$43 VDD sky130_fd_pr__pfet_01v8 L=0.6 W=1.4 AS=0.406 AD=0.406
+ PS=3.38 PD=3.38
M$175 on \$105 \$44 VDD sky130_fd_pr__pfet_01v8 L=0.6 W=1.4 AS=0.406 AD=0.406
+ PS=3.38 PD=3.38
M$176 op \$105 \$43 VDD sky130_fd_pr__pfet_01v8 L=0.6 W=1.4 AS=0.406 AD=0.406
+ PS=3.38 PD=3.38
M$177 on \$105 \$44 VDD sky130_fd_pr__pfet_01v8 L=0.6 W=1.4 AS=0.406 AD=0.406
+ PS=3.38 PD=3.38
M$178 op \$105 \$43 VDD sky130_fd_pr__pfet_01v8 L=0.6 W=1.4 AS=0.406 AD=0.406
+ PS=3.38 PD=3.38
M$179 op \$105 \$43 VDD sky130_fd_pr__pfet_01v8 L=0.6 W=1.4 AS=0.406 AD=0.406
+ PS=3.38 PD=3.38
M$180 on \$105 \$44 VDD sky130_fd_pr__pfet_01v8 L=0.6 W=1.4 AS=0.406 AD=0.406
+ PS=3.38 PD=3.38
M$181 on VDD VDD VDD sky130_fd_pr__pfet_01v8 L=0.6 W=1.4 AS=0.406 AD=0.406
+ PS=3.38 PD=3.38
M$182 op VDD VDD VDD sky130_fd_pr__pfet_01v8 L=0.6 W=1.4 AS=0.406 AD=0.406
+ PS=3.38 PD=3.38
M$183 op VDD VDD VDD sky130_fd_pr__pfet_01v8 L=0.6 W=1.4 AS=0.406 AD=0.406
+ PS=3.38 PD=3.38
M$184 on VDD VDD VDD sky130_fd_pr__pfet_01v8 L=0.6 W=1.4 AS=0.406 AD=0.406
+ PS=3.38 PD=3.38
M$185 on VDD VDD VDD sky130_fd_pr__pfet_01v8 L=0.6 W=1.4 AS=0.406 AD=0.406
+ PS=3.38 PD=3.38
M$186 op VDD VDD VDD sky130_fd_pr__pfet_01v8 L=0.6 W=1.4 AS=0.406 AD=0.406
+ PS=3.38 PD=3.38
M$187 on VDD VDD VDD sky130_fd_pr__pfet_01v8 L=0.6 W=1.4 AS=0.406 AD=0.406
+ PS=3.38 PD=3.38
M$188 op VDD VDD VDD sky130_fd_pr__pfet_01v8 L=0.6 W=1.4 AS=0.406 AD=0.406
+ PS=3.38 PD=3.38
M$189 \$268 \$121 VDD VDD sky130_fd_pr__pfet_01v8_lvt L=0.6 W=1.4 AS=0.406
+ AD=0.406 PS=3.38 PD=3.38
M$190 \$284 \$121 VDD VDD sky130_fd_pr__pfet_01v8_lvt L=0.6 W=1.4 AS=0.406
+ AD=0.406 PS=3.38 PD=3.38
M$191 \$284 \$121 VDD VDD sky130_fd_pr__pfet_01v8_lvt L=0.6 W=1.4 AS=0.406
+ AD=0.406 PS=3.38 PD=3.38
M$192 \$318 \$121 VDD VDD sky130_fd_pr__pfet_01v8_lvt L=0.6 W=1.4 AS=0.406
+ AD=0.406 PS=3.38 PD=3.38
M$193 \$318 \$121 VDD VDD sky130_fd_pr__pfet_01v8_lvt L=0.6 W=1.4 AS=0.406
+ AD=0.406 PS=3.38 PD=3.38
M$194 \$284 \$121 VDD VDD sky130_fd_pr__pfet_01v8_lvt L=0.6 W=1.4 AS=0.406
+ AD=0.406 PS=3.38 PD=3.38
M$195 \$318 \$121 VDD VDD sky130_fd_pr__pfet_01v8_lvt L=0.6 W=1.4 AS=0.406
+ AD=0.406 PS=3.38 PD=3.38
M$196 \$268 \$121 VDD VDD sky130_fd_pr__pfet_01v8_lvt L=0.6 W=1.4 AS=0.406
+ AD=0.406 PS=3.38 PD=3.38
M$197 \$268 \$121 VDD VDD sky130_fd_pr__pfet_01v8_lvt L=0.6 W=1.4 AS=0.406
+ AD=0.406 PS=3.38 PD=3.38
M$198 \$318 \$121 VDD VDD sky130_fd_pr__pfet_01v8_lvt L=0.6 W=1.4 AS=0.406
+ AD=0.406 PS=3.38 PD=3.38
M$199 \$268 \$121 VDD VDD sky130_fd_pr__pfet_01v8_lvt L=0.6 W=1.4 AS=0.406
+ AD=0.406 PS=3.38 PD=3.38
M$200 \$318 \$121 VDD VDD sky130_fd_pr__pfet_01v8_lvt L=0.6 W=1.4 AS=0.406
+ AD=0.406 PS=3.38 PD=3.38
M$201 \$284 \$121 VDD VDD sky130_fd_pr__pfet_01v8_lvt L=0.6 W=1.4 AS=0.406
+ AD=0.406 PS=3.38 PD=3.38
M$202 \$284 \$121 VDD VDD sky130_fd_pr__pfet_01v8_lvt L=0.6 W=1.4 AS=0.406
+ AD=0.406 PS=3.38 PD=3.38
M$203 \$318 \$121 VDD VDD sky130_fd_pr__pfet_01v8_lvt L=0.6 W=1.4 AS=0.406
+ AD=0.406 PS=3.38 PD=3.38
M$204 \$268 \$121 VDD VDD sky130_fd_pr__pfet_01v8_lvt L=0.6 W=1.4 AS=0.406
+ AD=0.406 PS=3.38 PD=3.38
M$205 \$284 \$121 VDD VDD sky130_fd_pr__pfet_01v8_lvt L=0.6 W=1.4 AS=0.406
+ AD=0.406 PS=3.38 PD=3.38
M$206 \$268 \$121 VDD VDD sky130_fd_pr__pfet_01v8_lvt L=0.6 W=1.4 AS=0.406
+ AD=0.406 PS=3.38 PD=3.38
M$207 \$43 \$121 VDD VDD sky130_fd_pr__pfet_01v8_lvt L=0.6 W=1.4 AS=0.406
+ AD=0.406 PS=3.38 PD=3.38
M$208 \$44 \$121 VDD VDD sky130_fd_pr__pfet_01v8_lvt L=0.6 W=1.4 AS=0.406
+ AD=0.406 PS=3.38 PD=3.38
M$209 \$43 \$121 VDD VDD sky130_fd_pr__pfet_01v8_lvt L=0.6 W=1.4 AS=0.406
+ AD=0.406 PS=3.38 PD=3.38
M$210 \$44 \$121 VDD VDD sky130_fd_pr__pfet_01v8_lvt L=0.6 W=1.4 AS=0.406
+ AD=0.406 PS=3.38 PD=3.38
M$211 \$43 \$121 VDD VDD sky130_fd_pr__pfet_01v8_lvt L=0.6 W=1.4 AS=0.406
+ AD=0.406 PS=3.38 PD=3.38
M$212 \$44 \$121 VDD VDD sky130_fd_pr__pfet_01v8_lvt L=0.6 W=1.4 AS=0.406
+ AD=0.406 PS=3.38 PD=3.38
M$213 \$43 \$121 VDD VDD sky130_fd_pr__pfet_01v8_lvt L=0.6 W=1.4 AS=0.406
+ AD=0.406 PS=3.38 PD=3.38
M$214 \$43 \$121 VDD VDD sky130_fd_pr__pfet_01v8_lvt L=0.6 W=1.4 AS=0.406
+ AD=0.406 PS=3.38 PD=3.38
M$215 \$44 \$121 VDD VDD sky130_fd_pr__pfet_01v8_lvt L=0.6 W=1.4 AS=0.406
+ AD=0.406 PS=3.38 PD=3.38
M$216 \$43 \$121 VDD VDD sky130_fd_pr__pfet_01v8_lvt L=0.6 W=1.4 AS=0.406
+ AD=0.406 PS=3.38 PD=3.38
M$217 \$44 \$121 VDD VDD sky130_fd_pr__pfet_01v8_lvt L=0.6 W=1.4 AS=0.406
+ AD=0.406 PS=3.38 PD=3.38
M$218 \$43 \$121 VDD VDD sky130_fd_pr__pfet_01v8_lvt L=0.6 W=1.4 AS=0.406
+ AD=0.406 PS=3.38 PD=3.38
M$219 \$44 \$121 VDD VDD sky130_fd_pr__pfet_01v8_lvt L=0.6 W=1.4 AS=0.406
+ AD=0.406 PS=3.38 PD=3.38
M$220 \$43 \$121 VDD VDD sky130_fd_pr__pfet_01v8_lvt L=0.6 W=1.4 AS=0.406
+ AD=0.406 PS=3.38 PD=3.38
M$221 \$44 \$121 VDD VDD sky130_fd_pr__pfet_01v8_lvt L=0.6 W=1.4 AS=0.406
+ AD=0.406 PS=3.38 PD=3.38
M$222 \$44 \$121 VDD VDD sky130_fd_pr__pfet_01v8_lvt L=0.6 W=1.4 AS=0.406
+ AD=0.406 PS=3.38 PD=3.38
M$223 \$44 \$121 VDD VDD sky130_fd_pr__pfet_01v8_lvt L=0.6 W=1.4 AS=0.406
+ AD=0.406 PS=3.38 PD=3.38
M$224 \$43 \$121 VDD VDD sky130_fd_pr__pfet_01v8_lvt L=0.6 W=1.4 AS=0.406
+ AD=0.406 PS=3.38 PD=3.38
M$225 \$44 \$121 VDD VDD sky130_fd_pr__pfet_01v8_lvt L=0.6 W=1.4 AS=0.406
+ AD=0.406 PS=3.38 PD=3.38
M$226 \$43 \$121 VDD VDD sky130_fd_pr__pfet_01v8_lvt L=0.6 W=1.4 AS=0.406
+ AD=0.406 PS=3.38 PD=3.38
M$227 \$44 \$121 VDD VDD sky130_fd_pr__pfet_01v8_lvt L=0.6 W=1.4 AS=0.406
+ AD=0.406 PS=3.38 PD=3.38
M$228 \$43 \$121 VDD VDD sky130_fd_pr__pfet_01v8_lvt L=0.6 W=1.4 AS=0.406
+ AD=0.406 PS=3.38 PD=3.38
M$229 \$44 \$121 VDD VDD sky130_fd_pr__pfet_01v8_lvt L=0.6 W=1.4 AS=0.406
+ AD=0.406 PS=3.38 PD=3.38
M$230 \$43 \$121 VDD VDD sky130_fd_pr__pfet_01v8_lvt L=0.6 W=1.4 AS=0.406
+ AD=0.406 PS=3.38 PD=3.38
M$231 \$44 \$121 VDD VDD sky130_fd_pr__pfet_01v8_lvt L=0.6 W=1.4 AS=0.406
+ AD=0.406 PS=3.38 PD=3.38
M$232 \$44 \$121 VDD VDD sky130_fd_pr__pfet_01v8_lvt L=0.6 W=1.4 AS=0.406
+ AD=0.406 PS=3.38 PD=3.38
M$233 \$43 \$121 VDD VDD sky130_fd_pr__pfet_01v8_lvt L=0.6 W=1.4 AS=0.406
+ AD=0.406 PS=3.38 PD=3.38
M$234 \$44 \$121 VDD VDD sky130_fd_pr__pfet_01v8_lvt L=0.6 W=1.4 AS=0.406
+ AD=0.406 PS=3.38 PD=3.38
M$235 \$43 \$121 VDD VDD sky130_fd_pr__pfet_01v8_lvt L=0.6 W=1.4 AS=0.406
+ AD=0.406 PS=3.38 PD=3.38
M$236 \$44 \$121 VDD VDD sky130_fd_pr__pfet_01v8_lvt L=0.6 W=1.4 AS=0.406
+ AD=0.406 PS=3.38 PD=3.38
M$237 \$43 \$121 VDD VDD sky130_fd_pr__pfet_01v8_lvt L=0.6 W=1.4 AS=0.406
+ AD=0.406 PS=3.38 PD=3.38
M$238 \$43 \$121 VDD VDD sky130_fd_pr__pfet_01v8_lvt L=0.6 W=1.4 AS=0.406
+ AD=0.406 PS=3.38 PD=3.38
M$239 \$43 \$121 VDD VDD sky130_fd_pr__pfet_01v8_lvt L=0.6 W=1.4 AS=0.406
+ AD=0.406 PS=3.38 PD=3.38
M$240 \$44 \$121 VDD VDD sky130_fd_pr__pfet_01v8_lvt L=0.6 W=1.4 AS=0.406
+ AD=0.406 PS=3.38 PD=3.38
M$241 \$43 \$121 VDD VDD sky130_fd_pr__pfet_01v8_lvt L=0.6 W=1.4 AS=0.406
+ AD=0.406 PS=3.38 PD=3.38
M$242 \$43 \$121 VDD VDD sky130_fd_pr__pfet_01v8_lvt L=0.6 W=1.4 AS=0.406
+ AD=0.406 PS=3.38 PD=3.38
M$243 \$44 \$121 VDD VDD sky130_fd_pr__pfet_01v8_lvt L=0.6 W=1.4 AS=0.406
+ AD=0.406 PS=3.38 PD=3.38
M$244 \$43 \$121 VDD VDD sky130_fd_pr__pfet_01v8_lvt L=0.6 W=1.4 AS=0.406
+ AD=0.406 PS=3.38 PD=3.38
M$245 \$44 \$121 VDD VDD sky130_fd_pr__pfet_01v8_lvt L=0.6 W=1.4 AS=0.406
+ AD=0.406 PS=3.38 PD=3.38
M$246 \$43 \$121 VDD VDD sky130_fd_pr__pfet_01v8_lvt L=0.6 W=1.4 AS=0.406
+ AD=0.406 PS=3.38 PD=3.38
M$247 \$44 \$121 VDD VDD sky130_fd_pr__pfet_01v8_lvt L=0.6 W=1.4 AS=0.406
+ AD=0.406 PS=3.38 PD=3.38
M$248 \$43 \$121 VDD VDD sky130_fd_pr__pfet_01v8_lvt L=0.6 W=1.4 AS=0.406
+ AD=0.406 PS=3.38 PD=3.38
M$249 \$44 \$121 VDD VDD sky130_fd_pr__pfet_01v8_lvt L=0.6 W=1.4 AS=0.406
+ AD=0.406 PS=3.38 PD=3.38
M$250 \$43 \$121 VDD VDD sky130_fd_pr__pfet_01v8_lvt L=0.6 W=1.4 AS=0.406
+ AD=0.406 PS=3.38 PD=3.38
M$251 \$44 \$121 VDD VDD sky130_fd_pr__pfet_01v8_lvt L=0.6 W=1.4 AS=0.406
+ AD=0.406 PS=3.38 PD=3.38
M$252 \$43 \$121 VDD VDD sky130_fd_pr__pfet_01v8_lvt L=0.6 W=1.4 AS=0.406
+ AD=0.406 PS=3.38 PD=3.38
M$253 \$44 \$121 VDD VDD sky130_fd_pr__pfet_01v8_lvt L=0.6 W=1.4 AS=0.406
+ AD=0.406 PS=3.38 PD=3.38
M$254 \$44 \$121 VDD VDD sky130_fd_pr__pfet_01v8_lvt L=0.6 W=1.4 AS=0.406
+ AD=0.406 PS=3.38 PD=3.38
M$255 cm VDD VDD VDD sky130_fd_pr__pfet_01v8 L=0.6 W=1.4 AS=0.406 AD=0.406
+ PS=3.38 PD=3.38
M$256 \$121 VDD VDD VDD sky130_fd_pr__pfet_01v8 L=0.6 W=1.4 AS=0.406 AD=0.406
+ PS=3.38 PD=3.38
M$257 \$121 VDD VDD VDD sky130_fd_pr__pfet_01v8 L=0.6 W=1.4 AS=0.406 AD=0.406
+ PS=3.38 PD=3.38
M$258 \$229 VDD VDD VDD sky130_fd_pr__pfet_01v8 L=0.6 W=1.4 AS=0.406 AD=0.406
+ PS=3.38 PD=3.38
M$259 \$229 VDD VDD VDD sky130_fd_pr__pfet_01v8 L=0.6 W=1.4 AS=0.406 AD=0.406
+ PS=3.38 PD=3.38
M$260 cm VDD VDD VDD sky130_fd_pr__pfet_01v8 L=0.6 W=1.4 AS=0.406 AD=0.406
+ PS=3.38 PD=3.38
M$261 \$284 VDD VDD VDD sky130_fd_pr__pfet_01v8 L=0.6 W=1.4 AS=0.406 AD=0.406
+ PS=3.38 PD=3.38
M$262 \$268 \$268 \$268 VDD sky130_fd_pr__pfet_01v8 L=0.6 W=1.4 AS=0.406
+ AD=0.406 PS=3.38 PD=3.38
M$263 \$268 \$268 \$268 VDD sky130_fd_pr__pfet_01v8 L=0.6 W=1.4 AS=0.406
+ AD=0.406 PS=3.38 PD=3.38
M$264 \$318 \$318 \$318 VDD sky130_fd_pr__pfet_01v8 L=0.6 W=1.4 AS=0.406
+ AD=0.406 PS=3.38 PD=3.38
M$265 \$318 \$318 \$318 VDD sky130_fd_pr__pfet_01v8 L=0.6 W=1.4 AS=0.406
+ AD=0.406 PS=3.38 PD=3.38
M$266 \$284 VDD VDD VDD sky130_fd_pr__pfet_01v8 L=0.6 W=1.4 AS=0.406 AD=0.406
+ PS=3.38 PD=3.38
M$267 \$43 VDD VDD VDD sky130_fd_pr__pfet_01v8 L=0.6 W=1.4 AS=0.406 AD=0.406
+ PS=3.38 PD=3.38
M$268 \$43 VDD VDD VDD sky130_fd_pr__pfet_01v8 L=0.6 W=1.4 AS=0.406 AD=0.406
+ PS=3.38 PD=3.38
M$269 \$44 \$44 \$44 VDD sky130_fd_pr__pfet_01v8 L=0.6 W=1.4 AS=0.406 AD=0.406
+ PS=3.38 PD=3.38
M$270 VDD VDD VDD VDD sky130_fd_pr__pfet_01v8 L=0.6 W=1.4 AS=0.406 AD=0.406
+ PS=3.38 PD=3.38
M$271 \$44 VDD VDD VDD sky130_fd_pr__pfet_01v8 L=0.6 W=1.4 AS=0.406 AD=0.406
+ PS=3.38 PD=3.38
M$272 \$44 VDD VDD VDD sky130_fd_pr__pfet_01v8 L=0.6 W=1.4 AS=0.406 AD=0.406
+ PS=3.38 PD=3.38
M$273 VDD VDD VDD VDD sky130_fd_pr__pfet_01v8 L=0.6 W=1.4 AS=0.406 AD=0.406
+ PS=3.38 PD=3.38
M$274 VDD VDD VDD VDD sky130_fd_pr__pfet_01v8 L=0.6 W=1.4 AS=0.406 AD=0.406
+ PS=3.38 PD=3.38
M$275 \$43 \$43 \$43 VDD sky130_fd_pr__pfet_01v8 L=0.6 W=1.4 AS=0.406 AD=0.406
+ PS=3.38 PD=3.38
M$276 \$43 \$43 \$43 VDD sky130_fd_pr__pfet_01v8 L=0.6 W=1.4 AS=0.406 AD=0.406
+ PS=3.38 PD=3.38
M$277 VDD VDD VDD VDD sky130_fd_pr__pfet_01v8 L=0.6 W=1.4 AS=0.406 AD=0.406
+ PS=3.38 PD=3.38
M$278 \$44 \$44 \$44 VDD sky130_fd_pr__pfet_01v8 L=0.6 W=1.4 AS=0.406 AD=0.406
+ PS=3.38 PD=3.38
M$279 VSS VSS VSS sky130_gnd sky130_fd_pr__nfet_01v8 L=0.6 W=1.4 AS=0.406
+ AD=0.406 PS=3.38 PD=3.38
M$280 VSS VSS VSS sky130_gnd sky130_fd_pr__nfet_01v8 L=0.6 W=1.4 AS=0.406
+ AD=0.406 PS=3.38 PD=3.38
M$281 VSS VSS VSS sky130_gnd sky130_fd_pr__nfet_01v8 L=0.6 W=1.4 AS=0.406
+ AD=0.406 PS=3.38 PD=3.38
M$282 VSS VSS VSS sky130_gnd sky130_fd_pr__nfet_01v8 L=0.6 W=1.4 AS=0.406
+ AD=0.406 PS=3.38 PD=3.38
M$283 VSS VSS VSS sky130_gnd sky130_fd_pr__nfet_01v8 L=0.6 W=1.4 AS=0.406
+ AD=0.406 PS=3.38 PD=3.38
M$284 VSS VSS VSS sky130_gnd sky130_fd_pr__nfet_01v8 L=0.6 W=1.4 AS=0.406
+ AD=0.406 PS=3.38 PD=3.38
M$285 VSS VSS VSS sky130_gnd sky130_fd_pr__nfet_01v8 L=0.6 W=1.4 AS=0.406
+ AD=0.406 PS=3.38 PD=3.38
M$286 VSS VSS VSS sky130_gnd sky130_fd_pr__nfet_01v8 L=0.6 W=1.4 AS=0.406
+ AD=0.406 PS=3.38 PD=3.38
M$287 VSS VSS VSS sky130_gnd sky130_fd_pr__nfet_01v8 L=0.6 W=1.4 AS=0.406
+ AD=0.406 PS=3.38 PD=3.38
M$288 VSS VSS VSS sky130_gnd sky130_fd_pr__nfet_01v8 L=0.6 W=1.4 AS=0.406
+ AD=0.406 PS=3.38 PD=3.38
M$289 VSS VSS VSS sky130_gnd sky130_fd_pr__nfet_01v8 L=0.6 W=1.4 AS=0.406
+ AD=0.406 PS=3.38 PD=3.38
M$290 VSS VSS VSS sky130_gnd sky130_fd_pr__nfet_01v8 L=0.6 W=1.4 AS=0.406
+ AD=0.406 PS=3.38 PD=3.38
M$291 VSS VSS VSS sky130_gnd sky130_fd_pr__nfet_01v8 L=0.6 W=1.4 AS=0.406
+ AD=0.406 PS=3.38 PD=3.38
M$292 VSS VSS VSS sky130_gnd sky130_fd_pr__nfet_01v8 L=0.6 W=1.4 AS=0.406
+ AD=0.406 PS=3.38 PD=3.38
M$293 VSS VSS VSS sky130_gnd sky130_fd_pr__nfet_01v8 L=0.6 W=1.4 AS=0.406
+ AD=0.406 PS=3.38 PD=3.38
M$294 VSS VSS VSS sky130_gnd sky130_fd_pr__nfet_01v8 L=0.6 W=1.4 AS=0.406
+ AD=0.406 PS=3.38 PD=3.38
M$295 VSS VSS VSS sky130_gnd sky130_fd_pr__nfet_01v8 L=0.6 W=1.4 AS=0.406
+ AD=0.406 PS=3.38 PD=3.38
M$296 VSS VSS VSS sky130_gnd sky130_fd_pr__nfet_01v8 L=0.6 W=1.4 AS=0.406
+ AD=0.406 PS=3.38 PD=3.38
M$297 VSS VSS VSS sky130_gnd sky130_fd_pr__nfet_01v8 L=0.6 W=1.4 AS=0.406
+ AD=0.406 PS=3.38 PD=3.38
M$298 VSS VSS VSS sky130_gnd sky130_fd_pr__nfet_01v8 L=0.6 W=1.4 AS=0.406
+ AD=0.406 PS=3.38 PD=3.38
M$299 VSS VSS VSS sky130_gnd sky130_fd_pr__nfet_01v8 L=0.6 W=1.4 AS=0.406
+ AD=0.406 PS=3.38 PD=3.38
M$300 VSS VSS VSS sky130_gnd sky130_fd_pr__nfet_01v8 L=0.6 W=1.4 AS=0.406
+ AD=0.406 PS=3.38 PD=3.38
M$301 VSS VSS VSS sky130_gnd sky130_fd_pr__nfet_01v8 L=0.6 W=1.4 AS=0.406
+ AD=0.406 PS=3.38 PD=3.38
M$302 VSS VSS VSS sky130_gnd sky130_fd_pr__nfet_01v8 L=0.6 W=1.4 AS=0.406
+ AD=0.406 PS=3.38 PD=3.38
M$303 VSS VSS VSS sky130_gnd sky130_fd_pr__nfet_01v8 L=0.6 W=1.4 AS=0.406
+ AD=0.406 PS=3.38 PD=3.38
M$304 bias_a bias_a bias_a sky130_gnd sky130_fd_pr__nfet_01v8 L=0.6 W=1.4
+ AS=0.406 AD=0.406 PS=3.38 PD=3.38
M$305 bias_a bias_a bias_a sky130_gnd sky130_fd_pr__nfet_01v8 L=0.6 W=1.4
+ AS=0.406 AD=0.406 PS=3.38 PD=3.38
M$306 bias_a bias_a bias_a sky130_gnd sky130_fd_pr__nfet_01v8 L=0.6 W=1.4
+ AS=0.406 AD=0.406 PS=3.38 PD=3.38
M$307 bias_a bias_a bias_a sky130_gnd sky130_fd_pr__nfet_01v8 L=0.6 W=1.4
+ AS=0.406 AD=0.406 PS=3.38 PD=3.38
M$308 \$120 \$120 \$120 sky130_gnd sky130_fd_pr__nfet_01v8 L=0.6 W=1.4 AS=0.406
+ AD=0.406 PS=3.38 PD=3.38
M$309 \$120 \$120 \$120 sky130_gnd sky130_fd_pr__nfet_01v8 L=0.6 W=1.4 AS=0.406
+ AD=0.406 PS=3.38 PD=3.38
M$310 \$120 \$120 \$120 sky130_gnd sky130_fd_pr__nfet_01v8 L=0.6 W=1.4 AS=0.406
+ AD=0.406 PS=3.38 PD=3.38
M$311 \$120 \$120 \$120 sky130_gnd sky130_fd_pr__nfet_01v8 L=0.6 W=1.4 AS=0.406
+ AD=0.406 PS=3.38 PD=3.38
M$312 \$120 \$120 \$120 sky130_gnd sky130_fd_pr__nfet_01v8 L=0.6 W=1.4 AS=0.406
+ AD=0.406 PS=3.38 PD=3.38
M$313 \$120 \$120 \$120 sky130_gnd sky130_fd_pr__nfet_01v8 L=0.6 W=1.4 AS=0.406
+ AD=0.406 PS=3.38 PD=3.38
M$314 \$120 VSS VSS sky130_gnd sky130_fd_pr__nfet_01v8 L=0.6 W=1.4 AS=0.406
+ AD=0.406 PS=3.38 PD=3.38
M$315 \$120 VSS VSS sky130_gnd sky130_fd_pr__nfet_01v8 L=0.6 W=1.4 AS=0.406
+ AD=0.406 PS=3.38 PD=3.38
M$316 \$120 VSS VSS sky130_gnd sky130_fd_pr__nfet_01v8 L=0.6 W=1.4 AS=0.406
+ AD=0.406 PS=3.38 PD=3.38
M$317 \$120 VSS VSS sky130_gnd sky130_fd_pr__nfet_01v8 L=0.6 W=1.4 AS=0.406
+ AD=0.406 PS=3.38 PD=3.38
M$318 \$120 VSS VSS sky130_gnd sky130_fd_pr__nfet_01v8 L=0.6 W=1.4 AS=0.406
+ AD=0.406 PS=3.38 PD=3.38
M$319 \$120 VSS VSS sky130_gnd sky130_fd_pr__nfet_01v8 L=0.6 W=1.4 AS=0.406
+ AD=0.406 PS=3.38 PD=3.38
M$320 \$19 VSS VSS sky130_gnd sky130_fd_pr__nfet_01v8 L=0.6 W=1.4 AS=0.406
+ AD=0.406 PS=3.38 PD=3.38
M$321 \$19 VSS VSS sky130_gnd sky130_fd_pr__nfet_01v8 L=0.6 W=1.4 AS=0.406
+ AD=0.406 PS=3.38 PD=3.38
M$322 \$19 VSS VSS sky130_gnd sky130_fd_pr__nfet_01v8 L=0.6 W=1.4 AS=0.406
+ AD=0.406 PS=3.38 PD=3.38
M$323 \$19 VSS VSS sky130_gnd sky130_fd_pr__nfet_01v8 L=0.6 W=1.4 AS=0.406
+ AD=0.406 PS=3.38 PD=3.38
M$324 \$19 VSS VSS sky130_gnd sky130_fd_pr__nfet_01v8 L=0.6 W=1.4 AS=0.406
+ AD=0.406 PS=3.38 PD=3.38
M$325 \$19 VSS VSS sky130_gnd sky130_fd_pr__nfet_01v8 L=0.6 W=1.4 AS=0.406
+ AD=0.406 PS=3.38 PD=3.38
M$326 VSS VSS VSS sky130_gnd sky130_fd_pr__nfet_01v8 L=0.6 W=1.4 AS=0.406
+ AD=0.406 PS=3.38 PD=3.38
M$327 VSS VSS VSS sky130_gnd sky130_fd_pr__nfet_01v8 L=0.6 W=1.4 AS=0.406
+ AD=0.406 PS=3.38 PD=3.38
M$328 \$1 \$1 \$1 sky130_gnd sky130_fd_pr__nfet_01v8 L=0.6 W=1.4 AS=0.406
+ AD=0.406 PS=3.38 PD=3.38
M$329 \$1 \$1 \$1 sky130_gnd sky130_fd_pr__nfet_01v8 L=0.6 W=1.4 AS=0.406
+ AD=0.406 PS=3.38 PD=3.38
M$330 \$1 \$1 \$1 sky130_gnd sky130_fd_pr__nfet_01v8 L=0.6 W=1.4 AS=0.406
+ AD=0.406 PS=3.38 PD=3.38
M$331 \$1 \$1 \$1 sky130_gnd sky130_fd_pr__nfet_01v8 L=0.6 W=1.4 AS=0.406
+ AD=0.406 PS=3.38 PD=3.38
M$332 \$1 \$1 \$1 sky130_gnd sky130_fd_pr__nfet_01v8 L=0.6 W=1.4 AS=0.406
+ AD=0.406 PS=3.38 PD=3.38
M$333 \$1 \$1 \$1 sky130_gnd sky130_fd_pr__nfet_01v8 L=0.6 W=1.4 AS=0.406
+ AD=0.406 PS=3.38 PD=3.38
M$334 \$131 \$131 \$131 sky130_gnd sky130_fd_pr__nfet_01v8 L=0.6 W=1.4 AS=0.406
+ AD=0.406 PS=3.38 PD=3.38
M$335 \$131 \$131 \$131 sky130_gnd sky130_fd_pr__nfet_01v8 L=0.6 W=1.4 AS=0.406
+ AD=0.406 PS=3.38 PD=3.38
M$336 \$131 \$131 \$131 sky130_gnd sky130_fd_pr__nfet_01v8 L=0.6 W=1.4 AS=0.406
+ AD=0.406 PS=3.38 PD=3.38
M$337 \$131 \$131 \$131 sky130_gnd sky130_fd_pr__nfet_01v8 L=0.6 W=1.4 AS=0.406
+ AD=0.406 PS=3.38 PD=3.38
M$338 \$131 \$131 \$131 sky130_gnd sky130_fd_pr__nfet_01v8 L=0.6 W=1.4 AS=0.406
+ AD=0.406 PS=3.38 PD=3.38
M$339 \$131 \$131 \$131 sky130_gnd sky130_fd_pr__nfet_01v8 L=0.6 W=1.4 AS=0.406
+ AD=0.406 PS=3.38 PD=3.38
M$340 \$131 \$131 \$131 sky130_gnd sky130_fd_pr__nfet_01v8 L=0.6 W=1.4 AS=0.406
+ AD=0.406 PS=3.38 PD=3.38
M$341 \$131 \$131 \$131 sky130_gnd sky130_fd_pr__nfet_01v8 L=0.6 W=1.4 AS=0.406
+ AD=0.406 PS=3.38 PD=3.38
M$342 cm cm cm sky130_gnd sky130_fd_pr__nfet_01v8 L=0.6 W=1.4 AS=0.406 AD=0.406
+ PS=3.38 PD=3.38
M$343 cm cm cm sky130_gnd sky130_fd_pr__nfet_01v8 L=0.6 W=1.4 AS=0.406 AD=0.406
+ PS=3.38 PD=3.38
M$344 cm cm cm sky130_gnd sky130_fd_pr__nfet_01v8 L=0.6 W=1.4 AS=0.406 AD=0.406
+ PS=3.38 PD=3.38
M$345 cm cm cm sky130_gnd sky130_fd_pr__nfet_01v8 L=0.6 W=1.4 AS=0.406 AD=0.406
+ PS=3.38 PD=3.38
M$346 cm cm cm sky130_gnd sky130_fd_pr__nfet_01v8 L=0.6 W=1.4 AS=0.406 AD=0.406
+ PS=3.38 PD=3.38
M$347 cm cm cm sky130_gnd sky130_fd_pr__nfet_01v8 L=0.6 W=1.4 AS=0.406 AD=0.406
+ PS=3.38 PD=3.38
M$348 cm cm cm sky130_gnd sky130_fd_pr__nfet_01v8 L=0.6 W=1.4 AS=0.406 AD=0.406
+ PS=3.38 PD=3.38
M$349 cm cm cm sky130_gnd sky130_fd_pr__nfet_01v8 L=0.6 W=1.4 AS=0.406 AD=0.406
+ PS=3.38 PD=3.38
M$350 \$35 VSS VSS sky130_gnd sky130_fd_pr__nfet_01v8 L=0.6 W=1.4 AS=0.406
+ AD=0.406 PS=3.38 PD=3.38
M$351 \$35 VSS VSS sky130_gnd sky130_fd_pr__nfet_01v8 L=0.6 W=1.4 AS=0.406
+ AD=0.406 PS=3.38 PD=3.38
M$352 \$35 VSS VSS sky130_gnd sky130_fd_pr__nfet_01v8 L=0.6 W=1.4 AS=0.406
+ AD=0.406 PS=3.38 PD=3.38
M$353 \$35 VSS VSS sky130_gnd sky130_fd_pr__nfet_01v8 L=0.6 W=1.4 AS=0.406
+ AD=0.406 PS=3.38 PD=3.38
M$354 \$35 VSS VSS sky130_gnd sky130_fd_pr__nfet_01v8 L=0.6 W=1.4 AS=0.406
+ AD=0.406 PS=3.38 PD=3.38
M$355 \$35 VSS VSS sky130_gnd sky130_fd_pr__nfet_01v8 L=0.6 W=1.4 AS=0.406
+ AD=0.406 PS=3.38 PD=3.38
M$356 \$35 VSS VSS sky130_gnd sky130_fd_pr__nfet_01v8 L=0.6 W=1.4 AS=0.406
+ AD=0.406 PS=3.38 PD=3.38
M$357 \$35 VSS VSS sky130_gnd sky130_fd_pr__nfet_01v8 L=0.6 W=1.4 AS=0.406
+ AD=0.406 PS=3.38 PD=3.38
M$358 \$229 \$229 \$131 sky130_gnd sky130_fd_pr__nfet_01v8 L=0.6 W=1.4 AS=0.406
+ AD=0.406 PS=3.38 PD=3.38
M$359 \$229 \$229 \$131 sky130_gnd sky130_fd_pr__nfet_01v8 L=0.6 W=1.4 AS=0.406
+ AD=0.406 PS=3.38 PD=3.38
M$360 \$229 \$229 \$131 sky130_gnd sky130_fd_pr__nfet_01v8 L=0.6 W=1.4 AS=0.406
+ AD=0.406 PS=3.38 PD=3.38
M$361 \$229 \$229 \$131 sky130_gnd sky130_fd_pr__nfet_01v8 L=0.6 W=1.4 AS=0.406
+ AD=0.406 PS=3.38 PD=3.38
M$362 \$229 \$229 \$131 sky130_gnd sky130_fd_pr__nfet_01v8 L=0.6 W=1.4 AS=0.406
+ AD=0.406 PS=3.38 PD=3.38
M$363 \$229 \$229 \$131 sky130_gnd sky130_fd_pr__nfet_01v8 L=0.6 W=1.4 AS=0.406
+ AD=0.406 PS=3.38 PD=3.38
M$364 \$229 \$229 \$131 sky130_gnd sky130_fd_pr__nfet_01v8 L=0.6 W=1.4 AS=0.406
+ AD=0.406 PS=3.38 PD=3.38
M$365 \$229 \$229 \$131 sky130_gnd sky130_fd_pr__nfet_01v8 L=0.6 W=1.4 AS=0.406
+ AD=0.406 PS=3.38 PD=3.38
M$366 \$229 \$229 \$131 sky130_gnd sky130_fd_pr__nfet_01v8 L=0.6 W=1.4 AS=0.406
+ AD=0.406 PS=3.38 PD=3.38
M$367 \$229 \$229 \$131 sky130_gnd sky130_fd_pr__nfet_01v8 L=0.6 W=1.4 AS=0.406
+ AD=0.406 PS=3.38 PD=3.38
M$368 \$229 \$229 \$131 sky130_gnd sky130_fd_pr__nfet_01v8 L=0.6 W=1.4 AS=0.406
+ AD=0.406 PS=3.38 PD=3.38
M$369 \$229 \$229 \$131 sky130_gnd sky130_fd_pr__nfet_01v8 L=0.6 W=1.4 AS=0.406
+ AD=0.406 PS=3.38 PD=3.38
M$370 \$229 \$229 \$131 sky130_gnd sky130_fd_pr__nfet_01v8 L=0.6 W=1.4 AS=0.406
+ AD=0.406 PS=3.38 PD=3.38
M$371 \$229 \$229 \$131 sky130_gnd sky130_fd_pr__nfet_01v8 L=0.6 W=1.4 AS=0.406
+ AD=0.406 PS=3.38 PD=3.38
M$372 \$229 \$229 \$131 sky130_gnd sky130_fd_pr__nfet_01v8 L=0.6 W=1.4 AS=0.406
+ AD=0.406 PS=3.38 PD=3.38
M$373 \$229 \$229 \$131 sky130_gnd sky130_fd_pr__nfet_01v8 L=0.6 W=1.4 AS=0.406
+ AD=0.406 PS=3.38 PD=3.38
M$374 \$229 \$229 \$131 sky130_gnd sky130_fd_pr__nfet_01v8 L=0.6 W=1.4 AS=0.406
+ AD=0.406 PS=3.38 PD=3.38
M$375 \$229 \$229 \$131 sky130_gnd sky130_fd_pr__nfet_01v8 L=0.6 W=1.4 AS=0.406
+ AD=0.406 PS=3.38 PD=3.38
M$376 \$229 \$229 \$131 sky130_gnd sky130_fd_pr__nfet_01v8 L=0.6 W=1.4 AS=0.406
+ AD=0.406 PS=3.38 PD=3.38
M$377 \$229 \$229 \$131 sky130_gnd sky130_fd_pr__nfet_01v8 L=0.6 W=1.4 AS=0.406
+ AD=0.406 PS=3.38 PD=3.38
M$378 \$229 \$229 \$131 sky130_gnd sky130_fd_pr__nfet_01v8 L=0.6 W=1.4 AS=0.406
+ AD=0.406 PS=3.38 PD=3.38
M$379 \$229 \$229 \$131 sky130_gnd sky130_fd_pr__nfet_01v8 L=0.6 W=1.4 AS=0.406
+ AD=0.406 PS=3.38 PD=3.38
M$380 \$229 \$229 \$131 sky130_gnd sky130_fd_pr__nfet_01v8 L=0.6 W=1.4 AS=0.406
+ AD=0.406 PS=3.38 PD=3.38
M$381 \$229 \$229 \$131 sky130_gnd sky130_fd_pr__nfet_01v8 L=0.6 W=1.4 AS=0.406
+ AD=0.406 PS=3.38 PD=3.38
M$382 \$229 \$229 \$131 sky130_gnd sky130_fd_pr__nfet_01v8 L=0.6 W=1.4 AS=0.406
+ AD=0.406 PS=3.38 PD=3.38
M$383 \$229 \$229 \$131 sky130_gnd sky130_fd_pr__nfet_01v8 L=0.6 W=1.4 AS=0.406
+ AD=0.406 PS=3.38 PD=3.38
M$384 \$229 \$229 \$131 sky130_gnd sky130_fd_pr__nfet_01v8 L=0.6 W=1.4 AS=0.406
+ AD=0.406 PS=3.38 PD=3.38
M$385 \$229 \$229 \$131 sky130_gnd sky130_fd_pr__nfet_01v8 L=0.6 W=1.4 AS=0.406
+ AD=0.406 PS=3.38 PD=3.38
M$386 \$229 \$229 \$131 sky130_gnd sky130_fd_pr__nfet_01v8 L=0.6 W=1.4 AS=0.406
+ AD=0.406 PS=3.38 PD=3.38
M$387 \$229 \$229 \$131 sky130_gnd sky130_fd_pr__nfet_01v8 L=0.6 W=1.4 AS=0.406
+ AD=0.406 PS=3.38 PD=3.38
M$388 \$229 \$229 \$131 sky130_gnd sky130_fd_pr__nfet_01v8 L=0.6 W=1.4 AS=0.406
+ AD=0.406 PS=3.38 PD=3.38
M$389 \$229 \$229 \$131 sky130_gnd sky130_fd_pr__nfet_01v8 L=0.6 W=1.4 AS=0.406
+ AD=0.406 PS=3.38 PD=3.38
M$390 \$229 \$229 \$131 sky130_gnd sky130_fd_pr__nfet_01v8 L=0.6 W=1.4 AS=0.406
+ AD=0.406 PS=3.38 PD=3.38
M$391 \$229 \$229 \$131 sky130_gnd sky130_fd_pr__nfet_01v8 L=0.6 W=1.4 AS=0.406
+ AD=0.406 PS=3.38 PD=3.38
M$392 \$229 \$229 \$131 sky130_gnd sky130_fd_pr__nfet_01v8 L=0.6 W=1.4 AS=0.406
+ AD=0.406 PS=3.38 PD=3.38
M$393 \$229 \$229 \$131 sky130_gnd sky130_fd_pr__nfet_01v8 L=0.6 W=1.4 AS=0.406
+ AD=0.406 PS=3.38 PD=3.38
M$394 \$229 \$229 \$131 sky130_gnd sky130_fd_pr__nfet_01v8 L=0.6 W=1.4 AS=0.406
+ AD=0.406 PS=3.38 PD=3.38
M$395 \$229 \$229 \$131 sky130_gnd sky130_fd_pr__nfet_01v8 L=0.6 W=1.4 AS=0.406
+ AD=0.406 PS=3.38 PD=3.38
M$396 \$229 \$229 \$131 sky130_gnd sky130_fd_pr__nfet_01v8 L=0.6 W=1.4 AS=0.406
+ AD=0.406 PS=3.38 PD=3.38
M$397 \$229 \$229 \$131 sky130_gnd sky130_fd_pr__nfet_01v8 L=0.6 W=1.4 AS=0.406
+ AD=0.406 PS=3.38 PD=3.38
M$398 \$229 \$229 \$131 sky130_gnd sky130_fd_pr__nfet_01v8 L=0.6 W=1.4 AS=0.406
+ AD=0.406 PS=3.38 PD=3.38
M$399 \$229 \$229 \$131 sky130_gnd sky130_fd_pr__nfet_01v8 L=0.6 W=1.4 AS=0.406
+ AD=0.406 PS=3.38 PD=3.38
M$400 \$229 \$229 \$131 sky130_gnd sky130_fd_pr__nfet_01v8 L=0.6 W=1.4 AS=0.406
+ AD=0.406 PS=3.38 PD=3.38
M$401 \$229 \$229 \$131 sky130_gnd sky130_fd_pr__nfet_01v8 L=0.6 W=1.4 AS=0.406
+ AD=0.406 PS=3.38 PD=3.38
M$402 \$229 \$229 \$131 sky130_gnd sky130_fd_pr__nfet_01v8 L=0.6 W=1.4 AS=0.406
+ AD=0.406 PS=3.38 PD=3.38
M$403 \$229 \$229 \$131 sky130_gnd sky130_fd_pr__nfet_01v8 L=0.6 W=1.4 AS=0.406
+ AD=0.406 PS=3.38 PD=3.38
M$404 \$229 \$229 \$131 sky130_gnd sky130_fd_pr__nfet_01v8 L=0.6 W=1.4 AS=0.406
+ AD=0.406 PS=3.38 PD=3.38
M$405 \$229 \$229 \$131 sky130_gnd sky130_fd_pr__nfet_01v8 L=0.6 W=1.4 AS=0.406
+ AD=0.406 PS=3.38 PD=3.38
M$406 \$229 \$229 \$131 sky130_gnd sky130_fd_pr__nfet_01v8 L=0.6 W=1.4 AS=0.406
+ AD=0.406 PS=3.38 PD=3.38
M$407 \$229 \$229 \$131 sky130_gnd sky130_fd_pr__nfet_01v8 L=0.6 W=1.4 AS=0.406
+ AD=0.406 PS=3.38 PD=3.38
M$408 VSS VSS VSS sky130_gnd sky130_fd_pr__nfet_01v8 L=0.6 W=1.4 AS=0.406
+ AD=0.406 PS=3.38 PD=3.38
M$409 VSS VSS VSS sky130_gnd sky130_fd_pr__nfet_01v8 L=0.6 W=1.4 AS=0.406
+ AD=0.406 PS=3.38 PD=3.38
M$410 \$5.x1_net12 cm VSS sky130_gnd sky130_fd_pr__nfet_01v8 L=0.6 W=1.4
+ AS=0.406 AD=0.406 PS=3.38 PD=3.38
M$411 \$5.x1_net9 cm VSS sky130_gnd sky130_fd_pr__nfet_01v8 L=0.6 W=1.4
+ AS=0.406 AD=0.406 PS=3.38 PD=3.38
M$412 \$5.x1_net6 cm VSS sky130_gnd sky130_fd_pr__nfet_01v8 L=0.6 W=1.4
+ AS=0.406 AD=0.406 PS=3.38 PD=3.38
M$413 \$5.x1_net3 cm VSS sky130_gnd sky130_fd_pr__nfet_01v8 L=0.6 W=1.4
+ AS=0.406 AD=0.406 PS=3.38 PD=3.38
M$414 \$5.x1_net15 cm VSS sky130_gnd sky130_fd_pr__nfet_01v8 L=0.6 W=1.4
+ AS=0.406 AD=0.406 PS=3.38 PD=3.38
M$415 \$5.x1_net1 cm \$5.x1_net2 sky130_gnd sky130_fd_pr__nfet_01v8 L=0.6 W=1.4
+ AS=0.406 AD=0.406 PS=3.38 PD=3.38
M$416 \$5.x1_net2 cm \$5.x1_net3 sky130_gnd sky130_fd_pr__nfet_01v8 L=0.6 W=1.4
+ AS=0.406 AD=0.406 PS=3.38 PD=3.38
M$417 \$5.x1_net13 cm \$5.x1_net14 sky130_gnd sky130_fd_pr__nfet_01v8 L=0.6
+ W=1.4 AS=0.406 AD=0.406 PS=3.38 PD=3.38
M$418 \$5.x1_net14 cm \$5.x1_net15 sky130_gnd sky130_fd_pr__nfet_01v8 L=0.6
+ W=1.4 AS=0.406 AD=0.406 PS=3.38 PD=3.38
M$419 \$5.x1_net4 cm \$5.x1_net5 sky130_gnd sky130_fd_pr__nfet_01v8 L=0.6 W=1.4
+ AS=0.406 AD=0.406 PS=3.38 PD=3.38
M$420 \$5.x1_net5 cm \$5.x1_net6 sky130_gnd sky130_fd_pr__nfet_01v8 L=0.6 W=1.4
+ AS=0.406 AD=0.406 PS=3.38 PD=3.38
M$421 \$5.x1_net7 cm \$5.x1_net8 sky130_gnd sky130_fd_pr__nfet_01v8 L=0.6 W=1.4
+ AS=0.406 AD=0.406 PS=3.38 PD=3.38
M$422 \$5.x1_net8 cm \$5.x1_net9 sky130_gnd sky130_fd_pr__nfet_01v8 L=0.6 W=1.4
+ AS=0.406 AD=0.406 PS=3.38 PD=3.38
M$423 \$5.x1_net10 cm \$5.x1_net11 sky130_gnd sky130_fd_pr__nfet_01v8 L=0.6
+ W=1.4 AS=0.406 AD=0.406 PS=3.38 PD=3.38
M$424 \$5.x1_net11 cm \$5.x1_net12 sky130_gnd sky130_fd_pr__nfet_01v8 L=0.6
+ W=1.4 AS=0.406 AD=0.406 PS=3.38 PD=3.38
M$425 cm cm \$5.x1_net1 sky130_gnd sky130_fd_pr__nfet_01v8 L=0.6 W=1.4 AS=0.406
+ AD=0.406 PS=3.38 PD=3.38
M$426 cm cm \$5.x1_net13 sky130_gnd sky130_fd_pr__nfet_01v8 L=0.6 W=1.4
+ AS=0.406 AD=0.406 PS=3.38 PD=3.38
M$427 cm cm \$5.x1_net4 sky130_gnd sky130_fd_pr__nfet_01v8 L=0.6 W=1.4 AS=0.406
+ AD=0.406 PS=3.38 PD=3.38
M$428 cm cm \$5.x1_net7 sky130_gnd sky130_fd_pr__nfet_01v8 L=0.6 W=1.4 AS=0.406
+ AD=0.406 PS=3.38 PD=3.38
M$429 cm cm \$5.x1_net10 sky130_gnd sky130_fd_pr__nfet_01v8 L=0.6 W=1.4
+ AS=0.406 AD=0.406 PS=3.38 PD=3.38
M$430 \$120 bias_a VSS sky130_gnd sky130_fd_pr__nfet_01v8 L=0.6 W=1.4 AS=0.406
+ AD=0.406 PS=3.38 PD=3.38
M$431 \$120 bias_a VSS sky130_gnd sky130_fd_pr__nfet_01v8 L=0.6 W=1.4 AS=0.406
+ AD=0.406 PS=3.38 PD=3.38
M$432 \$120 bias_a VSS sky130_gnd sky130_fd_pr__nfet_01v8 L=0.6 W=1.4 AS=0.406
+ AD=0.406 PS=3.38 PD=3.38
M$433 \$120 bias_a VSS sky130_gnd sky130_fd_pr__nfet_01v8 L=0.6 W=1.4 AS=0.406
+ AD=0.406 PS=3.38 PD=3.38
M$434 \$120 bias_a VSS sky130_gnd sky130_fd_pr__nfet_01v8 L=0.6 W=1.4 AS=0.406
+ AD=0.406 PS=3.38 PD=3.38
M$435 \$120 bias_a VSS sky130_gnd sky130_fd_pr__nfet_01v8 L=0.6 W=1.4 AS=0.406
+ AD=0.406 PS=3.38 PD=3.38
M$436 \$120 bias_a VSS sky130_gnd sky130_fd_pr__nfet_01v8 L=0.6 W=1.4 AS=0.406
+ AD=0.406 PS=3.38 PD=3.38
M$437 \$120 bias_a VSS sky130_gnd sky130_fd_pr__nfet_01v8 L=0.6 W=1.4 AS=0.406
+ AD=0.406 PS=3.38 PD=3.38
M$438 \$120 bias_a VSS sky130_gnd sky130_fd_pr__nfet_01v8 L=0.6 W=1.4 AS=0.406
+ AD=0.406 PS=3.38 PD=3.38
M$439 \$120 bias_a VSS sky130_gnd sky130_fd_pr__nfet_01v8 L=0.6 W=1.4 AS=0.406
+ AD=0.406 PS=3.38 PD=3.38
M$440 \$120 bias_a VSS sky130_gnd sky130_fd_pr__nfet_01v8 L=0.6 W=1.4 AS=0.406
+ AD=0.406 PS=3.38 PD=3.38
M$441 \$120 bias_a VSS sky130_gnd sky130_fd_pr__nfet_01v8 L=0.6 W=1.4 AS=0.406
+ AD=0.406 PS=3.38 PD=3.38
M$442 \$120 bias_a VSS sky130_gnd sky130_fd_pr__nfet_01v8 L=0.6 W=1.4 AS=0.406
+ AD=0.406 PS=3.38 PD=3.38
M$443 \$120 bias_a VSS sky130_gnd sky130_fd_pr__nfet_01v8 L=0.6 W=1.4 AS=0.406
+ AD=0.406 PS=3.38 PD=3.38
M$444 \$120 bias_a VSS sky130_gnd sky130_fd_pr__nfet_01v8 L=0.6 W=1.4 AS=0.406
+ AD=0.406 PS=3.38 PD=3.38
M$445 \$120 bias_a VSS sky130_gnd sky130_fd_pr__nfet_01v8 L=0.6 W=1.4 AS=0.406
+ AD=0.406 PS=3.38 PD=3.38
M$446 \$120 bias_a VSS sky130_gnd sky130_fd_pr__nfet_01v8 L=0.6 W=1.4 AS=0.406
+ AD=0.406 PS=3.38 PD=3.38
M$447 \$120 bias_a VSS sky130_gnd sky130_fd_pr__nfet_01v8 L=0.6 W=1.4 AS=0.406
+ AD=0.406 PS=3.38 PD=3.38
M$448 bias_a \$131 \$120 sky130_gnd sky130_fd_pr__nfet_01v8 L=0.6 W=1.4
+ AS=0.406 AD=0.406 PS=3.38 PD=3.38
M$449 bias_a \$131 \$120 sky130_gnd sky130_fd_pr__nfet_01v8 L=0.6 W=1.4
+ AS=0.406 AD=0.406 PS=3.38 PD=3.38
M$450 bias_a \$131 \$120 sky130_gnd sky130_fd_pr__nfet_01v8 L=0.6 W=1.4
+ AS=0.406 AD=0.406 PS=3.38 PD=3.38
M$451 bias_a \$131 \$120 sky130_gnd sky130_fd_pr__nfet_01v8 L=0.6 W=1.4
+ AS=0.406 AD=0.406 PS=3.38 PD=3.38
M$452 bias_a \$131 \$120 sky130_gnd sky130_fd_pr__nfet_01v8 L=0.6 W=1.4
+ AS=0.406 AD=0.406 PS=3.38 PD=3.38
M$453 bias_a \$131 \$120 sky130_gnd sky130_fd_pr__nfet_01v8 L=0.6 W=1.4
+ AS=0.406 AD=0.406 PS=3.38 PD=3.38
M$454 bias_a \$131 \$120 sky130_gnd sky130_fd_pr__nfet_01v8 L=0.6 W=1.4
+ AS=0.406 AD=0.406 PS=3.38 PD=3.38
M$455 bias_a \$131 \$120 sky130_gnd sky130_fd_pr__nfet_01v8 L=0.6 W=1.4
+ AS=0.406 AD=0.406 PS=3.38 PD=3.38
M$456 bias_a \$131 \$120 sky130_gnd sky130_fd_pr__nfet_01v8 L=0.6 W=1.4
+ AS=0.406 AD=0.406 PS=3.38 PD=3.38
M$457 bias_a \$131 \$120 sky130_gnd sky130_fd_pr__nfet_01v8 L=0.6 W=1.4
+ AS=0.406 AD=0.406 PS=3.38 PD=3.38
M$458 bias_a \$131 \$120 sky130_gnd sky130_fd_pr__nfet_01v8 L=0.6 W=1.4
+ AS=0.406 AD=0.406 PS=3.38 PD=3.38
M$459 bias_a \$131 \$120 sky130_gnd sky130_fd_pr__nfet_01v8 L=0.6 W=1.4
+ AS=0.406 AD=0.406 PS=3.38 PD=3.38
M$460 bias_a \$131 \$120 sky130_gnd sky130_fd_pr__nfet_01v8 L=0.6 W=1.4
+ AS=0.406 AD=0.406 PS=3.38 PD=3.38
M$461 bias_a \$131 \$120 sky130_gnd sky130_fd_pr__nfet_01v8 L=0.6 W=1.4
+ AS=0.406 AD=0.406 PS=3.38 PD=3.38
M$462 bias_a \$131 \$120 sky130_gnd sky130_fd_pr__nfet_01v8 L=0.6 W=1.4
+ AS=0.406 AD=0.406 PS=3.38 PD=3.38
M$463 bias_a \$131 \$120 sky130_gnd sky130_fd_pr__nfet_01v8 L=0.6 W=1.4
+ AS=0.406 AD=0.406 PS=3.38 PD=3.38
M$464 bias_a \$131 \$120 sky130_gnd sky130_fd_pr__nfet_01v8 L=0.6 W=1.4
+ AS=0.406 AD=0.406 PS=3.38 PD=3.38
M$465 bias_a \$131 \$120 sky130_gnd sky130_fd_pr__nfet_01v8 L=0.6 W=1.4
+ AS=0.406 AD=0.406 PS=3.38 PD=3.38
M$466 VSS VSS VSS sky130_gnd sky130_fd_pr__nfet_01v8 L=0.6 W=1.4 AS=0.406
+ AD=0.406 PS=3.38 PD=3.38
M$467 VSS VSS VSS sky130_gnd sky130_fd_pr__nfet_01v8 L=0.6 W=1.4 AS=0.406
+ AD=0.406 PS=3.38 PD=3.38
M$468 \$105 IBIAS VSS sky130_gnd sky130_fd_pr__nfet_01v8 L=0.6 W=1.4 AS=0.406
+ AD=0.406 PS=3.38 PD=3.38
M$469 \$105 IBIAS VSS sky130_gnd sky130_fd_pr__nfet_01v8 L=0.6 W=1.4 AS=0.406
+ AD=0.406 PS=3.38 PD=3.38
M$470 \$105 IBIAS VSS sky130_gnd sky130_fd_pr__nfet_01v8 L=0.6 W=1.4 AS=0.406
+ AD=0.406 PS=3.38 PD=3.38
M$471 \$105 IBIAS VSS sky130_gnd sky130_fd_pr__nfet_01v8 L=0.6 W=1.4 AS=0.406
+ AD=0.406 PS=3.38 PD=3.38
M$472 \$105 IBIAS VSS sky130_gnd sky130_fd_pr__nfet_01v8 L=0.6 W=1.4 AS=0.406
+ AD=0.406 PS=3.38 PD=3.38
M$473 \$105 IBIAS VSS sky130_gnd sky130_fd_pr__nfet_01v8 L=0.6 W=1.4 AS=0.406
+ AD=0.406 PS=3.38 PD=3.38
M$474 \$105 IBIAS VSS sky130_gnd sky130_fd_pr__nfet_01v8 L=0.6 W=1.4 AS=0.406
+ AD=0.406 PS=3.38 PD=3.38
M$475 \$105 IBIAS VSS sky130_gnd sky130_fd_pr__nfet_01v8 L=0.6 W=1.4 AS=0.406
+ AD=0.406 PS=3.38 PD=3.38
M$476 \$105 IBIAS VSS sky130_gnd sky130_fd_pr__nfet_01v8 L=0.6 W=1.4 AS=0.406
+ AD=0.406 PS=3.38 PD=3.38
M$477 \$105 IBIAS VSS sky130_gnd sky130_fd_pr__nfet_01v8 L=0.6 W=1.4 AS=0.406
+ AD=0.406 PS=3.38 PD=3.38
M$478 \$105 IBIAS VSS sky130_gnd sky130_fd_pr__nfet_01v8 L=0.6 W=1.4 AS=0.406
+ AD=0.406 PS=3.38 PD=3.38
M$479 \$105 IBIAS VSS sky130_gnd sky130_fd_pr__nfet_01v8 L=0.6 W=1.4 AS=0.406
+ AD=0.406 PS=3.38 PD=3.38
M$480 \$105 IBIAS VSS sky130_gnd sky130_fd_pr__nfet_01v8 L=0.6 W=1.4 AS=0.406
+ AD=0.406 PS=3.38 PD=3.38
M$481 \$105 IBIAS VSS sky130_gnd sky130_fd_pr__nfet_01v8 L=0.6 W=1.4 AS=0.406
+ AD=0.406 PS=3.38 PD=3.38
M$482 \$105 IBIAS VSS sky130_gnd sky130_fd_pr__nfet_01v8 L=0.6 W=1.4 AS=0.406
+ AD=0.406 PS=3.38 PD=3.38
M$483 \$105 IBIAS VSS sky130_gnd sky130_fd_pr__nfet_01v8 L=0.6 W=1.4 AS=0.406
+ AD=0.406 PS=3.38 PD=3.38
M$484 \$105 IBIAS VSS sky130_gnd sky130_fd_pr__nfet_01v8 L=0.6 W=1.4 AS=0.406
+ AD=0.406 PS=3.38 PD=3.38
M$485 \$105 IBIAS VSS sky130_gnd sky130_fd_pr__nfet_01v8 L=0.6 W=1.4 AS=0.406
+ AD=0.406 PS=3.38 PD=3.38
M$486 IBIAS IBIAS VSS sky130_gnd sky130_fd_pr__nfet_01v8 L=0.6 W=1.4 AS=0.406
+ AD=0.406 PS=3.38 PD=3.38
M$487 IBIAS IBIAS VSS sky130_gnd sky130_fd_pr__nfet_01v8 L=0.6 W=1.4 AS=0.406
+ AD=0.406 PS=3.38 PD=3.38
M$488 IBIAS IBIAS VSS sky130_gnd sky130_fd_pr__nfet_01v8 L=0.6 W=1.4 AS=0.406
+ AD=0.406 PS=3.38 PD=3.38
M$489 IBIAS IBIAS VSS sky130_gnd sky130_fd_pr__nfet_01v8 L=0.6 W=1.4 AS=0.406
+ AD=0.406 PS=3.38 PD=3.38
M$490 IBIAS IBIAS VSS sky130_gnd sky130_fd_pr__nfet_01v8 L=0.6 W=1.4 AS=0.406
+ AD=0.406 PS=3.38 PD=3.38
M$491 IBIAS IBIAS VSS sky130_gnd sky130_fd_pr__nfet_01v8 L=0.6 W=1.4 AS=0.406
+ AD=0.406 PS=3.38 PD=3.38
M$492 IBIAS IBIAS VSS sky130_gnd sky130_fd_pr__nfet_01v8 L=0.6 W=1.4 AS=0.406
+ AD=0.406 PS=3.38 PD=3.38
M$493 IBIAS IBIAS VSS sky130_gnd sky130_fd_pr__nfet_01v8 L=0.6 W=1.4 AS=0.406
+ AD=0.406 PS=3.38 PD=3.38
M$494 IBIAS IBIAS VSS sky130_gnd sky130_fd_pr__nfet_01v8 L=0.6 W=1.4 AS=0.406
+ AD=0.406 PS=3.38 PD=3.38
M$495 IBIAS IBIAS VSS sky130_gnd sky130_fd_pr__nfet_01v8 L=0.6 W=1.4 AS=0.406
+ AD=0.406 PS=3.38 PD=3.38
M$496 IBIAS IBIAS VSS sky130_gnd sky130_fd_pr__nfet_01v8 L=0.6 W=1.4 AS=0.406
+ AD=0.406 PS=3.38 PD=3.38
M$497 IBIAS IBIAS VSS sky130_gnd sky130_fd_pr__nfet_01v8 L=0.6 W=1.4 AS=0.406
+ AD=0.406 PS=3.38 PD=3.38
M$498 IBIAS IBIAS VSS sky130_gnd sky130_fd_pr__nfet_01v8 L=0.6 W=1.4 AS=0.406
+ AD=0.406 PS=3.38 PD=3.38
M$499 IBIAS IBIAS VSS sky130_gnd sky130_fd_pr__nfet_01v8 L=0.6 W=1.4 AS=0.406
+ AD=0.406 PS=3.38 PD=3.38
M$500 IBIAS IBIAS VSS sky130_gnd sky130_fd_pr__nfet_01v8 L=0.6 W=1.4 AS=0.406
+ AD=0.406 PS=3.38 PD=3.38
M$501 IBIAS IBIAS VSS sky130_gnd sky130_fd_pr__nfet_01v8 L=0.6 W=1.4 AS=0.406
+ AD=0.406 PS=3.38 PD=3.38
M$502 IBIAS IBIAS VSS sky130_gnd sky130_fd_pr__nfet_01v8 L=0.6 W=1.4 AS=0.406
+ AD=0.406 PS=3.38 PD=3.38
M$503 IBIAS IBIAS VSS sky130_gnd sky130_fd_pr__nfet_01v8 L=0.6 W=1.4 AS=0.406
+ AD=0.406 PS=3.38 PD=3.38
M$504 \$229 \$229 \$229 sky130_gnd sky130_fd_pr__nfet_01v8 L=0.6 W=1.4 AS=0.406
+ AD=0.406 PS=3.38 PD=3.38
M$505 \$229 \$229 \$229 sky130_gnd sky130_fd_pr__nfet_01v8 L=0.6 W=1.4 AS=0.406
+ AD=0.406 PS=3.38 PD=3.38
M$506 \$131 \$229 bias_a sky130_gnd sky130_fd_pr__nfet_01v8 L=0.6 W=1.4
+ AS=0.406 AD=0.406 PS=3.38 PD=3.38
M$507 \$131 \$229 bias_a sky130_gnd sky130_fd_pr__nfet_01v8 L=0.6 W=1.4
+ AS=0.406 AD=0.406 PS=3.38 PD=3.38
M$508 \$105 \$105 \$105 sky130_gnd sky130_fd_pr__nfet_01v8 L=0.6 W=1.4 AS=0.406
+ AD=0.406 PS=3.38 PD=3.38
M$509 \$105 \$105 \$105 sky130_gnd sky130_fd_pr__nfet_01v8 L=0.6 W=1.4 AS=0.406
+ AD=0.406 PS=3.38 PD=3.38
M$510 IBIAS IBIAS IBIAS sky130_gnd sky130_fd_pr__nfet_01v8 L=0.6 W=1.4 AS=0.406
+ AD=0.406 PS=3.38 PD=3.38
M$511 IBIAS IBIAS IBIAS sky130_gnd sky130_fd_pr__nfet_01v8 L=0.6 W=1.4 AS=0.406
+ AD=0.406 PS=3.38 PD=3.38
M$512 VSS VSS VSS sky130_gnd sky130_fd_pr__nfet_01v8 L=0.6 W=1.4 AS=0.406
+ AD=0.406 PS=3.38 PD=3.38
M$513 on VSS VSS sky130_gnd sky130_fd_pr__nfet_01v8 L=0.6 W=1.4 AS=0.406
+ AD=0.406 PS=3.38 PD=3.38
M$514 on VSS VSS sky130_gnd sky130_fd_pr__nfet_01v8 L=0.6 W=1.4 AS=0.406
+ AD=0.406 PS=3.38 PD=3.38
M$515 VSS VSS VSS sky130_gnd sky130_fd_pr__nfet_01v8 L=0.6 W=1.4 AS=0.406
+ AD=0.406 PS=3.38 PD=3.38
M$516 VSS VSS VSS sky130_gnd sky130_fd_pr__nfet_01v8 L=0.6 W=1.4 AS=0.406
+ AD=0.406 PS=3.38 PD=3.38
M$517 VSS VSS VSS sky130_gnd sky130_fd_pr__nfet_01v8 L=0.6 W=1.4 AS=0.406
+ AD=0.406 PS=3.38 PD=3.38
M$518 op VSS VSS sky130_gnd sky130_fd_pr__nfet_01v8 L=0.6 W=1.4 AS=0.406
+ AD=0.406 PS=3.38 PD=3.38
M$519 op VSS VSS sky130_gnd sky130_fd_pr__nfet_01v8 L=0.6 W=1.4 AS=0.406
+ AD=0.406 PS=3.38 PD=3.38
M$520 on on on sky130_gnd sky130_fd_pr__nfet_01v8 L=0.6 W=1.4 AS=0.406 AD=0.406
+ PS=3.38 PD=3.38
M$521 on on on sky130_gnd sky130_fd_pr__nfet_01v8 L=0.6 W=1.4 AS=0.406 AD=0.406
+ PS=3.38 PD=3.38
M$522 op op op sky130_gnd sky130_fd_pr__nfet_01v8 L=0.6 W=1.4 AS=0.406 AD=0.406
+ PS=3.38 PD=3.38
M$523 op op op sky130_gnd sky130_fd_pr__nfet_01v8 L=0.6 W=1.4 AS=0.406 AD=0.406
+ PS=3.38 PD=3.38
M$524 \$1 VSS VSS sky130_gnd sky130_fd_pr__nfet_01v8 L=0.6 W=1.4 AS=0.406
+ AD=0.406 PS=3.38 PD=3.38
M$525 \$1 VSS VSS sky130_gnd sky130_fd_pr__nfet_01v8 L=0.6 W=1.4 AS=0.406
+ AD=0.406 PS=3.38 PD=3.38
M$526 on \$131 \$35 sky130_gnd sky130_fd_pr__nfet_01v8 L=0.6 W=1.4 AS=0.406
+ AD=0.406 PS=3.38 PD=3.38
M$527 on \$131 \$35 sky130_gnd sky130_fd_pr__nfet_01v8 L=0.6 W=1.4 AS=0.406
+ AD=0.406 PS=3.38 PD=3.38
M$528 on \$131 \$35 sky130_gnd sky130_fd_pr__nfet_01v8 L=0.6 W=1.4 AS=0.406
+ AD=0.406 PS=3.38 PD=3.38
M$529 on \$131 \$35 sky130_gnd sky130_fd_pr__nfet_01v8 L=0.6 W=1.4 AS=0.406
+ AD=0.406 PS=3.38 PD=3.38
M$530 on \$131 \$35 sky130_gnd sky130_fd_pr__nfet_01v8 L=0.6 W=1.4 AS=0.406
+ AD=0.406 PS=3.38 PD=3.38
M$531 on \$131 \$35 sky130_gnd sky130_fd_pr__nfet_01v8 L=0.6 W=1.4 AS=0.406
+ AD=0.406 PS=3.38 PD=3.38
M$532 on \$131 \$35 sky130_gnd sky130_fd_pr__nfet_01v8 L=0.6 W=1.4 AS=0.406
+ AD=0.406 PS=3.38 PD=3.38
M$533 on \$131 \$35 sky130_gnd sky130_fd_pr__nfet_01v8 L=0.6 W=1.4 AS=0.406
+ AD=0.406 PS=3.38 PD=3.38
M$534 on \$131 \$35 sky130_gnd sky130_fd_pr__nfet_01v8 L=0.6 W=1.4 AS=0.406
+ AD=0.406 PS=3.38 PD=3.38
M$535 on \$131 \$35 sky130_gnd sky130_fd_pr__nfet_01v8 L=0.6 W=1.4 AS=0.406
+ AD=0.406 PS=3.38 PD=3.38
M$536 on \$131 \$35 sky130_gnd sky130_fd_pr__nfet_01v8 L=0.6 W=1.4 AS=0.406
+ AD=0.406 PS=3.38 PD=3.38
M$537 on \$131 \$35 sky130_gnd sky130_fd_pr__nfet_01v8 L=0.6 W=1.4 AS=0.406
+ AD=0.406 PS=3.38 PD=3.38
M$538 on \$131 \$35 sky130_gnd sky130_fd_pr__nfet_01v8 L=0.6 W=1.4 AS=0.406
+ AD=0.406 PS=3.38 PD=3.38
M$539 on \$131 \$35 sky130_gnd sky130_fd_pr__nfet_01v8 L=0.6 W=1.4 AS=0.406
+ AD=0.406 PS=3.38 PD=3.38
M$540 on \$131 \$35 sky130_gnd sky130_fd_pr__nfet_01v8 L=0.6 W=1.4 AS=0.406
+ AD=0.406 PS=3.38 PD=3.38
M$541 on \$131 \$35 sky130_gnd sky130_fd_pr__nfet_01v8 L=0.6 W=1.4 AS=0.406
+ AD=0.406 PS=3.38 PD=3.38
M$542 on \$131 \$35 sky130_gnd sky130_fd_pr__nfet_01v8 L=0.6 W=1.4 AS=0.406
+ AD=0.406 PS=3.38 PD=3.38
M$543 on \$131 \$35 sky130_gnd sky130_fd_pr__nfet_01v8 L=0.6 W=1.4 AS=0.406
+ AD=0.406 PS=3.38 PD=3.38
M$544 on \$131 \$35 sky130_gnd sky130_fd_pr__nfet_01v8 L=0.6 W=1.4 AS=0.406
+ AD=0.406 PS=3.38 PD=3.38
M$545 on \$131 \$35 sky130_gnd sky130_fd_pr__nfet_01v8 L=0.6 W=1.4 AS=0.406
+ AD=0.406 PS=3.38 PD=3.38
M$546 on \$131 \$35 sky130_gnd sky130_fd_pr__nfet_01v8 L=0.6 W=1.4 AS=0.406
+ AD=0.406 PS=3.38 PD=3.38
M$547 on \$131 \$35 sky130_gnd sky130_fd_pr__nfet_01v8 L=0.6 W=1.4 AS=0.406
+ AD=0.406 PS=3.38 PD=3.38
M$548 on \$131 \$35 sky130_gnd sky130_fd_pr__nfet_01v8 L=0.6 W=1.4 AS=0.406
+ AD=0.406 PS=3.38 PD=3.38
M$549 on \$131 \$35 sky130_gnd sky130_fd_pr__nfet_01v8 L=0.6 W=1.4 AS=0.406
+ AD=0.406 PS=3.38 PD=3.38
M$550 on \$131 \$35 sky130_gnd sky130_fd_pr__nfet_01v8 L=0.6 W=1.4 AS=0.406
+ AD=0.406 PS=3.38 PD=3.38
M$551 on \$131 \$35 sky130_gnd sky130_fd_pr__nfet_01v8 L=0.6 W=1.4 AS=0.406
+ AD=0.406 PS=3.38 PD=3.38
M$552 on \$131 \$35 sky130_gnd sky130_fd_pr__nfet_01v8 L=0.6 W=1.4 AS=0.406
+ AD=0.406 PS=3.38 PD=3.38
M$553 on \$131 \$35 sky130_gnd sky130_fd_pr__nfet_01v8 L=0.6 W=1.4 AS=0.406
+ AD=0.406 PS=3.38 PD=3.38
M$554 on \$131 \$35 sky130_gnd sky130_fd_pr__nfet_01v8 L=0.6 W=1.4 AS=0.406
+ AD=0.406 PS=3.38 PD=3.38
M$555 on \$131 \$35 sky130_gnd sky130_fd_pr__nfet_01v8 L=0.6 W=1.4 AS=0.406
+ AD=0.406 PS=3.38 PD=3.38
M$556 on \$131 \$35 sky130_gnd sky130_fd_pr__nfet_01v8 L=0.6 W=1.4 AS=0.406
+ AD=0.406 PS=3.38 PD=3.38
M$557 on \$131 \$35 sky130_gnd sky130_fd_pr__nfet_01v8 L=0.6 W=1.4 AS=0.406
+ AD=0.406 PS=3.38 PD=3.38
M$558 on \$131 \$35 sky130_gnd sky130_fd_pr__nfet_01v8 L=0.6 W=1.4 AS=0.406
+ AD=0.406 PS=3.38 PD=3.38
M$559 on \$131 \$35 sky130_gnd sky130_fd_pr__nfet_01v8 L=0.6 W=1.4 AS=0.406
+ AD=0.406 PS=3.38 PD=3.38
M$560 on \$131 \$35 sky130_gnd sky130_fd_pr__nfet_01v8 L=0.6 W=1.4 AS=0.406
+ AD=0.406 PS=3.38 PD=3.38
M$561 on \$131 \$35 sky130_gnd sky130_fd_pr__nfet_01v8 L=0.6 W=1.4 AS=0.406
+ AD=0.406 PS=3.38 PD=3.38
M$562 op \$131 \$19 sky130_gnd sky130_fd_pr__nfet_01v8 L=0.6 W=1.4 AS=0.406
+ AD=0.406 PS=3.38 PD=3.38
M$563 op \$131 \$19 sky130_gnd sky130_fd_pr__nfet_01v8 L=0.6 W=1.4 AS=0.406
+ AD=0.406 PS=3.38 PD=3.38
M$564 op \$131 \$19 sky130_gnd sky130_fd_pr__nfet_01v8 L=0.6 W=1.4 AS=0.406
+ AD=0.406 PS=3.38 PD=3.38
M$565 op \$131 \$19 sky130_gnd sky130_fd_pr__nfet_01v8 L=0.6 W=1.4 AS=0.406
+ AD=0.406 PS=3.38 PD=3.38
M$566 op \$131 \$19 sky130_gnd sky130_fd_pr__nfet_01v8 L=0.6 W=1.4 AS=0.406
+ AD=0.406 PS=3.38 PD=3.38
M$567 op \$131 \$19 sky130_gnd sky130_fd_pr__nfet_01v8 L=0.6 W=1.4 AS=0.406
+ AD=0.406 PS=3.38 PD=3.38
M$568 op \$131 \$19 sky130_gnd sky130_fd_pr__nfet_01v8 L=0.6 W=1.4 AS=0.406
+ AD=0.406 PS=3.38 PD=3.38
M$569 op \$131 \$19 sky130_gnd sky130_fd_pr__nfet_01v8 L=0.6 W=1.4 AS=0.406
+ AD=0.406 PS=3.38 PD=3.38
M$570 op \$131 \$19 sky130_gnd sky130_fd_pr__nfet_01v8 L=0.6 W=1.4 AS=0.406
+ AD=0.406 PS=3.38 PD=3.38
M$571 op \$131 \$19 sky130_gnd sky130_fd_pr__nfet_01v8 L=0.6 W=1.4 AS=0.406
+ AD=0.406 PS=3.38 PD=3.38
M$572 op \$131 \$19 sky130_gnd sky130_fd_pr__nfet_01v8 L=0.6 W=1.4 AS=0.406
+ AD=0.406 PS=3.38 PD=3.38
M$573 op \$131 \$19 sky130_gnd sky130_fd_pr__nfet_01v8 L=0.6 W=1.4 AS=0.406
+ AD=0.406 PS=3.38 PD=3.38
M$574 op \$131 \$19 sky130_gnd sky130_fd_pr__nfet_01v8 L=0.6 W=1.4 AS=0.406
+ AD=0.406 PS=3.38 PD=3.38
M$575 op \$131 \$19 sky130_gnd sky130_fd_pr__nfet_01v8 L=0.6 W=1.4 AS=0.406
+ AD=0.406 PS=3.38 PD=3.38
M$576 op \$131 \$19 sky130_gnd sky130_fd_pr__nfet_01v8 L=0.6 W=1.4 AS=0.406
+ AD=0.406 PS=3.38 PD=3.38
M$577 op \$131 \$19 sky130_gnd sky130_fd_pr__nfet_01v8 L=0.6 W=1.4 AS=0.406
+ AD=0.406 PS=3.38 PD=3.38
M$578 op \$131 \$19 sky130_gnd sky130_fd_pr__nfet_01v8 L=0.6 W=1.4 AS=0.406
+ AD=0.406 PS=3.38 PD=3.38
M$579 op \$131 \$19 sky130_gnd sky130_fd_pr__nfet_01v8 L=0.6 W=1.4 AS=0.406
+ AD=0.406 PS=3.38 PD=3.38
M$580 op \$131 \$19 sky130_gnd sky130_fd_pr__nfet_01v8 L=0.6 W=1.4 AS=0.406
+ AD=0.406 PS=3.38 PD=3.38
M$581 op \$131 \$19 sky130_gnd sky130_fd_pr__nfet_01v8 L=0.6 W=1.4 AS=0.406
+ AD=0.406 PS=3.38 PD=3.38
M$582 op \$131 \$19 sky130_gnd sky130_fd_pr__nfet_01v8 L=0.6 W=1.4 AS=0.406
+ AD=0.406 PS=3.38 PD=3.38
M$583 op \$131 \$19 sky130_gnd sky130_fd_pr__nfet_01v8 L=0.6 W=1.4 AS=0.406
+ AD=0.406 PS=3.38 PD=3.38
M$584 op \$131 \$19 sky130_gnd sky130_fd_pr__nfet_01v8 L=0.6 W=1.4 AS=0.406
+ AD=0.406 PS=3.38 PD=3.38
M$585 op \$131 \$19 sky130_gnd sky130_fd_pr__nfet_01v8 L=0.6 W=1.4 AS=0.406
+ AD=0.406 PS=3.38 PD=3.38
M$586 op \$131 \$19 sky130_gnd sky130_fd_pr__nfet_01v8 L=0.6 W=1.4 AS=0.406
+ AD=0.406 PS=3.38 PD=3.38
M$587 op \$131 \$19 sky130_gnd sky130_fd_pr__nfet_01v8 L=0.6 W=1.4 AS=0.406
+ AD=0.406 PS=3.38 PD=3.38
M$588 op \$131 \$19 sky130_gnd sky130_fd_pr__nfet_01v8 L=0.6 W=1.4 AS=0.406
+ AD=0.406 PS=3.38 PD=3.38
M$589 op \$131 \$19 sky130_gnd sky130_fd_pr__nfet_01v8 L=0.6 W=1.4 AS=0.406
+ AD=0.406 PS=3.38 PD=3.38
M$590 op \$131 \$19 sky130_gnd sky130_fd_pr__nfet_01v8 L=0.6 W=1.4 AS=0.406
+ AD=0.406 PS=3.38 PD=3.38
M$591 op \$131 \$19 sky130_gnd sky130_fd_pr__nfet_01v8 L=0.6 W=1.4 AS=0.406
+ AD=0.406 PS=3.38 PD=3.38
M$592 op \$131 \$19 sky130_gnd sky130_fd_pr__nfet_01v8 L=0.6 W=1.4 AS=0.406
+ AD=0.406 PS=3.38 PD=3.38
M$593 op \$131 \$19 sky130_gnd sky130_fd_pr__nfet_01v8 L=0.6 W=1.4 AS=0.406
+ AD=0.406 PS=3.38 PD=3.38
M$594 op \$131 \$19 sky130_gnd sky130_fd_pr__nfet_01v8 L=0.6 W=1.4 AS=0.406
+ AD=0.406 PS=3.38 PD=3.38
M$595 op \$131 \$19 sky130_gnd sky130_fd_pr__nfet_01v8 L=0.6 W=1.4 AS=0.406
+ AD=0.406 PS=3.38 PD=3.38
M$596 op \$131 \$19 sky130_gnd sky130_fd_pr__nfet_01v8 L=0.6 W=1.4 AS=0.406
+ AD=0.406 PS=3.38 PD=3.38
M$597 op \$131 \$19 sky130_gnd sky130_fd_pr__nfet_01v8 L=0.6 W=1.4 AS=0.406
+ AD=0.406 PS=3.38 PD=3.38
M$598 \$35 bias_a VSS sky130_gnd sky130_fd_pr__nfet_01v8 L=0.6 W=1.4 AS=0.406
+ AD=0.406 PS=3.38 PD=3.38
M$599 \$35 bias_a VSS sky130_gnd sky130_fd_pr__nfet_01v8 L=0.6 W=1.4 AS=0.406
+ AD=0.406 PS=3.38 PD=3.38
M$600 \$35 bias_a VSS sky130_gnd sky130_fd_pr__nfet_01v8 L=0.6 W=1.4 AS=0.406
+ AD=0.406 PS=3.38 PD=3.38
M$601 \$35 bias_a VSS sky130_gnd sky130_fd_pr__nfet_01v8 L=0.6 W=1.4 AS=0.406
+ AD=0.406 PS=3.38 PD=3.38
M$602 \$35 bias_a VSS sky130_gnd sky130_fd_pr__nfet_01v8 L=0.6 W=1.4 AS=0.406
+ AD=0.406 PS=3.38 PD=3.38
M$603 \$35 bias_a VSS sky130_gnd sky130_fd_pr__nfet_01v8 L=0.6 W=1.4 AS=0.406
+ AD=0.406 PS=3.38 PD=3.38
M$604 \$35 bias_a VSS sky130_gnd sky130_fd_pr__nfet_01v8 L=0.6 W=1.4 AS=0.406
+ AD=0.406 PS=3.38 PD=3.38
M$605 \$35 bias_a VSS sky130_gnd sky130_fd_pr__nfet_01v8 L=0.6 W=1.4 AS=0.406
+ AD=0.406 PS=3.38 PD=3.38
M$606 \$35 bias_a VSS sky130_gnd sky130_fd_pr__nfet_01v8 L=0.6 W=1.4 AS=0.406
+ AD=0.406 PS=3.38 PD=3.38
M$607 \$35 bias_a VSS sky130_gnd sky130_fd_pr__nfet_01v8 L=0.6 W=1.4 AS=0.406
+ AD=0.406 PS=3.38 PD=3.38
M$608 \$35 bias_a VSS sky130_gnd sky130_fd_pr__nfet_01v8 L=0.6 W=1.4 AS=0.406
+ AD=0.406 PS=3.38 PD=3.38
M$609 \$35 bias_a VSS sky130_gnd sky130_fd_pr__nfet_01v8 L=0.6 W=1.4 AS=0.406
+ AD=0.406 PS=3.38 PD=3.38
M$610 \$35 bias_a VSS sky130_gnd sky130_fd_pr__nfet_01v8 L=0.6 W=1.4 AS=0.406
+ AD=0.406 PS=3.38 PD=3.38
M$611 \$35 bias_a VSS sky130_gnd sky130_fd_pr__nfet_01v8 L=0.6 W=1.4 AS=0.406
+ AD=0.406 PS=3.38 PD=3.38
M$612 \$35 bias_a VSS sky130_gnd sky130_fd_pr__nfet_01v8 L=0.6 W=1.4 AS=0.406
+ AD=0.406 PS=3.38 PD=3.38
M$613 \$35 bias_a VSS sky130_gnd sky130_fd_pr__nfet_01v8 L=0.6 W=1.4 AS=0.406
+ AD=0.406 PS=3.38 PD=3.38
M$614 \$35 bias_a VSS sky130_gnd sky130_fd_pr__nfet_01v8 L=0.6 W=1.4 AS=0.406
+ AD=0.406 PS=3.38 PD=3.38
M$615 \$35 bias_a VSS sky130_gnd sky130_fd_pr__nfet_01v8 L=0.6 W=1.4 AS=0.406
+ AD=0.406 PS=3.38 PD=3.38
M$616 \$35 bias_a VSS sky130_gnd sky130_fd_pr__nfet_01v8 L=0.6 W=1.4 AS=0.406
+ AD=0.406 PS=3.38 PD=3.38
M$617 \$35 bias_a VSS sky130_gnd sky130_fd_pr__nfet_01v8 L=0.6 W=1.4 AS=0.406
+ AD=0.406 PS=3.38 PD=3.38
M$618 \$35 bias_a VSS sky130_gnd sky130_fd_pr__nfet_01v8 L=0.6 W=1.4 AS=0.406
+ AD=0.406 PS=3.38 PD=3.38
M$619 \$35 bias_a VSS sky130_gnd sky130_fd_pr__nfet_01v8 L=0.6 W=1.4 AS=0.406
+ AD=0.406 PS=3.38 PD=3.38
M$620 \$35 bias_a VSS sky130_gnd sky130_fd_pr__nfet_01v8 L=0.6 W=1.4 AS=0.406
+ AD=0.406 PS=3.38 PD=3.38
M$621 \$35 bias_a VSS sky130_gnd sky130_fd_pr__nfet_01v8 L=0.6 W=1.4 AS=0.406
+ AD=0.406 PS=3.38 PD=3.38
M$622 \$35 bias_a VSS sky130_gnd sky130_fd_pr__nfet_01v8 L=0.6 W=1.4 AS=0.406
+ AD=0.406 PS=3.38 PD=3.38
M$623 \$35 bias_a VSS sky130_gnd sky130_fd_pr__nfet_01v8 L=0.6 W=1.4 AS=0.406
+ AD=0.406 PS=3.38 PD=3.38
M$624 \$35 bias_a VSS sky130_gnd sky130_fd_pr__nfet_01v8 L=0.6 W=1.4 AS=0.406
+ AD=0.406 PS=3.38 PD=3.38
M$625 \$35 bias_a VSS sky130_gnd sky130_fd_pr__nfet_01v8 L=0.6 W=1.4 AS=0.406
+ AD=0.406 PS=3.38 PD=3.38
M$626 \$35 bias_a VSS sky130_gnd sky130_fd_pr__nfet_01v8 L=0.6 W=1.4 AS=0.406
+ AD=0.406 PS=3.38 PD=3.38
M$627 \$35 bias_a VSS sky130_gnd sky130_fd_pr__nfet_01v8 L=0.6 W=1.4 AS=0.406
+ AD=0.406 PS=3.38 PD=3.38
M$628 \$35 bias_a VSS sky130_gnd sky130_fd_pr__nfet_01v8 L=0.6 W=1.4 AS=0.406
+ AD=0.406 PS=3.38 PD=3.38
M$629 \$35 bias_a VSS sky130_gnd sky130_fd_pr__nfet_01v8 L=0.6 W=1.4 AS=0.406
+ AD=0.406 PS=3.38 PD=3.38
M$630 \$35 bias_a VSS sky130_gnd sky130_fd_pr__nfet_01v8 L=0.6 W=1.4 AS=0.406
+ AD=0.406 PS=3.38 PD=3.38
M$631 \$35 bias_a VSS sky130_gnd sky130_fd_pr__nfet_01v8 L=0.6 W=1.4 AS=0.406
+ AD=0.406 PS=3.38 PD=3.38
M$632 \$35 bias_a VSS sky130_gnd sky130_fd_pr__nfet_01v8 L=0.6 W=1.4 AS=0.406
+ AD=0.406 PS=3.38 PD=3.38
M$633 \$35 bias_a VSS sky130_gnd sky130_fd_pr__nfet_01v8 L=0.6 W=1.4 AS=0.406
+ AD=0.406 PS=3.38 PD=3.38
M$634 \$19 bias_a VSS sky130_gnd sky130_fd_pr__nfet_01v8 L=0.6 W=1.4 AS=0.406
+ AD=0.406 PS=3.38 PD=3.38
M$635 \$19 bias_a VSS sky130_gnd sky130_fd_pr__nfet_01v8 L=0.6 W=1.4 AS=0.406
+ AD=0.406 PS=3.38 PD=3.38
M$636 \$19 bias_a VSS sky130_gnd sky130_fd_pr__nfet_01v8 L=0.6 W=1.4 AS=0.406
+ AD=0.406 PS=3.38 PD=3.38
M$637 \$19 bias_a VSS sky130_gnd sky130_fd_pr__nfet_01v8 L=0.6 W=1.4 AS=0.406
+ AD=0.406 PS=3.38 PD=3.38
M$638 \$19 bias_a VSS sky130_gnd sky130_fd_pr__nfet_01v8 L=0.6 W=1.4 AS=0.406
+ AD=0.406 PS=3.38 PD=3.38
M$639 \$19 bias_a VSS sky130_gnd sky130_fd_pr__nfet_01v8 L=0.6 W=1.4 AS=0.406
+ AD=0.406 PS=3.38 PD=3.38
M$640 \$19 bias_a VSS sky130_gnd sky130_fd_pr__nfet_01v8 L=0.6 W=1.4 AS=0.406
+ AD=0.406 PS=3.38 PD=3.38
M$641 \$19 bias_a VSS sky130_gnd sky130_fd_pr__nfet_01v8 L=0.6 W=1.4 AS=0.406
+ AD=0.406 PS=3.38 PD=3.38
M$642 \$19 bias_a VSS sky130_gnd sky130_fd_pr__nfet_01v8 L=0.6 W=1.4 AS=0.406
+ AD=0.406 PS=3.38 PD=3.38
M$643 \$19 bias_a VSS sky130_gnd sky130_fd_pr__nfet_01v8 L=0.6 W=1.4 AS=0.406
+ AD=0.406 PS=3.38 PD=3.38
M$644 \$19 bias_a VSS sky130_gnd sky130_fd_pr__nfet_01v8 L=0.6 W=1.4 AS=0.406
+ AD=0.406 PS=3.38 PD=3.38
M$645 \$19 bias_a VSS sky130_gnd sky130_fd_pr__nfet_01v8 L=0.6 W=1.4 AS=0.406
+ AD=0.406 PS=3.38 PD=3.38
M$646 \$19 bias_a VSS sky130_gnd sky130_fd_pr__nfet_01v8 L=0.6 W=1.4 AS=0.406
+ AD=0.406 PS=3.38 PD=3.38
M$647 \$19 bias_a VSS sky130_gnd sky130_fd_pr__nfet_01v8 L=0.6 W=1.4 AS=0.406
+ AD=0.406 PS=3.38 PD=3.38
M$648 \$19 bias_a VSS sky130_gnd sky130_fd_pr__nfet_01v8 L=0.6 W=1.4 AS=0.406
+ AD=0.406 PS=3.38 PD=3.38
M$649 \$19 bias_a VSS sky130_gnd sky130_fd_pr__nfet_01v8 L=0.6 W=1.4 AS=0.406
+ AD=0.406 PS=3.38 PD=3.38
M$650 \$19 bias_a VSS sky130_gnd sky130_fd_pr__nfet_01v8 L=0.6 W=1.4 AS=0.406
+ AD=0.406 PS=3.38 PD=3.38
M$651 \$19 bias_a VSS sky130_gnd sky130_fd_pr__nfet_01v8 L=0.6 W=1.4 AS=0.406
+ AD=0.406 PS=3.38 PD=3.38
M$652 \$19 bias_a VSS sky130_gnd sky130_fd_pr__nfet_01v8 L=0.6 W=1.4 AS=0.406
+ AD=0.406 PS=3.38 PD=3.38
M$653 \$19 bias_a VSS sky130_gnd sky130_fd_pr__nfet_01v8 L=0.6 W=1.4 AS=0.406
+ AD=0.406 PS=3.38 PD=3.38
M$654 \$19 bias_a VSS sky130_gnd sky130_fd_pr__nfet_01v8 L=0.6 W=1.4 AS=0.406
+ AD=0.406 PS=3.38 PD=3.38
M$655 \$19 bias_a VSS sky130_gnd sky130_fd_pr__nfet_01v8 L=0.6 W=1.4 AS=0.406
+ AD=0.406 PS=3.38 PD=3.38
M$656 \$19 bias_a VSS sky130_gnd sky130_fd_pr__nfet_01v8 L=0.6 W=1.4 AS=0.406
+ AD=0.406 PS=3.38 PD=3.38
M$657 \$19 bias_a VSS sky130_gnd sky130_fd_pr__nfet_01v8 L=0.6 W=1.4 AS=0.406
+ AD=0.406 PS=3.38 PD=3.38
M$658 \$19 bias_a VSS sky130_gnd sky130_fd_pr__nfet_01v8 L=0.6 W=1.4 AS=0.406
+ AD=0.406 PS=3.38 PD=3.38
M$659 \$19 bias_a VSS sky130_gnd sky130_fd_pr__nfet_01v8 L=0.6 W=1.4 AS=0.406
+ AD=0.406 PS=3.38 PD=3.38
M$660 \$19 bias_a VSS sky130_gnd sky130_fd_pr__nfet_01v8 L=0.6 W=1.4 AS=0.406
+ AD=0.406 PS=3.38 PD=3.38
M$661 \$19 bias_a VSS sky130_gnd sky130_fd_pr__nfet_01v8 L=0.6 W=1.4 AS=0.406
+ AD=0.406 PS=3.38 PD=3.38
M$662 \$19 bias_a VSS sky130_gnd sky130_fd_pr__nfet_01v8 L=0.6 W=1.4 AS=0.406
+ AD=0.406 PS=3.38 PD=3.38
M$663 \$19 bias_a VSS sky130_gnd sky130_fd_pr__nfet_01v8 L=0.6 W=1.4 AS=0.406
+ AD=0.406 PS=3.38 PD=3.38
M$664 \$19 bias_a VSS sky130_gnd sky130_fd_pr__nfet_01v8 L=0.6 W=1.4 AS=0.406
+ AD=0.406 PS=3.38 PD=3.38
M$665 \$19 bias_a VSS sky130_gnd sky130_fd_pr__nfet_01v8 L=0.6 W=1.4 AS=0.406
+ AD=0.406 PS=3.38 PD=3.38
M$666 \$19 bias_a VSS sky130_gnd sky130_fd_pr__nfet_01v8 L=0.6 W=1.4 AS=0.406
+ AD=0.406 PS=3.38 PD=3.38
M$667 \$19 bias_a VSS sky130_gnd sky130_fd_pr__nfet_01v8 L=0.6 W=1.4 AS=0.406
+ AD=0.406 PS=3.38 PD=3.38
M$668 \$19 bias_a VSS sky130_gnd sky130_fd_pr__nfet_01v8 L=0.6 W=1.4 AS=0.406
+ AD=0.406 PS=3.38 PD=3.38
M$669 \$19 bias_a VSS sky130_gnd sky130_fd_pr__nfet_01v8 L=0.6 W=1.4 AS=0.406
+ AD=0.406 PS=3.38 PD=3.38
M$670 \$1 cmc VSS sky130_gnd sky130_fd_pr__nfet_01v8 L=0.6 W=1.4 AS=0.406
+ AD=0.406 PS=3.38 PD=3.38
M$671 \$1 cmc VSS sky130_gnd sky130_fd_pr__nfet_01v8 L=0.6 W=1.4 AS=0.406
+ AD=0.406 PS=3.38 PD=3.38
M$672 \$1 bias_a VSS sky130_gnd sky130_fd_pr__nfet_01v8 L=0.6 W=1.4 AS=0.406
+ AD=0.406 PS=3.38 PD=3.38
M$673 \$1 cmc VSS sky130_gnd sky130_fd_pr__nfet_01v8 L=0.6 W=1.4 AS=0.406
+ AD=0.406 PS=3.38 PD=3.38
M$674 \$1 bias_a VSS sky130_gnd sky130_fd_pr__nfet_01v8 L=0.6 W=1.4 AS=0.406
+ AD=0.406 PS=3.38 PD=3.38
M$675 \$1 cmc VSS sky130_gnd sky130_fd_pr__nfet_01v8 L=0.6 W=1.4 AS=0.406
+ AD=0.406 PS=3.38 PD=3.38
M$676 \$1 bias_a VSS sky130_gnd sky130_fd_pr__nfet_01v8 L=0.6 W=1.4 AS=0.406
+ AD=0.406 PS=3.38 PD=3.38
M$677 \$1 bias_a VSS sky130_gnd sky130_fd_pr__nfet_01v8 L=0.6 W=1.4 AS=0.406
+ AD=0.406 PS=3.38 PD=3.38
M$678 \$1 cmc VSS sky130_gnd sky130_fd_pr__nfet_01v8 L=0.6 W=1.4 AS=0.406
+ AD=0.406 PS=3.38 PD=3.38
M$679 \$1 cmc VSS sky130_gnd sky130_fd_pr__nfet_01v8 L=0.6 W=1.4 AS=0.406
+ AD=0.406 PS=3.38 PD=3.38
M$680 \$1 cmc VSS sky130_gnd sky130_fd_pr__nfet_01v8 L=0.6 W=1.4 AS=0.406
+ AD=0.406 PS=3.38 PD=3.38
M$681 \$1 cmc VSS sky130_gnd sky130_fd_pr__nfet_01v8 L=0.6 W=1.4 AS=0.406
+ AD=0.406 PS=3.38 PD=3.38
M$682 \$1 bias_a VSS sky130_gnd sky130_fd_pr__nfet_01v8 L=0.6 W=1.4 AS=0.406
+ AD=0.406 PS=3.38 PD=3.38
M$683 \$1 bias_a VSS sky130_gnd sky130_fd_pr__nfet_01v8 L=0.6 W=1.4 AS=0.406
+ AD=0.406 PS=3.38 PD=3.38
M$684 \$1 cmc VSS sky130_gnd sky130_fd_pr__nfet_01v8 L=0.6 W=1.4 AS=0.406
+ AD=0.406 PS=3.38 PD=3.38
M$685 \$1 bias_a VSS sky130_gnd sky130_fd_pr__nfet_01v8 L=0.6 W=1.4 AS=0.406
+ AD=0.406 PS=3.38 PD=3.38
M$686 \$1 cmc VSS sky130_gnd sky130_fd_pr__nfet_01v8 L=0.6 W=1.4 AS=0.406
+ AD=0.406 PS=3.38 PD=3.38
M$687 \$1 bias_a VSS sky130_gnd sky130_fd_pr__nfet_01v8 L=0.6 W=1.4 AS=0.406
+ AD=0.406 PS=3.38 PD=3.38
M$688 \$1 cmc VSS sky130_gnd sky130_fd_pr__nfet_01v8 L=0.6 W=1.4 AS=0.406
+ AD=0.406 PS=3.38 PD=3.38
M$689 \$1 bias_a VSS sky130_gnd sky130_fd_pr__nfet_01v8 L=0.6 W=1.4 AS=0.406
+ AD=0.406 PS=3.38 PD=3.38
M$690 \$1 cmc VSS sky130_gnd sky130_fd_pr__nfet_01v8 L=0.6 W=1.4 AS=0.406
+ AD=0.406 PS=3.38 PD=3.38
M$691 \$1 bias_a VSS sky130_gnd sky130_fd_pr__nfet_01v8 L=0.6 W=1.4 AS=0.406
+ AD=0.406 PS=3.38 PD=3.38
M$692 \$1 cmc VSS sky130_gnd sky130_fd_pr__nfet_01v8 L=0.6 W=1.4 AS=0.406
+ AD=0.406 PS=3.38 PD=3.38
M$693 \$1 bias_a VSS sky130_gnd sky130_fd_pr__nfet_01v8 L=0.6 W=1.4 AS=0.406
+ AD=0.406 PS=3.38 PD=3.38
M$694 \$1 cmc VSS sky130_gnd sky130_fd_pr__nfet_01v8 L=0.6 W=1.4 AS=0.406
+ AD=0.406 PS=3.38 PD=3.38
M$695 \$1 bias_a VSS sky130_gnd sky130_fd_pr__nfet_01v8 L=0.6 W=1.4 AS=0.406
+ AD=0.406 PS=3.38 PD=3.38
M$696 \$1 bias_a VSS sky130_gnd sky130_fd_pr__nfet_01v8 L=0.6 W=1.4 AS=0.406
+ AD=0.406 PS=3.38 PD=3.38
M$697 \$1 bias_a VSS sky130_gnd sky130_fd_pr__nfet_01v8 L=0.6 W=1.4 AS=0.406
+ AD=0.406 PS=3.38 PD=3.38
M$698 \$1 cmc VSS sky130_gnd sky130_fd_pr__nfet_01v8 L=0.6 W=1.4 AS=0.406
+ AD=0.406 PS=3.38 PD=3.38
M$699 \$1 bias_a VSS sky130_gnd sky130_fd_pr__nfet_01v8 L=0.6 W=1.4 AS=0.406
+ AD=0.406 PS=3.38 PD=3.38
M$700 \$1 bias_a VSS sky130_gnd sky130_fd_pr__nfet_01v8 L=0.6 W=1.4 AS=0.406
+ AD=0.406 PS=3.38 PD=3.38
M$701 \$1 cmc VSS sky130_gnd sky130_fd_pr__nfet_01v8 L=0.6 W=1.4 AS=0.406
+ AD=0.406 PS=3.38 PD=3.38
M$702 \$1 cmc VSS sky130_gnd sky130_fd_pr__nfet_01v8 L=0.6 W=1.4 AS=0.406
+ AD=0.406 PS=3.38 PD=3.38
M$703 \$1 bias_a VSS sky130_gnd sky130_fd_pr__nfet_01v8 L=0.6 W=1.4 AS=0.406
+ AD=0.406 PS=3.38 PD=3.38
M$704 \$1 bias_a VSS sky130_gnd sky130_fd_pr__nfet_01v8 L=0.6 W=1.4 AS=0.406
+ AD=0.406 PS=3.38 PD=3.38
M$705 \$1 cmc VSS sky130_gnd sky130_fd_pr__nfet_01v8 L=0.6 W=1.4 AS=0.406
+ AD=0.406 PS=3.38 PD=3.38
M$706 \$1 cmc VSS sky130_gnd sky130_fd_pr__nfet_01v8 L=0.6 W=1.4 AS=0.406
+ AD=0.406 PS=3.38 PD=3.38
M$707 \$1 bias_a VSS sky130_gnd sky130_fd_pr__nfet_01v8 L=0.6 W=1.4 AS=0.406
+ AD=0.406 PS=3.38 PD=3.38
M$708 \$1 cmc VSS sky130_gnd sky130_fd_pr__nfet_01v8 L=0.6 W=1.4 AS=0.406
+ AD=0.406 PS=3.38 PD=3.38
M$709 \$1 cmc VSS sky130_gnd sky130_fd_pr__nfet_01v8 L=0.6 W=1.4 AS=0.406
+ AD=0.406 PS=3.38 PD=3.38
M$710 \$1 bias_a VSS sky130_gnd sky130_fd_pr__nfet_01v8 L=0.6 W=1.4 AS=0.406
+ AD=0.406 PS=3.38 PD=3.38
M$711 \$1 cmc VSS sky130_gnd sky130_fd_pr__nfet_01v8 L=0.6 W=1.4 AS=0.406
+ AD=0.406 PS=3.38 PD=3.38
M$712 \$1 cmc VSS sky130_gnd sky130_fd_pr__nfet_01v8 L=0.6 W=1.4 AS=0.406
+ AD=0.406 PS=3.38 PD=3.38
M$713 \$1 bias_a VSS sky130_gnd sky130_fd_pr__nfet_01v8 L=0.6 W=1.4 AS=0.406
+ AD=0.406 PS=3.38 PD=3.38
M$714 \$1 cmc VSS sky130_gnd sky130_fd_pr__nfet_01v8 L=0.6 W=1.4 AS=0.406
+ AD=0.406 PS=3.38 PD=3.38
M$715 \$1 bias_a VSS sky130_gnd sky130_fd_pr__nfet_01v8 L=0.6 W=1.4 AS=0.406
+ AD=0.406 PS=3.38 PD=3.38
M$716 \$1 bias_a VSS sky130_gnd sky130_fd_pr__nfet_01v8 L=0.6 W=1.4 AS=0.406
+ AD=0.406 PS=3.38 PD=3.38
M$717 \$1 cmc VSS sky130_gnd sky130_fd_pr__nfet_01v8 L=0.6 W=1.4 AS=0.406
+ AD=0.406 PS=3.38 PD=3.38
M$718 \$1 bias_a VSS sky130_gnd sky130_fd_pr__nfet_01v8 L=0.6 W=1.4 AS=0.406
+ AD=0.406 PS=3.38 PD=3.38
M$719 \$1 cmc VSS sky130_gnd sky130_fd_pr__nfet_01v8 L=0.6 W=1.4 AS=0.406
+ AD=0.406 PS=3.38 PD=3.38
M$720 \$1 bias_a VSS sky130_gnd sky130_fd_pr__nfet_01v8 L=0.6 W=1.4 AS=0.406
+ AD=0.406 PS=3.38 PD=3.38
M$721 \$1 bias_a VSS sky130_gnd sky130_fd_pr__nfet_01v8 L=0.6 W=1.4 AS=0.406
+ AD=0.406 PS=3.38 PD=3.38
M$722 \$1 bias_a VSS sky130_gnd sky130_fd_pr__nfet_01v8 L=0.6 W=1.4 AS=0.406
+ AD=0.406 PS=3.38 PD=3.38
M$723 \$1 bias_a VSS sky130_gnd sky130_fd_pr__nfet_01v8 L=0.6 W=1.4 AS=0.406
+ AD=0.406 PS=3.38 PD=3.38
M$724 \$1 cmc VSS sky130_gnd sky130_fd_pr__nfet_01v8 L=0.6 W=1.4 AS=0.406
+ AD=0.406 PS=3.38 PD=3.38
M$725 \$1 bias_a VSS sky130_gnd sky130_fd_pr__nfet_01v8 L=0.6 W=1.4 AS=0.406
+ AD=0.406 PS=3.38 PD=3.38
M$726 \$1 cmc VSS sky130_gnd sky130_fd_pr__nfet_01v8 L=0.6 W=1.4 AS=0.406
+ AD=0.406 PS=3.38 PD=3.38
M$727 \$1 cmc VSS sky130_gnd sky130_fd_pr__nfet_01v8 L=0.6 W=1.4 AS=0.406
+ AD=0.406 PS=3.38 PD=3.38
M$728 \$1 bias_a VSS sky130_gnd sky130_fd_pr__nfet_01v8 L=0.6 W=1.4 AS=0.406
+ AD=0.406 PS=3.38 PD=3.38
M$729 \$1 cmc VSS sky130_gnd sky130_fd_pr__nfet_01v8 L=0.6 W=1.4 AS=0.406
+ AD=0.406 PS=3.38 PD=3.38
M$730 \$1 bias_a VSS sky130_gnd sky130_fd_pr__nfet_01v8 L=0.6 W=1.4 AS=0.406
+ AD=0.406 PS=3.38 PD=3.38
M$731 \$1 cmc VSS sky130_gnd sky130_fd_pr__nfet_01v8 L=0.6 W=1.4 AS=0.406
+ AD=0.406 PS=3.38 PD=3.38
M$732 \$1 bias_a VSS sky130_gnd sky130_fd_pr__nfet_01v8 L=0.6 W=1.4 AS=0.406
+ AD=0.406 PS=3.38 PD=3.38
M$733 \$1 cmc VSS sky130_gnd sky130_fd_pr__nfet_01v8 L=0.6 W=1.4 AS=0.406
+ AD=0.406 PS=3.38 PD=3.38
M$734 \$1 bias_a VSS sky130_gnd sky130_fd_pr__nfet_01v8 L=0.6 W=1.4 AS=0.406
+ AD=0.406 PS=3.38 PD=3.38
M$735 \$1 cmc VSS sky130_gnd sky130_fd_pr__nfet_01v8 L=0.6 W=1.4 AS=0.406
+ AD=0.406 PS=3.38 PD=3.38
M$736 \$1 bias_a VSS sky130_gnd sky130_fd_pr__nfet_01v8 L=0.6 W=1.4 AS=0.406
+ AD=0.406 PS=3.38 PD=3.38
M$737 \$1 cmc VSS sky130_gnd sky130_fd_pr__nfet_01v8 L=0.6 W=1.4 AS=0.406
+ AD=0.406 PS=3.38 PD=3.38
M$738 \$1 bias_a VSS sky130_gnd sky130_fd_pr__nfet_01v8 L=0.6 W=1.4 AS=0.406
+ AD=0.406 PS=3.38 PD=3.38
M$739 \$1 bias_a VSS sky130_gnd sky130_fd_pr__nfet_01v8 L=0.6 W=1.4 AS=0.406
+ AD=0.406 PS=3.38 PD=3.38
M$740 \$1 cmc VSS sky130_gnd sky130_fd_pr__nfet_01v8 L=0.6 W=1.4 AS=0.406
+ AD=0.406 PS=3.38 PD=3.38
M$741 \$1 cmc VSS sky130_gnd sky130_fd_pr__nfet_01v8 L=0.6 W=1.4 AS=0.406
+ AD=0.406 PS=3.38 PD=3.38
M$742 \$1 bias_a VSS sky130_gnd sky130_fd_pr__nfet_01v8 L=0.6 W=1.4 AS=0.406
+ AD=0.406 PS=3.38 PD=3.38
M$743 \$1 cmc VSS sky130_gnd sky130_fd_pr__nfet_01v8 L=0.6 W=1.4 AS=0.406
+ AD=0.406 PS=3.38 PD=3.38
M$744 \$1 cmc VSS sky130_gnd sky130_fd_pr__nfet_01v8 L=0.6 W=1.4 AS=0.406
+ AD=0.406 PS=3.38 PD=3.38
M$745 \$1 bias_a VSS sky130_gnd sky130_fd_pr__nfet_01v8 L=0.6 W=1.4 AS=0.406
+ AD=0.406 PS=3.38 PD=3.38
M$746 \$1 cmc VSS sky130_gnd sky130_fd_pr__nfet_01v8 L=0.6 W=1.4 AS=0.406
+ AD=0.406 PS=3.38 PD=3.38
M$747 \$1 cmc VSS sky130_gnd sky130_fd_pr__nfet_01v8 L=0.6 W=1.4 AS=0.406
+ AD=0.406 PS=3.38 PD=3.38
M$748 \$1 bias_a VSS sky130_gnd sky130_fd_pr__nfet_01v8 L=0.6 W=1.4 AS=0.406
+ AD=0.406 PS=3.38 PD=3.38
M$749 \$1 cmc VSS sky130_gnd sky130_fd_pr__nfet_01v8 L=0.6 W=1.4 AS=0.406
+ AD=0.406 PS=3.38 PD=3.38
M$750 \$1 bias_a VSS sky130_gnd sky130_fd_pr__nfet_01v8 L=0.6 W=1.4 AS=0.406
+ AD=0.406 PS=3.38 PD=3.38
M$751 \$1 cmc VSS sky130_gnd sky130_fd_pr__nfet_01v8 L=0.6 W=1.4 AS=0.406
+ AD=0.406 PS=3.38 PD=3.38
M$752 \$1 bias_a VSS sky130_gnd sky130_fd_pr__nfet_01v8 L=0.6 W=1.4 AS=0.406
+ AD=0.406 PS=3.38 PD=3.38
M$753 \$1 cmc VSS sky130_gnd sky130_fd_pr__nfet_01v8 L=0.6 W=1.4 AS=0.406
+ AD=0.406 PS=3.38 PD=3.38
M$754 \$1 bias_a VSS sky130_gnd sky130_fd_pr__nfet_01v8 L=0.6 W=1.4 AS=0.406
+ AD=0.406 PS=3.38 PD=3.38
M$755 \$1 cmc VSS sky130_gnd sky130_fd_pr__nfet_01v8 L=0.6 W=1.4 AS=0.406
+ AD=0.406 PS=3.38 PD=3.38
M$756 \$1 bias_a VSS sky130_gnd sky130_fd_pr__nfet_01v8 L=0.6 W=1.4 AS=0.406
+ AD=0.406 PS=3.38 PD=3.38
M$757 \$1 cmc VSS sky130_gnd sky130_fd_pr__nfet_01v8 L=0.6 W=1.4 AS=0.406
+ AD=0.406 PS=3.38 PD=3.38
M$758 \$1 bias_a VSS sky130_gnd sky130_fd_pr__nfet_01v8 L=0.6 W=1.4 AS=0.406
+ AD=0.406 PS=3.38 PD=3.38
M$759 \$1 cmc VSS sky130_gnd sky130_fd_pr__nfet_01v8 L=0.6 W=1.4 AS=0.406
+ AD=0.406 PS=3.38 PD=3.38
M$760 \$1 bias_a VSS sky130_gnd sky130_fd_pr__nfet_01v8 L=0.6 W=1.4 AS=0.406
+ AD=0.406 PS=3.38 PD=3.38
M$761 \$1 cmc VSS sky130_gnd sky130_fd_pr__nfet_01v8 L=0.6 W=1.4 AS=0.406
+ AD=0.406 PS=3.38 PD=3.38
M$762 \$1 bias_a VSS sky130_gnd sky130_fd_pr__nfet_01v8 L=0.6 W=1.4 AS=0.406
+ AD=0.406 PS=3.38 PD=3.38
M$763 \$1 bias_a VSS sky130_gnd sky130_fd_pr__nfet_01v8 L=0.6 W=1.4 AS=0.406
+ AD=0.406 PS=3.38 PD=3.38
M$764 \$1 cmc VSS sky130_gnd sky130_fd_pr__nfet_01v8 L=0.6 W=1.4 AS=0.406
+ AD=0.406 PS=3.38 PD=3.38
M$765 \$1 bias_a VSS sky130_gnd sky130_fd_pr__nfet_01v8 L=0.6 W=1.4 AS=0.406
+ AD=0.406 PS=3.38 PD=3.38
M$766 \$1 cmc VSS sky130_gnd sky130_fd_pr__nfet_01v8 L=0.6 W=1.4 AS=0.406
+ AD=0.406 PS=3.38 PD=3.38
M$767 \$1 bias_a VSS sky130_gnd sky130_fd_pr__nfet_01v8 L=0.6 W=1.4 AS=0.406
+ AD=0.406 PS=3.38 PD=3.38
M$768 \$1 bias_a VSS sky130_gnd sky130_fd_pr__nfet_01v8 L=0.6 W=1.4 AS=0.406
+ AD=0.406 PS=3.38 PD=3.38
M$769 \$1 cmc VSS sky130_gnd sky130_fd_pr__nfet_01v8 L=0.6 W=1.4 AS=0.406
+ AD=0.406 PS=3.38 PD=3.38
M$770 \$1 bias_a VSS sky130_gnd sky130_fd_pr__nfet_01v8 L=0.6 W=1.4 AS=0.406
+ AD=0.406 PS=3.38 PD=3.38
M$771 \$1 cmc VSS sky130_gnd sky130_fd_pr__nfet_01v8 L=0.6 W=1.4 AS=0.406
+ AD=0.406 PS=3.38 PD=3.38
M$772 \$1 bias_a VSS sky130_gnd sky130_fd_pr__nfet_01v8 L=0.6 W=1.4 AS=0.406
+ AD=0.406 PS=3.38 PD=3.38
M$773 \$1 cmc VSS sky130_gnd sky130_fd_pr__nfet_01v8 L=0.6 W=1.4 AS=0.406
+ AD=0.406 PS=3.38 PD=3.38
M$774 \$1 bias_a VSS sky130_gnd sky130_fd_pr__nfet_01v8 L=0.6 W=1.4 AS=0.406
+ AD=0.406 PS=3.38 PD=3.38
M$775 \$1 cmc VSS sky130_gnd sky130_fd_pr__nfet_01v8 L=0.6 W=1.4 AS=0.406
+ AD=0.406 PS=3.38 PD=3.38
M$776 \$1 bias_a VSS sky130_gnd sky130_fd_pr__nfet_01v8 L=0.6 W=1.4 AS=0.406
+ AD=0.406 PS=3.38 PD=3.38
M$777 \$1 bias_a VSS sky130_gnd sky130_fd_pr__nfet_01v8 L=0.6 W=1.4 AS=0.406
+ AD=0.406 PS=3.38 PD=3.38
M$778 \$1 cmc VSS sky130_gnd sky130_fd_pr__nfet_01v8 L=0.6 W=1.4 AS=0.406
+ AD=0.406 PS=3.38 PD=3.38
M$779 \$1 cmc VSS sky130_gnd sky130_fd_pr__nfet_01v8 L=0.6 W=1.4 AS=0.406
+ AD=0.406 PS=3.38 PD=3.38
M$780 \$1 bias_a VSS sky130_gnd sky130_fd_pr__nfet_01v8 L=0.6 W=1.4 AS=0.406
+ AD=0.406 PS=3.38 PD=3.38
M$781 \$1 cmc VSS sky130_gnd sky130_fd_pr__nfet_01v8 L=0.6 W=1.4 AS=0.406
+ AD=0.406 PS=3.38 PD=3.38
M$782 \$1 cmc VSS sky130_gnd sky130_fd_pr__nfet_01v8 L=0.6 W=1.4 AS=0.406
+ AD=0.406 PS=3.38 PD=3.38
M$783 \$1 bias_a VSS sky130_gnd sky130_fd_pr__nfet_01v8 L=0.6 W=1.4 AS=0.406
+ AD=0.406 PS=3.38 PD=3.38
M$784 \$1 cmc VSS sky130_gnd sky130_fd_pr__nfet_01v8 L=0.6 W=1.4 AS=0.406
+ AD=0.406 PS=3.38 PD=3.38
M$785 \$1 bias_a VSS sky130_gnd sky130_fd_pr__nfet_01v8 L=0.6 W=1.4 AS=0.406
+ AD=0.406 PS=3.38 PD=3.38
M$786 \$1 cmc VSS sky130_gnd sky130_fd_pr__nfet_01v8 L=0.6 W=1.4 AS=0.406
+ AD=0.406 PS=3.38 PD=3.38
M$787 \$1 bias_a VSS sky130_gnd sky130_fd_pr__nfet_01v8 L=0.6 W=1.4 AS=0.406
+ AD=0.406 PS=3.38 PD=3.38
M$788 \$1 cmc VSS sky130_gnd sky130_fd_pr__nfet_01v8 L=0.6 W=1.4 AS=0.406
+ AD=0.406 PS=3.38 PD=3.38
M$789 \$1 bias_a VSS sky130_gnd sky130_fd_pr__nfet_01v8 L=0.6 W=1.4 AS=0.406
+ AD=0.406 PS=3.38 PD=3.38
M$790 \$1 cmc VSS sky130_gnd sky130_fd_pr__nfet_01v8 L=0.6 W=1.4 AS=0.406
+ AD=0.406 PS=3.38 PD=3.38
M$791 \$1 bias_a VSS sky130_gnd sky130_fd_pr__nfet_01v8 L=0.6 W=1.4 AS=0.406
+ AD=0.406 PS=3.38 PD=3.38
M$792 \$1 cmc VSS sky130_gnd sky130_fd_pr__nfet_01v8 L=0.6 W=1.4 AS=0.406
+ AD=0.406 PS=3.38 PD=3.38
M$793 \$1 bias_a VSS sky130_gnd sky130_fd_pr__nfet_01v8 L=0.6 W=1.4 AS=0.406
+ AD=0.406 PS=3.38 PD=3.38
M$794 \$1 cmc VSS sky130_gnd sky130_fd_pr__nfet_01v8 L=0.6 W=1.4 AS=0.406
+ AD=0.406 PS=3.38 PD=3.38
M$795 \$1 bias_a VSS sky130_gnd sky130_fd_pr__nfet_01v8 L=0.6 W=1.4 AS=0.406
+ AD=0.406 PS=3.38 PD=3.38
M$796 \$1 cmc VSS sky130_gnd sky130_fd_pr__nfet_01v8 L=0.6 W=1.4 AS=0.406
+ AD=0.406 PS=3.38 PD=3.38
M$797 \$1 bias_a VSS sky130_gnd sky130_fd_pr__nfet_01v8 L=0.6 W=1.4 AS=0.406
+ AD=0.406 PS=3.38 PD=3.38
M$798 \$1 cmc VSS sky130_gnd sky130_fd_pr__nfet_01v8 L=0.6 W=1.4 AS=0.406
+ AD=0.406 PS=3.38 PD=3.38
M$799 \$1 bias_a VSS sky130_gnd sky130_fd_pr__nfet_01v8 L=0.6 W=1.4 AS=0.406
+ AD=0.406 PS=3.38 PD=3.38
M$800 \$1 cmc VSS sky130_gnd sky130_fd_pr__nfet_01v8 L=0.6 W=1.4 AS=0.406
+ AD=0.406 PS=3.38 PD=3.38
M$801 \$1 bias_a VSS sky130_gnd sky130_fd_pr__nfet_01v8 L=0.6 W=1.4 AS=0.406
+ AD=0.406 PS=3.38 PD=3.38
M$802 \$1 cmc VSS sky130_gnd sky130_fd_pr__nfet_01v8 L=0.6 W=1.4 AS=0.406
+ AD=0.406 PS=3.38 PD=3.38
M$803 \$1 bias_a VSS sky130_gnd sky130_fd_pr__nfet_01v8 L=0.6 W=1.4 AS=0.406
+ AD=0.406 PS=3.38 PD=3.38
M$804 \$1 cmc VSS sky130_gnd sky130_fd_pr__nfet_01v8 L=0.6 W=1.4 AS=0.406
+ AD=0.406 PS=3.38 PD=3.38
M$805 \$1 bias_a VSS sky130_gnd sky130_fd_pr__nfet_01v8 L=0.6 W=1.4 AS=0.406
+ AD=0.406 PS=3.38 PD=3.38
M$806 \$1 cmc VSS sky130_gnd sky130_fd_pr__nfet_01v8 L=0.6 W=1.4 AS=0.406
+ AD=0.406 PS=3.38 PD=3.38
M$807 \$1 bias_a VSS sky130_gnd sky130_fd_pr__nfet_01v8 L=0.6 W=1.4 AS=0.406
+ AD=0.406 PS=3.38 PD=3.38
M$808 \$1 cmc VSS sky130_gnd sky130_fd_pr__nfet_01v8 L=0.6 W=1.4 AS=0.406
+ AD=0.406 PS=3.38 PD=3.38
M$809 \$1 bias_a VSS sky130_gnd sky130_fd_pr__nfet_01v8 L=0.6 W=1.4 AS=0.406
+ AD=0.406 PS=3.38 PD=3.38
M$810 \$1 cmc VSS sky130_gnd sky130_fd_pr__nfet_01v8 L=0.6 W=1.4 AS=0.406
+ AD=0.406 PS=3.38 PD=3.38
M$811 \$1 cmc VSS sky130_gnd sky130_fd_pr__nfet_01v8 L=0.6 W=1.4 AS=0.406
+ AD=0.406 PS=3.38 PD=3.38
M$812 \$1 bias_a VSS sky130_gnd sky130_fd_pr__nfet_01v8 L=0.6 W=1.4 AS=0.406
+ AD=0.406 PS=3.38 PD=3.38
M$813 \$1 cmc VSS sky130_gnd sky130_fd_pr__nfet_01v8 L=0.6 W=1.4 AS=0.406
+ AD=0.406 PS=3.38 PD=3.38
M$814 \$1 cmc VSS sky130_gnd sky130_fd_pr__nfet_01v8 L=0.6 W=1.4 AS=0.406
+ AD=0.406 PS=3.38 PD=3.38
M$815 \$1 bias_a VSS sky130_gnd sky130_fd_pr__nfet_01v8 L=0.6 W=1.4 AS=0.406
+ AD=0.406 PS=3.38 PD=3.38
M$816 \$1 bias_a VSS sky130_gnd sky130_fd_pr__nfet_01v8 L=0.6 W=1.4 AS=0.406
+ AD=0.406 PS=3.38 PD=3.38
M$817 \$1 cmc VSS sky130_gnd sky130_fd_pr__nfet_01v8 L=0.6 W=1.4 AS=0.406
+ AD=0.406 PS=3.38 PD=3.38
M$818 \$1 bias_a VSS sky130_gnd sky130_fd_pr__nfet_01v8 L=0.6 W=1.4 AS=0.406
+ AD=0.406 PS=3.38 PD=3.38
M$819 \$1 cmc VSS sky130_gnd sky130_fd_pr__nfet_01v8 L=0.6 W=1.4 AS=0.406
+ AD=0.406 PS=3.38 PD=3.38
M$820 \$1 bias_a VSS sky130_gnd sky130_fd_pr__nfet_01v8 L=0.6 W=1.4 AS=0.406
+ AD=0.406 PS=3.38 PD=3.38
M$821 \$1 bias_a VSS sky130_gnd sky130_fd_pr__nfet_01v8 L=0.6 W=1.4 AS=0.406
+ AD=0.406 PS=3.38 PD=3.38
M$822 \$1 cmc VSS sky130_gnd sky130_fd_pr__nfet_01v8 L=0.6 W=1.4 AS=0.406
+ AD=0.406 PS=3.38 PD=3.38
M$823 \$1 cmc VSS sky130_gnd sky130_fd_pr__nfet_01v8 L=0.6 W=1.4 AS=0.406
+ AD=0.406 PS=3.38 PD=3.38
M$824 \$1 bias_a VSS sky130_gnd sky130_fd_pr__nfet_01v8 L=0.6 W=1.4 AS=0.406
+ AD=0.406 PS=3.38 PD=3.38
M$825 \$1 bias_a VSS sky130_gnd sky130_fd_pr__nfet_01v8 L=0.6 W=1.4 AS=0.406
+ AD=0.406 PS=3.38 PD=3.38
M$826 \$1 cmc VSS sky130_gnd sky130_fd_pr__nfet_01v8 L=0.6 W=1.4 AS=0.406
+ AD=0.406 PS=3.38 PD=3.38
M$827 \$1 cmc VSS sky130_gnd sky130_fd_pr__nfet_01v8 L=0.6 W=1.4 AS=0.406
+ AD=0.406 PS=3.38 PD=3.38
M$828 \$1 bias_a VSS sky130_gnd sky130_fd_pr__nfet_01v8 L=0.6 W=1.4 AS=0.406
+ AD=0.406 PS=3.38 PD=3.38
M$829 \$1 cmc VSS sky130_gnd sky130_fd_pr__nfet_01v8 L=0.6 W=1.4 AS=0.406
+ AD=0.406 PS=3.38 PD=3.38
M$830 \$1 bias_a VSS sky130_gnd sky130_fd_pr__nfet_01v8 L=0.6 W=1.4 AS=0.406
+ AD=0.406 PS=3.38 PD=3.38
M$831 \$1 cmc VSS sky130_gnd sky130_fd_pr__nfet_01v8 L=0.6 W=1.4 AS=0.406
+ AD=0.406 PS=3.38 PD=3.38
M$832 \$1 bias_a VSS sky130_gnd sky130_fd_pr__nfet_01v8 L=0.6 W=1.4 AS=0.406
+ AD=0.406 PS=3.38 PD=3.38
M$833 \$1 cmc VSS sky130_gnd sky130_fd_pr__nfet_01v8 L=0.6 W=1.4 AS=0.406
+ AD=0.406 PS=3.38 PD=3.38
M$834 \$1 bias_a VSS sky130_gnd sky130_fd_pr__nfet_01v8 L=0.6 W=1.4 AS=0.406
+ AD=0.406 PS=3.38 PD=3.38
M$835 \$1 bias_a VSS sky130_gnd sky130_fd_pr__nfet_01v8 L=0.6 W=1.4 AS=0.406
+ AD=0.406 PS=3.38 PD=3.38
M$836 \$1 bias_a VSS sky130_gnd sky130_fd_pr__nfet_01v8 L=0.6 W=1.4 AS=0.406
+ AD=0.406 PS=3.38 PD=3.38
M$837 \$1 cmc VSS sky130_gnd sky130_fd_pr__nfet_01v8 L=0.6 W=1.4 AS=0.406
+ AD=0.406 PS=3.38 PD=3.38
M$838 \$1 bias_a VSS sky130_gnd sky130_fd_pr__nfet_01v8 L=0.6 W=1.4 AS=0.406
+ AD=0.406 PS=3.38 PD=3.38
M$839 \$1 cmc VSS sky130_gnd sky130_fd_pr__nfet_01v8 L=0.6 W=1.4 AS=0.406
+ AD=0.406 PS=3.38 PD=3.38
M$840 \$1 bias_a VSS sky130_gnd sky130_fd_pr__nfet_01v8 L=0.6 W=1.4 AS=0.406
+ AD=0.406 PS=3.38 PD=3.38
M$841 \$1 bias_a VSS sky130_gnd sky130_fd_pr__nfet_01v8 L=0.6 W=1.4 AS=0.406
+ AD=0.406 PS=3.38 PD=3.38
M$842 \$1 bias_a VSS sky130_gnd sky130_fd_pr__nfet_01v8 L=0.6 W=1.4 AS=0.406
+ AD=0.406 PS=3.38 PD=3.38
M$843 \$1 cmc VSS sky130_gnd sky130_fd_pr__nfet_01v8 L=0.6 W=1.4 AS=0.406
+ AD=0.406 PS=3.38 PD=3.38
M$844 \$1 cmc VSS sky130_gnd sky130_fd_pr__nfet_01v8 L=0.6 W=1.4 AS=0.406
+ AD=0.406 PS=3.38 PD=3.38
M$845 \$1 cmc VSS sky130_gnd sky130_fd_pr__nfet_01v8 L=0.6 W=1.4 AS=0.406
+ AD=0.406 PS=3.38 PD=3.38
M$846 \$1 bias_a VSS sky130_gnd sky130_fd_pr__nfet_01v8 L=0.6 W=1.4 AS=0.406
+ AD=0.406 PS=3.38 PD=3.38
M$847 \$1 cmc VSS sky130_gnd sky130_fd_pr__nfet_01v8 L=0.6 W=1.4 AS=0.406
+ AD=0.406 PS=3.38 PD=3.38
M$848 \$1 bias_a VSS sky130_gnd sky130_fd_pr__nfet_01v8 L=0.6 W=1.4 AS=0.406
+ AD=0.406 PS=3.38 PD=3.38
M$849 \$1 cmc VSS sky130_gnd sky130_fd_pr__nfet_01v8 L=0.6 W=1.4 AS=0.406
+ AD=0.406 PS=3.38 PD=3.38
M$850 \$1 bias_a VSS sky130_gnd sky130_fd_pr__nfet_01v8 L=0.6 W=1.4 AS=0.406
+ AD=0.406 PS=3.38 PD=3.38
M$851 \$1 cmc VSS sky130_gnd sky130_fd_pr__nfet_01v8 L=0.6 W=1.4 AS=0.406
+ AD=0.406 PS=3.38 PD=3.38
M$852 \$1 cmc VSS sky130_gnd sky130_fd_pr__nfet_01v8 L=0.6 W=1.4 AS=0.406
+ AD=0.406 PS=3.38 PD=3.38
M$853 \$1 cmc VSS sky130_gnd sky130_fd_pr__nfet_01v8 L=0.6 W=1.4 AS=0.406
+ AD=0.406 PS=3.38 PD=3.38
M$854 \$1 bias_a VSS sky130_gnd sky130_fd_pr__nfet_01v8 L=0.6 W=1.4 AS=0.406
+ AD=0.406 PS=3.38 PD=3.38
M$855 \$1 cmc VSS sky130_gnd sky130_fd_pr__nfet_01v8 L=0.6 W=1.4 AS=0.406
+ AD=0.406 PS=3.38 PD=3.38
M$856 \$1 bias_a VSS sky130_gnd sky130_fd_pr__nfet_01v8 L=0.6 W=1.4 AS=0.406
+ AD=0.406 PS=3.38 PD=3.38
M$857 \$1 cmc VSS sky130_gnd sky130_fd_pr__nfet_01v8 L=0.6 W=1.4 AS=0.406
+ AD=0.406 PS=3.38 PD=3.38
M$858 \$1 bias_a VSS sky130_gnd sky130_fd_pr__nfet_01v8 L=0.6 W=1.4 AS=0.406
+ AD=0.406 PS=3.38 PD=3.38
M$859 \$1 cmc VSS sky130_gnd sky130_fd_pr__nfet_01v8 L=0.6 W=1.4 AS=0.406
+ AD=0.406 PS=3.38 PD=3.38
M$860 \$1 bias_a VSS sky130_gnd sky130_fd_pr__nfet_01v8 L=0.6 W=1.4 AS=0.406
+ AD=0.406 PS=3.38 PD=3.38
M$861 \$1 bias_a VSS sky130_gnd sky130_fd_pr__nfet_01v8 L=0.6 W=1.4 AS=0.406
+ AD=0.406 PS=3.38 PD=3.38
.ENDS iadc_ota_v2_routed
