* NGSPICE file created from XC1__A_flat.ext - technology: sky130A

.subckt XC1__A_flat Vop1 Vom
X0 Vop1 Vom sky130_fd_pr__cap_mim_m3_1 l=10 w=10
X1 Vop1 Vom sky130_fd_pr__cap_mim_m3_1 l=10 w=10
X2 Vop1 Vom sky130_fd_pr__cap_mim_m3_1 l=10 w=10
X3 Vop1 Vom sky130_fd_pr__cap_mim_m3_1 l=10 w=10
X4 Vop1 Vom sky130_fd_pr__cap_mim_m3_1 l=10 w=10
.ends
