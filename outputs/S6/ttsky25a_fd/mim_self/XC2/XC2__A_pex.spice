* NGSPICE file created from XC2__A_flat.ext - technology: sky130A

.subckt XC2__A_flat Vom1 Vop
X0 Vom1 Vop sky130_fd_pr__cap_mim_m3_1 l=10 w=10
X1 Vom1 Vop sky130_fd_pr__cap_mim_m3_1 l=10 w=10
X2 Vom1 Vop sky130_fd_pr__cap_mim_m3_1 l=10 w=10
X3 Vom1 Vop sky130_fd_pr__cap_mim_m3_1 l=10 w=10
X4 Vom1 Vop sky130_fd_pr__cap_mim_m3_1 l=10 w=10
C0 Vom1 Vop 48.5305f
C1 Vop VSUBS 26.93773f
.ends
