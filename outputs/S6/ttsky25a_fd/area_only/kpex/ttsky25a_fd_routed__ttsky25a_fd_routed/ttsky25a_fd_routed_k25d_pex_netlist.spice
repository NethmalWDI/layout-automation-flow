*********************************************************
*** NGSPICE file created by KLayout-PEX 0.6.8
*** -----------------------------------------------------
***     Extraction Engine: KPEX/2.5D
***     Technology: sky130a
***     Date: 2026-11-04 13:30:44
*********************************************************

.SUBCKT ttsky25a_fd_routed \$3.x2_x1_net1 \$3.x2_x1_net10 \$3.x2_x1_net11
+ \$3.x2_x1_net12 \$3.x2_x1_net13 \$3.x2_x1_net14 \$3.x2_x1_net15
+ \$3.x2_x1_net16 \$3.x2_x1_net17 \$3.x2_x1_net18 \$3.x2_x1_net19
+ \$3.x2_x1_net2 \$3.x2_x1_net3 \$3.x2_x1_net4 \$3.x2_x1_net5 \$3.x2_x1_net6
+ \$3.x2_x1_net7 \$3.x2_x1_net8 \$3.x2_x1_net9 \$3.x2_x2_net1 \$3.x2_x2_net10
+ \$3.x2_x2_net11 \$3.x2_x2_net12 \$3.x2_x2_net13 \$3.x2_x2_net14
+ \$3.x2_x2_net15 \$3.x2_x2_net16 \$3.x2_x2_net17 \$3.x2_x2_net18
+ \$3.x2_x2_net19 \$3.x2_x2_net2 \$3.x2_x2_net3 \$3.x2_x2_net4 \$3.x2_x2_net5
+ \$3.x2_x2_net6 \$3.x2_x2_net7 \$3.x2_x2_net8 \$3.x2_x2_net9 RGM VREF Vdd Vm
+ Vom Vop Vp Vss sky130_gnd
X$11 Vom \$3.x2_x2_net16 sky130_fd_pr__res_generic_po w=0.5 l=40
X$12 \$206 \$3.x2_x2_net4 sky130_fd_pr__res_generic_po w=0.5 l=40
X$13 \$206 \$3.x2_x1_net16 sky130_fd_pr__res_generic_po w=0.5 l=40
X$14 Vop \$3.x2_x1_net4 sky130_fd_pr__res_generic_po w=0.5 l=40
X$15 Vss Vss sky130_fd_pr__res_generic_po w=0.5 l=40
X$16 Vss Vss sky130_fd_pr__res_generic_po w=0.5 l=40
X$17 \$3.x2_x2_net5 \$3.x2_x2_net6 sky130_fd_pr__res_generic_po w=0.5 l=40
X$18 \$3.x2_x2_net5 \$3.x2_x2_net4 sky130_fd_pr__res_generic_po w=0.5 l=40
X$19 \$3.x2_x1_net5 \$3.x2_x1_net6 sky130_fd_pr__res_generic_po w=0.5 l=40
X$20 \$3.x2_x1_net5 \$3.x2_x1_net4 sky130_fd_pr__res_generic_po w=0.5 l=40
X$21 \$3.x2_x2_net7 \$3.x2_x2_net1 sky130_fd_pr__res_generic_po w=0.5 l=40
X$22 \$3.x2_x2_net7 \$3.x2_x2_net6 sky130_fd_pr__res_generic_po w=0.5 l=40
X$23 \$3.x2_x1_net7 \$3.x2_x1_net1 sky130_fd_pr__res_generic_po w=0.5 l=40
X$24 \$3.x2_x1_net7 \$3.x2_x1_net6 sky130_fd_pr__res_generic_po w=0.5 l=40
X$25 \$3.x2_x2_net11 \$3.x2_x2_net10 sky130_fd_pr__res_generic_po w=0.5 l=40
X$26 \$3.x2_x2_net11 \$3.x2_x2_net1 sky130_fd_pr__res_generic_po w=0.5 l=40
X$27 \$3.x2_x1_net11 \$3.x2_x1_net10 sky130_fd_pr__res_generic_po w=0.5 l=40
X$28 \$3.x2_x1_net11 \$3.x2_x1_net1 sky130_fd_pr__res_generic_po w=0.5 l=40
X$29 \$3.x2_x2_net9 \$3.x2_x2_net8 sky130_fd_pr__res_generic_po w=0.5 l=40
X$30 \$3.x2_x2_net9 \$3.x2_x2_net10 sky130_fd_pr__res_generic_po w=0.5 l=40
X$31 \$3.x2_x1_net9 \$3.x2_x1_net8 sky130_fd_pr__res_generic_po w=0.5 l=40
X$32 \$3.x2_x1_net9 \$3.x2_x1_net10 sky130_fd_pr__res_generic_po w=0.5 l=40
X$33 \$3.x2_x2_net2 \$3.x2_x2_net8 sky130_fd_pr__res_generic_po w=0.5 l=40
X$34 \$3.x2_x2_net2 \$3.x2_x2_net12 sky130_fd_pr__res_generic_po w=0.5 l=40
X$35 \$3.x2_x1_net2 \$3.x2_x1_net8 sky130_fd_pr__res_generic_po w=0.5 l=40
X$36 \$3.x2_x1_net2 \$3.x2_x1_net12 sky130_fd_pr__res_generic_po w=0.5 l=40
X$37 \$3.x2_x2_net13 \$3.x2_x2_net14 sky130_fd_pr__res_generic_po w=0.5 l=40
X$38 \$3.x2_x2_net13 \$3.x2_x2_net12 sky130_fd_pr__res_generic_po w=0.5 l=40
X$39 \$3.x2_x1_net13 \$3.x2_x1_net14 sky130_fd_pr__res_generic_po w=0.5 l=40
X$40 \$3.x2_x1_net13 \$3.x2_x1_net12 sky130_fd_pr__res_generic_po w=0.5 l=40
X$41 \$3.x2_x2_net15 \$3.x2_x2_net3 sky130_fd_pr__res_generic_po w=0.5 l=40
X$42 \$3.x2_x2_net15 \$3.x2_x2_net14 sky130_fd_pr__res_generic_po w=0.5 l=40
X$43 \$3.x2_x1_net15 \$3.x2_x1_net3 sky130_fd_pr__res_generic_po w=0.5 l=40
X$44 \$3.x2_x1_net15 \$3.x2_x1_net14 sky130_fd_pr__res_generic_po w=0.5 l=40
X$45 \$3.x2_x2_net19 \$3.x2_x2_net18 sky130_fd_pr__res_generic_po w=0.5 l=40
X$46 \$3.x2_x2_net19 \$3.x2_x2_net3 sky130_fd_pr__res_generic_po w=0.5 l=40
X$47 \$3.x2_x1_net19 \$3.x2_x1_net18 sky130_fd_pr__res_generic_po w=0.5 l=40
X$48 \$3.x2_x1_net19 \$3.x2_x1_net3 sky130_fd_pr__res_generic_po w=0.5 l=40
X$49 \$3.x2_x2_net17 \$3.x2_x2_net16 sky130_fd_pr__res_generic_po w=0.5 l=40
X$50 \$3.x2_x2_net17 \$3.x2_x2_net18 sky130_fd_pr__res_generic_po w=0.5 l=40
X$51 \$3.x2_x1_net17 \$3.x2_x1_net16 sky130_fd_pr__res_generic_po w=0.5 l=40
X$52 \$3.x2_x1_net17 \$3.x2_x1_net18 sky130_fd_pr__res_generic_po w=0.5 l=40
X$53 Vdd \$416 \$416 Vdd sky130_fd_pr__pfet_01v8_lvt l=10 w=1.5 as=0.435
+ ad=0.435 ps=3.58 pd=3.58
X$54 Vdd \$416 \$416 Vdd sky130_fd_pr__pfet_01v8_lvt l=10 w=1.5 as=0.435
+ ad=0.435 ps=3.58 pd=3.58
X$55 Vdd Vdd Vdd Vdd sky130_fd_pr__pfet_01v8_lvt l=5 w=1 as=0.29 ad=0.145
+ ps=2.58 pd=1.29
X$56 Vdd Vdd Vdd Vdd sky130_fd_pr__pfet_01v8_lvt l=5 w=1 as=0.145 ad=0.29
+ ps=1.29 pd=2.58
X$57 Vdd Vdd Vdd Vdd sky130_fd_pr__pfet_01v8_lvt l=5 w=1 as=0.29 ad=0.145
+ ps=2.58 pd=1.29
X$58 Vdd Vdd Vdd Vdd sky130_fd_pr__pfet_01v8_lvt l=5 w=1 as=0.145 ad=0.29
+ ps=1.29 pd=2.58
X$59 \$276 \$279 Vdd Vdd sky130_fd_pr__pfet_01v8_lvt l=5 w=1 as=0.29 ad=0.145
+ ps=2.58 pd=1.29
X$60 Vdd \$279 \$276 Vdd sky130_fd_pr__pfet_01v8_lvt l=5 w=1 as=0.145 ad=0.29
+ ps=1.29 pd=2.58
X$61 \$286 \$279 Vdd Vdd sky130_fd_pr__pfet_01v8_lvt l=5 w=1 as=0.29 ad=0.145
+ ps=2.58 pd=1.29
X$62 Vdd \$279 \$286 Vdd sky130_fd_pr__pfet_01v8_lvt l=5 w=1 as=0.145 ad=0.29
+ ps=1.29 pd=2.58
X$63 \$276 \$279 Vdd Vdd sky130_fd_pr__pfet_01v8_lvt l=5 w=1 as=0.29 ad=0.145
+ ps=2.58 pd=1.29
X$64 Vdd \$279 \$276 Vdd sky130_fd_pr__pfet_01v8_lvt l=5 w=1 as=0.145 ad=0.29
+ ps=1.29 pd=2.58
X$65 \$286 \$279 Vdd Vdd sky130_fd_pr__pfet_01v8_lvt l=5 w=1 as=0.29 ad=0.145
+ ps=2.58 pd=1.29
X$66 Vdd \$279 \$286 Vdd sky130_fd_pr__pfet_01v8_lvt l=5 w=1 as=0.145 ad=0.29
+ ps=1.29 pd=2.58
X$67 \$276 \$279 Vdd Vdd sky130_fd_pr__pfet_01v8_lvt l=5 w=1 as=0.29 ad=0.145
+ ps=2.58 pd=1.29
X$68 Vdd \$279 \$276 Vdd sky130_fd_pr__pfet_01v8_lvt l=5 w=1 as=0.145 ad=0.29
+ ps=1.29 pd=2.58
X$69 \$286 \$279 Vdd Vdd sky130_fd_pr__pfet_01v8_lvt l=5 w=1 as=0.29 ad=0.145
+ ps=2.58 pd=1.29
X$70 Vdd \$279 \$286 Vdd sky130_fd_pr__pfet_01v8_lvt l=5 w=1 as=0.145 ad=0.29
+ ps=1.29 pd=2.58
X$71 \$276 \$279 Vdd Vdd sky130_fd_pr__pfet_01v8_lvt l=5 w=1 as=0.29 ad=0.145
+ ps=2.58 pd=1.29
X$72 Vdd \$279 \$276 Vdd sky130_fd_pr__pfet_01v8_lvt l=5 w=1 as=0.145 ad=0.29
+ ps=1.29 pd=2.58
X$73 \$286 \$279 Vdd Vdd sky130_fd_pr__pfet_01v8_lvt l=5 w=1 as=0.29 ad=0.145
+ ps=2.58 pd=1.29
X$74 Vdd \$279 \$286 Vdd sky130_fd_pr__pfet_01v8_lvt l=5 w=1 as=0.145 ad=0.29
+ ps=1.29 pd=2.58
X$75 Vdd Vdd Vdd Vdd sky130_fd_pr__pfet_01v8_lvt l=5 w=1 as=0.29 ad=0.145
+ ps=2.58 pd=1.29
X$76 Vdd Vdd Vdd Vdd sky130_fd_pr__pfet_01v8_lvt l=5 w=1 as=0.145 ad=0.29
+ ps=1.29 pd=2.58
X$77 Vdd Vdd Vdd Vdd sky130_fd_pr__pfet_01v8_lvt l=5 w=1 as=0.29 ad=0.145
+ ps=2.58 pd=1.29
X$78 Vdd Vdd Vdd Vdd sky130_fd_pr__pfet_01v8_lvt l=5 w=1 as=0.145 ad=0.29
+ ps=1.29 pd=2.58
X$79 \$3 \$416 \$276 Vdd sky130_fd_pr__pfet_01v8_lvt l=5 w=1 as=0.29 ad=0.145
+ ps=2.58 pd=1.29
X$80 \$276 \$416 \$3 Vdd sky130_fd_pr__pfet_01v8_lvt l=5 w=1 as=0.145 ad=0.29
+ ps=1.29 pd=2.58
X$81 \$67 \$416 \$286 Vdd sky130_fd_pr__pfet_01v8_lvt l=5 w=1 as=0.29 ad=0.145
+ ps=2.58 pd=1.29
X$82 \$286 \$416 \$67 Vdd sky130_fd_pr__pfet_01v8_lvt l=5 w=1 as=0.145 ad=0.29
+ ps=1.29 pd=2.58
X$83 \$3 \$416 \$276 Vdd sky130_fd_pr__pfet_01v8_lvt l=5 w=1 as=0.29 ad=0.145
+ ps=2.58 pd=1.29
X$84 \$276 \$416 \$3 Vdd sky130_fd_pr__pfet_01v8_lvt l=5 w=1 as=0.145 ad=0.29
+ ps=1.29 pd=2.58
X$85 \$67 \$416 \$286 Vdd sky130_fd_pr__pfet_01v8_lvt l=5 w=1 as=0.29 ad=0.145
+ ps=2.58 pd=1.29
X$86 \$286 \$416 \$67 Vdd sky130_fd_pr__pfet_01v8_lvt l=5 w=1 as=0.145 ad=0.29
+ ps=1.29 pd=2.58
X$87 Vss \$121 \$121 sky130_gnd sky130_fd_pr__nfet_01v8_lvt l=2 w=1 as=0.29
+ ad=0.29 ps=2.58 pd=2.58
X$88 Vss \$121 \$121 sky130_gnd sky130_fd_pr__nfet_01v8_lvt l=2 w=1 as=0.29
+ ad=0.29 ps=2.58 pd=2.58
X$89 Vss Vss Vss sky130_gnd sky130_fd_pr__nfet_01v8_lvt l=20 w=1 as=0.29
+ ad=0.29 ps=2.58 pd=2.58
X$90 Vss Vss Vss sky130_gnd sky130_fd_pr__nfet_01v8_lvt l=20 w=1 as=0.29
+ ad=0.29 ps=2.58 pd=2.58
X$91 Vss \$121 \$343 sky130_gnd sky130_fd_pr__nfet_01v8_lvt l=20 w=1 as=0.29
+ ad=0.29 ps=2.58 pd=2.58
X$92 Vss \$121 \$278 sky130_gnd sky130_fd_pr__nfet_01v8_lvt l=20 w=1 as=0.29
+ ad=0.29 ps=2.58 pd=2.58
X$93 Vss \$121 \$343 sky130_gnd sky130_fd_pr__nfet_01v8_lvt l=20 w=1 as=0.29
+ ad=0.29 ps=2.58 pd=2.58
X$94 Vss \$121 \$278 sky130_gnd sky130_fd_pr__nfet_01v8_lvt l=20 w=1 as=0.29
+ ad=0.29 ps=2.58 pd=2.58
X$95 Vss \$301 \$301 sky130_gnd sky130_fd_pr__nfet_01v8_lvt l=5 w=0.6 as=0.174
+ ad=0.174 ps=1.78 pd=1.78
X$96 Vss \$301 \$301 sky130_gnd sky130_fd_pr__nfet_01v8_lvt l=5 w=0.6 as=0.174
+ ad=0.174 ps=1.78 pd=1.78
X$97 Vss \$121 \$418 sky130_gnd sky130_fd_pr__nfet_01v8_lvt l=10 w=1 as=0.29
+ ad=0.29 ps=2.58 pd=2.58
X$98 Vss \$121 \$418 sky130_gnd sky130_fd_pr__nfet_01v8_lvt l=10 w=1 as=0.29
+ ad=0.29 ps=2.58 pd=2.58
X$99 Vss \$121 \$346 sky130_gnd sky130_fd_pr__nfet_01v8_lvt l=10 w=1 as=0.29
+ ad=0.29 ps=2.58 pd=2.58
X$100 Vss \$121 \$346 sky130_gnd sky130_fd_pr__nfet_01v8_lvt l=10 w=1 as=0.29
+ ad=0.29 ps=2.58 pd=2.58
X$101 Vss \$121 \$403 sky130_gnd sky130_fd_pr__nfet_01v8_lvt l=10 w=1 as=0.29
+ ad=0.29 ps=2.58 pd=2.58
X$102 Vss \$121 \$403 sky130_gnd sky130_fd_pr__nfet_01v8_lvt l=10 w=1 as=0.29
+ ad=0.29 ps=2.58 pd=2.58
X$103 Vss \$121 \$345 sky130_gnd sky130_fd_pr__nfet_01v8_lvt l=10 w=1 as=0.29
+ ad=0.29 ps=2.58 pd=2.58
X$104 Vss \$121 \$345 sky130_gnd sky130_fd_pr__nfet_01v8_lvt l=10 w=1 as=0.29
+ ad=0.29 ps=2.58 pd=2.58
X$105 Vss Vss Vss sky130_gnd sky130_fd_pr__nfet_01v8_lvt l=10 w=1 as=0.29
+ ad=0.29 ps=2.58 pd=2.58
X$106 Vss Vss Vss sky130_gnd sky130_fd_pr__nfet_01v8_lvt l=10 w=1 as=0.29
+ ad=0.29 ps=2.58 pd=2.58
X$107 Vss Vss Vss sky130_gnd sky130_fd_pr__nfet_01v8_lvt l=20 w=0.5 as=0.145
+ ad=0.145 ps=1.58 pd=1.58
X$108 Vss Vss Vss sky130_gnd sky130_fd_pr__nfet_01v8_lvt l=20 w=0.5 as=0.145
+ ad=0.145 ps=1.58 pd=1.58
X$109 Vss \$174 \$174 sky130_gnd sky130_fd_pr__nfet_01v8_lvt l=20 w=0.5
+ as=0.145 ad=0.145 ps=1.58 pd=1.58
X$110 Vss \$174 \$154 sky130_gnd sky130_fd_pr__nfet_01v8_lvt l=20 w=0.5
+ as=0.145 ad=0.145 ps=1.58 pd=1.58
X$111 Vss \$174 \$154 sky130_gnd sky130_fd_pr__nfet_01v8_lvt l=20 w=0.5
+ as=0.145 ad=0.145 ps=1.58 pd=1.58
X$112 Vss \$174 \$174 sky130_gnd sky130_fd_pr__nfet_01v8_lvt l=20 w=0.5
+ as=0.145 ad=0.145 ps=1.58 pd=1.58
X$113 \$345 \$301 \$3 sky130_gnd sky130_fd_pr__nfet_01v8_lvt l=1 w=1 as=0.29
+ ad=0.29 ps=2.58 pd=2.58
X$114 \$345 \$301 \$3 sky130_gnd sky130_fd_pr__nfet_01v8_lvt l=1 w=1 as=0.29
+ ad=0.29 ps=2.58 pd=2.58
X$115 \$346 \$301 \$277 sky130_gnd sky130_fd_pr__nfet_01v8_lvt l=1 w=1 as=0.29
+ ad=0.29 ps=2.58 pd=2.58
X$116 \$346 \$301 \$277 sky130_gnd sky130_fd_pr__nfet_01v8_lvt l=1 w=1 as=0.29
+ ad=0.29 ps=2.58 pd=2.58
X$117 Vss Vss Vss sky130_gnd sky130_fd_pr__nfet_01v8_lvt l=1 w=1 as=0.29
+ ad=0.29 ps=2.58 pd=2.58
X$118 Vss Vss Vss sky130_gnd sky130_fd_pr__nfet_01v8_lvt l=1 w=1 as=0.29
+ ad=0.29 ps=2.58 pd=2.58
X$119 \$418 \$301 \$277 sky130_gnd sky130_fd_pr__nfet_01v8_lvt l=1 w=1 as=0.29
+ ad=0.29 ps=2.58 pd=2.58
X$120 \$418 \$301 \$277 sky130_gnd sky130_fd_pr__nfet_01v8_lvt l=1 w=1 as=0.29
+ ad=0.29 ps=2.58 pd=2.58
X$121 \$403 \$301 \$67 sky130_gnd sky130_fd_pr__nfet_01v8_lvt l=1 w=1 as=0.29
+ ad=0.29 ps=2.58 pd=2.58
X$122 \$403 \$301 \$67 sky130_gnd sky130_fd_pr__nfet_01v8_lvt l=1 w=1 as=0.29
+ ad=0.29 ps=2.58 pd=2.58
X$123 Vss Vss Vss sky130_gnd sky130_fd_pr__nfet_01v8_lvt l=1 w=1 as=0.29
+ ad=0.29 ps=2.58 pd=2.58
X$124 Vss Vss Vss sky130_gnd sky130_fd_pr__nfet_01v8_lvt l=1 w=1 as=0.29
+ ad=0.29 ps=2.58 pd=2.58
X$125 Vss \$154 Vop sky130_gnd sky130_fd_pr__nfet_01v8_lvt l=1 w=1 as=0.29
+ ad=0.29 ps=2.58 pd=2.58
X$126 Vss \$154 Vop sky130_gnd sky130_fd_pr__nfet_01v8_lvt l=1 w=1 as=0.29
+ ad=0.29 ps=2.58 pd=2.58
X$127 Vss \$154 Vop sky130_gnd sky130_fd_pr__nfet_01v8_lvt l=1 w=1 as=0.29
+ ad=0.29 ps=2.58 pd=2.58
X$128 Vss \$154 Vop sky130_gnd sky130_fd_pr__nfet_01v8_lvt l=1 w=1 as=0.29
+ ad=0.29 ps=2.58 pd=2.58
X$129 Vss \$154 Vop sky130_gnd sky130_fd_pr__nfet_01v8_lvt l=1 w=1 as=0.29
+ ad=0.29 ps=2.58 pd=2.58
X$130 Vss \$154 Vop sky130_gnd sky130_fd_pr__nfet_01v8_lvt l=1 w=1 as=0.29
+ ad=0.29 ps=2.58 pd=2.58
X$131 Vss \$154 Vop sky130_gnd sky130_fd_pr__nfet_01v8_lvt l=1 w=1 as=0.29
+ ad=0.29 ps=2.58 pd=2.58
X$132 Vss \$154 Vop sky130_gnd sky130_fd_pr__nfet_01v8_lvt l=1 w=1 as=0.29
+ ad=0.29 ps=2.58 pd=2.58
X$133 Vss \$154 Vop sky130_gnd sky130_fd_pr__nfet_01v8_lvt l=1 w=1 as=0.29
+ ad=0.29 ps=2.58 pd=2.58
X$134 Vss Vss Vss sky130_gnd sky130_fd_pr__nfet_01v8_lvt l=1 w=1 as=0.29
+ ad=0.29 ps=2.58 pd=2.58
X$135 Vss \$154 Vom sky130_gnd sky130_fd_pr__nfet_01v8_lvt l=1 w=1 as=0.29
+ ad=0.29 ps=2.58 pd=2.58
X$136 Vss \$154 Vom sky130_gnd sky130_fd_pr__nfet_01v8_lvt l=1 w=1 as=0.29
+ ad=0.29 ps=2.58 pd=2.58
X$137 Vss \$154 Vom sky130_gnd sky130_fd_pr__nfet_01v8_lvt l=1 w=1 as=0.29
+ ad=0.29 ps=2.58 pd=2.58
X$138 Vss \$154 Vom sky130_gnd sky130_fd_pr__nfet_01v8_lvt l=1 w=1 as=0.29
+ ad=0.29 ps=2.58 pd=2.58
X$139 Vss \$154 Vom sky130_gnd sky130_fd_pr__nfet_01v8_lvt l=1 w=1 as=0.29
+ ad=0.29 ps=2.58 pd=2.58
X$140 Vss \$154 Vom sky130_gnd sky130_fd_pr__nfet_01v8_lvt l=1 w=1 as=0.29
+ ad=0.29 ps=2.58 pd=2.58
X$141 Vss \$154 Vom sky130_gnd sky130_fd_pr__nfet_01v8_lvt l=1 w=1 as=0.29
+ ad=0.29 ps=2.58 pd=2.58
X$142 Vss \$154 Vom sky130_gnd sky130_fd_pr__nfet_01v8_lvt l=1 w=1 as=0.29
+ ad=0.29 ps=2.58 pd=2.58
X$143 Vss Vss Vss sky130_gnd sky130_fd_pr__nfet_01v8_lvt l=1 w=1 as=0.29
+ ad=0.29 ps=2.58 pd=2.58
X$144 Vss \$154 Vom sky130_gnd sky130_fd_pr__nfet_01v8_lvt l=1 w=1 as=0.29
+ ad=0.29 ps=2.58 pd=2.58
X$145 Vss Vss Vss sky130_gnd sky130_fd_pr__nfet_01v8_lvt l=1 w=0.6 as=0.174
+ ad=0.174 ps=1.78 pd=1.78
X$146 Vss Vss Vss sky130_gnd sky130_fd_pr__nfet_01v8_lvt l=1 w=0.6 as=0.174
+ ad=0.174 ps=1.78 pd=1.78
X$147 Vss \$402 \$416 sky130_gnd sky130_fd_pr__nfet_01v8_lvt l=1 w=0.6 as=0.174
+ ad=0.174 ps=1.78 pd=1.78
X$148 Vss \$402 \$402 sky130_gnd sky130_fd_pr__nfet_01v8_lvt l=1 w=0.6 as=0.174
+ ad=0.174 ps=1.78 pd=1.78
X$149 Vss \$402 \$402 sky130_gnd sky130_fd_pr__nfet_01v8_lvt l=1 w=0.6 as=0.174
+ ad=0.174 ps=1.78 pd=1.78
X$150 Vss \$402 \$416 sky130_gnd sky130_fd_pr__nfet_01v8_lvt l=1 w=0.6 as=0.174
+ ad=0.174 ps=1.78 pd=1.78
X$151 Vss Vss Vss sky130_gnd sky130_fd_pr__nfet_01v8_lvt l=1 w=0.6 as=0.174
+ ad=0.174 ps=1.78 pd=1.78
X$152 Vss Vss Vss sky130_gnd sky130_fd_pr__nfet_01v8_lvt l=1 w=0.6 as=0.174
+ ad=0.174 ps=1.78 pd=1.78
X$153 Vss \$176 \$192 sky130_gnd sky130_fd_pr__nfet_01v8_lvt l=1 w=0.6 as=0.174
+ ad=0.174 ps=1.78 pd=1.78
X$154 Vss \$176 \$176 sky130_gnd sky130_fd_pr__nfet_01v8_lvt l=1 w=0.6 as=0.174
+ ad=0.174 ps=1.78 pd=1.78
X$155 Vss \$176 \$192 sky130_gnd sky130_fd_pr__nfet_01v8_lvt l=1 w=0.6 as=0.174
+ ad=0.174 ps=1.78 pd=1.78
X$156 Vss \$176 \$176 sky130_gnd sky130_fd_pr__nfet_01v8_lvt l=1 w=0.6 as=0.174
+ ad=0.174 ps=1.78 pd=1.78
X$157 Vdd \$192 \$207 Vdd sky130_fd_pr__pfet_01v8_lvt l=5 w=1 as=0.29 ad=0.29
+ ps=2.58 pd=2.58
X$158 Vdd Vdd Vdd Vdd sky130_fd_pr__pfet_01v8_lvt l=5 w=1 as=0.29 ad=0.29
+ ps=2.58 pd=2.58
X$159 Vdd \$192 \$207 Vdd sky130_fd_pr__pfet_01v8_lvt l=5 w=1 as=0.29 ad=0.29
+ ps=2.58 pd=2.58
X$160 Vdd Vdd Vdd Vdd sky130_fd_pr__pfet_01v8_lvt l=1 w=6 as=1.74 ad=1.74
+ ps=12.58 pd=12.58
X$161 Vdd \$192 \$192 Vdd sky130_fd_pr__pfet_01v8_lvt l=1 w=6 as=1.74 ad=1.74
+ ps=12.58 pd=12.58
X$162 Vdd \$192 \$192 Vdd sky130_fd_pr__pfet_01v8_lvt l=1 w=6 as=1.74 ad=1.74
+ ps=12.58 pd=12.58
X$163 Vdd Vdd Vdd Vdd sky130_fd_pr__pfet_01v8_lvt l=10 w=1 as=0.29 ad=0.29
+ ps=2.58 pd=2.58
X$164 Vdd Vdd Vdd Vdd sky130_fd_pr__pfet_01v8_lvt l=10 w=1 as=0.29 ad=0.29
+ ps=2.58 pd=2.58
X$165 Vdd \$287 \$287 Vdd sky130_fd_pr__pfet_01v8_lvt l=10 w=1 as=0.29 ad=0.29
+ ps=2.58 pd=2.58
X$166 Vdd \$287 \$279 Vdd sky130_fd_pr__pfet_01v8_lvt l=10 w=1 as=0.29 ad=0.29
+ ps=2.58 pd=2.58
X$167 Vdd \$287 \$287 Vdd sky130_fd_pr__pfet_01v8_lvt l=10 w=1 as=0.29 ad=0.29
+ ps=2.58 pd=2.58
X$168 Vdd \$287 \$279 Vdd sky130_fd_pr__pfet_01v8_lvt l=10 w=1 as=0.29 ad=0.29
+ ps=2.58 pd=2.58
X$169 Vdd Vdd Vdd Vdd sky130_fd_pr__pfet_01v8_lvt l=10 w=1 as=0.29 ad=0.29
+ ps=2.58 pd=2.58
X$170 \$207 \$206 \$174 Vdd sky130_fd_pr__pfet_01v8_lvt l=10 w=1 as=0.29
+ ad=0.29 ps=2.58 pd=2.58
X$171 \$207 VREF \$154 Vdd sky130_fd_pr__pfet_01v8_lvt l=10 w=1 as=0.29 ad=0.29
+ ps=2.58 pd=2.58
X$172 \$207 VREF \$154 Vdd sky130_fd_pr__pfet_01v8_lvt l=10 w=1 as=0.29 ad=0.29
+ ps=2.58 pd=2.58
X$173 \$207 \$206 \$174 Vdd sky130_fd_pr__pfet_01v8_lvt l=10 w=1 as=0.29
+ ad=0.29 ps=2.58 pd=2.58
X$174 Vdd Vdd Vdd Vdd sky130_fd_pr__pfet_01v8_lvt l=10 w=1 as=0.29 ad=0.29
+ ps=2.58 pd=2.58
X$175 Vop \$3 Vdd Vdd sky130_fd_pr__pfet_01v8_lvt l=1 w=1 as=0.29 ad=0.145
+ ps=2.58 pd=1.29
X$176 Vdd \$3 Vop Vdd sky130_fd_pr__pfet_01v8_lvt l=1 w=1 as=0.145 ad=0.29
+ ps=1.29 pd=2.58
X$177 Vop \$3 Vdd Vdd sky130_fd_pr__pfet_01v8_lvt l=1 w=1 as=0.29 ad=0.145
+ ps=2.58 pd=1.29
X$178 Vdd \$3 Vop Vdd sky130_fd_pr__pfet_01v8_lvt l=1 w=1 as=0.145 ad=0.29
+ ps=1.29 pd=2.58
X$179 Vop \$3 Vdd Vdd sky130_fd_pr__pfet_01v8_lvt l=1 w=1 as=0.29 ad=0.145
+ ps=2.58 pd=1.29
X$180 Vdd \$3 Vop Vdd sky130_fd_pr__pfet_01v8_lvt l=1 w=1 as=0.145 ad=0.29
+ ps=1.29 pd=2.58
X$181 Vop \$3 Vdd Vdd sky130_fd_pr__pfet_01v8_lvt l=1 w=1 as=0.29 ad=0.145
+ ps=2.58 pd=1.29
X$182 Vdd \$3 Vop Vdd sky130_fd_pr__pfet_01v8_lvt l=1 w=1 as=0.145 ad=0.29
+ ps=1.29 pd=2.58
X$183 Vop \$3 Vdd Vdd sky130_fd_pr__pfet_01v8_lvt l=1 w=1 as=0.29 ad=0.145
+ ps=2.58 pd=1.29
X$184 Vdd \$3 Vop Vdd sky130_fd_pr__pfet_01v8_lvt l=1 w=1 as=0.145 ad=0.29
+ ps=1.29 pd=2.58
X$185 Vop \$3 Vdd Vdd sky130_fd_pr__pfet_01v8_lvt l=1 w=1 as=0.29 ad=0.145
+ ps=2.58 pd=1.29
X$186 Vdd \$3 Vop Vdd sky130_fd_pr__pfet_01v8_lvt l=1 w=1 as=0.145 ad=0.29
+ ps=1.29 pd=2.58
X$187 Vop \$3 Vdd Vdd sky130_fd_pr__pfet_01v8_lvt l=1 w=1 as=0.29 ad=0.145
+ ps=2.58 pd=1.29
X$188 Vdd \$3 Vop Vdd sky130_fd_pr__pfet_01v8_lvt l=1 w=1 as=0.145 ad=0.29
+ ps=1.29 pd=2.58
X$189 Vop \$3 Vdd Vdd sky130_fd_pr__pfet_01v8_lvt l=1 w=1 as=0.29 ad=0.145
+ ps=2.58 pd=1.29
X$190 Vdd \$3 Vop Vdd sky130_fd_pr__pfet_01v8_lvt l=1 w=1 as=0.145 ad=0.29
+ ps=1.29 pd=2.58
X$191 Vop \$3 Vdd Vdd sky130_fd_pr__pfet_01v8_lvt l=1 w=1 as=0.29 ad=0.145
+ ps=2.58 pd=1.29
X$192 Vdd \$3 Vop Vdd sky130_fd_pr__pfet_01v8_lvt l=1 w=1 as=0.145 ad=0.29
+ ps=1.29 pd=2.58
X$193 Vom \$67 Vdd Vdd sky130_fd_pr__pfet_01v8_lvt l=1 w=1 as=0.29 ad=0.145
+ ps=2.58 pd=1.29
X$194 Vdd \$67 Vom Vdd sky130_fd_pr__pfet_01v8_lvt l=1 w=1 as=0.145 ad=0.29
+ ps=1.29 pd=2.58
X$195 Vom \$67 Vdd Vdd sky130_fd_pr__pfet_01v8_lvt l=1 w=1 as=0.29 ad=0.145
+ ps=2.58 pd=1.29
X$196 Vdd \$67 Vom Vdd sky130_fd_pr__pfet_01v8_lvt l=1 w=1 as=0.145 ad=0.29
+ ps=1.29 pd=2.58
X$197 Vom \$67 Vdd Vdd sky130_fd_pr__pfet_01v8_lvt l=1 w=1 as=0.29 ad=0.145
+ ps=2.58 pd=1.29
X$198 Vdd \$67 Vom Vdd sky130_fd_pr__pfet_01v8_lvt l=1 w=1 as=0.145 ad=0.29
+ ps=1.29 pd=2.58
X$199 Vom \$67 Vdd Vdd sky130_fd_pr__pfet_01v8_lvt l=1 w=1 as=0.29 ad=0.145
+ ps=2.58 pd=1.29
X$200 Vdd \$67 Vom Vdd sky130_fd_pr__pfet_01v8_lvt l=1 w=1 as=0.145 ad=0.29
+ ps=1.29 pd=2.58
X$201 Vom \$67 Vdd Vdd sky130_fd_pr__pfet_01v8_lvt l=1 w=1 as=0.29 ad=0.145
+ ps=2.58 pd=1.29
X$202 Vdd \$67 Vom Vdd sky130_fd_pr__pfet_01v8_lvt l=1 w=1 as=0.145 ad=0.29
+ ps=1.29 pd=2.58
X$203 Vom \$67 Vdd Vdd sky130_fd_pr__pfet_01v8_lvt l=1 w=1 as=0.29 ad=0.145
+ ps=2.58 pd=1.29
X$204 Vdd \$67 Vom Vdd sky130_fd_pr__pfet_01v8_lvt l=1 w=1 as=0.145 ad=0.29
+ ps=1.29 pd=2.58
X$205 Vom \$67 Vdd Vdd sky130_fd_pr__pfet_01v8_lvt l=1 w=1 as=0.29 ad=0.145
+ ps=2.58 pd=1.29
X$206 Vdd \$67 Vom Vdd sky130_fd_pr__pfet_01v8_lvt l=1 w=1 as=0.145 ad=0.29
+ ps=1.29 pd=2.58
X$207 Vom \$67 Vdd Vdd sky130_fd_pr__pfet_01v8_lvt l=1 w=1 as=0.29 ad=0.145
+ ps=2.58 pd=1.29
X$208 Vdd \$67 Vom Vdd sky130_fd_pr__pfet_01v8_lvt l=1 w=1 as=0.145 ad=0.29
+ ps=1.29 pd=2.58
X$209 Vom \$67 Vdd Vdd sky130_fd_pr__pfet_01v8_lvt l=1 w=1 as=0.29 ad=0.145
+ ps=2.58 pd=1.29
X$210 Vdd \$67 Vom Vdd sky130_fd_pr__pfet_01v8_lvt l=1 w=1 as=0.145 ad=0.29
+ ps=1.29 pd=2.58
X$211 Vss Vss Vss sky130_gnd sky130_fd_pr__nfet_01v8_lvt l=20 w=5 as=1.45
+ ad=1.45 ps=10.58 pd=10.58
X$212 Vss Vss Vss sky130_gnd sky130_fd_pr__nfet_01v8_lvt l=20 w=5 as=1.45
+ ad=1.45 ps=10.58 pd=10.58
X$213 \$343 VREF \$279 sky130_gnd sky130_fd_pr__nfet_01v8_lvt l=20 w=5 as=1.45
+ ad=1.45 ps=10.58 pd=10.58
X$214 \$343 VREF \$279 sky130_gnd sky130_fd_pr__nfet_01v8_lvt l=20 w=5 as=1.45
+ ad=1.45 ps=10.58 pd=10.58
X$215 \$343 \$67 \$287 sky130_gnd sky130_fd_pr__nfet_01v8_lvt l=20 w=5 as=1.45
+ ad=1.45 ps=10.58 pd=10.58
X$216 \$343 \$67 \$287 sky130_gnd sky130_fd_pr__nfet_01v8_lvt l=20 w=5 as=1.45
+ ad=1.45 ps=10.58 pd=10.58
X$217 Vss Vss Vss sky130_gnd sky130_fd_pr__nfet_01v8_lvt l=20 w=5 as=1.45
+ ad=1.45 ps=10.58 pd=10.58
X$218 Vss Vss Vss sky130_gnd sky130_fd_pr__nfet_01v8_lvt l=20 w=5 as=1.45
+ ad=1.45 ps=10.58 pd=10.58
X$219 \$278 \$3 \$287 sky130_gnd sky130_fd_pr__nfet_01v8_lvt l=20 w=5 as=1.45
+ ad=1.45 ps=10.58 pd=10.58
X$220 \$278 \$3 \$287 sky130_gnd sky130_fd_pr__nfet_01v8_lvt l=20 w=5 as=1.45
+ ad=1.45 ps=10.58 pd=10.58
X$221 \$278 VREF \$279 sky130_gnd sky130_fd_pr__nfet_01v8_lvt l=20 w=5 as=1.45
+ ad=1.45 ps=10.58 pd=10.58
X$222 \$278 VREF \$279 sky130_gnd sky130_fd_pr__nfet_01v8_lvt l=20 w=5 as=1.45
+ ad=1.45 ps=10.58 pd=10.58
X$223 \$277 Vm \$286 sky130_gnd sky130_fd_pr__nfet_01v8_lvt l=4 w=4 as=1.16
+ ad=1.16 ps=8.58 pd=8.58
X$224 \$277 Vp \$276 sky130_gnd sky130_fd_pr__nfet_01v8_lvt l=4 w=4 as=1.16
+ ad=1.16 ps=8.58 pd=8.58
X$225 \$277 Vm \$286 sky130_gnd sky130_fd_pr__nfet_01v8_lvt l=4 w=4 as=1.16
+ ad=1.16 ps=8.58 pd=8.58
X$226 \$277 Vp \$276 sky130_gnd sky130_fd_pr__nfet_01v8_lvt l=4 w=4 as=1.16
+ ad=1.16 ps=8.58 pd=8.58
X$227 Vss Vss Vss sky130_gnd sky130_fd_pr__nfet_01v8_lvt l=4 w=4 as=1.16
+ ad=1.16 ps=8.58 pd=8.58
X$228 Vss Vss Vss sky130_gnd sky130_fd_pr__nfet_01v8_lvt l=4 w=4 as=1.16
+ ad=1.16 ps=8.58 pd=8.58
X$229 RGM \$27 \$27 sky130_gnd sky130_fd_pr__nfet_01v8_lvt l=1 w=10 as=2.9
+ ad=2.9 ps=20.58 pd=20.58
X$230 RGM \$27 \$27 sky130_gnd sky130_fd_pr__nfet_01v8_lvt l=1 w=10 as=2.9
+ ad=2.9 ps=20.58 pd=20.58
X$231 \$66 \$55 \$7 sky130_gnd sky130_fd_pr__nfet_01v8_lvt l=1 w=2 as=0.58
+ ad=0.58 ps=4.58 pd=4.58
X$232 Vdd \$55 \$55 Vdd sky130_fd_pr__pfet_01v8_lvt l=20 w=1 as=0.29 ad=0.29
+ ps=2.58 pd=2.58
X$233 Vdd \$55 \$55 Vdd sky130_fd_pr__pfet_01v8_lvt l=20 w=1 as=0.29 ad=0.29
+ ps=2.58 pd=2.58
X$234 Vdd Vdd Vdd Vdd sky130_fd_pr__pfet_01v8_lvt l=1 w=5 as=1.45 ad=1.45
+ ps=10.58 pd=10.58
X$235 Vdd Vdd Vdd Vdd sky130_fd_pr__pfet_01v8_lvt l=1 w=5 as=1.45 ad=1.45
+ ps=10.58 pd=10.58
X$236 Vdd \$7 \$121 Vdd sky130_fd_pr__pfet_01v8_lvt l=1 w=5 as=1.45 ad=1.45
+ ps=10.58 pd=10.58
X$237 Vdd \$7 \$301 Vdd sky130_fd_pr__pfet_01v8_lvt l=1 w=5 as=1.45 ad=1.45
+ ps=10.58 pd=10.58
X$238 Vdd \$7 \$121 Vdd sky130_fd_pr__pfet_01v8_lvt l=1 w=5 as=1.45 ad=1.45
+ ps=10.58 pd=10.58
X$239 Vdd \$7 \$301 Vdd sky130_fd_pr__pfet_01v8_lvt l=1 w=5 as=1.45 ad=1.45
+ ps=10.58 pd=10.58
X$240 Vdd Vdd Vdd Vdd sky130_fd_pr__pfet_01v8_lvt l=1 w=5 as=1.45 ad=1.45
+ ps=10.58 pd=10.58
X$241 Vdd \$7 \$66 Vdd sky130_fd_pr__pfet_01v8_lvt l=1 w=5 as=1.45 ad=1.45
+ ps=10.58 pd=10.58
X$242 Vdd \$7 \$27 Vdd sky130_fd_pr__pfet_01v8_lvt l=1 w=5 as=1.45 ad=1.45
+ ps=10.58 pd=10.58
X$243 Vdd \$7 \$27 Vdd sky130_fd_pr__pfet_01v8_lvt l=1 w=5 as=1.45 ad=1.45
+ ps=10.58 pd=10.58
X$244 Vdd \$7 \$66 Vdd sky130_fd_pr__pfet_01v8_lvt l=1 w=5 as=1.45 ad=1.45
+ ps=10.58 pd=10.58
X$245 Vdd Vdd Vdd Vdd sky130_fd_pr__pfet_01v8_lvt l=1 w=5 as=1.45 ad=1.45
+ ps=10.58 pd=10.58
X$246 Vdd Vdd Vdd Vdd sky130_fd_pr__pfet_01v8_lvt l=1 w=5 as=1.45 ad=1.45
+ ps=10.58 pd=10.58
X$247 Vdd \$45 \$45 Vdd sky130_fd_pr__pfet_01v8_lvt l=1 w=5 as=1.45 ad=1.45
+ ps=10.58 pd=10.58
X$248 Vdd \$45 \$7 Vdd sky130_fd_pr__pfet_01v8_lvt l=1 w=5 as=1.45 ad=1.45
+ ps=10.58 pd=10.58
X$249 Vdd \$45 \$45 Vdd sky130_fd_pr__pfet_01v8_lvt l=1 w=5 as=1.45 ad=1.45
+ ps=10.58 pd=10.58
X$250 Vdd \$45 \$7 Vdd sky130_fd_pr__pfet_01v8_lvt l=1 w=5 as=1.45 ad=1.45
+ ps=10.58 pd=10.58
X$251 Vdd Vdd Vdd Vdd sky130_fd_pr__pfet_01v8_lvt l=1 w=5 as=1.45 ad=1.45
+ ps=10.58 pd=10.58
X$252 Vdd Vdd Vdd Vdd sky130_fd_pr__pfet_01v8_lvt l=1 w=5 as=1.45 ad=1.45
+ ps=10.58 pd=10.58
X$253 Vdd \$7 \$402 Vdd sky130_fd_pr__pfet_01v8_lvt l=1 w=5 as=1.45 ad=1.45
+ ps=10.58 pd=10.58
X$254 Vdd \$7 \$176 Vdd sky130_fd_pr__pfet_01v8_lvt l=1 w=5 as=1.45 ad=1.45
+ ps=10.58 pd=10.58
X$255 Vdd \$7 \$402 Vdd sky130_fd_pr__pfet_01v8_lvt l=1 w=5 as=1.45 ad=1.45
+ ps=10.58 pd=10.58
X$256 Vdd \$7 \$176 Vdd sky130_fd_pr__pfet_01v8_lvt l=1 w=5 as=1.45 ad=1.45
+ ps=10.58 pd=10.58
X$257 Vdd Vdd Vdd Vdd sky130_fd_pr__pfet_01v8_lvt l=1 w=5 as=1.45 ad=1.45
+ ps=10.58 pd=10.58
X$258 Vss \$27 \$45 sky130_gnd sky130_fd_pr__nfet_01v8_lvt l=2 w=5 as=1.45
+ ad=1.45 ps=10.58 pd=10.58
X$259 Vss \$27 \$45 sky130_gnd sky130_fd_pr__nfet_01v8_lvt l=2 w=5 as=1.45
+ ad=1.45 ps=10.58 pd=10.58
X$260 Vss \$66 \$55 sky130_gnd sky130_fd_pr__nfet_01v8_lvt l=2 w=5 as=1.45
+ ad=1.45 ps=10.58 pd=10.58
X$261 Vss \$66 \$55 sky130_gnd sky130_fd_pr__nfet_01v8_lvt l=2 w=5 as=1.45
+ ad=1.45 ps=10.58 pd=10.58
X$262 Vss \$66 \$7 sky130_gnd sky130_fd_pr__nfet_01v8_lvt l=2 w=5 as=1.45
+ ad=1.45 ps=10.58 pd=10.58
X$263 Vss \$66 \$7 sky130_gnd sky130_fd_pr__nfet_01v8_lvt l=2 w=5 as=1.45
+ ad=1.45 ps=10.58 pd=10.58
X$264 Vss Vss Vss sky130_gnd sky130_fd_pr__nfet_01v8_lvt l=2 w=5 as=1.45
+ ad=1.45 ps=10.58 pd=10.58
X$265 Vss Vss Vss sky130_gnd sky130_fd_pr__nfet_01v8_lvt l=2 w=5 as=1.45
+ ad=1.45 ps=10.58 pd=10.58
X$266 Vss \$66 \$66 sky130_gnd sky130_fd_pr__nfet_01v8_lvt l=2 w=5 as=1.45
+ ad=1.45 ps=10.58 pd=10.58
X$267 Vss \$66 \$66 sky130_gnd sky130_fd_pr__nfet_01v8_lvt l=2 w=5 as=1.45
+ ad=1.45 ps=10.58 pd=10.58
Cext_1 \$121 \$154 278.615a
Cext_2 \$121 \$174 302.344a
Cext_3 \$121 \$192 82.5909a
Cext_4 \$121 \$206 51.685a
Cext_5 \$121 \$207 73.0327a
Cext_6 \$121 \$276 67.8922a
Cext_7 \$121 \$277 555.866a
Cext_8 \$121 \$278 802.986a
Cext_9 \$121 \$279 2.22996f
Cext_10 \$121 \$286 76.9186a
Cext_11 \$121 \$287 1.61237f
Cext_12 \$121 \$3 4.12068f
Cext_13 \$121 \$301 1.65315f
Cext_14 \$121 \$343 732.81a
Cext_15 \$121 \$345 608.385a
Cext_16 \$121 \$346 594.563a
Cext_17 \$121 \$402 339.504a
Cext_18 \$121 \$403 460.213a
Cext_19 \$121 \$416 0.117388a
Cext_20 \$121 \$418 627.064a
Cext_21 \$121 \$67 228.25a
Cext_22 \$121 \$7 666.304a
Cext_23 \$121 Vdd 5.36295f
Cext_24 \$121 Vom 84.5855a
Cext_25 \$121 Vop 191.281a
Cext_26 \$121 VREF 1.08781f
Cext_27 \$121 Vss 27.4012f
Cext_28 \$121 sky130_gnd 75.8459f
Cext_29 \$154 \$174 6.77451f
Cext_30 \$154 \$176 68.9855a
Cext_31 \$154 \$192 1.08199f
Cext_32 \$154 \$206 136.319a
Cext_33 \$154 \$207 3.34685f
Cext_34 \$154 \$3 259.688a
Cext_35 \$154 \$301 404.266a
Cext_36 \$154 \$402 175.116a
Cext_37 \$154 \$67 101.948a
Cext_38 \$154 Vdd 2.65622f
Cext_39 \$154 Vom 1.2408f
Cext_40 \$154 Vop 1.92543f
Cext_41 \$154 VREF 326.011a
Cext_42 \$154 Vss 9.25465f
Cext_43 \$154 sky130_gnd 20.5988f
Cext_44 \$174 \$176 467.571a
Cext_45 \$174 \$192 71.8955a
Cext_46 \$174 \$206 549.791a
Cext_47 \$174 \$207 3.35957f
Cext_48 \$174 \$3 272.212a
Cext_49 \$174 \$3.x2_x2_net10 0.114829a
Cext_50 \$174 \$301 379.197a
Cext_51 \$174 \$402 310.299a
Cext_52 \$174 \$67 553.869a
Cext_53 \$174 Vdd 5.30905f
Cext_54 \$174 Vom 259.068a
Cext_55 \$174 Vop 220.228a
Cext_56 \$174 VREF 77.7085a
Cext_57 \$174 Vss 18.628f
Cext_58 \$174 sky130_gnd 37.9165f
Cext_59 \$176 \$192 1.05662f
Cext_60 \$176 \$3 3.44114a
Cext_61 \$176 \$301 4.35294a
Cext_62 \$176 \$402 2.28343f
Cext_63 \$176 \$67 104.661a
Cext_64 \$176 \$7 665.062a
Cext_65 \$176 Vdd 3.23241f
Cext_66 \$176 Vom 73.314a
Cext_67 \$176 Vop 98.5465a
Cext_68 \$176 Vss 3.37544f
Cext_69 \$176 sky130_gnd 4.65497f
Cext_70 \$192 \$206 411.127a
Cext_71 \$192 \$207 1.78942f
Cext_72 \$192 \$3 65.5381a
Cext_73 \$192 \$301 99.6437a
Cext_74 \$192 \$402 310.522a
Cext_75 \$192 \$67 61.9419a
Cext_76 \$192 Vdd 13.9011f
Cext_77 \$192 Vom 726.06a
Cext_78 \$192 Vop 86.5839a
Cext_79 \$192 VREF 9.36202a
Cext_80 \$192 Vss 752.808a
Cext_81 \$192 sky130_gnd 5.24394f
Cext_82 \$206 \$207 746.381a
Cext_83 \$206 \$27 0.603362a
Cext_84 \$206 \$3 51.685a
Cext_85 \$206 \$3.x2_x1_net11 0.840458a
Cext_86 \$206 \$3.x2_x1_net13 0.46419a
Cext_87 \$206 \$3.x2_x1_net15 0.840458a
Cext_88 \$206 \$3.x2_x1_net17 1.10535a
Cext_89 \$206 \$3.x2_x1_net19 0.46419a
Cext_90 \$206 \$3.x2_x1_net2 0.840458a
Cext_91 \$206 \$3.x2_x1_net4 73.9865a
Cext_92 \$206 \$3.x2_x1_net5 12.3655a
Cext_93 \$206 \$3.x2_x1_net7 0.46419a
Cext_94 \$206 \$3.x2_x1_net9 0.46419a
Cext_95 \$206 \$3.x2_x2_net11 0.46419a
Cext_96 \$206 \$3.x2_x2_net13 0.840458a
Cext_97 \$206 \$3.x2_x2_net15 0.46419a
Cext_98 \$206 \$3.x2_x2_net17 1.13649a
Cext_99 \$206 \$3.x2_x2_net19 0.840458a
Cext_100 \$206 \$3.x2_x2_net2 0.46419a
Cext_101 \$206 \$3.x2_x2_net4 4.12606a
Cext_102 \$206 \$3.x2_x2_net5 160.545a
Cext_103 \$206 \$3.x2_x2_net7 0.840458a
Cext_104 \$206 \$3.x2_x2_net9 0.840458a
Cext_105 \$206 \$301 209.301a
Cext_106 \$206 \$402 220.552a
Cext_107 \$206 \$66 0.603362a
Cext_108 \$206 \$67 10.292a
Cext_109 \$206 \$7 0.603362a
Cext_110 \$206 Vdd 14.9345f
Cext_111 \$206 Vom 2.77996f
Cext_112 \$206 Vop 3.0355f
Cext_113 \$206 VREF 3.29557f
Cext_114 \$206 Vss 3.93784f
Cext_115 \$206 sky130_gnd 5.78599f
Cext_116 \$207 \$3 57.3962a
Cext_117 \$207 \$301 85.7905a
Cext_118 \$207 \$402 85.007a
Cext_119 \$207 \$67 7.066a
Cext_120 \$207 Vdd 4.99168f
Cext_121 \$207 Vom 84.7229a
Cext_122 \$207 Vop 89.2991a
Cext_123 \$207 VREF 349.53a
Cext_124 \$207 Vss 120.597a
Cext_125 \$207 sky130_gnd 1.5341f
Cext_126 \$27 \$3 213.427a
Cext_127 \$27 \$45 1.46232f
Cext_128 \$27 \$55 305.889a
Cext_129 \$27 \$66 1.16188f
Cext_130 \$27 \$67 141.136a
Cext_131 \$27 \$7 813.669a
Cext_132 \$27 RGM 3.01883f
Cext_133 \$27 Vdd 2.19955f
Cext_134 \$27 Vom 514.964a
Cext_135 \$27 Vop 779.8a
Cext_136 \$27 Vss 2.77692f
Cext_137 \$27 sky130_gnd 9.43366f
Cext_138 \$276 \$277 2.28165f
Cext_139 \$276 \$278 51.685a
Cext_140 \$276 \$279 5.75093f
Cext_141 \$276 \$286 9.50833f
Cext_142 \$276 \$287 137.54a
Cext_143 \$276 \$3 1.50706f
Cext_144 \$276 \$301 81.2265a
Cext_145 \$276 \$343 110.974a
Cext_146 \$276 \$345 7.72937a
Cext_147 \$276 \$346 7.72937a
Cext_148 \$276 \$402 72.8674a
Cext_149 \$276 \$403 7.72937a
Cext_150 \$276 \$416 5.08376f
Cext_151 \$276 \$418 7.72937a
Cext_152 \$276 \$67 134.418a
Cext_153 \$276 Vdd 11.7956f
Cext_154 \$276 Vm 92.3339a
Cext_155 \$276 Vp 1.00643f
Cext_156 \$276 VREF 372.391a
Cext_157 \$276 Vss 1.09561f
Cext_158 \$276 sky130_gnd 7.49883f
Cext_159 \$277 \$278 358.615a
Cext_160 \$277 \$279 95.3419a
Cext_161 \$277 \$286 2.11863f
Cext_162 \$277 \$287 149.105a
Cext_163 \$277 \$3 392.357a
Cext_164 \$277 \$301 1.05065f
Cext_165 \$277 \$343 206.838a
Cext_166 \$277 \$345 305.114a
Cext_167 \$277 \$346 1.12346f
Cext_168 \$277 \$402 98.9936a
Cext_169 \$277 \$403 191.659a
Cext_170 \$277 \$418 1.26395f
Cext_171 \$277 \$67 2.99597f
Cext_172 \$277 Vdd 94.9421a
Cext_173 \$277 Vm 985.604a
Cext_174 \$277 Vp 1.00333f
Cext_175 \$277 VREF 1.97316f
Cext_176 \$277 Vss 8.37108f
Cext_177 \$277 sky130_gnd 6.04084f
Cext_178 \$278 \$279 7.60349f
Cext_179 \$278 \$286 67.4624a
Cext_180 \$278 \$287 6.14797f
Cext_181 \$278 \$3 1.84792f
Cext_182 \$278 \$301 236.665a
Cext_183 \$278 \$343 5.71922f
Cext_184 \$278 \$345 67.0493a
Cext_185 \$278 \$346 68.7378a
Cext_186 \$278 \$402 172.355a
Cext_187 \$278 \$403 0.503546a
Cext_188 \$278 \$67 232.601a
Cext_189 \$278 Vdd 166.194a
Cext_190 \$278 Vm 0.413139a
Cext_191 \$278 Vom 1.70307a
Cext_192 \$278 Vop 3.37604a
Cext_193 \$278 Vp 0.413139a
Cext_194 \$278 VREF 1.72345f
Cext_195 \$278 Vss 7.7308f
Cext_196 \$278 sky130_gnd 6.69906f
Cext_197 \$279 \$286 3.9075f
Cext_198 \$279 \$287 4.86721f
Cext_199 \$279 \$3 1.34699f
Cext_200 \$279 \$301 242.679a
Cext_201 \$279 \$343 6.04862f
Cext_202 \$279 \$345 50.2543a
Cext_203 \$279 \$346 44.583a
Cext_204 \$279 \$402 251.021a
Cext_205 \$279 \$403 44.4323a
Cext_206 \$279 \$416 5.16141a
Cext_207 \$279 \$418 44.4323a
Cext_208 \$279 \$67 749.573a
Cext_209 \$279 Vdd 53.267f
Cext_210 \$279 Vom 253.321a
Cext_211 \$279 Vop 261.613a
Cext_212 \$279 VREF 2.62657f
Cext_213 \$279 Vss 7.80301f
Cext_214 \$279 sky130_gnd 15.9228f
Cext_215 \$286 \$287 181.886a
Cext_216 \$286 \$3 215.977a
Cext_217 \$286 \$301 81.2265a
Cext_218 \$286 \$343 157.287a
Cext_219 \$286 \$345 1.3915a
Cext_220 \$286 \$346 1.32193a
Cext_221 \$286 \$402 140.88a
Cext_222 \$286 \$403 1.3915a
Cext_223 \$286 \$416 5.27519f
Cext_224 \$286 \$418 1.32193a
Cext_225 \$286 \$67 1.41705f
Cext_226 \$286 Vdd 16.8697f
Cext_227 \$286 Vm 978.701a
Cext_228 \$286 Vp 260.588a
Cext_229 \$286 VREF 135.626a
Cext_230 \$286 Vss 3.01769f
Cext_231 \$286 sky130_gnd 2.91197f
Cext_232 \$287 \$3 1.75508f
Cext_233 \$287 \$301 253.512a
Cext_234 \$287 \$343 6.34758f
Cext_235 \$287 \$345 97.311a
Cext_236 \$287 \$346 85.9413a
Cext_237 \$287 \$402 241.405a
Cext_238 \$287 \$403 85.7905a
Cext_239 \$287 \$416 5.66718a
Cext_240 \$287 \$418 85.7905a
Cext_241 \$287 \$67 2.22717f
Cext_242 \$287 Vdd 29.3711f
Cext_243 \$287 VREF 942.222a
Cext_244 \$287 Vss 8.57924f
Cext_245 \$287 sky130_gnd 13.7011f
Cext_246 \$3 \$301 777.8a
Cext_247 \$3 \$343 170.565a
Cext_248 \$3 \$345 1.21826f
Cext_249 \$3 \$346 1.35796f
Cext_250 \$3 \$402 410.457a
Cext_251 \$3 \$403 84.1021a
Cext_252 \$3 \$416 1.98202f
Cext_253 \$3 \$418 98.2245a
Cext_254 \$3 \$45 110.335a
Cext_255 \$3 \$55 94.5782a
Cext_256 \$3 \$66 83.352a
Cext_257 \$3 \$67 4.51519f
Cext_258 \$3 \$7 213.927a
Cext_259 \$3 RGM 18.2416a
Cext_260 \$3 Vdd 21.3814f
Cext_261 \$3 Vom 624.529a
Cext_262 \$3 Vop 1.04888p
Cext_263 \$3 Vp 3.29674a
Cext_264 \$3 VREF 6.45773f
Cext_265 \$3 Vss 12.168f
Cext_266 \$3 sky130_gnd 36.0887f
Cext_267 \$3.x2_x1_net1 \$3.x2_x1_net10 159.659a
Cext_268 \$3.x2_x1_net1 \$3.x2_x1_net6 159.659a
Cext_269 \$3.x2_x1_net1 \$3.x2_x2_net1 512.201a
Cext_270 \$3.x2_x1_net1 \$3.x2_x2_net10 9.25a
Cext_271 \$3.x2_x1_net1 \$3.x2_x2_net6 9.25a
Cext_272 \$3.x2_x1_net1 Vss 55.6378a
Cext_273 \$3.x2_x1_net1 sky130_gnd 1.22892f
Cext_274 \$3.x2_x1_net10 \$3.x2_x1_net8 159.659a
Cext_275 \$3.x2_x1_net10 \$3.x2_x2_net1 20.8047a
Cext_276 \$3.x2_x1_net10 \$3.x2_x2_net10 414.569a
Cext_277 \$3.x2_x1_net10 \$3.x2_x2_net8 20.8047a
Cext_278 \$3.x2_x1_net10 Vss 196.432a
Cext_279 \$3.x2_x1_net10 sky130_gnd 1.2461f
Cext_280 \$3.x2_x1_net11 \$3.x2_x2_net11 512.979a
Cext_281 \$3.x2_x1_net11 \$3.x2_x2_net7 20.8047a
Cext_282 \$3.x2_x1_net11 \$3.x2_x2_net9 20.8047a
Cext_283 \$3.x2_x1_net11 Vom 0.46419a
Cext_284 \$3.x2_x1_net11 Vop 2.4283a
Cext_285 \$3.x2_x1_net11 Vss 97.9997a
Cext_286 \$3.x2_x1_net11 sky130_gnd 1.12882f
Cext_287 \$3.x2_x1_net12 \$3.x2_x1_net14 159.659a
Cext_288 \$3.x2_x1_net12 \$3.x2_x1_net8 159.659a
Cext_289 \$3.x2_x1_net12 \$3.x2_x2_net12 414.569a
Cext_290 \$3.x2_x1_net12 \$3.x2_x2_net14 20.8047a
Cext_291 \$3.x2_x1_net12 \$3.x2_x2_net8 20.8047a
Cext_292 \$3.x2_x1_net12 Vss 195.518a
Cext_293 \$3.x2_x1_net12 sky130_gnd 1.24701f
Cext_294 \$3.x2_x1_net13 \$3.x2_x2_net13 414.418a
Cext_295 \$3.x2_x1_net13 \$3.x2_x2_net15 9.25a
Cext_296 \$3.x2_x1_net13 \$3.x2_x2_net2 9.25a
Cext_297 \$3.x2_x1_net13 Vom 0.292982a
Cext_298 \$3.x2_x1_net13 Vop 1.34603a
Cext_299 \$3.x2_x1_net13 Vss 6.05559a
Cext_300 \$3.x2_x1_net13 sky130_gnd 1.12785f
Cext_301 \$3.x2_x1_net14 \$3.x2_x1_net3 159.659a
Cext_302 \$3.x2_x1_net14 \$3.x2_x2_net12 9.25a
Cext_303 \$3.x2_x1_net14 \$3.x2_x2_net14 512.201a
Cext_304 \$3.x2_x1_net14 \$3.x2_x2_net3 9.25a
Cext_305 \$3.x2_x1_net14 Vss 55.4537a
Cext_306 \$3.x2_x1_net14 sky130_gnd 1.23f
Cext_307 \$3.x2_x1_net15 \$3.x2_x2_net13 20.8047a
Cext_308 \$3.x2_x1_net15 \$3.x2_x2_net15 512.979a
Cext_309 \$3.x2_x1_net15 \$3.x2_x2_net19 20.8047a
Cext_310 \$3.x2_x1_net15 Vom 0.46419a
Cext_311 \$3.x2_x1_net15 Vop 2.4283a
Cext_312 \$3.x2_x1_net15 Vss 97.9997a
Cext_313 \$3.x2_x1_net15 sky130_gnd 1.12882f
Cext_314 \$3.x2_x1_net16 \$3.x2_x1_net18 159.659a
Cext_315 \$3.x2_x1_net16 \$3.x2_x2_net16 414.569a
Cext_316 \$3.x2_x1_net16 \$3.x2_x2_net18 20.8047a
Cext_317 \$3.x2_x1_net16 Vss 382.491a
Cext_318 \$3.x2_x1_net16 sky130_gnd 1.24945f
Cext_319 \$3.x2_x1_net17 \$3.x2_x2_net17 512.979a
Cext_320 \$3.x2_x1_net17 \$3.x2_x2_net19 20.8047a
Cext_321 \$3.x2_x1_net17 Vom 11.7275a
Cext_322 \$3.x2_x1_net17 Vop 2.4283a
Cext_323 \$3.x2_x1_net17 Vss 99.664a
Cext_324 \$3.x2_x1_net17 sky130_gnd 1.13923f
Cext_325 \$3.x2_x1_net18 \$3.x2_x1_net3 159.659a
Cext_326 \$3.x2_x1_net18 \$3.x2_x2_net16 9.25a
Cext_327 \$3.x2_x1_net18 \$3.x2_x2_net18 512.201a
Cext_328 \$3.x2_x1_net18 \$3.x2_x2_net3 9.25a
Cext_329 \$3.x2_x1_net18 Vss 55.9663a
Cext_330 \$3.x2_x1_net18 sky130_gnd 1.23f
Cext_331 \$3.x2_x1_net19 \$3.x2_x2_net15 9.25a
Cext_332 \$3.x2_x1_net19 \$3.x2_x2_net17 9.25a
Cext_333 \$3.x2_x1_net19 \$3.x2_x2_net19 414.418a
Cext_334 \$3.x2_x1_net19 Vom 0.292982a
Cext_335 \$3.x2_x1_net19 Vop 1.34603a
Cext_336 \$3.x2_x1_net19 Vss 6.05559a
Cext_337 \$3.x2_x1_net19 sky130_gnd 1.12785f
Cext_338 \$3.x2_x1_net2 \$3.x2_x2_net13 20.8047a
Cext_339 \$3.x2_x1_net2 \$3.x2_x2_net2 512.979a
Cext_340 \$3.x2_x1_net2 \$3.x2_x2_net9 20.8047a
Cext_341 \$3.x2_x1_net2 Vom 0.46419a
Cext_342 \$3.x2_x1_net2 Vop 2.4283a
Cext_343 \$3.x2_x1_net2 Vss 97.9997a
Cext_344 \$3.x2_x1_net2 sky130_gnd 1.12882f
Cext_345 \$3.x2_x1_net3 \$3.x2_x2_net14 20.8047a
Cext_346 \$3.x2_x1_net3 \$3.x2_x2_net18 20.8047a
Cext_347 \$3.x2_x1_net3 \$3.x2_x2_net3 414.569a
Cext_348 \$3.x2_x1_net3 Vss 195.518a
Cext_349 \$3.x2_x1_net3 sky130_gnd 1.24701f
Cext_350 \$3.x2_x1_net4 \$3.x2_x1_net6 159.659a
Cext_351 \$3.x2_x1_net4 \$3.x2_x2_net4 512.201a
Cext_352 \$3.x2_x1_net4 \$3.x2_x2_net6 9.25a
Cext_353 \$3.x2_x1_net4 Vss 328.697a
Cext_354 \$3.x2_x1_net4 sky130_gnd 1.24014f
Cext_355 \$3.x2_x1_net5 \$3.x2_x2_net5 512.979a
Cext_356 \$3.x2_x1_net5 \$3.x2_x2_net7 20.8047a
Cext_357 \$3.x2_x1_net5 Vom 0.581781a
Cext_358 \$3.x2_x1_net5 Vop 2.86193a
Cext_359 \$3.x2_x1_net5 Vss 115.283a
Cext_360 \$3.x2_x1_net5 sky130_gnd 1.13948f
Cext_361 \$3.x2_x1_net6 \$3.x2_x2_net1 20.8047a
Cext_362 \$3.x2_x1_net6 \$3.x2_x2_net4 20.8047a
Cext_363 \$3.x2_x1_net6 \$3.x2_x2_net6 414.569a
Cext_364 \$3.x2_x1_net6 Vss 206.337a
Cext_365 \$3.x2_x1_net6 sky130_gnd 1.24585f
Cext_366 \$3.x2_x1_net7 \$3.x2_x2_net11 9.25a
Cext_367 \$3.x2_x1_net7 \$3.x2_x2_net5 9.25a
Cext_368 \$3.x2_x1_net7 \$3.x2_x2_net7 414.418a
Cext_369 \$3.x2_x1_net7 Vom 0.292982a
Cext_370 \$3.x2_x1_net7 Vop 1.34603a
Cext_371 \$3.x2_x1_net7 Vss 8.54699a
Cext_372 \$3.x2_x1_net7 sky130_gnd 1.12785f
Cext_373 \$3.x2_x1_net8 \$3.x2_x2_net10 9.25a
Cext_374 \$3.x2_x1_net8 \$3.x2_x2_net12 9.25a
Cext_375 \$3.x2_x1_net8 \$3.x2_x2_net8 512.201a
Cext_376 \$3.x2_x1_net8 Vss 55.4537a
Cext_377 \$3.x2_x1_net8 sky130_gnd 1.23f
Cext_378 \$3.x2_x1_net9 \$3.x2_x2_net11 9.25a
Cext_379 \$3.x2_x1_net9 \$3.x2_x2_net2 9.25a
Cext_380 \$3.x2_x1_net9 \$3.x2_x2_net9 414.418a
Cext_381 \$3.x2_x1_net9 Vom 0.292982a
Cext_382 \$3.x2_x1_net9 Vop 1.34603a
Cext_383 \$3.x2_x1_net9 Vss 6.05559a
Cext_384 \$3.x2_x1_net9 sky130_gnd 1.12785f
Cext_385 \$3.x2_x2_net1 Vss 103.139a
Cext_386 \$3.x2_x2_net1 sky130_gnd 1.12347f
Cext_387 \$3.x2_x2_net10 Vss 8.98715a
Cext_388 \$3.x2_x2_net10 sky130_gnd 1.12288f
Cext_389 \$3.x2_x2_net11 \$3.x2_x2_net7 159.492a
Cext_390 \$3.x2_x2_net11 \$3.x2_x2_net9 159.492a
Cext_391 \$3.x2_x2_net11 Vom 0.292982a
Cext_392 \$3.x2_x2_net11 Vop 1.34603a
Cext_393 \$3.x2_x2_net11 Vss 51.5188a
Cext_394 \$3.x2_x2_net11 sky130_gnd 1.2341f
Cext_395 \$3.x2_x2_net12 Vss 9.10591a
Cext_396 \$3.x2_x2_net12 sky130_gnd 1.12408f
Cext_397 \$3.x2_x2_net13 \$3.x2_x2_net15 159.492a
Cext_398 \$3.x2_x2_net13 \$3.x2_x2_net2 159.492a
Cext_399 \$3.x2_x2_net13 Vom 0.46419a
Cext_400 \$3.x2_x2_net13 Vop 2.4283a
Cext_401 \$3.x2_x2_net13 Vss 189.003a
Cext_402 \$3.x2_x2_net13 sky130_gnd 1.2512f
Cext_403 \$3.x2_x2_net14 Vss 102.91a
Cext_404 \$3.x2_x2_net14 sky130_gnd 1.12463f
Cext_405 \$3.x2_x2_net15 \$3.x2_x2_net19 159.492a
Cext_406 \$3.x2_x2_net15 Vom 0.292982a
Cext_407 \$3.x2_x2_net15 Vop 1.34603a
Cext_408 \$3.x2_x2_net15 Vss 51.5188a
Cext_409 \$3.x2_x2_net15 sky130_gnd 1.2341f
Cext_410 \$3.x2_x2_net16 Vss 14.5324a
Cext_411 \$3.x2_x2_net16 sky130_gnd 1.1347f
Cext_412 \$3.x2_x2_net17 \$3.x2_x2_net19 159.492a
Cext_413 \$3.x2_x2_net17 Vom 159.785a
Cext_414 \$3.x2_x2_net17 Vop 1.34603a
Cext_415 \$3.x2_x2_net17 Vss 54.3489a
Cext_416 \$3.x2_x2_net17 sky130_gnd 1.24444f
Cext_417 \$3.x2_x2_net18 Vss 103.109a
Cext_418 \$3.x2_x2_net18 sky130_gnd 1.12463f
Cext_419 \$3.x2_x2_net19 Vom 0.46419a
Cext_420 \$3.x2_x2_net19 Vop 2.4283a
Cext_421 \$3.x2_x2_net19 Vss 189.003a
Cext_422 \$3.x2_x2_net19 sky130_gnd 1.2512f
Cext_423 \$3.x2_x2_net2 \$3.x2_x2_net9 159.492a
Cext_424 \$3.x2_x2_net2 Vom 0.292982a
Cext_425 \$3.x2_x2_net2 Vop 1.34603a
Cext_426 \$3.x2_x2_net2 Vss 51.5188a
Cext_427 \$3.x2_x2_net2 sky130_gnd 1.2341f
Cext_428 \$3.x2_x2_net3 Vss 9.10591a
Cext_429 \$3.x2_x2_net3 sky130_gnd 1.12408f
Cext_430 \$3.x2_x2_net4 Vss 186.615a
Cext_431 \$3.x2_x2_net4 sky130_gnd 1.13482f
Cext_432 \$3.x2_x2_net5 \$3.x2_x2_net7 159.492a
Cext_433 \$3.x2_x2_net5 Vom 0.489768a
Cext_434 \$3.x2_x2_net5 Vop 2.33548a
Cext_435 \$3.x2_x2_net5 Vss 75.958a
Cext_436 \$3.x2_x2_net5 sky130_gnd 1.24476f
Cext_437 \$3.x2_x2_net6 Vss 16.2982a
Cext_438 \$3.x2_x2_net6 sky130_gnd 1.123f
Cext_439 \$3.x2_x2_net7 Vom 0.46419a
Cext_440 \$3.x2_x2_net7 Vop 2.4283a
Cext_441 \$3.x2_x2_net7 Vss 192.638a
Cext_442 \$3.x2_x2_net7 sky130_gnd 1.2512f
Cext_443 \$3.x2_x2_net8 Vss 102.91a
Cext_444 \$3.x2_x2_net8 sky130_gnd 1.12463f
Cext_445 \$3.x2_x2_net9 Vom 0.46419a
Cext_446 \$3.x2_x2_net9 Vop 2.4283a
Cext_447 \$3.x2_x2_net9 Vss 189.003a
Cext_448 \$3.x2_x2_net9 sky130_gnd 1.2512f
Cext_449 \$301 \$343 219.053a
Cext_450 \$301 \$345 331.807a
Cext_451 \$301 \$346 322.05a
Cext_452 \$301 \$402 160.492a
Cext_453 \$301 \$403 300.652a
Cext_454 \$301 \$418 337.868a
Cext_455 \$301 \$67 4.11009f
Cext_456 \$301 \$7 689.938a
Cext_457 \$301 Vdd 3.50087f
Cext_458 \$301 Vm 1.38479a
Cext_459 \$301 Vom 117.288a
Cext_460 \$301 Vop 246.074a
Cext_461 \$301 Vp 166.429a
Cext_462 \$301 VREF 1.94618f
Cext_463 \$301 Vss 7.90296f
Cext_464 \$301 sky130_gnd 23.0166f
Cext_465 \$343 \$345 596.69a
Cext_466 \$343 \$346 75.6287a
Cext_467 \$343 \$402 664.708a
Cext_468 \$343 \$403 6.10153a
Cext_469 \$343 \$67 1.765f
Cext_470 \$343 Vdd 228.536a
Cext_471 \$343 VREF 1.25251f
Cext_472 \$343 Vss 2.74722f
Cext_473 \$343 sky130_gnd 9.02642f
Cext_474 \$345 \$346 1.41926f
Cext_475 \$345 \$402 749.194a
Cext_476 \$345 \$403 5.0935f
Cext_477 \$345 \$418 113.723a
Cext_478 \$345 \$67 445.35a
Cext_479 \$345 Vdd 89.6716a
Cext_480 \$345 Vss 1.65614f
Cext_481 \$345 sky130_gnd 6.5628f
Cext_482 \$346 \$402 1.18049a
Cext_483 \$346 \$403 5.09539f
Cext_484 \$346 \$418 4.99904f
Cext_485 \$346 \$67 98.6728a
Cext_486 \$346 Vdd 86.2166a
Cext_487 \$346 Vss 1.40323f
Cext_488 \$346 sky130_gnd 3.44463f
Cext_489 \$402 \$403 1.22581a
Cext_490 \$402 \$416 1.0322f
Cext_491 \$402 \$418 0.81437a
Cext_492 \$402 \$67 887.67a
Cext_493 \$402 \$7 662.525a
Cext_494 \$402 Vdd 4.15857f
Cext_495 \$402 Vom 545.789a
Cext_496 \$402 Vop 121.405a
Cext_497 \$402 VREF 303.978a
Cext_498 \$402 Vss 4.88449f
Cext_499 \$402 sky130_gnd 8.96565f
Cext_500 \$403 \$418 242.981a
Cext_501 \$403 \$67 1.44566f
Cext_502 \$403 Vdd 84.4498a
Cext_503 \$403 Vss 1.03867f
Cext_504 \$403 sky130_gnd 4.16558f
Cext_505 \$416 \$67 2.9145f
Cext_506 \$416 Vdd 30.911f
Cext_507 \$416 Vss 652.706a
Cext_508 \$416 sky130_gnd 4.50349f
Cext_509 \$418 \$67 1.10956f
Cext_510 \$418 Vdd 87.6789a
Cext_511 \$418 Vss 6.11089f
Cext_512 \$418 sky130_gnd 3.37142f
Cext_513 \$45 \$55 867.004a
Cext_514 \$45 \$66 620.183a
Cext_515 \$45 \$67 73.2156a
Cext_516 \$45 \$7 2.19944f
Cext_517 \$45 Vdd 8.44637f
Cext_518 \$45 Vom 2.78882f
Cext_519 \$45 Vop 906.704a
Cext_520 \$45 Vss 1.9548f
Cext_521 \$45 sky130_gnd 6.98239f
Cext_522 \$55 \$66 5.70726f
Cext_523 \$55 \$67 1.23076f
Cext_524 \$55 \$7 3.73546f
Cext_525 \$55 RGM 1.27666a
Cext_526 \$55 Vdd 16.7863f
Cext_527 \$55 Vom 192.452a
Cext_528 \$55 Vop 177.977a
Cext_529 \$55 Vss 1.79215f
Cext_530 \$55 sky130_gnd 5.99112f
Cext_531 \$66 \$67 785.146a
Cext_532 \$66 \$7 6.01318f
Cext_533 \$66 RGM 5.05846a
Cext_534 \$66 Vdd 3.77143f
Cext_535 \$66 Vom 341.472a
Cext_536 \$66 Vop 157.839a
Cext_537 \$66 Vss 9.01991f
Cext_538 \$66 sky130_gnd 11.7331f
Cext_539 \$67 \$7 1.35228f
Cext_540 \$67 RGM 0.252639a
Cext_541 \$67 Vdd 23.9652f
Cext_542 \$67 Vm 0.102096a
Cext_543 \$67 Vom 1.04652p
Cext_544 \$67 Vop 340.635a
Cext_545 \$67 Vp 86.0929a
Cext_546 \$67 VREF 6.68676f
Cext_547 \$67 Vss 6.96603f
Cext_548 \$67 sky130_gnd 33.8884f
Cext_549 \$7 RGM 5.55262a
Cext_550 \$7 Vdd 19.3966f
Cext_551 \$7 Vom 687.39a
Cext_552 \$7 Vop 292.239a
Cext_553 \$7 Vss 1.86165f
Cext_554 \$7 sky130_gnd 7.39652f
Cext_555 RGM Vop 77.2029a
Cext_556 RGM Vss 238.888a
Cext_557 RGM sky130_gnd 1.6151f
Cext_558 Vdd Vom 7.87288f
Cext_559 Vdd Vop 6.70139f
Cext_560 Vdd Vss 4.65671f
Cext_561 Vm Vp 1.83465f
Cext_562 Vm Vss 2.5799f
Cext_563 Vom Vop 6.75548f
Cext_564 Vom Vss 3.76875f
Cext_565 Vop Vss 7.52504f
Cext_566 Vp Vss 1.13472f
Cext_567 VREF Vdd 13.1569f
Cext_568 VREF Vom 208.996a
Cext_569 VREF Vop 175.617a
Cext_570 VREF Vss 14.1746f
Cext_571 VREF sky130_gnd 38.6552f
Cext_572 sky130_gnd Vdd 57.24f
Cext_573 sky130_gnd Vm 3.9792f
Cext_574 sky130_gnd Vom 26.5932f
Cext_575 sky130_gnd Vop 27.574f
Cext_576 sky130_gnd Vp 5.08391f
Cext_577 sky130_gnd Vss 329.99f
.ENDS ttsky25a_fd_routed
