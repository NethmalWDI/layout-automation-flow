*********************************************************
*** NGSPICE file created by KLayout-PEX 0.6.8
*** -----------------------------------------------------
***     Extraction Engine: KPEX/2.5D
***     Technology: sky130a
***     Date: 2026-11-04 12:38:39
*********************************************************

.SUBCKT ttsky25a_fd_routed \$3.x2_x1_net1 \$3.x2_x1_net10 \$3.x2_x1_net11
+ \$3.x2_x1_net12 \$3.x2_x1_net13 \$3.x2_x1_net14 \$3.x2_x1_net15
+ \$3.x2_x1_net16 \$3.x2_x1_net17 \$3.x2_x1_net18 \$3.x2_x1_net19
+ \$3.x2_x1_net2 \$3.x2_x1_net3 \$3.x2_x1_net4 \$3.x2_x1_net5 \$3.x2_x1_net6
+ \$3.x2_x1_net7 \$3.x2_x1_net8 \$3.x2_x1_net9 \$3.x2_x2_net1 \$3.x2_x2_net10
+ \$3.x2_x2_net11 \$3.x2_x2_net12 \$3.x2_x2_net13 \$3.x2_x2_net14
+ \$3.x2_x2_net15 \$3.x2_x2_net16 \$3.x2_x2_net17 \$3.x2_x2_net18
+ \$3.x2_x2_net19 \$3.x2_x2_net2 \$3.x2_x2_net3 \$3.x2_x2_net4 \$3.x2_x2_net5
+ \$3.x2_x2_net6 \$3.x2_x2_net7 \$3.x2_x2_net8 \$3.x2_x2_net9 RGM VREF Vdd Vm
+ Vom Vop Vp Vss sky130_gnd
X$11 Vom \$3.x2_x2_net16 sky130_fd_pr__res_generic_po w=0.5 l=40
X$12 \$254 \$3.x2_x2_net4 sky130_fd_pr__res_generic_po w=0.5 l=40
X$13 \$254 \$3.x2_x1_net16 sky130_fd_pr__res_generic_po w=0.5 l=40
X$14 Vop \$3.x2_x1_net4 sky130_fd_pr__res_generic_po w=0.5 l=40
X$15 Vss Vss sky130_fd_pr__res_generic_po w=0.5 l=40
X$16 Vss Vss sky130_fd_pr__res_generic_po w=0.5 l=40
X$17 \$3.x2_x2_net5 \$3.x2_x2_net6 sky130_fd_pr__res_generic_po w=0.5 l=40
X$18 \$3.x2_x2_net5 \$3.x2_x2_net4 sky130_fd_pr__res_generic_po w=0.5 l=40
X$19 \$3.x2_x1_net5 \$3.x2_x1_net6 sky130_fd_pr__res_generic_po w=0.5 l=40
X$20 \$3.x2_x1_net5 \$3.x2_x1_net4 sky130_fd_pr__res_generic_po w=0.5 l=40
X$21 \$3.x2_x2_net7 \$3.x2_x2_net1 sky130_fd_pr__res_generic_po w=0.5 l=40
X$22 \$3.x2_x2_net7 \$3.x2_x2_net6 sky130_fd_pr__res_generic_po w=0.5 l=40
X$23 \$3.x2_x1_net7 \$3.x2_x1_net1 sky130_fd_pr__res_generic_po w=0.5 l=40
X$24 \$3.x2_x1_net7 \$3.x2_x1_net6 sky130_fd_pr__res_generic_po w=0.5 l=40
X$25 \$3.x2_x2_net11 \$3.x2_x2_net10 sky130_fd_pr__res_generic_po w=0.5 l=40
X$26 \$3.x2_x2_net11 \$3.x2_x2_net1 sky130_fd_pr__res_generic_po w=0.5 l=40
X$27 \$3.x2_x1_net11 \$3.x2_x1_net10 sky130_fd_pr__res_generic_po w=0.5 l=40
X$28 \$3.x2_x1_net11 \$3.x2_x1_net1 sky130_fd_pr__res_generic_po w=0.5 l=40
X$29 \$3.x2_x2_net9 \$3.x2_x2_net8 sky130_fd_pr__res_generic_po w=0.5 l=40
X$30 \$3.x2_x2_net9 \$3.x2_x2_net10 sky130_fd_pr__res_generic_po w=0.5 l=40
X$31 \$3.x2_x1_net9 \$3.x2_x1_net8 sky130_fd_pr__res_generic_po w=0.5 l=40
X$32 \$3.x2_x1_net9 \$3.x2_x1_net10 sky130_fd_pr__res_generic_po w=0.5 l=40
X$33 \$3.x2_x2_net2 \$3.x2_x2_net8 sky130_fd_pr__res_generic_po w=0.5 l=40
X$34 \$3.x2_x2_net2 \$3.x2_x2_net12 sky130_fd_pr__res_generic_po w=0.5 l=40
X$35 \$3.x2_x1_net2 \$3.x2_x1_net8 sky130_fd_pr__res_generic_po w=0.5 l=40
X$36 \$3.x2_x1_net2 \$3.x2_x1_net12 sky130_fd_pr__res_generic_po w=0.5 l=40
X$37 \$3.x2_x2_net13 \$3.x2_x2_net14 sky130_fd_pr__res_generic_po w=0.5 l=40
X$38 \$3.x2_x2_net13 \$3.x2_x2_net12 sky130_fd_pr__res_generic_po w=0.5 l=40
X$39 \$3.x2_x1_net13 \$3.x2_x1_net14 sky130_fd_pr__res_generic_po w=0.5 l=40
X$40 \$3.x2_x1_net13 \$3.x2_x1_net12 sky130_fd_pr__res_generic_po w=0.5 l=40
X$41 \$3.x2_x2_net15 \$3.x2_x2_net3 sky130_fd_pr__res_generic_po w=0.5 l=40
X$42 \$3.x2_x2_net15 \$3.x2_x2_net14 sky130_fd_pr__res_generic_po w=0.5 l=40
X$43 \$3.x2_x1_net15 \$3.x2_x1_net3 sky130_fd_pr__res_generic_po w=0.5 l=40
X$44 \$3.x2_x1_net15 \$3.x2_x1_net14 sky130_fd_pr__res_generic_po w=0.5 l=40
X$45 \$3.x2_x2_net19 \$3.x2_x2_net18 sky130_fd_pr__res_generic_po w=0.5 l=40
X$46 \$3.x2_x2_net19 \$3.x2_x2_net3 sky130_fd_pr__res_generic_po w=0.5 l=40
X$47 \$3.x2_x1_net19 \$3.x2_x1_net18 sky130_fd_pr__res_generic_po w=0.5 l=40
X$48 \$3.x2_x1_net19 \$3.x2_x1_net3 sky130_fd_pr__res_generic_po w=0.5 l=40
X$49 \$3.x2_x2_net17 \$3.x2_x2_net16 sky130_fd_pr__res_generic_po w=0.5 l=40
X$50 \$3.x2_x2_net17 \$3.x2_x2_net18 sky130_fd_pr__res_generic_po w=0.5 l=40
X$51 \$3.x2_x1_net17 \$3.x2_x1_net16 sky130_fd_pr__res_generic_po w=0.5 l=40
X$52 \$3.x2_x1_net17 \$3.x2_x1_net18 sky130_fd_pr__res_generic_po w=0.5 l=40
X$53 Vss Vss Vss sky130_gnd sky130_fd_pr__nfet_01v8_lvt l=20 w=1 as=0.29
+ ad=0.29 ps=2.58 pd=2.58
X$54 Vss Vss Vss sky130_gnd sky130_fd_pr__nfet_01v8_lvt l=20 w=1 as=0.29
+ ad=0.29 ps=2.58 pd=2.58
X$55 Vss \$121 \$359 sky130_gnd sky130_fd_pr__nfet_01v8_lvt l=20 w=1 as=0.29
+ ad=0.29 ps=2.58 pd=2.58
X$56 Vss \$121 \$283 sky130_gnd sky130_fd_pr__nfet_01v8_lvt l=20 w=1 as=0.29
+ ad=0.29 ps=2.58 pd=2.58
X$57 Vss \$121 \$359 sky130_gnd sky130_fd_pr__nfet_01v8_lvt l=20 w=1 as=0.29
+ ad=0.29 ps=2.58 pd=2.58
X$58 Vss \$121 \$283 sky130_gnd sky130_fd_pr__nfet_01v8_lvt l=20 w=1 as=0.29
+ ad=0.29 ps=2.58 pd=2.58
X$59 Vss \$122 \$122 sky130_gnd sky130_fd_pr__nfet_01v8_lvt l=5 w=0.6 as=0.174
+ ad=0.174 ps=1.78 pd=1.78
X$60 Vss \$122 \$122 sky130_gnd sky130_fd_pr__nfet_01v8_lvt l=5 w=0.6 as=0.174
+ ad=0.174 ps=1.78 pd=1.78
X$61 Vss \$121 \$434 sky130_gnd sky130_fd_pr__nfet_01v8_lvt l=10 w=1 as=0.29
+ ad=0.29 ps=2.58 pd=2.58
X$62 Vss \$121 \$434 sky130_gnd sky130_fd_pr__nfet_01v8_lvt l=10 w=1 as=0.29
+ ad=0.29 ps=2.58 pd=2.58
X$63 Vss \$121 \$342 sky130_gnd sky130_fd_pr__nfet_01v8_lvt l=10 w=1 as=0.29
+ ad=0.29 ps=2.58 pd=2.58
X$64 Vss \$121 \$406 sky130_gnd sky130_fd_pr__nfet_01v8_lvt l=10 w=1 as=0.29
+ ad=0.29 ps=2.58 pd=2.58
X$65 Vss \$121 \$341 sky130_gnd sky130_fd_pr__nfet_01v8_lvt l=10 w=1 as=0.29
+ ad=0.29 ps=2.58 pd=2.58
X$66 Vss \$121 \$341 sky130_gnd sky130_fd_pr__nfet_01v8_lvt l=10 w=1 as=0.29
+ ad=0.29 ps=2.58 pd=2.58
X$67 Vss \$121 \$406 sky130_gnd sky130_fd_pr__nfet_01v8_lvt l=10 w=1 as=0.29
+ ad=0.29 ps=2.58 pd=2.58
X$68 Vss \$121 \$342 sky130_gnd sky130_fd_pr__nfet_01v8_lvt l=10 w=1 as=0.29
+ ad=0.29 ps=2.58 pd=2.58
X$69 Vss Vss Vss sky130_gnd sky130_fd_pr__nfet_01v8_lvt l=10 w=1 as=0.29
+ ad=0.29 ps=2.58 pd=2.58
X$70 Vss Vss Vss sky130_gnd sky130_fd_pr__nfet_01v8_lvt l=10 w=1 as=0.29
+ ad=0.29 ps=2.58 pd=2.58
X$71 Vdd \$432 \$432 Vdd sky130_fd_pr__pfet_01v8_lvt l=10 w=1.5 as=0.435
+ ad=0.435 ps=3.58 pd=3.58
X$72 Vdd \$432 \$432 Vdd sky130_fd_pr__pfet_01v8_lvt l=10 w=1.5 as=0.435
+ ad=0.435 ps=3.58 pd=3.58
X$73 Vdd Vdd Vdd Vdd sky130_fd_pr__pfet_01v8_lvt l=5 w=1 as=0.29 ad=0.145
+ ps=2.58 pd=1.29
X$74 Vdd Vdd Vdd Vdd sky130_fd_pr__pfet_01v8_lvt l=5 w=1 as=0.145 ad=0.29
+ ps=1.29 pd=2.58
X$75 Vdd Vdd Vdd Vdd sky130_fd_pr__pfet_01v8_lvt l=5 w=1 as=0.29 ad=0.145
+ ps=2.58 pd=1.29
X$76 Vdd Vdd Vdd Vdd sky130_fd_pr__pfet_01v8_lvt l=5 w=1 as=0.145 ad=0.29
+ ps=1.29 pd=2.58
X$77 \$281 \$284 Vdd Vdd sky130_fd_pr__pfet_01v8_lvt l=5 w=1 as=0.29 ad=0.145
+ ps=2.58 pd=1.29
X$78 Vdd \$284 \$281 Vdd sky130_fd_pr__pfet_01v8_lvt l=5 w=1 as=0.145 ad=0.29
+ ps=1.29 pd=2.58
X$79 \$280 \$284 Vdd Vdd sky130_fd_pr__pfet_01v8_lvt l=5 w=1 as=0.29 ad=0.145
+ ps=2.58 pd=1.29
X$80 Vdd \$284 \$280 Vdd sky130_fd_pr__pfet_01v8_lvt l=5 w=1 as=0.145 ad=0.29
+ ps=1.29 pd=2.58
X$81 \$281 \$284 Vdd Vdd sky130_fd_pr__pfet_01v8_lvt l=5 w=1 as=0.29 ad=0.145
+ ps=2.58 pd=1.29
X$82 Vdd \$284 \$281 Vdd sky130_fd_pr__pfet_01v8_lvt l=5 w=1 as=0.145 ad=0.29
+ ps=1.29 pd=2.58
X$83 \$280 \$284 Vdd Vdd sky130_fd_pr__pfet_01v8_lvt l=5 w=1 as=0.29 ad=0.145
+ ps=2.58 pd=1.29
X$84 Vdd \$284 \$280 Vdd sky130_fd_pr__pfet_01v8_lvt l=5 w=1 as=0.145 ad=0.29
+ ps=1.29 pd=2.58
X$85 \$281 \$284 Vdd Vdd sky130_fd_pr__pfet_01v8_lvt l=5 w=1 as=0.29 ad=0.145
+ ps=2.58 pd=1.29
X$86 Vdd \$284 \$281 Vdd sky130_fd_pr__pfet_01v8_lvt l=5 w=1 as=0.145 ad=0.29
+ ps=1.29 pd=2.58
X$87 \$280 \$284 Vdd Vdd sky130_fd_pr__pfet_01v8_lvt l=5 w=1 as=0.29 ad=0.145
+ ps=2.58 pd=1.29
X$88 Vdd \$284 \$280 Vdd sky130_fd_pr__pfet_01v8_lvt l=5 w=1 as=0.145 ad=0.29
+ ps=1.29 pd=2.58
X$89 \$281 \$284 Vdd Vdd sky130_fd_pr__pfet_01v8_lvt l=5 w=1 as=0.29 ad=0.145
+ ps=2.58 pd=1.29
X$90 Vdd \$284 \$281 Vdd sky130_fd_pr__pfet_01v8_lvt l=5 w=1 as=0.145 ad=0.29
+ ps=1.29 pd=2.58
X$91 \$280 \$284 Vdd Vdd sky130_fd_pr__pfet_01v8_lvt l=5 w=1 as=0.29 ad=0.145
+ ps=2.58 pd=1.29
X$92 Vdd \$284 \$280 Vdd sky130_fd_pr__pfet_01v8_lvt l=5 w=1 as=0.145 ad=0.29
+ ps=1.29 pd=2.58
X$93 Vdd Vdd Vdd Vdd sky130_fd_pr__pfet_01v8_lvt l=5 w=1 as=0.29 ad=0.145
+ ps=2.58 pd=1.29
X$94 Vdd Vdd Vdd Vdd sky130_fd_pr__pfet_01v8_lvt l=5 w=1 as=0.145 ad=0.29
+ ps=1.29 pd=2.58
X$95 Vdd Vdd Vdd Vdd sky130_fd_pr__pfet_01v8_lvt l=5 w=1 as=0.29 ad=0.145
+ ps=2.58 pd=1.29
X$96 Vdd Vdd Vdd Vdd sky130_fd_pr__pfet_01v8_lvt l=5 w=1 as=0.145 ad=0.29
+ ps=1.29 pd=2.58
X$97 \$3 \$432 \$281 Vdd sky130_fd_pr__pfet_01v8_lvt l=5 w=1 as=0.29 ad=0.145
+ ps=2.58 pd=1.29
X$98 \$281 \$432 \$3 Vdd sky130_fd_pr__pfet_01v8_lvt l=5 w=1 as=0.145 ad=0.29
+ ps=1.29 pd=2.58
X$99 \$200 \$432 \$280 Vdd sky130_fd_pr__pfet_01v8_lvt l=5 w=1 as=0.29 ad=0.145
+ ps=2.58 pd=1.29
X$100 \$280 \$432 \$200 Vdd sky130_fd_pr__pfet_01v8_lvt l=5 w=1 as=0.145
+ ad=0.29 ps=1.29 pd=2.58
X$101 \$3 \$432 \$281 Vdd sky130_fd_pr__pfet_01v8_lvt l=5 w=1 as=0.29 ad=0.145
+ ps=2.58 pd=1.29
X$102 \$281 \$432 \$3 Vdd sky130_fd_pr__pfet_01v8_lvt l=5 w=1 as=0.145 ad=0.29
+ ps=1.29 pd=2.58
X$103 \$200 \$432 \$280 Vdd sky130_fd_pr__pfet_01v8_lvt l=5 w=1 as=0.29
+ ad=0.145 ps=2.58 pd=1.29
X$104 \$280 \$432 \$200 Vdd sky130_fd_pr__pfet_01v8_lvt l=5 w=1 as=0.145
+ ad=0.29 ps=1.29 pd=2.58
X$105 Vss \$121 \$121 sky130_gnd sky130_fd_pr__nfet_01v8_lvt l=2 w=1 as=0.29
+ ad=0.29 ps=2.58 pd=2.58
X$106 Vss \$121 \$121 sky130_gnd sky130_fd_pr__nfet_01v8_lvt l=2 w=1 as=0.29
+ ad=0.29 ps=2.58 pd=2.58
X$107 Vss Vss Vss sky130_gnd sky130_fd_pr__nfet_01v8_lvt l=4 w=4 as=1.16
+ ad=1.16 ps=8.58 pd=8.58
X$108 Vss Vss Vss sky130_gnd sky130_fd_pr__nfet_01v8_lvt l=4 w=4 as=1.16
+ ad=1.16 ps=8.58 pd=8.58
X$109 \$282 Vp \$281 sky130_gnd sky130_fd_pr__nfet_01v8_lvt l=4 w=4 as=1.16
+ ad=1.16 ps=8.58 pd=8.58
X$110 \$282 Vm \$280 sky130_gnd sky130_fd_pr__nfet_01v8_lvt l=4 w=4 as=1.16
+ ad=1.16 ps=8.58 pd=8.58
X$111 \$282 Vp \$281 sky130_gnd sky130_fd_pr__nfet_01v8_lvt l=4 w=4 as=1.16
+ ad=1.16 ps=8.58 pd=8.58
X$112 \$282 Vm \$280 sky130_gnd sky130_fd_pr__nfet_01v8_lvt l=4 w=4 as=1.16
+ ad=1.16 ps=8.58 pd=8.58
X$113 Vss Vss Vss sky130_gnd sky130_fd_pr__nfet_01v8_lvt l=20 w=5 as=1.45
+ ad=1.45 ps=10.58 pd=10.58
X$114 Vss Vss Vss sky130_gnd sky130_fd_pr__nfet_01v8_lvt l=20 w=5 as=1.45
+ ad=1.45 ps=10.58 pd=10.58
X$115 \$359 VREF \$284 sky130_gnd sky130_fd_pr__nfet_01v8_lvt l=20 w=5 as=1.45
+ ad=1.45 ps=10.58 pd=10.58
X$116 \$359 \$200 \$285 sky130_gnd sky130_fd_pr__nfet_01v8_lvt l=20 w=5 as=1.45
+ ad=1.45 ps=10.58 pd=10.58
X$117 \$359 VREF \$284 sky130_gnd sky130_fd_pr__nfet_01v8_lvt l=20 w=5 as=1.45
+ ad=1.45 ps=10.58 pd=10.58
X$118 \$359 \$200 \$285 sky130_gnd sky130_fd_pr__nfet_01v8_lvt l=20 w=5 as=1.45
+ ad=1.45 ps=10.58 pd=10.58
X$119 Vss Vss Vss sky130_gnd sky130_fd_pr__nfet_01v8_lvt l=20 w=5 as=1.45
+ ad=1.45 ps=10.58 pd=10.58
X$120 Vss Vss Vss sky130_gnd sky130_fd_pr__nfet_01v8_lvt l=20 w=5 as=1.45
+ ad=1.45 ps=10.58 pd=10.58
X$121 \$283 VREF \$284 sky130_gnd sky130_fd_pr__nfet_01v8_lvt l=20 w=5 as=1.45
+ ad=1.45 ps=10.58 pd=10.58
X$122 \$283 \$3 \$285 sky130_gnd sky130_fd_pr__nfet_01v8_lvt l=20 w=5 as=1.45
+ ad=1.45 ps=10.58 pd=10.58
X$123 \$283 VREF \$284 sky130_gnd sky130_fd_pr__nfet_01v8_lvt l=20 w=5 as=1.45
+ ad=1.45 ps=10.58 pd=10.58
X$124 \$283 \$3 \$285 sky130_gnd sky130_fd_pr__nfet_01v8_lvt l=20 w=5 as=1.45
+ ad=1.45 ps=10.58 pd=10.58
X$125 Vdd Vdd Vdd Vdd sky130_fd_pr__pfet_01v8_lvt l=10 w=1 as=0.29 ad=0.29
+ ps=2.58 pd=2.58
X$126 Vdd Vdd Vdd Vdd sky130_fd_pr__pfet_01v8_lvt l=10 w=1 as=0.29 ad=0.29
+ ps=2.58 pd=2.58
X$127 Vdd \$285 \$285 Vdd sky130_fd_pr__pfet_01v8_lvt l=10 w=1 as=0.29 ad=0.29
+ ps=2.58 pd=2.58
X$128 Vdd \$285 \$284 Vdd sky130_fd_pr__pfet_01v8_lvt l=10 w=1 as=0.29 ad=0.29
+ ps=2.58 pd=2.58
X$129 Vdd \$285 \$285 Vdd sky130_fd_pr__pfet_01v8_lvt l=10 w=1 as=0.29 ad=0.29
+ ps=2.58 pd=2.58
X$130 Vdd \$285 \$284 Vdd sky130_fd_pr__pfet_01v8_lvt l=10 w=1 as=0.29 ad=0.29
+ ps=2.58 pd=2.58
X$131 Vdd Vdd Vdd Vdd sky130_fd_pr__pfet_01v8_lvt l=10 w=1 as=0.29 ad=0.29
+ ps=2.58 pd=2.58
X$132 \$201 \$254 \$166 Vdd sky130_fd_pr__pfet_01v8_lvt l=10 w=1 as=0.29
+ ad=0.29 ps=2.58 pd=2.58
X$133 \$201 VREF \$144 Vdd sky130_fd_pr__pfet_01v8_lvt l=10 w=1 as=0.29 ad=0.29
+ ps=2.58 pd=2.58
X$134 \$201 VREF \$144 Vdd sky130_fd_pr__pfet_01v8_lvt l=10 w=1 as=0.29 ad=0.29
+ ps=2.58 pd=2.58
X$135 \$201 \$254 \$166 Vdd sky130_fd_pr__pfet_01v8_lvt l=10 w=1 as=0.29
+ ad=0.29 ps=2.58 pd=2.58
X$136 Vdd Vdd Vdd Vdd sky130_fd_pr__pfet_01v8_lvt l=10 w=1 as=0.29 ad=0.29
+ ps=2.58 pd=2.58
X$137 Vdd \$202 \$201 Vdd sky130_fd_pr__pfet_01v8_lvt l=5 w=1 as=0.29 ad=0.29
+ ps=2.58 pd=2.58
X$138 Vdd Vdd Vdd Vdd sky130_fd_pr__pfet_01v8_lvt l=5 w=1 as=0.29 ad=0.29
+ ps=2.58 pd=2.58
X$139 Vdd \$202 \$201 Vdd sky130_fd_pr__pfet_01v8_lvt l=5 w=1 as=0.29 ad=0.29
+ ps=2.58 pd=2.58
X$140 Vdd Vdd Vdd Vdd sky130_fd_pr__pfet_01v8_lvt l=1 w=6 as=1.74 ad=1.74
+ ps=12.58 pd=12.58
X$141 Vdd \$202 \$202 Vdd sky130_fd_pr__pfet_01v8_lvt l=1 w=6 as=1.74 ad=1.74
+ ps=12.58 pd=12.58
X$142 Vdd \$202 \$202 Vdd sky130_fd_pr__pfet_01v8_lvt l=1 w=6 as=1.74 ad=1.74
+ ps=12.58 pd=12.58
X$143 Vom \$200 Vdd Vdd sky130_fd_pr__pfet_01v8_lvt l=1 w=1 as=0.29 ad=0.145
+ ps=2.58 pd=1.29
X$144 Vdd \$200 Vom Vdd sky130_fd_pr__pfet_01v8_lvt l=1 w=1 as=0.145 ad=0.29
+ ps=1.29 pd=2.58
X$145 Vom \$200 Vdd Vdd sky130_fd_pr__pfet_01v8_lvt l=1 w=1 as=0.29 ad=0.145
+ ps=2.58 pd=1.29
X$146 Vdd \$200 Vom Vdd sky130_fd_pr__pfet_01v8_lvt l=1 w=1 as=0.145 ad=0.29
+ ps=1.29 pd=2.58
X$147 Vom \$200 Vdd Vdd sky130_fd_pr__pfet_01v8_lvt l=1 w=1 as=0.29 ad=0.145
+ ps=2.58 pd=1.29
X$148 Vdd \$200 Vom Vdd sky130_fd_pr__pfet_01v8_lvt l=1 w=1 as=0.145 ad=0.29
+ ps=1.29 pd=2.58
X$149 Vom \$200 Vdd Vdd sky130_fd_pr__pfet_01v8_lvt l=1 w=1 as=0.29 ad=0.145
+ ps=2.58 pd=1.29
X$150 Vdd \$200 Vom Vdd sky130_fd_pr__pfet_01v8_lvt l=1 w=1 as=0.145 ad=0.29
+ ps=1.29 pd=2.58
X$151 Vom \$200 Vdd Vdd sky130_fd_pr__pfet_01v8_lvt l=1 w=1 as=0.29 ad=0.145
+ ps=2.58 pd=1.29
X$152 Vdd \$200 Vom Vdd sky130_fd_pr__pfet_01v8_lvt l=1 w=1 as=0.145 ad=0.29
+ ps=1.29 pd=2.58
X$153 Vom \$200 Vdd Vdd sky130_fd_pr__pfet_01v8_lvt l=1 w=1 as=0.29 ad=0.145
+ ps=2.58 pd=1.29
X$154 Vdd \$200 Vom Vdd sky130_fd_pr__pfet_01v8_lvt l=1 w=1 as=0.145 ad=0.29
+ ps=1.29 pd=2.58
X$155 Vom \$200 Vdd Vdd sky130_fd_pr__pfet_01v8_lvt l=1 w=1 as=0.29 ad=0.145
+ ps=2.58 pd=1.29
X$156 Vdd \$200 Vom Vdd sky130_fd_pr__pfet_01v8_lvt l=1 w=1 as=0.145 ad=0.29
+ ps=1.29 pd=2.58
X$157 Vom \$200 Vdd Vdd sky130_fd_pr__pfet_01v8_lvt l=1 w=1 as=0.29 ad=0.145
+ ps=2.58 pd=1.29
X$158 Vdd \$200 Vom Vdd sky130_fd_pr__pfet_01v8_lvt l=1 w=1 as=0.145 ad=0.29
+ ps=1.29 pd=2.58
X$159 Vom \$200 Vdd Vdd sky130_fd_pr__pfet_01v8_lvt l=1 w=1 as=0.29 ad=0.145
+ ps=2.58 pd=1.29
X$160 Vdd \$200 Vom Vdd sky130_fd_pr__pfet_01v8_lvt l=1 w=1 as=0.145 ad=0.29
+ ps=1.29 pd=2.58
X$161 Vop \$3 Vdd Vdd sky130_fd_pr__pfet_01v8_lvt l=1 w=1 as=0.29 ad=0.145
+ ps=2.58 pd=1.29
X$162 Vdd \$3 Vop Vdd sky130_fd_pr__pfet_01v8_lvt l=1 w=1 as=0.145 ad=0.29
+ ps=1.29 pd=2.58
X$163 Vop \$3 Vdd Vdd sky130_fd_pr__pfet_01v8_lvt l=1 w=1 as=0.29 ad=0.145
+ ps=2.58 pd=1.29
X$164 Vdd \$3 Vop Vdd sky130_fd_pr__pfet_01v8_lvt l=1 w=1 as=0.145 ad=0.29
+ ps=1.29 pd=2.58
X$165 Vop \$3 Vdd Vdd sky130_fd_pr__pfet_01v8_lvt l=1 w=1 as=0.29 ad=0.145
+ ps=2.58 pd=1.29
X$166 Vdd \$3 Vop Vdd sky130_fd_pr__pfet_01v8_lvt l=1 w=1 as=0.145 ad=0.29
+ ps=1.29 pd=2.58
X$167 Vop \$3 Vdd Vdd sky130_fd_pr__pfet_01v8_lvt l=1 w=1 as=0.29 ad=0.145
+ ps=2.58 pd=1.29
X$168 Vdd \$3 Vop Vdd sky130_fd_pr__pfet_01v8_lvt l=1 w=1 as=0.145 ad=0.29
+ ps=1.29 pd=2.58
X$169 Vop \$3 Vdd Vdd sky130_fd_pr__pfet_01v8_lvt l=1 w=1 as=0.29 ad=0.145
+ ps=2.58 pd=1.29
X$170 Vdd \$3 Vop Vdd sky130_fd_pr__pfet_01v8_lvt l=1 w=1 as=0.145 ad=0.29
+ ps=1.29 pd=2.58
X$171 Vop \$3 Vdd Vdd sky130_fd_pr__pfet_01v8_lvt l=1 w=1 as=0.29 ad=0.145
+ ps=2.58 pd=1.29
X$172 Vdd \$3 Vop Vdd sky130_fd_pr__pfet_01v8_lvt l=1 w=1 as=0.145 ad=0.29
+ ps=1.29 pd=2.58
X$173 Vop \$3 Vdd Vdd sky130_fd_pr__pfet_01v8_lvt l=1 w=1 as=0.29 ad=0.145
+ ps=2.58 pd=1.29
X$174 Vdd \$3 Vop Vdd sky130_fd_pr__pfet_01v8_lvt l=1 w=1 as=0.145 ad=0.29
+ ps=1.29 pd=2.58
X$175 Vop \$3 Vdd Vdd sky130_fd_pr__pfet_01v8_lvt l=1 w=1 as=0.29 ad=0.145
+ ps=2.58 pd=1.29
X$176 Vdd \$3 Vop Vdd sky130_fd_pr__pfet_01v8_lvt l=1 w=1 as=0.145 ad=0.29
+ ps=1.29 pd=2.58
X$177 Vop \$3 Vdd Vdd sky130_fd_pr__pfet_01v8_lvt l=1 w=1 as=0.29 ad=0.145
+ ps=2.58 pd=1.29
X$178 Vdd \$3 Vop Vdd sky130_fd_pr__pfet_01v8_lvt l=1 w=1 as=0.145 ad=0.29
+ ps=1.29 pd=2.58
X$179 Vss Vss Vss sky130_gnd sky130_fd_pr__nfet_01v8_lvt l=20 w=0.5 as=0.145
+ ad=0.145 ps=1.58 pd=1.58
X$180 Vss Vss Vss sky130_gnd sky130_fd_pr__nfet_01v8_lvt l=20 w=0.5 as=0.145
+ ad=0.145 ps=1.58 pd=1.58
X$181 Vss \$166 \$144 sky130_gnd sky130_fd_pr__nfet_01v8_lvt l=20 w=0.5
+ as=0.145 ad=0.145 ps=1.58 pd=1.58
X$182 Vss \$166 \$166 sky130_gnd sky130_fd_pr__nfet_01v8_lvt l=20 w=0.5
+ as=0.145 ad=0.145 ps=1.58 pd=1.58
X$183 Vss \$166 \$144 sky130_gnd sky130_fd_pr__nfet_01v8_lvt l=20 w=0.5
+ as=0.145 ad=0.145 ps=1.58 pd=1.58
X$184 Vss \$166 \$166 sky130_gnd sky130_fd_pr__nfet_01v8_lvt l=20 w=0.5
+ as=0.145 ad=0.145 ps=1.58 pd=1.58
X$185 \$434 \$122 \$282 sky130_gnd sky130_fd_pr__nfet_01v8_lvt l=1 w=1 as=0.29
+ ad=0.29 ps=2.58 pd=2.58
X$186 \$434 \$122 \$282 sky130_gnd sky130_fd_pr__nfet_01v8_lvt l=1 w=1 as=0.29
+ ad=0.29 ps=2.58 pd=2.58
X$187 \$406 \$122 \$200 sky130_gnd sky130_fd_pr__nfet_01v8_lvt l=1 w=1 as=0.29
+ ad=0.29 ps=2.58 pd=2.58
X$188 \$406 \$122 \$200 sky130_gnd sky130_fd_pr__nfet_01v8_lvt l=1 w=1 as=0.29
+ ad=0.29 ps=2.58 pd=2.58
X$189 Vss Vss Vss sky130_gnd sky130_fd_pr__nfet_01v8_lvt l=1 w=1 as=0.29
+ ad=0.29 ps=2.58 pd=2.58
X$190 Vss Vss Vss sky130_gnd sky130_fd_pr__nfet_01v8_lvt l=1 w=1 as=0.29
+ ad=0.29 ps=2.58 pd=2.58
X$191 \$341 \$122 \$3 sky130_gnd sky130_fd_pr__nfet_01v8_lvt l=1 w=1 as=0.29
+ ad=0.29 ps=2.58 pd=2.58
X$192 \$341 \$122 \$3 sky130_gnd sky130_fd_pr__nfet_01v8_lvt l=1 w=1 as=0.29
+ ad=0.29 ps=2.58 pd=2.58
X$193 \$342 \$122 \$282 sky130_gnd sky130_fd_pr__nfet_01v8_lvt l=1 w=1 as=0.29
+ ad=0.29 ps=2.58 pd=2.58
X$194 \$342 \$122 \$282 sky130_gnd sky130_fd_pr__nfet_01v8_lvt l=1 w=1 as=0.29
+ ad=0.29 ps=2.58 pd=2.58
X$195 Vss Vss Vss sky130_gnd sky130_fd_pr__nfet_01v8_lvt l=1 w=1 as=0.29
+ ad=0.29 ps=2.58 pd=2.58
X$196 Vss Vss Vss sky130_gnd sky130_fd_pr__nfet_01v8_lvt l=1 w=1 as=0.29
+ ad=0.29 ps=2.58 pd=2.58
X$197 Vss Vss Vss sky130_gnd sky130_fd_pr__nfet_01v8_lvt l=1 w=1 as=0.29
+ ad=0.29 ps=2.58 pd=2.58
X$198 Vss \$144 Vom sky130_gnd sky130_fd_pr__nfet_01v8_lvt l=1 w=1 as=0.29
+ ad=0.29 ps=2.58 pd=2.58
X$199 Vss \$144 Vop sky130_gnd sky130_fd_pr__nfet_01v8_lvt l=1 w=1 as=0.29
+ ad=0.29 ps=2.58 pd=2.58
X$200 Vss \$144 Vom sky130_gnd sky130_fd_pr__nfet_01v8_lvt l=1 w=1 as=0.29
+ ad=0.29 ps=2.58 pd=2.58
X$201 Vss \$144 Vop sky130_gnd sky130_fd_pr__nfet_01v8_lvt l=1 w=1 as=0.29
+ ad=0.29 ps=2.58 pd=2.58
X$202 Vss \$144 Vom sky130_gnd sky130_fd_pr__nfet_01v8_lvt l=1 w=1 as=0.29
+ ad=0.29 ps=2.58 pd=2.58
X$203 Vss \$144 Vop sky130_gnd sky130_fd_pr__nfet_01v8_lvt l=1 w=1 as=0.29
+ ad=0.29 ps=2.58 pd=2.58
X$204 Vss \$144 Vom sky130_gnd sky130_fd_pr__nfet_01v8_lvt l=1 w=1 as=0.29
+ ad=0.29 ps=2.58 pd=2.58
X$205 Vss \$144 Vop sky130_gnd sky130_fd_pr__nfet_01v8_lvt l=1 w=1 as=0.29
+ ad=0.29 ps=2.58 pd=2.58
X$206 Vss \$144 Vom sky130_gnd sky130_fd_pr__nfet_01v8_lvt l=1 w=1 as=0.29
+ ad=0.29 ps=2.58 pd=2.58
X$207 Vss Vss Vss sky130_gnd sky130_fd_pr__nfet_01v8_lvt l=1 w=1 as=0.29
+ ad=0.29 ps=2.58 pd=2.58
X$208 Vss \$144 Vop sky130_gnd sky130_fd_pr__nfet_01v8_lvt l=1 w=1 as=0.29
+ ad=0.29 ps=2.58 pd=2.58
X$209 Vss \$144 Vom sky130_gnd sky130_fd_pr__nfet_01v8_lvt l=1 w=1 as=0.29
+ ad=0.29 ps=2.58 pd=2.58
X$210 Vss \$144 Vop sky130_gnd sky130_fd_pr__nfet_01v8_lvt l=1 w=1 as=0.29
+ ad=0.29 ps=2.58 pd=2.58
X$211 Vss \$144 Vom sky130_gnd sky130_fd_pr__nfet_01v8_lvt l=1 w=1 as=0.29
+ ad=0.29 ps=2.58 pd=2.58
X$212 Vss \$144 Vop sky130_gnd sky130_fd_pr__nfet_01v8_lvt l=1 w=1 as=0.29
+ ad=0.29 ps=2.58 pd=2.58
X$213 Vss \$144 Vom sky130_gnd sky130_fd_pr__nfet_01v8_lvt l=1 w=1 as=0.29
+ ad=0.29 ps=2.58 pd=2.58
X$214 Vss \$144 Vop sky130_gnd sky130_fd_pr__nfet_01v8_lvt l=1 w=1 as=0.29
+ ad=0.29 ps=2.58 pd=2.58
X$215 Vss \$144 Vom sky130_gnd sky130_fd_pr__nfet_01v8_lvt l=1 w=1 as=0.29
+ ad=0.29 ps=2.58 pd=2.58
X$216 Vss \$144 Vop sky130_gnd sky130_fd_pr__nfet_01v8_lvt l=1 w=1 as=0.29
+ ad=0.29 ps=2.58 pd=2.58
X$217 Vss Vss Vss sky130_gnd sky130_fd_pr__nfet_01v8_lvt l=1 w=0.6 as=0.174
+ ad=0.174 ps=1.78 pd=1.78
X$218 Vss Vss Vss sky130_gnd sky130_fd_pr__nfet_01v8_lvt l=1 w=0.6 as=0.174
+ ad=0.174 ps=1.78 pd=1.78
X$219 Vss \$405 \$432 sky130_gnd sky130_fd_pr__nfet_01v8_lvt l=1 w=0.6 as=0.174
+ ad=0.174 ps=1.78 pd=1.78
X$220 Vss \$405 \$405 sky130_gnd sky130_fd_pr__nfet_01v8_lvt l=1 w=0.6 as=0.174
+ ad=0.174 ps=1.78 pd=1.78
X$221 Vss \$405 \$405 sky130_gnd sky130_fd_pr__nfet_01v8_lvt l=1 w=0.6 as=0.174
+ ad=0.174 ps=1.78 pd=1.78
X$222 Vss \$405 \$432 sky130_gnd sky130_fd_pr__nfet_01v8_lvt l=1 w=0.6 as=0.174
+ ad=0.174 ps=1.78 pd=1.78
X$223 Vss Vss Vss sky130_gnd sky130_fd_pr__nfet_01v8_lvt l=1 w=0.6 as=0.174
+ ad=0.174 ps=1.78 pd=1.78
X$224 Vss Vss Vss sky130_gnd sky130_fd_pr__nfet_01v8_lvt l=1 w=0.6 as=0.174
+ ad=0.174 ps=1.78 pd=1.78
X$225 Vss \$120 \$202 sky130_gnd sky130_fd_pr__nfet_01v8_lvt l=1 w=0.6 as=0.174
+ ad=0.174 ps=1.78 pd=1.78
X$226 Vss \$120 \$120 sky130_gnd sky130_fd_pr__nfet_01v8_lvt l=1 w=0.6 as=0.174
+ ad=0.174 ps=1.78 pd=1.78
X$227 Vss \$120 \$202 sky130_gnd sky130_fd_pr__nfet_01v8_lvt l=1 w=0.6 as=0.174
+ ad=0.174 ps=1.78 pd=1.78
X$228 Vss \$120 \$120 sky130_gnd sky130_fd_pr__nfet_01v8_lvt l=1 w=0.6 as=0.174
+ ad=0.174 ps=1.78 pd=1.78
X$229 RGM \$27 \$27 sky130_gnd sky130_fd_pr__nfet_01v8_lvt l=1 w=10 as=2.9
+ ad=2.9 ps=20.58 pd=20.58
X$230 RGM \$27 \$27 sky130_gnd sky130_fd_pr__nfet_01v8_lvt l=1 w=10 as=2.9
+ ad=2.9 ps=20.58 pd=20.58
X$231 \$59 \$57 \$7 sky130_gnd sky130_fd_pr__nfet_01v8_lvt l=1 w=2 as=0.58
+ ad=0.58 ps=4.58 pd=4.58
X$232 Vdd Vdd Vdd Vdd sky130_fd_pr__pfet_01v8_lvt l=1 w=5 as=1.45 ad=1.45
+ ps=10.58 pd=10.58
X$233 Vdd Vdd Vdd Vdd sky130_fd_pr__pfet_01v8_lvt l=1 w=5 as=1.45 ad=1.45
+ ps=10.58 pd=10.58
X$234 Vdd \$7 \$405 Vdd sky130_fd_pr__pfet_01v8_lvt l=1 w=5 as=1.45 ad=1.45
+ ps=10.58 pd=10.58
X$235 Vdd \$7 \$120 Vdd sky130_fd_pr__pfet_01v8_lvt l=1 w=5 as=1.45 ad=1.45
+ ps=10.58 pd=10.58
X$236 Vdd \$7 \$405 Vdd sky130_fd_pr__pfet_01v8_lvt l=1 w=5 as=1.45 ad=1.45
+ ps=10.58 pd=10.58
X$237 Vdd \$7 \$120 Vdd sky130_fd_pr__pfet_01v8_lvt l=1 w=5 as=1.45 ad=1.45
+ ps=10.58 pd=10.58
X$238 Vdd Vdd Vdd Vdd sky130_fd_pr__pfet_01v8_lvt l=1 w=5 as=1.45 ad=1.45
+ ps=10.58 pd=10.58
X$239 Vdd \$7 \$121 Vdd sky130_fd_pr__pfet_01v8_lvt l=1 w=5 as=1.45 ad=1.45
+ ps=10.58 pd=10.58
X$240 Vdd \$7 \$122 Vdd sky130_fd_pr__pfet_01v8_lvt l=1 w=5 as=1.45 ad=1.45
+ ps=10.58 pd=10.58
X$241 Vdd \$7 \$121 Vdd sky130_fd_pr__pfet_01v8_lvt l=1 w=5 as=1.45 ad=1.45
+ ps=10.58 pd=10.58
X$242 Vdd \$7 \$122 Vdd sky130_fd_pr__pfet_01v8_lvt l=1 w=5 as=1.45 ad=1.45
+ ps=10.58 pd=10.58
X$243 Vdd Vdd Vdd Vdd sky130_fd_pr__pfet_01v8_lvt l=1 w=5 as=1.45 ad=1.45
+ ps=10.58 pd=10.58
X$244 Vdd Vdd Vdd Vdd sky130_fd_pr__pfet_01v8_lvt l=1 w=5 as=1.45 ad=1.45
+ ps=10.58 pd=10.58
X$245 Vdd \$7 \$59 Vdd sky130_fd_pr__pfet_01v8_lvt l=1 w=5 as=1.45 ad=1.45
+ ps=10.58 pd=10.58
X$246 Vdd \$7 \$27 Vdd sky130_fd_pr__pfet_01v8_lvt l=1 w=5 as=1.45 ad=1.45
+ ps=10.58 pd=10.58
X$247 Vdd \$7 \$27 Vdd sky130_fd_pr__pfet_01v8_lvt l=1 w=5 as=1.45 ad=1.45
+ ps=10.58 pd=10.58
X$248 Vdd \$7 \$59 Vdd sky130_fd_pr__pfet_01v8_lvt l=1 w=5 as=1.45 ad=1.45
+ ps=10.58 pd=10.58
X$249 Vdd Vdd Vdd Vdd sky130_fd_pr__pfet_01v8_lvt l=1 w=5 as=1.45 ad=1.45
+ ps=10.58 pd=10.58
X$250 Vdd Vdd Vdd Vdd sky130_fd_pr__pfet_01v8_lvt l=1 w=5 as=1.45 ad=1.45
+ ps=10.58 pd=10.58
X$251 Vdd \$33 \$33 Vdd sky130_fd_pr__pfet_01v8_lvt l=1 w=5 as=1.45 ad=1.45
+ ps=10.58 pd=10.58
X$252 Vdd \$33 \$7 Vdd sky130_fd_pr__pfet_01v8_lvt l=1 w=5 as=1.45 ad=1.45
+ ps=10.58 pd=10.58
X$253 Vdd \$33 \$33 Vdd sky130_fd_pr__pfet_01v8_lvt l=1 w=5 as=1.45 ad=1.45
+ ps=10.58 pd=10.58
X$254 Vdd \$33 \$7 Vdd sky130_fd_pr__pfet_01v8_lvt l=1 w=5 as=1.45 ad=1.45
+ ps=10.58 pd=10.58
X$255 Vdd Vdd Vdd Vdd sky130_fd_pr__pfet_01v8_lvt l=1 w=5 as=1.45 ad=1.45
+ ps=10.58 pd=10.58
X$256 Vdd \$57 \$57 Vdd sky130_fd_pr__pfet_01v8_lvt l=20 w=1 as=0.29 ad=0.29
+ ps=2.58 pd=2.58
X$257 Vdd \$57 \$57 Vdd sky130_fd_pr__pfet_01v8_lvt l=20 w=1 as=0.29 ad=0.29
+ ps=2.58 pd=2.58
X$258 Vss \$27 \$33 sky130_gnd sky130_fd_pr__nfet_01v8_lvt l=2 w=5 as=1.45
+ ad=1.45 ps=10.58 pd=10.58
X$259 Vss \$27 \$33 sky130_gnd sky130_fd_pr__nfet_01v8_lvt l=2 w=5 as=1.45
+ ad=1.45 ps=10.58 pd=10.58
X$260 Vss \$59 \$7 sky130_gnd sky130_fd_pr__nfet_01v8_lvt l=2 w=5 as=1.45
+ ad=1.45 ps=10.58 pd=10.58
X$261 Vss \$59 \$7 sky130_gnd sky130_fd_pr__nfet_01v8_lvt l=2 w=5 as=1.45
+ ad=1.45 ps=10.58 pd=10.58
X$262 Vss Vss Vss sky130_gnd sky130_fd_pr__nfet_01v8_lvt l=2 w=5 as=1.45
+ ad=1.45 ps=10.58 pd=10.58
X$263 Vss Vss Vss sky130_gnd sky130_fd_pr__nfet_01v8_lvt l=2 w=5 as=1.45
+ ad=1.45 ps=10.58 pd=10.58
X$264 Vss \$59 \$59 sky130_gnd sky130_fd_pr__nfet_01v8_lvt l=2 w=5 as=1.45
+ ad=1.45 ps=10.58 pd=10.58
X$265 Vss \$59 \$57 sky130_gnd sky130_fd_pr__nfet_01v8_lvt l=2 w=5 as=1.45
+ ad=1.45 ps=10.58 pd=10.58
X$266 Vss \$59 \$59 sky130_gnd sky130_fd_pr__nfet_01v8_lvt l=2 w=5 as=1.45
+ ad=1.45 ps=10.58 pd=10.58
X$267 Vss \$59 \$57 sky130_gnd sky130_fd_pr__nfet_01v8_lvt l=2 w=5 as=1.45
+ ad=1.45 ps=10.58 pd=10.58
Cext_1 \$120 \$121 219.854a
Cext_2 \$120 \$122 99.2425a
Cext_3 \$120 \$144 2.32532f
Cext_4 \$120 \$166 1.336f
Cext_5 \$120 \$202 1.04739f
Cext_6 \$120 \$254 59.5962a
Cext_7 \$120 \$3 104.291a
Cext_8 \$120 \$3.x2_x1_net10 0.116014a
Cext_9 \$120 \$3.x2_x1_net16 1.29955a
Cext_10 \$120 \$3.x2_x1_net3 0.116014a
Cext_11 \$120 \$3.x2_x1_net6 0.116014a
Cext_12 \$120 \$3.x2_x2_net1 0.116014a
Cext_13 \$120 \$3.x2_x2_net14 0.116014a
Cext_14 \$120 \$3.x2_x2_net18 0.232029a
Cext_15 \$120 \$3.x2_x2_net4 0.116014a
Cext_16 \$120 \$3.x2_x2_net8 0.116014a
Cext_17 \$120 \$405 998.601a
Cext_18 \$120 \$7 665.137a
Cext_19 \$120 Vdd 2.15523f
Cext_20 \$120 Vom 78.385a
Cext_21 \$120 Vop 61.4645a
Cext_22 \$120 Vss 4.29937f
Cext_23 \$120 sky130_gnd 9.04109f
Cext_24 \$121 \$122 4.39752f
Cext_25 \$121 \$144 190.14a
Cext_26 \$121 \$166 362.325a
Cext_27 \$121 \$200 231.803a
Cext_28 \$121 \$201 88.3638a
Cext_29 \$121 \$254 241.922a
Cext_30 \$121 \$280 76.9186a
Cext_31 \$121 \$281 67.8922a
Cext_32 \$121 \$282 555.866a
Cext_33 \$121 \$283 839.774a
Cext_34 \$121 \$284 2.24837f
Cext_35 \$121 \$285 1.61726f
Cext_36 \$121 \$3 613.245a
Cext_37 \$121 \$341 608.385a
Cext_38 \$121 \$342 594.563a
Cext_39 \$121 \$359 732.715a
Cext_40 \$121 \$405 329.839a
Cext_41 \$121 \$406 460.213a
Cext_42 \$121 \$432 0.117388a
Cext_43 \$121 \$434 627.203a
Cext_44 \$121 \$7 666.232a
Cext_45 \$121 Vdd 4.81377f
Cext_46 \$121 VREF 1.00859f
Cext_47 \$121 Vss 25.7664f
Cext_48 \$121 sky130_gnd 76.502f
Cext_49 \$122 \$144 173.944a
Cext_50 \$122 \$166 172.549a
Cext_51 \$122 \$200 864.624a
Cext_52 \$122 \$201 726.802a
Cext_53 \$122 \$202 340.641a
Cext_54 \$122 \$254 120.354a
Cext_55 \$122 \$280 75.2491a
Cext_56 \$122 \$281 59.8848a
Cext_57 \$122 \$282 1.01689f
Cext_58 \$122 \$283 238.205a
Cext_59 \$122 \$284 152.219a
Cext_60 \$122 \$285 196.565a
Cext_61 \$122 \$3 801.643a
Cext_62 \$122 \$341 407.056a
Cext_63 \$122 \$342 398.988a
Cext_64 \$122 \$359 173.47a
Cext_65 \$122 \$405 156.709a
Cext_66 \$122 \$406 300.652a
Cext_67 \$122 \$434 337.868a
Cext_68 \$122 \$7 689.314a
Cext_69 \$122 Vdd 3.11157f
Cext_70 \$122 Vom 291.932a
Cext_71 \$122 Vop 45.3794a
Cext_72 \$122 VREF 627.318a
Cext_73 \$122 Vss 15.1328f
Cext_74 \$122 sky130_gnd 20.2017f
Cext_75 \$144 \$166 6.63549f
Cext_76 \$144 \$200 582.509a
Cext_77 \$144 \$201 3.43776f
Cext_78 \$144 \$202 4.58939a
Cext_79 \$144 \$254 99.1985a
Cext_80 \$144 \$3 217.863a
Cext_81 \$144 \$3.x2_x1_net12 0.214777a
Cext_82 \$144 \$3.x2_x1_net14 1.12586a
Cext_83 \$144 \$3.x2_x1_net6 1.86454a
Cext_84 \$144 \$3.x2_x1_net8 1.35887a
Cext_85 \$144 \$3.x2_x2_net10 0.902647a
Cext_86 \$144 \$3.x2_x2_net14 1.29739a
Cext_87 \$144 \$3.x2_x2_net6 0.642231a
Cext_88 \$144 \$3.x2_x2_net8 0.56715a
Cext_89 \$144 \$405 172.323a
Cext_90 \$144 Vdd 3.33163f
Cext_91 \$144 Vom 1.13343f
Cext_92 \$144 Vop 892.208a
Cext_93 \$144 VREF 325.747a
Cext_94 \$144 Vss 8.07385f
Cext_95 \$144 sky130_gnd 19.2985f
Cext_96 \$166 \$200 326.911a
Cext_97 \$166 \$201 3.29696f
Cext_98 \$166 \$254 368.855a
Cext_99 \$166 \$3 321.419a
Cext_100 \$166 \$405 317.281a
Cext_101 \$166 Vdd 5.45103f
Cext_102 \$166 Vom 329.338a
Cext_103 \$166 VREF 74.665a
Cext_104 \$166 Vss 17.6433f
Cext_105 \$166 sky130_gnd 37.2796f
Cext_106 \$200 \$201 0.765973a
Cext_107 \$200 \$27 141.1a
Cext_108 \$200 \$280 1.48776f
Cext_109 \$200 \$281 213.893a
Cext_110 \$200 \$282 3.06582f
Cext_111 \$200 \$283 160.585a
Cext_112 \$200 \$284 371.255a
Cext_113 \$200 \$285 1.42732f
Cext_114 \$200 \$3 3.71719f
Cext_115 \$200 \$33 44.087a
Cext_116 \$200 \$341 445.35a
Cext_117 \$200 \$342 98.6728a
Cext_118 \$200 \$359 1.76614f
Cext_119 \$200 \$405 739.441a
Cext_120 \$200 \$406 1.44566f
Cext_121 \$200 \$432 2.9145f
Cext_122 \$200 \$434 1.10956f
Cext_123 \$200 \$57 1.16382f
Cext_124 \$200 \$59 769.168a
Cext_125 \$200 \$7 1.33133f
Cext_126 \$200 RGM 0.252639a
Cext_127 \$200 Vdd 24.6143f
Cext_128 \$200 Vm 82.3273a
Cext_129 \$200 Vom 1.04874p
Cext_130 \$200 Vop 14.9098a
Cext_131 \$200 Vp 313.739a
Cext_132 \$200 VREF 6.87089f
Cext_133 \$200 Vss 7.15886f
Cext_134 \$200 sky130_gnd 35.4927f
Cext_135 \$201 \$202 1.8153f
Cext_136 \$201 \$254 446.406a
Cext_137 \$201 \$3 121.221a
Cext_138 \$201 \$405 94.9102a
Cext_139 \$201 Vdd 4.39423f
Cext_140 \$201 Vom 84.5925a
Cext_141 \$201 Vop 4.7262a
Cext_142 \$201 VREF 346.704a
Cext_143 \$201 Vss 110.845a
Cext_144 \$201 sky130_gnd 668.327a
Cext_145 \$202 \$254 700.258a
Cext_146 \$202 \$284 218.795a
Cext_147 \$202 \$3 36.8149a
Cext_148 \$202 Vdd 13.6341f
Cext_149 \$202 Vom 290.074a
Cext_150 \$202 Vop 858.8a
Cext_151 \$202 VREF 0.120181a
Cext_152 \$202 Vss 1.00711f
Cext_153 \$202 sky130_gnd 4.04468f
Cext_154 \$254 \$3 83.2427a
Cext_155 \$254 \$3.x2_x1_net11 0.840458a
Cext_156 \$254 \$3.x2_x1_net13 0.46419a
Cext_157 \$254 \$3.x2_x1_net15 0.840458a
Cext_158 \$254 \$3.x2_x1_net17 1.10535a
Cext_159 \$254 \$3.x2_x1_net19 0.46419a
Cext_160 \$254 \$3.x2_x1_net2 0.840458a
Cext_161 \$254 \$3.x2_x1_net4 73.9463a
Cext_162 \$254 \$3.x2_x1_net5 12.3655a
Cext_163 \$254 \$3.x2_x1_net7 0.46419a
Cext_164 \$254 \$3.x2_x1_net9 0.46419a
Cext_165 \$254 \$3.x2_x2_net11 0.46419a
Cext_166 \$254 \$3.x2_x2_net13 0.840458a
Cext_167 \$254 \$3.x2_x2_net15 0.46419a
Cext_168 \$254 \$3.x2_x2_net17 1.13649a
Cext_169 \$254 \$3.x2_x2_net19 0.840458a
Cext_170 \$254 \$3.x2_x2_net2 0.46419a
Cext_171 \$254 \$3.x2_x2_net4 4.12606a
Cext_172 \$254 \$3.x2_x2_net5 160.545a
Cext_173 \$254 \$3.x2_x2_net7 0.840458a
Cext_174 \$254 \$3.x2_x2_net9 0.840458a
Cext_175 \$254 \$405 83.2427a
Cext_176 \$254 Vdd 15.9362f
Cext_177 \$254 Vom 2.59154f
Cext_178 \$254 Vop 5.57254f
Cext_179 \$254 VREF 3.31283f
Cext_180 \$254 Vss 3.98897f
Cext_181 \$254 sky130_gnd 3.45557f
Cext_182 \$27 \$33 1.49426f
Cext_183 \$27 \$57 318.968a
Cext_184 \$27 \$59 1.16059f
Cext_185 \$27 \$7 813.146a
Cext_186 \$27 RGM 3.01948f
Cext_187 \$27 Vdd 2.20013f
Cext_188 \$27 Vom 519.98a
Cext_189 \$27 Vop 809.033a
Cext_190 \$27 Vss 2.77262f
Cext_191 \$27 sky130_gnd 9.4029f
Cext_192 \$280 \$281 9.50833f
Cext_193 \$280 \$282 2.11863f
Cext_194 \$280 \$283 67.4624a
Cext_195 \$280 \$284 3.90766f
Cext_196 \$280 \$285 181.886a
Cext_197 \$280 \$3 215.977a
Cext_198 \$280 \$341 1.3915a
Cext_199 \$280 \$342 1.32193a
Cext_200 \$280 \$359 157.287a
Cext_201 \$280 \$405 140.88a
Cext_202 \$280 \$406 1.3915a
Cext_203 \$280 \$432 5.27519f
Cext_204 \$280 \$434 1.32193a
Cext_205 \$280 Vdd 16.8686f
Cext_206 \$280 Vm 978.701a
Cext_207 \$280 Vp 261.527a
Cext_208 \$280 VREF 135.917a
Cext_209 \$280 Vss 2.99157f
Cext_210 \$280 sky130_gnd 2.92197f
Cext_211 \$281 \$282 2.28165f
Cext_212 \$281 \$283 51.685a
Cext_213 \$281 \$284 5.75093f
Cext_214 \$281 \$285 137.54a
Cext_215 \$281 \$3 1.50706f
Cext_216 \$281 \$341 7.72937a
Cext_217 \$281 \$342 7.72937a
Cext_218 \$281 \$359 110.974a
Cext_219 \$281 \$405 72.8674a
Cext_220 \$281 \$406 7.72937a
Cext_221 \$281 \$432 5.08376f
Cext_222 \$281 \$434 7.72937a
Cext_223 \$281 Vdd 11.8108f
Cext_224 \$281 Vm 92.3339a
Cext_225 \$281 Vp 1.00718f
Cext_226 \$281 VREF 402.837a
Cext_227 \$281 Vss 1.07101f
Cext_228 \$281 sky130_gnd 7.49802f
Cext_229 \$282 \$283 358.615a
Cext_230 \$282 \$284 95.3419a
Cext_231 \$282 \$285 143.382a
Cext_232 \$282 \$3 382.582a
Cext_233 \$282 \$341 305.114a
Cext_234 \$282 \$342 1.12346f
Cext_235 \$282 \$359 206.941a
Cext_236 \$282 \$405 98.9936a
Cext_237 \$282 \$406 191.659a
Cext_238 \$282 \$434 1.26395f
Cext_239 \$282 Vdd 99.405a
Cext_240 \$282 Vm 985.604a
Cext_241 \$282 Vp 1.00375f
Cext_242 \$282 VREF 1.98755f
Cext_243 \$282 Vss 8.34326f
Cext_244 \$282 sky130_gnd 6.0819f
Cext_245 \$283 \$284 7.60671f
Cext_246 \$283 \$285 6.14774f
Cext_247 \$283 \$3 1.90945f
Cext_248 \$283 \$341 67.0493a
Cext_249 \$283 \$342 68.7378a
Cext_250 \$283 \$359 5.71922f
Cext_251 \$283 \$405 169.807a
Cext_252 \$283 \$406 0.503546a
Cext_253 \$283 Vdd 194.403a
Cext_254 \$283 Vm 0.413139a
Cext_255 \$283 Vp 0.413139a
Cext_256 \$283 VREF 1.73757f
Cext_257 \$283 Vss 7.71402f
Cext_258 \$283 sky130_gnd 6.72203f
Cext_259 \$284 \$285 5.11653f
Cext_260 \$284 \$3 1.41575f
Cext_261 \$284 \$341 50.2543a
Cext_262 \$284 \$342 44.583a
Cext_263 \$284 \$359 6.04862f
Cext_264 \$284 \$405 248.992a
Cext_265 \$284 \$406 44.4323a
Cext_266 \$284 \$432 5.16141a
Cext_267 \$284 \$434 44.4323a
Cext_268 \$284 Vdd 53.2805f
Cext_269 \$284 VREF 2.94952f
Cext_270 \$284 Vss 7.82189f
Cext_271 \$284 sky130_gnd 16.3405f
Cext_272 \$285 \$3 2.45448f
Cext_273 \$285 \$341 97.311a
Cext_274 \$285 \$342 85.9413a
Cext_275 \$285 \$359 6.35082f
Cext_276 \$285 \$405 239.066a
Cext_277 \$285 \$406 85.7905a
Cext_278 \$285 \$432 5.66718a
Cext_279 \$285 \$434 85.7905a
Cext_280 \$285 Vdd 29.1565f
Cext_281 \$285 VREF 1.42363f
Cext_282 \$285 Vss 8.18644f
Cext_283 \$285 sky130_gnd 13.7506f
Cext_284 \$3 \$33 176.523a
Cext_285 \$3 \$341 1.21995f
Cext_286 \$3 \$342 1.35965f
Cext_287 \$3 \$359 162.479a
Cext_288 \$3 \$405 826.419a
Cext_289 \$3 \$406 85.7905a
Cext_290 \$3 \$432 1.98202f
Cext_291 \$3 \$434 99.913a
Cext_292 \$3 \$57 92.1135a
Cext_293 \$3 \$59 87.8203a
Cext_294 \$3 \$7 242.087a
Cext_295 \$3 Vdd 21.8908f
Cext_296 \$3 Vom 733.972a
Cext_297 \$3 Vop 1.047p
Cext_298 \$3 Vp 3.29674a
Cext_299 \$3 VREF 6.85723f
Cext_300 \$3 Vss 12.1616f
Cext_301 \$3 sky130_gnd 36.6581f
Cext_302 \$3.x2_x1_net1 \$3.x2_x1_net10 159.659a
Cext_303 \$3.x2_x1_net1 \$3.x2_x1_net6 159.659a
Cext_304 \$3.x2_x1_net1 \$3.x2_x2_net1 512.201a
Cext_305 \$3.x2_x1_net1 \$3.x2_x2_net10 9.25a
Cext_306 \$3.x2_x1_net1 \$3.x2_x2_net6 9.25a
Cext_307 \$3.x2_x1_net1 Vss 55.6378a
Cext_308 \$3.x2_x1_net1 sky130_gnd 1.22892f
Cext_309 \$3.x2_x1_net10 \$3.x2_x1_net8 159.659a
Cext_310 \$3.x2_x1_net10 \$3.x2_x2_net1 20.8047a
Cext_311 \$3.x2_x1_net10 \$3.x2_x2_net10 414.347a
Cext_312 \$3.x2_x1_net10 \$3.x2_x2_net8 20.8047a
Cext_313 \$3.x2_x1_net10 Vss 195.596a
Cext_314 \$3.x2_x1_net10 sky130_gnd 1.24512f
Cext_315 \$3.x2_x1_net11 \$3.x2_x2_net11 512.979a
Cext_316 \$3.x2_x1_net11 \$3.x2_x2_net7 20.8047a
Cext_317 \$3.x2_x1_net11 \$3.x2_x2_net9 20.8047a
Cext_318 \$3.x2_x1_net11 Vom 0.46419a
Cext_319 \$3.x2_x1_net11 Vop 2.4283a
Cext_320 \$3.x2_x1_net11 Vss 97.9997a
Cext_321 \$3.x2_x1_net11 sky130_gnd 1.12882f
Cext_322 \$3.x2_x1_net12 \$3.x2_x1_net14 159.659a
Cext_323 \$3.x2_x1_net12 \$3.x2_x1_net8 159.659a
Cext_324 \$3.x2_x1_net12 \$3.x2_x2_net12 414.569a
Cext_325 \$3.x2_x1_net12 \$3.x2_x2_net14 20.8047a
Cext_326 \$3.x2_x1_net12 \$3.x2_x2_net8 20.8047a
Cext_327 \$3.x2_x1_net12 Vss 195.351a
Cext_328 \$3.x2_x1_net12 sky130_gnd 1.24444f
Cext_329 \$3.x2_x1_net13 \$3.x2_x2_net13 414.418a
Cext_330 \$3.x2_x1_net13 \$3.x2_x2_net15 9.25a
Cext_331 \$3.x2_x1_net13 \$3.x2_x2_net2 9.25a
Cext_332 \$3.x2_x1_net13 Vom 0.292982a
Cext_333 \$3.x2_x1_net13 Vop 1.34603a
Cext_334 \$3.x2_x1_net13 Vss 6.05559a
Cext_335 \$3.x2_x1_net13 sky130_gnd 1.12785f
Cext_336 \$3.x2_x1_net14 \$3.x2_x1_net3 159.659a
Cext_337 \$3.x2_x1_net14 \$3.x2_x2_net12 9.25a
Cext_338 \$3.x2_x1_net14 \$3.x2_x2_net14 512.201a
Cext_339 \$3.x2_x1_net14 \$3.x2_x2_net3 9.25a
Cext_340 \$3.x2_x1_net14 Vss 55.3305a
Cext_341 \$3.x2_x1_net14 sky130_gnd 1.22796f
Cext_342 \$3.x2_x1_net15 \$3.x2_x2_net13 20.8047a
Cext_343 \$3.x2_x1_net15 \$3.x2_x2_net15 512.979a
Cext_344 \$3.x2_x1_net15 \$3.x2_x2_net19 20.8047a
Cext_345 \$3.x2_x1_net15 Vom 0.46419a
Cext_346 \$3.x2_x1_net15 Vop 2.4283a
Cext_347 \$3.x2_x1_net15 Vss 97.9997a
Cext_348 \$3.x2_x1_net15 sky130_gnd 1.12882f
Cext_349 \$3.x2_x1_net16 \$3.x2_x1_net18 159.659a
Cext_350 \$3.x2_x1_net16 \$3.x2_x2_net16 414.456a
Cext_351 \$3.x2_x1_net16 \$3.x2_x2_net18 20.8047a
Cext_352 \$3.x2_x1_net16 Vss 390.87a
Cext_353 \$3.x2_x1_net16 sky130_gnd 1.24662f
Cext_354 \$3.x2_x1_net17 \$3.x2_x2_net17 512.979a
Cext_355 \$3.x2_x1_net17 \$3.x2_x2_net19 20.8047a
Cext_356 \$3.x2_x1_net17 Vom 11.7275a
Cext_357 \$3.x2_x1_net17 Vop 2.4283a
Cext_358 \$3.x2_x1_net17 Vss 99.664a
Cext_359 \$3.x2_x1_net17 sky130_gnd 1.13923f
Cext_360 \$3.x2_x1_net18 \$3.x2_x1_net3 159.659a
Cext_361 \$3.x2_x1_net18 \$3.x2_x2_net16 9.25a
Cext_362 \$3.x2_x1_net18 \$3.x2_x2_net18 512.201a
Cext_363 \$3.x2_x1_net18 \$3.x2_x2_net3 9.25a
Cext_364 \$3.x2_x1_net18 Vss 55.897a
Cext_365 \$3.x2_x1_net18 sky130_gnd 1.22993f
Cext_366 \$3.x2_x1_net19 \$3.x2_x2_net15 9.25a
Cext_367 \$3.x2_x1_net19 \$3.x2_x2_net17 9.25a
Cext_368 \$3.x2_x1_net19 \$3.x2_x2_net19 414.418a
Cext_369 \$3.x2_x1_net19 Vom 0.292982a
Cext_370 \$3.x2_x1_net19 Vop 1.34603a
Cext_371 \$3.x2_x1_net19 Vss 6.05559a
Cext_372 \$3.x2_x1_net19 sky130_gnd 1.12785f
Cext_373 \$3.x2_x1_net2 \$3.x2_x2_net13 20.8047a
Cext_374 \$3.x2_x1_net2 \$3.x2_x2_net2 512.979a
Cext_375 \$3.x2_x1_net2 \$3.x2_x2_net9 20.8047a
Cext_376 \$3.x2_x1_net2 Vom 0.46419a
Cext_377 \$3.x2_x1_net2 Vop 2.4283a
Cext_378 \$3.x2_x1_net2 Vss 97.9997a
Cext_379 \$3.x2_x1_net2 sky130_gnd 1.12882f
Cext_380 \$3.x2_x1_net3 \$3.x2_x2_net14 20.8047a
Cext_381 \$3.x2_x1_net3 \$3.x2_x2_net18 20.8047a
Cext_382 \$3.x2_x1_net3 \$3.x2_x2_net3 414.569a
Cext_383 \$3.x2_x1_net3 Vss 196.061a
Cext_384 \$3.x2_x1_net3 sky130_gnd 1.24508f
Cext_385 \$3.x2_x1_net4 \$3.x2_x1_net6 159.659a
Cext_386 \$3.x2_x1_net4 \$3.x2_x2_net4 512.201a
Cext_387 \$3.x2_x1_net4 \$3.x2_x2_net6 9.25a
Cext_388 \$3.x2_x1_net4 Vom 1.09265a
Cext_389 \$3.x2_x1_net4 Vop 3.60549a
Cext_390 \$3.x2_x1_net4 Vss 328.697a
Cext_391 \$3.x2_x1_net4 sky130_gnd 1.24014f
Cext_392 \$3.x2_x1_net5 \$3.x2_x2_net5 512.979a
Cext_393 \$3.x2_x1_net5 \$3.x2_x2_net7 20.8047a
Cext_394 \$3.x2_x1_net5 Vom 0.581781a
Cext_395 \$3.x2_x1_net5 Vop 2.86193a
Cext_396 \$3.x2_x1_net5 Vss 115.283a
Cext_397 \$3.x2_x1_net5 sky130_gnd 1.13948f
Cext_398 \$3.x2_x1_net6 \$3.x2_x2_net1 20.8047a
Cext_399 \$3.x2_x1_net6 \$3.x2_x2_net4 20.8047a
Cext_400 \$3.x2_x1_net6 \$3.x2_x2_net6 414.359a
Cext_401 \$3.x2_x1_net6 Vss 205.681a
Cext_402 \$3.x2_x1_net6 sky130_gnd 1.24304f
Cext_403 \$3.x2_x1_net7 \$3.x2_x2_net11 9.25a
Cext_404 \$3.x2_x1_net7 \$3.x2_x2_net5 9.25a
Cext_405 \$3.x2_x1_net7 \$3.x2_x2_net7 414.418a
Cext_406 \$3.x2_x1_net7 Vom 0.292982a
Cext_407 \$3.x2_x1_net7 Vop 1.34603a
Cext_408 \$3.x2_x1_net7 Vss 8.54699a
Cext_409 \$3.x2_x1_net7 sky130_gnd 1.12785f
Cext_410 \$3.x2_x1_net8 \$3.x2_x2_net10 9.25a
Cext_411 \$3.x2_x1_net8 \$3.x2_x2_net12 9.25a
Cext_412 \$3.x2_x1_net8 \$3.x2_x2_net8 512.201a
Cext_413 \$3.x2_x1_net8 Vss 55.1596a
Cext_414 \$3.x2_x1_net8 sky130_gnd 1.22781f
Cext_415 \$3.x2_x1_net9 \$3.x2_x2_net11 9.25a
Cext_416 \$3.x2_x1_net9 \$3.x2_x2_net2 9.25a
Cext_417 \$3.x2_x1_net9 \$3.x2_x2_net9 414.418a
Cext_418 \$3.x2_x1_net9 Vom 0.292982a
Cext_419 \$3.x2_x1_net9 Vop 1.34603a
Cext_420 \$3.x2_x1_net9 Vss 6.05559a
Cext_421 \$3.x2_x1_net9 sky130_gnd 1.12785f
Cext_422 \$3.x2_x2_net1 Vss 102.895a
Cext_423 \$3.x2_x2_net1 sky130_gnd 1.12285f
Cext_424 \$3.x2_x2_net10 Vss 8.7673a
Cext_425 \$3.x2_x2_net10 sky130_gnd 1.1223f
Cext_426 \$3.x2_x2_net11 \$3.x2_x2_net7 159.492a
Cext_427 \$3.x2_x2_net11 \$3.x2_x2_net9 159.492a
Cext_428 \$3.x2_x2_net11 Vom 0.292982a
Cext_429 \$3.x2_x2_net11 Vop 1.34603a
Cext_430 \$3.x2_x2_net11 Vss 51.5188a
Cext_431 \$3.x2_x2_net11 sky130_gnd 1.2341f
Cext_432 \$3.x2_x2_net12 Vss 9.10591a
Cext_433 \$3.x2_x2_net12 sky130_gnd 1.1229f
Cext_434 \$3.x2_x2_net13 \$3.x2_x2_net15 159.492a
Cext_435 \$3.x2_x2_net13 \$3.x2_x2_net2 159.492a
Cext_436 \$3.x2_x2_net13 Vom 0.46419a
Cext_437 \$3.x2_x2_net13 Vop 2.4283a
Cext_438 \$3.x2_x2_net13 Vss 189.003a
Cext_439 \$3.x2_x2_net13 sky130_gnd 1.2512f
Cext_440 \$3.x2_x2_net14 Vss 102.694a
Cext_441 \$3.x2_x2_net14 sky130_gnd 1.12179f
Cext_442 \$3.x2_x2_net15 \$3.x2_x2_net19 159.492a
Cext_443 \$3.x2_x2_net15 Vom 0.292982a
Cext_444 \$3.x2_x2_net15 Vop 1.34603a
Cext_445 \$3.x2_x2_net15 Vss 51.5188a
Cext_446 \$3.x2_x2_net15 sky130_gnd 1.2341f
Cext_447 \$3.x2_x2_net16 Vss 20.198a
Cext_448 \$3.x2_x2_net16 sky130_gnd 1.13353f
Cext_449 \$3.x2_x2_net17 \$3.x2_x2_net19 159.492a
Cext_450 \$3.x2_x2_net17 Vom 159.785a
Cext_451 \$3.x2_x2_net17 Vop 1.34603a
Cext_452 \$3.x2_x2_net17 Vss 54.3489a
Cext_453 \$3.x2_x2_net17 sky130_gnd 1.24444f
Cext_454 \$3.x2_x2_net18 Vss 103.109a
Cext_455 \$3.x2_x2_net18 sky130_gnd 1.12463f
Cext_456 \$3.x2_x2_net19 Vom 0.46419a
Cext_457 \$3.x2_x2_net19 Vop 2.4283a
Cext_458 \$3.x2_x2_net19 Vss 189.003a
Cext_459 \$3.x2_x2_net19 sky130_gnd 1.2512f
Cext_460 \$3.x2_x2_net2 \$3.x2_x2_net9 159.492a
Cext_461 \$3.x2_x2_net2 Vom 0.292982a
Cext_462 \$3.x2_x2_net2 Vop 1.34603a
Cext_463 \$3.x2_x2_net2 Vss 51.5188a
Cext_464 \$3.x2_x2_net2 sky130_gnd 1.2341f
Cext_465 \$3.x2_x2_net3 Vss 9.24338a
Cext_466 \$3.x2_x2_net3 sky130_gnd 1.12294f
Cext_467 \$3.x2_x2_net4 Vom 0.391894a
Cext_468 \$3.x2_x2_net4 Vop 0.785698a
Cext_469 \$3.x2_x2_net4 Vss 186.464a
Cext_470 \$3.x2_x2_net4 sky130_gnd 1.13439f
Cext_471 \$3.x2_x2_net5 \$3.x2_x2_net7 159.492a
Cext_472 \$3.x2_x2_net5 Vom 0.489768a
Cext_473 \$3.x2_x2_net5 Vop 2.33548a
Cext_474 \$3.x2_x2_net5 Vss 75.958a
Cext_475 \$3.x2_x2_net5 sky130_gnd 1.24476f
Cext_476 \$3.x2_x2_net6 Vss 15.9191a
Cext_477 \$3.x2_x2_net6 sky130_gnd 1.12242f
Cext_478 \$3.x2_x2_net7 Vom 0.46419a
Cext_479 \$3.x2_x2_net7 Vop 2.4283a
Cext_480 \$3.x2_x2_net7 Vss 192.638a
Cext_481 \$3.x2_x2_net7 sky130_gnd 1.2512f
Cext_482 \$3.x2_x2_net8 Vss 102.712a
Cext_483 \$3.x2_x2_net8 sky130_gnd 1.12233f
Cext_484 \$3.x2_x2_net9 Vom 0.46419a
Cext_485 \$3.x2_x2_net9 Vop 2.4283a
Cext_486 \$3.x2_x2_net9 Vss 189.003a
Cext_487 \$3.x2_x2_net9 sky130_gnd 1.2512f
Cext_488 \$33 \$57 698.133a
Cext_489 \$33 \$59 615.54a
Cext_490 \$33 \$7 2.0878f
Cext_491 \$33 RGM 0.21365a
Cext_492 \$33 Vdd 8.44306f
Cext_493 \$33 Vom 1.41216f
Cext_494 \$33 Vop 978.344a
Cext_495 \$33 Vss 2.21909f
Cext_496 \$33 sky130_gnd 7.23031f
Cext_497 \$341 \$342 1.41926f
Cext_498 \$341 \$359 596.69a
Cext_499 \$341 \$405 749.194a
Cext_500 \$341 \$406 5.0935f
Cext_501 \$341 \$434 113.723a
Cext_502 \$341 Vdd 99.6097a
Cext_503 \$341 Vss 1.64088f
Cext_504 \$341 sky130_gnd 6.55585f
Cext_505 \$342 \$359 75.6287a
Cext_506 \$342 \$405 1.18049a
Cext_507 \$342 \$406 5.09539f
Cext_508 \$342 \$434 4.99904f
Cext_509 \$342 Vdd 86.1383a
Cext_510 \$342 Vss 1.38528f
Cext_511 \$342 sky130_gnd 3.43422f
Cext_512 \$359 \$405 664.708a
Cext_513 \$359 \$406 6.10153a
Cext_514 \$359 Vdd 181.592a
Cext_515 \$359 VREF 1.25273f
Cext_516 \$359 Vss 2.73487f
Cext_517 \$359 sky130_gnd 9.07149f
Cext_518 \$405 \$406 1.22581a
Cext_519 \$405 \$432 1.0322f
Cext_520 \$405 \$434 0.81437a
Cext_521 \$405 \$7 662.884a
Cext_522 \$405 Vdd 4.44495f
Cext_523 \$405 VREF 448.824a
Cext_524 \$405 Vss 4.74423f
Cext_525 \$405 sky130_gnd 8.43465f
Cext_526 \$406 \$434 242.981a
Cext_527 \$406 Vdd 88.7175a
Cext_528 \$406 Vss 1.03838f
Cext_529 \$406 sky130_gnd 4.16513f
Cext_530 \$432 Vdd 30.911f
Cext_531 \$432 Vss 652.706a
Cext_532 \$432 sky130_gnd 4.50349f
Cext_533 \$434 Vdd 87.6724a
Cext_534 \$434 Vss 6.11102f
Cext_535 \$434 sky130_gnd 3.37142f
Cext_536 \$57 \$59 5.69249f
Cext_537 \$57 \$7 3.73512f
Cext_538 \$57 RGM 1.27666a
Cext_539 \$57 Vdd 16.807f
Cext_540 \$57 Vom 375.24a
Cext_541 \$57 Vop 104.915a
Cext_542 \$57 Vss 1.39345f
Cext_543 \$57 sky130_gnd 6.22427f
Cext_544 \$59 \$7 5.97771f
Cext_545 \$59 RGM 5.05846a
Cext_546 \$59 Vdd 3.76268f
Cext_547 \$59 Vom 401.493a
Cext_548 \$59 Vop 84.5225a
Cext_549 \$59 Vss 8.96973f
Cext_550 \$59 sky130_gnd 11.7338f
Cext_551 \$7 RGM 5.55262a
Cext_552 \$7 Vdd 19.0504f
Cext_553 \$7 Vom 720.628a
Cext_554 \$7 Vop 87.3377a
Cext_555 \$7 Vss 2.81635f
Cext_556 \$7 sky130_gnd 7.24361f
Cext_557 RGM Vop 78.1009a
Cext_558 RGM Vss 236.604a
Cext_559 RGM sky130_gnd 1.62214f
Cext_560 Vdd Vom 7.34119f
Cext_561 Vdd Vop 5.70621f
Cext_562 Vdd Vss 4.54018f
Cext_563 Vm Vp 1.83465f
Cext_564 Vm Vss 2.56516f
Cext_565 Vom Vop 6.41339f
Cext_566 Vom Vss 3.53915f
Cext_567 Vop Vss 7.63773f
Cext_568 Vp Vss 1.10133f
Cext_569 VREF Vdd 11.4099f
Cext_570 VREF Vom 0.236934a
Cext_571 VREF Vss 14.4874f
Cext_572 VREF sky130_gnd 39.6959f
Cext_573 sky130_gnd Vdd 58.1429f
Cext_574 sky130_gnd Vm 3.9792f
Cext_575 sky130_gnd Vom 30.1433f
Cext_576 sky130_gnd Vop 25.9219f
Cext_577 sky130_gnd Vp 5.18359f
Cext_578 sky130_gnd Vss 327.604f
.ENDS ttsky25a_fd_routed
