* Extracted by KLayout with SKY130 LVS runset on : 04/11/2026 12:36

.SUBCKT ttsky25a_fd_routed \$3.x2_x1_net1 \$3.x2_x1_net10 \$3.x2_x1_net11
+ \$3.x2_x1_net12 \$3.x2_x1_net13 \$3.x2_x1_net14 \$3.x2_x1_net15
+ \$3.x2_x1_net16 \$3.x2_x1_net17 \$3.x2_x1_net18 \$3.x2_x1_net19
+ \$3.x2_x1_net2 \$3.x2_x1_net3 \$3.x2_x1_net4 \$3.x2_x1_net5 \$3.x2_x1_net6
+ \$3.x2_x1_net7 \$3.x2_x1_net8 \$3.x2_x1_net9 \$3.x2_x2_net1 \$3.x2_x2_net10
+ \$3.x2_x2_net11 \$3.x2_x2_net12 \$3.x2_x2_net13 \$3.x2_x2_net14
+ \$3.x2_x2_net15 \$3.x2_x2_net16 \$3.x2_x2_net17 \$3.x2_x2_net18
+ \$3.x2_x2_net19 \$3.x2_x2_net2 \$3.x2_x2_net3 \$3.x2_x2_net4 \$3.x2_x2_net5
+ \$3.x2_x2_net6 \$3.x2_x2_net7 \$3.x2_x2_net8 \$3.x2_x2_net9 RGM VREF Vdd Vm
+ Vom Vop Vp Vss sky130_gnd
C$1 Vom \$200 sky130_fd_pr__model__cap_mim C=2e-13 A=100 P=40
C$2 Vom \$200 sky130_fd_pr__model__cap_mim C=2e-13 A=100 P=40
C$3 Vom \$200 sky130_fd_pr__model__cap_mim C=2e-13 A=100 P=40
C$4 Vom \$200 sky130_fd_pr__model__cap_mim C=2e-13 A=100 P=40
C$5 Vom \$200 sky130_fd_pr__model__cap_mim C=2e-13 A=100 P=40
C$6 Vop \$3 sky130_fd_pr__model__cap_mim C=2e-13 A=100 P=40
C$7 Vop \$3 sky130_fd_pr__model__cap_mim C=2e-13 A=100 P=40
C$8 Vop \$3 sky130_fd_pr__model__cap_mim C=2e-13 A=100 P=40
C$9 Vop \$3 sky130_fd_pr__model__cap_mim C=2e-13 A=100 P=40
C$10 Vop \$3 sky130_fd_pr__model__cap_mim C=2e-13 A=100 P=40
R$11 Vom \$3.x2_x2_net16 sky130_fd_pr__res_generic_po R=3856 L=40 W=0.5 A=20
+ P=81
R$12 \$254 \$3.x2_x2_net4 sky130_fd_pr__res_generic_po R=3856 L=40 W=0.5 A=20
+ P=81
R$13 \$254 \$3.x2_x1_net16 sky130_fd_pr__res_generic_po R=3856 L=40 W=0.5 A=20
+ P=81
R$14 Vop \$3.x2_x1_net4 sky130_fd_pr__res_generic_po R=3856 L=40 W=0.5 A=20 P=81
R$15 Vss Vss sky130_fd_pr__res_generic_po R=3856 L=40 W=0.5 A=20 P=81
R$16 Vss Vss sky130_fd_pr__res_generic_po R=3856 L=40 W=0.5 A=20 P=81
R$17 \$3.x2_x2_net5 \$3.x2_x2_net6 sky130_fd_pr__res_generic_po R=3856 L=40
+ W=0.5 A=20 P=81
R$18 \$3.x2_x2_net5 \$3.x2_x2_net4 sky130_fd_pr__res_generic_po R=3856 L=40
+ W=0.5 A=20 P=81
R$19 \$3.x2_x1_net5 \$3.x2_x1_net6 sky130_fd_pr__res_generic_po R=3856 L=40
+ W=0.5 A=20 P=81
R$20 \$3.x2_x1_net5 \$3.x2_x1_net4 sky130_fd_pr__res_generic_po R=3856 L=40
+ W=0.5 A=20 P=81
R$21 \$3.x2_x2_net7 \$3.x2_x2_net1 sky130_fd_pr__res_generic_po R=3856 L=40
+ W=0.5 A=20 P=81
R$22 \$3.x2_x2_net7 \$3.x2_x2_net6 sky130_fd_pr__res_generic_po R=3856 L=40
+ W=0.5 A=20 P=81
R$23 \$3.x2_x1_net7 \$3.x2_x1_net1 sky130_fd_pr__res_generic_po R=3856 L=40
+ W=0.5 A=20 P=81
R$24 \$3.x2_x1_net7 \$3.x2_x1_net6 sky130_fd_pr__res_generic_po R=3856 L=40
+ W=0.5 A=20 P=81
R$25 \$3.x2_x2_net11 \$3.x2_x2_net10 sky130_fd_pr__res_generic_po R=3856 L=40
+ W=0.5 A=20 P=81
R$26 \$3.x2_x2_net11 \$3.x2_x2_net1 sky130_fd_pr__res_generic_po R=3856 L=40
+ W=0.5 A=20 P=81
R$27 \$3.x2_x1_net11 \$3.x2_x1_net10 sky130_fd_pr__res_generic_po R=3856 L=40
+ W=0.5 A=20 P=81
R$28 \$3.x2_x1_net11 \$3.x2_x1_net1 sky130_fd_pr__res_generic_po R=3856 L=40
+ W=0.5 A=20 P=81
R$29 \$3.x2_x2_net9 \$3.x2_x2_net8 sky130_fd_pr__res_generic_po R=3856 L=40
+ W=0.5 A=20 P=81
R$30 \$3.x2_x2_net9 \$3.x2_x2_net10 sky130_fd_pr__res_generic_po R=3856 L=40
+ W=0.5 A=20 P=81
R$31 \$3.x2_x1_net9 \$3.x2_x1_net8 sky130_fd_pr__res_generic_po R=3856 L=40
+ W=0.5 A=20 P=81
R$32 \$3.x2_x1_net9 \$3.x2_x1_net10 sky130_fd_pr__res_generic_po R=3856 L=40
+ W=0.5 A=20 P=81
R$33 \$3.x2_x2_net2 \$3.x2_x2_net8 sky130_fd_pr__res_generic_po R=3856 L=40
+ W=0.5 A=20 P=81
R$34 \$3.x2_x2_net2 \$3.x2_x2_net12 sky130_fd_pr__res_generic_po R=3856 L=40
+ W=0.5 A=20 P=81
R$35 \$3.x2_x1_net2 \$3.x2_x1_net8 sky130_fd_pr__res_generic_po R=3856 L=40
+ W=0.5 A=20 P=81
R$36 \$3.x2_x1_net2 \$3.x2_x1_net12 sky130_fd_pr__res_generic_po R=3856 L=40
+ W=0.5 A=20 P=81
R$37 \$3.x2_x2_net13 \$3.x2_x2_net14 sky130_fd_pr__res_generic_po R=3856 L=40
+ W=0.5 A=20 P=81
R$38 \$3.x2_x2_net13 \$3.x2_x2_net12 sky130_fd_pr__res_generic_po R=3856 L=40
+ W=0.5 A=20 P=81
R$39 \$3.x2_x1_net13 \$3.x2_x1_net14 sky130_fd_pr__res_generic_po R=3856 L=40
+ W=0.5 A=20 P=81
R$40 \$3.x2_x1_net13 \$3.x2_x1_net12 sky130_fd_pr__res_generic_po R=3856 L=40
+ W=0.5 A=20 P=81
R$41 \$3.x2_x2_net15 \$3.x2_x2_net3 sky130_fd_pr__res_generic_po R=3856 L=40
+ W=0.5 A=20 P=81
R$42 \$3.x2_x2_net15 \$3.x2_x2_net14 sky130_fd_pr__res_generic_po R=3856 L=40
+ W=0.5 A=20 P=81
R$43 \$3.x2_x1_net15 \$3.x2_x1_net3 sky130_fd_pr__res_generic_po R=3856 L=40
+ W=0.5 A=20 P=81
R$44 \$3.x2_x1_net15 \$3.x2_x1_net14 sky130_fd_pr__res_generic_po R=3856 L=40
+ W=0.5 A=20 P=81
R$45 \$3.x2_x2_net19 \$3.x2_x2_net18 sky130_fd_pr__res_generic_po R=3856 L=40
+ W=0.5 A=20 P=81
R$46 \$3.x2_x2_net19 \$3.x2_x2_net3 sky130_fd_pr__res_generic_po R=3856 L=40
+ W=0.5 A=20 P=81
R$47 \$3.x2_x1_net19 \$3.x2_x1_net18 sky130_fd_pr__res_generic_po R=3856 L=40
+ W=0.5 A=20 P=81
R$48 \$3.x2_x1_net19 \$3.x2_x1_net3 sky130_fd_pr__res_generic_po R=3856 L=40
+ W=0.5 A=20 P=81
R$49 \$3.x2_x2_net17 \$3.x2_x2_net16 sky130_fd_pr__res_generic_po R=3856 L=40
+ W=0.5 A=20 P=81
R$50 \$3.x2_x2_net17 \$3.x2_x2_net18 sky130_fd_pr__res_generic_po R=3856 L=40
+ W=0.5 A=20 P=81
R$51 \$3.x2_x1_net17 \$3.x2_x1_net16 sky130_fd_pr__res_generic_po R=3856 L=40
+ W=0.5 A=20 P=81
R$52 \$3.x2_x1_net17 \$3.x2_x1_net18 sky130_fd_pr__res_generic_po R=3856 L=40
+ W=0.5 A=20 P=81
M$53 Vss Vss Vss sky130_gnd sky130_fd_pr__nfet_01v8_lvt L=20 W=1 AS=0.29
+ AD=0.29 PS=2.58 PD=2.58
M$54 Vss Vss Vss sky130_gnd sky130_fd_pr__nfet_01v8_lvt L=20 W=1 AS=0.29
+ AD=0.29 PS=2.58 PD=2.58
M$55 \$359 \$121 Vss sky130_gnd sky130_fd_pr__nfet_01v8_lvt L=20 W=1 AS=0.29
+ AD=0.29 PS=2.58 PD=2.58
M$56 \$283 \$121 Vss sky130_gnd sky130_fd_pr__nfet_01v8_lvt L=20 W=1 AS=0.29
+ AD=0.29 PS=2.58 PD=2.58
M$57 \$359 \$121 Vss sky130_gnd sky130_fd_pr__nfet_01v8_lvt L=20 W=1 AS=0.29
+ AD=0.29 PS=2.58 PD=2.58
M$58 \$283 \$121 Vss sky130_gnd sky130_fd_pr__nfet_01v8_lvt L=20 W=1 AS=0.29
+ AD=0.29 PS=2.58 PD=2.58
M$59 \$122 \$122 Vss sky130_gnd sky130_fd_pr__nfet_01v8_lvt L=5 W=0.6 AS=0.174
+ AD=0.174 PS=1.78 PD=1.78
M$60 \$122 \$122 Vss sky130_gnd sky130_fd_pr__nfet_01v8_lvt L=5 W=0.6 AS=0.174
+ AD=0.174 PS=1.78 PD=1.78
M$61 \$434 \$121 Vss sky130_gnd sky130_fd_pr__nfet_01v8_lvt L=10 W=1 AS=0.29
+ AD=0.29 PS=2.58 PD=2.58
M$62 \$434 \$121 Vss sky130_gnd sky130_fd_pr__nfet_01v8_lvt L=10 W=1 AS=0.29
+ AD=0.29 PS=2.58 PD=2.58
M$63 \$342 \$121 Vss sky130_gnd sky130_fd_pr__nfet_01v8_lvt L=10 W=1 AS=0.29
+ AD=0.29 PS=2.58 PD=2.58
M$64 \$406 \$121 Vss sky130_gnd sky130_fd_pr__nfet_01v8_lvt L=10 W=1 AS=0.29
+ AD=0.29 PS=2.58 PD=2.58
M$65 \$341 \$121 Vss sky130_gnd sky130_fd_pr__nfet_01v8_lvt L=10 W=1 AS=0.29
+ AD=0.29 PS=2.58 PD=2.58
M$66 \$341 \$121 Vss sky130_gnd sky130_fd_pr__nfet_01v8_lvt L=10 W=1 AS=0.29
+ AD=0.29 PS=2.58 PD=2.58
M$67 \$406 \$121 Vss sky130_gnd sky130_fd_pr__nfet_01v8_lvt L=10 W=1 AS=0.29
+ AD=0.29 PS=2.58 PD=2.58
M$68 \$342 \$121 Vss sky130_gnd sky130_fd_pr__nfet_01v8_lvt L=10 W=1 AS=0.29
+ AD=0.29 PS=2.58 PD=2.58
M$69 Vss Vss Vss sky130_gnd sky130_fd_pr__nfet_01v8_lvt L=10 W=1 AS=0.29
+ AD=0.29 PS=2.58 PD=2.58
M$70 Vss Vss Vss sky130_gnd sky130_fd_pr__nfet_01v8_lvt L=10 W=1 AS=0.29
+ AD=0.29 PS=2.58 PD=2.58
M$71 \$432 \$432 Vdd Vdd sky130_fd_pr__pfet_01v8_lvt L=10 W=1.5 AS=0.435
+ AD=0.435 PS=3.58 PD=3.58
M$72 \$432 \$432 Vdd Vdd sky130_fd_pr__pfet_01v8_lvt L=10 W=1.5 AS=0.435
+ AD=0.435 PS=3.58 PD=3.58
M$73 Vdd Vdd Vdd Vdd sky130_fd_pr__pfet_01v8_lvt L=5 W=1 AS=0.29 AD=0.145
+ PS=2.58 PD=1.29
M$74 Vdd Vdd Vdd Vdd sky130_fd_pr__pfet_01v8_lvt L=5 W=1 AS=0.145 AD=0.29
+ PS=1.29 PD=2.58
M$75 Vdd Vdd Vdd Vdd sky130_fd_pr__pfet_01v8_lvt L=5 W=1 AS=0.29 AD=0.145
+ PS=2.58 PD=1.29
M$76 Vdd Vdd Vdd Vdd sky130_fd_pr__pfet_01v8_lvt L=5 W=1 AS=0.145 AD=0.29
+ PS=1.29 PD=2.58
M$77 Vdd \$284 \$281 Vdd sky130_fd_pr__pfet_01v8_lvt L=5 W=1 AS=0.29 AD=0.145
+ PS=2.58 PD=1.29
M$78 \$281 \$284 Vdd Vdd sky130_fd_pr__pfet_01v8_lvt L=5 W=1 AS=0.145 AD=0.29
+ PS=1.29 PD=2.58
M$79 Vdd \$284 \$280 Vdd sky130_fd_pr__pfet_01v8_lvt L=5 W=1 AS=0.29 AD=0.145
+ PS=2.58 PD=1.29
M$80 \$280 \$284 Vdd Vdd sky130_fd_pr__pfet_01v8_lvt L=5 W=1 AS=0.145 AD=0.29
+ PS=1.29 PD=2.58
M$81 Vdd \$284 \$281 Vdd sky130_fd_pr__pfet_01v8_lvt L=5 W=1 AS=0.29 AD=0.145
+ PS=2.58 PD=1.29
M$82 \$281 \$284 Vdd Vdd sky130_fd_pr__pfet_01v8_lvt L=5 W=1 AS=0.145 AD=0.29
+ PS=1.29 PD=2.58
M$83 Vdd \$284 \$280 Vdd sky130_fd_pr__pfet_01v8_lvt L=5 W=1 AS=0.29 AD=0.145
+ PS=2.58 PD=1.29
M$84 \$280 \$284 Vdd Vdd sky130_fd_pr__pfet_01v8_lvt L=5 W=1 AS=0.145 AD=0.29
+ PS=1.29 PD=2.58
M$85 Vdd \$284 \$281 Vdd sky130_fd_pr__pfet_01v8_lvt L=5 W=1 AS=0.29 AD=0.145
+ PS=2.58 PD=1.29
M$86 \$281 \$284 Vdd Vdd sky130_fd_pr__pfet_01v8_lvt L=5 W=1 AS=0.145 AD=0.29
+ PS=1.29 PD=2.58
M$87 Vdd \$284 \$280 Vdd sky130_fd_pr__pfet_01v8_lvt L=5 W=1 AS=0.29 AD=0.145
+ PS=2.58 PD=1.29
M$88 \$280 \$284 Vdd Vdd sky130_fd_pr__pfet_01v8_lvt L=5 W=1 AS=0.145 AD=0.29
+ PS=1.29 PD=2.58
M$89 Vdd \$284 \$281 Vdd sky130_fd_pr__pfet_01v8_lvt L=5 W=1 AS=0.29 AD=0.145
+ PS=2.58 PD=1.29
M$90 \$281 \$284 Vdd Vdd sky130_fd_pr__pfet_01v8_lvt L=5 W=1 AS=0.145 AD=0.29
+ PS=1.29 PD=2.58
M$91 Vdd \$284 \$280 Vdd sky130_fd_pr__pfet_01v8_lvt L=5 W=1 AS=0.29 AD=0.145
+ PS=2.58 PD=1.29
M$92 \$280 \$284 Vdd Vdd sky130_fd_pr__pfet_01v8_lvt L=5 W=1 AS=0.145 AD=0.29
+ PS=1.29 PD=2.58
M$93 Vdd Vdd Vdd Vdd sky130_fd_pr__pfet_01v8_lvt L=5 W=1 AS=0.29 AD=0.145
+ PS=2.58 PD=1.29
M$94 Vdd Vdd Vdd Vdd sky130_fd_pr__pfet_01v8_lvt L=5 W=1 AS=0.145 AD=0.29
+ PS=1.29 PD=2.58
M$95 Vdd Vdd Vdd Vdd sky130_fd_pr__pfet_01v8_lvt L=5 W=1 AS=0.29 AD=0.145
+ PS=2.58 PD=1.29
M$96 Vdd Vdd Vdd Vdd sky130_fd_pr__pfet_01v8_lvt L=5 W=1 AS=0.145 AD=0.29
+ PS=1.29 PD=2.58
M$97 \$281 \$432 \$3 Vdd sky130_fd_pr__pfet_01v8_lvt L=5 W=1 AS=0.29 AD=0.145
+ PS=2.58 PD=1.29
M$98 \$3 \$432 \$281 Vdd sky130_fd_pr__pfet_01v8_lvt L=5 W=1 AS=0.145 AD=0.29
+ PS=1.29 PD=2.58
M$99 \$280 \$432 \$200 Vdd sky130_fd_pr__pfet_01v8_lvt L=5 W=1 AS=0.29 AD=0.145
+ PS=2.58 PD=1.29
M$100 \$200 \$432 \$280 Vdd sky130_fd_pr__pfet_01v8_lvt L=5 W=1 AS=0.145
+ AD=0.29 PS=1.29 PD=2.58
M$101 \$281 \$432 \$3 Vdd sky130_fd_pr__pfet_01v8_lvt L=5 W=1 AS=0.29 AD=0.145
+ PS=2.58 PD=1.29
M$102 \$3 \$432 \$281 Vdd sky130_fd_pr__pfet_01v8_lvt L=5 W=1 AS=0.145 AD=0.29
+ PS=1.29 PD=2.58
M$103 \$280 \$432 \$200 Vdd sky130_fd_pr__pfet_01v8_lvt L=5 W=1 AS=0.29
+ AD=0.145 PS=2.58 PD=1.29
M$104 \$200 \$432 \$280 Vdd sky130_fd_pr__pfet_01v8_lvt L=5 W=1 AS=0.145
+ AD=0.29 PS=1.29 PD=2.58
M$105 \$121 \$121 Vss sky130_gnd sky130_fd_pr__nfet_01v8_lvt L=2 W=1 AS=0.29
+ AD=0.29 PS=2.58 PD=2.58
M$106 \$121 \$121 Vss sky130_gnd sky130_fd_pr__nfet_01v8_lvt L=2 W=1 AS=0.29
+ AD=0.29 PS=2.58 PD=2.58
M$107 Vss Vss Vss sky130_gnd sky130_fd_pr__nfet_01v8_lvt L=4 W=4 AS=1.16
+ AD=1.16 PS=8.58 PD=8.58
M$108 Vss Vss Vss sky130_gnd sky130_fd_pr__nfet_01v8_lvt L=4 W=4 AS=1.16
+ AD=1.16 PS=8.58 PD=8.58
M$109 \$281 Vp \$282 sky130_gnd sky130_fd_pr__nfet_01v8_lvt L=4 W=4 AS=1.16
+ AD=1.16 PS=8.58 PD=8.58
M$110 \$280 Vm \$282 sky130_gnd sky130_fd_pr__nfet_01v8_lvt L=4 W=4 AS=1.16
+ AD=1.16 PS=8.58 PD=8.58
M$111 \$281 Vp \$282 sky130_gnd sky130_fd_pr__nfet_01v8_lvt L=4 W=4 AS=1.16
+ AD=1.16 PS=8.58 PD=8.58
M$112 \$280 Vm \$282 sky130_gnd sky130_fd_pr__nfet_01v8_lvt L=4 W=4 AS=1.16
+ AD=1.16 PS=8.58 PD=8.58
M$113 Vss Vss Vss sky130_gnd sky130_fd_pr__nfet_01v8_lvt L=20 W=5 AS=1.45
+ AD=1.45 PS=10.58 PD=10.58
M$114 Vss Vss Vss sky130_gnd sky130_fd_pr__nfet_01v8_lvt L=20 W=5 AS=1.45
+ AD=1.45 PS=10.58 PD=10.58
M$115 \$284 VREF \$359 sky130_gnd sky130_fd_pr__nfet_01v8_lvt L=20 W=5 AS=1.45
+ AD=1.45 PS=10.58 PD=10.58
M$116 \$285 \$200 \$359 sky130_gnd sky130_fd_pr__nfet_01v8_lvt L=20 W=5 AS=1.45
+ AD=1.45 PS=10.58 PD=10.58
M$117 \$284 VREF \$359 sky130_gnd sky130_fd_pr__nfet_01v8_lvt L=20 W=5 AS=1.45
+ AD=1.45 PS=10.58 PD=10.58
M$118 \$285 \$200 \$359 sky130_gnd sky130_fd_pr__nfet_01v8_lvt L=20 W=5 AS=1.45
+ AD=1.45 PS=10.58 PD=10.58
M$119 Vss Vss Vss sky130_gnd sky130_fd_pr__nfet_01v8_lvt L=20 W=5 AS=1.45
+ AD=1.45 PS=10.58 PD=10.58
M$120 Vss Vss Vss sky130_gnd sky130_fd_pr__nfet_01v8_lvt L=20 W=5 AS=1.45
+ AD=1.45 PS=10.58 PD=10.58
M$121 \$284 VREF \$283 sky130_gnd sky130_fd_pr__nfet_01v8_lvt L=20 W=5 AS=1.45
+ AD=1.45 PS=10.58 PD=10.58
M$122 \$285 \$3 \$283 sky130_gnd sky130_fd_pr__nfet_01v8_lvt L=20 W=5 AS=1.45
+ AD=1.45 PS=10.58 PD=10.58
M$123 \$284 VREF \$283 sky130_gnd sky130_fd_pr__nfet_01v8_lvt L=20 W=5 AS=1.45
+ AD=1.45 PS=10.58 PD=10.58
M$124 \$285 \$3 \$283 sky130_gnd sky130_fd_pr__nfet_01v8_lvt L=20 W=5 AS=1.45
+ AD=1.45 PS=10.58 PD=10.58
M$125 Vdd Vdd Vdd Vdd sky130_fd_pr__pfet_01v8_lvt L=10 W=1 AS=0.29 AD=0.29
+ PS=2.58 PD=2.58
M$126 Vdd Vdd Vdd Vdd sky130_fd_pr__pfet_01v8_lvt L=10 W=1 AS=0.29 AD=0.29
+ PS=2.58 PD=2.58
M$127 \$285 \$285 Vdd Vdd sky130_fd_pr__pfet_01v8_lvt L=10 W=1 AS=0.29 AD=0.29
+ PS=2.58 PD=2.58
M$128 \$284 \$285 Vdd Vdd sky130_fd_pr__pfet_01v8_lvt L=10 W=1 AS=0.29 AD=0.29
+ PS=2.58 PD=2.58
M$129 \$285 \$285 Vdd Vdd sky130_fd_pr__pfet_01v8_lvt L=10 W=1 AS=0.29 AD=0.29
+ PS=2.58 PD=2.58
M$130 \$284 \$285 Vdd Vdd sky130_fd_pr__pfet_01v8_lvt L=10 W=1 AS=0.29 AD=0.29
+ PS=2.58 PD=2.58
M$131 Vdd Vdd Vdd Vdd sky130_fd_pr__pfet_01v8_lvt L=10 W=1 AS=0.29 AD=0.29
+ PS=2.58 PD=2.58
M$132 \$166 \$254 \$201 Vdd sky130_fd_pr__pfet_01v8_lvt L=10 W=1 AS=0.29
+ AD=0.29 PS=2.58 PD=2.58
M$133 \$144 VREF \$201 Vdd sky130_fd_pr__pfet_01v8_lvt L=10 W=1 AS=0.29 AD=0.29
+ PS=2.58 PD=2.58
M$134 \$144 VREF \$201 Vdd sky130_fd_pr__pfet_01v8_lvt L=10 W=1 AS=0.29 AD=0.29
+ PS=2.58 PD=2.58
M$135 \$166 \$254 \$201 Vdd sky130_fd_pr__pfet_01v8_lvt L=10 W=1 AS=0.29
+ AD=0.29 PS=2.58 PD=2.58
M$136 Vdd Vdd Vdd Vdd sky130_fd_pr__pfet_01v8_lvt L=10 W=1 AS=0.29 AD=0.29
+ PS=2.58 PD=2.58
M$137 \$201 \$202 Vdd Vdd sky130_fd_pr__pfet_01v8_lvt L=5 W=1 AS=0.29 AD=0.29
+ PS=2.58 PD=2.58
M$138 Vdd Vdd Vdd Vdd sky130_fd_pr__pfet_01v8_lvt L=5 W=1 AS=0.29 AD=0.29
+ PS=2.58 PD=2.58
M$139 \$201 \$202 Vdd Vdd sky130_fd_pr__pfet_01v8_lvt L=5 W=1 AS=0.29 AD=0.29
+ PS=2.58 PD=2.58
M$140 Vdd Vdd Vdd Vdd sky130_fd_pr__pfet_01v8_lvt L=1 W=6 AS=1.74 AD=1.74
+ PS=12.58 PD=12.58
M$141 \$202 \$202 Vdd Vdd sky130_fd_pr__pfet_01v8_lvt L=1 W=6 AS=1.74 AD=1.74
+ PS=12.58 PD=12.58
M$142 \$202 \$202 Vdd Vdd sky130_fd_pr__pfet_01v8_lvt L=1 W=6 AS=1.74 AD=1.74
+ PS=12.58 PD=12.58
M$143 Vdd \$200 Vom Vdd sky130_fd_pr__pfet_01v8_lvt L=1 W=1 AS=0.29 AD=0.145
+ PS=2.58 PD=1.29
M$144 Vom \$200 Vdd Vdd sky130_fd_pr__pfet_01v8_lvt L=1 W=1 AS=0.145 AD=0.29
+ PS=1.29 PD=2.58
M$145 Vdd \$200 Vom Vdd sky130_fd_pr__pfet_01v8_lvt L=1 W=1 AS=0.29 AD=0.145
+ PS=2.58 PD=1.29
M$146 Vom \$200 Vdd Vdd sky130_fd_pr__pfet_01v8_lvt L=1 W=1 AS=0.145 AD=0.29
+ PS=1.29 PD=2.58
M$147 Vdd \$200 Vom Vdd sky130_fd_pr__pfet_01v8_lvt L=1 W=1 AS=0.29 AD=0.145
+ PS=2.58 PD=1.29
M$148 Vom \$200 Vdd Vdd sky130_fd_pr__pfet_01v8_lvt L=1 W=1 AS=0.145 AD=0.29
+ PS=1.29 PD=2.58
M$149 Vdd \$200 Vom Vdd sky130_fd_pr__pfet_01v8_lvt L=1 W=1 AS=0.29 AD=0.145
+ PS=2.58 PD=1.29
M$150 Vom \$200 Vdd Vdd sky130_fd_pr__pfet_01v8_lvt L=1 W=1 AS=0.145 AD=0.29
+ PS=1.29 PD=2.58
M$151 Vdd \$200 Vom Vdd sky130_fd_pr__pfet_01v8_lvt L=1 W=1 AS=0.29 AD=0.145
+ PS=2.58 PD=1.29
M$152 Vom \$200 Vdd Vdd sky130_fd_pr__pfet_01v8_lvt L=1 W=1 AS=0.145 AD=0.29
+ PS=1.29 PD=2.58
M$153 Vdd \$200 Vom Vdd sky130_fd_pr__pfet_01v8_lvt L=1 W=1 AS=0.29 AD=0.145
+ PS=2.58 PD=1.29
M$154 Vom \$200 Vdd Vdd sky130_fd_pr__pfet_01v8_lvt L=1 W=1 AS=0.145 AD=0.29
+ PS=1.29 PD=2.58
M$155 Vdd \$200 Vom Vdd sky130_fd_pr__pfet_01v8_lvt L=1 W=1 AS=0.29 AD=0.145
+ PS=2.58 PD=1.29
M$156 Vom \$200 Vdd Vdd sky130_fd_pr__pfet_01v8_lvt L=1 W=1 AS=0.145 AD=0.29
+ PS=1.29 PD=2.58
M$157 Vdd \$200 Vom Vdd sky130_fd_pr__pfet_01v8_lvt L=1 W=1 AS=0.29 AD=0.145
+ PS=2.58 PD=1.29
M$158 Vom \$200 Vdd Vdd sky130_fd_pr__pfet_01v8_lvt L=1 W=1 AS=0.145 AD=0.29
+ PS=1.29 PD=2.58
M$159 Vdd \$200 Vom Vdd sky130_fd_pr__pfet_01v8_lvt L=1 W=1 AS=0.29 AD=0.145
+ PS=2.58 PD=1.29
M$160 Vom \$200 Vdd Vdd sky130_fd_pr__pfet_01v8_lvt L=1 W=1 AS=0.145 AD=0.29
+ PS=1.29 PD=2.58
M$161 Vdd \$3 Vop Vdd sky130_fd_pr__pfet_01v8_lvt L=1 W=1 AS=0.29 AD=0.145
+ PS=2.58 PD=1.29
M$162 Vop \$3 Vdd Vdd sky130_fd_pr__pfet_01v8_lvt L=1 W=1 AS=0.145 AD=0.29
+ PS=1.29 PD=2.58
M$163 Vdd \$3 Vop Vdd sky130_fd_pr__pfet_01v8_lvt L=1 W=1 AS=0.29 AD=0.145
+ PS=2.58 PD=1.29
M$164 Vop \$3 Vdd Vdd sky130_fd_pr__pfet_01v8_lvt L=1 W=1 AS=0.145 AD=0.29
+ PS=1.29 PD=2.58
M$165 Vdd \$3 Vop Vdd sky130_fd_pr__pfet_01v8_lvt L=1 W=1 AS=0.29 AD=0.145
+ PS=2.58 PD=1.29
M$166 Vop \$3 Vdd Vdd sky130_fd_pr__pfet_01v8_lvt L=1 W=1 AS=0.145 AD=0.29
+ PS=1.29 PD=2.58
M$167 Vdd \$3 Vop Vdd sky130_fd_pr__pfet_01v8_lvt L=1 W=1 AS=0.29 AD=0.145
+ PS=2.58 PD=1.29
M$168 Vop \$3 Vdd Vdd sky130_fd_pr__pfet_01v8_lvt L=1 W=1 AS=0.145 AD=0.29
+ PS=1.29 PD=2.58
M$169 Vdd \$3 Vop Vdd sky130_fd_pr__pfet_01v8_lvt L=1 W=1 AS=0.29 AD=0.145
+ PS=2.58 PD=1.29
M$170 Vop \$3 Vdd Vdd sky130_fd_pr__pfet_01v8_lvt L=1 W=1 AS=0.145 AD=0.29
+ PS=1.29 PD=2.58
M$171 Vdd \$3 Vop Vdd sky130_fd_pr__pfet_01v8_lvt L=1 W=1 AS=0.29 AD=0.145
+ PS=2.58 PD=1.29
M$172 Vop \$3 Vdd Vdd sky130_fd_pr__pfet_01v8_lvt L=1 W=1 AS=0.145 AD=0.29
+ PS=1.29 PD=2.58
M$173 Vdd \$3 Vop Vdd sky130_fd_pr__pfet_01v8_lvt L=1 W=1 AS=0.29 AD=0.145
+ PS=2.58 PD=1.29
M$174 Vop \$3 Vdd Vdd sky130_fd_pr__pfet_01v8_lvt L=1 W=1 AS=0.145 AD=0.29
+ PS=1.29 PD=2.58
M$175 Vdd \$3 Vop Vdd sky130_fd_pr__pfet_01v8_lvt L=1 W=1 AS=0.29 AD=0.145
+ PS=2.58 PD=1.29
M$176 Vop \$3 Vdd Vdd sky130_fd_pr__pfet_01v8_lvt L=1 W=1 AS=0.145 AD=0.29
+ PS=1.29 PD=2.58
M$177 Vdd \$3 Vop Vdd sky130_fd_pr__pfet_01v8_lvt L=1 W=1 AS=0.29 AD=0.145
+ PS=2.58 PD=1.29
M$178 Vop \$3 Vdd Vdd sky130_fd_pr__pfet_01v8_lvt L=1 W=1 AS=0.145 AD=0.29
+ PS=1.29 PD=2.58
M$179 Vss Vss Vss sky130_gnd sky130_fd_pr__nfet_01v8_lvt L=20 W=0.5 AS=0.145
+ AD=0.145 PS=1.58 PD=1.58
M$180 Vss Vss Vss sky130_gnd sky130_fd_pr__nfet_01v8_lvt L=20 W=0.5 AS=0.145
+ AD=0.145 PS=1.58 PD=1.58
M$181 \$144 \$166 Vss sky130_gnd sky130_fd_pr__nfet_01v8_lvt L=20 W=0.5
+ AS=0.145 AD=0.145 PS=1.58 PD=1.58
M$182 \$166 \$166 Vss sky130_gnd sky130_fd_pr__nfet_01v8_lvt L=20 W=0.5
+ AS=0.145 AD=0.145 PS=1.58 PD=1.58
M$183 \$144 \$166 Vss sky130_gnd sky130_fd_pr__nfet_01v8_lvt L=20 W=0.5
+ AS=0.145 AD=0.145 PS=1.58 PD=1.58
M$184 \$166 \$166 Vss sky130_gnd sky130_fd_pr__nfet_01v8_lvt L=20 W=0.5
+ AS=0.145 AD=0.145 PS=1.58 PD=1.58
M$185 \$282 \$122 \$434 sky130_gnd sky130_fd_pr__nfet_01v8_lvt L=1 W=1 AS=0.29
+ AD=0.29 PS=2.58 PD=2.58
M$186 \$282 \$122 \$434 sky130_gnd sky130_fd_pr__nfet_01v8_lvt L=1 W=1 AS=0.29
+ AD=0.29 PS=2.58 PD=2.58
M$187 \$200 \$122 \$406 sky130_gnd sky130_fd_pr__nfet_01v8_lvt L=1 W=1 AS=0.29
+ AD=0.29 PS=2.58 PD=2.58
M$188 \$200 \$122 \$406 sky130_gnd sky130_fd_pr__nfet_01v8_lvt L=1 W=1 AS=0.29
+ AD=0.29 PS=2.58 PD=2.58
M$189 Vss Vss Vss sky130_gnd sky130_fd_pr__nfet_01v8_lvt L=1 W=1 AS=0.29
+ AD=0.29 PS=2.58 PD=2.58
M$190 Vss Vss Vss sky130_gnd sky130_fd_pr__nfet_01v8_lvt L=1 W=1 AS=0.29
+ AD=0.29 PS=2.58 PD=2.58
M$191 \$3 \$122 \$341 sky130_gnd sky130_fd_pr__nfet_01v8_lvt L=1 W=1 AS=0.29
+ AD=0.29 PS=2.58 PD=2.58
M$192 \$3 \$122 \$341 sky130_gnd sky130_fd_pr__nfet_01v8_lvt L=1 W=1 AS=0.29
+ AD=0.29 PS=2.58 PD=2.58
M$193 \$282 \$122 \$342 sky130_gnd sky130_fd_pr__nfet_01v8_lvt L=1 W=1 AS=0.29
+ AD=0.29 PS=2.58 PD=2.58
M$194 \$282 \$122 \$342 sky130_gnd sky130_fd_pr__nfet_01v8_lvt L=1 W=1 AS=0.29
+ AD=0.29 PS=2.58 PD=2.58
M$195 Vss Vss Vss sky130_gnd sky130_fd_pr__nfet_01v8_lvt L=1 W=1 AS=0.29
+ AD=0.29 PS=2.58 PD=2.58
M$196 Vss Vss Vss sky130_gnd sky130_fd_pr__nfet_01v8_lvt L=1 W=1 AS=0.29
+ AD=0.29 PS=2.58 PD=2.58
M$197 Vss Vss Vss sky130_gnd sky130_fd_pr__nfet_01v8_lvt L=1 W=1 AS=0.29
+ AD=0.29 PS=2.58 PD=2.58
M$198 Vom \$144 Vss sky130_gnd sky130_fd_pr__nfet_01v8_lvt L=1 W=1 AS=0.29
+ AD=0.29 PS=2.58 PD=2.58
M$199 Vop \$144 Vss sky130_gnd sky130_fd_pr__nfet_01v8_lvt L=1 W=1 AS=0.29
+ AD=0.29 PS=2.58 PD=2.58
M$200 Vom \$144 Vss sky130_gnd sky130_fd_pr__nfet_01v8_lvt L=1 W=1 AS=0.29
+ AD=0.29 PS=2.58 PD=2.58
M$201 Vop \$144 Vss sky130_gnd sky130_fd_pr__nfet_01v8_lvt L=1 W=1 AS=0.29
+ AD=0.29 PS=2.58 PD=2.58
M$202 Vom \$144 Vss sky130_gnd sky130_fd_pr__nfet_01v8_lvt L=1 W=1 AS=0.29
+ AD=0.29 PS=2.58 PD=2.58
M$203 Vop \$144 Vss sky130_gnd sky130_fd_pr__nfet_01v8_lvt L=1 W=1 AS=0.29
+ AD=0.29 PS=2.58 PD=2.58
M$204 Vom \$144 Vss sky130_gnd sky130_fd_pr__nfet_01v8_lvt L=1 W=1 AS=0.29
+ AD=0.29 PS=2.58 PD=2.58
M$205 Vop \$144 Vss sky130_gnd sky130_fd_pr__nfet_01v8_lvt L=1 W=1 AS=0.29
+ AD=0.29 PS=2.58 PD=2.58
M$206 Vom \$144 Vss sky130_gnd sky130_fd_pr__nfet_01v8_lvt L=1 W=1 AS=0.29
+ AD=0.29 PS=2.58 PD=2.58
M$207 Vss Vss Vss sky130_gnd sky130_fd_pr__nfet_01v8_lvt L=1 W=1 AS=0.29
+ AD=0.29 PS=2.58 PD=2.58
M$208 Vop \$144 Vss sky130_gnd sky130_fd_pr__nfet_01v8_lvt L=1 W=1 AS=0.29
+ AD=0.29 PS=2.58 PD=2.58
M$209 Vom \$144 Vss sky130_gnd sky130_fd_pr__nfet_01v8_lvt L=1 W=1 AS=0.29
+ AD=0.29 PS=2.58 PD=2.58
M$210 Vop \$144 Vss sky130_gnd sky130_fd_pr__nfet_01v8_lvt L=1 W=1 AS=0.29
+ AD=0.29 PS=2.58 PD=2.58
M$211 Vom \$144 Vss sky130_gnd sky130_fd_pr__nfet_01v8_lvt L=1 W=1 AS=0.29
+ AD=0.29 PS=2.58 PD=2.58
M$212 Vop \$144 Vss sky130_gnd sky130_fd_pr__nfet_01v8_lvt L=1 W=1 AS=0.29
+ AD=0.29 PS=2.58 PD=2.58
M$213 Vom \$144 Vss sky130_gnd sky130_fd_pr__nfet_01v8_lvt L=1 W=1 AS=0.29
+ AD=0.29 PS=2.58 PD=2.58
M$214 Vop \$144 Vss sky130_gnd sky130_fd_pr__nfet_01v8_lvt L=1 W=1 AS=0.29
+ AD=0.29 PS=2.58 PD=2.58
M$215 Vom \$144 Vss sky130_gnd sky130_fd_pr__nfet_01v8_lvt L=1 W=1 AS=0.29
+ AD=0.29 PS=2.58 PD=2.58
M$216 Vop \$144 Vss sky130_gnd sky130_fd_pr__nfet_01v8_lvt L=1 W=1 AS=0.29
+ AD=0.29 PS=2.58 PD=2.58
M$217 Vss Vss Vss sky130_gnd sky130_fd_pr__nfet_01v8_lvt L=1 W=0.6 AS=0.174
+ AD=0.174 PS=1.78 PD=1.78
M$218 Vss Vss Vss sky130_gnd sky130_fd_pr__nfet_01v8_lvt L=1 W=0.6 AS=0.174
+ AD=0.174 PS=1.78 PD=1.78
M$219 \$432 \$405 Vss sky130_gnd sky130_fd_pr__nfet_01v8_lvt L=1 W=0.6 AS=0.174
+ AD=0.174 PS=1.78 PD=1.78
M$220 \$405 \$405 Vss sky130_gnd sky130_fd_pr__nfet_01v8_lvt L=1 W=0.6 AS=0.174
+ AD=0.174 PS=1.78 PD=1.78
M$221 \$405 \$405 Vss sky130_gnd sky130_fd_pr__nfet_01v8_lvt L=1 W=0.6 AS=0.174
+ AD=0.174 PS=1.78 PD=1.78
M$222 \$432 \$405 Vss sky130_gnd sky130_fd_pr__nfet_01v8_lvt L=1 W=0.6 AS=0.174
+ AD=0.174 PS=1.78 PD=1.78
M$223 Vss Vss Vss sky130_gnd sky130_fd_pr__nfet_01v8_lvt L=1 W=0.6 AS=0.174
+ AD=0.174 PS=1.78 PD=1.78
M$224 Vss Vss Vss sky130_gnd sky130_fd_pr__nfet_01v8_lvt L=1 W=0.6 AS=0.174
+ AD=0.174 PS=1.78 PD=1.78
M$225 \$202 \$120 Vss sky130_gnd sky130_fd_pr__nfet_01v8_lvt L=1 W=0.6 AS=0.174
+ AD=0.174 PS=1.78 PD=1.78
M$226 \$120 \$120 Vss sky130_gnd sky130_fd_pr__nfet_01v8_lvt L=1 W=0.6 AS=0.174
+ AD=0.174 PS=1.78 PD=1.78
M$227 \$202 \$120 Vss sky130_gnd sky130_fd_pr__nfet_01v8_lvt L=1 W=0.6 AS=0.174
+ AD=0.174 PS=1.78 PD=1.78
M$228 \$120 \$120 Vss sky130_gnd sky130_fd_pr__nfet_01v8_lvt L=1 W=0.6 AS=0.174
+ AD=0.174 PS=1.78 PD=1.78
M$229 \$27 \$27 RGM sky130_gnd sky130_fd_pr__nfet_01v8_lvt L=1 W=10 AS=2.9
+ AD=2.9 PS=20.58 PD=20.58
M$230 \$27 \$27 RGM sky130_gnd sky130_fd_pr__nfet_01v8_lvt L=1 W=10 AS=2.9
+ AD=2.9 PS=20.58 PD=20.58
M$231 \$7 \$57 \$59 sky130_gnd sky130_fd_pr__nfet_01v8_lvt L=1 W=2 AS=0.58
+ AD=0.58 PS=4.58 PD=4.58
M$232 Vdd Vdd Vdd Vdd sky130_fd_pr__pfet_01v8_lvt L=1 W=5 AS=1.45 AD=1.45
+ PS=10.58 PD=10.58
M$233 Vdd Vdd Vdd Vdd sky130_fd_pr__pfet_01v8_lvt L=1 W=5 AS=1.45 AD=1.45
+ PS=10.58 PD=10.58
M$234 \$405 \$7 Vdd Vdd sky130_fd_pr__pfet_01v8_lvt L=1 W=5 AS=1.45 AD=1.45
+ PS=10.58 PD=10.58
M$235 \$120 \$7 Vdd Vdd sky130_fd_pr__pfet_01v8_lvt L=1 W=5 AS=1.45 AD=1.45
+ PS=10.58 PD=10.58
M$236 \$405 \$7 Vdd Vdd sky130_fd_pr__pfet_01v8_lvt L=1 W=5 AS=1.45 AD=1.45
+ PS=10.58 PD=10.58
M$237 \$120 \$7 Vdd Vdd sky130_fd_pr__pfet_01v8_lvt L=1 W=5 AS=1.45 AD=1.45
+ PS=10.58 PD=10.58
M$238 Vdd Vdd Vdd Vdd sky130_fd_pr__pfet_01v8_lvt L=1 W=5 AS=1.45 AD=1.45
+ PS=10.58 PD=10.58
M$239 \$121 \$7 Vdd Vdd sky130_fd_pr__pfet_01v8_lvt L=1 W=5 AS=1.45 AD=1.45
+ PS=10.58 PD=10.58
M$240 \$122 \$7 Vdd Vdd sky130_fd_pr__pfet_01v8_lvt L=1 W=5 AS=1.45 AD=1.45
+ PS=10.58 PD=10.58
M$241 \$121 \$7 Vdd Vdd sky130_fd_pr__pfet_01v8_lvt L=1 W=5 AS=1.45 AD=1.45
+ PS=10.58 PD=10.58
M$242 \$122 \$7 Vdd Vdd sky130_fd_pr__pfet_01v8_lvt L=1 W=5 AS=1.45 AD=1.45
+ PS=10.58 PD=10.58
M$243 Vdd Vdd Vdd Vdd sky130_fd_pr__pfet_01v8_lvt L=1 W=5 AS=1.45 AD=1.45
+ PS=10.58 PD=10.58
M$244 Vdd Vdd Vdd Vdd sky130_fd_pr__pfet_01v8_lvt L=1 W=5 AS=1.45 AD=1.45
+ PS=10.58 PD=10.58
M$245 \$59 \$7 Vdd Vdd sky130_fd_pr__pfet_01v8_lvt L=1 W=5 AS=1.45 AD=1.45
+ PS=10.58 PD=10.58
M$246 \$27 \$7 Vdd Vdd sky130_fd_pr__pfet_01v8_lvt L=1 W=5 AS=1.45 AD=1.45
+ PS=10.58 PD=10.58
M$247 \$27 \$7 Vdd Vdd sky130_fd_pr__pfet_01v8_lvt L=1 W=5 AS=1.45 AD=1.45
+ PS=10.58 PD=10.58
M$248 \$59 \$7 Vdd Vdd sky130_fd_pr__pfet_01v8_lvt L=1 W=5 AS=1.45 AD=1.45
+ PS=10.58 PD=10.58
M$249 Vdd Vdd Vdd Vdd sky130_fd_pr__pfet_01v8_lvt L=1 W=5 AS=1.45 AD=1.45
+ PS=10.58 PD=10.58
M$250 Vdd Vdd Vdd Vdd sky130_fd_pr__pfet_01v8_lvt L=1 W=5 AS=1.45 AD=1.45
+ PS=10.58 PD=10.58
M$251 \$33 \$33 Vdd Vdd sky130_fd_pr__pfet_01v8_lvt L=1 W=5 AS=1.45 AD=1.45
+ PS=10.58 PD=10.58
M$252 \$7 \$33 Vdd Vdd sky130_fd_pr__pfet_01v8_lvt L=1 W=5 AS=1.45 AD=1.45
+ PS=10.58 PD=10.58
M$253 \$33 \$33 Vdd Vdd sky130_fd_pr__pfet_01v8_lvt L=1 W=5 AS=1.45 AD=1.45
+ PS=10.58 PD=10.58
M$254 \$7 \$33 Vdd Vdd sky130_fd_pr__pfet_01v8_lvt L=1 W=5 AS=1.45 AD=1.45
+ PS=10.58 PD=10.58
M$255 Vdd Vdd Vdd Vdd sky130_fd_pr__pfet_01v8_lvt L=1 W=5 AS=1.45 AD=1.45
+ PS=10.58 PD=10.58
M$256 \$57 \$57 Vdd Vdd sky130_fd_pr__pfet_01v8_lvt L=20 W=1 AS=0.29 AD=0.29
+ PS=2.58 PD=2.58
M$257 \$57 \$57 Vdd Vdd sky130_fd_pr__pfet_01v8_lvt L=20 W=1 AS=0.29 AD=0.29
+ PS=2.58 PD=2.58
M$258 \$33 \$27 Vss sky130_gnd sky130_fd_pr__nfet_01v8_lvt L=2 W=5 AS=1.45
+ AD=1.45 PS=10.58 PD=10.58
M$259 \$33 \$27 Vss sky130_gnd sky130_fd_pr__nfet_01v8_lvt L=2 W=5 AS=1.45
+ AD=1.45 PS=10.58 PD=10.58
M$260 \$7 \$59 Vss sky130_gnd sky130_fd_pr__nfet_01v8_lvt L=2 W=5 AS=1.45
+ AD=1.45 PS=10.58 PD=10.58
M$261 \$7 \$59 Vss sky130_gnd sky130_fd_pr__nfet_01v8_lvt L=2 W=5 AS=1.45
+ AD=1.45 PS=10.58 PD=10.58
M$262 Vss Vss Vss sky130_gnd sky130_fd_pr__nfet_01v8_lvt L=2 W=5 AS=1.45
+ AD=1.45 PS=10.58 PD=10.58
M$263 Vss Vss Vss sky130_gnd sky130_fd_pr__nfet_01v8_lvt L=2 W=5 AS=1.45
+ AD=1.45 PS=10.58 PD=10.58
M$264 \$59 \$59 Vss sky130_gnd sky130_fd_pr__nfet_01v8_lvt L=2 W=5 AS=1.45
+ AD=1.45 PS=10.58 PD=10.58
M$265 \$57 \$59 Vss sky130_gnd sky130_fd_pr__nfet_01v8_lvt L=2 W=5 AS=1.45
+ AD=1.45 PS=10.58 PD=10.58
M$266 \$59 \$59 Vss sky130_gnd sky130_fd_pr__nfet_01v8_lvt L=2 W=5 AS=1.45
+ AD=1.45 PS=10.58 PD=10.58
M$267 \$57 \$59 Vss sky130_gnd sky130_fd_pr__nfet_01v8_lvt L=2 W=5 AS=1.45
+ AD=1.45 PS=10.58 PD=10.58
.ENDS ttsky25a_fd_routed
