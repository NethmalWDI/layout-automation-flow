* Extracted by KLayout with SKY130 LVS runset on : 04/11/2026 13:29

.SUBCKT ttsky25a_fd_routed \$3.x2_x1_net1 \$3.x2_x1_net10 \$3.x2_x1_net11
+ \$3.x2_x1_net12 \$3.x2_x1_net13 \$3.x2_x1_net14 \$3.x2_x1_net15
+ \$3.x2_x1_net16 \$3.x2_x1_net17 \$3.x2_x1_net18 \$3.x2_x1_net19
+ \$3.x2_x1_net2 \$3.x2_x1_net3 \$3.x2_x1_net4 \$3.x2_x1_net5 \$3.x2_x1_net6
+ \$3.x2_x1_net7 \$3.x2_x1_net8 \$3.x2_x1_net9 \$3.x2_x2_net1 \$3.x2_x2_net10
+ \$3.x2_x2_net11 \$3.x2_x2_net12 \$3.x2_x2_net13 \$3.x2_x2_net14
+ \$3.x2_x2_net15 \$3.x2_x2_net16 \$3.x2_x2_net17 \$3.x2_x2_net18
+ \$3.x2_x2_net19 \$3.x2_x2_net2 \$3.x2_x2_net3 \$3.x2_x2_net4 \$3.x2_x2_net5
+ \$3.x2_x2_net6 \$3.x2_x2_net7 \$3.x2_x2_net8 \$3.x2_x2_net9 RGM VREF Vdd Vm
+ Vom Vop Vp Vss sky130_gnd
C$1 Vom \$67 sky130_fd_pr__model__cap_mim C=2e-13 A=100 P=40
C$2 Vom \$67 sky130_fd_pr__model__cap_mim C=2e-13 A=100 P=40
C$3 Vom \$67 sky130_fd_pr__model__cap_mim C=2e-13 A=100 P=40
C$4 Vom \$67 sky130_fd_pr__model__cap_mim C=2e-13 A=100 P=40
C$5 Vom \$67 sky130_fd_pr__model__cap_mim C=2e-13 A=100 P=40
C$6 Vop \$3 sky130_fd_pr__model__cap_mim C=2e-13 A=100 P=40
C$7 Vop \$3 sky130_fd_pr__model__cap_mim C=2e-13 A=100 P=40
C$8 Vop \$3 sky130_fd_pr__model__cap_mim C=2e-13 A=100 P=40
C$9 Vop \$3 sky130_fd_pr__model__cap_mim C=2e-13 A=100 P=40
C$10 Vop \$3 sky130_fd_pr__model__cap_mim C=2e-13 A=100 P=40
R$11 Vom \$3.x2_x2_net16 sky130_fd_pr__res_generic_po R=3856 L=40 W=0.5 A=20
+ P=81
R$12 \$206 \$3.x2_x2_net4 sky130_fd_pr__res_generic_po R=3856 L=40 W=0.5 A=20
+ P=81
R$13 \$206 \$3.x2_x1_net16 sky130_fd_pr__res_generic_po R=3856 L=40 W=0.5 A=20
+ P=81
R$14 Vop \$3.x2_x1_net4 sky130_fd_pr__res_generic_po R=3856 L=40 W=0.5 A=20 P=81
R$15 Vss Vss sky130_fd_pr__res_generic_po R=3856 L=40 W=0.5 A=20 P=81
R$16 Vss Vss sky130_fd_pr__res_generic_po R=3856 L=40 W=0.5 A=20 P=81
R$17 \$3.x2_x2_net5 \$3.x2_x2_net6 sky130_fd_pr__res_generic_po R=3856 L=40
+ W=0.5 A=20 P=81
R$18 \$3.x2_x2_net5 \$3.x2_x2_net4 sky130_fd_pr__res_generic_po R=3856 L=40
+ W=0.5 A=20 P=81
R$19 \$3.x2_x1_net5 \$3.x2_x1_net6 sky130_fd_pr__res_generic_po R=3856 L=40
+ W=0.5 A=20 P=81
R$20 \$3.x2_x1_net5 \$3.x2_x1_net4 sky130_fd_pr__res_generic_po R=3856 L=40
+ W=0.5 A=20 P=81
R$21 \$3.x2_x2_net7 \$3.x2_x2_net1 sky130_fd_pr__res_generic_po R=3856 L=40
+ W=0.5 A=20 P=81
R$22 \$3.x2_x2_net7 \$3.x2_x2_net6 sky130_fd_pr__res_generic_po R=3856 L=40
+ W=0.5 A=20 P=81
R$23 \$3.x2_x1_net7 \$3.x2_x1_net1 sky130_fd_pr__res_generic_po R=3856 L=40
+ W=0.5 A=20 P=81
R$24 \$3.x2_x1_net7 \$3.x2_x1_net6 sky130_fd_pr__res_generic_po R=3856 L=40
+ W=0.5 A=20 P=81
R$25 \$3.x2_x2_net11 \$3.x2_x2_net10 sky130_fd_pr__res_generic_po R=3856 L=40
+ W=0.5 A=20 P=81
R$26 \$3.x2_x2_net11 \$3.x2_x2_net1 sky130_fd_pr__res_generic_po R=3856 L=40
+ W=0.5 A=20 P=81
R$27 \$3.x2_x1_net11 \$3.x2_x1_net10 sky130_fd_pr__res_generic_po R=3856 L=40
+ W=0.5 A=20 P=81
R$28 \$3.x2_x1_net11 \$3.x2_x1_net1 sky130_fd_pr__res_generic_po R=3856 L=40
+ W=0.5 A=20 P=81
R$29 \$3.x2_x2_net9 \$3.x2_x2_net8 sky130_fd_pr__res_generic_po R=3856 L=40
+ W=0.5 A=20 P=81
R$30 \$3.x2_x2_net9 \$3.x2_x2_net10 sky130_fd_pr__res_generic_po R=3856 L=40
+ W=0.5 A=20 P=81
R$31 \$3.x2_x1_net9 \$3.x2_x1_net8 sky130_fd_pr__res_generic_po R=3856 L=40
+ W=0.5 A=20 P=81
R$32 \$3.x2_x1_net9 \$3.x2_x1_net10 sky130_fd_pr__res_generic_po R=3856 L=40
+ W=0.5 A=20 P=81
R$33 \$3.x2_x2_net2 \$3.x2_x2_net8 sky130_fd_pr__res_generic_po R=3856 L=40
+ W=0.5 A=20 P=81
R$34 \$3.x2_x2_net2 \$3.x2_x2_net12 sky130_fd_pr__res_generic_po R=3856 L=40
+ W=0.5 A=20 P=81
R$35 \$3.x2_x1_net2 \$3.x2_x1_net8 sky130_fd_pr__res_generic_po R=3856 L=40
+ W=0.5 A=20 P=81
R$36 \$3.x2_x1_net2 \$3.x2_x1_net12 sky130_fd_pr__res_generic_po R=3856 L=40
+ W=0.5 A=20 P=81
R$37 \$3.x2_x2_net13 \$3.x2_x2_net14 sky130_fd_pr__res_generic_po R=3856 L=40
+ W=0.5 A=20 P=81
R$38 \$3.x2_x2_net13 \$3.x2_x2_net12 sky130_fd_pr__res_generic_po R=3856 L=40
+ W=0.5 A=20 P=81
R$39 \$3.x2_x1_net13 \$3.x2_x1_net14 sky130_fd_pr__res_generic_po R=3856 L=40
+ W=0.5 A=20 P=81
R$40 \$3.x2_x1_net13 \$3.x2_x1_net12 sky130_fd_pr__res_generic_po R=3856 L=40
+ W=0.5 A=20 P=81
R$41 \$3.x2_x2_net15 \$3.x2_x2_net3 sky130_fd_pr__res_generic_po R=3856 L=40
+ W=0.5 A=20 P=81
R$42 \$3.x2_x2_net15 \$3.x2_x2_net14 sky130_fd_pr__res_generic_po R=3856 L=40
+ W=0.5 A=20 P=81
R$43 \$3.x2_x1_net15 \$3.x2_x1_net3 sky130_fd_pr__res_generic_po R=3856 L=40
+ W=0.5 A=20 P=81
R$44 \$3.x2_x1_net15 \$3.x2_x1_net14 sky130_fd_pr__res_generic_po R=3856 L=40
+ W=0.5 A=20 P=81
R$45 \$3.x2_x2_net19 \$3.x2_x2_net18 sky130_fd_pr__res_generic_po R=3856 L=40
+ W=0.5 A=20 P=81
R$46 \$3.x2_x2_net19 \$3.x2_x2_net3 sky130_fd_pr__res_generic_po R=3856 L=40
+ W=0.5 A=20 P=81
R$47 \$3.x2_x1_net19 \$3.x2_x1_net18 sky130_fd_pr__res_generic_po R=3856 L=40
+ W=0.5 A=20 P=81
R$48 \$3.x2_x1_net19 \$3.x2_x1_net3 sky130_fd_pr__res_generic_po R=3856 L=40
+ W=0.5 A=20 P=81
R$49 \$3.x2_x2_net17 \$3.x2_x2_net16 sky130_fd_pr__res_generic_po R=3856 L=40
+ W=0.5 A=20 P=81
R$50 \$3.x2_x2_net17 \$3.x2_x2_net18 sky130_fd_pr__res_generic_po R=3856 L=40
+ W=0.5 A=20 P=81
R$51 \$3.x2_x1_net17 \$3.x2_x1_net16 sky130_fd_pr__res_generic_po R=3856 L=40
+ W=0.5 A=20 P=81
R$52 \$3.x2_x1_net17 \$3.x2_x1_net18 sky130_fd_pr__res_generic_po R=3856 L=40
+ W=0.5 A=20 P=81
M$53 \$416 \$416 Vdd Vdd sky130_fd_pr__pfet_01v8_lvt L=10 W=1.5 AS=0.435
+ AD=0.435 PS=3.58 PD=3.58
M$54 \$416 \$416 Vdd Vdd sky130_fd_pr__pfet_01v8_lvt L=10 W=1.5 AS=0.435
+ AD=0.435 PS=3.58 PD=3.58
M$55 Vdd Vdd Vdd Vdd sky130_fd_pr__pfet_01v8_lvt L=5 W=1 AS=0.29 AD=0.145
+ PS=2.58 PD=1.29
M$56 Vdd Vdd Vdd Vdd sky130_fd_pr__pfet_01v8_lvt L=5 W=1 AS=0.145 AD=0.29
+ PS=1.29 PD=2.58
M$57 Vdd Vdd Vdd Vdd sky130_fd_pr__pfet_01v8_lvt L=5 W=1 AS=0.29 AD=0.145
+ PS=2.58 PD=1.29
M$58 Vdd Vdd Vdd Vdd sky130_fd_pr__pfet_01v8_lvt L=5 W=1 AS=0.145 AD=0.29
+ PS=1.29 PD=2.58
M$59 Vdd \$279 \$276 Vdd sky130_fd_pr__pfet_01v8_lvt L=5 W=1 AS=0.29 AD=0.145
+ PS=2.58 PD=1.29
M$60 \$276 \$279 Vdd Vdd sky130_fd_pr__pfet_01v8_lvt L=5 W=1 AS=0.145 AD=0.29
+ PS=1.29 PD=2.58
M$61 Vdd \$279 \$286 Vdd sky130_fd_pr__pfet_01v8_lvt L=5 W=1 AS=0.29 AD=0.145
+ PS=2.58 PD=1.29
M$62 \$286 \$279 Vdd Vdd sky130_fd_pr__pfet_01v8_lvt L=5 W=1 AS=0.145 AD=0.29
+ PS=1.29 PD=2.58
M$63 Vdd \$279 \$276 Vdd sky130_fd_pr__pfet_01v8_lvt L=5 W=1 AS=0.29 AD=0.145
+ PS=2.58 PD=1.29
M$64 \$276 \$279 Vdd Vdd sky130_fd_pr__pfet_01v8_lvt L=5 W=1 AS=0.145 AD=0.29
+ PS=1.29 PD=2.58
M$65 Vdd \$279 \$286 Vdd sky130_fd_pr__pfet_01v8_lvt L=5 W=1 AS=0.29 AD=0.145
+ PS=2.58 PD=1.29
M$66 \$286 \$279 Vdd Vdd sky130_fd_pr__pfet_01v8_lvt L=5 W=1 AS=0.145 AD=0.29
+ PS=1.29 PD=2.58
M$67 Vdd \$279 \$276 Vdd sky130_fd_pr__pfet_01v8_lvt L=5 W=1 AS=0.29 AD=0.145
+ PS=2.58 PD=1.29
M$68 \$276 \$279 Vdd Vdd sky130_fd_pr__pfet_01v8_lvt L=5 W=1 AS=0.145 AD=0.29
+ PS=1.29 PD=2.58
M$69 Vdd \$279 \$286 Vdd sky130_fd_pr__pfet_01v8_lvt L=5 W=1 AS=0.29 AD=0.145
+ PS=2.58 PD=1.29
M$70 \$286 \$279 Vdd Vdd sky130_fd_pr__pfet_01v8_lvt L=5 W=1 AS=0.145 AD=0.29
+ PS=1.29 PD=2.58
M$71 Vdd \$279 \$276 Vdd sky130_fd_pr__pfet_01v8_lvt L=5 W=1 AS=0.29 AD=0.145
+ PS=2.58 PD=1.29
M$72 \$276 \$279 Vdd Vdd sky130_fd_pr__pfet_01v8_lvt L=5 W=1 AS=0.145 AD=0.29
+ PS=1.29 PD=2.58
M$73 Vdd \$279 \$286 Vdd sky130_fd_pr__pfet_01v8_lvt L=5 W=1 AS=0.29 AD=0.145
+ PS=2.58 PD=1.29
M$74 \$286 \$279 Vdd Vdd sky130_fd_pr__pfet_01v8_lvt L=5 W=1 AS=0.145 AD=0.29
+ PS=1.29 PD=2.58
M$75 Vdd Vdd Vdd Vdd sky130_fd_pr__pfet_01v8_lvt L=5 W=1 AS=0.29 AD=0.145
+ PS=2.58 PD=1.29
M$76 Vdd Vdd Vdd Vdd sky130_fd_pr__pfet_01v8_lvt L=5 W=1 AS=0.145 AD=0.29
+ PS=1.29 PD=2.58
M$77 Vdd Vdd Vdd Vdd sky130_fd_pr__pfet_01v8_lvt L=5 W=1 AS=0.29 AD=0.145
+ PS=2.58 PD=1.29
M$78 Vdd Vdd Vdd Vdd sky130_fd_pr__pfet_01v8_lvt L=5 W=1 AS=0.145 AD=0.29
+ PS=1.29 PD=2.58
M$79 \$276 \$416 \$3 Vdd sky130_fd_pr__pfet_01v8_lvt L=5 W=1 AS=0.29 AD=0.145
+ PS=2.58 PD=1.29
M$80 \$3 \$416 \$276 Vdd sky130_fd_pr__pfet_01v8_lvt L=5 W=1 AS=0.145 AD=0.29
+ PS=1.29 PD=2.58
M$81 \$286 \$416 \$67 Vdd sky130_fd_pr__pfet_01v8_lvt L=5 W=1 AS=0.29 AD=0.145
+ PS=2.58 PD=1.29
M$82 \$67 \$416 \$286 Vdd sky130_fd_pr__pfet_01v8_lvt L=5 W=1 AS=0.145 AD=0.29
+ PS=1.29 PD=2.58
M$83 \$276 \$416 \$3 Vdd sky130_fd_pr__pfet_01v8_lvt L=5 W=1 AS=0.29 AD=0.145
+ PS=2.58 PD=1.29
M$84 \$3 \$416 \$276 Vdd sky130_fd_pr__pfet_01v8_lvt L=5 W=1 AS=0.145 AD=0.29
+ PS=1.29 PD=2.58
M$85 \$286 \$416 \$67 Vdd sky130_fd_pr__pfet_01v8_lvt L=5 W=1 AS=0.29 AD=0.145
+ PS=2.58 PD=1.29
M$86 \$67 \$416 \$286 Vdd sky130_fd_pr__pfet_01v8_lvt L=5 W=1 AS=0.145 AD=0.29
+ PS=1.29 PD=2.58
M$87 \$121 \$121 Vss sky130_gnd sky130_fd_pr__nfet_01v8_lvt L=2 W=1 AS=0.29
+ AD=0.29 PS=2.58 PD=2.58
M$88 \$121 \$121 Vss sky130_gnd sky130_fd_pr__nfet_01v8_lvt L=2 W=1 AS=0.29
+ AD=0.29 PS=2.58 PD=2.58
M$89 Vss Vss Vss sky130_gnd sky130_fd_pr__nfet_01v8_lvt L=20 W=1 AS=0.29
+ AD=0.29 PS=2.58 PD=2.58
M$90 Vss Vss Vss sky130_gnd sky130_fd_pr__nfet_01v8_lvt L=20 W=1 AS=0.29
+ AD=0.29 PS=2.58 PD=2.58
M$91 \$343 \$121 Vss sky130_gnd sky130_fd_pr__nfet_01v8_lvt L=20 W=1 AS=0.29
+ AD=0.29 PS=2.58 PD=2.58
M$92 \$278 \$121 Vss sky130_gnd sky130_fd_pr__nfet_01v8_lvt L=20 W=1 AS=0.29
+ AD=0.29 PS=2.58 PD=2.58
M$93 \$343 \$121 Vss sky130_gnd sky130_fd_pr__nfet_01v8_lvt L=20 W=1 AS=0.29
+ AD=0.29 PS=2.58 PD=2.58
M$94 \$278 \$121 Vss sky130_gnd sky130_fd_pr__nfet_01v8_lvt L=20 W=1 AS=0.29
+ AD=0.29 PS=2.58 PD=2.58
M$95 \$301 \$301 Vss sky130_gnd sky130_fd_pr__nfet_01v8_lvt L=5 W=0.6 AS=0.174
+ AD=0.174 PS=1.78 PD=1.78
M$96 \$301 \$301 Vss sky130_gnd sky130_fd_pr__nfet_01v8_lvt L=5 W=0.6 AS=0.174
+ AD=0.174 PS=1.78 PD=1.78
M$97 \$418 \$121 Vss sky130_gnd sky130_fd_pr__nfet_01v8_lvt L=10 W=1 AS=0.29
+ AD=0.29 PS=2.58 PD=2.58
M$98 \$418 \$121 Vss sky130_gnd sky130_fd_pr__nfet_01v8_lvt L=10 W=1 AS=0.29
+ AD=0.29 PS=2.58 PD=2.58
M$99 \$346 \$121 Vss sky130_gnd sky130_fd_pr__nfet_01v8_lvt L=10 W=1 AS=0.29
+ AD=0.29 PS=2.58 PD=2.58
M$100 \$346 \$121 Vss sky130_gnd sky130_fd_pr__nfet_01v8_lvt L=10 W=1 AS=0.29
+ AD=0.29 PS=2.58 PD=2.58
M$101 \$403 \$121 Vss sky130_gnd sky130_fd_pr__nfet_01v8_lvt L=10 W=1 AS=0.29
+ AD=0.29 PS=2.58 PD=2.58
M$102 \$403 \$121 Vss sky130_gnd sky130_fd_pr__nfet_01v8_lvt L=10 W=1 AS=0.29
+ AD=0.29 PS=2.58 PD=2.58
M$103 \$345 \$121 Vss sky130_gnd sky130_fd_pr__nfet_01v8_lvt L=10 W=1 AS=0.29
+ AD=0.29 PS=2.58 PD=2.58
M$104 \$345 \$121 Vss sky130_gnd sky130_fd_pr__nfet_01v8_lvt L=10 W=1 AS=0.29
+ AD=0.29 PS=2.58 PD=2.58
M$105 Vss Vss Vss sky130_gnd sky130_fd_pr__nfet_01v8_lvt L=10 W=1 AS=0.29
+ AD=0.29 PS=2.58 PD=2.58
M$106 Vss Vss Vss sky130_gnd sky130_fd_pr__nfet_01v8_lvt L=10 W=1 AS=0.29
+ AD=0.29 PS=2.58 PD=2.58
M$107 Vss Vss Vss sky130_gnd sky130_fd_pr__nfet_01v8_lvt L=20 W=0.5 AS=0.145
+ AD=0.145 PS=1.58 PD=1.58
M$108 Vss Vss Vss sky130_gnd sky130_fd_pr__nfet_01v8_lvt L=20 W=0.5 AS=0.145
+ AD=0.145 PS=1.58 PD=1.58
M$109 \$174 \$174 Vss sky130_gnd sky130_fd_pr__nfet_01v8_lvt L=20 W=0.5
+ AS=0.145 AD=0.145 PS=1.58 PD=1.58
M$110 \$154 \$174 Vss sky130_gnd sky130_fd_pr__nfet_01v8_lvt L=20 W=0.5
+ AS=0.145 AD=0.145 PS=1.58 PD=1.58
M$111 \$154 \$174 Vss sky130_gnd sky130_fd_pr__nfet_01v8_lvt L=20 W=0.5
+ AS=0.145 AD=0.145 PS=1.58 PD=1.58
M$112 \$174 \$174 Vss sky130_gnd sky130_fd_pr__nfet_01v8_lvt L=20 W=0.5
+ AS=0.145 AD=0.145 PS=1.58 PD=1.58
M$113 \$3 \$301 \$345 sky130_gnd sky130_fd_pr__nfet_01v8_lvt L=1 W=1 AS=0.29
+ AD=0.29 PS=2.58 PD=2.58
M$114 \$3 \$301 \$345 sky130_gnd sky130_fd_pr__nfet_01v8_lvt L=1 W=1 AS=0.29
+ AD=0.29 PS=2.58 PD=2.58
M$115 \$277 \$301 \$346 sky130_gnd sky130_fd_pr__nfet_01v8_lvt L=1 W=1 AS=0.29
+ AD=0.29 PS=2.58 PD=2.58
M$116 \$277 \$301 \$346 sky130_gnd sky130_fd_pr__nfet_01v8_lvt L=1 W=1 AS=0.29
+ AD=0.29 PS=2.58 PD=2.58
M$117 Vss Vss Vss sky130_gnd sky130_fd_pr__nfet_01v8_lvt L=1 W=1 AS=0.29
+ AD=0.29 PS=2.58 PD=2.58
M$118 Vss Vss Vss sky130_gnd sky130_fd_pr__nfet_01v8_lvt L=1 W=1 AS=0.29
+ AD=0.29 PS=2.58 PD=2.58
M$119 \$277 \$301 \$418 sky130_gnd sky130_fd_pr__nfet_01v8_lvt L=1 W=1 AS=0.29
+ AD=0.29 PS=2.58 PD=2.58
M$120 \$277 \$301 \$418 sky130_gnd sky130_fd_pr__nfet_01v8_lvt L=1 W=1 AS=0.29
+ AD=0.29 PS=2.58 PD=2.58
M$121 \$67 \$301 \$403 sky130_gnd sky130_fd_pr__nfet_01v8_lvt L=1 W=1 AS=0.29
+ AD=0.29 PS=2.58 PD=2.58
M$122 \$67 \$301 \$403 sky130_gnd sky130_fd_pr__nfet_01v8_lvt L=1 W=1 AS=0.29
+ AD=0.29 PS=2.58 PD=2.58
M$123 Vss Vss Vss sky130_gnd sky130_fd_pr__nfet_01v8_lvt L=1 W=1 AS=0.29
+ AD=0.29 PS=2.58 PD=2.58
M$124 Vss Vss Vss sky130_gnd sky130_fd_pr__nfet_01v8_lvt L=1 W=1 AS=0.29
+ AD=0.29 PS=2.58 PD=2.58
M$125 Vop \$154 Vss sky130_gnd sky130_fd_pr__nfet_01v8_lvt L=1 W=1 AS=0.29
+ AD=0.29 PS=2.58 PD=2.58
M$126 Vop \$154 Vss sky130_gnd sky130_fd_pr__nfet_01v8_lvt L=1 W=1 AS=0.29
+ AD=0.29 PS=2.58 PD=2.58
M$127 Vop \$154 Vss sky130_gnd sky130_fd_pr__nfet_01v8_lvt L=1 W=1 AS=0.29
+ AD=0.29 PS=2.58 PD=2.58
M$128 Vop \$154 Vss sky130_gnd sky130_fd_pr__nfet_01v8_lvt L=1 W=1 AS=0.29
+ AD=0.29 PS=2.58 PD=2.58
M$129 Vop \$154 Vss sky130_gnd sky130_fd_pr__nfet_01v8_lvt L=1 W=1 AS=0.29
+ AD=0.29 PS=2.58 PD=2.58
M$130 Vop \$154 Vss sky130_gnd sky130_fd_pr__nfet_01v8_lvt L=1 W=1 AS=0.29
+ AD=0.29 PS=2.58 PD=2.58
M$131 Vop \$154 Vss sky130_gnd sky130_fd_pr__nfet_01v8_lvt L=1 W=1 AS=0.29
+ AD=0.29 PS=2.58 PD=2.58
M$132 Vop \$154 Vss sky130_gnd sky130_fd_pr__nfet_01v8_lvt L=1 W=1 AS=0.29
+ AD=0.29 PS=2.58 PD=2.58
M$133 Vop \$154 Vss sky130_gnd sky130_fd_pr__nfet_01v8_lvt L=1 W=1 AS=0.29
+ AD=0.29 PS=2.58 PD=2.58
M$134 Vss Vss Vss sky130_gnd sky130_fd_pr__nfet_01v8_lvt L=1 W=1 AS=0.29
+ AD=0.29 PS=2.58 PD=2.58
M$135 Vom \$154 Vss sky130_gnd sky130_fd_pr__nfet_01v8_lvt L=1 W=1 AS=0.29
+ AD=0.29 PS=2.58 PD=2.58
M$136 Vom \$154 Vss sky130_gnd sky130_fd_pr__nfet_01v8_lvt L=1 W=1 AS=0.29
+ AD=0.29 PS=2.58 PD=2.58
M$137 Vom \$154 Vss sky130_gnd sky130_fd_pr__nfet_01v8_lvt L=1 W=1 AS=0.29
+ AD=0.29 PS=2.58 PD=2.58
M$138 Vom \$154 Vss sky130_gnd sky130_fd_pr__nfet_01v8_lvt L=1 W=1 AS=0.29
+ AD=0.29 PS=2.58 PD=2.58
M$139 Vom \$154 Vss sky130_gnd sky130_fd_pr__nfet_01v8_lvt L=1 W=1 AS=0.29
+ AD=0.29 PS=2.58 PD=2.58
M$140 Vom \$154 Vss sky130_gnd sky130_fd_pr__nfet_01v8_lvt L=1 W=1 AS=0.29
+ AD=0.29 PS=2.58 PD=2.58
M$141 Vom \$154 Vss sky130_gnd sky130_fd_pr__nfet_01v8_lvt L=1 W=1 AS=0.29
+ AD=0.29 PS=2.58 PD=2.58
M$142 Vom \$154 Vss sky130_gnd sky130_fd_pr__nfet_01v8_lvt L=1 W=1 AS=0.29
+ AD=0.29 PS=2.58 PD=2.58
M$143 Vss Vss Vss sky130_gnd sky130_fd_pr__nfet_01v8_lvt L=1 W=1 AS=0.29
+ AD=0.29 PS=2.58 PD=2.58
M$144 Vom \$154 Vss sky130_gnd sky130_fd_pr__nfet_01v8_lvt L=1 W=1 AS=0.29
+ AD=0.29 PS=2.58 PD=2.58
M$145 Vss Vss Vss sky130_gnd sky130_fd_pr__nfet_01v8_lvt L=1 W=0.6 AS=0.174
+ AD=0.174 PS=1.78 PD=1.78
M$146 Vss Vss Vss sky130_gnd sky130_fd_pr__nfet_01v8_lvt L=1 W=0.6 AS=0.174
+ AD=0.174 PS=1.78 PD=1.78
M$147 \$416 \$402 Vss sky130_gnd sky130_fd_pr__nfet_01v8_lvt L=1 W=0.6 AS=0.174
+ AD=0.174 PS=1.78 PD=1.78
M$148 \$402 \$402 Vss sky130_gnd sky130_fd_pr__nfet_01v8_lvt L=1 W=0.6 AS=0.174
+ AD=0.174 PS=1.78 PD=1.78
M$149 \$402 \$402 Vss sky130_gnd sky130_fd_pr__nfet_01v8_lvt L=1 W=0.6 AS=0.174
+ AD=0.174 PS=1.78 PD=1.78
M$150 \$416 \$402 Vss sky130_gnd sky130_fd_pr__nfet_01v8_lvt L=1 W=0.6 AS=0.174
+ AD=0.174 PS=1.78 PD=1.78
M$151 Vss Vss Vss sky130_gnd sky130_fd_pr__nfet_01v8_lvt L=1 W=0.6 AS=0.174
+ AD=0.174 PS=1.78 PD=1.78
M$152 Vss Vss Vss sky130_gnd sky130_fd_pr__nfet_01v8_lvt L=1 W=0.6 AS=0.174
+ AD=0.174 PS=1.78 PD=1.78
M$153 \$192 \$176 Vss sky130_gnd sky130_fd_pr__nfet_01v8_lvt L=1 W=0.6 AS=0.174
+ AD=0.174 PS=1.78 PD=1.78
M$154 \$176 \$176 Vss sky130_gnd sky130_fd_pr__nfet_01v8_lvt L=1 W=0.6 AS=0.174
+ AD=0.174 PS=1.78 PD=1.78
M$155 \$192 \$176 Vss sky130_gnd sky130_fd_pr__nfet_01v8_lvt L=1 W=0.6 AS=0.174
+ AD=0.174 PS=1.78 PD=1.78
M$156 \$176 \$176 Vss sky130_gnd sky130_fd_pr__nfet_01v8_lvt L=1 W=0.6 AS=0.174
+ AD=0.174 PS=1.78 PD=1.78
M$157 \$207 \$192 Vdd Vdd sky130_fd_pr__pfet_01v8_lvt L=5 W=1 AS=0.29 AD=0.29
+ PS=2.58 PD=2.58
M$158 Vdd Vdd Vdd Vdd sky130_fd_pr__pfet_01v8_lvt L=5 W=1 AS=0.29 AD=0.29
+ PS=2.58 PD=2.58
M$159 \$207 \$192 Vdd Vdd sky130_fd_pr__pfet_01v8_lvt L=5 W=1 AS=0.29 AD=0.29
+ PS=2.58 PD=2.58
M$160 Vdd Vdd Vdd Vdd sky130_fd_pr__pfet_01v8_lvt L=1 W=6 AS=1.74 AD=1.74
+ PS=12.58 PD=12.58
M$161 \$192 \$192 Vdd Vdd sky130_fd_pr__pfet_01v8_lvt L=1 W=6 AS=1.74 AD=1.74
+ PS=12.58 PD=12.58
M$162 \$192 \$192 Vdd Vdd sky130_fd_pr__pfet_01v8_lvt L=1 W=6 AS=1.74 AD=1.74
+ PS=12.58 PD=12.58
M$163 Vdd Vdd Vdd Vdd sky130_fd_pr__pfet_01v8_lvt L=10 W=1 AS=0.29 AD=0.29
+ PS=2.58 PD=2.58
M$164 Vdd Vdd Vdd Vdd sky130_fd_pr__pfet_01v8_lvt L=10 W=1 AS=0.29 AD=0.29
+ PS=2.58 PD=2.58
M$165 \$287 \$287 Vdd Vdd sky130_fd_pr__pfet_01v8_lvt L=10 W=1 AS=0.29 AD=0.29
+ PS=2.58 PD=2.58
M$166 \$279 \$287 Vdd Vdd sky130_fd_pr__pfet_01v8_lvt L=10 W=1 AS=0.29 AD=0.29
+ PS=2.58 PD=2.58
M$167 \$287 \$287 Vdd Vdd sky130_fd_pr__pfet_01v8_lvt L=10 W=1 AS=0.29 AD=0.29
+ PS=2.58 PD=2.58
M$168 \$279 \$287 Vdd Vdd sky130_fd_pr__pfet_01v8_lvt L=10 W=1 AS=0.29 AD=0.29
+ PS=2.58 PD=2.58
M$169 Vdd Vdd Vdd Vdd sky130_fd_pr__pfet_01v8_lvt L=10 W=1 AS=0.29 AD=0.29
+ PS=2.58 PD=2.58
M$170 \$174 \$206 \$207 Vdd sky130_fd_pr__pfet_01v8_lvt L=10 W=1 AS=0.29
+ AD=0.29 PS=2.58 PD=2.58
M$171 \$154 VREF \$207 Vdd sky130_fd_pr__pfet_01v8_lvt L=10 W=1 AS=0.29 AD=0.29
+ PS=2.58 PD=2.58
M$172 \$154 VREF \$207 Vdd sky130_fd_pr__pfet_01v8_lvt L=10 W=1 AS=0.29 AD=0.29
+ PS=2.58 PD=2.58
M$173 \$174 \$206 \$207 Vdd sky130_fd_pr__pfet_01v8_lvt L=10 W=1 AS=0.29
+ AD=0.29 PS=2.58 PD=2.58
M$174 Vdd Vdd Vdd Vdd sky130_fd_pr__pfet_01v8_lvt L=10 W=1 AS=0.29 AD=0.29
+ PS=2.58 PD=2.58
M$175 Vdd \$3 Vop Vdd sky130_fd_pr__pfet_01v8_lvt L=1 W=1 AS=0.29 AD=0.145
+ PS=2.58 PD=1.29
M$176 Vop \$3 Vdd Vdd sky130_fd_pr__pfet_01v8_lvt L=1 W=1 AS=0.145 AD=0.29
+ PS=1.29 PD=2.58
M$177 Vdd \$3 Vop Vdd sky130_fd_pr__pfet_01v8_lvt L=1 W=1 AS=0.29 AD=0.145
+ PS=2.58 PD=1.29
M$178 Vop \$3 Vdd Vdd sky130_fd_pr__pfet_01v8_lvt L=1 W=1 AS=0.145 AD=0.29
+ PS=1.29 PD=2.58
M$179 Vdd \$3 Vop Vdd sky130_fd_pr__pfet_01v8_lvt L=1 W=1 AS=0.29 AD=0.145
+ PS=2.58 PD=1.29
M$180 Vop \$3 Vdd Vdd sky130_fd_pr__pfet_01v8_lvt L=1 W=1 AS=0.145 AD=0.29
+ PS=1.29 PD=2.58
M$181 Vdd \$3 Vop Vdd sky130_fd_pr__pfet_01v8_lvt L=1 W=1 AS=0.29 AD=0.145
+ PS=2.58 PD=1.29
M$182 Vop \$3 Vdd Vdd sky130_fd_pr__pfet_01v8_lvt L=1 W=1 AS=0.145 AD=0.29
+ PS=1.29 PD=2.58
M$183 Vdd \$3 Vop Vdd sky130_fd_pr__pfet_01v8_lvt L=1 W=1 AS=0.29 AD=0.145
+ PS=2.58 PD=1.29
M$184 Vop \$3 Vdd Vdd sky130_fd_pr__pfet_01v8_lvt L=1 W=1 AS=0.145 AD=0.29
+ PS=1.29 PD=2.58
M$185 Vdd \$3 Vop Vdd sky130_fd_pr__pfet_01v8_lvt L=1 W=1 AS=0.29 AD=0.145
+ PS=2.58 PD=1.29
M$186 Vop \$3 Vdd Vdd sky130_fd_pr__pfet_01v8_lvt L=1 W=1 AS=0.145 AD=0.29
+ PS=1.29 PD=2.58
M$187 Vdd \$3 Vop Vdd sky130_fd_pr__pfet_01v8_lvt L=1 W=1 AS=0.29 AD=0.145
+ PS=2.58 PD=1.29
M$188 Vop \$3 Vdd Vdd sky130_fd_pr__pfet_01v8_lvt L=1 W=1 AS=0.145 AD=0.29
+ PS=1.29 PD=2.58
M$189 Vdd \$3 Vop Vdd sky130_fd_pr__pfet_01v8_lvt L=1 W=1 AS=0.29 AD=0.145
+ PS=2.58 PD=1.29
M$190 Vop \$3 Vdd Vdd sky130_fd_pr__pfet_01v8_lvt L=1 W=1 AS=0.145 AD=0.29
+ PS=1.29 PD=2.58
M$191 Vdd \$3 Vop Vdd sky130_fd_pr__pfet_01v8_lvt L=1 W=1 AS=0.29 AD=0.145
+ PS=2.58 PD=1.29
M$192 Vop \$3 Vdd Vdd sky130_fd_pr__pfet_01v8_lvt L=1 W=1 AS=0.145 AD=0.29
+ PS=1.29 PD=2.58
M$193 Vdd \$67 Vom Vdd sky130_fd_pr__pfet_01v8_lvt L=1 W=1 AS=0.29 AD=0.145
+ PS=2.58 PD=1.29
M$194 Vom \$67 Vdd Vdd sky130_fd_pr__pfet_01v8_lvt L=1 W=1 AS=0.145 AD=0.29
+ PS=1.29 PD=2.58
M$195 Vdd \$67 Vom Vdd sky130_fd_pr__pfet_01v8_lvt L=1 W=1 AS=0.29 AD=0.145
+ PS=2.58 PD=1.29
M$196 Vom \$67 Vdd Vdd sky130_fd_pr__pfet_01v8_lvt L=1 W=1 AS=0.145 AD=0.29
+ PS=1.29 PD=2.58
M$197 Vdd \$67 Vom Vdd sky130_fd_pr__pfet_01v8_lvt L=1 W=1 AS=0.29 AD=0.145
+ PS=2.58 PD=1.29
M$198 Vom \$67 Vdd Vdd sky130_fd_pr__pfet_01v8_lvt L=1 W=1 AS=0.145 AD=0.29
+ PS=1.29 PD=2.58
M$199 Vdd \$67 Vom Vdd sky130_fd_pr__pfet_01v8_lvt L=1 W=1 AS=0.29 AD=0.145
+ PS=2.58 PD=1.29
M$200 Vom \$67 Vdd Vdd sky130_fd_pr__pfet_01v8_lvt L=1 W=1 AS=0.145 AD=0.29
+ PS=1.29 PD=2.58
M$201 Vdd \$67 Vom Vdd sky130_fd_pr__pfet_01v8_lvt L=1 W=1 AS=0.29 AD=0.145
+ PS=2.58 PD=1.29
M$202 Vom \$67 Vdd Vdd sky130_fd_pr__pfet_01v8_lvt L=1 W=1 AS=0.145 AD=0.29
+ PS=1.29 PD=2.58
M$203 Vdd \$67 Vom Vdd sky130_fd_pr__pfet_01v8_lvt L=1 W=1 AS=0.29 AD=0.145
+ PS=2.58 PD=1.29
M$204 Vom \$67 Vdd Vdd sky130_fd_pr__pfet_01v8_lvt L=1 W=1 AS=0.145 AD=0.29
+ PS=1.29 PD=2.58
M$205 Vdd \$67 Vom Vdd sky130_fd_pr__pfet_01v8_lvt L=1 W=1 AS=0.29 AD=0.145
+ PS=2.58 PD=1.29
M$206 Vom \$67 Vdd Vdd sky130_fd_pr__pfet_01v8_lvt L=1 W=1 AS=0.145 AD=0.29
+ PS=1.29 PD=2.58
M$207 Vdd \$67 Vom Vdd sky130_fd_pr__pfet_01v8_lvt L=1 W=1 AS=0.29 AD=0.145
+ PS=2.58 PD=1.29
M$208 Vom \$67 Vdd Vdd sky130_fd_pr__pfet_01v8_lvt L=1 W=1 AS=0.145 AD=0.29
+ PS=1.29 PD=2.58
M$209 Vdd \$67 Vom Vdd sky130_fd_pr__pfet_01v8_lvt L=1 W=1 AS=0.29 AD=0.145
+ PS=2.58 PD=1.29
M$210 Vom \$67 Vdd Vdd sky130_fd_pr__pfet_01v8_lvt L=1 W=1 AS=0.145 AD=0.29
+ PS=1.29 PD=2.58
M$211 Vss Vss Vss sky130_gnd sky130_fd_pr__nfet_01v8_lvt L=20 W=5 AS=1.45
+ AD=1.45 PS=10.58 PD=10.58
M$212 Vss Vss Vss sky130_gnd sky130_fd_pr__nfet_01v8_lvt L=20 W=5 AS=1.45
+ AD=1.45 PS=10.58 PD=10.58
M$213 \$279 VREF \$343 sky130_gnd sky130_fd_pr__nfet_01v8_lvt L=20 W=5 AS=1.45
+ AD=1.45 PS=10.58 PD=10.58
M$214 \$279 VREF \$343 sky130_gnd sky130_fd_pr__nfet_01v8_lvt L=20 W=5 AS=1.45
+ AD=1.45 PS=10.58 PD=10.58
M$215 \$287 \$67 \$343 sky130_gnd sky130_fd_pr__nfet_01v8_lvt L=20 W=5 AS=1.45
+ AD=1.45 PS=10.58 PD=10.58
M$216 \$287 \$67 \$343 sky130_gnd sky130_fd_pr__nfet_01v8_lvt L=20 W=5 AS=1.45
+ AD=1.45 PS=10.58 PD=10.58
M$217 Vss Vss Vss sky130_gnd sky130_fd_pr__nfet_01v8_lvt L=20 W=5 AS=1.45
+ AD=1.45 PS=10.58 PD=10.58
M$218 Vss Vss Vss sky130_gnd sky130_fd_pr__nfet_01v8_lvt L=20 W=5 AS=1.45
+ AD=1.45 PS=10.58 PD=10.58
M$219 \$287 \$3 \$278 sky130_gnd sky130_fd_pr__nfet_01v8_lvt L=20 W=5 AS=1.45
+ AD=1.45 PS=10.58 PD=10.58
M$220 \$287 \$3 \$278 sky130_gnd sky130_fd_pr__nfet_01v8_lvt L=20 W=5 AS=1.45
+ AD=1.45 PS=10.58 PD=10.58
M$221 \$279 VREF \$278 sky130_gnd sky130_fd_pr__nfet_01v8_lvt L=20 W=5 AS=1.45
+ AD=1.45 PS=10.58 PD=10.58
M$222 \$279 VREF \$278 sky130_gnd sky130_fd_pr__nfet_01v8_lvt L=20 W=5 AS=1.45
+ AD=1.45 PS=10.58 PD=10.58
M$223 \$286 Vm \$277 sky130_gnd sky130_fd_pr__nfet_01v8_lvt L=4 W=4 AS=1.16
+ AD=1.16 PS=8.58 PD=8.58
M$224 \$276 Vp \$277 sky130_gnd sky130_fd_pr__nfet_01v8_lvt L=4 W=4 AS=1.16
+ AD=1.16 PS=8.58 PD=8.58
M$225 \$286 Vm \$277 sky130_gnd sky130_fd_pr__nfet_01v8_lvt L=4 W=4 AS=1.16
+ AD=1.16 PS=8.58 PD=8.58
M$226 \$276 Vp \$277 sky130_gnd sky130_fd_pr__nfet_01v8_lvt L=4 W=4 AS=1.16
+ AD=1.16 PS=8.58 PD=8.58
M$227 Vss Vss Vss sky130_gnd sky130_fd_pr__nfet_01v8_lvt L=4 W=4 AS=1.16
+ AD=1.16 PS=8.58 PD=8.58
M$228 Vss Vss Vss sky130_gnd sky130_fd_pr__nfet_01v8_lvt L=4 W=4 AS=1.16
+ AD=1.16 PS=8.58 PD=8.58
M$229 \$27 \$27 RGM sky130_gnd sky130_fd_pr__nfet_01v8_lvt L=1 W=10 AS=2.9
+ AD=2.9 PS=20.58 PD=20.58
M$230 \$27 \$27 RGM sky130_gnd sky130_fd_pr__nfet_01v8_lvt L=1 W=10 AS=2.9
+ AD=2.9 PS=20.58 PD=20.58
M$231 \$7 \$55 \$66 sky130_gnd sky130_fd_pr__nfet_01v8_lvt L=1 W=2 AS=0.58
+ AD=0.58 PS=4.58 PD=4.58
M$232 \$55 \$55 Vdd Vdd sky130_fd_pr__pfet_01v8_lvt L=20 W=1 AS=0.29 AD=0.29
+ PS=2.58 PD=2.58
M$233 \$55 \$55 Vdd Vdd sky130_fd_pr__pfet_01v8_lvt L=20 W=1 AS=0.29 AD=0.29
+ PS=2.58 PD=2.58
M$234 Vdd Vdd Vdd Vdd sky130_fd_pr__pfet_01v8_lvt L=1 W=5 AS=1.45 AD=1.45
+ PS=10.58 PD=10.58
M$235 Vdd Vdd Vdd Vdd sky130_fd_pr__pfet_01v8_lvt L=1 W=5 AS=1.45 AD=1.45
+ PS=10.58 PD=10.58
M$236 \$121 \$7 Vdd Vdd sky130_fd_pr__pfet_01v8_lvt L=1 W=5 AS=1.45 AD=1.45
+ PS=10.58 PD=10.58
M$237 \$301 \$7 Vdd Vdd sky130_fd_pr__pfet_01v8_lvt L=1 W=5 AS=1.45 AD=1.45
+ PS=10.58 PD=10.58
M$238 \$121 \$7 Vdd Vdd sky130_fd_pr__pfet_01v8_lvt L=1 W=5 AS=1.45 AD=1.45
+ PS=10.58 PD=10.58
M$239 \$301 \$7 Vdd Vdd sky130_fd_pr__pfet_01v8_lvt L=1 W=5 AS=1.45 AD=1.45
+ PS=10.58 PD=10.58
M$240 Vdd Vdd Vdd Vdd sky130_fd_pr__pfet_01v8_lvt L=1 W=5 AS=1.45 AD=1.45
+ PS=10.58 PD=10.58
M$241 \$66 \$7 Vdd Vdd sky130_fd_pr__pfet_01v8_lvt L=1 W=5 AS=1.45 AD=1.45
+ PS=10.58 PD=10.58
M$242 \$27 \$7 Vdd Vdd sky130_fd_pr__pfet_01v8_lvt L=1 W=5 AS=1.45 AD=1.45
+ PS=10.58 PD=10.58
M$243 \$27 \$7 Vdd Vdd sky130_fd_pr__pfet_01v8_lvt L=1 W=5 AS=1.45 AD=1.45
+ PS=10.58 PD=10.58
M$244 \$66 \$7 Vdd Vdd sky130_fd_pr__pfet_01v8_lvt L=1 W=5 AS=1.45 AD=1.45
+ PS=10.58 PD=10.58
M$245 Vdd Vdd Vdd Vdd sky130_fd_pr__pfet_01v8_lvt L=1 W=5 AS=1.45 AD=1.45
+ PS=10.58 PD=10.58
M$246 Vdd Vdd Vdd Vdd sky130_fd_pr__pfet_01v8_lvt L=1 W=5 AS=1.45 AD=1.45
+ PS=10.58 PD=10.58
M$247 \$45 \$45 Vdd Vdd sky130_fd_pr__pfet_01v8_lvt L=1 W=5 AS=1.45 AD=1.45
+ PS=10.58 PD=10.58
M$248 \$7 \$45 Vdd Vdd sky130_fd_pr__pfet_01v8_lvt L=1 W=5 AS=1.45 AD=1.45
+ PS=10.58 PD=10.58
M$249 \$45 \$45 Vdd Vdd sky130_fd_pr__pfet_01v8_lvt L=1 W=5 AS=1.45 AD=1.45
+ PS=10.58 PD=10.58
M$250 \$7 \$45 Vdd Vdd sky130_fd_pr__pfet_01v8_lvt L=1 W=5 AS=1.45 AD=1.45
+ PS=10.58 PD=10.58
M$251 Vdd Vdd Vdd Vdd sky130_fd_pr__pfet_01v8_lvt L=1 W=5 AS=1.45 AD=1.45
+ PS=10.58 PD=10.58
M$252 Vdd Vdd Vdd Vdd sky130_fd_pr__pfet_01v8_lvt L=1 W=5 AS=1.45 AD=1.45
+ PS=10.58 PD=10.58
M$253 \$402 \$7 Vdd Vdd sky130_fd_pr__pfet_01v8_lvt L=1 W=5 AS=1.45 AD=1.45
+ PS=10.58 PD=10.58
M$254 \$176 \$7 Vdd Vdd sky130_fd_pr__pfet_01v8_lvt L=1 W=5 AS=1.45 AD=1.45
+ PS=10.58 PD=10.58
M$255 \$402 \$7 Vdd Vdd sky130_fd_pr__pfet_01v8_lvt L=1 W=5 AS=1.45 AD=1.45
+ PS=10.58 PD=10.58
M$256 \$176 \$7 Vdd Vdd sky130_fd_pr__pfet_01v8_lvt L=1 W=5 AS=1.45 AD=1.45
+ PS=10.58 PD=10.58
M$257 Vdd Vdd Vdd Vdd sky130_fd_pr__pfet_01v8_lvt L=1 W=5 AS=1.45 AD=1.45
+ PS=10.58 PD=10.58
M$258 \$45 \$27 Vss sky130_gnd sky130_fd_pr__nfet_01v8_lvt L=2 W=5 AS=1.45
+ AD=1.45 PS=10.58 PD=10.58
M$259 \$45 \$27 Vss sky130_gnd sky130_fd_pr__nfet_01v8_lvt L=2 W=5 AS=1.45
+ AD=1.45 PS=10.58 PD=10.58
M$260 \$55 \$66 Vss sky130_gnd sky130_fd_pr__nfet_01v8_lvt L=2 W=5 AS=1.45
+ AD=1.45 PS=10.58 PD=10.58
M$261 \$55 \$66 Vss sky130_gnd sky130_fd_pr__nfet_01v8_lvt L=2 W=5 AS=1.45
+ AD=1.45 PS=10.58 PD=10.58
M$262 \$7 \$66 Vss sky130_gnd sky130_fd_pr__nfet_01v8_lvt L=2 W=5 AS=1.45
+ AD=1.45 PS=10.58 PD=10.58
M$263 \$7 \$66 Vss sky130_gnd sky130_fd_pr__nfet_01v8_lvt L=2 W=5 AS=1.45
+ AD=1.45 PS=10.58 PD=10.58
M$264 Vss Vss Vss sky130_gnd sky130_fd_pr__nfet_01v8_lvt L=2 W=5 AS=1.45
+ AD=1.45 PS=10.58 PD=10.58
M$265 Vss Vss Vss sky130_gnd sky130_fd_pr__nfet_01v8_lvt L=2 W=5 AS=1.45
+ AD=1.45 PS=10.58 PD=10.58
M$266 \$66 \$66 Vss sky130_gnd sky130_fd_pr__nfet_01v8_lvt L=2 W=5 AS=1.45
+ AD=1.45 PS=10.58 PD=10.58
M$267 \$66 \$66 Vss sky130_gnd sky130_fd_pr__nfet_01v8_lvt L=2 W=5 AS=1.45
+ AD=1.45 PS=10.58 PD=10.58
.ENDS ttsky25a_fd_routed
