* NGSPICE file created from ttsky25a_fd_routed_flat.ext - technology: sky130A

.subckt ttsky25a_fd_routed_flat Vom Vop RGM VREF Vdd Vm Vp Vss pmos_differential_pair__ABBA_0.x2_Vtest
+ pmos_differential_pair__ABBA_0.x2_Vout pmos_current_mirror_2__row_0.x2_Vbiasp pmos_current_mirror_2__row_0.x2_net1
+ nmos_current_mirror_3__ABBA_0.net7 res_packs__interleaved_0.x2_x1_net4 res_packs__interleaved_0.x2_x2_net4
+ res_packs__interleaved_0.x2_x1_net6 res_packs__interleaved_0.x2_x2_net6 res_packs__interleaved_0.x2_x1_net1
+ res_packs__interleaved_0.x2_x2_net1 res_packs__interleaved_0.x2_x1_net10 res_packs__interleaved_0.x2_x2_net10
+ res_packs__interleaved_0.x2_x1_net8 res_packs__interleaved_0.x2_x2_net8 res_packs__interleaved_0.x2_x1_net12
+ res_packs__interleaved_0.x2_x2_net12 res_packs__interleaved_0.x2_x1_net14 res_packs__interleaved_0.x2_x2_net14
+ res_packs__interleaved_0.x2_x1_net3 res_packs__interleaved_0.x2_x2_net3 res_packs__interleaved_0.x2_x1_net18
+ res_packs__interleaved_0.x2_x2_net18 res_packs__interleaved_0.x2_x1_net16 res_packs__interleaved_0.x2_x2_net16
+ res_packs__interleaved_0.x2_Vcm res_packs__interleaved_0.x2_x2_net5 res_packs__interleaved_0.x2_x1_net5
+ res_packs__interleaved_0.x2_x2_net7 res_packs__interleaved_0.x2_x1_net7 res_packs__interleaved_0.x2_x2_net11
+ res_packs__interleaved_0.x2_x1_net11 res_packs__interleaved_0.x2_x2_net9 res_packs__interleaved_0.x2_x1_net9
+ res_packs__interleaved_0.x2_x2_net2 res_packs__interleaved_0.x2_x1_net2 res_packs__interleaved_0.x2_x2_net13
+ res_packs__interleaved_0.x2_x1_net13 res_packs__interleaved_0.x2_x2_net15 res_packs__interleaved_0.x2_x1_net15
+ res_packs__interleaved_0.x2_x2_net19 res_packs__interleaved_0.x2_x1_net19 res_packs__interleaved_0.x2_x2_net17
+ res_packs__interleaved_0.x2_x1_net17 XC2__A_0.Vom1 nmos_matched_cascode_pair_2__ABBA_0.x1_net4
+ nmos_matched_cascode_pair_2__ABBA_0.x1_net6 nmos_diode__A_0.net1 nmos_single_2__A_0.PBias
+ nmos_single_2__A_0.NBias nmos_matched_cascode_pair__ABBA_0.x1_net3 nmos_matched_cascode_pair__ABBA_0.x1_net5
+ nmos_current_mirror_4__A_0.net4 nmos_single__A_0.net2 XC1__A_0.Vop1 mirror_XX1_M22_XX1_M15__ABBA_0.x1_net7
+ mirror_XX1_M22_XX1_M15__ABBA_0.x1_net8 pmos_diode__A_0.net3 nmos_current_mirror_2__ABBA_0.net6
+ nmos_diode_2__A_0.net5 nmos_differential_pair__ABBA_0.x1_Vtest2 nmos_differential_pair__ABBA_0.x1_net2
+ nmos_differential_pair__ABBA_0.x1_net1 pmos_diode_2__A_0.x1_Vbias pmos_current_mirror_load__ABAB_0.x1_net9
+ pmos_current_mirror_load__ABAB_0.x1_Vout
X0 Vss Vss Vss Vss sky130_fd_pr__nfet_01v8_lvt ad=1.16 pd=8.58 as=53.012 ps=424.76001 w=4 l=4
X1 Vss Vss Vss Vss sky130_fd_pr__nfet_01v8_lvt ad=1.45 pd=10.58 as=0 ps=0 w=5 l=2
X2 Vdd Vdd Vdd Vdd sky130_fd_pr__pfet_01v8_lvt ad=0.145 pd=1.29 as=78.01 ps=607.59998 w=1 l=5
X3 pmos_differential_pair__ABBA_0.x2_Vout VREF pmos_current_mirror_2__row_0.x2_net1 Vdd sky130_fd_pr__pfet_01v8_lvt ad=0.29 pd=2.58 as=0.29 ps=2.58 w=1 l=10
X4 Vop XC2__A_0.Vom1 Vdd Vdd sky130_fd_pr__pfet_01v8_lvt ad=0.145 pd=1.29 as=0.29 ps=2.58 w=1 l=1
X5 Vdd nmos_single_2__A_0.PBias nmos_single_2__A_0.NBias Vdd sky130_fd_pr__pfet_01v8_lvt ad=1.45 pd=10.58 as=1.45 ps=10.58 w=5 l=1
X6 nmos_current_mirror_3__ABBA_0.net7 nmos_single_2__A_0.PBias Vdd Vdd sky130_fd_pr__pfet_01v8_lvt ad=1.45 pd=10.58 as=1.45 ps=10.58 w=5 l=1
X7 mirror_XX1_M22_XX1_M15__ABBA_0.x1_net8 nmos_current_mirror_4__A_0.net4 Vss Vss sky130_fd_pr__nfet_01v8_lvt ad=0.29 pd=2.58 as=0.29 ps=2.58 w=1 l=20
X8 res_packs__interleaved_0.x2_x2_net18 res_packs__interleaved_0.x2_x2_net17 sky130_fd_pr__res_generic_po w=0.5 l=40
X9 Vdd pmos_diode__A_0.net3 pmos_diode__A_0.net3 Vdd sky130_fd_pr__pfet_01v8_lvt ad=0.29 pd=2.58 as=0.29 ps=2.58 w=1 l=20
X10 pmos_current_mirror_load__ABAB_0.x1_net9 XC2__A_0.Vom1 mirror_XX1_M22_XX1_M15__ABBA_0.x1_net7 Vss sky130_fd_pr__nfet_01v8_lvt ad=1.45 pd=10.58 as=1.45 ps=10.58 w=5 l=20
X11 Vss Vss Vss Vss sky130_fd_pr__nfet_01v8_lvt ad=0.29 pd=2.58 as=0 ps=0 w=1 l=10
X12 Vdd Vdd Vdd Vdd sky130_fd_pr__pfet_01v8_lvt ad=0.29 pd=2.58 as=0 ps=0 w=1 l=10
X13 nmos_differential_pair__ABBA_0.x1_Vtest2 pmos_current_mirror_load__ABAB_0.x1_Vout Vdd Vdd sky130_fd_pr__pfet_01v8_lvt ad=0.145 pd=1.29 as=0.29 ps=2.58 w=1 l=5
X14 Vdd XC2__A_0.Vom1 Vop Vdd sky130_fd_pr__pfet_01v8_lvt ad=0.29 pd=2.58 as=0.145 ps=1.29 w=1 l=1
X15 XC1__A_0.Vop1 Vom sky130_fd_pr__cap_mim_m3_1 l=10 w=10
X16 Vdd nmos_single__A_0.net2 nmos_single__A_0.net2 Vdd sky130_fd_pr__pfet_01v8_lvt ad=1.45 pd=10.58 as=1.45 ps=10.58 w=5 l=1
X17 res_packs__interleaved_0.x2_x1_net3 res_packs__interleaved_0.x2_x1_net15 sky130_fd_pr__res_generic_po w=0.5 l=40
X18 res_packs__interleaved_0.x2_x1_net10 res_packs__interleaved_0.x2_x1_net9 sky130_fd_pr__res_generic_po w=0.5 l=40
X19 Vom XC1__A_0.Vop1 Vdd Vdd sky130_fd_pr__pfet_01v8_lvt ad=0.145 pd=1.29 as=0.29 ps=2.58 w=1 l=1
X20 res_packs__interleaved_0.x2_x2_net14 res_packs__interleaved_0.x2_x2_net15 sky130_fd_pr__res_generic_po w=0.5 l=40
X21 nmos_differential_pair__ABBA_0.x1_net1 Vp nmos_differential_pair__ABBA_0.x1_net2 Vss sky130_fd_pr__nfet_01v8_lvt ad=1.16 pd=8.58 as=1.16 ps=8.58 w=4 l=4
X22 Vdd nmos_single__A_0.net2 nmos_single_2__A_0.PBias Vdd sky130_fd_pr__pfet_01v8_lvt ad=1.45 pd=10.58 as=1.45 ps=10.58 w=5 l=1
X23 res_packs__interleaved_0.x2_x2_net4 res_packs__interleaved_0.x2_x2_net5 sky130_fd_pr__res_generic_po w=0.5 l=40
X24 Vom XC1__A_0.Vop1 Vdd Vdd sky130_fd_pr__pfet_01v8_lvt ad=0.145 pd=1.29 as=0.29 ps=2.58 w=1 l=1
X25 res_packs__interleaved_0.x2_x2_net12 res_packs__interleaved_0.x2_x2_net13 sky130_fd_pr__res_generic_po w=0.5 l=40
X26 Vom XC1__A_0.Vop1 Vdd Vdd sky130_fd_pr__pfet_01v8_lvt ad=0.145 pd=1.29 as=0.29 ps=2.58 w=1 l=1
X27 res_packs__interleaved_0.x2_x2_net1 res_packs__interleaved_0.x2_x2_net7 sky130_fd_pr__res_generic_po w=0.5 l=40
X28 Vss nmos_current_mirror_4__A_0.net4 nmos_matched_cascode_pair__ABBA_0.x1_net3 Vss sky130_fd_pr__nfet_01v8_lvt ad=0.29 pd=2.58 as=0.29 ps=2.58 w=1 l=10
X29 Vss nmos_diode_2__A_0.net5 nmos_diode_2__A_0.net5 Vss sky130_fd_pr__nfet_01v8_lvt ad=0.174 pd=1.78 as=0.174 ps=1.78 w=0.6 l=5
X30 Vdd nmos_single_2__A_0.PBias nmos_single_2__A_0.NBias Vdd sky130_fd_pr__pfet_01v8_lvt ad=1.45 pd=10.58 as=1.45 ps=10.58 w=5 l=1
X31 nmos_matched_cascode_pair__ABBA_0.x1_net3 nmos_diode_2__A_0.net5 nmos_differential_pair__ABBA_0.x1_net2 Vss sky130_fd_pr__nfet_01v8_lvt ad=0.29 pd=2.58 as=0.29 ps=2.58 w=1 l=1
X32 res_packs__interleaved_0.x2_x1_net6 res_packs__interleaved_0.x2_x1_net7 sky130_fd_pr__res_generic_po w=0.5 l=40
X33 Vdd pmos_current_mirror_load__ABAB_0.x1_net9 pmos_current_mirror_load__ABAB_0.x1_Vout Vdd sky130_fd_pr__pfet_01v8_lvt ad=0.29 pd=2.58 as=0.29 ps=2.58 w=1 l=10
X34 Vdd Vdd Vdd Vdd sky130_fd_pr__pfet_01v8_lvt ad=1.45 pd=10.58 as=0 ps=0 w=5 l=1
X35 Vss Vss Vss Vss sky130_fd_pr__nfet_01v8_lvt ad=0.145 pd=1.58 as=0 ps=0 w=0.5 l=20
X36 Vss Vss Vss Vss sky130_fd_pr__nfet_01v8_lvt ad=1.45 pd=10.58 as=0 ps=0 w=5 l=20
X37 Vom XC1__A_0.Vop1 Vdd Vdd sky130_fd_pr__pfet_01v8_lvt ad=0.145 pd=1.29 as=0.29 ps=2.58 w=1 l=1
X38 Vdd pmos_current_mirror_load__ABAB_0.x1_Vout nmos_differential_pair__ABBA_0.x1_Vtest2 Vdd sky130_fd_pr__pfet_01v8_lvt ad=0.29 pd=2.58 as=0.145 ps=1.29 w=1 l=5
X39 Vdd Vdd Vdd Vdd sky130_fd_pr__pfet_01v8_lvt ad=0.29 pd=2.58 as=0 ps=0 w=1 l=5
X40 Vss Vss Vss Vss sky130_fd_pr__nfet_01v8_lvt ad=1.45 pd=10.58 as=0 ps=0 w=5 l=20
X41 Vss nmos_current_mirror_4__A_0.net4 nmos_current_mirror_4__A_0.net4 Vss sky130_fd_pr__nfet_01v8_lvt ad=0.29 pd=2.58 as=0.29 ps=2.58 w=1 l=2
X42 Vom XC1__A_0.Vop1 Vdd Vdd sky130_fd_pr__pfet_01v8_lvt ad=0.145 pd=1.29 as=0.29 ps=2.58 w=1 l=1
X43 Vdd Vdd Vdd Vdd sky130_fd_pr__pfet_01v8_lvt ad=1.45 pd=10.58 as=0 ps=0 w=5 l=1
X44 Vop XC2__A_0.Vom1 Vdd Vdd sky130_fd_pr__pfet_01v8_lvt ad=0.145 pd=1.29 as=0.29 ps=2.58 w=1 l=1
X45 Vdd pmos_current_mirror_load__ABAB_0.x1_Vout nmos_differential_pair__ABBA_0.x1_net1 Vdd sky130_fd_pr__pfet_01v8_lvt ad=0.29 pd=2.58 as=0.145 ps=1.29 w=1 l=5
X46 nmos_differential_pair__ABBA_0.x1_net2 Vm nmos_differential_pair__ABBA_0.x1_Vtest2 Vss sky130_fd_pr__nfet_01v8_lvt ad=1.16 pd=8.58 as=1.16 ps=8.58 w=4 l=4
X47 nmos_single_2__A_0.NBias pmos_diode__A_0.net3 nmos_single_2__A_0.PBias Vss sky130_fd_pr__nfet_01v8_lvt ad=0.58 pd=4.58 as=0.58 ps=4.58 w=2 l=1
X48 res_packs__interleaved_0.x2_x1_net16 res_packs__interleaved_0.x2_Vcm sky130_fd_pr__res_generic_po w=0.5 l=40
X49 Vss nmos_current_mirror_4__A_0.net4 mirror_XX1_M22_XX1_M15__ABBA_0.x1_net7 Vss sky130_fd_pr__nfet_01v8_lvt ad=0.29 pd=2.58 as=0.29 ps=2.58 w=1 l=20
X50 Vdd XC2__A_0.Vom1 Vop Vdd sky130_fd_pr__pfet_01v8_lvt ad=0.29 pd=2.58 as=0.145 ps=1.29 w=1 l=1
X51 nmos_current_mirror_3__ABBA_0.net7 nmos_current_mirror_3__ABBA_0.net7 Vss Vss sky130_fd_pr__nfet_01v8_lvt ad=0.174 pd=1.78 as=0.174 ps=1.78 w=0.6 l=1
X52 nmos_differential_pair__ABBA_0.x1_Vtest2 pmos_current_mirror_load__ABAB_0.x1_Vout Vdd Vdd sky130_fd_pr__pfet_01v8_lvt ad=0.145 pd=1.29 as=0.29 ps=2.58 w=1 l=5
X53 Vss nmos_current_mirror_4__A_0.net4 mirror_XX1_M22_XX1_M15__ABBA_0.x1_net8 Vss sky130_fd_pr__nfet_01v8_lvt ad=0.29 pd=2.58 as=0.29 ps=2.58 w=1 l=20
X54 Vdd XC1__A_0.Vop1 Vom Vdd sky130_fd_pr__pfet_01v8_lvt ad=0.29 pd=2.58 as=0.145 ps=1.29 w=1 l=1
X55 RGM nmos_diode__A_0.net1 nmos_diode__A_0.net1 Vss sky130_fd_pr__nfet_01v8_lvt ad=2.9 pd=20.58 as=2.9 ps=20.58 w=10 l=1
X56 Vdd Vdd Vdd Vdd sky130_fd_pr__pfet_01v8_lvt ad=0.29 pd=2.58 as=0 ps=0 w=1 l=10
X57 XC1__A_0.Vop1 pmos_diode_2__A_0.x1_Vbias nmos_differential_pair__ABBA_0.x1_Vtest2 Vdd sky130_fd_pr__pfet_01v8_lvt ad=0.145 pd=1.29 as=0.29 ps=2.58 w=1 l=5
X58 nmos_matched_cascode_pair_2__ABBA_0.x1_net4 nmos_diode_2__A_0.net5 nmos_differential_pair__ABBA_0.x1_net2 Vss sky130_fd_pr__nfet_01v8_lvt ad=0.29 pd=2.58 as=0.29 ps=2.58 w=1 l=1
X59 res_packs__interleaved_0.x2_x2_net18 res_packs__interleaved_0.x2_x2_net19 sky130_fd_pr__res_generic_po w=0.5 l=40
X60 res_packs__interleaved_0.x2_x1_net12 res_packs__interleaved_0.x2_x1_net2 sky130_fd_pr__res_generic_po w=0.5 l=40
X61 nmos_differential_pair__ABBA_0.x1_net1 pmos_current_mirror_load__ABAB_0.x1_Vout Vdd Vdd sky130_fd_pr__pfet_01v8_lvt ad=0.145 pd=1.29 as=0.29 ps=2.58 w=1 l=5
X62 Vss nmos_current_mirror_3__ABBA_0.net7 nmos_current_mirror_3__ABBA_0.net7 Vss sky130_fd_pr__nfet_01v8_lvt ad=0.174 pd=1.78 as=0.174 ps=1.78 w=0.6 l=1
X63 Vss Vss Vss Vss sky130_fd_pr__nfet_01v8_lvt ad=1.45 pd=10.58 as=0 ps=0 w=5 l=20
X64 XC2__A_0.Vom1 Vop sky130_fd_pr__cap_mim_m3_1 l=10 w=10
X65 Vdd Vdd Vdd Vdd sky130_fd_pr__pfet_01v8_lvt ad=1.45 pd=10.58 as=0 ps=0 w=5 l=1
X66 nmos_differential_pair__ABBA_0.x1_net1 pmos_current_mirror_load__ABAB_0.x1_Vout Vdd Vdd sky130_fd_pr__pfet_01v8_lvt ad=0.145 pd=1.29 as=0.29 ps=2.58 w=1 l=5
X67 Vdd XC2__A_0.Vom1 Vop Vdd sky130_fd_pr__pfet_01v8_lvt ad=0.29 pd=2.58 as=0.145 ps=1.29 w=1 l=1
X68 res_packs__interleaved_0.x2_x1_net14 res_packs__interleaved_0.x2_x1_net15 sky130_fd_pr__res_generic_po w=0.5 l=40
X69 Vdd pmos_current_mirror_load__ABAB_0.x1_net9 pmos_current_mirror_load__ABAB_0.x1_net9 Vdd sky130_fd_pr__pfet_01v8_lvt ad=0.29 pd=2.58 as=0.29 ps=2.58 w=1 l=10
X70 Vss Vss Vss Vss sky130_fd_pr__nfet_01v8_lvt ad=1.45 pd=10.58 as=0 ps=0 w=5 l=20
X71 XC1__A_0.Vop1 Vom sky130_fd_pr__cap_mim_m3_1 l=10 w=10
X72 res_packs__interleaved_0.x2_x2_net10 res_packs__interleaved_0.x2_x2_net9 sky130_fd_pr__res_generic_po w=0.5 l=40
X73 Vss pmos_differential_pair__ABBA_0.x2_Vout Vom Vss sky130_fd_pr__nfet_01v8_lvt ad=0.29 pd=2.58 as=0.29 ps=2.58 w=1 l=1
X74 Vdd nmos_single_2__A_0.PBias nmos_current_mirror_3__ABBA_0.net7 Vdd sky130_fd_pr__pfet_01v8_lvt ad=1.45 pd=10.58 as=1.45 ps=10.58 w=5 l=1
X75 Vss nmos_current_mirror_4__A_0.net4 nmos_matched_cascode_pair_2__ABBA_0.x1_net6 Vss sky130_fd_pr__nfet_01v8_lvt ad=0.29 pd=2.58 as=0.29 ps=2.58 w=1 l=10
X76 XC2__A_0.Vom1 Vop sky130_fd_pr__cap_mim_m3_1 l=10 w=10
X77 Vss pmos_differential_pair__ABBA_0.x2_Vout Vom Vss sky130_fd_pr__nfet_01v8_lvt ad=0.29 pd=2.58 as=0.29 ps=2.58 w=1 l=1
X78 nmos_current_mirror_2__ABBA_0.net6 nmos_single_2__A_0.PBias Vdd Vdd sky130_fd_pr__pfet_01v8_lvt ad=1.45 pd=10.58 as=1.45 ps=10.58 w=5 l=1
X79 Vdd XC2__A_0.Vom1 Vop Vdd sky130_fd_pr__pfet_01v8_lvt ad=0.29 pd=2.58 as=0.145 ps=1.29 w=1 l=1
X80 XC2__A_0.Vom1 pmos_diode_2__A_0.x1_Vbias nmos_differential_pair__ABBA_0.x1_net1 Vdd sky130_fd_pr__pfet_01v8_lvt ad=0.145 pd=1.29 as=0.29 ps=2.58 w=1 l=5
X81 Vdd Vdd Vdd Vdd sky130_fd_pr__pfet_01v8_lvt ad=0.145 pd=1.29 as=0 ps=0 w=1 l=5
X82 Vss Vss Vss Vss sky130_fd_pr__nfet_01v8_lvt ad=0.29 pd=2.58 as=0 ps=0 w=1 l=1
X83 res_packs__interleaved_0.x2_x1_net10 res_packs__interleaved_0.x2_x1_net11 sky130_fd_pr__res_generic_po w=0.5 l=40
X84 Vss pmos_differential_pair__ABBA_0.x2_Vtest pmos_differential_pair__ABBA_0.x2_Vout Vss sky130_fd_pr__nfet_01v8_lvt ad=0.145 pd=1.58 as=0.145 ps=1.58 w=0.5 l=20
X85 nmos_single_2__A_0.PBias nmos_single_2__A_0.NBias Vss Vss sky130_fd_pr__nfet_01v8_lvt ad=1.45 pd=10.58 as=1.45 ps=10.58 w=5 l=2
X86 XC1__A_0.Vop1 Vom sky130_fd_pr__cap_mim_m3_1 l=10 w=10
X87 res_packs__interleaved_0.x2_x2_net4 res_packs__interleaved_0.x2_Vcm sky130_fd_pr__res_generic_po w=0.5 l=40
X88 Vdd pmos_current_mirror_load__ABAB_0.x1_Vout nmos_differential_pair__ABBA_0.x1_Vtest2 Vdd sky130_fd_pr__pfet_01v8_lvt ad=0.29 pd=2.58 as=0.145 ps=1.29 w=1 l=5
X89 Vdd Vdd Vdd Vdd sky130_fd_pr__pfet_01v8_lvt ad=1.74 pd=12.58 as=0 ps=0 w=6 l=1
X90 Vss pmos_differential_pair__ABBA_0.x2_Vout Vom Vss sky130_fd_pr__nfet_01v8_lvt ad=0.29 pd=2.58 as=0.29 ps=2.58 w=1 l=1
X91 Vss pmos_differential_pair__ABBA_0.x2_Vout Vop Vss sky130_fd_pr__nfet_01v8_lvt ad=0.29 pd=2.58 as=0.29 ps=2.58 w=1 l=1
X92 Vom XC1__A_0.Vop1 Vdd Vdd sky130_fd_pr__pfet_01v8_lvt ad=0.145 pd=1.29 as=0.29 ps=2.58 w=1 l=1
X93 Vdd Vdd Vdd Vdd sky130_fd_pr__pfet_01v8_lvt ad=1.45 pd=10.58 as=0 ps=0 w=5 l=1
X94 Vdd pmos_current_mirror_2__row_0.x2_Vbiasp pmos_current_mirror_2__row_0.x2_Vbiasp Vdd sky130_fd_pr__pfet_01v8_lvt ad=1.74 pd=12.58 as=1.74 ps=12.58 w=6 l=1
X95 Vop XC2__A_0.Vom1 Vdd Vdd sky130_fd_pr__pfet_01v8_lvt ad=0.145 pd=1.29 as=0.29 ps=2.58 w=1 l=1
X96 Vss pmos_differential_pair__ABBA_0.x2_Vout Vop Vss sky130_fd_pr__nfet_01v8_lvt ad=0.29 pd=2.58 as=0.29 ps=2.58 w=1 l=1
X97 Vdd pmos_current_mirror_load__ABAB_0.x1_net9 pmos_current_mirror_load__ABAB_0.x1_net9 Vdd sky130_fd_pr__pfet_01v8_lvt ad=0.29 pd=2.58 as=0.29 ps=2.58 w=1 l=10
X98 mirror_XX1_M22_XX1_M15__ABBA_0.x1_net7 nmos_current_mirror_4__A_0.net4 Vss Vss sky130_fd_pr__nfet_01v8_lvt ad=0.29 pd=2.58 as=0.29 ps=2.58 w=1 l=20
X99 Vss pmos_differential_pair__ABBA_0.x2_Vout Vop Vss sky130_fd_pr__nfet_01v8_lvt ad=0.29 pd=2.58 as=0.29 ps=2.58 w=1 l=1
X100 Vop XC2__A_0.Vom1 Vdd Vdd sky130_fd_pr__pfet_01v8_lvt ad=0.145 pd=1.29 as=0.29 ps=2.58 w=1 l=1
X101 Vss pmos_differential_pair__ABBA_0.x2_Vout Vop Vss sky130_fd_pr__nfet_01v8_lvt ad=0.29 pd=2.58 as=0.29 ps=2.58 w=1 l=1
X102 Vdd pmos_current_mirror_load__ABAB_0.x1_Vout nmos_differential_pair__ABBA_0.x1_net1 Vdd sky130_fd_pr__pfet_01v8_lvt ad=0.29 pd=2.58 as=0.145 ps=1.29 w=1 l=5
X103 nmos_differential_pair__ABBA_0.x1_Vtest2 pmos_diode_2__A_0.x1_Vbias XC1__A_0.Vop1 Vdd sky130_fd_pr__pfet_01v8_lvt ad=0.29 pd=2.58 as=0.145 ps=1.29 w=1 l=5
X104 Vdd Vdd Vdd Vdd sky130_fd_pr__pfet_01v8_lvt ad=1.45 pd=10.58 as=0 ps=0 w=5 l=1
X105 nmos_differential_pair__ABBA_0.x1_net2 nmos_diode_2__A_0.net5 nmos_matched_cascode_pair__ABBA_0.x1_net3 Vss sky130_fd_pr__nfet_01v8_lvt ad=0.29 pd=2.58 as=0.29 ps=2.58 w=1 l=1
X106 res_packs__interleaved_0.x2_x2_net6 res_packs__interleaved_0.x2_x2_net7 sky130_fd_pr__res_generic_po w=0.5 l=40
X107 Vss pmos_differential_pair__ABBA_0.x2_Vout Vom Vss sky130_fd_pr__nfet_01v8_lvt ad=0.29 pd=2.58 as=0.29 ps=2.58 w=1 l=1
X108 Vdd XC1__A_0.Vop1 Vom Vdd sky130_fd_pr__pfet_01v8_lvt ad=0.29 pd=2.58 as=0.145 ps=1.29 w=1 l=1
X109 nmos_differential_pair__ABBA_0.x1_Vtest2 pmos_diode_2__A_0.x1_Vbias XC1__A_0.Vop1 Vdd sky130_fd_pr__pfet_01v8_lvt ad=0.29 pd=2.58 as=0.145 ps=1.29 w=1 l=5
X110 Vdd Vdd Vdd Vdd sky130_fd_pr__pfet_01v8_lvt ad=1.45 pd=10.58 as=0 ps=0 w=5 l=1
X111 Vss pmos_differential_pair__ABBA_0.x2_Vout Vom Vss sky130_fd_pr__nfet_01v8_lvt ad=0.29 pd=2.58 as=0.29 ps=2.58 w=1 l=1
X112 Vdd nmos_single__A_0.net2 nmos_single__A_0.net2 Vdd sky130_fd_pr__pfet_01v8_lvt ad=1.45 pd=10.58 as=1.45 ps=10.58 w=5 l=1
X113 Vss nmos_current_mirror_4__A_0.net4 nmos_matched_cascode_pair_2__ABBA_0.x1_net4 Vss sky130_fd_pr__nfet_01v8_lvt ad=0.29 pd=2.58 as=0.29 ps=2.58 w=1 l=10
X114 Vdd pmos_diode_2__A_0.x1_Vbias pmos_diode_2__A_0.x1_Vbias Vdd sky130_fd_pr__pfet_01v8_lvt ad=0.435 pd=3.58 as=0.435 ps=3.58 w=1.5 l=10
X115 nmos_differential_pair__ABBA_0.x1_Vtest2 Vm nmos_differential_pair__ABBA_0.x1_net2 Vss sky130_fd_pr__nfet_01v8_lvt ad=1.16 pd=8.58 as=1.16 ps=8.58 w=4 l=4
X116 Vss Vss Vss Vss sky130_fd_pr__nfet_01v8_lvt ad=0.29 pd=2.58 as=0 ps=0 w=1 l=1
X117 res_packs__interleaved_0.x2_x2_net16 Vom sky130_fd_pr__res_generic_po w=0.5 l=40
X118 res_packs__interleaved_0.x2_x2_net14 res_packs__interleaved_0.x2_x2_net13 sky130_fd_pr__res_generic_po w=0.5 l=40
X119 Vom XC1__A_0.Vop1 Vdd Vdd sky130_fd_pr__pfet_01v8_lvt ad=0.145 pd=1.29 as=0.29 ps=2.58 w=1 l=1
X120 Vss pmos_differential_pair__ABBA_0.x2_Vout Vop Vss sky130_fd_pr__nfet_01v8_lvt ad=0.29 pd=2.58 as=0.29 ps=2.58 w=1 l=1
X121 Vss pmos_differential_pair__ABBA_0.x2_Vtest pmos_differential_pair__ABBA_0.x2_Vtest Vss sky130_fd_pr__nfet_01v8_lvt ad=0.145 pd=1.58 as=0.145 ps=1.58 w=0.5 l=20
X122 Vdd Vdd Vdd Vdd sky130_fd_pr__pfet_01v8_lvt ad=0.29 pd=2.58 as=0 ps=0 w=1 l=5
X123 Vss nmos_current_mirror_4__A_0.net4 nmos_matched_cascode_pair__ABBA_0.x1_net5 Vss sky130_fd_pr__nfet_01v8_lvt ad=0.29 pd=2.58 as=0.29 ps=2.58 w=1 l=10
X124 Vdd pmos_diode_2__A_0.x1_Vbias pmos_diode_2__A_0.x1_Vbias Vdd sky130_fd_pr__pfet_01v8_lvt ad=0.435 pd=3.58 as=0.435 ps=3.58 w=1.5 l=10
X125 XC1__A_0.Vop1 nmos_diode_2__A_0.net5 nmos_matched_cascode_pair__ABBA_0.x1_net5 Vss sky130_fd_pr__nfet_01v8_lvt ad=0.29 pd=2.58 as=0.29 ps=2.58 w=1 l=1
X126 Vdd XC2__A_0.Vom1 Vop Vdd sky130_fd_pr__pfet_01v8_lvt ad=0.29 pd=2.58 as=0.145 ps=1.29 w=1 l=1
X127 Vss Vss sky130_fd_pr__res_generic_po w=0.5 l=40
X128 Vss nmos_current_mirror_4__A_0.net4 nmos_matched_cascode_pair__ABBA_0.x1_net5 Vss sky130_fd_pr__nfet_01v8_lvt ad=0.29 pd=2.58 as=0.29 ps=2.58 w=1 l=10
X129 nmos_differential_pair__ABBA_0.x1_net2 nmos_diode_2__A_0.net5 nmos_matched_cascode_pair_2__ABBA_0.x1_net4 Vss sky130_fd_pr__nfet_01v8_lvt ad=0.29 pd=2.58 as=0.29 ps=2.58 w=1 l=1
X130 pmos_current_mirror_2__row_0.x2_net1 res_packs__interleaved_0.x2_Vcm pmos_differential_pair__ABBA_0.x2_Vtest Vdd sky130_fd_pr__pfet_01v8_lvt ad=0.29 pd=2.58 as=0.29 ps=2.58 w=1 l=10
X131 Vdd pmos_current_mirror_2__row_0.x2_Vbiasp pmos_current_mirror_2__row_0.x2_net1 Vdd sky130_fd_pr__pfet_01v8_lvt ad=0.29 pd=2.58 as=0.29 ps=2.58 w=1 l=5
X132 res_packs__interleaved_0.x2_x1_net18 res_packs__interleaved_0.x2_x1_net19 sky130_fd_pr__res_generic_po w=0.5 l=40
X133 res_packs__interleaved_0.x2_x1_net8 res_packs__interleaved_0.x2_x1_net2 sky130_fd_pr__res_generic_po w=0.5 l=40
X134 Vdd Vdd Vdd Vdd sky130_fd_pr__pfet_01v8_lvt ad=0.29 pd=2.58 as=0 ps=0 w=1 l=5
X135 Vdd XC1__A_0.Vop1 Vom Vdd sky130_fd_pr__pfet_01v8_lvt ad=0.29 pd=2.58 as=0.145 ps=1.29 w=1 l=1
X136 res_packs__interleaved_0.x2_x2_net8 res_packs__interleaved_0.x2_x2_net9 sky130_fd_pr__res_generic_po w=0.5 l=40
X137 pmos_differential_pair__ABBA_0.x2_Vout pmos_differential_pair__ABBA_0.x2_Vtest Vss Vss sky130_fd_pr__nfet_01v8_lvt ad=0.145 pd=1.58 as=0.145 ps=1.58 w=0.5 l=20
X138 Vss nmos_current_mirror_4__A_0.net4 nmos_current_mirror_4__A_0.net4 Vss sky130_fd_pr__nfet_01v8_lvt ad=0.29 pd=2.58 as=0.29 ps=2.58 w=1 l=2
X139 Vss nmos_current_mirror_2__ABBA_0.net6 pmos_diode_2__A_0.x1_Vbias Vss sky130_fd_pr__nfet_01v8_lvt ad=0.174 pd=1.78 as=0.174 ps=1.78 w=0.6 l=1
X140 Vdd Vdd Vdd Vdd sky130_fd_pr__pfet_01v8_lvt ad=1.45 pd=10.58 as=0 ps=0 w=5 l=1
X141 nmos_matched_cascode_pair__ABBA_0.x1_net5 nmos_diode_2__A_0.net5 XC1__A_0.Vop1 Vss sky130_fd_pr__nfet_01v8_lvt ad=0.29 pd=2.58 as=0.29 ps=2.58 w=1 l=1
X142 Vss nmos_current_mirror_4__A_0.net4 nmos_matched_cascode_pair_2__ABBA_0.x1_net6 Vss sky130_fd_pr__nfet_01v8_lvt ad=0.29 pd=2.58 as=0.29 ps=2.58 w=1 l=10
X143 res_packs__interleaved_0.x2_x2_net10 res_packs__interleaved_0.x2_x2_net11 sky130_fd_pr__res_generic_po w=0.5 l=40
X144 Vss Vss Vss Vss sky130_fd_pr__nfet_01v8_lvt ad=0.29 pd=2.58 as=0 ps=0 w=1 l=1
X145 Vop XC2__A_0.Vom1 Vdd Vdd sky130_fd_pr__pfet_01v8_lvt ad=0.145 pd=1.29 as=0.29 ps=2.58 w=1 l=1
X146 Vss nmos_current_mirror_2__ABBA_0.net6 nmos_current_mirror_2__ABBA_0.net6 Vss sky130_fd_pr__nfet_01v8_lvt ad=0.174 pd=1.78 as=0.174 ps=1.78 w=0.6 l=1
X147 Vss nmos_current_mirror_3__ABBA_0.net7 pmos_current_mirror_2__row_0.x2_Vbiasp Vss sky130_fd_pr__nfet_01v8_lvt ad=0.174 pd=1.78 as=0.174 ps=1.78 w=0.6 l=1
X148 res_packs__interleaved_0.x2_x1_net1 res_packs__interleaved_0.x2_x1_net11 sky130_fd_pr__res_generic_po w=0.5 l=40
X149 XC2__A_0.Vom1 nmos_diode_2__A_0.net5 nmos_matched_cascode_pair_2__ABBA_0.x1_net6 Vss sky130_fd_pr__nfet_01v8_lvt ad=0.29 pd=2.58 as=0.29 ps=2.58 w=1 l=1
X150 XC2__A_0.Vom1 Vop sky130_fd_pr__cap_mim_m3_1 l=10 w=10
X151 pmos_current_mirror_load__ABAB_0.x1_net9 XC1__A_0.Vop1 mirror_XX1_M22_XX1_M15__ABBA_0.x1_net8 Vss sky130_fd_pr__nfet_01v8_lvt ad=1.45 pd=10.58 as=1.45 ps=10.58 w=5 l=20
X152 Vss Vss Vss Vss sky130_fd_pr__nfet_01v8_lvt ad=0.29 pd=2.58 as=0 ps=0 w=1 l=20
X153 pmos_current_mirror_2__row_0.x2_Vbiasp nmos_current_mirror_3__ABBA_0.net7 Vss Vss sky130_fd_pr__nfet_01v8_lvt ad=0.174 pd=1.78 as=0.174 ps=1.78 w=0.6 l=1
X154 Vop XC2__A_0.Vom1 Vdd Vdd sky130_fd_pr__pfet_01v8_lvt ad=0.145 pd=1.29 as=0.29 ps=2.58 w=1 l=1
X155 XC1__A_0.Vop1 Vom sky130_fd_pr__cap_mim_m3_1 l=10 w=10
X156 Vss Vss Vss Vss sky130_fd_pr__nfet_01v8_lvt ad=0.174 pd=1.78 as=0 ps=0 w=0.6 l=1
X157 Vss Vss Vss Vss sky130_fd_pr__nfet_01v8_lvt ad=0.29 pd=2.58 as=0 ps=0 w=1 l=20
X158 res_packs__interleaved_0.x2_x2_net3 res_packs__interleaved_0.x2_x2_net19 sky130_fd_pr__res_generic_po w=0.5 l=40
X159 RGM nmos_diode__A_0.net1 nmos_diode__A_0.net1 Vss sky130_fd_pr__nfet_01v8_lvt ad=2.9 pd=20.58 as=2.9 ps=20.58 w=10 l=1
X160 Vdd pmos_current_mirror_2__row_0.x2_Vbiasp pmos_current_mirror_2__row_0.x2_Vbiasp Vdd sky130_fd_pr__pfet_01v8_lvt ad=1.74 pd=12.58 as=1.74 ps=12.58 w=6 l=1
X161 nmos_current_mirror_2__ABBA_0.net6 nmos_current_mirror_2__ABBA_0.net6 Vss Vss sky130_fd_pr__nfet_01v8_lvt ad=0.174 pd=1.78 as=0.174 ps=1.78 w=0.6 l=1
X162 Vss nmos_current_mirror_4__A_0.net4 nmos_matched_cascode_pair_2__ABBA_0.x1_net4 Vss sky130_fd_pr__nfet_01v8_lvt ad=0.29 pd=2.58 as=0.29 ps=2.58 w=1 l=10
X163 nmos_matched_cascode_pair_2__ABBA_0.x1_net6 nmos_diode_2__A_0.net5 XC2__A_0.Vom1 Vss sky130_fd_pr__nfet_01v8_lvt ad=0.29 pd=2.58 as=0.29 ps=2.58 w=1 l=1
X164 Vom XC1__A_0.Vop1 Vdd Vdd sky130_fd_pr__pfet_01v8_lvt ad=0.145 pd=1.29 as=0.29 ps=2.58 w=1 l=1
X165 Vdd XC1__A_0.Vop1 Vom Vdd sky130_fd_pr__pfet_01v8_lvt ad=0.29 pd=2.58 as=0.145 ps=1.29 w=1 l=1
X166 pmos_diode_2__A_0.x1_Vbias nmos_current_mirror_2__ABBA_0.net6 Vss Vss sky130_fd_pr__nfet_01v8_lvt ad=0.174 pd=1.78 as=0.174 ps=1.78 w=0.6 l=1
X167 Vdd nmos_single_2__A_0.PBias nmos_diode_2__A_0.net5 Vdd sky130_fd_pr__pfet_01v8_lvt ad=1.45 pd=10.58 as=1.45 ps=10.58 w=5 l=1
X168 Vss Vss Vss Vss sky130_fd_pr__nfet_01v8_lvt ad=0.29 pd=2.58 as=0 ps=0 w=1 l=1
X169 Vdd XC2__A_0.Vom1 Vop Vdd sky130_fd_pr__pfet_01v8_lvt ad=0.29 pd=2.58 as=0.145 ps=1.29 w=1 l=1
X170 Vss Vss Vss Vss sky130_fd_pr__nfet_01v8_lvt ad=0.174 pd=1.78 as=0 ps=0 w=0.6 l=1
X171 Vss nmos_single_2__A_0.NBias pmos_diode__A_0.net3 Vss sky130_fd_pr__nfet_01v8_lvt ad=1.45 pd=10.58 as=1.45 ps=10.58 w=5 l=2
X172 res_packs__interleaved_0.x2_x2_net16 res_packs__interleaved_0.x2_x2_net17 sky130_fd_pr__res_generic_po w=0.5 l=40
X173 res_packs__interleaved_0.x2_x1_net14 res_packs__interleaved_0.x2_x1_net13 sky130_fd_pr__res_generic_po w=0.5 l=40
X174 pmos_diode__A_0.net3 nmos_single_2__A_0.NBias Vss Vss sky130_fd_pr__nfet_01v8_lvt ad=1.45 pd=10.58 as=1.45 ps=10.58 w=5 l=2
X175 res_packs__interleaved_0.x2_x1_net4 Vop sky130_fd_pr__res_generic_po w=0.5 l=40
X176 nmos_differential_pair__ABBA_0.x1_Vtest2 pmos_current_mirror_load__ABAB_0.x1_Vout Vdd Vdd sky130_fd_pr__pfet_01v8_lvt ad=0.145 pd=1.29 as=0.29 ps=2.58 w=1 l=5
X177 Vdd pmos_current_mirror_2__row_0.x2_Vbiasp pmos_current_mirror_2__row_0.x2_net1 Vdd sky130_fd_pr__pfet_01v8_lvt ad=0.29 pd=2.58 as=0.29 ps=2.58 w=1 l=5
X178 Vss Vss Vss Vss sky130_fd_pr__nfet_01v8_lvt ad=0.145 pd=1.58 as=0 ps=0 w=0.5 l=20
X179 Vdd nmos_single__A_0.net2 nmos_single_2__A_0.PBias Vdd sky130_fd_pr__pfet_01v8_lvt ad=1.45 pd=10.58 as=1.45 ps=10.58 w=5 l=1
X180 Vss Vss Vss Vss sky130_fd_pr__nfet_01v8_lvt ad=0.29 pd=2.58 as=0 ps=0 w=1 l=1
X181 pmos_differential_pair__ABBA_0.x2_Vtest pmos_differential_pair__ABBA_0.x2_Vtest Vss Vss sky130_fd_pr__nfet_01v8_lvt ad=0.145 pd=1.58 as=0.145 ps=1.58 w=0.5 l=20
X182 res_packs__interleaved_0.x2_x1_net3 res_packs__interleaved_0.x2_x1_net19 sky130_fd_pr__res_generic_po w=0.5 l=40
X183 res_packs__interleaved_0.x2_x2_net8 res_packs__interleaved_0.x2_x2_net2 sky130_fd_pr__res_generic_po w=0.5 l=40
X184 res_packs__interleaved_0.x2_x2_net6 res_packs__interleaved_0.x2_x2_net5 sky130_fd_pr__res_generic_po w=0.5 l=40
X185 pmos_current_mirror_load__ABAB_0.x1_Vout VREF mirror_XX1_M22_XX1_M15__ABBA_0.x1_net7 Vss sky130_fd_pr__nfet_01v8_lvt ad=1.45 pd=10.58 as=1.45 ps=10.58 w=5 l=20
X186 Vss nmos_current_mirror_4__A_0.net4 nmos_matched_cascode_pair__ABBA_0.x1_net3 Vss sky130_fd_pr__nfet_01v8_lvt ad=0.29 pd=2.58 as=0.29 ps=2.58 w=1 l=10
X187 Vss pmos_differential_pair__ABBA_0.x2_Vout Vom Vss sky130_fd_pr__nfet_01v8_lvt ad=0.29 pd=2.58 as=0.29 ps=2.58 w=1 l=1
X188 Vdd XC1__A_0.Vop1 Vom Vdd sky130_fd_pr__pfet_01v8_lvt ad=0.29 pd=2.58 as=0.145 ps=1.29 w=1 l=1
X189 res_packs__interleaved_0.x2_x1_net8 res_packs__interleaved_0.x2_x1_net9 sky130_fd_pr__res_generic_po w=0.5 l=40
X190 nmos_differential_pair__ABBA_0.x1_net1 pmos_current_mirror_load__ABAB_0.x1_Vout Vdd Vdd sky130_fd_pr__pfet_01v8_lvt ad=0.145 pd=1.29 as=0.29 ps=2.58 w=1 l=5
X191 Vdd pmos_current_mirror_load__ABAB_0.x1_Vout nmos_differential_pair__ABBA_0.x1_net1 Vdd sky130_fd_pr__pfet_01v8_lvt ad=0.29 pd=2.58 as=0.145 ps=1.29 w=1 l=5
X192 Vdd nmos_single_2__A_0.PBias nmos_diode__A_0.net1 Vdd sky130_fd_pr__pfet_01v8_lvt ad=1.45 pd=10.58 as=1.45 ps=10.58 w=5 l=1
X193 pmos_current_mirror_2__row_0.x2_net1 VREF pmos_differential_pair__ABBA_0.x2_Vout Vdd sky130_fd_pr__pfet_01v8_lvt ad=0.29 pd=2.58 as=0.29 ps=2.58 w=1 l=10
X194 Vss Vss Vss Vss sky130_fd_pr__nfet_01v8_lvt ad=0.174 pd=1.78 as=0 ps=0 w=0.6 l=1
X195 nmos_single_2__A_0.NBias nmos_single_2__A_0.NBias Vss Vss sky130_fd_pr__nfet_01v8_lvt ad=1.45 pd=10.58 as=1.45 ps=10.58 w=5 l=2
X196 Vop XC2__A_0.Vom1 Vdd Vdd sky130_fd_pr__pfet_01v8_lvt ad=0.145 pd=1.29 as=0.29 ps=2.58 w=1 l=1
X197 Vss pmos_differential_pair__ABBA_0.x2_Vout Vom Vss sky130_fd_pr__nfet_01v8_lvt ad=0.29 pd=2.58 as=0.29 ps=2.58 w=1 l=1
X198 Vss pmos_differential_pair__ABBA_0.x2_Vout Vop Vss sky130_fd_pr__nfet_01v8_lvt ad=0.29 pd=2.58 as=0.29 ps=2.58 w=1 l=1
X199 nmos_differential_pair__ABBA_0.x1_net1 pmos_diode_2__A_0.x1_Vbias XC2__A_0.Vom1 Vdd sky130_fd_pr__pfet_01v8_lvt ad=0.29 pd=2.58 as=0.145 ps=1.29 w=1 l=5
X200 nmos_differential_pair__ABBA_0.x1_net2 Vp nmos_differential_pair__ABBA_0.x1_net1 Vss sky130_fd_pr__nfet_01v8_lvt ad=1.16 pd=8.58 as=1.16 ps=8.58 w=4 l=4
X201 Vss nmos_diode__A_0.net1 nmos_single__A_0.net2 Vss sky130_fd_pr__nfet_01v8_lvt ad=1.45 pd=10.58 as=1.45 ps=10.58 w=5 l=2
X202 XC1__A_0.Vop1 Vom sky130_fd_pr__cap_mim_m3_1 l=10 w=10
X203 mirror_XX1_M22_XX1_M15__ABBA_0.x1_net8 VREF pmos_current_mirror_load__ABAB_0.x1_Vout Vss sky130_fd_pr__nfet_01v8_lvt ad=1.45 pd=10.58 as=1.45 ps=10.58 w=5 l=20
X204 mirror_XX1_M22_XX1_M15__ABBA_0.x1_net8 XC1__A_0.Vop1 pmos_current_mirror_load__ABAB_0.x1_net9 Vss sky130_fd_pr__nfet_01v8_lvt ad=1.45 pd=10.58 as=1.45 ps=10.58 w=5 l=20
X205 Vss nmos_diode__A_0.net1 nmos_single__A_0.net2 Vss sky130_fd_pr__nfet_01v8_lvt ad=1.45 pd=10.58 as=1.45 ps=10.58 w=5 l=2
X206 Vdd Vdd Vdd Vdd sky130_fd_pr__pfet_01v8_lvt ad=0.29 pd=2.58 as=0 ps=0 w=1 l=10
X207 Vdd pmos_current_mirror_load__ABAB_0.x1_Vout nmos_differential_pair__ABBA_0.x1_Vtest2 Vdd sky130_fd_pr__pfet_01v8_lvt ad=0.29 pd=2.58 as=0.145 ps=1.29 w=1 l=5
X208 XC2__A_0.Vom1 pmos_diode_2__A_0.x1_Vbias nmos_differential_pair__ABBA_0.x1_net1 Vdd sky130_fd_pr__pfet_01v8_lvt ad=0.145 pd=1.29 as=0.29 ps=2.58 w=1 l=5
X209 Vdd XC2__A_0.Vom1 Vop Vdd sky130_fd_pr__pfet_01v8_lvt ad=0.29 pd=2.58 as=0.145 ps=1.29 w=1 l=1
X210 res_packs__interleaved_0.x2_x1_net18 res_packs__interleaved_0.x2_x1_net17 sky130_fd_pr__res_generic_po w=0.5 l=40
X211 Vss Vss Vss Vss sky130_fd_pr__nfet_01v8_lvt ad=0.29 pd=2.58 as=0 ps=0 w=1 l=1
X212 Vdd Vdd Vdd Vdd sky130_fd_pr__pfet_01v8_lvt ad=0.145 pd=1.29 as=0 ps=0 w=1 l=5
X213 Vss pmos_differential_pair__ABBA_0.x2_Vout Vop Vss sky130_fd_pr__nfet_01v8_lvt ad=0.29 pd=2.58 as=0.29 ps=2.58 w=1 l=1
X214 Vss pmos_differential_pair__ABBA_0.x2_Vout Vom Vss sky130_fd_pr__nfet_01v8_lvt ad=0.29 pd=2.58 as=0.29 ps=2.58 w=1 l=1
X215 Vdd pmos_current_mirror_load__ABAB_0.x1_Vout nmos_differential_pair__ABBA_0.x1_net1 Vdd sky130_fd_pr__pfet_01v8_lvt ad=0.29 pd=2.58 as=0.145 ps=1.29 w=1 l=5
X216 Vdd Vdd Vdd Vdd sky130_fd_pr__pfet_01v8_lvt ad=1.45 pd=10.58 as=0 ps=0 w=5 l=1
X217 Vdd XC2__A_0.Vom1 Vop Vdd sky130_fd_pr__pfet_01v8_lvt ad=0.29 pd=2.58 as=0.145 ps=1.29 w=1 l=1
X218 XC2__A_0.Vom1 Vop sky130_fd_pr__cap_mim_m3_1 l=10 w=10
X219 Vss pmos_differential_pair__ABBA_0.x2_Vout Vom Vss sky130_fd_pr__nfet_01v8_lvt ad=0.29 pd=2.58 as=0.29 ps=2.58 w=1 l=1
X220 nmos_differential_pair__ABBA_0.x1_Vtest2 pmos_current_mirror_load__ABAB_0.x1_Vout Vdd Vdd sky130_fd_pr__pfet_01v8_lvt ad=0.145 pd=1.29 as=0.29 ps=2.58 w=1 l=5
X221 XC1__A_0.Vop1 pmos_diode_2__A_0.x1_Vbias nmos_differential_pair__ABBA_0.x1_Vtest2 Vdd sky130_fd_pr__pfet_01v8_lvt ad=0.145 pd=1.29 as=0.29 ps=2.58 w=1 l=5
X222 Vdd pmos_diode__A_0.net3 pmos_diode__A_0.net3 Vdd sky130_fd_pr__pfet_01v8_lvt ad=0.29 pd=2.58 as=0.29 ps=2.58 w=1 l=20
X223 Vop XC2__A_0.Vom1 Vdd Vdd sky130_fd_pr__pfet_01v8_lvt ad=0.145 pd=1.29 as=0.29 ps=2.58 w=1 l=1
X224 res_packs__interleaved_0.x2_x2_net3 res_packs__interleaved_0.x2_x2_net15 sky130_fd_pr__res_generic_po w=0.5 l=40
X225 Vdd pmos_current_mirror_load__ABAB_0.x1_Vout nmos_differential_pair__ABBA_0.x1_Vtest2 Vdd sky130_fd_pr__pfet_01v8_lvt ad=0.29 pd=2.58 as=0.145 ps=1.29 w=1 l=5
X226 Vdd Vdd Vdd Vdd sky130_fd_pr__pfet_01v8_lvt ad=0.29 pd=2.58 as=0 ps=0 w=1 l=10
X227 Vop XC2__A_0.Vom1 Vdd Vdd sky130_fd_pr__pfet_01v8_lvt ad=0.145 pd=1.29 as=0.29 ps=2.58 w=1 l=1
X228 Vdd XC1__A_0.Vop1 Vom Vdd sky130_fd_pr__pfet_01v8_lvt ad=0.29 pd=2.58 as=0.145 ps=1.29 w=1 l=1
X229 Vdd Vdd Vdd Vdd sky130_fd_pr__pfet_01v8_lvt ad=0.29 pd=2.58 as=0 ps=0 w=1 l=5
X230 Vdd nmos_single_2__A_0.PBias nmos_diode__A_0.net1 Vdd sky130_fd_pr__pfet_01v8_lvt ad=1.45 pd=10.58 as=1.45 ps=10.58 w=5 l=1
X231 Vss Vss Vss Vss sky130_fd_pr__nfet_01v8_lvt ad=1.16 pd=8.58 as=0 ps=0 w=4 l=4
X232 res_packs__interleaved_0.x2_x1_net4 res_packs__interleaved_0.x2_x1_net5 sky130_fd_pr__res_generic_po w=0.5 l=40
X233 Vss Vss Vss Vss sky130_fd_pr__nfet_01v8_lvt ad=1.45 pd=10.58 as=0 ps=0 w=5 l=2
X234 res_packs__interleaved_0.x2_x1_net16 res_packs__interleaved_0.x2_x1_net17 sky130_fd_pr__res_generic_po w=0.5 l=40
X235 res_packs__interleaved_0.x2_x1_net12 res_packs__interleaved_0.x2_x1_net13 sky130_fd_pr__res_generic_po w=0.5 l=40
X236 Vss Vss Vss Vss sky130_fd_pr__nfet_01v8_lvt ad=0.174 pd=1.78 as=0 ps=0 w=0.6 l=1
X237 mirror_XX1_M22_XX1_M15__ABBA_0.x1_net7 XC2__A_0.Vom1 pmos_current_mirror_load__ABAB_0.x1_net9 Vss sky130_fd_pr__nfet_01v8_lvt ad=1.45 pd=10.58 as=1.45 ps=10.58 w=5 l=20
X238 res_packs__interleaved_0.x2_x2_net1 res_packs__interleaved_0.x2_x2_net11 sky130_fd_pr__res_generic_po w=0.5 l=40
X239 mirror_XX1_M22_XX1_M15__ABBA_0.x1_net7 VREF pmos_current_mirror_load__ABAB_0.x1_Vout Vss sky130_fd_pr__nfet_01v8_lvt ad=1.45 pd=10.58 as=1.45 ps=10.58 w=5 l=20
X240 Vss nmos_single_2__A_0.NBias nmos_single_2__A_0.NBias Vss sky130_fd_pr__nfet_01v8_lvt ad=1.45 pd=10.58 as=1.45 ps=10.58 w=5 l=2
X241 Vdd XC2__A_0.Vom1 Vop Vdd sky130_fd_pr__pfet_01v8_lvt ad=0.29 pd=2.58 as=0.145 ps=1.29 w=1 l=1
X242 Vdd XC1__A_0.Vop1 Vom Vdd sky130_fd_pr__pfet_01v8_lvt ad=0.29 pd=2.58 as=0.145 ps=1.29 w=1 l=1
X243 nmos_differential_pair__ABBA_0.x1_net1 pmos_current_mirror_load__ABAB_0.x1_Vout Vdd Vdd sky130_fd_pr__pfet_01v8_lvt ad=0.145 pd=1.29 as=0.29 ps=2.58 w=1 l=5
X244 Vdd nmos_single_2__A_0.PBias nmos_current_mirror_2__ABBA_0.net6 Vdd sky130_fd_pr__pfet_01v8_lvt ad=1.45 pd=10.58 as=1.45 ps=10.58 w=5 l=1
X245 nmos_differential_pair__ABBA_0.x1_net1 pmos_diode_2__A_0.x1_Vbias XC2__A_0.Vom1 Vdd sky130_fd_pr__pfet_01v8_lvt ad=0.29 pd=2.58 as=0.145 ps=1.29 w=1 l=5
X246 Vdd XC1__A_0.Vop1 Vom Vdd sky130_fd_pr__pfet_01v8_lvt ad=0.29 pd=2.58 as=0.145 ps=1.29 w=1 l=1
X247 res_packs__interleaved_0.x2_x2_net12 res_packs__interleaved_0.x2_x2_net2 sky130_fd_pr__res_generic_po w=0.5 l=40
X248 res_packs__interleaved_0.x2_x1_net1 res_packs__interleaved_0.x2_x1_net7 sky130_fd_pr__res_generic_po w=0.5 l=40
X249 pmos_current_mirror_load__ABAB_0.x1_Vout VREF mirror_XX1_M22_XX1_M15__ABBA_0.x1_net8 Vss sky130_fd_pr__nfet_01v8_lvt ad=1.45 pd=10.58 as=1.45 ps=10.58 w=5 l=20
X250 Vss pmos_differential_pair__ABBA_0.x2_Vout Vop Vss sky130_fd_pr__nfet_01v8_lvt ad=0.29 pd=2.58 as=0.29 ps=2.58 w=1 l=1
X251 Vdd nmos_single_2__A_0.PBias nmos_current_mirror_4__A_0.net4 Vdd sky130_fd_pr__pfet_01v8_lvt ad=1.45 pd=10.58 as=1.45 ps=10.58 w=5 l=1
X252 Vdd nmos_single_2__A_0.PBias nmos_current_mirror_4__A_0.net4 Vdd sky130_fd_pr__pfet_01v8_lvt ad=1.45 pd=10.58 as=1.45 ps=10.58 w=5 l=1
X253 res_packs__interleaved_0.x2_x1_net6 res_packs__interleaved_0.x2_x1_net5 sky130_fd_pr__res_generic_po w=0.5 l=40
X254 Vdd Vdd Vdd Vdd sky130_fd_pr__pfet_01v8_lvt ad=0.145 pd=1.29 as=0 ps=0 w=1 l=5
X255 Vom XC1__A_0.Vop1 Vdd Vdd sky130_fd_pr__pfet_01v8_lvt ad=0.145 pd=1.29 as=0.29 ps=2.58 w=1 l=1
X256 Vdd Vdd Vdd Vdd sky130_fd_pr__pfet_01v8_lvt ad=0.29 pd=2.58 as=0 ps=0 w=1 l=5
X257 Vss pmos_differential_pair__ABBA_0.x2_Vout Vop Vss sky130_fd_pr__nfet_01v8_lvt ad=0.29 pd=2.58 as=0.29 ps=2.58 w=1 l=1
X258 pmos_differential_pair__ABBA_0.x2_Vtest res_packs__interleaved_0.x2_Vcm pmos_current_mirror_2__row_0.x2_net1 Vdd sky130_fd_pr__pfet_01v8_lvt ad=0.29 pd=2.58 as=0.29 ps=2.58 w=1 l=10
X259 Vss Vss Vss Vss sky130_fd_pr__nfet_01v8_lvt ad=0.29 pd=2.58 as=0 ps=0 w=1 l=10
X260 XC2__A_0.Vom1 Vop sky130_fd_pr__cap_mim_m3_1 l=10 w=10
X261 Vss Vss sky130_fd_pr__res_generic_po w=0.5 l=40
X262 Vdd XC1__A_0.Vop1 Vom Vdd sky130_fd_pr__pfet_01v8_lvt ad=0.29 pd=2.58 as=0.145 ps=1.29 w=1 l=1
X263 Vdd pmos_current_mirror_load__ABAB_0.x1_net9 pmos_current_mirror_load__ABAB_0.x1_Vout Vdd sky130_fd_pr__pfet_01v8_lvt ad=0.29 pd=2.58 as=0.29 ps=2.58 w=1 l=10
X264 Vss nmos_diode_2__A_0.net5 nmos_diode_2__A_0.net5 Vss sky130_fd_pr__nfet_01v8_lvt ad=0.174 pd=1.78 as=0.174 ps=1.78 w=0.6 l=5
X265 Vdd nmos_single_2__A_0.PBias nmos_diode_2__A_0.net5 Vdd sky130_fd_pr__pfet_01v8_lvt ad=1.45 pd=10.58 as=1.45 ps=10.58 w=5 l=1
X266 Vss nmos_single_2__A_0.NBias nmos_single_2__A_0.PBias Vss sky130_fd_pr__nfet_01v8_lvt ad=1.45 pd=10.58 as=1.45 ps=10.58 w=5 l=2
C0 res_packs__interleaved_0.x2_Vcm res_packs__interleaved_0.x2_x1_net17 0.00196f
C1 nmos_single__A_0.net2 nmos_single_2__A_0.NBias 0
C2 res_packs__interleaved_0.x2_x2_net7 Vop 0.0031f
C3 res_packs__interleaved_0.x2_x1_net9 Vop 0.00207f
C4 nmos_current_mirror_4__A_0.net4 nmos_current_mirror_2__ABBA_0.net6 0.00538f
C5 pmos_differential_pair__ABBA_0.x2_Vout XC2__A_0.Vom1 0.3741f
C6 res_packs__interleaved_0.x2_x2_net2 Vom 0
C7 nmos_single_2__A_0.PBias pmos_diode__A_0.net3 3.03858f
C8 VREF pmos_current_mirror_load__ABAB_0.x1_Vout 2.48467f
C9 pmos_diode__A_0.net3 RGM 0.00524f
C10 nmos_current_mirror_4__A_0.net4 mirror_XX1_M22_XX1_M15__ABBA_0.x1_net8 0.41197f
C11 res_packs__interleaved_0.x2_x1_net15 Vop 0.0031f
C12 res_packs__interleaved_0.x2_x1_net5 Vop 0.00349f
C13 nmos_matched_cascode_pair__ABBA_0.x1_net5 nmos_matched_cascode_pair_2__ABBA_0.x1_net6 5.00784f
C14 Vdd mirror_XX1_M22_XX1_M15__ABBA_0.x1_net7 0.00308f
C15 nmos_single_2__A_0.PBias RGM 0.00482f
C16 res_packs__interleaved_0.x2_x1_net9 res_packs__interleaved_0.x2_x2_net9 0.41644f
C17 XC1__A_0.Vop1 nmos_matched_cascode_pair__ABBA_0.x1_net5 1.38245f
C18 Vom res_packs__interleaved_0.x2_x2_net11 0
C19 pmos_differential_pair__ABBA_0.x2_Vout pmos_current_mirror_2__row_0.x2_Vbiasp 0
C20 nmos_diode_2__A_0.net5 res_packs__interleaved_0.x2_x1_net6 0.00192f
C21 Vom nmos_diode_2__A_0.net5 0.00103f
C22 res_packs__interleaved_0.x2_Vcm res_packs__interleaved_0.x2_x2_net15 0.00135f
C23 Vom pmos_differential_pair__ABBA_0.x2_Vtest 0.09106f
C24 Vom res_packs__interleaved_0.x2_Vcm 2.67503f
C25 nmos_matched_cascode_pair__ABBA_0.x1_net5 XC2__A_0.Vom1 0.10842f
C26 res_packs__interleaved_0.x2_x1_net19 Vop 0.00207f
C27 res_packs__interleaved_0.x2_x2_net5 res_packs__interleaved_0.x2_x2_net7 0.16037f
C28 res_packs__interleaved_0.x2_x2_net14 res_packs__interleaved_0.x2_x1_net3 0.02074f
C29 nmos_differential_pair__ABBA_0.x1_net2 VREF 0.47999f
C30 res_packs__interleaved_0.x2_x1_net2 Vop 0.0031f
C31 nmos_current_mirror_4__A_0.net4 nmos_single_2__A_0.PBias 0.57236f
C32 res_packs__interleaved_0.x2_x2_net2 res_packs__interleaved_0.x2_x2_net13 0.16037f
C33 res_packs__interleaved_0.x2_x1_net10 res_packs__interleaved_0.x2_x2_net1 0.02074f
C34 Vm Vdd 0.00211f
C35 Vdd pmos_current_mirror_load__ABAB_0.x1_net9 29.9544f
C36 res_packs__interleaved_0.x2_x1_net5 res_packs__interleaved_0.x2_x2_net5 0.51022f
C37 Vdd nmos_diode_2__A_0.net5 2.3602f
C38 Vdd pmos_differential_pair__ABBA_0.x2_Vtest 5.69168f
C39 res_packs__interleaved_0.x2_Vcm Vdd 13.3745f
C40 pmos_diode_2__A_0.x1_Vbias pmos_current_mirror_load__ABAB_0.x1_net9 1.07659f
C41 XC1__A_0.Vop1 Vom 51.4215f
C42 nmos_matched_cascode_pair__ABBA_0.x1_net3 nmos_diode_2__A_0.net5 0.35374f
C43 nmos_current_mirror_3__ABBA_0.net7 nmos_diode_2__A_0.net5 0.00435f
C44 res_packs__interleaved_0.x2_x1_net2 res_packs__interleaved_0.x2_x2_net9 0.02074f
C45 res_packs__interleaved_0.x2_x2_net2 res_packs__interleaved_0.x2_x1_net9 0.00925f
C46 res_packs__interleaved_0.x2_x2_net17 res_packs__interleaved_0.x2_x2_net19 0.16037f
C47 nmos_current_mirror_3__ABBA_0.net7 pmos_differential_pair__ABBA_0.x2_Vtest 0.59933f
C48 res_packs__interleaved_0.x2_Vcm nmos_current_mirror_3__ABBA_0.net7 0.08106f
C49 nmos_diode__A_0.net1 Vop 0
C50 res_packs__interleaved_0.x2_x2_net16 res_packs__interleaved_0.x2_x1_net16 0.41702f
C51 res_packs__interleaved_0.x2_x2_net17 res_packs__interleaved_0.x2_x1_net17 0.51022f
C52 res_packs__interleaved_0.x2_Vcm res_packs__interleaved_0.x2_x2_net13 0.00171f
C53 Vom XC2__A_0.Vom1 0.61748f
C54 res_packs__interleaved_0.x2_x2_net6 res_packs__interleaved_0.x2_x1_net6 0.41702f
C55 res_packs__interleaved_0.x2_x1_net4 res_packs__interleaved_0.x2_x1_net6 0.16069f
C56 Vm Vp 1.73057f
C57 nmos_single__A_0.net2 nmos_diode__A_0.net1 1.03485f
C58 res_packs__interleaved_0.x2_x2_net11 res_packs__interleaved_0.x2_x2_net7 0.16037f
C59 res_packs__interleaved_0.x2_x2_net11 res_packs__interleaved_0.x2_x1_net9 0.00925f
C60 Vom nmos_current_mirror_2__ABBA_0.net6 0
C61 nmos_matched_cascode_pair_2__ABBA_0.x1_net4 nmos_diode_2__A_0.net5 0.356f
C62 mirror_XX1_M22_XX1_M15__ABBA_0.x1_net7 pmos_current_mirror_load__ABAB_0.x1_Vout 6.43151f
C63 res_packs__interleaved_0.x2_x1_net8 res_packs__interleaved_0.x2_x2_net10 0.00925f
C64 nmos_matched_cascode_pair_2__ABBA_0.x1_net6 nmos_matched_cascode_pair__ABBA_0.x1_net3 0.11869f
C65 XC1__A_0.Vop1 Vdd 21.8357f
C66 res_packs__interleaved_0.x2_Vcm res_packs__interleaved_0.x2_x2_net7 0.00406f
C67 res_packs__interleaved_0.x2_Vcm res_packs__interleaved_0.x2_x1_net9 0.00135f
C68 Vp nmos_diode_2__A_0.net5 0.00616f
C69 XC1__A_0.Vop1 nmos_matched_cascode_pair__ABBA_0.x1_net3 1.53213f
C70 XC1__A_0.Vop1 nmos_current_mirror_3__ABBA_0.net7 0.25626f
C71 VREF Vop 0.24179f
C72 Vdd XC2__A_0.Vom1 19.0012f
C73 res_packs__interleaved_0.x2_x1_net8 res_packs__interleaved_0.x2_x1_net12 0.16069f
C74 XC1__A_0.Vop1 pmos_diode_2__A_0.x1_Vbias 2.42766f
C75 Vom res_packs__interleaved_0.x2_x2_net17 0.16133f
C76 res_packs__interleaved_0.x2_x1_net15 res_packs__interleaved_0.x2_Vcm 0.00171f
C77 XC2__A_0.Vom1 nmos_matched_cascode_pair__ABBA_0.x1_net3 0.10094f
C78 res_packs__interleaved_0.x2_x1_net5 res_packs__interleaved_0.x2_Vcm 0.02252f
C79 res_packs__interleaved_0.x2_x1_net2 res_packs__interleaved_0.x2_x2_net2 0.51022f
C80 nmos_current_mirror_3__ABBA_0.net7 XC2__A_0.Vom1 0.50947f
C81 XC1__A_0.Vop1 nmos_single_2__A_0.NBias 0.09514f
C82 pmos_diode_2__A_0.x1_Vbias XC2__A_0.Vom1 1.76957f
C83 nmos_current_mirror_4__A_0.net4 nmos_matched_cascode_pair__ABBA_0.x1_net5 0.62113f
C84 res_packs__interleaved_0.x2_x1_net16 res_packs__interleaved_0.x2_x2_net18 0.02074f
C85 Vdd nmos_current_mirror_2__ABBA_0.net6 3.74775f
C86 nmos_matched_cascode_pair_2__ABBA_0.x1_net4 nmos_matched_cascode_pair_2__ABBA_0.x1_net6 0.59763f
C87 Vom pmos_diode__A_0.net3 0.3143f
C88 nmos_single_2__A_0.NBias XC2__A_0.Vom1 0.29773f
C89 nmos_differential_pair__ABBA_0.x1_net2 mirror_XX1_M22_XX1_M15__ABBA_0.x1_net7 0.18006f
C90 res_packs__interleaved_0.x2_x1_net14 res_packs__interleaved_0.x2_x2_net3 0.00925f
C91 nmos_current_mirror_3__ABBA_0.net7 nmos_current_mirror_2__ABBA_0.net6 0.93092f
C92 pmos_current_mirror_load__ABAB_0.x1_net9 pmos_current_mirror_load__ABAB_0.x1_Vout 5.23443f
C93 res_packs__interleaved_0.x2_x2_net1 res_packs__interleaved_0.x2_x1_net6 0.02074f
C94 Vdd pmos_current_mirror_2__row_0.x2_Vbiasp 12.6513f
C95 res_packs__interleaved_0.x2_x1_net13 res_packs__interleaved_0.x2_x2_net15 0.00925f
C96 nmos_differential_pair__ABBA_0.x1_net1 Vdd 11.4675f
C97 XC1__A_0.Vop1 nmos_matched_cascode_pair_2__ABBA_0.x1_net4 0.08237f
C98 Vom res_packs__interleaved_0.x2_x1_net13 0
C99 VREF pmos_current_mirror_2__row_0.x2_net1 0.30741f
C100 pmos_diode_2__A_0.x1_Vbias nmos_current_mirror_2__ABBA_0.net6 1.03123f
C101 mirror_XX1_M22_XX1_M15__ABBA_0.x1_net8 Vdd 0
C102 XC1__A_0.Vop1 Vp 0.27438f
C103 nmos_single_2__A_0.PBias Vom 0.16316f
C104 res_packs__interleaved_0.x2_Vcm res_packs__interleaved_0.x2_x1_net19 0.00135f
C105 nmos_current_mirror_3__ABBA_0.net7 pmos_current_mirror_2__row_0.x2_Vbiasp 1.276f
C106 nmos_diode_2__A_0.net5 pmos_current_mirror_load__ABAB_0.x1_Vout 1.2693f
C107 Vom RGM 0
C108 nmos_single_2__A_0.NBias nmos_current_mirror_2__ABBA_0.net6 0.00441f
C109 nmos_matched_cascode_pair_2__ABBA_0.x1_net4 XC2__A_0.Vom1 1.20364f
C110 nmos_differential_pair__ABBA_0.x1_net1 pmos_diode_2__A_0.x1_Vbias 5.04794f
C111 res_packs__interleaved_0.x2_x1_net2 res_packs__interleaved_0.x2_Vcm 0.00171f
C112 Vom res_packs__interleaved_0.x2_x1_net11 0.00112f
C113 Vom res_packs__interleaved_0.x2_x1_net7 0
C114 pmos_diode__A_0.net3 Vdd 17.3247f
C115 Vm nmos_differential_pair__ABBA_0.x1_net2 0.8855f
C116 nmos_differential_pair__ABBA_0.x1_net2 pmos_current_mirror_load__ABAB_0.x1_net9 0.17274f
C117 pmos_current_mirror_2__row_0.x2_net1 Vop 0.08025f
C118 pmos_diode__A_0.net3 nmos_current_mirror_3__ABBA_0.net7 0.14754f
C119 nmos_current_mirror_4__A_0.net4 Vom 0
C120 VREF mirror_XX1_M22_XX1_M15__ABBA_0.x1_net7 1.20408f
C121 res_packs__interleaved_0.x2_x2_net9 Vop 0.0031f
C122 nmos_differential_pair__ABBA_0.x1_net1 Vp 0.72489f
C123 nmos_single_2__A_0.PBias Vdd 17.5468f
C124 nmos_differential_pair__ABBA_0.x1_net2 nmos_diode_2__A_0.net5 0.61078f
C125 pmos_diode__A_0.net3 nmos_single_2__A_0.NBias 2.49777f
C126 nmos_single_2__A_0.PBias nmos_current_mirror_3__ABBA_0.net7 1.77444f
C127 res_packs__interleaved_0.x2_x2_net8 res_packs__interleaved_0.x2_x1_net12 0.02074f
C128 res_packs__interleaved_0.x2_x1_net14 res_packs__interleaved_0.x2_x2_net12 0.00925f
C129 XC1__A_0.Vop1 pmos_current_mirror_load__ABAB_0.x1_Vout 0.47477f
C130 res_packs__interleaved_0.x2_x1_net17 res_packs__interleaved_0.x2_x2_net19 0.02074f
C131 res_packs__interleaved_0.x2_x1_net13 res_packs__interleaved_0.x2_x2_net13 0.41644f
C132 nmos_differential_pair__ABBA_0.x1_Vtest2 Vdd 17.548f
C133 Vom pmos_differential_pair__ABBA_0.x2_Vout 0.84633f
C134 res_packs__interleaved_0.x2_x2_net5 Vop 0.00296f
C135 XC2__A_0.Vom1 pmos_current_mirror_load__ABAB_0.x1_Vout 0.22806f
C136 nmos_single_2__A_0.PBias nmos_single_2__A_0.NBias 3.59708f
C137 nmos_single_2__A_0.NBias RGM 0
C138 nmos_differential_pair__ABBA_0.x1_Vtest2 pmos_diode_2__A_0.x1_Vbias 5.24974f
C139 nmos_current_mirror_4__A_0.net4 Vdd 2.97795f
C140 Vm VREF 0
C141 VREF pmos_current_mirror_load__ABAB_0.x1_net9 1.56141f
C142 nmos_current_mirror_2__ABBA_0.net6 pmos_current_mirror_load__ABAB_0.x1_Vout 0.09884f
C143 nmos_current_mirror_4__A_0.net4 nmos_matched_cascode_pair__ABBA_0.x1_net3 0.61571f
C144 res_packs__interleaved_0.x2_x2_net16 res_packs__interleaved_0.x2_x1_net18 0.00925f
C145 nmos_differential_pair__ABBA_0.x1_net2 nmos_matched_cascode_pair_2__ABBA_0.x1_net6 0.20989f
C146 res_packs__interleaved_0.x2_x1_net18 res_packs__interleaved_0.x2_x2_net3 0.00925f
C147 VREF nmos_diode_2__A_0.net5 0.60064f
C148 nmos_differential_pair__ABBA_0.x1_net1 pmos_current_mirror_load__ABAB_0.x1_Vout 3.36931f
C149 XC1__A_0.Vop1 nmos_differential_pair__ABBA_0.x1_net2 0.71821f
C150 XC1__A_0.Vop1 nmos_diode__A_0.net1 0.44296f
C151 res_packs__interleaved_0.x2_Vcm VREF 3.27163f
C152 VREF pmos_differential_pair__ABBA_0.x2_Vtest 0.06426f
C153 mirror_XX1_M22_XX1_M15__ABBA_0.x1_net8 pmos_current_mirror_load__ABAB_0.x1_Vout 6.10297f
C154 res_packs__interleaved_0.x2_x2_net15 res_packs__interleaved_0.x2_x2_net19 0.16037f
C155 res_packs__interleaved_0.x2_x2_net2 Vop 0.00207f
C156 Vdd pmos_differential_pair__ABBA_0.x2_Vout 2.63927f
C157 Vom res_packs__interleaved_0.x2_x2_net19 0.00112f
C158 res_packs__interleaved_0.x2_x1_net11 res_packs__interleaved_0.x2_x2_net7 0.02074f
C159 res_packs__interleaved_0.x2_x1_net19 res_packs__interleaved_0.x2_x2_net17 0.00925f
C160 nmos_differential_pair__ABBA_0.x1_Vtest2 Vp 0.02558f
C161 res_packs__interleaved_0.x2_x1_net10 res_packs__interleaved_0.x2_x1_net8 0.16069f
C162 res_packs__interleaved_0.x2_x1_net7 res_packs__interleaved_0.x2_x2_net7 0.41644f
C163 nmos_differential_pair__ABBA_0.x1_net2 XC2__A_0.Vom1 1.40774f
C164 pmos_differential_pair__ABBA_0.x2_Vout nmos_current_mirror_3__ABBA_0.net7 0.23377f
C165 nmos_diode__A_0.net1 XC2__A_0.Vom1 0.00179f
C166 Vom res_packs__interleaved_0.x2_x1_net17 0.01232f
C167 nmos_current_mirror_4__A_0.net4 nmos_matched_cascode_pair_2__ABBA_0.x1_net4 0.41659f
C168 res_packs__interleaved_0.x2_x2_net11 Vop 0.00207f
C169 res_packs__interleaved_0.x2_x2_net12 res_packs__interleaved_0.x2_x1_net12 0.41702f
C170 VREF nmos_matched_cascode_pair_2__ABBA_0.x1_net6 0
C171 res_packs__interleaved_0.x2_x2_net2 res_packs__interleaved_0.x2_x2_net9 0.16037f
C172 nmos_differential_pair__ABBA_0.x1_net1 nmos_differential_pair__ABBA_0.x1_net2 2.17233f
C173 pmos_differential_pair__ABBA_0.x2_Vtest Vop 0.0933f
C174 res_packs__interleaved_0.x2_Vcm Vop 3.27438f
C175 mirror_XX1_M22_XX1_M15__ABBA_0.x1_net8 nmos_differential_pair__ABBA_0.x1_net2 0.18821f
C176 XC1__A_0.Vop1 VREF 6.37603f
C177 res_packs__interleaved_0.x2_x2_net18 res_packs__interleaved_0.x2_x1_net18 0.51069f
C178 nmos_matched_cascode_pair__ABBA_0.x1_net5 nmos_matched_cascode_pair__ABBA_0.x1_net3 0.87844f
C179 Vom res_packs__interleaved_0.x2_x2_net15 0
C180 VREF XC2__A_0.Vom1 6.70091f
C181 nmos_differential_pair__ABBA_0.x1_Vtest2 pmos_current_mirror_load__ABAB_0.x1_Vout 3.45561f
C182 res_packs__interleaved_0.x2_x2_net11 res_packs__interleaved_0.x2_x2_net9 0.16037f
C183 res_packs__interleaved_0.x2_x1_net1 nmos_diode_2__A_0.net5 0
C184 pmos_current_mirror_2__row_0.x2_net1 pmos_differential_pair__ABBA_0.x2_Vtest 3.69932f
C185 res_packs__interleaved_0.x2_Vcm pmos_current_mirror_2__row_0.x2_net1 0.30595f
C186 res_packs__interleaved_0.x2_Vcm res_packs__interleaved_0.x2_x2_net9 0.00171f
C187 nmos_diode__A_0.net1 pmos_diode__A_0.net3 0.0573f
C188 VREF nmos_current_mirror_2__ABBA_0.net6 0.00727f
C189 nmos_current_mirror_4__A_0.net4 pmos_current_mirror_load__ABAB_0.x1_Vout 0.86985f
C190 XC1__A_0.Vop1 Vop 0.00306f
C191 nmos_matched_cascode_pair_2__ABBA_0.x1_net4 nmos_matched_cascode_pair__ABBA_0.x1_net5 5.16307f
C192 res_packs__interleaved_0.x2_x2_net4 nmos_diode_2__A_0.net5 0.00153f
C193 nmos_single_2__A_0.PBias nmos_diode__A_0.net1 0.57198f
C194 res_packs__interleaved_0.x2_x1_net1 res_packs__interleaved_0.x2_x2_net10 0.00925f
C195 mirror_XX1_M22_XX1_M15__ABBA_0.x1_net8 VREF 1.22046f
C196 nmos_diode__A_0.net1 RGM 2.78193f
C197 res_packs__interleaved_0.x2_x1_net10 res_packs__interleaved_0.x2_x2_net8 0.02074f
C198 res_packs__interleaved_0.x2_x2_net5 res_packs__interleaved_0.x2_Vcm 0.17381f
C199 XC2__A_0.Vom1 Vop 52.4701f
C200 mirror_XX1_M22_XX1_M15__ABBA_0.x1_net7 pmos_current_mirror_load__ABAB_0.x1_net9 5.79294f
C201 Vom Vdd 9.55862f
C202 nmos_differential_pair__ABBA_0.x1_Vtest2 nmos_differential_pair__ABBA_0.x1_net2 1.96661f
C203 nmos_single__A_0.net2 XC1__A_0.Vop1 0.08019f
C204 Vom nmos_current_mirror_3__ABBA_0.net7 0.94594f
C205 res_packs__interleaved_0.x2_x1_net3 res_packs__interleaved_0.x2_x2_net3 0.41702f
C206 res_packs__interleaved_0.x2_x1_net15 res_packs__interleaved_0.x2_x2_net19 0.02074f
C207 mirror_XX1_M22_XX1_M15__ABBA_0.x1_net7 nmos_diode_2__A_0.net5 0.23342f
C208 res_packs__interleaved_0.x2_x2_net13 res_packs__interleaved_0.x2_x2_net15 0.16037f
C209 Vom res_packs__interleaved_0.x2_x2_net13 0.00112f
C210 nmos_current_mirror_4__A_0.net4 nmos_differential_pair__ABBA_0.x1_net2 0.50302f
C211 Vom nmos_single_2__A_0.NBias 0.627f
C212 Vop pmos_current_mirror_2__row_0.x2_Vbiasp 0.04067f
C213 pmos_current_mirror_2__row_0.x2_net1 XC2__A_0.Vom1 0.08137f
C214 res_packs__interleaved_0.x2_x1_net16 res_packs__interleaved_0.x2_x1_net18 0.16069f
C215 res_packs__interleaved_0.x2_x2_net2 res_packs__interleaved_0.x2_Vcm 0.00135f
C216 res_packs__interleaved_0.x2_x1_net1 res_packs__interleaved_0.x2_x2_net6 0.00925f
C217 res_packs__interleaved_0.x2_x1_net19 res_packs__interleaved_0.x2_x2_net19 0.41644f
C218 res_packs__interleaved_0.x2_x2_net17 Vop 0.00207f
C219 Vom res_packs__interleaved_0.x2_x2_net7 0.00112f
C220 Vom res_packs__interleaved_0.x2_x1_net9 0
C221 Vdd nmos_current_mirror_3__ABBA_0.net7 3.52499f
C222 Vm nmos_diode_2__A_0.net5 0.00174f
C223 Vdd pmos_diode_2__A_0.x1_Vbias 31.1472f
C224 pmos_current_mirror_load__ABAB_0.x1_net9 nmos_diode_2__A_0.net5 0.22183f
C225 XC1__A_0.Vop1 mirror_XX1_M22_XX1_M15__ABBA_0.x1_net7 0.27692f
C226 pmos_current_mirror_2__row_0.x2_net1 pmos_current_mirror_2__row_0.x2_Vbiasp 1.66679f
C227 pmos_diode__A_0.net3 Vop 0.00221f
C228 res_packs__interleaved_0.x2_x1_net4 res_packs__interleaved_0.x2_x2_net4 0.51069f
C229 res_packs__interleaved_0.x2_Vcm res_packs__interleaved_0.x2_x2_net11 0.00135f
C230 Vdd nmos_single_2__A_0.NBias 2.73052f
C231 res_packs__interleaved_0.x2_x1_net15 res_packs__interleaved_0.x2_x2_net15 0.51022f
C232 res_packs__interleaved_0.x2_x1_net3 res_packs__interleaved_0.x2_x2_net18 0.02074f
C233 res_packs__interleaved_0.x2_x1_net15 Vom 0.00112f
C234 Vom res_packs__interleaved_0.x2_x1_net5 0.00122f
C235 nmos_current_mirror_4__A_0.net4 VREF 0.49296f
C236 res_packs__interleaved_0.x2_x1_net13 Vop 0.00207f
C237 XC2__A_0.Vom1 mirror_XX1_M22_XX1_M15__ABBA_0.x1_net7 1.27073f
C238 nmos_current_mirror_3__ABBA_0.net7 nmos_single_2__A_0.NBias 0.36103f
C239 res_packs__interleaved_0.x2_Vcm pmos_differential_pair__ABBA_0.x2_Vtest 0.3285f
C240 res_packs__interleaved_0.x2_x1_net14 res_packs__interleaved_0.x2_x1_net12 0.16069f
C241 nmos_single_2__A_0.PBias Vop 0
C242 RGM Vop 0.00324f
C243 Vdd Vp 0.00211f
C244 nmos_differential_pair__ABBA_0.x1_net2 nmos_matched_cascode_pair__ABBA_0.x1_net5 0.20506f
C245 nmos_matched_cascode_pair_2__ABBA_0.x1_net4 nmos_matched_cascode_pair__ABBA_0.x1_net3 5.00238f
C246 res_packs__interleaved_0.x2_x1_net11 Vop 0.0031f
C247 VREF pmos_differential_pair__ABBA_0.x2_Vout 0.29051f
C248 res_packs__interleaved_0.x2_x1_net19 res_packs__interleaved_0.x2_x2_net15 0.00925f
C249 res_packs__interleaved_0.x2_x1_net7 Vop 0.00207f
C250 Vom res_packs__interleaved_0.x2_x1_net19 0
C251 nmos_single__A_0.net2 nmos_single_2__A_0.PBias 1.53128f
C252 res_packs__interleaved_0.x2_x2_net1 res_packs__interleaved_0.x2_x1_net1 0.51069f
C253 Vm XC1__A_0.Vop1 0.00206f
C254 XC1__A_0.Vop1 pmos_current_mirror_load__ABAB_0.x1_net9 1.6397f
C255 mirror_XX1_M22_XX1_M15__ABBA_0.x1_net8 mirror_XX1_M22_XX1_M15__ABBA_0.x1_net7 5.57901f
C256 nmos_matched_cascode_pair_2__ABBA_0.x1_net6 nmos_diode_2__A_0.net5 0.35001f
C257 res_packs__interleaved_0.x2_x1_net2 Vom 0.00112f
C258 XC1__A_0.Vop1 nmos_diode_2__A_0.net5 2.07121f
C259 XC2__A_0.Vom1 pmos_current_mirror_load__ABAB_0.x1_net9 1.53742f
C260 XC1__A_0.Vop1 res_packs__interleaved_0.x2_Vcm 0.09969f
C261 res_packs__interleaved_0.x2_x1_net15 res_packs__interleaved_0.x2_x2_net13 0.02074f
C262 res_packs__interleaved_0.x2_x1_net11 res_packs__interleaved_0.x2_x2_net9 0.02074f
C263 XC2__A_0.Vom1 nmos_diode_2__A_0.net5 1.83791f
C264 pmos_differential_pair__ABBA_0.x2_Vtest XC2__A_0.Vom1 0.08068f
C265 res_packs__interleaved_0.x2_Vcm XC2__A_0.Vom1 0.17744f
C266 pmos_differential_pair__ABBA_0.x2_Vout Vop 1.30857f
C267 nmos_current_mirror_2__ABBA_0.net6 pmos_current_mirror_load__ABAB_0.x1_net9 0.22363f
C268 nmos_matched_cascode_pair__ABBA_0.x1_net5 VREF 0
C269 nmos_diode_2__A_0.net5 res_packs__interleaved_0.x2_x2_net6 0
C270 Vdd pmos_current_mirror_load__ABAB_0.x1_Vout 53.4113f
C271 res_packs__interleaved_0.x2_x1_net4 nmos_diode_2__A_0.net5 0
C272 res_packs__interleaved_0.x2_x1_net4 res_packs__interleaved_0.x2_Vcm 0
C273 nmos_differential_pair__ABBA_0.x1_net1 Vm 0.01367f
C274 Vom nmos_diode__A_0.net1 0.83052f
C275 nmos_differential_pair__ABBA_0.x1_net1 pmos_current_mirror_load__ABAB_0.x1_net9 0.33891f
C276 nmos_current_mirror_2__ABBA_0.net6 nmos_diode_2__A_0.net5 0.01342f
C277 nmos_single_2__A_0.PBias mirror_XX1_M22_XX1_M15__ABBA_0.x1_net7 0
C278 mirror_XX1_M22_XX1_M15__ABBA_0.x1_net8 pmos_current_mirror_load__ABAB_0.x1_net9 7.2276f
C279 res_packs__interleaved_0.x2_x1_net10 res_packs__interleaved_0.x2_x1_net1 0.16069f
C280 res_packs__interleaved_0.x2_x1_net5 res_packs__interleaved_0.x2_x2_net7 0.02074f
C281 res_packs__interleaved_0.x2_x2_net5 res_packs__interleaved_0.x2_x1_net7 0.00925f
C282 XC1__A_0.Vop1 nmos_matched_cascode_pair_2__ABBA_0.x1_net6 0.0929f
C283 pmos_diode_2__A_0.x1_Vbias pmos_current_mirror_load__ABAB_0.x1_Vout 0.25903f
C284 res_packs__interleaved_0.x2_x2_net14 res_packs__interleaved_0.x2_x1_net14 0.51069f
C285 pmos_differential_pair__ABBA_0.x2_Vtest pmos_current_mirror_2__row_0.x2_Vbiasp 0.37212f
C286 mirror_XX1_M22_XX1_M15__ABBA_0.x1_net8 nmos_diode_2__A_0.net5 0.16175f
C287 res_packs__interleaved_0.x2_x1_net2 res_packs__interleaved_0.x2_x2_net13 0.02074f
C288 res_packs__interleaved_0.x2_x2_net2 res_packs__interleaved_0.x2_x1_net13 0.00925f
C289 res_packs__interleaved_0.x2_x1_net8 res_packs__interleaved_0.x2_x2_net8 0.51069f
C290 pmos_differential_pair__ABBA_0.x2_Vout pmos_current_mirror_2__row_0.x2_net1 3.47785f
C291 nmos_matched_cascode_pair_2__ABBA_0.x1_net6 XC2__A_0.Vom1 1.21639f
C292 res_packs__interleaved_0.x2_x2_net19 Vop 0.0031f
C293 XC1__A_0.Vop1 XC2__A_0.Vom1 4.88996f
C294 res_packs__interleaved_0.x2_Vcm res_packs__interleaved_0.x2_x2_net17 0.00199f
C295 nmos_current_mirror_4__A_0.net4 mirror_XX1_M22_XX1_M15__ABBA_0.x1_net7 0.86172f
C296 res_packs__interleaved_0.x2_x1_net17 Vop 0.0031f
C297 nmos_differential_pair__ABBA_0.x1_net2 Vdd 0.00995f
C298 nmos_diode__A_0.net1 Vdd 2.18402f
C299 Vom VREF 0.199f
C300 nmos_differential_pair__ABBA_0.x1_net2 nmos_matched_cascode_pair__ABBA_0.x1_net3 1.40813f
C301 XC1__A_0.Vop1 nmos_current_mirror_2__ABBA_0.net6 0.52714f
C302 nmos_diode__A_0.net1 nmos_current_mirror_3__ABBA_0.net7 0.00435f
C303 res_packs__interleaved_0.x2_x2_net1 nmos_diode_2__A_0.net5 0
C304 res_packs__interleaved_0.x2_Vcm res_packs__interleaved_0.x2_x1_net13 0.00135f
C305 nmos_differential_pair__ABBA_0.x1_net1 XC1__A_0.Vop1 0.10054f
C306 nmos_single_2__A_0.PBias nmos_diode_2__A_0.net5 0.56349f
C307 XC2__A_0.Vom1 nmos_current_mirror_2__ABBA_0.net6 0.11066f
C308 nmos_diode__A_0.net1 nmos_single_2__A_0.NBias 1.01136f
C309 nmos_differential_pair__ABBA_0.x1_Vtest2 Vm 0.73914f
C310 mirror_XX1_M22_XX1_M15__ABBA_0.x1_net8 XC1__A_0.Vop1 1.64002f
C311 res_packs__interleaved_0.x2_x1_net3 res_packs__interleaved_0.x2_x1_net14 0.16069f
C312 res_packs__interleaved_0.x2_x1_net4 res_packs__interleaved_0.x2_x2_net6 0.00925f
C313 nmos_differential_pair__ABBA_0.x1_Vtest2 pmos_current_mirror_load__ABAB_0.x1_net9 0.15557f
C314 res_packs__interleaved_0.x2_x1_net11 res_packs__interleaved_0.x2_x2_net11 0.51022f
C315 res_packs__interleaved_0.x2_x2_net11 res_packs__interleaved_0.x2_x1_net7 0.00925f
C316 XC2__A_0.Vom1 pmos_current_mirror_2__row_0.x2_Vbiasp 0.00376f
C317 nmos_differential_pair__ABBA_0.x1_net1 XC2__A_0.Vom1 1.5882f
C318 mirror_XX1_M22_XX1_M15__ABBA_0.x1_net8 XC2__A_0.Vom1 0.16895f
C319 res_packs__interleaved_0.x2_x1_net11 res_packs__interleaved_0.x2_Vcm 0.00171f
C320 nmos_differential_pair__ABBA_0.x1_net2 nmos_matched_cascode_pair_2__ABBA_0.x1_net4 1.60693f
C321 nmos_current_mirror_4__A_0.net4 pmos_current_mirror_load__ABAB_0.x1_net9 0.1594f
C322 res_packs__interleaved_0.x2_x2_net15 Vop 0.00207f
C323 res_packs__interleaved_0.x2_Vcm res_packs__interleaved_0.x2_x1_net7 0.00172f
C324 Vom Vop 4.36178f
C325 Vdd VREF 11.0473f
C326 nmos_differential_pair__ABBA_0.x1_net2 Vp 0.89709f
C327 res_packs__interleaved_0.x2_x2_net14 res_packs__interleaved_0.x2_x1_net12 0.02074f
C328 XC1__A_0.Vop1 pmos_diode__A_0.net3 0.27878f
C329 VREF nmos_matched_cascode_pair__ABBA_0.x1_net3 0
C330 VREF nmos_current_mirror_3__ABBA_0.net7 0.0897f
C331 nmos_current_mirror_4__A_0.net4 nmos_diode_2__A_0.net5 2.56756f
C332 res_packs__interleaved_0.x2_x1_net8 res_packs__interleaved_0.x2_x2_net12 0.00925f
C333 pmos_diode__A_0.net3 XC2__A_0.Vom1 0.06652f
C334 nmos_single__A_0.net2 Vom 0.00357f
C335 nmos_single_2__A_0.PBias XC1__A_0.Vop1 0.2743f
C336 res_packs__interleaved_0.x2_x1_net1 res_packs__interleaved_0.x2_x1_net6 0.16069f
C337 XC1__A_0.Vop1 RGM 0
C338 Vom pmos_current_mirror_2__row_0.x2_net1 0.09377f
C339 pmos_differential_pair__ABBA_0.x2_Vout pmos_differential_pair__ABBA_0.x2_Vtest 6.20206f
C340 Vom res_packs__interleaved_0.x2_x2_net9 0.00112f
C341 res_packs__interleaved_0.x2_Vcm pmos_differential_pair__ABBA_0.x2_Vout 0.03575f
C342 nmos_single_2__A_0.PBias XC2__A_0.Vom1 0
C343 nmos_differential_pair__ABBA_0.x1_Vtest2 XC1__A_0.Vop1 1.3611f
C344 pmos_diode__A_0.net3 nmos_current_mirror_2__ABBA_0.net6 0.25667f
C345 XC2__A_0.Vom1 RGM 0.07411f
C346 Vdd Vop 7.34695f
C347 nmos_matched_cascode_pair_2__ABBA_0.x1_net4 VREF 0
C348 res_packs__interleaved_0.x2_x1_net10 res_packs__interleaved_0.x2_x2_net10 0.41702f
C349 nmos_current_mirror_4__A_0.net4 nmos_matched_cascode_pair_2__ABBA_0.x1_net6 0.32584f
C350 res_packs__interleaved_0.x2_x2_net4 res_packs__interleaved_0.x2_x1_net6 0.02074f
C351 VREF Vp 0.00381f
C352 nmos_current_mirror_3__ABBA_0.net7 Vop 0.65627f
C353 nmos_differential_pair__ABBA_0.x1_Vtest2 XC2__A_0.Vom1 0.08125f
C354 nmos_differential_pair__ABBA_0.x1_net2 pmos_current_mirror_load__ABAB_0.x1_Vout 0.17274f
C355 nmos_single_2__A_0.PBias nmos_current_mirror_2__ABBA_0.net6 0.86618f
C356 Vom res_packs__interleaved_0.x2_x2_net5 0.00112f
C357 nmos_current_mirror_4__A_0.net4 XC1__A_0.Vop1 0.65117f
C358 res_packs__interleaved_0.x2_x2_net13 Vop 0.0031f
C359 nmos_single__A_0.net2 Vdd 8.08538f
C360 nmos_single_2__A_0.NBias Vop 0.00473f
C361 nmos_current_mirror_4__A_0.net4 XC2__A_0.Vom1 0.38603f
C362 Vdd pmos_current_mirror_2__row_0.x2_net1 3.91671f
C363 nmos_matched_cascode_pair__ABBA_0.x1_net5 nmos_diode_2__A_0.net5 0.34704f
C364 res_packs__interleaved_0.x2_Vcm res_packs__interleaved_0.x2_x2_net19 0.00171f
C365 res_packs__interleaved_0.x2_x1_net3 res_packs__interleaved_0.x2_x1_net18 0.16069f
C366 nmos_current_mirror_3__ABBA_0.net7 pmos_current_mirror_2__row_0.x2_net1 0.16206f
C367 nmos_differential_pair__ABBA_0.x1_net1 nmos_differential_pair__ABBA_0.x1_Vtest2 6.95598f
C368 res_packs__interleaved_0.x2_x2_net16 Vss 1.01524f
C369 res_packs__interleaved_0.x2_x1_net16 Vss 1.48257f
C370 res_packs__interleaved_0.x2_x1_net17 Vss 1.10261f
C371 res_packs__interleaved_0.x2_x2_net17 Vss 1.16246f
C372 res_packs__interleaved_0.x2_x2_net18 Vss 1.09142f
C373 res_packs__interleaved_0.x2_x1_net18 Vss 1.15006f
C374 res_packs__interleaved_0.x2_x1_net19 Vss 0.99661f
C375 res_packs__interleaved_0.x2_x2_net19 Vss 1.28412f
C376 res_packs__interleaved_0.x2_x2_net3 Vss 0.99757f
C377 res_packs__interleaved_0.x2_x1_net3 Vss 1.28865f
C378 res_packs__interleaved_0.x2_x1_net15 Vss 1.08817f
C379 res_packs__interleaved_0.x2_x2_net15 Vss 1.14752f
C380 res_packs__interleaved_0.x2_x2_net14 Vss 1.09105f
C381 res_packs__interleaved_0.x2_x1_net14 Vss 1.1493f
C382 res_packs__interleaved_0.x2_x1_net13 Vss 0.99662f
C383 res_packs__interleaved_0.x2_x2_net13 Vss 1.28412f
C384 res_packs__interleaved_0.x2_x2_net12 Vss 0.99757f
C385 res_packs__interleaved_0.x2_x1_net12 Vss 1.28865f
C386 res_packs__interleaved_0.x2_x1_net2 Vss 1.08817f
C387 res_packs__interleaved_0.x2_x2_net2 Vss 1.14752f
C388 res_packs__interleaved_0.x2_x2_net8 Vss 1.09106f
C389 res_packs__interleaved_0.x2_x1_net8 Vss 1.14929f
C390 res_packs__interleaved_0.x2_x1_net9 Vss 0.99662f
C391 res_packs__interleaved_0.x2_x2_net9 Vss 1.28412f
C392 res_packs__interleaved_0.x2_x2_net10 Vss 0.99758f
C393 res_packs__interleaved_0.x2_x1_net10 Vss 1.28864f
C394 res_packs__interleaved_0.x2_x1_net11 Vss 1.08818f
C395 res_packs__interleaved_0.x2_x2_net11 Vss 1.14751f
C396 res_packs__interleaved_0.x2_x2_net1 Vss 1.09113f
C397 res_packs__interleaved_0.x2_x1_net1 Vss 1.14883f
C398 res_packs__interleaved_0.x2_x1_net7 Vss 0.99662f
C399 res_packs__interleaved_0.x2_x2_net7 Vss 1.28412f
C400 res_packs__interleaved_0.x2_x2_net6 Vss 0.99715f
C401 res_packs__interleaved_0.x2_x1_net6 Vss 1.28543f
C402 res_packs__interleaved_0.x2_x1_net5 Vss 1.10176f
C403 res_packs__interleaved_0.x2_x2_net5 Vss 1.15987f
C404 res_packs__interleaved_0.x2_x2_net4 Vss 1.11495f
C405 res_packs__interleaved_0.x2_x1_net4 Vss 1.32573f
C406 Vom Vss 0.12205p
C407 Vop Vss 57.44213f
C408 pmos_current_mirror_2__row_0.x2_net1 Vss 35.64193f
C409 nmos_matched_cascode_pair_2__ABBA_0.x1_net6 Vss 8.69927f
C410 nmos_matched_cascode_pair_2__ABBA_0.x1_net4 Vss 3.5193f
C411 RGM Vss 6.67804f
C412 nmos_matched_cascode_pair__ABBA_0.x1_net5 Vss 4.58927f
C413 nmos_matched_cascode_pair__ABBA_0.x1_net3 Vss 8.38167f
C414 mirror_XX1_M22_XX1_M15__ABBA_0.x1_net7 Vss 12.22f
C415 mirror_XX1_M22_XX1_M15__ABBA_0.x1_net8 Vss 57.33525f
C416 nmos_differential_pair__ABBA_0.x1_net2 Vss 16.75995f
C417 nmos_differential_pair__ABBA_0.x1_net1 Vss 13.2048f
C418 nmos_differential_pair__ABBA_0.x1_Vtest2 Vss 27.00396f
.ends
