*********************************************************
*** NGSPICE file created by KLayout-PEX 0.6.8
*** -----------------------------------------------------
***     Extraction Engine: KPEX/2.5D
***     Technology: sky130a
***     Date: 2026-11-04 13:28:44
*********************************************************

.SUBCKT ttsky25a_fd_routed \$2.x2_x1_net1 \$2.x2_x1_net10 \$2.x2_x1_net11
+ \$2.x2_x1_net12 \$2.x2_x1_net13 \$2.x2_x1_net14 \$2.x2_x1_net15
+ \$2.x2_x1_net16 \$2.x2_x1_net17 \$2.x2_x1_net18 \$2.x2_x1_net19
+ \$2.x2_x1_net2 \$2.x2_x1_net3 \$2.x2_x1_net4 \$2.x2_x1_net5 \$2.x2_x1_net6
+ \$2.x2_x1_net7 \$2.x2_x1_net8 \$2.x2_x1_net9 \$2.x2_x2_net1 \$2.x2_x2_net10
+ \$2.x2_x2_net11 \$2.x2_x2_net12 \$2.x2_x2_net13 \$2.x2_x2_net14
+ \$2.x2_x2_net15 \$2.x2_x2_net16 \$2.x2_x2_net17 \$2.x2_x2_net18
+ \$2.x2_x2_net19 \$2.x2_x2_net2 \$2.x2_x2_net3 \$2.x2_x2_net4 \$2.x2_x2_net5
+ \$2.x2_x2_net6 \$2.x2_x2_net7 \$2.x2_x2_net8 \$2.x2_x2_net9 RGM VREF Vdd Vm
+ Vom Vop Vp Vss sky130_gnd
X$11 Vom \$2.x2_x2_net16 sky130_fd_pr__res_generic_po w=0.5 l=40
X$12 \$96 \$2.x2_x2_net4 sky130_fd_pr__res_generic_po w=0.5 l=40
X$13 \$96 \$2.x2_x1_net16 sky130_fd_pr__res_generic_po w=0.5 l=40
X$14 Vop \$2.x2_x1_net4 sky130_fd_pr__res_generic_po w=0.5 l=40
X$15 Vss Vss sky130_fd_pr__res_generic_po w=0.5 l=40
X$16 Vss Vss sky130_fd_pr__res_generic_po w=0.5 l=40
X$17 \$2.x2_x2_net5 \$2.x2_x2_net6 sky130_fd_pr__res_generic_po w=0.5 l=40
X$18 \$2.x2_x2_net5 \$2.x2_x2_net4 sky130_fd_pr__res_generic_po w=0.5 l=40
X$19 \$2.x2_x1_net5 \$2.x2_x1_net6 sky130_fd_pr__res_generic_po w=0.5 l=40
X$20 \$2.x2_x1_net5 \$2.x2_x1_net4 sky130_fd_pr__res_generic_po w=0.5 l=40
X$21 \$2.x2_x2_net7 \$2.x2_x2_net1 sky130_fd_pr__res_generic_po w=0.5 l=40
X$22 \$2.x2_x2_net7 \$2.x2_x2_net6 sky130_fd_pr__res_generic_po w=0.5 l=40
X$23 \$2.x2_x1_net7 \$2.x2_x1_net1 sky130_fd_pr__res_generic_po w=0.5 l=40
X$24 \$2.x2_x1_net7 \$2.x2_x1_net6 sky130_fd_pr__res_generic_po w=0.5 l=40
X$25 \$2.x2_x2_net11 \$2.x2_x2_net10 sky130_fd_pr__res_generic_po w=0.5 l=40
X$26 \$2.x2_x2_net11 \$2.x2_x2_net1 sky130_fd_pr__res_generic_po w=0.5 l=40
X$27 \$2.x2_x1_net11 \$2.x2_x1_net10 sky130_fd_pr__res_generic_po w=0.5 l=40
X$28 \$2.x2_x1_net11 \$2.x2_x1_net1 sky130_fd_pr__res_generic_po w=0.5 l=40
X$29 \$2.x2_x2_net9 \$2.x2_x2_net8 sky130_fd_pr__res_generic_po w=0.5 l=40
X$30 \$2.x2_x2_net9 \$2.x2_x2_net10 sky130_fd_pr__res_generic_po w=0.5 l=40
X$31 \$2.x2_x1_net9 \$2.x2_x1_net8 sky130_fd_pr__res_generic_po w=0.5 l=40
X$32 \$2.x2_x1_net9 \$2.x2_x1_net10 sky130_fd_pr__res_generic_po w=0.5 l=40
X$33 \$2.x2_x2_net2 \$2.x2_x2_net8 sky130_fd_pr__res_generic_po w=0.5 l=40
X$34 \$2.x2_x2_net2 \$2.x2_x2_net12 sky130_fd_pr__res_generic_po w=0.5 l=40
X$35 \$2.x2_x1_net2 \$2.x2_x1_net8 sky130_fd_pr__res_generic_po w=0.5 l=40
X$36 \$2.x2_x1_net2 \$2.x2_x1_net12 sky130_fd_pr__res_generic_po w=0.5 l=40
X$37 \$2.x2_x2_net13 \$2.x2_x2_net14 sky130_fd_pr__res_generic_po w=0.5 l=40
X$38 \$2.x2_x2_net13 \$2.x2_x2_net12 sky130_fd_pr__res_generic_po w=0.5 l=40
X$39 \$2.x2_x1_net13 \$2.x2_x1_net14 sky130_fd_pr__res_generic_po w=0.5 l=40
X$40 \$2.x2_x1_net13 \$2.x2_x1_net12 sky130_fd_pr__res_generic_po w=0.5 l=40
X$41 \$2.x2_x2_net15 \$2.x2_x2_net3 sky130_fd_pr__res_generic_po w=0.5 l=40
X$42 \$2.x2_x2_net15 \$2.x2_x2_net14 sky130_fd_pr__res_generic_po w=0.5 l=40
X$43 \$2.x2_x1_net15 \$2.x2_x1_net3 sky130_fd_pr__res_generic_po w=0.5 l=40
X$44 \$2.x2_x1_net15 \$2.x2_x1_net14 sky130_fd_pr__res_generic_po w=0.5 l=40
X$45 \$2.x2_x2_net19 \$2.x2_x2_net18 sky130_fd_pr__res_generic_po w=0.5 l=40
X$46 \$2.x2_x2_net19 \$2.x2_x2_net3 sky130_fd_pr__res_generic_po w=0.5 l=40
X$47 \$2.x2_x1_net19 \$2.x2_x1_net18 sky130_fd_pr__res_generic_po w=0.5 l=40
X$48 \$2.x2_x1_net19 \$2.x2_x1_net3 sky130_fd_pr__res_generic_po w=0.5 l=40
X$49 \$2.x2_x2_net17 \$2.x2_x2_net16 sky130_fd_pr__res_generic_po w=0.5 l=40
X$50 \$2.x2_x2_net17 \$2.x2_x2_net18 sky130_fd_pr__res_generic_po w=0.5 l=40
X$51 \$2.x2_x1_net17 \$2.x2_x1_net16 sky130_fd_pr__res_generic_po w=0.5 l=40
X$52 \$2.x2_x1_net17 \$2.x2_x1_net18 sky130_fd_pr__res_generic_po w=0.5 l=40
X$53 Vdd \$451 \$451 Vdd sky130_fd_pr__pfet_01v8_lvt l=10 w=1.5 as=0.435
+ ad=0.435 ps=3.58 pd=3.58
X$54 Vdd \$451 \$451 Vdd sky130_fd_pr__pfet_01v8_lvt l=10 w=1.5 as=0.435
+ ad=0.435 ps=3.58 pd=3.58
X$55 Vdd Vdd Vdd Vdd sky130_fd_pr__pfet_01v8_lvt l=5 w=1 as=0.29 ad=0.145
+ ps=2.58 pd=1.29
X$56 Vdd Vdd Vdd Vdd sky130_fd_pr__pfet_01v8_lvt l=5 w=1 as=0.145 ad=0.29
+ ps=1.29 pd=2.58
X$57 Vdd Vdd Vdd Vdd sky130_fd_pr__pfet_01v8_lvt l=5 w=1 as=0.29 ad=0.145
+ ps=2.58 pd=1.29
X$58 Vdd Vdd Vdd Vdd sky130_fd_pr__pfet_01v8_lvt l=5 w=1 as=0.145 ad=0.29
+ ps=1.29 pd=2.58
X$59 \$433 \$292 Vdd Vdd sky130_fd_pr__pfet_01v8_lvt l=5 w=1 as=0.29 ad=0.145
+ ps=2.58 pd=1.29
X$60 Vdd \$292 \$433 Vdd sky130_fd_pr__pfet_01v8_lvt l=5 w=1 as=0.145 ad=0.29
+ ps=1.29 pd=2.58
X$61 \$442 \$292 Vdd Vdd sky130_fd_pr__pfet_01v8_lvt l=5 w=1 as=0.29 ad=0.145
+ ps=2.58 pd=1.29
X$62 Vdd \$292 \$442 Vdd sky130_fd_pr__pfet_01v8_lvt l=5 w=1 as=0.145 ad=0.29
+ ps=1.29 pd=2.58
X$63 \$433 \$292 Vdd Vdd sky130_fd_pr__pfet_01v8_lvt l=5 w=1 as=0.29 ad=0.145
+ ps=2.58 pd=1.29
X$64 Vdd \$292 \$433 Vdd sky130_fd_pr__pfet_01v8_lvt l=5 w=1 as=0.145 ad=0.29
+ ps=1.29 pd=2.58
X$65 \$442 \$292 Vdd Vdd sky130_fd_pr__pfet_01v8_lvt l=5 w=1 as=0.29 ad=0.145
+ ps=2.58 pd=1.29
X$66 Vdd \$292 \$442 Vdd sky130_fd_pr__pfet_01v8_lvt l=5 w=1 as=0.145 ad=0.29
+ ps=1.29 pd=2.58
X$67 \$442 \$292 Vdd Vdd sky130_fd_pr__pfet_01v8_lvt l=5 w=1 as=0.29 ad=0.145
+ ps=2.58 pd=1.29
X$68 Vdd \$292 \$442 Vdd sky130_fd_pr__pfet_01v8_lvt l=5 w=1 as=0.145 ad=0.29
+ ps=1.29 pd=2.58
X$69 \$433 \$292 Vdd Vdd sky130_fd_pr__pfet_01v8_lvt l=5 w=1 as=0.29 ad=0.145
+ ps=2.58 pd=1.29
X$70 Vdd \$292 \$433 Vdd sky130_fd_pr__pfet_01v8_lvt l=5 w=1 as=0.145 ad=0.29
+ ps=1.29 pd=2.58
X$71 \$442 \$292 Vdd Vdd sky130_fd_pr__pfet_01v8_lvt l=5 w=1 as=0.29 ad=0.145
+ ps=2.58 pd=1.29
X$72 Vdd \$292 \$442 Vdd sky130_fd_pr__pfet_01v8_lvt l=5 w=1 as=0.145 ad=0.29
+ ps=1.29 pd=2.58
X$73 \$433 \$292 Vdd Vdd sky130_fd_pr__pfet_01v8_lvt l=5 w=1 as=0.29 ad=0.145
+ ps=2.58 pd=1.29
X$74 Vdd \$292 \$433 Vdd sky130_fd_pr__pfet_01v8_lvt l=5 w=1 as=0.145 ad=0.29
+ ps=1.29 pd=2.58
X$75 Vdd Vdd Vdd Vdd sky130_fd_pr__pfet_01v8_lvt l=5 w=1 as=0.29 ad=0.145
+ ps=2.58 pd=1.29
X$76 Vdd Vdd Vdd Vdd sky130_fd_pr__pfet_01v8_lvt l=5 w=1 as=0.145 ad=0.29
+ ps=1.29 pd=2.58
X$77 Vdd Vdd Vdd Vdd sky130_fd_pr__pfet_01v8_lvt l=5 w=1 as=0.29 ad=0.145
+ ps=2.58 pd=1.29
X$78 Vdd Vdd Vdd Vdd sky130_fd_pr__pfet_01v8_lvt l=5 w=1 as=0.145 ad=0.29
+ ps=1.29 pd=2.58
X$79 \$69 \$451 \$442 Vdd sky130_fd_pr__pfet_01v8_lvt l=5 w=1 as=0.29 ad=0.145
+ ps=2.58 pd=1.29
X$80 \$442 \$451 \$69 Vdd sky130_fd_pr__pfet_01v8_lvt l=5 w=1 as=0.145 ad=0.29
+ ps=1.29 pd=2.58
X$81 \$71 \$451 \$433 Vdd sky130_fd_pr__pfet_01v8_lvt l=5 w=1 as=0.29 ad=0.145
+ ps=2.58 pd=1.29
X$82 \$433 \$451 \$71 Vdd sky130_fd_pr__pfet_01v8_lvt l=5 w=1 as=0.145 ad=0.29
+ ps=1.29 pd=2.58
X$83 \$69 \$451 \$442 Vdd sky130_fd_pr__pfet_01v8_lvt l=5 w=1 as=0.29 ad=0.145
+ ps=2.58 pd=1.29
X$84 \$442 \$451 \$69 Vdd sky130_fd_pr__pfet_01v8_lvt l=5 w=1 as=0.145 ad=0.29
+ ps=1.29 pd=2.58
X$85 \$71 \$451 \$433 Vdd sky130_fd_pr__pfet_01v8_lvt l=5 w=1 as=0.29 ad=0.145
+ ps=2.58 pd=1.29
X$86 \$433 \$451 \$71 Vdd sky130_fd_pr__pfet_01v8_lvt l=5 w=1 as=0.145 ad=0.29
+ ps=1.29 pd=2.58
X$87 Vss \$129 \$129 sky130_gnd sky130_fd_pr__nfet_01v8_lvt l=5 w=0.6 as=0.174
+ ad=0.174 ps=1.78 pd=1.78
X$88 Vss \$129 \$129 sky130_gnd sky130_fd_pr__nfet_01v8_lvt l=5 w=0.6 as=0.174
+ ad=0.174 ps=1.78 pd=1.78
X$89 Vss Vss Vss sky130_gnd sky130_fd_pr__nfet_01v8_lvt l=4 w=4 as=1.16 ad=1.16
+ ps=8.58 pd=8.58
X$90 Vss Vss Vss sky130_gnd sky130_fd_pr__nfet_01v8_lvt l=4 w=4 as=1.16 ad=1.16
+ ps=8.58 pd=8.58
X$91 \$127 Vm \$433 sky130_gnd sky130_fd_pr__nfet_01v8_lvt l=4 w=4 as=1.16
+ ad=1.16 ps=8.58 pd=8.58
X$92 \$127 Vp \$442 sky130_gnd sky130_fd_pr__nfet_01v8_lvt l=4 w=4 as=1.16
+ ad=1.16 ps=8.58 pd=8.58
X$93 \$127 Vp \$442 sky130_gnd sky130_fd_pr__nfet_01v8_lvt l=4 w=4 as=1.16
+ ad=1.16 ps=8.58 pd=8.58
X$94 \$127 Vm \$433 sky130_gnd sky130_fd_pr__nfet_01v8_lvt l=4 w=4 as=1.16
+ ad=1.16 ps=8.58 pd=8.58
X$95 Vdd \$158 \$158 Vdd sky130_fd_pr__pfet_01v8_lvt l=20 w=1 as=0.29 ad=0.29
+ ps=2.58 pd=2.58
X$96 Vdd \$158 \$158 Vdd sky130_fd_pr__pfet_01v8_lvt l=20 w=1 as=0.29 ad=0.29
+ ps=2.58 pd=2.58
X$97 Vdd Vdd Vdd Vdd sky130_fd_pr__pfet_01v8_lvt l=1 w=5 as=1.45 ad=1.45
+ ps=10.58 pd=10.58
X$98 Vdd Vdd Vdd Vdd sky130_fd_pr__pfet_01v8_lvt l=1 w=5 as=1.45 ad=1.45
+ ps=10.58 pd=10.58
X$99 Vdd \$271 \$271 Vdd sky130_fd_pr__pfet_01v8_lvt l=1 w=5 as=1.45 ad=1.45
+ ps=10.58 pd=10.58
X$100 Vdd \$271 \$157 Vdd sky130_fd_pr__pfet_01v8_lvt l=1 w=5 as=1.45 ad=1.45
+ ps=10.58 pd=10.58
X$101 Vdd \$271 \$271 Vdd sky130_fd_pr__pfet_01v8_lvt l=1 w=5 as=1.45 ad=1.45
+ ps=10.58 pd=10.58
X$102 Vdd \$271 \$157 Vdd sky130_fd_pr__pfet_01v8_lvt l=1 w=5 as=1.45 ad=1.45
+ ps=10.58 pd=10.58
X$103 Vdd Vdd Vdd Vdd sky130_fd_pr__pfet_01v8_lvt l=1 w=5 as=1.45 ad=1.45
+ ps=10.58 pd=10.58
X$104 Vdd \$157 \$171 Vdd sky130_fd_pr__pfet_01v8_lvt l=1 w=5 as=1.45 ad=1.45
+ ps=10.58 pd=10.58
X$105 Vdd \$157 \$227 Vdd sky130_fd_pr__pfet_01v8_lvt l=1 w=5 as=1.45 ad=1.45
+ ps=10.58 pd=10.58
X$106 Vdd \$157 \$171 Vdd sky130_fd_pr__pfet_01v8_lvt l=1 w=5 as=1.45 ad=1.45
+ ps=10.58 pd=10.58
X$107 Vdd \$157 \$227 Vdd sky130_fd_pr__pfet_01v8_lvt l=1 w=5 as=1.45 ad=1.45
+ ps=10.58 pd=10.58
X$108 Vdd Vdd Vdd Vdd sky130_fd_pr__pfet_01v8_lvt l=1 w=5 as=1.45 ad=1.45
+ ps=10.58 pd=10.58
X$109 Vdd \$157 \$36 Vdd sky130_fd_pr__pfet_01v8_lvt l=1 w=5 as=1.45 ad=1.45
+ ps=10.58 pd=10.58
X$110 Vdd \$157 \$288 Vdd sky130_fd_pr__pfet_01v8_lvt l=1 w=5 as=1.45 ad=1.45
+ ps=10.58 pd=10.58
X$111 Vdd Vdd Vdd Vdd sky130_fd_pr__pfet_01v8_lvt l=1 w=5 as=1.45 ad=1.45
+ ps=10.58 pd=10.58
X$112 Vdd Vdd Vdd Vdd sky130_fd_pr__pfet_01v8_lvt l=1 w=5 as=1.45 ad=1.45
+ ps=10.58 pd=10.58
X$113 Vdd \$157 \$288 Vdd sky130_fd_pr__pfet_01v8_lvt l=1 w=5 as=1.45 ad=1.45
+ ps=10.58 pd=10.58
X$114 Vdd \$157 \$36 Vdd sky130_fd_pr__pfet_01v8_lvt l=1 w=5 as=1.45 ad=1.45
+ ps=10.58 pd=10.58
X$115 Vdd Vdd Vdd Vdd sky130_fd_pr__pfet_01v8_lvt l=1 w=5 as=1.45 ad=1.45
+ ps=10.58 pd=10.58
X$116 Vdd \$157 \$129 Vdd sky130_fd_pr__pfet_01v8_lvt l=1 w=5 as=1.45 ad=1.45
+ ps=10.58 pd=10.58
X$117 Vdd \$157 \$172 Vdd sky130_fd_pr__pfet_01v8_lvt l=1 w=5 as=1.45 ad=1.45
+ ps=10.58 pd=10.58
X$118 Vdd \$157 \$129 Vdd sky130_fd_pr__pfet_01v8_lvt l=1 w=5 as=1.45 ad=1.45
+ ps=10.58 pd=10.58
X$119 Vdd \$157 \$172 Vdd sky130_fd_pr__pfet_01v8_lvt l=1 w=5 as=1.45 ad=1.45
+ ps=10.58 pd=10.58
X$120 Vdd Vdd Vdd Vdd sky130_fd_pr__pfet_01v8_lvt l=1 w=5 as=1.45 ad=1.45
+ ps=10.58 pd=10.58
X$121 Vss Vss Vss sky130_gnd sky130_fd_pr__nfet_01v8_lvt l=20 w=1 as=0.29
+ ad=0.29 ps=2.58 pd=2.58
X$122 Vss Vss Vss sky130_gnd sky130_fd_pr__nfet_01v8_lvt l=20 w=1 as=0.29
+ ad=0.29 ps=2.58 pd=2.58
X$123 Vss \$172 \$291 sky130_gnd sky130_fd_pr__nfet_01v8_lvt l=20 w=1 as=0.29
+ ad=0.29 ps=2.58 pd=2.58
X$124 Vss \$172 \$344 sky130_gnd sky130_fd_pr__nfet_01v8_lvt l=20 w=1 as=0.29
+ ad=0.29 ps=2.58 pd=2.58
X$125 Vss \$172 \$344 sky130_gnd sky130_fd_pr__nfet_01v8_lvt l=20 w=1 as=0.29
+ ad=0.29 ps=2.58 pd=2.58
X$126 Vss \$172 \$291 sky130_gnd sky130_fd_pr__nfet_01v8_lvt l=20 w=1 as=0.29
+ ad=0.29 ps=2.58 pd=2.58
X$127 Vss Vss Vss sky130_gnd sky130_fd_pr__nfet_01v8_lvt l=20 w=5 as=1.45
+ ad=1.45 ps=10.58 pd=10.58
X$128 Vss Vss Vss sky130_gnd sky130_fd_pr__nfet_01v8_lvt l=20 w=5 as=1.45
+ ad=1.45 ps=10.58 pd=10.58
X$129 \$344 \$71 \$282 sky130_gnd sky130_fd_pr__nfet_01v8_lvt l=20 w=5 as=1.45
+ ad=1.45 ps=10.58 pd=10.58
X$130 \$344 VREF \$292 sky130_gnd sky130_fd_pr__nfet_01v8_lvt l=20 w=5 as=1.45
+ ad=1.45 ps=10.58 pd=10.58
X$131 \$344 VREF \$292 sky130_gnd sky130_fd_pr__nfet_01v8_lvt l=20 w=5 as=1.45
+ ad=1.45 ps=10.58 pd=10.58
X$132 \$344 \$71 \$282 sky130_gnd sky130_fd_pr__nfet_01v8_lvt l=20 w=5 as=1.45
+ ad=1.45 ps=10.58 pd=10.58
X$133 Vss Vss Vss sky130_gnd sky130_fd_pr__nfet_01v8_lvt l=20 w=5 as=1.45
+ ad=1.45 ps=10.58 pd=10.58
X$134 Vss Vss Vss sky130_gnd sky130_fd_pr__nfet_01v8_lvt l=20 w=5 as=1.45
+ ad=1.45 ps=10.58 pd=10.58
X$135 \$291 \$69 \$282 sky130_gnd sky130_fd_pr__nfet_01v8_lvt l=20 w=5 as=1.45
+ ad=1.45 ps=10.58 pd=10.58
X$136 \$291 VREF \$292 sky130_gnd sky130_fd_pr__nfet_01v8_lvt l=20 w=5 as=1.45
+ ad=1.45 ps=10.58 pd=10.58
X$137 \$291 VREF \$292 sky130_gnd sky130_fd_pr__nfet_01v8_lvt l=20 w=5 as=1.45
+ ad=1.45 ps=10.58 pd=10.58
X$138 \$291 \$69 \$282 sky130_gnd sky130_fd_pr__nfet_01v8_lvt l=20 w=5 as=1.45
+ ad=1.45 ps=10.58 pd=10.58
X$139 RGM \$227 \$227 sky130_gnd sky130_fd_pr__nfet_01v8_lvt l=1 w=10 as=2.9
+ ad=2.9 ps=20.58 pd=20.58
X$140 RGM \$227 \$227 sky130_gnd sky130_fd_pr__nfet_01v8_lvt l=1 w=10 as=2.9
+ ad=2.9 ps=20.58 pd=20.58
X$141 \$171 \$158 \$157 sky130_gnd sky130_fd_pr__nfet_01v8_lvt l=1 w=2 as=0.58
+ ad=0.58 ps=4.58 pd=4.58
X$142 Vss \$227 \$271 sky130_gnd sky130_fd_pr__nfet_01v8_lvt l=2 w=5 as=1.45
+ ad=1.45 ps=10.58 pd=10.58
X$143 Vss \$227 \$271 sky130_gnd sky130_fd_pr__nfet_01v8_lvt l=2 w=5 as=1.45
+ ad=1.45 ps=10.58 pd=10.58
X$144 Vss \$171 \$157 sky130_gnd sky130_fd_pr__nfet_01v8_lvt l=2 w=5 as=1.45
+ ad=1.45 ps=10.58 pd=10.58
X$145 Vss \$171 \$157 sky130_gnd sky130_fd_pr__nfet_01v8_lvt l=2 w=5 as=1.45
+ ad=1.45 ps=10.58 pd=10.58
X$146 Vss Vss Vss sky130_gnd sky130_fd_pr__nfet_01v8_lvt l=2 w=5 as=1.45
+ ad=1.45 ps=10.58 pd=10.58
X$147 Vss Vss Vss sky130_gnd sky130_fd_pr__nfet_01v8_lvt l=2 w=5 as=1.45
+ ad=1.45 ps=10.58 pd=10.58
X$148 Vss \$171 \$171 sky130_gnd sky130_fd_pr__nfet_01v8_lvt l=2 w=5 as=1.45
+ ad=1.45 ps=10.58 pd=10.58
X$149 Vss \$171 \$158 sky130_gnd sky130_fd_pr__nfet_01v8_lvt l=2 w=5 as=1.45
+ ad=1.45 ps=10.58 pd=10.58
X$150 Vss \$171 \$158 sky130_gnd sky130_fd_pr__nfet_01v8_lvt l=2 w=5 as=1.45
+ ad=1.45 ps=10.58 pd=10.58
X$151 Vss \$171 \$171 sky130_gnd sky130_fd_pr__nfet_01v8_lvt l=2 w=5 as=1.45
+ ad=1.45 ps=10.58 pd=10.58
X$152 Vss \$172 \$172 sky130_gnd sky130_fd_pr__nfet_01v8_lvt l=2 w=1 as=0.29
+ ad=0.29 ps=2.58 pd=2.58
X$153 Vss \$172 \$172 sky130_gnd sky130_fd_pr__nfet_01v8_lvt l=2 w=1 as=0.29
+ ad=0.29 ps=2.58 pd=2.58
X$154 Vss \$172 \$136 sky130_gnd sky130_fd_pr__nfet_01v8_lvt l=10 w=1 as=0.29
+ ad=0.29 ps=2.58 pd=2.58
X$155 Vss \$172 \$136 sky130_gnd sky130_fd_pr__nfet_01v8_lvt l=10 w=1 as=0.29
+ ad=0.29 ps=2.58 pd=2.58
X$156 Vss \$172 \$141 sky130_gnd sky130_fd_pr__nfet_01v8_lvt l=10 w=1 as=0.29
+ ad=0.29 ps=2.58 pd=2.58
X$157 Vss \$172 \$141 sky130_gnd sky130_fd_pr__nfet_01v8_lvt l=10 w=1 as=0.29
+ ad=0.29 ps=2.58 pd=2.58
X$158 Vss \$172 \$126 sky130_gnd sky130_fd_pr__nfet_01v8_lvt l=10 w=1 as=0.29
+ ad=0.29 ps=2.58 pd=2.58
X$159 Vss \$172 \$126 sky130_gnd sky130_fd_pr__nfet_01v8_lvt l=10 w=1 as=0.29
+ ad=0.29 ps=2.58 pd=2.58
X$160 Vss \$172 \$159 sky130_gnd sky130_fd_pr__nfet_01v8_lvt l=10 w=1 as=0.29
+ ad=0.29 ps=2.58 pd=2.58
X$161 Vss \$172 \$159 sky130_gnd sky130_fd_pr__nfet_01v8_lvt l=10 w=1 as=0.29
+ ad=0.29 ps=2.58 pd=2.58
X$162 Vss Vss Vss sky130_gnd sky130_fd_pr__nfet_01v8_lvt l=10 w=1 as=0.29
+ ad=0.29 ps=2.58 pd=2.58
X$163 Vss Vss Vss sky130_gnd sky130_fd_pr__nfet_01v8_lvt l=10 w=1 as=0.29
+ ad=0.29 ps=2.58 pd=2.58
X$164 Vss Vss Vss sky130_gnd sky130_fd_pr__nfet_01v8_lvt l=20 w=0.5 as=0.145
+ ad=0.145 ps=1.58 pd=1.58
X$165 Vss Vss Vss sky130_gnd sky130_fd_pr__nfet_01v8_lvt l=20 w=0.5 as=0.145
+ ad=0.145 ps=1.58 pd=1.58
X$166 Vss \$10 \$10 sky130_gnd sky130_fd_pr__nfet_01v8_lvt l=20 w=0.5 as=0.145
+ ad=0.145 ps=1.58 pd=1.58
X$167 Vss \$10 \$11 sky130_gnd sky130_fd_pr__nfet_01v8_lvt l=20 w=0.5 as=0.145
+ ad=0.145 ps=1.58 pd=1.58
X$168 Vss \$10 \$11 sky130_gnd sky130_fd_pr__nfet_01v8_lvt l=20 w=0.5 as=0.145
+ ad=0.145 ps=1.58 pd=1.58
X$169 Vss \$10 \$10 sky130_gnd sky130_fd_pr__nfet_01v8_lvt l=20 w=0.5 as=0.145
+ ad=0.145 ps=1.58 pd=1.58
X$170 \$159 \$129 \$127 sky130_gnd sky130_fd_pr__nfet_01v8_lvt l=1 w=1 as=0.29
+ ad=0.29 ps=2.58 pd=2.58
X$171 \$159 \$129 \$127 sky130_gnd sky130_fd_pr__nfet_01v8_lvt l=1 w=1 as=0.29
+ ad=0.29 ps=2.58 pd=2.58
X$172 \$141 \$129 \$71 sky130_gnd sky130_fd_pr__nfet_01v8_lvt l=1 w=1 as=0.29
+ ad=0.29 ps=2.58 pd=2.58
X$173 \$141 \$129 \$71 sky130_gnd sky130_fd_pr__nfet_01v8_lvt l=1 w=1 as=0.29
+ ad=0.29 ps=2.58 pd=2.58
X$174 Vss Vss Vss sky130_gnd sky130_fd_pr__nfet_01v8_lvt l=1 w=1 as=0.29
+ ad=0.29 ps=2.58 pd=2.58
X$175 Vss Vss Vss sky130_gnd sky130_fd_pr__nfet_01v8_lvt l=1 w=1 as=0.29
+ ad=0.29 ps=2.58 pd=2.58
X$176 \$126 \$129 \$127 sky130_gnd sky130_fd_pr__nfet_01v8_lvt l=1 w=1 as=0.29
+ ad=0.29 ps=2.58 pd=2.58
X$177 \$126 \$129 \$127 sky130_gnd sky130_fd_pr__nfet_01v8_lvt l=1 w=1 as=0.29
+ ad=0.29 ps=2.58 pd=2.58
X$178 \$136 \$129 \$69 sky130_gnd sky130_fd_pr__nfet_01v8_lvt l=1 w=1 as=0.29
+ ad=0.29 ps=2.58 pd=2.58
X$179 \$136 \$129 \$69 sky130_gnd sky130_fd_pr__nfet_01v8_lvt l=1 w=1 as=0.29
+ ad=0.29 ps=2.58 pd=2.58
X$180 Vss Vss Vss sky130_gnd sky130_fd_pr__nfet_01v8_lvt l=1 w=1 as=0.29
+ ad=0.29 ps=2.58 pd=2.58
X$181 Vss Vss Vss sky130_gnd sky130_fd_pr__nfet_01v8_lvt l=1 w=1 as=0.29
+ ad=0.29 ps=2.58 pd=2.58
X$182 Vss \$11 Vop sky130_gnd sky130_fd_pr__nfet_01v8_lvt l=1 w=1 as=0.29
+ ad=0.29 ps=2.58 pd=2.58
X$183 Vss \$11 Vop sky130_gnd sky130_fd_pr__nfet_01v8_lvt l=1 w=1 as=0.29
+ ad=0.29 ps=2.58 pd=2.58
X$184 Vss \$11 Vop sky130_gnd sky130_fd_pr__nfet_01v8_lvt l=1 w=1 as=0.29
+ ad=0.29 ps=2.58 pd=2.58
X$185 Vss \$11 Vop sky130_gnd sky130_fd_pr__nfet_01v8_lvt l=1 w=1 as=0.29
+ ad=0.29 ps=2.58 pd=2.58
X$186 Vss \$11 Vop sky130_gnd sky130_fd_pr__nfet_01v8_lvt l=1 w=1 as=0.29
+ ad=0.29 ps=2.58 pd=2.58
X$187 Vss \$11 Vop sky130_gnd sky130_fd_pr__nfet_01v8_lvt l=1 w=1 as=0.29
+ ad=0.29 ps=2.58 pd=2.58
X$188 Vss \$11 Vop sky130_gnd sky130_fd_pr__nfet_01v8_lvt l=1 w=1 as=0.29
+ ad=0.29 ps=2.58 pd=2.58
X$189 Vss \$11 Vop sky130_gnd sky130_fd_pr__nfet_01v8_lvt l=1 w=1 as=0.29
+ ad=0.29 ps=2.58 pd=2.58
X$190 Vss \$11 Vop sky130_gnd sky130_fd_pr__nfet_01v8_lvt l=1 w=1 as=0.29
+ ad=0.29 ps=2.58 pd=2.58
X$191 Vss Vss Vss sky130_gnd sky130_fd_pr__nfet_01v8_lvt l=1 w=1 as=0.29
+ ad=0.29 ps=2.58 pd=2.58
X$192 Vss \$11 Vom sky130_gnd sky130_fd_pr__nfet_01v8_lvt l=1 w=1 as=0.29
+ ad=0.29 ps=2.58 pd=2.58
X$193 Vss \$11 Vom sky130_gnd sky130_fd_pr__nfet_01v8_lvt l=1 w=1 as=0.29
+ ad=0.29 ps=2.58 pd=2.58
X$194 Vss \$11 Vom sky130_gnd sky130_fd_pr__nfet_01v8_lvt l=1 w=1 as=0.29
+ ad=0.29 ps=2.58 pd=2.58
X$195 Vss \$11 Vom sky130_gnd sky130_fd_pr__nfet_01v8_lvt l=1 w=1 as=0.29
+ ad=0.29 ps=2.58 pd=2.58
X$196 Vss \$11 Vom sky130_gnd sky130_fd_pr__nfet_01v8_lvt l=1 w=1 as=0.29
+ ad=0.29 ps=2.58 pd=2.58
X$197 Vss \$11 Vom sky130_gnd sky130_fd_pr__nfet_01v8_lvt l=1 w=1 as=0.29
+ ad=0.29 ps=2.58 pd=2.58
X$198 Vss \$11 Vom sky130_gnd sky130_fd_pr__nfet_01v8_lvt l=1 w=1 as=0.29
+ ad=0.29 ps=2.58 pd=2.58
X$199 Vss \$11 Vom sky130_gnd sky130_fd_pr__nfet_01v8_lvt l=1 w=1 as=0.29
+ ad=0.29 ps=2.58 pd=2.58
X$200 Vss Vss Vss sky130_gnd sky130_fd_pr__nfet_01v8_lvt l=1 w=1 as=0.29
+ ad=0.29 ps=2.58 pd=2.58
X$201 Vss \$11 Vom sky130_gnd sky130_fd_pr__nfet_01v8_lvt l=1 w=1 as=0.29
+ ad=0.29 ps=2.58 pd=2.58
X$202 Vss Vss Vss sky130_gnd sky130_fd_pr__nfet_01v8_lvt l=1 w=0.6 as=0.174
+ ad=0.174 ps=1.78 pd=1.78
X$203 Vss Vss Vss sky130_gnd sky130_fd_pr__nfet_01v8_lvt l=1 w=0.6 as=0.174
+ ad=0.174 ps=1.78 pd=1.78
X$204 Vss \$288 \$451 sky130_gnd sky130_fd_pr__nfet_01v8_lvt l=1 w=0.6 as=0.174
+ ad=0.174 ps=1.78 pd=1.78
X$205 Vss \$288 \$288 sky130_gnd sky130_fd_pr__nfet_01v8_lvt l=1 w=0.6 as=0.174
+ ad=0.174 ps=1.78 pd=1.78
X$206 Vss \$288 \$288 sky130_gnd sky130_fd_pr__nfet_01v8_lvt l=1 w=0.6 as=0.174
+ ad=0.174 ps=1.78 pd=1.78
X$207 Vss \$288 \$451 sky130_gnd sky130_fd_pr__nfet_01v8_lvt l=1 w=0.6 as=0.174
+ ad=0.174 ps=1.78 pd=1.78
X$208 Vss Vss Vss sky130_gnd sky130_fd_pr__nfet_01v8_lvt l=1 w=0.6 as=0.174
+ ad=0.174 ps=1.78 pd=1.78
X$209 Vss Vss Vss sky130_gnd sky130_fd_pr__nfet_01v8_lvt l=1 w=0.6 as=0.174
+ ad=0.174 ps=1.78 pd=1.78
X$210 Vss \$36 \$36 sky130_gnd sky130_fd_pr__nfet_01v8_lvt l=1 w=0.6 as=0.174
+ ad=0.174 ps=1.78 pd=1.78
X$211 Vss \$36 \$35 sky130_gnd sky130_fd_pr__nfet_01v8_lvt l=1 w=0.6 as=0.174
+ ad=0.174 ps=1.78 pd=1.78
X$212 Vss \$36 \$35 sky130_gnd sky130_fd_pr__nfet_01v8_lvt l=1 w=0.6 as=0.174
+ ad=0.174 ps=1.78 pd=1.78
X$213 Vss \$36 \$36 sky130_gnd sky130_fd_pr__nfet_01v8_lvt l=1 w=0.6 as=0.174
+ ad=0.174 ps=1.78 pd=1.78
X$214 Vom \$71 Vdd Vdd sky130_fd_pr__pfet_01v8_lvt l=1 w=1 as=0.29 ad=0.145
+ ps=2.58 pd=1.29
X$215 Vdd \$71 Vom Vdd sky130_fd_pr__pfet_01v8_lvt l=1 w=1 as=0.145 ad=0.29
+ ps=1.29 pd=2.58
X$216 Vom \$71 Vdd Vdd sky130_fd_pr__pfet_01v8_lvt l=1 w=1 as=0.29 ad=0.145
+ ps=2.58 pd=1.29
X$217 Vdd \$71 Vom Vdd sky130_fd_pr__pfet_01v8_lvt l=1 w=1 as=0.145 ad=0.29
+ ps=1.29 pd=2.58
X$218 Vom \$71 Vdd Vdd sky130_fd_pr__pfet_01v8_lvt l=1 w=1 as=0.29 ad=0.145
+ ps=2.58 pd=1.29
X$219 Vdd \$71 Vom Vdd sky130_fd_pr__pfet_01v8_lvt l=1 w=1 as=0.145 ad=0.29
+ ps=1.29 pd=2.58
X$220 Vom \$71 Vdd Vdd sky130_fd_pr__pfet_01v8_lvt l=1 w=1 as=0.29 ad=0.145
+ ps=2.58 pd=1.29
X$221 Vdd \$71 Vom Vdd sky130_fd_pr__pfet_01v8_lvt l=1 w=1 as=0.145 ad=0.29
+ ps=1.29 pd=2.58
X$222 Vom \$71 Vdd Vdd sky130_fd_pr__pfet_01v8_lvt l=1 w=1 as=0.29 ad=0.145
+ ps=2.58 pd=1.29
X$223 Vdd \$71 Vom Vdd sky130_fd_pr__pfet_01v8_lvt l=1 w=1 as=0.145 ad=0.29
+ ps=1.29 pd=2.58
X$224 Vom \$71 Vdd Vdd sky130_fd_pr__pfet_01v8_lvt l=1 w=1 as=0.29 ad=0.145
+ ps=2.58 pd=1.29
X$225 Vdd \$71 Vom Vdd sky130_fd_pr__pfet_01v8_lvt l=1 w=1 as=0.145 ad=0.29
+ ps=1.29 pd=2.58
X$226 Vom \$71 Vdd Vdd sky130_fd_pr__pfet_01v8_lvt l=1 w=1 as=0.29 ad=0.145
+ ps=2.58 pd=1.29
X$227 Vdd \$71 Vom Vdd sky130_fd_pr__pfet_01v8_lvt l=1 w=1 as=0.145 ad=0.29
+ ps=1.29 pd=2.58
X$228 Vom \$71 Vdd Vdd sky130_fd_pr__pfet_01v8_lvt l=1 w=1 as=0.29 ad=0.145
+ ps=2.58 pd=1.29
X$229 Vdd \$71 Vom Vdd sky130_fd_pr__pfet_01v8_lvt l=1 w=1 as=0.145 ad=0.29
+ ps=1.29 pd=2.58
X$230 Vom \$71 Vdd Vdd sky130_fd_pr__pfet_01v8_lvt l=1 w=1 as=0.29 ad=0.145
+ ps=2.58 pd=1.29
X$231 Vdd \$71 Vom Vdd sky130_fd_pr__pfet_01v8_lvt l=1 w=1 as=0.145 ad=0.29
+ ps=1.29 pd=2.58
X$232 Vop \$69 Vdd Vdd sky130_fd_pr__pfet_01v8_lvt l=1 w=1 as=0.29 ad=0.145
+ ps=2.58 pd=1.29
X$233 Vdd \$69 Vop Vdd sky130_fd_pr__pfet_01v8_lvt l=1 w=1 as=0.145 ad=0.29
+ ps=1.29 pd=2.58
X$234 Vop \$69 Vdd Vdd sky130_fd_pr__pfet_01v8_lvt l=1 w=1 as=0.29 ad=0.145
+ ps=2.58 pd=1.29
X$235 Vdd \$69 Vop Vdd sky130_fd_pr__pfet_01v8_lvt l=1 w=1 as=0.145 ad=0.29
+ ps=1.29 pd=2.58
X$236 Vop \$69 Vdd Vdd sky130_fd_pr__pfet_01v8_lvt l=1 w=1 as=0.29 ad=0.145
+ ps=2.58 pd=1.29
X$237 Vdd \$69 Vop Vdd sky130_fd_pr__pfet_01v8_lvt l=1 w=1 as=0.145 ad=0.29
+ ps=1.29 pd=2.58
X$238 Vop \$69 Vdd Vdd sky130_fd_pr__pfet_01v8_lvt l=1 w=1 as=0.29 ad=0.145
+ ps=2.58 pd=1.29
X$239 Vdd \$69 Vop Vdd sky130_fd_pr__pfet_01v8_lvt l=1 w=1 as=0.145 ad=0.29
+ ps=1.29 pd=2.58
X$240 Vop \$69 Vdd Vdd sky130_fd_pr__pfet_01v8_lvt l=1 w=1 as=0.29 ad=0.145
+ ps=2.58 pd=1.29
X$241 Vdd \$69 Vop Vdd sky130_fd_pr__pfet_01v8_lvt l=1 w=1 as=0.145 ad=0.29
+ ps=1.29 pd=2.58
X$242 Vop \$69 Vdd Vdd sky130_fd_pr__pfet_01v8_lvt l=1 w=1 as=0.29 ad=0.145
+ ps=2.58 pd=1.29
X$243 Vdd \$69 Vop Vdd sky130_fd_pr__pfet_01v8_lvt l=1 w=1 as=0.145 ad=0.29
+ ps=1.29 pd=2.58
X$244 Vop \$69 Vdd Vdd sky130_fd_pr__pfet_01v8_lvt l=1 w=1 as=0.29 ad=0.145
+ ps=2.58 pd=1.29
X$245 Vdd \$69 Vop Vdd sky130_fd_pr__pfet_01v8_lvt l=1 w=1 as=0.145 ad=0.29
+ ps=1.29 pd=2.58
X$246 Vop \$69 Vdd Vdd sky130_fd_pr__pfet_01v8_lvt l=1 w=1 as=0.29 ad=0.145
+ ps=2.58 pd=1.29
X$247 Vdd \$69 Vop Vdd sky130_fd_pr__pfet_01v8_lvt l=1 w=1 as=0.145 ad=0.29
+ ps=1.29 pd=2.58
X$248 Vop \$69 Vdd Vdd sky130_fd_pr__pfet_01v8_lvt l=1 w=1 as=0.29 ad=0.145
+ ps=2.58 pd=1.29
X$249 Vdd \$69 Vop Vdd sky130_fd_pr__pfet_01v8_lvt l=1 w=1 as=0.145 ad=0.29
+ ps=1.29 pd=2.58
X$250 Vdd \$35 \$92 Vdd sky130_fd_pr__pfet_01v8_lvt l=5 w=1 as=0.29 ad=0.29
+ ps=2.58 pd=2.58
X$251 Vdd Vdd Vdd Vdd sky130_fd_pr__pfet_01v8_lvt l=5 w=1 as=0.29 ad=0.29
+ ps=2.58 pd=2.58
X$252 Vdd \$35 \$92 Vdd sky130_fd_pr__pfet_01v8_lvt l=5 w=1 as=0.29 ad=0.29
+ ps=2.58 pd=2.58
X$253 Vdd Vdd Vdd Vdd sky130_fd_pr__pfet_01v8_lvt l=1 w=6 as=1.74 ad=1.74
+ ps=12.58 pd=12.58
X$254 Vdd \$35 \$35 Vdd sky130_fd_pr__pfet_01v8_lvt l=1 w=6 as=1.74 ad=1.74
+ ps=12.58 pd=12.58
X$255 Vdd \$35 \$35 Vdd sky130_fd_pr__pfet_01v8_lvt l=1 w=6 as=1.74 ad=1.74
+ ps=12.58 pd=12.58
X$256 Vdd Vdd Vdd Vdd sky130_fd_pr__pfet_01v8_lvt l=10 w=1 as=0.29 ad=0.29
+ ps=2.58 pd=2.58
X$257 Vdd Vdd Vdd Vdd sky130_fd_pr__pfet_01v8_lvt l=10 w=1 as=0.29 ad=0.29
+ ps=2.58 pd=2.58
X$258 Vdd \$282 \$282 Vdd sky130_fd_pr__pfet_01v8_lvt l=10 w=1 as=0.29 ad=0.29
+ ps=2.58 pd=2.58
X$259 Vdd \$282 \$292 Vdd sky130_fd_pr__pfet_01v8_lvt l=10 w=1 as=0.29 ad=0.29
+ ps=2.58 pd=2.58
X$260 Vdd \$282 \$282 Vdd sky130_fd_pr__pfet_01v8_lvt l=10 w=1 as=0.29 ad=0.29
+ ps=2.58 pd=2.58
X$261 Vdd \$282 \$292 Vdd sky130_fd_pr__pfet_01v8_lvt l=10 w=1 as=0.29 ad=0.29
+ ps=2.58 pd=2.58
X$262 Vdd Vdd Vdd Vdd sky130_fd_pr__pfet_01v8_lvt l=10 w=1 as=0.29 ad=0.29
+ ps=2.58 pd=2.58
X$263 \$92 \$96 \$10 Vdd sky130_fd_pr__pfet_01v8_lvt l=10 w=1 as=0.29 ad=0.29
+ ps=2.58 pd=2.58
X$264 \$92 VREF \$11 Vdd sky130_fd_pr__pfet_01v8_lvt l=10 w=1 as=0.29 ad=0.29
+ ps=2.58 pd=2.58
X$265 \$92 VREF \$11 Vdd sky130_fd_pr__pfet_01v8_lvt l=10 w=1 as=0.29 ad=0.29
+ ps=2.58 pd=2.58
X$266 \$92 \$96 \$10 Vdd sky130_fd_pr__pfet_01v8_lvt l=10 w=1 as=0.29 ad=0.29
+ ps=2.58 pd=2.58
X$267 Vdd Vdd Vdd Vdd sky130_fd_pr__pfet_01v8_lvt l=10 w=1 as=0.29 ad=0.29
+ ps=2.58 pd=2.58
Cext_1 \$10 \$11 6.26051f
Cext_2 \$10 \$35 400.613a
Cext_3 \$10 \$36 611.593a
Cext_4 \$10 \$69 84.4122a
Cext_5 \$10 \$92 3.71263f
Cext_6 \$10 \$96 369.141a
Cext_7 \$10 Vdd 6.11453f
Cext_8 \$10 Vom 94.8834a
Cext_9 \$10 Vop 98.5754a
Cext_10 \$10 VREF 75.0027a
Cext_11 \$10 Vss 18.41f
Cext_12 \$10 sky130_gnd 38.7021f
Cext_13 \$11 \$36 235.533a
Cext_14 \$11 \$69 401.913a
Cext_15 \$11 \$92 3.48431f
Cext_16 \$11 \$96 43.1585a
Cext_17 \$11 Vdd 3.15298f
Cext_18 \$11 Vom 949.436a
Cext_19 \$11 Vop 1.42531f
Cext_20 \$11 VREF 326.011a
Cext_21 \$11 Vss 8.68744f
Cext_22 \$11 sky130_gnd 22.3553f
Cext_23 \$126 \$127 1.61276f
Cext_24 \$126 \$129 383.821a
Cext_25 \$126 \$136 607.657a
Cext_26 \$126 \$141 5.17208f
Cext_27 \$126 \$159 5.0078f
Cext_28 \$126 \$172 479.463a
Cext_29 \$126 \$69 1.20907f
Cext_30 \$126 \$71 85.7905a
Cext_31 \$126 VREF 0.470072a
Cext_32 \$126 Vss 847.298a
Cext_33 \$126 sky130_gnd 3.08371f
Cext_34 \$127 \$129 674.084a
Cext_35 \$127 \$136 216.733a
Cext_36 \$127 \$141 211.966a
Cext_37 \$127 \$159 1.41596f
Cext_38 \$127 \$172 572.408a
Cext_39 \$127 \$282 179.985a
Cext_40 \$127 \$291 191.397a
Cext_41 \$127 \$292 179.985a
Cext_42 \$127 \$344 199.867a
Cext_43 \$127 \$433 1.97785f
Cext_44 \$127 \$442 2.17515f
Cext_45 \$127 \$69 1.42057f
Cext_46 \$127 \$71 810.338a
Cext_47 \$127 Vdd 12.8177a
Cext_48 \$127 Vm 987.622a
Cext_49 \$127 Vp 1.01485f
Cext_50 \$127 VREF 638.062a
Cext_51 \$127 Vss 5.41477f
Cext_52 \$127 sky130_gnd 5.81918f
Cext_53 \$129 \$136 375.763a
Cext_54 \$129 \$141 372.765a
Cext_55 \$129 \$157 664.998a
Cext_56 \$129 \$159 381.968a
Cext_57 \$129 \$172 2.6459f
Cext_58 \$129 \$2.x2_x1_net6 1.64976a
Cext_59 \$129 \$2.x2_x2_net4 1.08261a
Cext_60 \$129 \$282 230.734a
Cext_61 \$129 \$288 13.0723a
Cext_62 \$129 \$291 243.209a
Cext_63 \$129 \$292 1.27829f
Cext_64 \$129 \$344 168.806a
Cext_65 \$129 \$36 4.35294a
Cext_66 \$129 \$69 1.87207f
Cext_67 \$129 \$71 2.21035f
Cext_68 \$129 Vdd 2.43664f
Cext_69 \$129 Vm 1.57642a
Cext_70 \$129 Vom 0.96789a
Cext_71 \$129 Vp 6.18124a
Cext_72 \$129 VREF 713.037a
Cext_73 \$129 Vss 7.95601f
Cext_74 \$129 sky130_gnd 17.0027f
Cext_75 \$136 \$141 5.01419f
Cext_76 \$136 \$159 122.403a
Cext_77 \$136 \$172 372.727a
Cext_78 \$136 \$69 1.22281f
Cext_79 \$136 \$71 96.6699a
Cext_80 \$136 VREF 0.470072a
Cext_81 \$136 Vss 1.33488f
Cext_82 \$136 sky130_gnd 7.95451f
Cext_83 \$141 \$159 889.216a
Cext_84 \$141 \$172 699.787a
Cext_85 \$141 \$69 112.185a
Cext_86 \$141 \$71 1.39409f
Cext_87 \$141 VREF 0.470072a
Cext_88 \$141 Vss 1.09347f
Cext_89 \$141 sky130_gnd 4.00403f
Cext_90 \$157 \$158 3.06964f
Cext_91 \$157 \$171 3.83245f
Cext_92 \$157 \$172 668.812a
Cext_93 \$157 \$227 672.723a
Cext_94 \$157 \$271 1.63749f
Cext_95 \$157 \$288 971.66a
Cext_96 \$157 \$36 1.89463f
Cext_97 \$157 \$71 316.047a
Cext_98 \$157 RGM 4.68736a
Cext_99 \$157 Vdd 19.0218f
Cext_100 \$157 Vom 155.357a
Cext_101 \$157 Vss 1.37254f
Cext_102 \$157 sky130_gnd 6.0943f
Cext_103 \$158 \$171 2.66654f
Cext_104 \$158 \$227 59.7735a
Cext_105 \$158 \$288 291.655a
Cext_106 \$158 \$36 157.792a
Cext_107 \$158 \$69 65.1567a
Cext_108 \$158 \$71 323.353a
Cext_109 \$158 RGM 5.2827a
Cext_110 \$158 Vdd 18.2078f
Cext_111 \$158 Vom 302.647a
Cext_112 \$158 Vop 1.61892a
Cext_113 \$158 Vss 1.81852f
Cext_114 \$158 sky130_gnd 6.84587f
Cext_115 \$159 \$172 708.033a
Cext_116 \$159 \$69 104.803a
Cext_117 \$159 \$71 1.54312f
Cext_118 \$159 VREF 0.470072a
Cext_119 \$159 Vss 5.86248f
Cext_120 \$159 sky130_gnd 2.95798f
Cext_121 \$171 \$227 1.01849f
Cext_122 \$171 \$271 0.598222a
Cext_123 \$171 \$288 4.35294a
Cext_124 \$171 \$36 465.117a
Cext_125 \$171 \$69 297.078a
Cext_126 \$171 \$71 115.008a
Cext_127 \$171 RGM 0.662586a
Cext_128 \$171 Vdd 2.76908f
Cext_129 \$171 Vom 633.693a
Cext_130 \$171 Vop 3.50101a
Cext_131 \$171 Vss 9.30002f
Cext_132 \$171 sky130_gnd 10.2445f
Cext_133 \$172 \$282 167.827a
Cext_134 \$172 \$288 5.37065a
Cext_135 \$172 \$291 949.162a
Cext_136 \$172 \$292 880.436a
Cext_137 \$172 \$344 474.638a
Cext_138 \$172 \$69 454.307a
Cext_139 \$172 \$71 740.559a
Cext_140 \$172 Vdd 3.04292f
Cext_141 \$172 Vom 0.173703a
Cext_142 \$172 VREF 661.139a
Cext_143 \$172 Vss 26.0596f
Cext_144 \$172 sky130_gnd 74.8218f
Cext_145 \$2.x2_x1_net1 \$2.x2_x1_net10 159.659a
Cext_146 \$2.x2_x1_net1 \$2.x2_x1_net6 159.659a
Cext_147 \$2.x2_x1_net1 \$2.x2_x2_net1 512.201a
Cext_148 \$2.x2_x1_net1 \$2.x2_x2_net10 9.25a
Cext_149 \$2.x2_x1_net1 \$2.x2_x2_net6 9.25a
Cext_150 \$2.x2_x1_net1 Vss 55.637a
Cext_151 \$2.x2_x1_net1 sky130_gnd 1.22939f
Cext_152 \$2.x2_x1_net10 \$2.x2_x1_net8 159.659a
Cext_153 \$2.x2_x1_net10 \$2.x2_x2_net1 20.8047a
Cext_154 \$2.x2_x1_net10 \$2.x2_x2_net10 414.569a
Cext_155 \$2.x2_x1_net10 \$2.x2_x2_net8 20.8047a
Cext_156 \$2.x2_x1_net10 Vss 195.518a
Cext_157 \$2.x2_x1_net10 sky130_gnd 1.24701f
Cext_158 \$2.x2_x1_net11 \$2.x2_x2_net11 512.979a
Cext_159 \$2.x2_x1_net11 \$2.x2_x2_net7 20.8047a
Cext_160 \$2.x2_x1_net11 \$2.x2_x2_net9 20.8047a
Cext_161 \$2.x2_x1_net11 \$96 0.840458a
Cext_162 \$2.x2_x1_net11 Vom 0.46419a
Cext_163 \$2.x2_x1_net11 Vop 2.4283a
Cext_164 \$2.x2_x1_net11 Vss 97.9997a
Cext_165 \$2.x2_x1_net11 sky130_gnd 1.12882f
Cext_166 \$2.x2_x1_net12 \$2.x2_x1_net14 159.659a
Cext_167 \$2.x2_x1_net12 \$2.x2_x1_net8 159.659a
Cext_168 \$2.x2_x1_net12 \$2.x2_x2_net12 414.569a
Cext_169 \$2.x2_x1_net12 \$2.x2_x2_net14 20.8047a
Cext_170 \$2.x2_x1_net12 \$2.x2_x2_net8 20.8047a
Cext_171 \$2.x2_x1_net12 Vss 195.518a
Cext_172 \$2.x2_x1_net12 sky130_gnd 1.24701f
Cext_173 \$2.x2_x1_net13 \$2.x2_x2_net13 414.418a
Cext_174 \$2.x2_x1_net13 \$2.x2_x2_net15 9.25a
Cext_175 \$2.x2_x1_net13 \$2.x2_x2_net2 9.25a
Cext_176 \$2.x2_x1_net13 \$96 0.46419a
Cext_177 \$2.x2_x1_net13 Vom 0.292982a
Cext_178 \$2.x2_x1_net13 Vop 1.34603a
Cext_179 \$2.x2_x1_net13 Vss 6.05559a
Cext_180 \$2.x2_x1_net13 sky130_gnd 1.12785f
Cext_181 \$2.x2_x1_net14 \$2.x2_x1_net3 159.659a
Cext_182 \$2.x2_x1_net14 \$2.x2_x2_net12 9.25a
Cext_183 \$2.x2_x1_net14 \$2.x2_x2_net14 512.201a
Cext_184 \$2.x2_x1_net14 \$2.x2_x2_net3 9.25a
Cext_185 \$2.x2_x1_net14 Vss 55.4537a
Cext_186 \$2.x2_x1_net14 sky130_gnd 1.23f
Cext_187 \$2.x2_x1_net15 \$2.x2_x2_net13 20.8047a
Cext_188 \$2.x2_x1_net15 \$2.x2_x2_net15 512.979a
Cext_189 \$2.x2_x1_net15 \$2.x2_x2_net19 20.8047a
Cext_190 \$2.x2_x1_net15 \$96 0.840458a
Cext_191 \$2.x2_x1_net15 Vom 0.46419a
Cext_192 \$2.x2_x1_net15 Vop 2.4283a
Cext_193 \$2.x2_x1_net15 Vss 97.9997a
Cext_194 \$2.x2_x1_net15 sky130_gnd 1.12882f
Cext_195 \$2.x2_x1_net16 \$2.x2_x1_net18 159.659a
Cext_196 \$2.x2_x1_net16 \$2.x2_x2_net16 414.569a
Cext_197 \$2.x2_x1_net16 \$2.x2_x2_net18 20.8047a
Cext_198 \$2.x2_x1_net16 Vss 382.491a
Cext_199 \$2.x2_x1_net16 sky130_gnd 1.24945f
Cext_200 \$2.x2_x1_net17 \$2.x2_x2_net17 512.979a
Cext_201 \$2.x2_x1_net17 \$2.x2_x2_net19 20.8047a
Cext_202 \$2.x2_x1_net17 \$96 1.10535a
Cext_203 \$2.x2_x1_net17 Vom 11.7275a
Cext_204 \$2.x2_x1_net17 Vop 2.4283a
Cext_205 \$2.x2_x1_net17 Vss 99.664a
Cext_206 \$2.x2_x1_net17 sky130_gnd 1.13923f
Cext_207 \$2.x2_x1_net18 \$2.x2_x1_net3 159.659a
Cext_208 \$2.x2_x1_net18 \$2.x2_x2_net16 9.25a
Cext_209 \$2.x2_x1_net18 \$2.x2_x2_net18 512.201a
Cext_210 \$2.x2_x1_net18 \$2.x2_x2_net3 9.25a
Cext_211 \$2.x2_x1_net18 Vss 55.9663a
Cext_212 \$2.x2_x1_net18 sky130_gnd 1.23f
Cext_213 \$2.x2_x1_net19 \$2.x2_x2_net15 9.25a
Cext_214 \$2.x2_x1_net19 \$2.x2_x2_net17 9.25a
Cext_215 \$2.x2_x1_net19 \$2.x2_x2_net19 414.418a
Cext_216 \$2.x2_x1_net19 \$96 0.46419a
Cext_217 \$2.x2_x1_net19 Vom 0.292982a
Cext_218 \$2.x2_x1_net19 Vop 1.34603a
Cext_219 \$2.x2_x1_net19 Vss 6.05559a
Cext_220 \$2.x2_x1_net19 sky130_gnd 1.12785f
Cext_221 \$2.x2_x1_net2 \$2.x2_x2_net13 20.8047a
Cext_222 \$2.x2_x1_net2 \$2.x2_x2_net2 512.979a
Cext_223 \$2.x2_x1_net2 \$2.x2_x2_net9 20.8047a
Cext_224 \$2.x2_x1_net2 \$96 0.840458a
Cext_225 \$2.x2_x1_net2 Vom 0.46419a
Cext_226 \$2.x2_x1_net2 Vop 2.4283a
Cext_227 \$2.x2_x1_net2 Vss 97.9997a
Cext_228 \$2.x2_x1_net2 sky130_gnd 1.12882f
Cext_229 \$2.x2_x1_net3 \$2.x2_x2_net14 20.8047a
Cext_230 \$2.x2_x1_net3 \$2.x2_x2_net18 20.8047a
Cext_231 \$2.x2_x1_net3 \$2.x2_x2_net3 414.569a
Cext_232 \$2.x2_x1_net3 Vss 195.518a
Cext_233 \$2.x2_x1_net3 sky130_gnd 1.24701f
Cext_234 \$2.x2_x1_net4 \$2.x2_x1_net6 159.659a
Cext_235 \$2.x2_x1_net4 \$2.x2_x2_net4 512.201a
Cext_236 \$2.x2_x1_net4 \$2.x2_x2_net6 9.25a
Cext_237 \$2.x2_x1_net4 \$96 0.46395a
Cext_238 \$2.x2_x1_net4 Vss 219.288a
Cext_239 \$2.x2_x1_net4 sky130_gnd 1.23987f
Cext_240 \$2.x2_x1_net5 \$2.x2_x2_net5 512.979a
Cext_241 \$2.x2_x1_net5 \$2.x2_x2_net7 20.8047a
Cext_242 \$2.x2_x1_net5 \$96 23.376a
Cext_243 \$2.x2_x1_net5 Vom 0.56967a
Cext_244 \$2.x2_x1_net5 Vop 2.84148a
Cext_245 \$2.x2_x1_net5 Vss 98.8573a
Cext_246 \$2.x2_x1_net5 sky130_gnd 1.13948f
Cext_247 \$2.x2_x1_net6 \$2.x2_x2_net1 20.8047a
Cext_248 \$2.x2_x1_net6 \$2.x2_x2_net4 20.8047a
Cext_249 \$2.x2_x1_net6 \$2.x2_x2_net6 414.484a
Cext_250 \$2.x2_x1_net6 Vss 195.545a
Cext_251 \$2.x2_x1_net6 sky130_gnd 1.24351f
Cext_252 \$2.x2_x1_net7 \$2.x2_x2_net11 9.25a
Cext_253 \$2.x2_x1_net7 \$2.x2_x2_net5 9.25a
Cext_254 \$2.x2_x1_net7 \$2.x2_x2_net7 414.418a
Cext_255 \$2.x2_x1_net7 \$96 0.813482a
Cext_256 \$2.x2_x1_net7 Vom 0.292982a
Cext_257 \$2.x2_x1_net7 Vop 1.34603a
Cext_258 \$2.x2_x1_net7 Vss 6.05559a
Cext_259 \$2.x2_x1_net7 sky130_gnd 1.12785f
Cext_260 \$2.x2_x1_net8 \$2.x2_x2_net10 9.25a
Cext_261 \$2.x2_x1_net8 \$2.x2_x2_net12 9.25a
Cext_262 \$2.x2_x1_net8 \$2.x2_x2_net8 512.201a
Cext_263 \$2.x2_x1_net8 Vss 55.4537a
Cext_264 \$2.x2_x1_net8 sky130_gnd 1.23f
Cext_265 \$2.x2_x1_net9 \$2.x2_x2_net11 9.25a
Cext_266 \$2.x2_x1_net9 \$2.x2_x2_net2 9.25a
Cext_267 \$2.x2_x1_net9 \$2.x2_x2_net9 414.418a
Cext_268 \$2.x2_x1_net9 \$96 0.46419a
Cext_269 \$2.x2_x1_net9 Vom 0.292982a
Cext_270 \$2.x2_x1_net9 Vop 1.34603a
Cext_271 \$2.x2_x1_net9 Vss 6.05559a
Cext_272 \$2.x2_x1_net9 sky130_gnd 1.12785f
Cext_273 \$2.x2_x2_net1 Vss 102.91a
Cext_274 \$2.x2_x2_net1 sky130_gnd 1.12463f
Cext_275 \$2.x2_x2_net10 Vss 9.10591a
Cext_276 \$2.x2_x2_net10 sky130_gnd 1.12408f
Cext_277 \$2.x2_x2_net11 \$2.x2_x2_net7 159.492a
Cext_278 \$2.x2_x2_net11 \$2.x2_x2_net9 159.492a
Cext_279 \$2.x2_x2_net11 \$96 0.46419a
Cext_280 \$2.x2_x2_net11 Vom 0.292982a
Cext_281 \$2.x2_x2_net11 Vop 1.34603a
Cext_282 \$2.x2_x2_net11 Vss 51.5188a
Cext_283 \$2.x2_x2_net11 sky130_gnd 1.2341f
Cext_284 \$2.x2_x2_net12 Vss 9.10591a
Cext_285 \$2.x2_x2_net12 sky130_gnd 1.12408f
Cext_286 \$2.x2_x2_net13 \$2.x2_x2_net15 159.492a
Cext_287 \$2.x2_x2_net13 \$2.x2_x2_net2 159.492a
Cext_288 \$2.x2_x2_net13 \$96 0.840458a
Cext_289 \$2.x2_x2_net13 Vom 0.46419a
Cext_290 \$2.x2_x2_net13 Vop 2.4283a
Cext_291 \$2.x2_x2_net13 Vss 189.003a
Cext_292 \$2.x2_x2_net13 sky130_gnd 1.2512f
Cext_293 \$2.x2_x2_net14 Vss 102.91a
Cext_294 \$2.x2_x2_net14 sky130_gnd 1.12463f
Cext_295 \$2.x2_x2_net15 \$2.x2_x2_net19 159.492a
Cext_296 \$2.x2_x2_net15 \$96 0.46419a
Cext_297 \$2.x2_x2_net15 Vom 0.292982a
Cext_298 \$2.x2_x2_net15 Vop 1.34603a
Cext_299 \$2.x2_x2_net15 Vss 51.5188a
Cext_300 \$2.x2_x2_net15 sky130_gnd 1.2341f
Cext_301 \$2.x2_x2_net16 Vss 14.5324a
Cext_302 \$2.x2_x2_net16 sky130_gnd 1.1347f
Cext_303 \$2.x2_x2_net17 \$2.x2_x2_net19 159.492a
Cext_304 \$2.x2_x2_net17 \$96 1.13649a
Cext_305 \$2.x2_x2_net17 Vom 159.785a
Cext_306 \$2.x2_x2_net17 Vop 1.34603a
Cext_307 \$2.x2_x2_net17 Vss 54.3489a
Cext_308 \$2.x2_x2_net17 sky130_gnd 1.24444f
Cext_309 \$2.x2_x2_net18 Vss 103.109a
Cext_310 \$2.x2_x2_net18 sky130_gnd 1.12463f
Cext_311 \$2.x2_x2_net19 \$96 0.840458a
Cext_312 \$2.x2_x2_net19 Vom 0.46419a
Cext_313 \$2.x2_x2_net19 Vop 2.4283a
Cext_314 \$2.x2_x2_net19 Vss 189.003a
Cext_315 \$2.x2_x2_net19 sky130_gnd 1.2512f
Cext_316 \$2.x2_x2_net2 \$2.x2_x2_net9 159.492a
Cext_317 \$2.x2_x2_net2 \$96 0.46419a
Cext_318 \$2.x2_x2_net2 Vom 0.292982a
Cext_319 \$2.x2_x2_net2 Vop 1.34603a
Cext_320 \$2.x2_x2_net2 Vss 51.5188a
Cext_321 \$2.x2_x2_net2 sky130_gnd 1.2341f
Cext_322 \$2.x2_x2_net3 Vss 9.10591a
Cext_323 \$2.x2_x2_net3 sky130_gnd 1.12408f
Cext_324 \$2.x2_x2_net4 Vss 116.318a
Cext_325 \$2.x2_x2_net4 sky130_gnd 1.1332f
Cext_326 \$2.x2_x2_net5 \$2.x2_x2_net7 159.492a
Cext_327 \$2.x2_x2_net5 \$96 173.713a
Cext_328 \$2.x2_x2_net5 Vom 0.292982a
Cext_329 \$2.x2_x2_net5 Vop 2.28491a
Cext_330 \$2.x2_x2_net5 Vss 54.2804a
Cext_331 \$2.x2_x2_net5 sky130_gnd 1.2447f
Cext_332 \$2.x2_x2_net6 Vss 9.3339a
Cext_333 \$2.x2_x2_net6 sky130_gnd 1.12283f
Cext_334 \$2.x2_x2_net7 \$96 3.46362a
Cext_335 \$2.x2_x2_net7 Vom 0.46419a
Cext_336 \$2.x2_x2_net7 Vop 2.4283a
Cext_337 \$2.x2_x2_net7 Vss 189.003a
Cext_338 \$2.x2_x2_net7 sky130_gnd 1.2512f
Cext_339 \$2.x2_x2_net8 Vss 102.91a
Cext_340 \$2.x2_x2_net8 sky130_gnd 1.12463f
Cext_341 \$2.x2_x2_net9 \$96 0.840458a
Cext_342 \$2.x2_x2_net9 Vom 0.46419a
Cext_343 \$2.x2_x2_net9 Vop 2.4283a
Cext_344 \$2.x2_x2_net9 Vss 189.003a
Cext_345 \$2.x2_x2_net9 sky130_gnd 1.2512f
Cext_346 \$227 \$271 1.1095f
Cext_347 \$227 \$36 4.35294a
Cext_348 \$227 \$69 1.19392a
Cext_349 \$227 \$71 478.984a
Cext_350 \$227 RGM 2.99312f
Cext_351 \$227 Vdd 2.26462f
Cext_352 \$227 Vom 819.913a
Cext_353 \$227 Vop 0.219665a
Cext_354 \$227 Vss 3.18798f
Cext_355 \$227 sky130_gnd 7.87456f
Cext_356 \$271 \$71 79.4065a
Cext_357 \$271 Vdd 8.52743f
Cext_358 \$271 Vom 3.50207a
Cext_359 \$271 Vss 1.47008f
Cext_360 \$271 sky130_gnd 2.55797f
Cext_361 \$282 \$288 240.442a
Cext_362 \$282 \$291 5.80542f
Cext_363 \$282 \$292 5.31973f
Cext_364 \$282 \$344 7.23899f
Cext_365 \$282 \$433 161.748a
Cext_366 \$282 \$442 347.291a
Cext_367 \$282 \$451 1.08266f
Cext_368 \$282 \$69 1.69653f
Cext_369 \$282 \$71 1.78792f
Cext_370 \$282 Vdd 30.1995f
Cext_371 \$282 VREF 1.72947f
Cext_372 \$282 Vss 8.0431f
Cext_373 \$282 sky130_gnd 13.2547f
Cext_374 \$288 \$292 103.038a
Cext_375 \$288 \$36 935.749a
Cext_376 \$288 \$451 1.05054f
Cext_377 \$288 \$69 115.019a
Cext_378 \$288 \$71 531.145a
Cext_379 \$288 Vdd 3.93974f
Cext_380 \$288 Vom 0.285711a
Cext_381 \$288 VREF 5.5414a
Cext_382 \$288 Vss 3.36031f
Cext_383 \$288 sky130_gnd 9.86632f
Cext_384 \$291 \$292 6.44017f
Cext_385 \$291 \$344 5.58367f
Cext_386 \$291 \$69 1.41938f
Cext_387 \$291 \$71 285.887a
Cext_388 \$291 Vdd 2.77257a
Cext_389 \$291 VREF 1.36933f
Cext_390 \$291 Vss 7.01217f
Cext_391 \$291 sky130_gnd 6.1193f
Cext_392 \$292 \$344 6.11543f
Cext_393 \$292 \$433 3.71225f
Cext_394 \$292 \$442 3.61068f
Cext_395 \$292 \$451 300.724a
Cext_396 \$292 \$69 257.016a
Cext_397 \$292 \$71 510.715a
Cext_398 \$292 Vdd 54.3893f
Cext_399 \$292 VREF 2.77475f
Cext_400 \$292 Vss 8.25239f
Cext_401 \$292 sky130_gnd 16.3376f
Cext_402 \$344 \$69 176.007a
Cext_403 \$344 \$71 1.81322f
Cext_404 \$344 VREF 1.36663f
Cext_405 \$344 Vss 1.84454f
Cext_406 \$344 sky130_gnd 9.17339f
Cext_407 \$35 \$36 1.30561f
Cext_408 \$35 \$69 3.06859a
Cext_409 \$35 \$92 1.70312f
Cext_410 \$35 Vdd 13.2936f
Cext_411 \$35 Vop 41.2872a
Cext_412 \$35 Vss 592.671a
Cext_413 \$35 sky130_gnd 2.93535f
Cext_414 \$36 \$69 723.333a
Cext_415 \$36 \$71 278.891a
Cext_416 \$36 \$92 168.725a
Cext_417 \$36 \$96 84.4197a
Cext_418 \$36 Vdd 3.99101f
Cext_419 \$36 Vom 954.724a
Cext_420 \$36 Vop 572.313a
Cext_421 \$36 VREF 93.4846a
Cext_422 \$36 Vss 3.59312f
Cext_423 \$36 sky130_gnd 7.0107f
Cext_424 \$433 \$442 6.98288f
Cext_425 \$433 \$451 5.40619f
Cext_426 \$433 \$69 83.5382a
Cext_427 \$433 \$71 1.37531f
Cext_428 \$433 Vdd 16.8696f
Cext_429 \$433 Vm 839.206a
Cext_430 \$433 Vp 29.8607a
Cext_431 \$433 Vss 2.20035f
Cext_432 \$433 sky130_gnd 1.81685f
Cext_433 \$442 \$451 5.18982f
Cext_434 \$442 \$69 1.59856f
Cext_435 \$442 \$71 107.117a
Cext_436 \$442 Vdd 11.45f
Cext_437 \$442 Vm 23.5876a
Cext_438 \$442 Vp 822.225a
Cext_439 \$442 Vss 486.997a
Cext_440 \$442 sky130_gnd 6.84272f
Cext_441 \$451 \$69 1.89386f
Cext_442 \$451 \$71 2.55721f
Cext_443 \$451 Vdd 31.2721f
Cext_444 \$451 Vss 547.189a
Cext_445 \$451 sky130_gnd 4.38402f
Cext_446 \$69 \$71 4.90664f
Cext_447 \$69 \$92 84.5433a
Cext_448 \$69 \$96 219.397a
Cext_449 \$69 RGM 73.4681a
Cext_450 \$69 Vdd 19.7286f
Cext_451 \$69 Vom 638.56a
Cext_452 \$69 Vop 1.04724p
Cext_453 \$69 VREF 6.86314f
Cext_454 \$69 Vss 12.2835f
Cext_455 \$69 sky130_gnd 35.828f
Cext_456 \$71 \$96 103.974a
Cext_457 \$71 RGM 0.126319a
Cext_458 \$71 Vdd 22.4915f
Cext_459 \$71 Vm 1.71303a
Cext_460 \$71 Vom 1.04619p
Cext_461 \$71 Vop 0.752781a
Cext_462 \$71 Vp 274.34a
Cext_463 \$71 VREF 6.58041f
Cext_464 \$71 Vss 7.19036f
Cext_465 \$71 sky130_gnd 38.605f
Cext_466 \$92 \$96 342.825a
Cext_467 \$92 Vdd 4.35087f
Cext_468 \$92 Vom 99.2234a
Cext_469 \$92 Vop 83.5651a
Cext_470 \$92 VREF 347.092a
Cext_471 \$92 Vss 90.6344a
Cext_472 \$92 sky130_gnd 1.22004f
Cext_473 \$96 Vdd 13.3987f
Cext_474 \$96 Vom 2.68086f
Cext_475 \$96 Vop 3.31141f
Cext_476 \$96 VREF 3.30246f
Cext_477 \$96 Vss 874.941a
Cext_478 \$96 sky130_gnd 8.31289f
Cext_479 RGM Vop 3.05351a
Cext_480 RGM Vss 305.643a
Cext_481 RGM sky130_gnd 1.58591f
Cext_482 Vdd Vm 2.31514a
Cext_483 Vdd Vom 9.82277f
Cext_484 Vdd Vop 7.46942f
Cext_485 Vdd Vp 2.31514a
Cext_486 Vdd Vss 1.73994f
Cext_487 Vm Vp 1.78165f
Cext_488 Vm Vss 2.60011f
Cext_489 Vom Vop 4.39561f
Cext_490 Vom Vss 3.41234f
Cext_491 Vop Vss 7.14427f
Cext_492 Vp Vss 1.05114f
Cext_493 VREF Vdd 11.2124f
Cext_494 VREF Vm 0.103013a
Cext_495 VREF Vom 251.899a
Cext_496 VREF Vop 245.292a
Cext_497 VREF Vp 4.00706a
Cext_498 VREF Vss 17.0155f
Cext_499 VREF sky130_gnd 43.5724f
Cext_500 sky130_gnd Vdd 60.9789f
Cext_501 sky130_gnd Vm 3.9833f
Cext_502 sky130_gnd Vom 30.3813f
Cext_503 sky130_gnd Vop 27.6838f
Cext_504 sky130_gnd Vp 5.00809f
Cext_505 sky130_gnd Vss 334.499f
.ENDS ttsky25a_fd_routed
