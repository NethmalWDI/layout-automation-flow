*********************************************************
*** NGSPICE file created by KLayout-PEX 0.6.8
*** -----------------------------------------------------
***     Extraction Engine: KPEX/2.5D
***     Technology: sky130a
***     Date: 2026-11-04 12:35:50
*********************************************************

.SUBCKT ttsky25a_fd_routed \$1.x2_x1_net1 \$1.x2_x1_net10 \$1.x2_x1_net11
+ \$1.x2_x1_net12 \$1.x2_x1_net13 \$1.x2_x1_net14 \$1.x2_x1_net15
+ \$1.x2_x1_net16 \$1.x2_x1_net17 \$1.x2_x1_net18 \$1.x2_x1_net19
+ \$1.x2_x1_net2 \$1.x2_x1_net3 \$1.x2_x1_net4 \$1.x2_x1_net5 \$1.x2_x1_net6
+ \$1.x2_x1_net7 \$1.x2_x1_net8 \$1.x2_x1_net9 \$1.x2_x2_net1 \$1.x2_x2_net10
+ \$1.x2_x2_net11 \$1.x2_x2_net12 \$1.x2_x2_net13 \$1.x2_x2_net14
+ \$1.x2_x2_net15 \$1.x2_x2_net16 \$1.x2_x2_net17 \$1.x2_x2_net18
+ \$1.x2_x2_net19 \$1.x2_x2_net2 \$1.x2_x2_net3 \$1.x2_x2_net4 \$1.x2_x2_net5
+ \$1.x2_x2_net6 \$1.x2_x2_net7 \$1.x2_x2_net8 \$1.x2_x2_net9 RGM VREF Vdd Vm
+ Vom Vop Vp Vss sky130_gnd
X$11 Vom \$1.x2_x2_net16 sky130_fd_pr__res_generic_po w=0.5 l=40
X$12 \$3 \$1.x2_x2_net4 sky130_fd_pr__res_generic_po w=0.5 l=40
X$13 \$3 \$1.x2_x1_net16 sky130_fd_pr__res_generic_po w=0.5 l=40
X$14 Vop \$1.x2_x1_net4 sky130_fd_pr__res_generic_po w=0.5 l=40
X$15 Vss Vss sky130_fd_pr__res_generic_po w=0.5 l=40
X$16 Vss Vss sky130_fd_pr__res_generic_po w=0.5 l=40
X$17 \$1.x2_x2_net5 \$1.x2_x2_net6 sky130_fd_pr__res_generic_po w=0.5 l=40
X$18 \$1.x2_x2_net5 \$1.x2_x2_net4 sky130_fd_pr__res_generic_po w=0.5 l=40
X$19 \$1.x2_x1_net5 \$1.x2_x1_net6 sky130_fd_pr__res_generic_po w=0.5 l=40
X$20 \$1.x2_x1_net5 \$1.x2_x1_net4 sky130_fd_pr__res_generic_po w=0.5 l=40
X$21 \$1.x2_x2_net7 \$1.x2_x2_net1 sky130_fd_pr__res_generic_po w=0.5 l=40
X$22 \$1.x2_x2_net7 \$1.x2_x2_net6 sky130_fd_pr__res_generic_po w=0.5 l=40
X$23 \$1.x2_x1_net7 \$1.x2_x1_net1 sky130_fd_pr__res_generic_po w=0.5 l=40
X$24 \$1.x2_x1_net7 \$1.x2_x1_net6 sky130_fd_pr__res_generic_po w=0.5 l=40
X$25 \$1.x2_x2_net11 \$1.x2_x2_net10 sky130_fd_pr__res_generic_po w=0.5 l=40
X$26 \$1.x2_x2_net11 \$1.x2_x2_net1 sky130_fd_pr__res_generic_po w=0.5 l=40
X$27 \$1.x2_x1_net11 \$1.x2_x1_net10 sky130_fd_pr__res_generic_po w=0.5 l=40
X$28 \$1.x2_x1_net11 \$1.x2_x1_net1 sky130_fd_pr__res_generic_po w=0.5 l=40
X$29 \$1.x2_x2_net9 \$1.x2_x2_net8 sky130_fd_pr__res_generic_po w=0.5 l=40
X$30 \$1.x2_x2_net9 \$1.x2_x2_net10 sky130_fd_pr__res_generic_po w=0.5 l=40
X$31 \$1.x2_x1_net9 \$1.x2_x1_net8 sky130_fd_pr__res_generic_po w=0.5 l=40
X$32 \$1.x2_x1_net9 \$1.x2_x1_net10 sky130_fd_pr__res_generic_po w=0.5 l=40
X$33 \$1.x2_x2_net2 \$1.x2_x2_net8 sky130_fd_pr__res_generic_po w=0.5 l=40
X$34 \$1.x2_x2_net2 \$1.x2_x2_net12 sky130_fd_pr__res_generic_po w=0.5 l=40
X$35 \$1.x2_x1_net2 \$1.x2_x1_net8 sky130_fd_pr__res_generic_po w=0.5 l=40
X$36 \$1.x2_x1_net2 \$1.x2_x1_net12 sky130_fd_pr__res_generic_po w=0.5 l=40
X$37 \$1.x2_x2_net13 \$1.x2_x2_net14 sky130_fd_pr__res_generic_po w=0.5 l=40
X$38 \$1.x2_x2_net13 \$1.x2_x2_net12 sky130_fd_pr__res_generic_po w=0.5 l=40
X$39 \$1.x2_x1_net13 \$1.x2_x1_net14 sky130_fd_pr__res_generic_po w=0.5 l=40
X$40 \$1.x2_x1_net13 \$1.x2_x1_net12 sky130_fd_pr__res_generic_po w=0.5 l=40
X$41 \$1.x2_x2_net15 \$1.x2_x2_net3 sky130_fd_pr__res_generic_po w=0.5 l=40
X$42 \$1.x2_x2_net15 \$1.x2_x2_net14 sky130_fd_pr__res_generic_po w=0.5 l=40
X$43 \$1.x2_x1_net15 \$1.x2_x1_net3 sky130_fd_pr__res_generic_po w=0.5 l=40
X$44 \$1.x2_x1_net15 \$1.x2_x1_net14 sky130_fd_pr__res_generic_po w=0.5 l=40
X$45 \$1.x2_x2_net19 \$1.x2_x2_net18 sky130_fd_pr__res_generic_po w=0.5 l=40
X$46 \$1.x2_x2_net19 \$1.x2_x2_net3 sky130_fd_pr__res_generic_po w=0.5 l=40
X$47 \$1.x2_x1_net19 \$1.x2_x1_net18 sky130_fd_pr__res_generic_po w=0.5 l=40
X$48 \$1.x2_x1_net19 \$1.x2_x1_net3 sky130_fd_pr__res_generic_po w=0.5 l=40
X$49 \$1.x2_x2_net17 \$1.x2_x2_net16 sky130_fd_pr__res_generic_po w=0.5 l=40
X$50 \$1.x2_x2_net17 \$1.x2_x2_net18 sky130_fd_pr__res_generic_po w=0.5 l=40
X$51 \$1.x2_x1_net17 \$1.x2_x1_net16 sky130_fd_pr__res_generic_po w=0.5 l=40
X$52 \$1.x2_x1_net17 \$1.x2_x1_net18 sky130_fd_pr__res_generic_po w=0.5 l=40
X$53 Vdd \$451 \$451 Vdd sky130_fd_pr__pfet_01v8_lvt l=10 w=1.5 as=0.435
+ ad=0.435 ps=3.58 pd=3.58
X$54 Vdd \$451 \$451 Vdd sky130_fd_pr__pfet_01v8_lvt l=10 w=1.5 as=0.435
+ ad=0.435 ps=3.58 pd=3.58
X$55 Vdd Vdd Vdd Vdd sky130_fd_pr__pfet_01v8_lvt l=5 w=1 as=0.29 ad=0.145
+ ps=2.58 pd=1.29
X$56 Vdd Vdd Vdd Vdd sky130_fd_pr__pfet_01v8_lvt l=5 w=1 as=0.145 ad=0.29
+ ps=1.29 pd=2.58
X$57 Vdd Vdd Vdd Vdd sky130_fd_pr__pfet_01v8_lvt l=5 w=1 as=0.29 ad=0.145
+ ps=2.58 pd=1.29
X$58 Vdd Vdd Vdd Vdd sky130_fd_pr__pfet_01v8_lvt l=5 w=1 as=0.145 ad=0.29
+ ps=1.29 pd=2.58
X$59 \$432 \$289 Vdd Vdd sky130_fd_pr__pfet_01v8_lvt l=5 w=1 as=0.29 ad=0.145
+ ps=2.58 pd=1.29
X$60 Vdd \$289 \$432 Vdd sky130_fd_pr__pfet_01v8_lvt l=5 w=1 as=0.145 ad=0.29
+ ps=1.29 pd=2.58
X$61 \$441 \$289 Vdd Vdd sky130_fd_pr__pfet_01v8_lvt l=5 w=1 as=0.29 ad=0.145
+ ps=2.58 pd=1.29
X$62 Vdd \$289 \$441 Vdd sky130_fd_pr__pfet_01v8_lvt l=5 w=1 as=0.145 ad=0.29
+ ps=1.29 pd=2.58
X$63 \$432 \$289 Vdd Vdd sky130_fd_pr__pfet_01v8_lvt l=5 w=1 as=0.29 ad=0.145
+ ps=2.58 pd=1.29
X$64 Vdd \$289 \$432 Vdd sky130_fd_pr__pfet_01v8_lvt l=5 w=1 as=0.145 ad=0.29
+ ps=1.29 pd=2.58
X$65 \$441 \$289 Vdd Vdd sky130_fd_pr__pfet_01v8_lvt l=5 w=1 as=0.29 ad=0.145
+ ps=2.58 pd=1.29
X$66 Vdd \$289 \$441 Vdd sky130_fd_pr__pfet_01v8_lvt l=5 w=1 as=0.145 ad=0.29
+ ps=1.29 pd=2.58
X$67 \$441 \$289 Vdd Vdd sky130_fd_pr__pfet_01v8_lvt l=5 w=1 as=0.29 ad=0.145
+ ps=2.58 pd=1.29
X$68 Vdd \$289 \$441 Vdd sky130_fd_pr__pfet_01v8_lvt l=5 w=1 as=0.145 ad=0.29
+ ps=1.29 pd=2.58
X$69 \$432 \$289 Vdd Vdd sky130_fd_pr__pfet_01v8_lvt l=5 w=1 as=0.29 ad=0.145
+ ps=2.58 pd=1.29
X$70 Vdd \$289 \$432 Vdd sky130_fd_pr__pfet_01v8_lvt l=5 w=1 as=0.145 ad=0.29
+ ps=1.29 pd=2.58
X$71 \$441 \$289 Vdd Vdd sky130_fd_pr__pfet_01v8_lvt l=5 w=1 as=0.29 ad=0.145
+ ps=2.58 pd=1.29
X$72 Vdd \$289 \$441 Vdd sky130_fd_pr__pfet_01v8_lvt l=5 w=1 as=0.145 ad=0.29
+ ps=1.29 pd=2.58
X$73 \$432 \$289 Vdd Vdd sky130_fd_pr__pfet_01v8_lvt l=5 w=1 as=0.29 ad=0.145
+ ps=2.58 pd=1.29
X$74 Vdd \$289 \$432 Vdd sky130_fd_pr__pfet_01v8_lvt l=5 w=1 as=0.145 ad=0.29
+ ps=1.29 pd=2.58
X$75 Vdd Vdd Vdd Vdd sky130_fd_pr__pfet_01v8_lvt l=5 w=1 as=0.29 ad=0.145
+ ps=2.58 pd=1.29
X$76 Vdd Vdd Vdd Vdd sky130_fd_pr__pfet_01v8_lvt l=5 w=1 as=0.145 ad=0.29
+ ps=1.29 pd=2.58
X$77 Vdd Vdd Vdd Vdd sky130_fd_pr__pfet_01v8_lvt l=5 w=1 as=0.29 ad=0.145
+ ps=2.58 pd=1.29
X$78 Vdd Vdd Vdd Vdd sky130_fd_pr__pfet_01v8_lvt l=5 w=1 as=0.145 ad=0.29
+ ps=1.29 pd=2.58
X$79 \$125 \$451 \$441 Vdd sky130_fd_pr__pfet_01v8_lvt l=5 w=1 as=0.29 ad=0.145
+ ps=2.58 pd=1.29
X$80 \$441 \$451 \$125 Vdd sky130_fd_pr__pfet_01v8_lvt l=5 w=1 as=0.145 ad=0.29
+ ps=1.29 pd=2.58
X$81 \$61 \$451 \$432 Vdd sky130_fd_pr__pfet_01v8_lvt l=5 w=1 as=0.29 ad=0.145
+ ps=2.58 pd=1.29
X$82 \$432 \$451 \$61 Vdd sky130_fd_pr__pfet_01v8_lvt l=5 w=1 as=0.145 ad=0.29
+ ps=1.29 pd=2.58
X$83 \$125 \$451 \$441 Vdd sky130_fd_pr__pfet_01v8_lvt l=5 w=1 as=0.29 ad=0.145
+ ps=2.58 pd=1.29
X$84 \$441 \$451 \$125 Vdd sky130_fd_pr__pfet_01v8_lvt l=5 w=1 as=0.145 ad=0.29
+ ps=1.29 pd=2.58
X$85 \$61 \$451 \$432 Vdd sky130_fd_pr__pfet_01v8_lvt l=5 w=1 as=0.29 ad=0.145
+ ps=2.58 pd=1.29
X$86 \$432 \$451 \$61 Vdd sky130_fd_pr__pfet_01v8_lvt l=5 w=1 as=0.145 ad=0.29
+ ps=1.29 pd=2.58
X$87 Vss \$116 \$116 sky130_gnd sky130_fd_pr__nfet_01v8_lvt l=5 w=0.6 as=0.174
+ ad=0.174 ps=1.78 pd=1.78
X$88 Vss \$116 \$116 sky130_gnd sky130_fd_pr__nfet_01v8_lvt l=5 w=0.6 as=0.174
+ ad=0.174 ps=1.78 pd=1.78
X$89 Vss Vss Vss sky130_gnd sky130_fd_pr__nfet_01v8_lvt l=4 w=4 as=1.16 ad=1.16
+ ps=8.58 pd=8.58
X$90 Vss Vss Vss sky130_gnd sky130_fd_pr__nfet_01v8_lvt l=4 w=4 as=1.16 ad=1.16
+ ps=8.58 pd=8.58
X$91 \$115 Vm \$432 sky130_gnd sky130_fd_pr__nfet_01v8_lvt l=4 w=4 as=1.16
+ ad=1.16 ps=8.58 pd=8.58
X$92 \$115 Vp \$441 sky130_gnd sky130_fd_pr__nfet_01v8_lvt l=4 w=4 as=1.16
+ ad=1.16 ps=8.58 pd=8.58
X$93 \$115 Vp \$441 sky130_gnd sky130_fd_pr__nfet_01v8_lvt l=4 w=4 as=1.16
+ ad=1.16 ps=8.58 pd=8.58
X$94 \$115 Vm \$432 sky130_gnd sky130_fd_pr__nfet_01v8_lvt l=4 w=4 as=1.16
+ ad=1.16 ps=8.58 pd=8.58
X$95 Vdd \$151 \$151 Vdd sky130_fd_pr__pfet_01v8_lvt l=20 w=1 as=0.29 ad=0.29
+ ps=2.58 pd=2.58
X$96 Vdd \$151 \$151 Vdd sky130_fd_pr__pfet_01v8_lvt l=20 w=1 as=0.29 ad=0.29
+ ps=2.58 pd=2.58
X$97 Vdd Vdd Vdd Vdd sky130_fd_pr__pfet_01v8_lvt l=1 w=5 as=1.45 ad=1.45
+ ps=10.58 pd=10.58
X$98 Vdd Vdd Vdd Vdd sky130_fd_pr__pfet_01v8_lvt l=1 w=5 as=1.45 ad=1.45
+ ps=10.58 pd=10.58
X$99 Vdd \$262 \$262 Vdd sky130_fd_pr__pfet_01v8_lvt l=1 w=5 as=1.45 ad=1.45
+ ps=10.58 pd=10.58
X$100 Vdd \$262 \$150 Vdd sky130_fd_pr__pfet_01v8_lvt l=1 w=5 as=1.45 ad=1.45
+ ps=10.58 pd=10.58
X$101 Vdd \$262 \$262 Vdd sky130_fd_pr__pfet_01v8_lvt l=1 w=5 as=1.45 ad=1.45
+ ps=10.58 pd=10.58
X$102 Vdd \$262 \$150 Vdd sky130_fd_pr__pfet_01v8_lvt l=1 w=5 as=1.45 ad=1.45
+ ps=10.58 pd=10.58
X$103 Vdd Vdd Vdd Vdd sky130_fd_pr__pfet_01v8_lvt l=1 w=5 as=1.45 ad=1.45
+ ps=10.58 pd=10.58
X$104 Vdd \$150 \$168 Vdd sky130_fd_pr__pfet_01v8_lvt l=1 w=5 as=1.45 ad=1.45
+ ps=10.58 pd=10.58
X$105 Vdd \$150 \$223 Vdd sky130_fd_pr__pfet_01v8_lvt l=1 w=5 as=1.45 ad=1.45
+ ps=10.58 pd=10.58
X$106 Vdd \$150 \$168 Vdd sky130_fd_pr__pfet_01v8_lvt l=1 w=5 as=1.45 ad=1.45
+ ps=10.58 pd=10.58
X$107 Vdd \$150 \$223 Vdd sky130_fd_pr__pfet_01v8_lvt l=1 w=5 as=1.45 ad=1.45
+ ps=10.58 pd=10.58
X$108 Vdd Vdd Vdd Vdd sky130_fd_pr__pfet_01v8_lvt l=1 w=5 as=1.45 ad=1.45
+ ps=10.58 pd=10.58
X$109 Vdd \$150 \$278 Vdd sky130_fd_pr__pfet_01v8_lvt l=1 w=5 as=1.45 ad=1.45
+ ps=10.58 pd=10.58
X$110 Vdd \$150 \$308 Vdd sky130_fd_pr__pfet_01v8_lvt l=1 w=5 as=1.45 ad=1.45
+ ps=10.58 pd=10.58
X$111 Vdd Vdd Vdd Vdd sky130_fd_pr__pfet_01v8_lvt l=1 w=5 as=1.45 ad=1.45
+ ps=10.58 pd=10.58
X$112 Vdd Vdd Vdd Vdd sky130_fd_pr__pfet_01v8_lvt l=1 w=5 as=1.45 ad=1.45
+ ps=10.58 pd=10.58
X$113 Vdd \$150 \$308 Vdd sky130_fd_pr__pfet_01v8_lvt l=1 w=5 as=1.45 ad=1.45
+ ps=10.58 pd=10.58
X$114 Vdd \$150 \$278 Vdd sky130_fd_pr__pfet_01v8_lvt l=1 w=5 as=1.45 ad=1.45
+ ps=10.58 pd=10.58
X$115 Vdd Vdd Vdd Vdd sky130_fd_pr__pfet_01v8_lvt l=1 w=5 as=1.45 ad=1.45
+ ps=10.58 pd=10.58
X$116 Vdd \$150 \$116 Vdd sky130_fd_pr__pfet_01v8_lvt l=1 w=5 as=1.45 ad=1.45
+ ps=10.58 pd=10.58
X$117 Vdd \$150 \$169 Vdd sky130_fd_pr__pfet_01v8_lvt l=1 w=5 as=1.45 ad=1.45
+ ps=10.58 pd=10.58
X$118 Vdd \$150 \$116 Vdd sky130_fd_pr__pfet_01v8_lvt l=1 w=5 as=1.45 ad=1.45
+ ps=10.58 pd=10.58
X$119 Vdd \$150 \$169 Vdd sky130_fd_pr__pfet_01v8_lvt l=1 w=5 as=1.45 ad=1.45
+ ps=10.58 pd=10.58
X$120 Vdd Vdd Vdd Vdd sky130_fd_pr__pfet_01v8_lvt l=1 w=5 as=1.45 ad=1.45
+ ps=10.58 pd=10.58
X$121 Vss \$169 \$288 sky130_gnd sky130_fd_pr__nfet_01v8_lvt l=20 w=1 as=0.29
+ ad=0.29 ps=2.58 pd=2.58
X$122 Vss \$169 \$288 sky130_gnd sky130_fd_pr__nfet_01v8_lvt l=20 w=1 as=0.29
+ ad=0.29 ps=2.58 pd=2.58
X$123 Vss \$169 \$343 sky130_gnd sky130_fd_pr__nfet_01v8_lvt l=20 w=1 as=0.29
+ ad=0.29 ps=2.58 pd=2.58
X$124 Vss \$169 \$343 sky130_gnd sky130_fd_pr__nfet_01v8_lvt l=20 w=1 as=0.29
+ ad=0.29 ps=2.58 pd=2.58
X$125 Vss Vss Vss sky130_gnd sky130_fd_pr__nfet_01v8_lvt l=20 w=1 as=0.29
+ ad=0.29 ps=2.58 pd=2.58
X$126 Vss Vss Vss sky130_gnd sky130_fd_pr__nfet_01v8_lvt l=20 w=1 as=0.29
+ ad=0.29 ps=2.58 pd=2.58
X$127 Vss Vss Vss sky130_gnd sky130_fd_pr__nfet_01v8_lvt l=20 w=5 as=1.45
+ ad=1.45 ps=10.58 pd=10.58
X$128 Vss Vss Vss sky130_gnd sky130_fd_pr__nfet_01v8_lvt l=20 w=5 as=1.45
+ ad=1.45 ps=10.58 pd=10.58
X$129 \$343 \$61 \$279 sky130_gnd sky130_fd_pr__nfet_01v8_lvt l=20 w=5 as=1.45
+ ad=1.45 ps=10.58 pd=10.58
X$130 \$343 \$61 \$279 sky130_gnd sky130_fd_pr__nfet_01v8_lvt l=20 w=5 as=1.45
+ ad=1.45 ps=10.58 pd=10.58
X$131 \$343 VREF \$289 sky130_gnd sky130_fd_pr__nfet_01v8_lvt l=20 w=5 as=1.45
+ ad=1.45 ps=10.58 pd=10.58
X$132 \$343 VREF \$289 sky130_gnd sky130_fd_pr__nfet_01v8_lvt l=20 w=5 as=1.45
+ ad=1.45 ps=10.58 pd=10.58
X$133 Vss Vss Vss sky130_gnd sky130_fd_pr__nfet_01v8_lvt l=20 w=5 as=1.45
+ ad=1.45 ps=10.58 pd=10.58
X$134 Vss Vss Vss sky130_gnd sky130_fd_pr__nfet_01v8_lvt l=20 w=5 as=1.45
+ ad=1.45 ps=10.58 pd=10.58
X$135 \$288 VREF \$289 sky130_gnd sky130_fd_pr__nfet_01v8_lvt l=20 w=5 as=1.45
+ ad=1.45 ps=10.58 pd=10.58
X$136 \$288 VREF \$289 sky130_gnd sky130_fd_pr__nfet_01v8_lvt l=20 w=5 as=1.45
+ ad=1.45 ps=10.58 pd=10.58
X$137 \$288 \$125 \$279 sky130_gnd sky130_fd_pr__nfet_01v8_lvt l=20 w=5 as=1.45
+ ad=1.45 ps=10.58 pd=10.58
X$138 \$288 \$125 \$279 sky130_gnd sky130_fd_pr__nfet_01v8_lvt l=20 w=5 as=1.45
+ ad=1.45 ps=10.58 pd=10.58
X$139 RGM \$223 \$223 sky130_gnd sky130_fd_pr__nfet_01v8_lvt l=1 w=10 as=2.9
+ ad=2.9 ps=20.58 pd=20.58
X$140 RGM \$223 \$223 sky130_gnd sky130_fd_pr__nfet_01v8_lvt l=1 w=10 as=2.9
+ ad=2.9 ps=20.58 pd=20.58
X$141 \$168 \$151 \$150 sky130_gnd sky130_fd_pr__nfet_01v8_lvt l=1 w=2 as=0.58
+ ad=0.58 ps=4.58 pd=4.58
X$142 Vss \$223 \$262 sky130_gnd sky130_fd_pr__nfet_01v8_lvt l=2 w=5 as=1.45
+ ad=1.45 ps=10.58 pd=10.58
X$143 Vss \$223 \$262 sky130_gnd sky130_fd_pr__nfet_01v8_lvt l=2 w=5 as=1.45
+ ad=1.45 ps=10.58 pd=10.58
X$144 Vss \$168 \$151 sky130_gnd sky130_fd_pr__nfet_01v8_lvt l=2 w=5 as=1.45
+ ad=1.45 ps=10.58 pd=10.58
X$145 Vss \$168 \$151 sky130_gnd sky130_fd_pr__nfet_01v8_lvt l=2 w=5 as=1.45
+ ad=1.45 ps=10.58 pd=10.58
X$146 Vss \$168 \$150 sky130_gnd sky130_fd_pr__nfet_01v8_lvt l=2 w=5 as=1.45
+ ad=1.45 ps=10.58 pd=10.58
X$147 Vss \$168 \$150 sky130_gnd sky130_fd_pr__nfet_01v8_lvt l=2 w=5 as=1.45
+ ad=1.45 ps=10.58 pd=10.58
X$148 Vss Vss Vss sky130_gnd sky130_fd_pr__nfet_01v8_lvt l=2 w=5 as=1.45
+ ad=1.45 ps=10.58 pd=10.58
X$149 Vss Vss Vss sky130_gnd sky130_fd_pr__nfet_01v8_lvt l=2 w=5 as=1.45
+ ad=1.45 ps=10.58 pd=10.58
X$150 Vss \$168 \$168 sky130_gnd sky130_fd_pr__nfet_01v8_lvt l=2 w=5 as=1.45
+ ad=1.45 ps=10.58 pd=10.58
X$151 Vss \$168 \$168 sky130_gnd sky130_fd_pr__nfet_01v8_lvt l=2 w=5 as=1.45
+ ad=1.45 ps=10.58 pd=10.58
X$152 Vss \$169 \$169 sky130_gnd sky130_fd_pr__nfet_01v8_lvt l=2 w=1 as=0.29
+ ad=0.29 ps=2.58 pd=2.58
X$153 Vss \$169 \$169 sky130_gnd sky130_fd_pr__nfet_01v8_lvt l=2 w=1 as=0.29
+ ad=0.29 ps=2.58 pd=2.58
X$154 Vss \$169 \$114 sky130_gnd sky130_fd_pr__nfet_01v8_lvt l=10 w=1 as=0.29
+ ad=0.29 ps=2.58 pd=2.58
X$155 Vss \$169 \$114 sky130_gnd sky130_fd_pr__nfet_01v8_lvt l=10 w=1 as=0.29
+ ad=0.29 ps=2.58 pd=2.58
X$156 Vss \$169 \$144 sky130_gnd sky130_fd_pr__nfet_01v8_lvt l=10 w=1 as=0.29
+ ad=0.29 ps=2.58 pd=2.58
X$157 Vss \$169 \$144 sky130_gnd sky130_fd_pr__nfet_01v8_lvt l=10 w=1 as=0.29
+ ad=0.29 ps=2.58 pd=2.58
X$158 Vss \$169 \$152 sky130_gnd sky130_fd_pr__nfet_01v8_lvt l=10 w=1 as=0.29
+ ad=0.29 ps=2.58 pd=2.58
X$159 Vss \$169 \$124 sky130_gnd sky130_fd_pr__nfet_01v8_lvt l=10 w=1 as=0.29
+ ad=0.29 ps=2.58 pd=2.58
X$160 Vss \$169 \$152 sky130_gnd sky130_fd_pr__nfet_01v8_lvt l=10 w=1 as=0.29
+ ad=0.29 ps=2.58 pd=2.58
X$161 Vss \$169 \$124 sky130_gnd sky130_fd_pr__nfet_01v8_lvt l=10 w=1 as=0.29
+ ad=0.29 ps=2.58 pd=2.58
X$162 Vss Vss Vss sky130_gnd sky130_fd_pr__nfet_01v8_lvt l=10 w=1 as=0.29
+ ad=0.29 ps=2.58 pd=2.58
X$163 Vss Vss Vss sky130_gnd sky130_fd_pr__nfet_01v8_lvt l=10 w=1 as=0.29
+ ad=0.29 ps=2.58 pd=2.58
X$164 Vss \$14 \$14 sky130_gnd sky130_fd_pr__nfet_01v8_lvt l=20 w=0.5 as=0.145
+ ad=0.145 ps=1.58 pd=1.58
X$165 Vss \$14 \$13 sky130_gnd sky130_fd_pr__nfet_01v8_lvt l=20 w=0.5 as=0.145
+ ad=0.145 ps=1.58 pd=1.58
X$166 Vss \$14 \$14 sky130_gnd sky130_fd_pr__nfet_01v8_lvt l=20 w=0.5 as=0.145
+ ad=0.145 ps=1.58 pd=1.58
X$167 Vss \$14 \$13 sky130_gnd sky130_fd_pr__nfet_01v8_lvt l=20 w=0.5 as=0.145
+ ad=0.145 ps=1.58 pd=1.58
X$168 Vss Vss Vss sky130_gnd sky130_fd_pr__nfet_01v8_lvt l=20 w=0.5 as=0.145
+ ad=0.145 ps=1.58 pd=1.58
X$169 Vss Vss Vss sky130_gnd sky130_fd_pr__nfet_01v8_lvt l=20 w=0.5 as=0.145
+ ad=0.145 ps=1.58 pd=1.58
X$170 Vss Vss Vss sky130_gnd sky130_fd_pr__nfet_01v8_lvt l=1 w=0.6 as=0.174
+ ad=0.174 ps=1.78 pd=1.78
X$171 Vss Vss Vss sky130_gnd sky130_fd_pr__nfet_01v8_lvt l=1 w=0.6 as=0.174
+ ad=0.174 ps=1.78 pd=1.78
X$172 Vss \$308 \$451 sky130_gnd sky130_fd_pr__nfet_01v8_lvt l=1 w=0.6 as=0.174
+ ad=0.174 ps=1.78 pd=1.78
X$173 Vss \$308 \$308 sky130_gnd sky130_fd_pr__nfet_01v8_lvt l=1 w=0.6 as=0.174
+ ad=0.174 ps=1.78 pd=1.78
X$174 Vss \$308 \$308 sky130_gnd sky130_fd_pr__nfet_01v8_lvt l=1 w=0.6 as=0.174
+ ad=0.174 ps=1.78 pd=1.78
X$175 Vss \$308 \$451 sky130_gnd sky130_fd_pr__nfet_01v8_lvt l=1 w=0.6 as=0.174
+ ad=0.174 ps=1.78 pd=1.78
X$176 Vss Vss Vss sky130_gnd sky130_fd_pr__nfet_01v8_lvt l=1 w=0.6 as=0.174
+ ad=0.174 ps=1.78 pd=1.78
X$177 Vss Vss Vss sky130_gnd sky130_fd_pr__nfet_01v8_lvt l=1 w=0.6 as=0.174
+ ad=0.174 ps=1.78 pd=1.78
X$178 Vss \$278 \$55 sky130_gnd sky130_fd_pr__nfet_01v8_lvt l=1 w=0.6 as=0.174
+ ad=0.174 ps=1.78 pd=1.78
X$179 Vss \$278 \$278 sky130_gnd sky130_fd_pr__nfet_01v8_lvt l=1 w=0.6 as=0.174
+ ad=0.174 ps=1.78 pd=1.78
X$180 Vss \$278 \$55 sky130_gnd sky130_fd_pr__nfet_01v8_lvt l=1 w=0.6 as=0.174
+ ad=0.174 ps=1.78 pd=1.78
X$181 Vss \$278 \$278 sky130_gnd sky130_fd_pr__nfet_01v8_lvt l=1 w=0.6 as=0.174
+ ad=0.174 ps=1.78 pd=1.78
X$182 \$144 \$116 \$61 sky130_gnd sky130_fd_pr__nfet_01v8_lvt l=1 w=1 as=0.29
+ ad=0.29 ps=2.58 pd=2.58
X$183 \$144 \$116 \$61 sky130_gnd sky130_fd_pr__nfet_01v8_lvt l=1 w=1 as=0.29
+ ad=0.29 ps=2.58 pd=2.58
X$184 \$152 \$116 \$115 sky130_gnd sky130_fd_pr__nfet_01v8_lvt l=1 w=1 as=0.29
+ ad=0.29 ps=2.58 pd=2.58
X$185 \$152 \$116 \$115 sky130_gnd sky130_fd_pr__nfet_01v8_lvt l=1 w=1 as=0.29
+ ad=0.29 ps=2.58 pd=2.58
X$186 Vss Vss Vss sky130_gnd sky130_fd_pr__nfet_01v8_lvt l=1 w=1 as=0.29
+ ad=0.29 ps=2.58 pd=2.58
X$187 Vss Vss Vss sky130_gnd sky130_fd_pr__nfet_01v8_lvt l=1 w=1 as=0.29
+ ad=0.29 ps=2.58 pd=2.58
X$188 \$124 \$116 \$125 sky130_gnd sky130_fd_pr__nfet_01v8_lvt l=1 w=1 as=0.29
+ ad=0.29 ps=2.58 pd=2.58
X$189 \$124 \$116 \$125 sky130_gnd sky130_fd_pr__nfet_01v8_lvt l=1 w=1 as=0.29
+ ad=0.29 ps=2.58 pd=2.58
X$190 \$114 \$116 \$115 sky130_gnd sky130_fd_pr__nfet_01v8_lvt l=1 w=1 as=0.29
+ ad=0.29 ps=2.58 pd=2.58
X$191 \$114 \$116 \$115 sky130_gnd sky130_fd_pr__nfet_01v8_lvt l=1 w=1 as=0.29
+ ad=0.29 ps=2.58 pd=2.58
X$192 Vss Vss Vss sky130_gnd sky130_fd_pr__nfet_01v8_lvt l=1 w=1 as=0.29
+ ad=0.29 ps=2.58 pd=2.58
X$193 Vss Vss Vss sky130_gnd sky130_fd_pr__nfet_01v8_lvt l=1 w=1 as=0.29
+ ad=0.29 ps=2.58 pd=2.58
X$194 Vss \$13 Vop sky130_gnd sky130_fd_pr__nfet_01v8_lvt l=1 w=1 as=0.29
+ ad=0.29 ps=2.58 pd=2.58
X$195 Vss \$13 Vop sky130_gnd sky130_fd_pr__nfet_01v8_lvt l=1 w=1 as=0.29
+ ad=0.29 ps=2.58 pd=2.58
X$196 Vss \$13 Vop sky130_gnd sky130_fd_pr__nfet_01v8_lvt l=1 w=1 as=0.29
+ ad=0.29 ps=2.58 pd=2.58
X$197 Vss \$13 Vop sky130_gnd sky130_fd_pr__nfet_01v8_lvt l=1 w=1 as=0.29
+ ad=0.29 ps=2.58 pd=2.58
X$198 Vss \$13 Vop sky130_gnd sky130_fd_pr__nfet_01v8_lvt l=1 w=1 as=0.29
+ ad=0.29 ps=2.58 pd=2.58
X$199 Vss \$13 Vop sky130_gnd sky130_fd_pr__nfet_01v8_lvt l=1 w=1 as=0.29
+ ad=0.29 ps=2.58 pd=2.58
X$200 Vss \$13 Vop sky130_gnd sky130_fd_pr__nfet_01v8_lvt l=1 w=1 as=0.29
+ ad=0.29 ps=2.58 pd=2.58
X$201 Vss \$13 Vop sky130_gnd sky130_fd_pr__nfet_01v8_lvt l=1 w=1 as=0.29
+ ad=0.29 ps=2.58 pd=2.58
X$202 Vss \$13 Vop sky130_gnd sky130_fd_pr__nfet_01v8_lvt l=1 w=1 as=0.29
+ ad=0.29 ps=2.58 pd=2.58
X$203 Vss Vss Vss sky130_gnd sky130_fd_pr__nfet_01v8_lvt l=1 w=1 as=0.29
+ ad=0.29 ps=2.58 pd=2.58
X$204 Vss \$13 Vom sky130_gnd sky130_fd_pr__nfet_01v8_lvt l=1 w=1 as=0.29
+ ad=0.29 ps=2.58 pd=2.58
X$205 Vss \$13 Vom sky130_gnd sky130_fd_pr__nfet_01v8_lvt l=1 w=1 as=0.29
+ ad=0.29 ps=2.58 pd=2.58
X$206 Vss \$13 Vom sky130_gnd sky130_fd_pr__nfet_01v8_lvt l=1 w=1 as=0.29
+ ad=0.29 ps=2.58 pd=2.58
X$207 Vss \$13 Vom sky130_gnd sky130_fd_pr__nfet_01v8_lvt l=1 w=1 as=0.29
+ ad=0.29 ps=2.58 pd=2.58
X$208 Vss \$13 Vom sky130_gnd sky130_fd_pr__nfet_01v8_lvt l=1 w=1 as=0.29
+ ad=0.29 ps=2.58 pd=2.58
X$209 Vss Vss Vss sky130_gnd sky130_fd_pr__nfet_01v8_lvt l=1 w=1 as=0.29
+ ad=0.29 ps=2.58 pd=2.58
X$210 Vss \$13 Vom sky130_gnd sky130_fd_pr__nfet_01v8_lvt l=1 w=1 as=0.29
+ ad=0.29 ps=2.58 pd=2.58
X$211 Vss \$13 Vom sky130_gnd sky130_fd_pr__nfet_01v8_lvt l=1 w=1 as=0.29
+ ad=0.29 ps=2.58 pd=2.58
X$212 Vss \$13 Vom sky130_gnd sky130_fd_pr__nfet_01v8_lvt l=1 w=1 as=0.29
+ ad=0.29 ps=2.58 pd=2.58
X$213 Vss \$13 Vom sky130_gnd sky130_fd_pr__nfet_01v8_lvt l=1 w=1 as=0.29
+ ad=0.29 ps=2.58 pd=2.58
X$214 Vdd \$55 \$83 Vdd sky130_fd_pr__pfet_01v8_lvt l=5 w=1 as=0.29 ad=0.29
+ ps=2.58 pd=2.58
X$215 Vdd Vdd Vdd Vdd sky130_fd_pr__pfet_01v8_lvt l=5 w=1 as=0.29 ad=0.29
+ ps=2.58 pd=2.58
X$216 Vdd \$55 \$83 Vdd sky130_fd_pr__pfet_01v8_lvt l=5 w=1 as=0.29 ad=0.29
+ ps=2.58 pd=2.58
X$217 Vdd Vdd Vdd Vdd sky130_fd_pr__pfet_01v8_lvt l=1 w=6 as=1.74 ad=1.74
+ ps=12.58 pd=12.58
X$218 Vdd \$55 \$55 Vdd sky130_fd_pr__pfet_01v8_lvt l=1 w=6 as=1.74 ad=1.74
+ ps=12.58 pd=12.58
X$219 Vdd \$55 \$55 Vdd sky130_fd_pr__pfet_01v8_lvt l=1 w=6 as=1.74 ad=1.74
+ ps=12.58 pd=12.58
X$220 Vom \$61 Vdd Vdd sky130_fd_pr__pfet_01v8_lvt l=1 w=1 as=0.29 ad=0.145
+ ps=2.58 pd=1.29
X$221 Vdd \$61 Vom Vdd sky130_fd_pr__pfet_01v8_lvt l=1 w=1 as=0.145 ad=0.29
+ ps=1.29 pd=2.58
X$222 Vom \$61 Vdd Vdd sky130_fd_pr__pfet_01v8_lvt l=1 w=1 as=0.29 ad=0.145
+ ps=2.58 pd=1.29
X$223 Vdd \$61 Vom Vdd sky130_fd_pr__pfet_01v8_lvt l=1 w=1 as=0.145 ad=0.29
+ ps=1.29 pd=2.58
X$224 Vom \$61 Vdd Vdd sky130_fd_pr__pfet_01v8_lvt l=1 w=1 as=0.29 ad=0.145
+ ps=2.58 pd=1.29
X$225 Vdd \$61 Vom Vdd sky130_fd_pr__pfet_01v8_lvt l=1 w=1 as=0.145 ad=0.29
+ ps=1.29 pd=2.58
X$226 Vom \$61 Vdd Vdd sky130_fd_pr__pfet_01v8_lvt l=1 w=1 as=0.29 ad=0.145
+ ps=2.58 pd=1.29
X$227 Vdd \$61 Vom Vdd sky130_fd_pr__pfet_01v8_lvt l=1 w=1 as=0.145 ad=0.29
+ ps=1.29 pd=2.58
X$228 Vom \$61 Vdd Vdd sky130_fd_pr__pfet_01v8_lvt l=1 w=1 as=0.29 ad=0.145
+ ps=2.58 pd=1.29
X$229 Vdd \$61 Vom Vdd sky130_fd_pr__pfet_01v8_lvt l=1 w=1 as=0.145 ad=0.29
+ ps=1.29 pd=2.58
X$230 Vom \$61 Vdd Vdd sky130_fd_pr__pfet_01v8_lvt l=1 w=1 as=0.29 ad=0.145
+ ps=2.58 pd=1.29
X$231 Vdd \$61 Vom Vdd sky130_fd_pr__pfet_01v8_lvt l=1 w=1 as=0.145 ad=0.29
+ ps=1.29 pd=2.58
X$232 Vom \$61 Vdd Vdd sky130_fd_pr__pfet_01v8_lvt l=1 w=1 as=0.29 ad=0.145
+ ps=2.58 pd=1.29
X$233 Vdd \$61 Vom Vdd sky130_fd_pr__pfet_01v8_lvt l=1 w=1 as=0.145 ad=0.29
+ ps=1.29 pd=2.58
X$234 Vom \$61 Vdd Vdd sky130_fd_pr__pfet_01v8_lvt l=1 w=1 as=0.29 ad=0.145
+ ps=2.58 pd=1.29
X$235 Vdd \$61 Vom Vdd sky130_fd_pr__pfet_01v8_lvt l=1 w=1 as=0.145 ad=0.29
+ ps=1.29 pd=2.58
X$236 Vom \$61 Vdd Vdd sky130_fd_pr__pfet_01v8_lvt l=1 w=1 as=0.29 ad=0.145
+ ps=2.58 pd=1.29
X$237 Vdd \$61 Vom Vdd sky130_fd_pr__pfet_01v8_lvt l=1 w=1 as=0.145 ad=0.29
+ ps=1.29 pd=2.58
X$238 Vop \$125 Vdd Vdd sky130_fd_pr__pfet_01v8_lvt l=1 w=1 as=0.29 ad=0.145
+ ps=2.58 pd=1.29
X$239 Vdd \$125 Vop Vdd sky130_fd_pr__pfet_01v8_lvt l=1 w=1 as=0.145 ad=0.29
+ ps=1.29 pd=2.58
X$240 Vop \$125 Vdd Vdd sky130_fd_pr__pfet_01v8_lvt l=1 w=1 as=0.29 ad=0.145
+ ps=2.58 pd=1.29
X$241 Vdd \$125 Vop Vdd sky130_fd_pr__pfet_01v8_lvt l=1 w=1 as=0.145 ad=0.29
+ ps=1.29 pd=2.58
X$242 Vop \$125 Vdd Vdd sky130_fd_pr__pfet_01v8_lvt l=1 w=1 as=0.29 ad=0.145
+ ps=2.58 pd=1.29
X$243 Vdd \$125 Vop Vdd sky130_fd_pr__pfet_01v8_lvt l=1 w=1 as=0.145 ad=0.29
+ ps=1.29 pd=2.58
X$244 Vop \$125 Vdd Vdd sky130_fd_pr__pfet_01v8_lvt l=1 w=1 as=0.29 ad=0.145
+ ps=2.58 pd=1.29
X$245 Vdd \$125 Vop Vdd sky130_fd_pr__pfet_01v8_lvt l=1 w=1 as=0.145 ad=0.29
+ ps=1.29 pd=2.58
X$246 Vop \$125 Vdd Vdd sky130_fd_pr__pfet_01v8_lvt l=1 w=1 as=0.29 ad=0.145
+ ps=2.58 pd=1.29
X$247 Vdd \$125 Vop Vdd sky130_fd_pr__pfet_01v8_lvt l=1 w=1 as=0.145 ad=0.29
+ ps=1.29 pd=2.58
X$248 Vop \$125 Vdd Vdd sky130_fd_pr__pfet_01v8_lvt l=1 w=1 as=0.29 ad=0.145
+ ps=2.58 pd=1.29
X$249 Vdd \$125 Vop Vdd sky130_fd_pr__pfet_01v8_lvt l=1 w=1 as=0.145 ad=0.29
+ ps=1.29 pd=2.58
X$250 Vop \$125 Vdd Vdd sky130_fd_pr__pfet_01v8_lvt l=1 w=1 as=0.29 ad=0.145
+ ps=2.58 pd=1.29
X$251 Vdd \$125 Vop Vdd sky130_fd_pr__pfet_01v8_lvt l=1 w=1 as=0.145 ad=0.29
+ ps=1.29 pd=2.58
X$252 Vop \$125 Vdd Vdd sky130_fd_pr__pfet_01v8_lvt l=1 w=1 as=0.29 ad=0.145
+ ps=2.58 pd=1.29
X$253 Vdd \$125 Vop Vdd sky130_fd_pr__pfet_01v8_lvt l=1 w=1 as=0.145 ad=0.29
+ ps=1.29 pd=2.58
X$254 Vop \$125 Vdd Vdd sky130_fd_pr__pfet_01v8_lvt l=1 w=1 as=0.29 ad=0.145
+ ps=2.58 pd=1.29
X$255 Vdd \$125 Vop Vdd sky130_fd_pr__pfet_01v8_lvt l=1 w=1 as=0.145 ad=0.29
+ ps=1.29 pd=2.58
X$256 Vdd Vdd Vdd Vdd sky130_fd_pr__pfet_01v8_lvt l=10 w=1 as=0.29 ad=0.29
+ ps=2.58 pd=2.58
X$257 Vdd Vdd Vdd Vdd sky130_fd_pr__pfet_01v8_lvt l=10 w=1 as=0.29 ad=0.29
+ ps=2.58 pd=2.58
X$258 Vdd \$279 \$279 Vdd sky130_fd_pr__pfet_01v8_lvt l=10 w=1 as=0.29 ad=0.29
+ ps=2.58 pd=2.58
X$259 Vdd \$279 \$289 Vdd sky130_fd_pr__pfet_01v8_lvt l=10 w=1 as=0.29 ad=0.29
+ ps=2.58 pd=2.58
X$260 Vdd \$279 \$279 Vdd sky130_fd_pr__pfet_01v8_lvt l=10 w=1 as=0.29 ad=0.29
+ ps=2.58 pd=2.58
X$261 Vdd \$279 \$289 Vdd sky130_fd_pr__pfet_01v8_lvt l=10 w=1 as=0.29 ad=0.29
+ ps=2.58 pd=2.58
X$262 Vdd Vdd Vdd Vdd sky130_fd_pr__pfet_01v8_lvt l=10 w=1 as=0.29 ad=0.29
+ ps=2.58 pd=2.58
X$263 \$83 \$3 \$14 Vdd sky130_fd_pr__pfet_01v8_lvt l=10 w=1 as=0.29 ad=0.29
+ ps=2.58 pd=2.58
X$264 \$83 VREF \$13 Vdd sky130_fd_pr__pfet_01v8_lvt l=10 w=1 as=0.29 ad=0.29
+ ps=2.58 pd=2.58
X$265 \$83 VREF \$13 Vdd sky130_fd_pr__pfet_01v8_lvt l=10 w=1 as=0.29 ad=0.29
+ ps=2.58 pd=2.58
X$266 \$83 \$3 \$14 Vdd sky130_fd_pr__pfet_01v8_lvt l=10 w=1 as=0.29 ad=0.29
+ ps=2.58 pd=2.58
X$267 Vdd Vdd Vdd Vdd sky130_fd_pr__pfet_01v8_lvt l=10 w=1 as=0.29 ad=0.29
+ ps=2.58 pd=2.58
Cext_1 \$1.x2_x1_net1 \$1.x2_x1_net10 159.659a
Cext_2 \$1.x2_x1_net1 \$1.x2_x1_net6 159.659a
Cext_3 \$1.x2_x1_net1 \$1.x2_x2_net1 512.201a
Cext_4 \$1.x2_x1_net1 \$1.x2_x2_net10 9.25a
Cext_5 \$1.x2_x1_net1 \$1.x2_x2_net6 9.25a
Cext_6 \$1.x2_x1_net1 Vop 1.29129a
Cext_7 \$1.x2_x1_net1 Vss 55.2501a
Cext_8 \$1.x2_x1_net1 sky130_gnd 1.2299f
Cext_9 \$1.x2_x1_net10 \$1.x2_x1_net8 159.659a
Cext_10 \$1.x2_x1_net10 \$1.x2_x2_net1 20.8047a
Cext_11 \$1.x2_x1_net10 \$1.x2_x2_net10 414.569a
Cext_12 \$1.x2_x1_net10 \$1.x2_x2_net8 20.8047a
Cext_13 \$1.x2_x1_net10 \$125 0.241353a
Cext_14 \$1.x2_x1_net10 Vop 0.447347a
Cext_15 \$1.x2_x1_net10 Vss 195.518a
Cext_16 \$1.x2_x1_net10 sky130_gnd 1.24701f
Cext_17 \$1.x2_x1_net11 \$1.x2_x2_net11 512.979a
Cext_18 \$1.x2_x1_net11 \$1.x2_x2_net7 20.8047a
Cext_19 \$1.x2_x1_net11 \$1.x2_x2_net9 20.8047a
Cext_20 \$1.x2_x1_net11 \$3 0.840458a
Cext_21 \$1.x2_x1_net11 Vom 0.46419a
Cext_22 \$1.x2_x1_net11 Vop 2.4283a
Cext_23 \$1.x2_x1_net11 Vss 97.9997a
Cext_24 \$1.x2_x1_net11 sky130_gnd 1.12882f
Cext_25 \$1.x2_x1_net12 \$1.x2_x1_net14 159.659a
Cext_26 \$1.x2_x1_net12 \$1.x2_x1_net8 159.659a
Cext_27 \$1.x2_x1_net12 \$1.x2_x2_net12 414.569a
Cext_28 \$1.x2_x1_net12 \$1.x2_x2_net14 20.8047a
Cext_29 \$1.x2_x1_net12 \$1.x2_x2_net8 20.8047a
Cext_30 \$1.x2_x1_net12 \$125 0.644189a
Cext_31 \$1.x2_x1_net12 Vop 0.668699a
Cext_32 \$1.x2_x1_net12 Vss 195.518a
Cext_33 \$1.x2_x1_net12 sky130_gnd 1.24701f
Cext_34 \$1.x2_x1_net13 \$1.x2_x2_net13 414.418a
Cext_35 \$1.x2_x1_net13 \$1.x2_x2_net15 9.25a
Cext_36 \$1.x2_x1_net13 \$1.x2_x2_net2 9.25a
Cext_37 \$1.x2_x1_net13 \$3 0.46419a
Cext_38 \$1.x2_x1_net13 Vom 0.292982a
Cext_39 \$1.x2_x1_net13 Vop 1.34603a
Cext_40 \$1.x2_x1_net13 Vss 6.05559a
Cext_41 \$1.x2_x1_net13 sky130_gnd 1.12785f
Cext_42 \$1.x2_x1_net14 \$1.x2_x1_net3 159.659a
Cext_43 \$1.x2_x1_net14 \$1.x2_x2_net12 9.25a
Cext_44 \$1.x2_x1_net14 \$1.x2_x2_net14 512.166a
Cext_45 \$1.x2_x1_net14 \$1.x2_x2_net3 9.25a
Cext_46 \$1.x2_x1_net14 Vss 55.4537a
Cext_47 \$1.x2_x1_net14 sky130_gnd 1.22986f
Cext_48 \$1.x2_x1_net15 \$1.x2_x2_net13 20.8047a
Cext_49 \$1.x2_x1_net15 \$1.x2_x2_net15 512.979a
Cext_50 \$1.x2_x1_net15 \$1.x2_x2_net19 20.8047a
Cext_51 \$1.x2_x1_net15 \$3 0.840458a
Cext_52 \$1.x2_x1_net15 Vom 0.46419a
Cext_53 \$1.x2_x1_net15 Vop 2.4283a
Cext_54 \$1.x2_x1_net15 Vss 97.9997a
Cext_55 \$1.x2_x1_net15 sky130_gnd 1.12882f
Cext_56 \$1.x2_x1_net16 \$1.x2_x1_net18 159.659a
Cext_57 \$1.x2_x1_net16 \$1.x2_x2_net16 414.569a
Cext_58 \$1.x2_x1_net16 \$1.x2_x2_net18 20.8047a
Cext_59 \$1.x2_x1_net16 \$125 0.241353a
Cext_60 \$1.x2_x1_net16 Vop 22.1356a
Cext_61 \$1.x2_x1_net16 Vss 382.271a
Cext_62 \$1.x2_x1_net16 sky130_gnd 1.24931f
Cext_63 \$1.x2_x1_net17 \$1.x2_x2_net17 512.979a
Cext_64 \$1.x2_x1_net17 \$1.x2_x2_net19 20.8047a
Cext_65 \$1.x2_x1_net17 \$3 9.75498a
Cext_66 \$1.x2_x1_net17 Vom 11.7275a
Cext_67 \$1.x2_x1_net17 Vop 2.53378a
Cext_68 \$1.x2_x1_net17 Vss 99.664a
Cext_69 \$1.x2_x1_net17 sky130_gnd 1.13923f
Cext_70 \$1.x2_x1_net18 \$1.x2_x1_net3 159.659a
Cext_71 \$1.x2_x1_net18 \$1.x2_x2_net16 9.25a
Cext_72 \$1.x2_x1_net18 \$1.x2_x2_net18 512.201a
Cext_73 \$1.x2_x1_net18 \$1.x2_x2_net3 9.25a
Cext_74 \$1.x2_x1_net18 \$125 0.11221a
Cext_75 \$1.x2_x1_net18 Vop 2.86953a
Cext_76 \$1.x2_x1_net18 Vss 55.9663a
Cext_77 \$1.x2_x1_net18 sky130_gnd 1.23f
Cext_78 \$1.x2_x1_net19 \$1.x2_x2_net15 9.25a
Cext_79 \$1.x2_x1_net19 \$1.x2_x2_net17 9.25a
Cext_80 \$1.x2_x1_net19 \$1.x2_x2_net19 414.418a
Cext_81 \$1.x2_x1_net19 \$3 0.46419a
Cext_82 \$1.x2_x1_net19 Vom 0.292982a
Cext_83 \$1.x2_x1_net19 Vop 1.34603a
Cext_84 \$1.x2_x1_net19 Vss 6.05559a
Cext_85 \$1.x2_x1_net19 sky130_gnd 1.12785f
Cext_86 \$1.x2_x1_net2 \$1.x2_x2_net13 20.8047a
Cext_87 \$1.x2_x1_net2 \$1.x2_x2_net2 512.979a
Cext_88 \$1.x2_x1_net2 \$1.x2_x2_net9 20.8047a
Cext_89 \$1.x2_x1_net2 \$3 0.840458a
Cext_90 \$1.x2_x1_net2 Vom 0.46419a
Cext_91 \$1.x2_x1_net2 Vop 2.4283a
Cext_92 \$1.x2_x1_net2 Vss 97.9997a
Cext_93 \$1.x2_x1_net2 sky130_gnd 1.12882f
Cext_94 \$1.x2_x1_net3 \$1.x2_x2_net14 20.8047a
Cext_95 \$1.x2_x1_net3 \$1.x2_x2_net18 20.8047a
Cext_96 \$1.x2_x1_net3 \$1.x2_x2_net3 414.569a
Cext_97 \$1.x2_x1_net3 \$125 0.402836a
Cext_98 \$1.x2_x1_net3 Vop 0.447347a
Cext_99 \$1.x2_x1_net3 Vss 195.518a
Cext_100 \$1.x2_x1_net3 sky130_gnd 1.24701f
Cext_101 \$1.x2_x1_net4 \$1.x2_x1_net6 159.659a
Cext_102 \$1.x2_x1_net4 \$1.x2_x2_net4 512.201a
Cext_103 \$1.x2_x1_net4 \$1.x2_x2_net6 9.25a
Cext_104 \$1.x2_x1_net4 \$125 0.11221a
Cext_105 \$1.x2_x1_net4 Vss 219.285a
Cext_106 \$1.x2_x1_net4 sky130_gnd 1.24157f
Cext_107 \$1.x2_x1_net5 \$1.x2_x2_net5 512.979a
Cext_108 \$1.x2_x1_net5 \$1.x2_x2_net7 20.8047a
Cext_109 \$1.x2_x1_net5 \$3 12.1038a
Cext_110 \$1.x2_x1_net5 Vom 0.46419a
Cext_111 \$1.x2_x1_net5 Vop 2.6932a
Cext_112 \$1.x2_x1_net5 Vss 98.8573a
Cext_113 \$1.x2_x1_net5 sky130_gnd 1.13948f
Cext_114 \$1.x2_x1_net6 \$1.x2_x2_net1 20.8047a
Cext_115 \$1.x2_x1_net6 \$1.x2_x2_net4 20.8047a
Cext_116 \$1.x2_x1_net6 \$1.x2_x2_net6 414.569a
Cext_117 \$1.x2_x1_net6 \$125 0.644189a
Cext_118 \$1.x2_x1_net6 Vop 0.668699a
Cext_119 \$1.x2_x1_net6 Vss 195.774a
Cext_120 \$1.x2_x1_net6 sky130_gnd 1.24701f
Cext_121 \$1.x2_x1_net7 \$1.x2_x2_net11 9.25a
Cext_122 \$1.x2_x1_net7 \$1.x2_x2_net5 9.25a
Cext_123 \$1.x2_x1_net7 \$1.x2_x2_net7 414.418a
Cext_124 \$1.x2_x1_net7 \$3 0.46419a
Cext_125 \$1.x2_x1_net7 Vom 0.292982a
Cext_126 \$1.x2_x1_net7 Vop 1.34603a
Cext_127 \$1.x2_x1_net7 Vss 6.05559a
Cext_128 \$1.x2_x1_net7 sky130_gnd 1.12785f
Cext_129 \$1.x2_x1_net8 \$1.x2_x2_net10 9.25a
Cext_130 \$1.x2_x1_net8 \$1.x2_x2_net12 9.25a
Cext_131 \$1.x2_x1_net8 \$1.x2_x2_net8 512.201a
Cext_132 \$1.x2_x1_net8 \$125 0.11221a
Cext_133 \$1.x2_x1_net8 Vss 55.4537a
Cext_134 \$1.x2_x1_net8 sky130_gnd 1.23f
Cext_135 \$1.x2_x1_net9 \$1.x2_x2_net11 9.25a
Cext_136 \$1.x2_x1_net9 \$1.x2_x2_net2 9.25a
Cext_137 \$1.x2_x1_net9 \$1.x2_x2_net9 414.418a
Cext_138 \$1.x2_x1_net9 \$3 0.46419a
Cext_139 \$1.x2_x1_net9 Vom 0.292982a
Cext_140 \$1.x2_x1_net9 Vop 1.34603a
Cext_141 \$1.x2_x1_net9 Vss 6.05559a
Cext_142 \$1.x2_x1_net9 sky130_gnd 1.12785f
Cext_143 \$1.x2_x2_net1 \$125 0.147541a
Cext_144 \$1.x2_x2_net1 Vop 0.668699a
Cext_145 \$1.x2_x2_net1 Vss 102.91a
Cext_146 \$1.x2_x2_net1 sky130_gnd 1.12463f
Cext_147 \$1.x2_x2_net10 Vss 9.10591a
Cext_148 \$1.x2_x2_net10 sky130_gnd 1.12408f
Cext_149 \$1.x2_x2_net11 \$1.x2_x2_net7 159.492a
Cext_150 \$1.x2_x2_net11 \$1.x2_x2_net9 159.492a
Cext_151 \$1.x2_x2_net11 \$3 0.46419a
Cext_152 \$1.x2_x2_net11 Vom 0.292982a
Cext_153 \$1.x2_x2_net11 Vop 1.34603a
Cext_154 \$1.x2_x2_net11 Vss 51.5188a
Cext_155 \$1.x2_x2_net11 sky130_gnd 1.2341f
Cext_156 \$1.x2_x2_net12 \$125 0.11221a
Cext_157 \$1.x2_x2_net12 Vss 9.10591a
Cext_158 \$1.x2_x2_net12 sky130_gnd 1.12408f
Cext_159 \$1.x2_x2_net13 \$1.x2_x2_net15 159.492a
Cext_160 \$1.x2_x2_net13 \$1.x2_x2_net2 159.492a
Cext_161 \$1.x2_x2_net13 \$3 0.840458a
Cext_162 \$1.x2_x2_net13 Vom 0.46419a
Cext_163 \$1.x2_x2_net13 Vop 2.4283a
Cext_164 \$1.x2_x2_net13 Vss 189.003a
Cext_165 \$1.x2_x2_net13 sky130_gnd 1.2512f
Cext_166 \$1.x2_x2_net14 Vop 2.01611a
Cext_167 \$1.x2_x2_net14 Vss 102.854a
Cext_168 \$1.x2_x2_net14 sky130_gnd 1.12427f
Cext_169 \$1.x2_x2_net15 \$1.x2_x2_net19 159.492a
Cext_170 \$1.x2_x2_net15 \$3 0.46419a
Cext_171 \$1.x2_x2_net15 Vom 0.292982a
Cext_172 \$1.x2_x2_net15 Vop 1.34603a
Cext_173 \$1.x2_x2_net15 Vss 51.5188a
Cext_174 \$1.x2_x2_net15 sky130_gnd 1.2341f
Cext_175 \$1.x2_x2_net16 Vop 12.9239a
Cext_176 \$1.x2_x2_net16 Vss 14.5324a
Cext_177 \$1.x2_x2_net16 sky130_gnd 1.1347f
Cext_178 \$1.x2_x2_net17 \$1.x2_x2_net19 159.492a
Cext_179 \$1.x2_x2_net17 \$3 11.5114a
Cext_180 \$1.x2_x2_net17 Vom 159.904a
Cext_181 \$1.x2_x2_net17 Vop 1.51729a
Cext_182 \$1.x2_x2_net17 Vss 54.3489a
Cext_183 \$1.x2_x2_net17 sky130_gnd 1.24444f
Cext_184 \$1.x2_x2_net18 \$125 0.456565a
Cext_185 \$1.x2_x2_net18 Vop 2.86078a
Cext_186 \$1.x2_x2_net18 Vss 103.109a
Cext_187 \$1.x2_x2_net18 sky130_gnd 1.12463f
Cext_188 \$1.x2_x2_net19 \$3 2.62493a
Cext_189 \$1.x2_x2_net19 Vom 0.46419a
Cext_190 \$1.x2_x2_net19 Vop 2.4283a
Cext_191 \$1.x2_x2_net19 Vss 189.003a
Cext_192 \$1.x2_x2_net19 sky130_gnd 1.2512f
Cext_193 \$1.x2_x2_net2 \$1.x2_x2_net9 159.492a
Cext_194 \$1.x2_x2_net2 \$3 0.46419a
Cext_195 \$1.x2_x2_net2 Vom 0.292982a
Cext_196 \$1.x2_x2_net2 Vop 1.34603a
Cext_197 \$1.x2_x2_net2 Vss 51.5188a
Cext_198 \$1.x2_x2_net2 sky130_gnd 1.2341f
Cext_199 \$1.x2_x2_net3 \$125 0.11221a
Cext_200 \$1.x2_x2_net3 Vss 9.10591a
Cext_201 \$1.x2_x2_net3 sky130_gnd 1.12408f
Cext_202 \$1.x2_x2_net4 \$125 0.456565a
Cext_203 \$1.x2_x2_net4 Vop 0.668699a
Cext_204 \$1.x2_x2_net4 Vss 116.732a
Cext_205 \$1.x2_x2_net4 sky130_gnd 1.13599f
Cext_206 \$1.x2_x2_net5 \$1.x2_x2_net7 159.492a
Cext_207 \$1.x2_x2_net5 \$3 159.956a
Cext_208 \$1.x2_x2_net5 Vom 0.292982a
Cext_209 \$1.x2_x2_net5 Vop 2.01833a
Cext_210 \$1.x2_x2_net5 Vss 53.2937a
Cext_211 \$1.x2_x2_net5 sky130_gnd 1.24476f
Cext_212 \$1.x2_x2_net6 \$125 0.11221a
Cext_213 \$1.x2_x2_net6 Vss 9.10591a
Cext_214 \$1.x2_x2_net6 sky130_gnd 1.12408f
Cext_215 \$1.x2_x2_net7 \$3 0.840458a
Cext_216 \$1.x2_x2_net7 Vom 0.46419a
Cext_217 \$1.x2_x2_net7 Vop 2.4283a
Cext_218 \$1.x2_x2_net7 Vss 189.003a
Cext_219 \$1.x2_x2_net7 sky130_gnd 1.2512f
Cext_220 \$1.x2_x2_net8 \$125 0.456565a
Cext_221 \$1.x2_x2_net8 Vop 0.668699a
Cext_222 \$1.x2_x2_net8 Vss 102.91a
Cext_223 \$1.x2_x2_net8 sky130_gnd 1.12463f
Cext_224 \$1.x2_x2_net9 \$3 0.840458a
Cext_225 \$1.x2_x2_net9 Vom 0.46419a
Cext_226 \$1.x2_x2_net9 Vop 2.4283a
Cext_227 \$1.x2_x2_net9 Vss 189.003a
Cext_228 \$1.x2_x2_net9 sky130_gnd 1.2512f
Cext_229 \$114 \$115 1.61276f
Cext_230 \$114 \$116 384.147a
Cext_231 \$114 \$124 607.657a
Cext_232 \$114 \$125 1.20944f
Cext_233 \$114 \$144 5.17208f
Cext_234 \$114 \$152 5.0078f
Cext_235 \$114 \$169 479.463a
Cext_236 \$114 \$278 131.267a
Cext_237 \$114 \$61 141.079a
Cext_238 \$114 Vdd 68.7378a
Cext_239 \$114 VREF 61.4603a
Cext_240 \$114 Vss 816.925a
Cext_241 \$114 sky130_gnd 3.08416f
Cext_242 \$115 \$116 670.346a
Cext_243 \$115 \$124 216.733a
Cext_244 \$115 \$125 1.4201f
Cext_245 \$115 \$144 221.677a
Cext_246 \$115 \$152 1.47652f
Cext_247 \$115 \$169 572.408a
Cext_248 \$115 \$278 287.607a
Cext_249 \$115 \$279 179.985a
Cext_250 \$115 \$288 191.397a
Cext_251 \$115 \$289 179.985a
Cext_252 \$115 \$343 199.867a
Cext_253 \$115 \$432 1.97785f
Cext_254 \$115 \$441 2.17515f
Cext_255 \$115 \$61 766.712a
Cext_256 \$115 Vdd 12.8177a
Cext_257 \$115 Vm 987.622a
Cext_258 \$115 Vp 1.01485f
Cext_259 \$115 VREF 607.626a
Cext_260 \$115 Vss 5.40834f
Cext_261 \$115 sky130_gnd 5.77171f
Cext_262 \$116 \$124 371.347a
Cext_263 \$116 \$125 1.87703f
Cext_264 \$116 \$144 363.912a
Cext_265 \$116 \$150 664.998a
Cext_266 \$116 \$152 374.388a
Cext_267 \$116 \$169 2.61704f
Cext_268 \$116 \$278 937.557a
Cext_269 \$116 \$279 230.734a
Cext_270 \$116 \$288 243.096a
Cext_271 \$116 \$289 1.27829f
Cext_272 \$116 \$308 13.0723a
Cext_273 \$116 \$343 168.806a
Cext_274 \$116 \$61 2.19607f
Cext_275 \$116 Vdd 2.4551f
Cext_276 \$116 Vm 1.57642a
Cext_277 \$116 Vom 0.96789a
Cext_278 \$116 Vp 6.18124a
Cext_279 \$116 VREF 709.487a
Cext_280 \$116 Vss 7.63704f
Cext_281 \$116 sky130_gnd 16.7767f
Cext_282 \$124 \$125 1.22318f
Cext_283 \$124 \$144 5.01419f
Cext_284 \$124 \$152 122.403a
Cext_285 \$124 \$169 372.558a
Cext_286 \$124 \$278 158.403a
Cext_287 \$124 \$61 211.23a
Cext_288 \$124 Vdd 77.8295a
Cext_289 \$124 VREF 70.552a
Cext_290 \$124 Vss 1.30764f
Cext_291 \$124 sky130_gnd 7.9551f
Cext_292 \$125 \$13 127.191a
Cext_293 \$125 \$14 115.009a
Cext_294 \$125 \$144 112.464a
Cext_295 \$125 \$151 65.1567a
Cext_296 \$125 \$152 105.17a
Cext_297 \$125 \$168 296.872a
Cext_298 \$125 \$169 454.501a
Cext_299 \$125 \$223 0.916332a
Cext_300 \$125 \$278 1.35937f
Cext_301 \$125 \$279 1.69621f
Cext_302 \$125 \$288 1.41938f
Cext_303 \$125 \$289 257.016a
Cext_304 \$125 \$3 102.839a
Cext_305 \$125 \$308 115.019a
Cext_306 \$125 \$343 176.007a
Cext_307 \$125 \$432 83.5382a
Cext_308 \$125 \$441 1.59856f
Cext_309 \$125 \$451 1.89386f
Cext_310 \$125 \$55 0.120181a
Cext_311 \$125 \$61 4.96094f
Cext_312 \$125 RGM 69.079a
Cext_313 \$125 Vdd 18.81f
Cext_314 \$125 Vom 910.283a
Cext_315 \$125 Vop 1.04665p
Cext_316 \$125 VREF 6.41068f
Cext_317 \$125 Vss 11.9627f
Cext_318 \$125 sky130_gnd 37.5555f
Cext_319 \$13 \$14 7.95138f
Cext_320 \$13 \$278 220.101a
Cext_321 \$13 \$3 36.0346a
Cext_322 \$13 \$61 77.8295a
Cext_323 \$13 \$83 3.647f
Cext_324 \$13 Vdd 3.69052f
Cext_325 \$13 Vom 858.725a
Cext_326 \$13 Vop 996.851a
Cext_327 \$13 VREF 326.011a
Cext_328 \$13 Vss 8.54329f
Cext_329 \$13 sky130_gnd 21.425f
Cext_330 \$14 \$278 76.8896a
Cext_331 \$14 \$3 367.715a
Cext_332 \$14 \$61 81.1583a
Cext_333 \$14 \$83 3.30467f
Cext_334 \$14 Vdd 5.38387f
Cext_335 \$14 Vom 117.61a
Cext_336 \$14 Vop 476.305a
Cext_337 \$14 VREF 77.8463a
Cext_338 \$14 Vss 18.0729f
Cext_339 \$14 sky130_gnd 38.9292f
Cext_340 \$144 \$152 902.435a
Cext_341 \$144 \$169 721.933a
Cext_342 \$144 \$278 165.285a
Cext_343 \$144 \$61 1.27444f
Cext_344 \$144 Vdd 68.7378a
Cext_345 \$144 VREF 61.4603a
Cext_346 \$144 Vss 1.07441f
Cext_347 \$144 sky130_gnd 4.07648f
Cext_348 \$150 \$151 3.0714f
Cext_349 \$150 \$168 3.82038f
Cext_350 \$150 \$169 668.812a
Cext_351 \$150 \$223 672.723a
Cext_352 \$150 \$262 1.63749f
Cext_353 \$150 \$278 838.37a
Cext_354 \$150 \$308 968.619a
Cext_355 \$150 \$61 298.083a
Cext_356 \$150 RGM 4.68736a
Cext_357 \$150 Vdd 19.0581f
Cext_358 \$150 Vom 850.452a
Cext_359 \$150 Vss 1.37703f
Cext_360 \$150 sky130_gnd 6.37578f
Cext_361 \$151 \$168 2.66664f
Cext_362 \$151 \$223 59.7735a
Cext_363 \$151 \$278 2.20949a
Cext_364 \$151 \$308 291.655a
Cext_365 \$151 \$61 323.442a
Cext_366 \$151 RGM 5.2827a
Cext_367 \$151 Vdd 18.2077f
Cext_368 \$151 Vom 328.8a
Cext_369 \$151 Vop 1.61892a
Cext_370 \$151 Vss 1.81851f
Cext_371 \$151 sky130_gnd 6.86498f
Cext_372 \$152 \$169 709.137a
Cext_373 \$152 \$278 151.441a
Cext_374 \$152 \$61 1.37475f
Cext_375 \$152 Vdd 68.7378a
Cext_376 \$152 VREF 61.4603a
Cext_377 \$152 Vss 5.84909f
Cext_378 \$152 sky130_gnd 2.9705f
Cext_379 \$168 \$223 1.01849f
Cext_380 \$168 \$262 0.598222a
Cext_381 \$168 \$308 4.35294a
Cext_382 \$168 \$61 115.008a
Cext_383 \$168 RGM 0.662586a
Cext_384 \$168 Vdd 2.76908f
Cext_385 \$168 Vom 633.693a
Cext_386 \$168 Vop 3.50101a
Cext_387 \$168 Vss 9.30035f
Cext_388 \$168 sky130_gnd 10.2446f
Cext_389 \$169 \$278 128.404a
Cext_390 \$169 \$279 167.827a
Cext_391 \$169 \$288 949.162a
Cext_392 \$169 \$289 880.436a
Cext_393 \$169 \$308 5.37065a
Cext_394 \$169 \$343 474.638a
Cext_395 \$169 \$61 469.127a
Cext_396 \$169 Vdd 3.12075f
Cext_397 \$169 Vom 0.173703a
Cext_398 \$169 VREF 734.665a
Cext_399 \$169 Vss 26.0494f
Cext_400 \$169 sky130_gnd 75.0249f
Cext_401 \$223 \$262 1.1095f
Cext_402 \$223 \$278 4.35294a
Cext_403 \$223 \$61 478.984a
Cext_404 \$223 RGM 2.99277f
Cext_405 \$223 Vdd 2.26462f
Cext_406 \$223 Vom 819.913a
Cext_407 \$223 Vop 0.219665a
Cext_408 \$223 Vss 3.20876f
Cext_409 \$223 sky130_gnd 7.87228f
Cext_410 \$262 \$61 79.4065a
Cext_411 \$262 Vdd 8.52743f
Cext_412 \$262 Vom 3.50207a
Cext_413 \$262 Vss 1.47008f
Cext_414 \$262 sky130_gnd 2.55797f
Cext_415 \$278 \$279 68.7517a
Cext_416 \$278 \$288 126.696a
Cext_417 \$278 \$289 64.9211a
Cext_418 \$278 \$3 179.212a
Cext_419 \$278 \$308 936.125a
Cext_420 \$278 \$55 1.4004f
Cext_421 \$278 \$61 4.03488f
Cext_422 \$278 \$83 71.1786a
Cext_423 \$278 Vdd 3.6555f
Cext_424 \$278 Vom 233.867a
Cext_425 \$278 Vop 0.270609a
Cext_426 \$278 VREF 1.59127f
Cext_427 \$278 Vss 9.02407f
Cext_428 \$278 sky130_gnd 7.71024f
Cext_429 \$279 \$288 5.80542f
Cext_430 \$279 \$289 5.31973f
Cext_431 \$279 \$308 240.442a
Cext_432 \$279 \$343 7.23899f
Cext_433 \$279 \$432 161.748a
Cext_434 \$279 \$441 347.291a
Cext_435 \$279 \$451 1.08266f
Cext_436 \$279 \$61 1.78792f
Cext_437 \$279 Vdd 30.2001f
Cext_438 \$279 VREF 1.72947f
Cext_439 \$279 Vss 8.02977f
Cext_440 \$279 sky130_gnd 13.2538f
Cext_441 \$288 \$289 6.44017f
Cext_442 \$288 \$343 5.58367f
Cext_443 \$288 \$61 277.49a
Cext_444 \$288 Vdd 3.18026a
Cext_445 \$288 VREF 1.36933f
Cext_446 \$288 Vss 6.99975f
Cext_447 \$288 sky130_gnd 6.11757f
Cext_448 \$289 \$308 103.038a
Cext_449 \$289 \$343 6.11543f
Cext_450 \$289 \$432 3.71225f
Cext_451 \$289 \$441 3.61068f
Cext_452 \$289 \$451 300.724a
Cext_453 \$289 \$61 510.715a
Cext_454 \$289 Vdd 54.3894f
Cext_455 \$289 VREF 2.77466f
Cext_456 \$289 Vss 8.23871f
Cext_457 \$289 sky130_gnd 16.3367f
Cext_458 \$3 \$61 131.778a
Cext_459 \$3 \$83 350.886a
Cext_460 \$3 Vdd 13.4111f
Cext_461 \$3 Vom 2.55821f
Cext_462 \$3 Vop 4.70772f
Cext_463 \$3 VREF 3.30248f
Cext_464 \$3 Vss 981.814a
Cext_465 \$3 sky130_gnd 7.39855f
Cext_466 \$308 \$451 1.05054f
Cext_467 \$308 \$61 531.036a
Cext_468 \$308 Vdd 3.94064f
Cext_469 \$308 Vom 0.285711a
Cext_470 \$308 VREF 5.5414a
Cext_471 \$308 Vss 3.36031f
Cext_472 \$308 sky130_gnd 9.86555f
Cext_473 \$343 \$61 1.81322f
Cext_474 \$343 VREF 1.36663f
Cext_475 \$343 Vss 1.84454f
Cext_476 \$343 sky130_gnd 9.17339f
Cext_477 \$432 \$441 6.98288f
Cext_478 \$432 \$451 5.40619f
Cext_479 \$432 \$61 1.37531f
Cext_480 \$432 Vdd 16.8696f
Cext_481 \$432 Vm 839.206a
Cext_482 \$432 Vp 29.8607a
Cext_483 \$432 Vss 2.20035f
Cext_484 \$432 sky130_gnd 1.81685f
Cext_485 \$441 \$451 5.18982f
Cext_486 \$441 \$61 107.117a
Cext_487 \$441 Vdd 11.45f
Cext_488 \$441 Vm 23.5876a
Cext_489 \$441 Vp 822.225a
Cext_490 \$441 Vss 486.997a
Cext_491 \$441 sky130_gnd 6.84272f
Cext_492 \$451 \$61 2.55721f
Cext_493 \$451 Vdd 31.2721f
Cext_494 \$451 Vss 547.189a
Cext_495 \$451 sky130_gnd 4.38402f
Cext_496 \$55 \$61 6.9019a
Cext_497 \$55 \$83 1.69907f
Cext_498 \$55 Vdd 13.282f
Cext_499 \$55 Vom 651.982a
Cext_500 \$55 Vop 8.62001a
Cext_501 \$55 Vss 802.151a
Cext_502 \$55 sky130_gnd 2.69359f
Cext_503 \$61 \$83 68.9057a
Cext_504 \$61 RGM 0.126319a
Cext_505 \$61 Vdd 23.3876f
Cext_506 \$61 Vm 1.71303a
Cext_507 \$61 Vom 1.04619p
Cext_508 \$61 Vp 274.34a
Cext_509 \$61 VREF 6.61884f
Cext_510 \$61 Vss 7.28482f
Cext_511 \$61 sky130_gnd 34.7255f
Cext_512 \$83 Vdd 4.64294f
Cext_513 \$83 VREF 347.092a
Cext_514 \$83 Vss 194.037a
Cext_515 \$83 sky130_gnd 970.649a
Cext_516 RGM Vop 3.05351a
Cext_517 RGM Vss 344.787a
Cext_518 RGM sky130_gnd 1.57152f
Cext_519 Vdd Vm 2.31514a
Cext_520 Vdd Vom 6.62922f
Cext_521 Vdd Vop 5.79201f
Cext_522 Vdd Vp 2.31514a
Cext_523 Vdd Vss 3.7392f
Cext_524 Vm Vp 1.78165f
Cext_525 Vm Vss 2.60011f
Cext_526 Vom Vop 4.25556f
Cext_527 Vom Vss 3.76553f
Cext_528 Vop Vss 8.55935f
Cext_529 Vp Vss 1.05114f
Cext_530 VREF Vdd 13.3492f
Cext_531 VREF Vm 0.103013a
Cext_532 VREF Vom 2.35669a
Cext_533 VREF Vp 4.00706a
Cext_534 VREF Vss 16.5757f
Cext_535 VREF sky130_gnd 42.3154f
Cext_536 sky130_gnd Vdd 61.4704f
Cext_537 sky130_gnd Vm 3.9833f
Cext_538 sky130_gnd Vom 34.5046f
Cext_539 sky130_gnd Vop 26.2698f
Cext_540 sky130_gnd Vp 5.00809f
Cext_541 sky130_gnd Vss 332.461f
.ENDS ttsky25a_fd_routed
