* Extracted by KLayout with SKY130 LVS runset on : 04/11/2026 13:27

.SUBCKT ttsky25a_fd_routed \$2.x2_x1_net1 \$2.x2_x1_net10 \$2.x2_x1_net11
+ \$2.x2_x1_net12 \$2.x2_x1_net13 \$2.x2_x1_net14 \$2.x2_x1_net15
+ \$2.x2_x1_net16 \$2.x2_x1_net17 \$2.x2_x1_net18 \$2.x2_x1_net19
+ \$2.x2_x1_net2 \$2.x2_x1_net3 \$2.x2_x1_net4 \$2.x2_x1_net5 \$2.x2_x1_net6
+ \$2.x2_x1_net7 \$2.x2_x1_net8 \$2.x2_x1_net9 \$2.x2_x2_net1 \$2.x2_x2_net10
+ \$2.x2_x2_net11 \$2.x2_x2_net12 \$2.x2_x2_net13 \$2.x2_x2_net14
+ \$2.x2_x2_net15 \$2.x2_x2_net16 \$2.x2_x2_net17 \$2.x2_x2_net18
+ \$2.x2_x2_net19 \$2.x2_x2_net2 \$2.x2_x2_net3 \$2.x2_x2_net4 \$2.x2_x2_net5
+ \$2.x2_x2_net6 \$2.x2_x2_net7 \$2.x2_x2_net8 \$2.x2_x2_net9 RGM VREF Vdd Vm
+ Vom Vop Vp Vss sky130_gnd
C$1 Vom \$71 sky130_fd_pr__model__cap_mim C=2e-13 A=100 P=40
C$2 Vom \$71 sky130_fd_pr__model__cap_mim C=2e-13 A=100 P=40
C$3 Vom \$71 sky130_fd_pr__model__cap_mim C=2e-13 A=100 P=40
C$4 Vom \$71 sky130_fd_pr__model__cap_mim C=2e-13 A=100 P=40
C$5 Vom \$71 sky130_fd_pr__model__cap_mim C=2e-13 A=100 P=40
C$6 Vop \$69 sky130_fd_pr__model__cap_mim C=2e-13 A=100 P=40
C$7 Vop \$69 sky130_fd_pr__model__cap_mim C=2e-13 A=100 P=40
C$8 Vop \$69 sky130_fd_pr__model__cap_mim C=2e-13 A=100 P=40
C$9 Vop \$69 sky130_fd_pr__model__cap_mim C=2e-13 A=100 P=40
C$10 Vop \$69 sky130_fd_pr__model__cap_mim C=2e-13 A=100 P=40
R$11 Vom \$2.x2_x2_net16 sky130_fd_pr__res_generic_po R=3856 L=40 W=0.5 A=20
+ P=81
R$12 \$96 \$2.x2_x2_net4 sky130_fd_pr__res_generic_po R=3856 L=40 W=0.5 A=20
+ P=81
R$13 \$96 \$2.x2_x1_net16 sky130_fd_pr__res_generic_po R=3856 L=40 W=0.5 A=20
+ P=81
R$14 Vop \$2.x2_x1_net4 sky130_fd_pr__res_generic_po R=3856 L=40 W=0.5 A=20 P=81
R$15 Vss Vss sky130_fd_pr__res_generic_po R=3856 L=40 W=0.5 A=20 P=81
R$16 Vss Vss sky130_fd_pr__res_generic_po R=3856 L=40 W=0.5 A=20 P=81
R$17 \$2.x2_x2_net5 \$2.x2_x2_net6 sky130_fd_pr__res_generic_po R=3856 L=40
+ W=0.5 A=20 P=81
R$18 \$2.x2_x2_net5 \$2.x2_x2_net4 sky130_fd_pr__res_generic_po R=3856 L=40
+ W=0.5 A=20 P=81
R$19 \$2.x2_x1_net5 \$2.x2_x1_net6 sky130_fd_pr__res_generic_po R=3856 L=40
+ W=0.5 A=20 P=81
R$20 \$2.x2_x1_net5 \$2.x2_x1_net4 sky130_fd_pr__res_generic_po R=3856 L=40
+ W=0.5 A=20 P=81
R$21 \$2.x2_x2_net7 \$2.x2_x2_net1 sky130_fd_pr__res_generic_po R=3856 L=40
+ W=0.5 A=20 P=81
R$22 \$2.x2_x2_net7 \$2.x2_x2_net6 sky130_fd_pr__res_generic_po R=3856 L=40
+ W=0.5 A=20 P=81
R$23 \$2.x2_x1_net7 \$2.x2_x1_net1 sky130_fd_pr__res_generic_po R=3856 L=40
+ W=0.5 A=20 P=81
R$24 \$2.x2_x1_net7 \$2.x2_x1_net6 sky130_fd_pr__res_generic_po R=3856 L=40
+ W=0.5 A=20 P=81
R$25 \$2.x2_x2_net11 \$2.x2_x2_net10 sky130_fd_pr__res_generic_po R=3856 L=40
+ W=0.5 A=20 P=81
R$26 \$2.x2_x2_net11 \$2.x2_x2_net1 sky130_fd_pr__res_generic_po R=3856 L=40
+ W=0.5 A=20 P=81
R$27 \$2.x2_x1_net11 \$2.x2_x1_net10 sky130_fd_pr__res_generic_po R=3856 L=40
+ W=0.5 A=20 P=81
R$28 \$2.x2_x1_net11 \$2.x2_x1_net1 sky130_fd_pr__res_generic_po R=3856 L=40
+ W=0.5 A=20 P=81
R$29 \$2.x2_x2_net9 \$2.x2_x2_net8 sky130_fd_pr__res_generic_po R=3856 L=40
+ W=0.5 A=20 P=81
R$30 \$2.x2_x2_net9 \$2.x2_x2_net10 sky130_fd_pr__res_generic_po R=3856 L=40
+ W=0.5 A=20 P=81
R$31 \$2.x2_x1_net9 \$2.x2_x1_net8 sky130_fd_pr__res_generic_po R=3856 L=40
+ W=0.5 A=20 P=81
R$32 \$2.x2_x1_net9 \$2.x2_x1_net10 sky130_fd_pr__res_generic_po R=3856 L=40
+ W=0.5 A=20 P=81
R$33 \$2.x2_x2_net2 \$2.x2_x2_net8 sky130_fd_pr__res_generic_po R=3856 L=40
+ W=0.5 A=20 P=81
R$34 \$2.x2_x2_net2 \$2.x2_x2_net12 sky130_fd_pr__res_generic_po R=3856 L=40
+ W=0.5 A=20 P=81
R$35 \$2.x2_x1_net2 \$2.x2_x1_net8 sky130_fd_pr__res_generic_po R=3856 L=40
+ W=0.5 A=20 P=81
R$36 \$2.x2_x1_net2 \$2.x2_x1_net12 sky130_fd_pr__res_generic_po R=3856 L=40
+ W=0.5 A=20 P=81
R$37 \$2.x2_x2_net13 \$2.x2_x2_net14 sky130_fd_pr__res_generic_po R=3856 L=40
+ W=0.5 A=20 P=81
R$38 \$2.x2_x2_net13 \$2.x2_x2_net12 sky130_fd_pr__res_generic_po R=3856 L=40
+ W=0.5 A=20 P=81
R$39 \$2.x2_x1_net13 \$2.x2_x1_net14 sky130_fd_pr__res_generic_po R=3856 L=40
+ W=0.5 A=20 P=81
R$40 \$2.x2_x1_net13 \$2.x2_x1_net12 sky130_fd_pr__res_generic_po R=3856 L=40
+ W=0.5 A=20 P=81
R$41 \$2.x2_x2_net15 \$2.x2_x2_net3 sky130_fd_pr__res_generic_po R=3856 L=40
+ W=0.5 A=20 P=81
R$42 \$2.x2_x2_net15 \$2.x2_x2_net14 sky130_fd_pr__res_generic_po R=3856 L=40
+ W=0.5 A=20 P=81
R$43 \$2.x2_x1_net15 \$2.x2_x1_net3 sky130_fd_pr__res_generic_po R=3856 L=40
+ W=0.5 A=20 P=81
R$44 \$2.x2_x1_net15 \$2.x2_x1_net14 sky130_fd_pr__res_generic_po R=3856 L=40
+ W=0.5 A=20 P=81
R$45 \$2.x2_x2_net19 \$2.x2_x2_net18 sky130_fd_pr__res_generic_po R=3856 L=40
+ W=0.5 A=20 P=81
R$46 \$2.x2_x2_net19 \$2.x2_x2_net3 sky130_fd_pr__res_generic_po R=3856 L=40
+ W=0.5 A=20 P=81
R$47 \$2.x2_x1_net19 \$2.x2_x1_net18 sky130_fd_pr__res_generic_po R=3856 L=40
+ W=0.5 A=20 P=81
R$48 \$2.x2_x1_net19 \$2.x2_x1_net3 sky130_fd_pr__res_generic_po R=3856 L=40
+ W=0.5 A=20 P=81
R$49 \$2.x2_x2_net17 \$2.x2_x2_net16 sky130_fd_pr__res_generic_po R=3856 L=40
+ W=0.5 A=20 P=81
R$50 \$2.x2_x2_net17 \$2.x2_x2_net18 sky130_fd_pr__res_generic_po R=3856 L=40
+ W=0.5 A=20 P=81
R$51 \$2.x2_x1_net17 \$2.x2_x1_net16 sky130_fd_pr__res_generic_po R=3856 L=40
+ W=0.5 A=20 P=81
R$52 \$2.x2_x1_net17 \$2.x2_x1_net18 sky130_fd_pr__res_generic_po R=3856 L=40
+ W=0.5 A=20 P=81
M$53 \$451 \$451 Vdd Vdd sky130_fd_pr__pfet_01v8_lvt L=10 W=1.5 AS=0.435
+ AD=0.435 PS=3.58 PD=3.58
M$54 \$451 \$451 Vdd Vdd sky130_fd_pr__pfet_01v8_lvt L=10 W=1.5 AS=0.435
+ AD=0.435 PS=3.58 PD=3.58
M$55 Vdd Vdd Vdd Vdd sky130_fd_pr__pfet_01v8_lvt L=5 W=1 AS=0.29 AD=0.145
+ PS=2.58 PD=1.29
M$56 Vdd Vdd Vdd Vdd sky130_fd_pr__pfet_01v8_lvt L=5 W=1 AS=0.145 AD=0.29
+ PS=1.29 PD=2.58
M$57 Vdd Vdd Vdd Vdd sky130_fd_pr__pfet_01v8_lvt L=5 W=1 AS=0.29 AD=0.145
+ PS=2.58 PD=1.29
M$58 Vdd Vdd Vdd Vdd sky130_fd_pr__pfet_01v8_lvt L=5 W=1 AS=0.145 AD=0.29
+ PS=1.29 PD=2.58
M$59 Vdd \$292 \$433 Vdd sky130_fd_pr__pfet_01v8_lvt L=5 W=1 AS=0.29 AD=0.145
+ PS=2.58 PD=1.29
M$60 \$433 \$292 Vdd Vdd sky130_fd_pr__pfet_01v8_lvt L=5 W=1 AS=0.145 AD=0.29
+ PS=1.29 PD=2.58
M$61 Vdd \$292 \$442 Vdd sky130_fd_pr__pfet_01v8_lvt L=5 W=1 AS=0.29 AD=0.145
+ PS=2.58 PD=1.29
M$62 \$442 \$292 Vdd Vdd sky130_fd_pr__pfet_01v8_lvt L=5 W=1 AS=0.145 AD=0.29
+ PS=1.29 PD=2.58
M$63 Vdd \$292 \$433 Vdd sky130_fd_pr__pfet_01v8_lvt L=5 W=1 AS=0.29 AD=0.145
+ PS=2.58 PD=1.29
M$64 \$433 \$292 Vdd Vdd sky130_fd_pr__pfet_01v8_lvt L=5 W=1 AS=0.145 AD=0.29
+ PS=1.29 PD=2.58
M$65 Vdd \$292 \$442 Vdd sky130_fd_pr__pfet_01v8_lvt L=5 W=1 AS=0.29 AD=0.145
+ PS=2.58 PD=1.29
M$66 \$442 \$292 Vdd Vdd sky130_fd_pr__pfet_01v8_lvt L=5 W=1 AS=0.145 AD=0.29
+ PS=1.29 PD=2.58
M$67 Vdd \$292 \$442 Vdd sky130_fd_pr__pfet_01v8_lvt L=5 W=1 AS=0.29 AD=0.145
+ PS=2.58 PD=1.29
M$68 \$442 \$292 Vdd Vdd sky130_fd_pr__pfet_01v8_lvt L=5 W=1 AS=0.145 AD=0.29
+ PS=1.29 PD=2.58
M$69 Vdd \$292 \$433 Vdd sky130_fd_pr__pfet_01v8_lvt L=5 W=1 AS=0.29 AD=0.145
+ PS=2.58 PD=1.29
M$70 \$433 \$292 Vdd Vdd sky130_fd_pr__pfet_01v8_lvt L=5 W=1 AS=0.145 AD=0.29
+ PS=1.29 PD=2.58
M$71 Vdd \$292 \$442 Vdd sky130_fd_pr__pfet_01v8_lvt L=5 W=1 AS=0.29 AD=0.145
+ PS=2.58 PD=1.29
M$72 \$442 \$292 Vdd Vdd sky130_fd_pr__pfet_01v8_lvt L=5 W=1 AS=0.145 AD=0.29
+ PS=1.29 PD=2.58
M$73 Vdd \$292 \$433 Vdd sky130_fd_pr__pfet_01v8_lvt L=5 W=1 AS=0.29 AD=0.145
+ PS=2.58 PD=1.29
M$74 \$433 \$292 Vdd Vdd sky130_fd_pr__pfet_01v8_lvt L=5 W=1 AS=0.145 AD=0.29
+ PS=1.29 PD=2.58
M$75 Vdd Vdd Vdd Vdd sky130_fd_pr__pfet_01v8_lvt L=5 W=1 AS=0.29 AD=0.145
+ PS=2.58 PD=1.29
M$76 Vdd Vdd Vdd Vdd sky130_fd_pr__pfet_01v8_lvt L=5 W=1 AS=0.145 AD=0.29
+ PS=1.29 PD=2.58
M$77 Vdd Vdd Vdd Vdd sky130_fd_pr__pfet_01v8_lvt L=5 W=1 AS=0.29 AD=0.145
+ PS=2.58 PD=1.29
M$78 Vdd Vdd Vdd Vdd sky130_fd_pr__pfet_01v8_lvt L=5 W=1 AS=0.145 AD=0.29
+ PS=1.29 PD=2.58
M$79 \$442 \$451 \$69 Vdd sky130_fd_pr__pfet_01v8_lvt L=5 W=1 AS=0.29 AD=0.145
+ PS=2.58 PD=1.29
M$80 \$69 \$451 \$442 Vdd sky130_fd_pr__pfet_01v8_lvt L=5 W=1 AS=0.145 AD=0.29
+ PS=1.29 PD=2.58
M$81 \$433 \$451 \$71 Vdd sky130_fd_pr__pfet_01v8_lvt L=5 W=1 AS=0.29 AD=0.145
+ PS=2.58 PD=1.29
M$82 \$71 \$451 \$433 Vdd sky130_fd_pr__pfet_01v8_lvt L=5 W=1 AS=0.145 AD=0.29
+ PS=1.29 PD=2.58
M$83 \$442 \$451 \$69 Vdd sky130_fd_pr__pfet_01v8_lvt L=5 W=1 AS=0.29 AD=0.145
+ PS=2.58 PD=1.29
M$84 \$69 \$451 \$442 Vdd sky130_fd_pr__pfet_01v8_lvt L=5 W=1 AS=0.145 AD=0.29
+ PS=1.29 PD=2.58
M$85 \$433 \$451 \$71 Vdd sky130_fd_pr__pfet_01v8_lvt L=5 W=1 AS=0.29 AD=0.145
+ PS=2.58 PD=1.29
M$86 \$71 \$451 \$433 Vdd sky130_fd_pr__pfet_01v8_lvt L=5 W=1 AS=0.145 AD=0.29
+ PS=1.29 PD=2.58
M$87 \$129 \$129 Vss sky130_gnd sky130_fd_pr__nfet_01v8_lvt L=5 W=0.6 AS=0.174
+ AD=0.174 PS=1.78 PD=1.78
M$88 \$129 \$129 Vss sky130_gnd sky130_fd_pr__nfet_01v8_lvt L=5 W=0.6 AS=0.174
+ AD=0.174 PS=1.78 PD=1.78
M$89 Vss Vss Vss sky130_gnd sky130_fd_pr__nfet_01v8_lvt L=4 W=4 AS=1.16 AD=1.16
+ PS=8.58 PD=8.58
M$90 Vss Vss Vss sky130_gnd sky130_fd_pr__nfet_01v8_lvt L=4 W=4 AS=1.16 AD=1.16
+ PS=8.58 PD=8.58
M$91 \$433 Vm \$127 sky130_gnd sky130_fd_pr__nfet_01v8_lvt L=4 W=4 AS=1.16
+ AD=1.16 PS=8.58 PD=8.58
M$92 \$442 Vp \$127 sky130_gnd sky130_fd_pr__nfet_01v8_lvt L=4 W=4 AS=1.16
+ AD=1.16 PS=8.58 PD=8.58
M$93 \$442 Vp \$127 sky130_gnd sky130_fd_pr__nfet_01v8_lvt L=4 W=4 AS=1.16
+ AD=1.16 PS=8.58 PD=8.58
M$94 \$433 Vm \$127 sky130_gnd sky130_fd_pr__nfet_01v8_lvt L=4 W=4 AS=1.16
+ AD=1.16 PS=8.58 PD=8.58
M$95 \$158 \$158 Vdd Vdd sky130_fd_pr__pfet_01v8_lvt L=20 W=1 AS=0.29 AD=0.29
+ PS=2.58 PD=2.58
M$96 \$158 \$158 Vdd Vdd sky130_fd_pr__pfet_01v8_lvt L=20 W=1 AS=0.29 AD=0.29
+ PS=2.58 PD=2.58
M$97 Vdd Vdd Vdd Vdd sky130_fd_pr__pfet_01v8_lvt L=1 W=5 AS=1.45 AD=1.45
+ PS=10.58 PD=10.58
M$98 Vdd Vdd Vdd Vdd sky130_fd_pr__pfet_01v8_lvt L=1 W=5 AS=1.45 AD=1.45
+ PS=10.58 PD=10.58
M$99 \$271 \$271 Vdd Vdd sky130_fd_pr__pfet_01v8_lvt L=1 W=5 AS=1.45 AD=1.45
+ PS=10.58 PD=10.58
M$100 \$157 \$271 Vdd Vdd sky130_fd_pr__pfet_01v8_lvt L=1 W=5 AS=1.45 AD=1.45
+ PS=10.58 PD=10.58
M$101 \$271 \$271 Vdd Vdd sky130_fd_pr__pfet_01v8_lvt L=1 W=5 AS=1.45 AD=1.45
+ PS=10.58 PD=10.58
M$102 \$157 \$271 Vdd Vdd sky130_fd_pr__pfet_01v8_lvt L=1 W=5 AS=1.45 AD=1.45
+ PS=10.58 PD=10.58
M$103 Vdd Vdd Vdd Vdd sky130_fd_pr__pfet_01v8_lvt L=1 W=5 AS=1.45 AD=1.45
+ PS=10.58 PD=10.58
M$104 \$171 \$157 Vdd Vdd sky130_fd_pr__pfet_01v8_lvt L=1 W=5 AS=1.45 AD=1.45
+ PS=10.58 PD=10.58
M$105 \$227 \$157 Vdd Vdd sky130_fd_pr__pfet_01v8_lvt L=1 W=5 AS=1.45 AD=1.45
+ PS=10.58 PD=10.58
M$106 \$171 \$157 Vdd Vdd sky130_fd_pr__pfet_01v8_lvt L=1 W=5 AS=1.45 AD=1.45
+ PS=10.58 PD=10.58
M$107 \$227 \$157 Vdd Vdd sky130_fd_pr__pfet_01v8_lvt L=1 W=5 AS=1.45 AD=1.45
+ PS=10.58 PD=10.58
M$108 Vdd Vdd Vdd Vdd sky130_fd_pr__pfet_01v8_lvt L=1 W=5 AS=1.45 AD=1.45
+ PS=10.58 PD=10.58
M$109 \$36 \$157 Vdd Vdd sky130_fd_pr__pfet_01v8_lvt L=1 W=5 AS=1.45 AD=1.45
+ PS=10.58 PD=10.58
M$110 \$288 \$157 Vdd Vdd sky130_fd_pr__pfet_01v8_lvt L=1 W=5 AS=1.45 AD=1.45
+ PS=10.58 PD=10.58
M$111 Vdd Vdd Vdd Vdd sky130_fd_pr__pfet_01v8_lvt L=1 W=5 AS=1.45 AD=1.45
+ PS=10.58 PD=10.58
M$112 Vdd Vdd Vdd Vdd sky130_fd_pr__pfet_01v8_lvt L=1 W=5 AS=1.45 AD=1.45
+ PS=10.58 PD=10.58
M$113 \$288 \$157 Vdd Vdd sky130_fd_pr__pfet_01v8_lvt L=1 W=5 AS=1.45 AD=1.45
+ PS=10.58 PD=10.58
M$114 \$36 \$157 Vdd Vdd sky130_fd_pr__pfet_01v8_lvt L=1 W=5 AS=1.45 AD=1.45
+ PS=10.58 PD=10.58
M$115 Vdd Vdd Vdd Vdd sky130_fd_pr__pfet_01v8_lvt L=1 W=5 AS=1.45 AD=1.45
+ PS=10.58 PD=10.58
M$116 \$129 \$157 Vdd Vdd sky130_fd_pr__pfet_01v8_lvt L=1 W=5 AS=1.45 AD=1.45
+ PS=10.58 PD=10.58
M$117 \$172 \$157 Vdd Vdd sky130_fd_pr__pfet_01v8_lvt L=1 W=5 AS=1.45 AD=1.45
+ PS=10.58 PD=10.58
M$118 \$129 \$157 Vdd Vdd sky130_fd_pr__pfet_01v8_lvt L=1 W=5 AS=1.45 AD=1.45
+ PS=10.58 PD=10.58
M$119 \$172 \$157 Vdd Vdd sky130_fd_pr__pfet_01v8_lvt L=1 W=5 AS=1.45 AD=1.45
+ PS=10.58 PD=10.58
M$120 Vdd Vdd Vdd Vdd sky130_fd_pr__pfet_01v8_lvt L=1 W=5 AS=1.45 AD=1.45
+ PS=10.58 PD=10.58
M$121 Vss Vss Vss sky130_gnd sky130_fd_pr__nfet_01v8_lvt L=20 W=1 AS=0.29
+ AD=0.29 PS=2.58 PD=2.58
M$122 Vss Vss Vss sky130_gnd sky130_fd_pr__nfet_01v8_lvt L=20 W=1 AS=0.29
+ AD=0.29 PS=2.58 PD=2.58
M$123 \$291 \$172 Vss sky130_gnd sky130_fd_pr__nfet_01v8_lvt L=20 W=1 AS=0.29
+ AD=0.29 PS=2.58 PD=2.58
M$124 \$344 \$172 Vss sky130_gnd sky130_fd_pr__nfet_01v8_lvt L=20 W=1 AS=0.29
+ AD=0.29 PS=2.58 PD=2.58
M$125 \$344 \$172 Vss sky130_gnd sky130_fd_pr__nfet_01v8_lvt L=20 W=1 AS=0.29
+ AD=0.29 PS=2.58 PD=2.58
M$126 \$291 \$172 Vss sky130_gnd sky130_fd_pr__nfet_01v8_lvt L=20 W=1 AS=0.29
+ AD=0.29 PS=2.58 PD=2.58
M$127 Vss Vss Vss sky130_gnd sky130_fd_pr__nfet_01v8_lvt L=20 W=5 AS=1.45
+ AD=1.45 PS=10.58 PD=10.58
M$128 Vss Vss Vss sky130_gnd sky130_fd_pr__nfet_01v8_lvt L=20 W=5 AS=1.45
+ AD=1.45 PS=10.58 PD=10.58
M$129 \$282 \$71 \$344 sky130_gnd sky130_fd_pr__nfet_01v8_lvt L=20 W=5 AS=1.45
+ AD=1.45 PS=10.58 PD=10.58
M$130 \$292 VREF \$344 sky130_gnd sky130_fd_pr__nfet_01v8_lvt L=20 W=5 AS=1.45
+ AD=1.45 PS=10.58 PD=10.58
M$131 \$292 VREF \$344 sky130_gnd sky130_fd_pr__nfet_01v8_lvt L=20 W=5 AS=1.45
+ AD=1.45 PS=10.58 PD=10.58
M$132 \$282 \$71 \$344 sky130_gnd sky130_fd_pr__nfet_01v8_lvt L=20 W=5 AS=1.45
+ AD=1.45 PS=10.58 PD=10.58
M$133 Vss Vss Vss sky130_gnd sky130_fd_pr__nfet_01v8_lvt L=20 W=5 AS=1.45
+ AD=1.45 PS=10.58 PD=10.58
M$134 Vss Vss Vss sky130_gnd sky130_fd_pr__nfet_01v8_lvt L=20 W=5 AS=1.45
+ AD=1.45 PS=10.58 PD=10.58
M$135 \$282 \$69 \$291 sky130_gnd sky130_fd_pr__nfet_01v8_lvt L=20 W=5 AS=1.45
+ AD=1.45 PS=10.58 PD=10.58
M$136 \$292 VREF \$291 sky130_gnd sky130_fd_pr__nfet_01v8_lvt L=20 W=5 AS=1.45
+ AD=1.45 PS=10.58 PD=10.58
M$137 \$292 VREF \$291 sky130_gnd sky130_fd_pr__nfet_01v8_lvt L=20 W=5 AS=1.45
+ AD=1.45 PS=10.58 PD=10.58
M$138 \$282 \$69 \$291 sky130_gnd sky130_fd_pr__nfet_01v8_lvt L=20 W=5 AS=1.45
+ AD=1.45 PS=10.58 PD=10.58
M$139 \$227 \$227 RGM sky130_gnd sky130_fd_pr__nfet_01v8_lvt L=1 W=10 AS=2.9
+ AD=2.9 PS=20.58 PD=20.58
M$140 \$227 \$227 RGM sky130_gnd sky130_fd_pr__nfet_01v8_lvt L=1 W=10 AS=2.9
+ AD=2.9 PS=20.58 PD=20.58
M$141 \$157 \$158 \$171 sky130_gnd sky130_fd_pr__nfet_01v8_lvt L=1 W=2 AS=0.58
+ AD=0.58 PS=4.58 PD=4.58
M$142 \$271 \$227 Vss sky130_gnd sky130_fd_pr__nfet_01v8_lvt L=2 W=5 AS=1.45
+ AD=1.45 PS=10.58 PD=10.58
M$143 \$271 \$227 Vss sky130_gnd sky130_fd_pr__nfet_01v8_lvt L=2 W=5 AS=1.45
+ AD=1.45 PS=10.58 PD=10.58
M$144 \$157 \$171 Vss sky130_gnd sky130_fd_pr__nfet_01v8_lvt L=2 W=5 AS=1.45
+ AD=1.45 PS=10.58 PD=10.58
M$145 \$157 \$171 Vss sky130_gnd sky130_fd_pr__nfet_01v8_lvt L=2 W=5 AS=1.45
+ AD=1.45 PS=10.58 PD=10.58
M$146 Vss Vss Vss sky130_gnd sky130_fd_pr__nfet_01v8_lvt L=2 W=5 AS=1.45
+ AD=1.45 PS=10.58 PD=10.58
M$147 Vss Vss Vss sky130_gnd sky130_fd_pr__nfet_01v8_lvt L=2 W=5 AS=1.45
+ AD=1.45 PS=10.58 PD=10.58
M$148 \$171 \$171 Vss sky130_gnd sky130_fd_pr__nfet_01v8_lvt L=2 W=5 AS=1.45
+ AD=1.45 PS=10.58 PD=10.58
M$149 \$158 \$171 Vss sky130_gnd sky130_fd_pr__nfet_01v8_lvt L=2 W=5 AS=1.45
+ AD=1.45 PS=10.58 PD=10.58
M$150 \$158 \$171 Vss sky130_gnd sky130_fd_pr__nfet_01v8_lvt L=2 W=5 AS=1.45
+ AD=1.45 PS=10.58 PD=10.58
M$151 \$171 \$171 Vss sky130_gnd sky130_fd_pr__nfet_01v8_lvt L=2 W=5 AS=1.45
+ AD=1.45 PS=10.58 PD=10.58
M$152 \$172 \$172 Vss sky130_gnd sky130_fd_pr__nfet_01v8_lvt L=2 W=1 AS=0.29
+ AD=0.29 PS=2.58 PD=2.58
M$153 \$172 \$172 Vss sky130_gnd sky130_fd_pr__nfet_01v8_lvt L=2 W=1 AS=0.29
+ AD=0.29 PS=2.58 PD=2.58
M$154 \$136 \$172 Vss sky130_gnd sky130_fd_pr__nfet_01v8_lvt L=10 W=1 AS=0.29
+ AD=0.29 PS=2.58 PD=2.58
M$155 \$136 \$172 Vss sky130_gnd sky130_fd_pr__nfet_01v8_lvt L=10 W=1 AS=0.29
+ AD=0.29 PS=2.58 PD=2.58
M$156 \$141 \$172 Vss sky130_gnd sky130_fd_pr__nfet_01v8_lvt L=10 W=1 AS=0.29
+ AD=0.29 PS=2.58 PD=2.58
M$157 \$141 \$172 Vss sky130_gnd sky130_fd_pr__nfet_01v8_lvt L=10 W=1 AS=0.29
+ AD=0.29 PS=2.58 PD=2.58
M$158 \$126 \$172 Vss sky130_gnd sky130_fd_pr__nfet_01v8_lvt L=10 W=1 AS=0.29
+ AD=0.29 PS=2.58 PD=2.58
M$159 \$126 \$172 Vss sky130_gnd sky130_fd_pr__nfet_01v8_lvt L=10 W=1 AS=0.29
+ AD=0.29 PS=2.58 PD=2.58
M$160 \$159 \$172 Vss sky130_gnd sky130_fd_pr__nfet_01v8_lvt L=10 W=1 AS=0.29
+ AD=0.29 PS=2.58 PD=2.58
M$161 \$159 \$172 Vss sky130_gnd sky130_fd_pr__nfet_01v8_lvt L=10 W=1 AS=0.29
+ AD=0.29 PS=2.58 PD=2.58
M$162 Vss Vss Vss sky130_gnd sky130_fd_pr__nfet_01v8_lvt L=10 W=1 AS=0.29
+ AD=0.29 PS=2.58 PD=2.58
M$163 Vss Vss Vss sky130_gnd sky130_fd_pr__nfet_01v8_lvt L=10 W=1 AS=0.29
+ AD=0.29 PS=2.58 PD=2.58
M$164 Vss Vss Vss sky130_gnd sky130_fd_pr__nfet_01v8_lvt L=20 W=0.5 AS=0.145
+ AD=0.145 PS=1.58 PD=1.58
M$165 Vss Vss Vss sky130_gnd sky130_fd_pr__nfet_01v8_lvt L=20 W=0.5 AS=0.145
+ AD=0.145 PS=1.58 PD=1.58
M$166 \$10 \$10 Vss sky130_gnd sky130_fd_pr__nfet_01v8_lvt L=20 W=0.5 AS=0.145
+ AD=0.145 PS=1.58 PD=1.58
M$167 \$11 \$10 Vss sky130_gnd sky130_fd_pr__nfet_01v8_lvt L=20 W=0.5 AS=0.145
+ AD=0.145 PS=1.58 PD=1.58
M$168 \$11 \$10 Vss sky130_gnd sky130_fd_pr__nfet_01v8_lvt L=20 W=0.5 AS=0.145
+ AD=0.145 PS=1.58 PD=1.58
M$169 \$10 \$10 Vss sky130_gnd sky130_fd_pr__nfet_01v8_lvt L=20 W=0.5 AS=0.145
+ AD=0.145 PS=1.58 PD=1.58
M$170 \$127 \$129 \$159 sky130_gnd sky130_fd_pr__nfet_01v8_lvt L=1 W=1 AS=0.29
+ AD=0.29 PS=2.58 PD=2.58
M$171 \$127 \$129 \$159 sky130_gnd sky130_fd_pr__nfet_01v8_lvt L=1 W=1 AS=0.29
+ AD=0.29 PS=2.58 PD=2.58
M$172 \$71 \$129 \$141 sky130_gnd sky130_fd_pr__nfet_01v8_lvt L=1 W=1 AS=0.29
+ AD=0.29 PS=2.58 PD=2.58
M$173 \$71 \$129 \$141 sky130_gnd sky130_fd_pr__nfet_01v8_lvt L=1 W=1 AS=0.29
+ AD=0.29 PS=2.58 PD=2.58
M$174 Vss Vss Vss sky130_gnd sky130_fd_pr__nfet_01v8_lvt L=1 W=1 AS=0.29
+ AD=0.29 PS=2.58 PD=2.58
M$175 Vss Vss Vss sky130_gnd sky130_fd_pr__nfet_01v8_lvt L=1 W=1 AS=0.29
+ AD=0.29 PS=2.58 PD=2.58
M$176 \$127 \$129 \$126 sky130_gnd sky130_fd_pr__nfet_01v8_lvt L=1 W=1 AS=0.29
+ AD=0.29 PS=2.58 PD=2.58
M$177 \$127 \$129 \$126 sky130_gnd sky130_fd_pr__nfet_01v8_lvt L=1 W=1 AS=0.29
+ AD=0.29 PS=2.58 PD=2.58
M$178 \$69 \$129 \$136 sky130_gnd sky130_fd_pr__nfet_01v8_lvt L=1 W=1 AS=0.29
+ AD=0.29 PS=2.58 PD=2.58
M$179 \$69 \$129 \$136 sky130_gnd sky130_fd_pr__nfet_01v8_lvt L=1 W=1 AS=0.29
+ AD=0.29 PS=2.58 PD=2.58
M$180 Vss Vss Vss sky130_gnd sky130_fd_pr__nfet_01v8_lvt L=1 W=1 AS=0.29
+ AD=0.29 PS=2.58 PD=2.58
M$181 Vss Vss Vss sky130_gnd sky130_fd_pr__nfet_01v8_lvt L=1 W=1 AS=0.29
+ AD=0.29 PS=2.58 PD=2.58
M$182 Vop \$11 Vss sky130_gnd sky130_fd_pr__nfet_01v8_lvt L=1 W=1 AS=0.29
+ AD=0.29 PS=2.58 PD=2.58
M$183 Vop \$11 Vss sky130_gnd sky130_fd_pr__nfet_01v8_lvt L=1 W=1 AS=0.29
+ AD=0.29 PS=2.58 PD=2.58
M$184 Vop \$11 Vss sky130_gnd sky130_fd_pr__nfet_01v8_lvt L=1 W=1 AS=0.29
+ AD=0.29 PS=2.58 PD=2.58
M$185 Vop \$11 Vss sky130_gnd sky130_fd_pr__nfet_01v8_lvt L=1 W=1 AS=0.29
+ AD=0.29 PS=2.58 PD=2.58
M$186 Vop \$11 Vss sky130_gnd sky130_fd_pr__nfet_01v8_lvt L=1 W=1 AS=0.29
+ AD=0.29 PS=2.58 PD=2.58
M$187 Vop \$11 Vss sky130_gnd sky130_fd_pr__nfet_01v8_lvt L=1 W=1 AS=0.29
+ AD=0.29 PS=2.58 PD=2.58
M$188 Vop \$11 Vss sky130_gnd sky130_fd_pr__nfet_01v8_lvt L=1 W=1 AS=0.29
+ AD=0.29 PS=2.58 PD=2.58
M$189 Vop \$11 Vss sky130_gnd sky130_fd_pr__nfet_01v8_lvt L=1 W=1 AS=0.29
+ AD=0.29 PS=2.58 PD=2.58
M$190 Vop \$11 Vss sky130_gnd sky130_fd_pr__nfet_01v8_lvt L=1 W=1 AS=0.29
+ AD=0.29 PS=2.58 PD=2.58
M$191 Vss Vss Vss sky130_gnd sky130_fd_pr__nfet_01v8_lvt L=1 W=1 AS=0.29
+ AD=0.29 PS=2.58 PD=2.58
M$192 Vom \$11 Vss sky130_gnd sky130_fd_pr__nfet_01v8_lvt L=1 W=1 AS=0.29
+ AD=0.29 PS=2.58 PD=2.58
M$193 Vom \$11 Vss sky130_gnd sky130_fd_pr__nfet_01v8_lvt L=1 W=1 AS=0.29
+ AD=0.29 PS=2.58 PD=2.58
M$194 Vom \$11 Vss sky130_gnd sky130_fd_pr__nfet_01v8_lvt L=1 W=1 AS=0.29
+ AD=0.29 PS=2.58 PD=2.58
M$195 Vom \$11 Vss sky130_gnd sky130_fd_pr__nfet_01v8_lvt L=1 W=1 AS=0.29
+ AD=0.29 PS=2.58 PD=2.58
M$196 Vom \$11 Vss sky130_gnd sky130_fd_pr__nfet_01v8_lvt L=1 W=1 AS=0.29
+ AD=0.29 PS=2.58 PD=2.58
M$197 Vom \$11 Vss sky130_gnd sky130_fd_pr__nfet_01v8_lvt L=1 W=1 AS=0.29
+ AD=0.29 PS=2.58 PD=2.58
M$198 Vom \$11 Vss sky130_gnd sky130_fd_pr__nfet_01v8_lvt L=1 W=1 AS=0.29
+ AD=0.29 PS=2.58 PD=2.58
M$199 Vom \$11 Vss sky130_gnd sky130_fd_pr__nfet_01v8_lvt L=1 W=1 AS=0.29
+ AD=0.29 PS=2.58 PD=2.58
M$200 Vss Vss Vss sky130_gnd sky130_fd_pr__nfet_01v8_lvt L=1 W=1 AS=0.29
+ AD=0.29 PS=2.58 PD=2.58
M$201 Vom \$11 Vss sky130_gnd sky130_fd_pr__nfet_01v8_lvt L=1 W=1 AS=0.29
+ AD=0.29 PS=2.58 PD=2.58
M$202 Vss Vss Vss sky130_gnd sky130_fd_pr__nfet_01v8_lvt L=1 W=0.6 AS=0.174
+ AD=0.174 PS=1.78 PD=1.78
M$203 Vss Vss Vss sky130_gnd sky130_fd_pr__nfet_01v8_lvt L=1 W=0.6 AS=0.174
+ AD=0.174 PS=1.78 PD=1.78
M$204 \$451 \$288 Vss sky130_gnd sky130_fd_pr__nfet_01v8_lvt L=1 W=0.6 AS=0.174
+ AD=0.174 PS=1.78 PD=1.78
M$205 \$288 \$288 Vss sky130_gnd sky130_fd_pr__nfet_01v8_lvt L=1 W=0.6 AS=0.174
+ AD=0.174 PS=1.78 PD=1.78
M$206 \$288 \$288 Vss sky130_gnd sky130_fd_pr__nfet_01v8_lvt L=1 W=0.6 AS=0.174
+ AD=0.174 PS=1.78 PD=1.78
M$207 \$451 \$288 Vss sky130_gnd sky130_fd_pr__nfet_01v8_lvt L=1 W=0.6 AS=0.174
+ AD=0.174 PS=1.78 PD=1.78
M$208 Vss Vss Vss sky130_gnd sky130_fd_pr__nfet_01v8_lvt L=1 W=0.6 AS=0.174
+ AD=0.174 PS=1.78 PD=1.78
M$209 Vss Vss Vss sky130_gnd sky130_fd_pr__nfet_01v8_lvt L=1 W=0.6 AS=0.174
+ AD=0.174 PS=1.78 PD=1.78
M$210 \$36 \$36 Vss sky130_gnd sky130_fd_pr__nfet_01v8_lvt L=1 W=0.6 AS=0.174
+ AD=0.174 PS=1.78 PD=1.78
M$211 \$35 \$36 Vss sky130_gnd sky130_fd_pr__nfet_01v8_lvt L=1 W=0.6 AS=0.174
+ AD=0.174 PS=1.78 PD=1.78
M$212 \$35 \$36 Vss sky130_gnd sky130_fd_pr__nfet_01v8_lvt L=1 W=0.6 AS=0.174
+ AD=0.174 PS=1.78 PD=1.78
M$213 \$36 \$36 Vss sky130_gnd sky130_fd_pr__nfet_01v8_lvt L=1 W=0.6 AS=0.174
+ AD=0.174 PS=1.78 PD=1.78
M$214 Vdd \$71 Vom Vdd sky130_fd_pr__pfet_01v8_lvt L=1 W=1 AS=0.29 AD=0.145
+ PS=2.58 PD=1.29
M$215 Vom \$71 Vdd Vdd sky130_fd_pr__pfet_01v8_lvt L=1 W=1 AS=0.145 AD=0.29
+ PS=1.29 PD=2.58
M$216 Vdd \$71 Vom Vdd sky130_fd_pr__pfet_01v8_lvt L=1 W=1 AS=0.29 AD=0.145
+ PS=2.58 PD=1.29
M$217 Vom \$71 Vdd Vdd sky130_fd_pr__pfet_01v8_lvt L=1 W=1 AS=0.145 AD=0.29
+ PS=1.29 PD=2.58
M$218 Vdd \$71 Vom Vdd sky130_fd_pr__pfet_01v8_lvt L=1 W=1 AS=0.29 AD=0.145
+ PS=2.58 PD=1.29
M$219 Vom \$71 Vdd Vdd sky130_fd_pr__pfet_01v8_lvt L=1 W=1 AS=0.145 AD=0.29
+ PS=1.29 PD=2.58
M$220 Vdd \$71 Vom Vdd sky130_fd_pr__pfet_01v8_lvt L=1 W=1 AS=0.29 AD=0.145
+ PS=2.58 PD=1.29
M$221 Vom \$71 Vdd Vdd sky130_fd_pr__pfet_01v8_lvt L=1 W=1 AS=0.145 AD=0.29
+ PS=1.29 PD=2.58
M$222 Vdd \$71 Vom Vdd sky130_fd_pr__pfet_01v8_lvt L=1 W=1 AS=0.29 AD=0.145
+ PS=2.58 PD=1.29
M$223 Vom \$71 Vdd Vdd sky130_fd_pr__pfet_01v8_lvt L=1 W=1 AS=0.145 AD=0.29
+ PS=1.29 PD=2.58
M$224 Vdd \$71 Vom Vdd sky130_fd_pr__pfet_01v8_lvt L=1 W=1 AS=0.29 AD=0.145
+ PS=2.58 PD=1.29
M$225 Vom \$71 Vdd Vdd sky130_fd_pr__pfet_01v8_lvt L=1 W=1 AS=0.145 AD=0.29
+ PS=1.29 PD=2.58
M$226 Vdd \$71 Vom Vdd sky130_fd_pr__pfet_01v8_lvt L=1 W=1 AS=0.29 AD=0.145
+ PS=2.58 PD=1.29
M$227 Vom \$71 Vdd Vdd sky130_fd_pr__pfet_01v8_lvt L=1 W=1 AS=0.145 AD=0.29
+ PS=1.29 PD=2.58
M$228 Vdd \$71 Vom Vdd sky130_fd_pr__pfet_01v8_lvt L=1 W=1 AS=0.29 AD=0.145
+ PS=2.58 PD=1.29
M$229 Vom \$71 Vdd Vdd sky130_fd_pr__pfet_01v8_lvt L=1 W=1 AS=0.145 AD=0.29
+ PS=1.29 PD=2.58
M$230 Vdd \$71 Vom Vdd sky130_fd_pr__pfet_01v8_lvt L=1 W=1 AS=0.29 AD=0.145
+ PS=2.58 PD=1.29
M$231 Vom \$71 Vdd Vdd sky130_fd_pr__pfet_01v8_lvt L=1 W=1 AS=0.145 AD=0.29
+ PS=1.29 PD=2.58
M$232 Vdd \$69 Vop Vdd sky130_fd_pr__pfet_01v8_lvt L=1 W=1 AS=0.29 AD=0.145
+ PS=2.58 PD=1.29
M$233 Vop \$69 Vdd Vdd sky130_fd_pr__pfet_01v8_lvt L=1 W=1 AS=0.145 AD=0.29
+ PS=1.29 PD=2.58
M$234 Vdd \$69 Vop Vdd sky130_fd_pr__pfet_01v8_lvt L=1 W=1 AS=0.29 AD=0.145
+ PS=2.58 PD=1.29
M$235 Vop \$69 Vdd Vdd sky130_fd_pr__pfet_01v8_lvt L=1 W=1 AS=0.145 AD=0.29
+ PS=1.29 PD=2.58
M$236 Vdd \$69 Vop Vdd sky130_fd_pr__pfet_01v8_lvt L=1 W=1 AS=0.29 AD=0.145
+ PS=2.58 PD=1.29
M$237 Vop \$69 Vdd Vdd sky130_fd_pr__pfet_01v8_lvt L=1 W=1 AS=0.145 AD=0.29
+ PS=1.29 PD=2.58
M$238 Vdd \$69 Vop Vdd sky130_fd_pr__pfet_01v8_lvt L=1 W=1 AS=0.29 AD=0.145
+ PS=2.58 PD=1.29
M$239 Vop \$69 Vdd Vdd sky130_fd_pr__pfet_01v8_lvt L=1 W=1 AS=0.145 AD=0.29
+ PS=1.29 PD=2.58
M$240 Vdd \$69 Vop Vdd sky130_fd_pr__pfet_01v8_lvt L=1 W=1 AS=0.29 AD=0.145
+ PS=2.58 PD=1.29
M$241 Vop \$69 Vdd Vdd sky130_fd_pr__pfet_01v8_lvt L=1 W=1 AS=0.145 AD=0.29
+ PS=1.29 PD=2.58
M$242 Vdd \$69 Vop Vdd sky130_fd_pr__pfet_01v8_lvt L=1 W=1 AS=0.29 AD=0.145
+ PS=2.58 PD=1.29
M$243 Vop \$69 Vdd Vdd sky130_fd_pr__pfet_01v8_lvt L=1 W=1 AS=0.145 AD=0.29
+ PS=1.29 PD=2.58
M$244 Vdd \$69 Vop Vdd sky130_fd_pr__pfet_01v8_lvt L=1 W=1 AS=0.29 AD=0.145
+ PS=2.58 PD=1.29
M$245 Vop \$69 Vdd Vdd sky130_fd_pr__pfet_01v8_lvt L=1 W=1 AS=0.145 AD=0.29
+ PS=1.29 PD=2.58
M$246 Vdd \$69 Vop Vdd sky130_fd_pr__pfet_01v8_lvt L=1 W=1 AS=0.29 AD=0.145
+ PS=2.58 PD=1.29
M$247 Vop \$69 Vdd Vdd sky130_fd_pr__pfet_01v8_lvt L=1 W=1 AS=0.145 AD=0.29
+ PS=1.29 PD=2.58
M$248 Vdd \$69 Vop Vdd sky130_fd_pr__pfet_01v8_lvt L=1 W=1 AS=0.29 AD=0.145
+ PS=2.58 PD=1.29
M$249 Vop \$69 Vdd Vdd sky130_fd_pr__pfet_01v8_lvt L=1 W=1 AS=0.145 AD=0.29
+ PS=1.29 PD=2.58
M$250 \$92 \$35 Vdd Vdd sky130_fd_pr__pfet_01v8_lvt L=5 W=1 AS=0.29 AD=0.29
+ PS=2.58 PD=2.58
M$251 Vdd Vdd Vdd Vdd sky130_fd_pr__pfet_01v8_lvt L=5 W=1 AS=0.29 AD=0.29
+ PS=2.58 PD=2.58
M$252 \$92 \$35 Vdd Vdd sky130_fd_pr__pfet_01v8_lvt L=5 W=1 AS=0.29 AD=0.29
+ PS=2.58 PD=2.58
M$253 Vdd Vdd Vdd Vdd sky130_fd_pr__pfet_01v8_lvt L=1 W=6 AS=1.74 AD=1.74
+ PS=12.58 PD=12.58
M$254 \$35 \$35 Vdd Vdd sky130_fd_pr__pfet_01v8_lvt L=1 W=6 AS=1.74 AD=1.74
+ PS=12.58 PD=12.58
M$255 \$35 \$35 Vdd Vdd sky130_fd_pr__pfet_01v8_lvt L=1 W=6 AS=1.74 AD=1.74
+ PS=12.58 PD=12.58
M$256 Vdd Vdd Vdd Vdd sky130_fd_pr__pfet_01v8_lvt L=10 W=1 AS=0.29 AD=0.29
+ PS=2.58 PD=2.58
M$257 Vdd Vdd Vdd Vdd sky130_fd_pr__pfet_01v8_lvt L=10 W=1 AS=0.29 AD=0.29
+ PS=2.58 PD=2.58
M$258 \$282 \$282 Vdd Vdd sky130_fd_pr__pfet_01v8_lvt L=10 W=1 AS=0.29 AD=0.29
+ PS=2.58 PD=2.58
M$259 \$292 \$282 Vdd Vdd sky130_fd_pr__pfet_01v8_lvt L=10 W=1 AS=0.29 AD=0.29
+ PS=2.58 PD=2.58
M$260 \$282 \$282 Vdd Vdd sky130_fd_pr__pfet_01v8_lvt L=10 W=1 AS=0.29 AD=0.29
+ PS=2.58 PD=2.58
M$261 \$292 \$282 Vdd Vdd sky130_fd_pr__pfet_01v8_lvt L=10 W=1 AS=0.29 AD=0.29
+ PS=2.58 PD=2.58
M$262 Vdd Vdd Vdd Vdd sky130_fd_pr__pfet_01v8_lvt L=10 W=1 AS=0.29 AD=0.29
+ PS=2.58 PD=2.58
M$263 \$10 \$96 \$92 Vdd sky130_fd_pr__pfet_01v8_lvt L=10 W=1 AS=0.29 AD=0.29
+ PS=2.58 PD=2.58
M$264 \$11 VREF \$92 Vdd sky130_fd_pr__pfet_01v8_lvt L=10 W=1 AS=0.29 AD=0.29
+ PS=2.58 PD=2.58
M$265 \$11 VREF \$92 Vdd sky130_fd_pr__pfet_01v8_lvt L=10 W=1 AS=0.29 AD=0.29
+ PS=2.58 PD=2.58
M$266 \$10 \$96 \$92 Vdd sky130_fd_pr__pfet_01v8_lvt L=10 W=1 AS=0.29 AD=0.29
+ PS=2.58 PD=2.58
M$267 Vdd Vdd Vdd Vdd sky130_fd_pr__pfet_01v8_lvt L=10 W=1 AS=0.29 AD=0.29
+ PS=2.58 PD=2.58
.ENDS ttsky25a_fd_routed
