* Extracted by KLayout with SKY130 LVS runset on : 04/11/2026 12:34

.SUBCKT ttsky25a_fd_routed \$1.x2_x1_net1 \$1.x2_x1_net10 \$1.x2_x1_net11
+ \$1.x2_x1_net12 \$1.x2_x1_net13 \$1.x2_x1_net14 \$1.x2_x1_net15
+ \$1.x2_x1_net16 \$1.x2_x1_net17 \$1.x2_x1_net18 \$1.x2_x1_net19
+ \$1.x2_x1_net2 \$1.x2_x1_net3 \$1.x2_x1_net4 \$1.x2_x1_net5 \$1.x2_x1_net6
+ \$1.x2_x1_net7 \$1.x2_x1_net8 \$1.x2_x1_net9 \$1.x2_x2_net1 \$1.x2_x2_net10
+ \$1.x2_x2_net11 \$1.x2_x2_net12 \$1.x2_x2_net13 \$1.x2_x2_net14
+ \$1.x2_x2_net15 \$1.x2_x2_net16 \$1.x2_x2_net17 \$1.x2_x2_net18
+ \$1.x2_x2_net19 \$1.x2_x2_net2 \$1.x2_x2_net3 \$1.x2_x2_net4 \$1.x2_x2_net5
+ \$1.x2_x2_net6 \$1.x2_x2_net7 \$1.x2_x2_net8 \$1.x2_x2_net9 RGM VREF Vdd Vm
+ Vom Vop Vp Vss sky130_gnd
C$1 Vom \$61 sky130_fd_pr__model__cap_mim C=2e-13 A=100 P=40
C$2 Vom \$61 sky130_fd_pr__model__cap_mim C=2e-13 A=100 P=40
C$3 Vom \$61 sky130_fd_pr__model__cap_mim C=2e-13 A=100 P=40
C$4 Vom \$61 sky130_fd_pr__model__cap_mim C=2e-13 A=100 P=40
C$5 Vom \$61 sky130_fd_pr__model__cap_mim C=2e-13 A=100 P=40
C$6 Vop \$125 sky130_fd_pr__model__cap_mim C=2e-13 A=100 P=40
C$7 Vop \$125 sky130_fd_pr__model__cap_mim C=2e-13 A=100 P=40
C$8 Vop \$125 sky130_fd_pr__model__cap_mim C=2e-13 A=100 P=40
C$9 Vop \$125 sky130_fd_pr__model__cap_mim C=2e-13 A=100 P=40
C$10 Vop \$125 sky130_fd_pr__model__cap_mim C=2e-13 A=100 P=40
R$11 Vom \$1.x2_x2_net16 sky130_fd_pr__res_generic_po R=3856 L=40 W=0.5 A=20
+ P=81
R$12 \$3 \$1.x2_x2_net4 sky130_fd_pr__res_generic_po R=3856 L=40 W=0.5 A=20 P=81
R$13 \$3 \$1.x2_x1_net16 sky130_fd_pr__res_generic_po R=3856 L=40 W=0.5 A=20
+ P=81
R$14 Vop \$1.x2_x1_net4 sky130_fd_pr__res_generic_po R=3856 L=40 W=0.5 A=20 P=81
R$15 Vss Vss sky130_fd_pr__res_generic_po R=3856 L=40 W=0.5 A=20 P=81
R$16 Vss Vss sky130_fd_pr__res_generic_po R=3856 L=40 W=0.5 A=20 P=81
R$17 \$1.x2_x2_net5 \$1.x2_x2_net6 sky130_fd_pr__res_generic_po R=3856 L=40
+ W=0.5 A=20 P=81
R$18 \$1.x2_x2_net5 \$1.x2_x2_net4 sky130_fd_pr__res_generic_po R=3856 L=40
+ W=0.5 A=20 P=81
R$19 \$1.x2_x1_net5 \$1.x2_x1_net6 sky130_fd_pr__res_generic_po R=3856 L=40
+ W=0.5 A=20 P=81
R$20 \$1.x2_x1_net5 \$1.x2_x1_net4 sky130_fd_pr__res_generic_po R=3856 L=40
+ W=0.5 A=20 P=81
R$21 \$1.x2_x2_net7 \$1.x2_x2_net1 sky130_fd_pr__res_generic_po R=3856 L=40
+ W=0.5 A=20 P=81
R$22 \$1.x2_x2_net7 \$1.x2_x2_net6 sky130_fd_pr__res_generic_po R=3856 L=40
+ W=0.5 A=20 P=81
R$23 \$1.x2_x1_net7 \$1.x2_x1_net1 sky130_fd_pr__res_generic_po R=3856 L=40
+ W=0.5 A=20 P=81
R$24 \$1.x2_x1_net7 \$1.x2_x1_net6 sky130_fd_pr__res_generic_po R=3856 L=40
+ W=0.5 A=20 P=81
R$25 \$1.x2_x2_net11 \$1.x2_x2_net10 sky130_fd_pr__res_generic_po R=3856 L=40
+ W=0.5 A=20 P=81
R$26 \$1.x2_x2_net11 \$1.x2_x2_net1 sky130_fd_pr__res_generic_po R=3856 L=40
+ W=0.5 A=20 P=81
R$27 \$1.x2_x1_net11 \$1.x2_x1_net10 sky130_fd_pr__res_generic_po R=3856 L=40
+ W=0.5 A=20 P=81
R$28 \$1.x2_x1_net11 \$1.x2_x1_net1 sky130_fd_pr__res_generic_po R=3856 L=40
+ W=0.5 A=20 P=81
R$29 \$1.x2_x2_net9 \$1.x2_x2_net8 sky130_fd_pr__res_generic_po R=3856 L=40
+ W=0.5 A=20 P=81
R$30 \$1.x2_x2_net9 \$1.x2_x2_net10 sky130_fd_pr__res_generic_po R=3856 L=40
+ W=0.5 A=20 P=81
R$31 \$1.x2_x1_net9 \$1.x2_x1_net8 sky130_fd_pr__res_generic_po R=3856 L=40
+ W=0.5 A=20 P=81
R$32 \$1.x2_x1_net9 \$1.x2_x1_net10 sky130_fd_pr__res_generic_po R=3856 L=40
+ W=0.5 A=20 P=81
R$33 \$1.x2_x2_net2 \$1.x2_x2_net8 sky130_fd_pr__res_generic_po R=3856 L=40
+ W=0.5 A=20 P=81
R$34 \$1.x2_x2_net2 \$1.x2_x2_net12 sky130_fd_pr__res_generic_po R=3856 L=40
+ W=0.5 A=20 P=81
R$35 \$1.x2_x1_net2 \$1.x2_x1_net8 sky130_fd_pr__res_generic_po R=3856 L=40
+ W=0.5 A=20 P=81
R$36 \$1.x2_x1_net2 \$1.x2_x1_net12 sky130_fd_pr__res_generic_po R=3856 L=40
+ W=0.5 A=20 P=81
R$37 \$1.x2_x2_net13 \$1.x2_x2_net14 sky130_fd_pr__res_generic_po R=3856 L=40
+ W=0.5 A=20 P=81
R$38 \$1.x2_x2_net13 \$1.x2_x2_net12 sky130_fd_pr__res_generic_po R=3856 L=40
+ W=0.5 A=20 P=81
R$39 \$1.x2_x1_net13 \$1.x2_x1_net14 sky130_fd_pr__res_generic_po R=3856 L=40
+ W=0.5 A=20 P=81
R$40 \$1.x2_x1_net13 \$1.x2_x1_net12 sky130_fd_pr__res_generic_po R=3856 L=40
+ W=0.5 A=20 P=81
R$41 \$1.x2_x2_net15 \$1.x2_x2_net3 sky130_fd_pr__res_generic_po R=3856 L=40
+ W=0.5 A=20 P=81
R$42 \$1.x2_x2_net15 \$1.x2_x2_net14 sky130_fd_pr__res_generic_po R=3856 L=40
+ W=0.5 A=20 P=81
R$43 \$1.x2_x1_net15 \$1.x2_x1_net3 sky130_fd_pr__res_generic_po R=3856 L=40
+ W=0.5 A=20 P=81
R$44 \$1.x2_x1_net15 \$1.x2_x1_net14 sky130_fd_pr__res_generic_po R=3856 L=40
+ W=0.5 A=20 P=81
R$45 \$1.x2_x2_net19 \$1.x2_x2_net18 sky130_fd_pr__res_generic_po R=3856 L=40
+ W=0.5 A=20 P=81
R$46 \$1.x2_x2_net19 \$1.x2_x2_net3 sky130_fd_pr__res_generic_po R=3856 L=40
+ W=0.5 A=20 P=81
R$47 \$1.x2_x1_net19 \$1.x2_x1_net18 sky130_fd_pr__res_generic_po R=3856 L=40
+ W=0.5 A=20 P=81
R$48 \$1.x2_x1_net19 \$1.x2_x1_net3 sky130_fd_pr__res_generic_po R=3856 L=40
+ W=0.5 A=20 P=81
R$49 \$1.x2_x2_net17 \$1.x2_x2_net16 sky130_fd_pr__res_generic_po R=3856 L=40
+ W=0.5 A=20 P=81
R$50 \$1.x2_x2_net17 \$1.x2_x2_net18 sky130_fd_pr__res_generic_po R=3856 L=40
+ W=0.5 A=20 P=81
R$51 \$1.x2_x1_net17 \$1.x2_x1_net16 sky130_fd_pr__res_generic_po R=3856 L=40
+ W=0.5 A=20 P=81
R$52 \$1.x2_x1_net17 \$1.x2_x1_net18 sky130_fd_pr__res_generic_po R=3856 L=40
+ W=0.5 A=20 P=81
M$53 \$451 \$451 Vdd Vdd sky130_fd_pr__pfet_01v8_lvt L=10 W=1.5 AS=0.435
+ AD=0.435 PS=3.58 PD=3.58
M$54 \$451 \$451 Vdd Vdd sky130_fd_pr__pfet_01v8_lvt L=10 W=1.5 AS=0.435
+ AD=0.435 PS=3.58 PD=3.58
M$55 Vdd Vdd Vdd Vdd sky130_fd_pr__pfet_01v8_lvt L=5 W=1 AS=0.29 AD=0.145
+ PS=2.58 PD=1.29
M$56 Vdd Vdd Vdd Vdd sky130_fd_pr__pfet_01v8_lvt L=5 W=1 AS=0.145 AD=0.29
+ PS=1.29 PD=2.58
M$57 Vdd Vdd Vdd Vdd sky130_fd_pr__pfet_01v8_lvt L=5 W=1 AS=0.29 AD=0.145
+ PS=2.58 PD=1.29
M$58 Vdd Vdd Vdd Vdd sky130_fd_pr__pfet_01v8_lvt L=5 W=1 AS=0.145 AD=0.29
+ PS=1.29 PD=2.58
M$59 Vdd \$289 \$432 Vdd sky130_fd_pr__pfet_01v8_lvt L=5 W=1 AS=0.29 AD=0.145
+ PS=2.58 PD=1.29
M$60 \$432 \$289 Vdd Vdd sky130_fd_pr__pfet_01v8_lvt L=5 W=1 AS=0.145 AD=0.29
+ PS=1.29 PD=2.58
M$61 Vdd \$289 \$441 Vdd sky130_fd_pr__pfet_01v8_lvt L=5 W=1 AS=0.29 AD=0.145
+ PS=2.58 PD=1.29
M$62 \$441 \$289 Vdd Vdd sky130_fd_pr__pfet_01v8_lvt L=5 W=1 AS=0.145 AD=0.29
+ PS=1.29 PD=2.58
M$63 Vdd \$289 \$432 Vdd sky130_fd_pr__pfet_01v8_lvt L=5 W=1 AS=0.29 AD=0.145
+ PS=2.58 PD=1.29
M$64 \$432 \$289 Vdd Vdd sky130_fd_pr__pfet_01v8_lvt L=5 W=1 AS=0.145 AD=0.29
+ PS=1.29 PD=2.58
M$65 Vdd \$289 \$441 Vdd sky130_fd_pr__pfet_01v8_lvt L=5 W=1 AS=0.29 AD=0.145
+ PS=2.58 PD=1.29
M$66 \$441 \$289 Vdd Vdd sky130_fd_pr__pfet_01v8_lvt L=5 W=1 AS=0.145 AD=0.29
+ PS=1.29 PD=2.58
M$67 Vdd \$289 \$441 Vdd sky130_fd_pr__pfet_01v8_lvt L=5 W=1 AS=0.29 AD=0.145
+ PS=2.58 PD=1.29
M$68 \$441 \$289 Vdd Vdd sky130_fd_pr__pfet_01v8_lvt L=5 W=1 AS=0.145 AD=0.29
+ PS=1.29 PD=2.58
M$69 Vdd \$289 \$432 Vdd sky130_fd_pr__pfet_01v8_lvt L=5 W=1 AS=0.29 AD=0.145
+ PS=2.58 PD=1.29
M$70 \$432 \$289 Vdd Vdd sky130_fd_pr__pfet_01v8_lvt L=5 W=1 AS=0.145 AD=0.29
+ PS=1.29 PD=2.58
M$71 Vdd \$289 \$441 Vdd sky130_fd_pr__pfet_01v8_lvt L=5 W=1 AS=0.29 AD=0.145
+ PS=2.58 PD=1.29
M$72 \$441 \$289 Vdd Vdd sky130_fd_pr__pfet_01v8_lvt L=5 W=1 AS=0.145 AD=0.29
+ PS=1.29 PD=2.58
M$73 Vdd \$289 \$432 Vdd sky130_fd_pr__pfet_01v8_lvt L=5 W=1 AS=0.29 AD=0.145
+ PS=2.58 PD=1.29
M$74 \$432 \$289 Vdd Vdd sky130_fd_pr__pfet_01v8_lvt L=5 W=1 AS=0.145 AD=0.29
+ PS=1.29 PD=2.58
M$75 Vdd Vdd Vdd Vdd sky130_fd_pr__pfet_01v8_lvt L=5 W=1 AS=0.29 AD=0.145
+ PS=2.58 PD=1.29
M$76 Vdd Vdd Vdd Vdd sky130_fd_pr__pfet_01v8_lvt L=5 W=1 AS=0.145 AD=0.29
+ PS=1.29 PD=2.58
M$77 Vdd Vdd Vdd Vdd sky130_fd_pr__pfet_01v8_lvt L=5 W=1 AS=0.29 AD=0.145
+ PS=2.58 PD=1.29
M$78 Vdd Vdd Vdd Vdd sky130_fd_pr__pfet_01v8_lvt L=5 W=1 AS=0.145 AD=0.29
+ PS=1.29 PD=2.58
M$79 \$441 \$451 \$125 Vdd sky130_fd_pr__pfet_01v8_lvt L=5 W=1 AS=0.29 AD=0.145
+ PS=2.58 PD=1.29
M$80 \$125 \$451 \$441 Vdd sky130_fd_pr__pfet_01v8_lvt L=5 W=1 AS=0.145 AD=0.29
+ PS=1.29 PD=2.58
M$81 \$432 \$451 \$61 Vdd sky130_fd_pr__pfet_01v8_lvt L=5 W=1 AS=0.29 AD=0.145
+ PS=2.58 PD=1.29
M$82 \$61 \$451 \$432 Vdd sky130_fd_pr__pfet_01v8_lvt L=5 W=1 AS=0.145 AD=0.29
+ PS=1.29 PD=2.58
M$83 \$441 \$451 \$125 Vdd sky130_fd_pr__pfet_01v8_lvt L=5 W=1 AS=0.29 AD=0.145
+ PS=2.58 PD=1.29
M$84 \$125 \$451 \$441 Vdd sky130_fd_pr__pfet_01v8_lvt L=5 W=1 AS=0.145 AD=0.29
+ PS=1.29 PD=2.58
M$85 \$432 \$451 \$61 Vdd sky130_fd_pr__pfet_01v8_lvt L=5 W=1 AS=0.29 AD=0.145
+ PS=2.58 PD=1.29
M$86 \$61 \$451 \$432 Vdd sky130_fd_pr__pfet_01v8_lvt L=5 W=1 AS=0.145 AD=0.29
+ PS=1.29 PD=2.58
M$87 \$116 \$116 Vss sky130_gnd sky130_fd_pr__nfet_01v8_lvt L=5 W=0.6 AS=0.174
+ AD=0.174 PS=1.78 PD=1.78
M$88 \$116 \$116 Vss sky130_gnd sky130_fd_pr__nfet_01v8_lvt L=5 W=0.6 AS=0.174
+ AD=0.174 PS=1.78 PD=1.78
M$89 Vss Vss Vss sky130_gnd sky130_fd_pr__nfet_01v8_lvt L=4 W=4 AS=1.16 AD=1.16
+ PS=8.58 PD=8.58
M$90 Vss Vss Vss sky130_gnd sky130_fd_pr__nfet_01v8_lvt L=4 W=4 AS=1.16 AD=1.16
+ PS=8.58 PD=8.58
M$91 \$432 Vm \$115 sky130_gnd sky130_fd_pr__nfet_01v8_lvt L=4 W=4 AS=1.16
+ AD=1.16 PS=8.58 PD=8.58
M$92 \$441 Vp \$115 sky130_gnd sky130_fd_pr__nfet_01v8_lvt L=4 W=4 AS=1.16
+ AD=1.16 PS=8.58 PD=8.58
M$93 \$441 Vp \$115 sky130_gnd sky130_fd_pr__nfet_01v8_lvt L=4 W=4 AS=1.16
+ AD=1.16 PS=8.58 PD=8.58
M$94 \$432 Vm \$115 sky130_gnd sky130_fd_pr__nfet_01v8_lvt L=4 W=4 AS=1.16
+ AD=1.16 PS=8.58 PD=8.58
M$95 \$151 \$151 Vdd Vdd sky130_fd_pr__pfet_01v8_lvt L=20 W=1 AS=0.29 AD=0.29
+ PS=2.58 PD=2.58
M$96 \$151 \$151 Vdd Vdd sky130_fd_pr__pfet_01v8_lvt L=20 W=1 AS=0.29 AD=0.29
+ PS=2.58 PD=2.58
M$97 Vdd Vdd Vdd Vdd sky130_fd_pr__pfet_01v8_lvt L=1 W=5 AS=1.45 AD=1.45
+ PS=10.58 PD=10.58
M$98 Vdd Vdd Vdd Vdd sky130_fd_pr__pfet_01v8_lvt L=1 W=5 AS=1.45 AD=1.45
+ PS=10.58 PD=10.58
M$99 \$262 \$262 Vdd Vdd sky130_fd_pr__pfet_01v8_lvt L=1 W=5 AS=1.45 AD=1.45
+ PS=10.58 PD=10.58
M$100 \$150 \$262 Vdd Vdd sky130_fd_pr__pfet_01v8_lvt L=1 W=5 AS=1.45 AD=1.45
+ PS=10.58 PD=10.58
M$101 \$262 \$262 Vdd Vdd sky130_fd_pr__pfet_01v8_lvt L=1 W=5 AS=1.45 AD=1.45
+ PS=10.58 PD=10.58
M$102 \$150 \$262 Vdd Vdd sky130_fd_pr__pfet_01v8_lvt L=1 W=5 AS=1.45 AD=1.45
+ PS=10.58 PD=10.58
M$103 Vdd Vdd Vdd Vdd sky130_fd_pr__pfet_01v8_lvt L=1 W=5 AS=1.45 AD=1.45
+ PS=10.58 PD=10.58
M$104 \$168 \$150 Vdd Vdd sky130_fd_pr__pfet_01v8_lvt L=1 W=5 AS=1.45 AD=1.45
+ PS=10.58 PD=10.58
M$105 \$223 \$150 Vdd Vdd sky130_fd_pr__pfet_01v8_lvt L=1 W=5 AS=1.45 AD=1.45
+ PS=10.58 PD=10.58
M$106 \$168 \$150 Vdd Vdd sky130_fd_pr__pfet_01v8_lvt L=1 W=5 AS=1.45 AD=1.45
+ PS=10.58 PD=10.58
M$107 \$223 \$150 Vdd Vdd sky130_fd_pr__pfet_01v8_lvt L=1 W=5 AS=1.45 AD=1.45
+ PS=10.58 PD=10.58
M$108 Vdd Vdd Vdd Vdd sky130_fd_pr__pfet_01v8_lvt L=1 W=5 AS=1.45 AD=1.45
+ PS=10.58 PD=10.58
M$109 \$278 \$150 Vdd Vdd sky130_fd_pr__pfet_01v8_lvt L=1 W=5 AS=1.45 AD=1.45
+ PS=10.58 PD=10.58
M$110 \$308 \$150 Vdd Vdd sky130_fd_pr__pfet_01v8_lvt L=1 W=5 AS=1.45 AD=1.45
+ PS=10.58 PD=10.58
M$111 Vdd Vdd Vdd Vdd sky130_fd_pr__pfet_01v8_lvt L=1 W=5 AS=1.45 AD=1.45
+ PS=10.58 PD=10.58
M$112 Vdd Vdd Vdd Vdd sky130_fd_pr__pfet_01v8_lvt L=1 W=5 AS=1.45 AD=1.45
+ PS=10.58 PD=10.58
M$113 \$308 \$150 Vdd Vdd sky130_fd_pr__pfet_01v8_lvt L=1 W=5 AS=1.45 AD=1.45
+ PS=10.58 PD=10.58
M$114 \$278 \$150 Vdd Vdd sky130_fd_pr__pfet_01v8_lvt L=1 W=5 AS=1.45 AD=1.45
+ PS=10.58 PD=10.58
M$115 Vdd Vdd Vdd Vdd sky130_fd_pr__pfet_01v8_lvt L=1 W=5 AS=1.45 AD=1.45
+ PS=10.58 PD=10.58
M$116 \$116 \$150 Vdd Vdd sky130_fd_pr__pfet_01v8_lvt L=1 W=5 AS=1.45 AD=1.45
+ PS=10.58 PD=10.58
M$117 \$169 \$150 Vdd Vdd sky130_fd_pr__pfet_01v8_lvt L=1 W=5 AS=1.45 AD=1.45
+ PS=10.58 PD=10.58
M$118 \$116 \$150 Vdd Vdd sky130_fd_pr__pfet_01v8_lvt L=1 W=5 AS=1.45 AD=1.45
+ PS=10.58 PD=10.58
M$119 \$169 \$150 Vdd Vdd sky130_fd_pr__pfet_01v8_lvt L=1 W=5 AS=1.45 AD=1.45
+ PS=10.58 PD=10.58
M$120 Vdd Vdd Vdd Vdd sky130_fd_pr__pfet_01v8_lvt L=1 W=5 AS=1.45 AD=1.45
+ PS=10.58 PD=10.58
M$121 \$288 \$169 Vss sky130_gnd sky130_fd_pr__nfet_01v8_lvt L=20 W=1 AS=0.29
+ AD=0.29 PS=2.58 PD=2.58
M$122 \$288 \$169 Vss sky130_gnd sky130_fd_pr__nfet_01v8_lvt L=20 W=1 AS=0.29
+ AD=0.29 PS=2.58 PD=2.58
M$123 \$343 \$169 Vss sky130_gnd sky130_fd_pr__nfet_01v8_lvt L=20 W=1 AS=0.29
+ AD=0.29 PS=2.58 PD=2.58
M$124 \$343 \$169 Vss sky130_gnd sky130_fd_pr__nfet_01v8_lvt L=20 W=1 AS=0.29
+ AD=0.29 PS=2.58 PD=2.58
M$125 Vss Vss Vss sky130_gnd sky130_fd_pr__nfet_01v8_lvt L=20 W=1 AS=0.29
+ AD=0.29 PS=2.58 PD=2.58
M$126 Vss Vss Vss sky130_gnd sky130_fd_pr__nfet_01v8_lvt L=20 W=1 AS=0.29
+ AD=0.29 PS=2.58 PD=2.58
M$127 Vss Vss Vss sky130_gnd sky130_fd_pr__nfet_01v8_lvt L=20 W=5 AS=1.45
+ AD=1.45 PS=10.58 PD=10.58
M$128 Vss Vss Vss sky130_gnd sky130_fd_pr__nfet_01v8_lvt L=20 W=5 AS=1.45
+ AD=1.45 PS=10.58 PD=10.58
M$129 \$279 \$61 \$343 sky130_gnd sky130_fd_pr__nfet_01v8_lvt L=20 W=5 AS=1.45
+ AD=1.45 PS=10.58 PD=10.58
M$130 \$279 \$61 \$343 sky130_gnd sky130_fd_pr__nfet_01v8_lvt L=20 W=5 AS=1.45
+ AD=1.45 PS=10.58 PD=10.58
M$131 \$289 VREF \$343 sky130_gnd sky130_fd_pr__nfet_01v8_lvt L=20 W=5 AS=1.45
+ AD=1.45 PS=10.58 PD=10.58
M$132 \$289 VREF \$343 sky130_gnd sky130_fd_pr__nfet_01v8_lvt L=20 W=5 AS=1.45
+ AD=1.45 PS=10.58 PD=10.58
M$133 Vss Vss Vss sky130_gnd sky130_fd_pr__nfet_01v8_lvt L=20 W=5 AS=1.45
+ AD=1.45 PS=10.58 PD=10.58
M$134 Vss Vss Vss sky130_gnd sky130_fd_pr__nfet_01v8_lvt L=20 W=5 AS=1.45
+ AD=1.45 PS=10.58 PD=10.58
M$135 \$289 VREF \$288 sky130_gnd sky130_fd_pr__nfet_01v8_lvt L=20 W=5 AS=1.45
+ AD=1.45 PS=10.58 PD=10.58
M$136 \$289 VREF \$288 sky130_gnd sky130_fd_pr__nfet_01v8_lvt L=20 W=5 AS=1.45
+ AD=1.45 PS=10.58 PD=10.58
M$137 \$279 \$125 \$288 sky130_gnd sky130_fd_pr__nfet_01v8_lvt L=20 W=5 AS=1.45
+ AD=1.45 PS=10.58 PD=10.58
M$138 \$279 \$125 \$288 sky130_gnd sky130_fd_pr__nfet_01v8_lvt L=20 W=5 AS=1.45
+ AD=1.45 PS=10.58 PD=10.58
M$139 \$223 \$223 RGM sky130_gnd sky130_fd_pr__nfet_01v8_lvt L=1 W=10 AS=2.9
+ AD=2.9 PS=20.58 PD=20.58
M$140 \$223 \$223 RGM sky130_gnd sky130_fd_pr__nfet_01v8_lvt L=1 W=10 AS=2.9
+ AD=2.9 PS=20.58 PD=20.58
M$141 \$150 \$151 \$168 sky130_gnd sky130_fd_pr__nfet_01v8_lvt L=1 W=2 AS=0.58
+ AD=0.58 PS=4.58 PD=4.58
M$142 \$262 \$223 Vss sky130_gnd sky130_fd_pr__nfet_01v8_lvt L=2 W=5 AS=1.45
+ AD=1.45 PS=10.58 PD=10.58
M$143 \$262 \$223 Vss sky130_gnd sky130_fd_pr__nfet_01v8_lvt L=2 W=5 AS=1.45
+ AD=1.45 PS=10.58 PD=10.58
M$144 \$151 \$168 Vss sky130_gnd sky130_fd_pr__nfet_01v8_lvt L=2 W=5 AS=1.45
+ AD=1.45 PS=10.58 PD=10.58
M$145 \$151 \$168 Vss sky130_gnd sky130_fd_pr__nfet_01v8_lvt L=2 W=5 AS=1.45
+ AD=1.45 PS=10.58 PD=10.58
M$146 \$150 \$168 Vss sky130_gnd sky130_fd_pr__nfet_01v8_lvt L=2 W=5 AS=1.45
+ AD=1.45 PS=10.58 PD=10.58
M$147 \$150 \$168 Vss sky130_gnd sky130_fd_pr__nfet_01v8_lvt L=2 W=5 AS=1.45
+ AD=1.45 PS=10.58 PD=10.58
M$148 Vss Vss Vss sky130_gnd sky130_fd_pr__nfet_01v8_lvt L=2 W=5 AS=1.45
+ AD=1.45 PS=10.58 PD=10.58
M$149 Vss Vss Vss sky130_gnd sky130_fd_pr__nfet_01v8_lvt L=2 W=5 AS=1.45
+ AD=1.45 PS=10.58 PD=10.58
M$150 \$168 \$168 Vss sky130_gnd sky130_fd_pr__nfet_01v8_lvt L=2 W=5 AS=1.45
+ AD=1.45 PS=10.58 PD=10.58
M$151 \$168 \$168 Vss sky130_gnd sky130_fd_pr__nfet_01v8_lvt L=2 W=5 AS=1.45
+ AD=1.45 PS=10.58 PD=10.58
M$152 \$169 \$169 Vss sky130_gnd sky130_fd_pr__nfet_01v8_lvt L=2 W=1 AS=0.29
+ AD=0.29 PS=2.58 PD=2.58
M$153 \$169 \$169 Vss sky130_gnd sky130_fd_pr__nfet_01v8_lvt L=2 W=1 AS=0.29
+ AD=0.29 PS=2.58 PD=2.58
M$154 \$114 \$169 Vss sky130_gnd sky130_fd_pr__nfet_01v8_lvt L=10 W=1 AS=0.29
+ AD=0.29 PS=2.58 PD=2.58
M$155 \$114 \$169 Vss sky130_gnd sky130_fd_pr__nfet_01v8_lvt L=10 W=1 AS=0.29
+ AD=0.29 PS=2.58 PD=2.58
M$156 \$144 \$169 Vss sky130_gnd sky130_fd_pr__nfet_01v8_lvt L=10 W=1 AS=0.29
+ AD=0.29 PS=2.58 PD=2.58
M$157 \$144 \$169 Vss sky130_gnd sky130_fd_pr__nfet_01v8_lvt L=10 W=1 AS=0.29
+ AD=0.29 PS=2.58 PD=2.58
M$158 \$152 \$169 Vss sky130_gnd sky130_fd_pr__nfet_01v8_lvt L=10 W=1 AS=0.29
+ AD=0.29 PS=2.58 PD=2.58
M$159 \$124 \$169 Vss sky130_gnd sky130_fd_pr__nfet_01v8_lvt L=10 W=1 AS=0.29
+ AD=0.29 PS=2.58 PD=2.58
M$160 \$152 \$169 Vss sky130_gnd sky130_fd_pr__nfet_01v8_lvt L=10 W=1 AS=0.29
+ AD=0.29 PS=2.58 PD=2.58
M$161 \$124 \$169 Vss sky130_gnd sky130_fd_pr__nfet_01v8_lvt L=10 W=1 AS=0.29
+ AD=0.29 PS=2.58 PD=2.58
M$162 Vss Vss Vss sky130_gnd sky130_fd_pr__nfet_01v8_lvt L=10 W=1 AS=0.29
+ AD=0.29 PS=2.58 PD=2.58
M$163 Vss Vss Vss sky130_gnd sky130_fd_pr__nfet_01v8_lvt L=10 W=1 AS=0.29
+ AD=0.29 PS=2.58 PD=2.58
M$164 \$14 \$14 Vss sky130_gnd sky130_fd_pr__nfet_01v8_lvt L=20 W=0.5 AS=0.145
+ AD=0.145 PS=1.58 PD=1.58
M$165 \$13 \$14 Vss sky130_gnd sky130_fd_pr__nfet_01v8_lvt L=20 W=0.5 AS=0.145
+ AD=0.145 PS=1.58 PD=1.58
M$166 \$14 \$14 Vss sky130_gnd sky130_fd_pr__nfet_01v8_lvt L=20 W=0.5 AS=0.145
+ AD=0.145 PS=1.58 PD=1.58
M$167 \$13 \$14 Vss sky130_gnd sky130_fd_pr__nfet_01v8_lvt L=20 W=0.5 AS=0.145
+ AD=0.145 PS=1.58 PD=1.58
M$168 Vss Vss Vss sky130_gnd sky130_fd_pr__nfet_01v8_lvt L=20 W=0.5 AS=0.145
+ AD=0.145 PS=1.58 PD=1.58
M$169 Vss Vss Vss sky130_gnd sky130_fd_pr__nfet_01v8_lvt L=20 W=0.5 AS=0.145
+ AD=0.145 PS=1.58 PD=1.58
M$170 Vss Vss Vss sky130_gnd sky130_fd_pr__nfet_01v8_lvt L=1 W=0.6 AS=0.174
+ AD=0.174 PS=1.78 PD=1.78
M$171 Vss Vss Vss sky130_gnd sky130_fd_pr__nfet_01v8_lvt L=1 W=0.6 AS=0.174
+ AD=0.174 PS=1.78 PD=1.78
M$172 \$451 \$308 Vss sky130_gnd sky130_fd_pr__nfet_01v8_lvt L=1 W=0.6 AS=0.174
+ AD=0.174 PS=1.78 PD=1.78
M$173 \$308 \$308 Vss sky130_gnd sky130_fd_pr__nfet_01v8_lvt L=1 W=0.6 AS=0.174
+ AD=0.174 PS=1.78 PD=1.78
M$174 \$308 \$308 Vss sky130_gnd sky130_fd_pr__nfet_01v8_lvt L=1 W=0.6 AS=0.174
+ AD=0.174 PS=1.78 PD=1.78
M$175 \$451 \$308 Vss sky130_gnd sky130_fd_pr__nfet_01v8_lvt L=1 W=0.6 AS=0.174
+ AD=0.174 PS=1.78 PD=1.78
M$176 Vss Vss Vss sky130_gnd sky130_fd_pr__nfet_01v8_lvt L=1 W=0.6 AS=0.174
+ AD=0.174 PS=1.78 PD=1.78
M$177 Vss Vss Vss sky130_gnd sky130_fd_pr__nfet_01v8_lvt L=1 W=0.6 AS=0.174
+ AD=0.174 PS=1.78 PD=1.78
M$178 \$55 \$278 Vss sky130_gnd sky130_fd_pr__nfet_01v8_lvt L=1 W=0.6 AS=0.174
+ AD=0.174 PS=1.78 PD=1.78
M$179 \$278 \$278 Vss sky130_gnd sky130_fd_pr__nfet_01v8_lvt L=1 W=0.6 AS=0.174
+ AD=0.174 PS=1.78 PD=1.78
M$180 \$55 \$278 Vss sky130_gnd sky130_fd_pr__nfet_01v8_lvt L=1 W=0.6 AS=0.174
+ AD=0.174 PS=1.78 PD=1.78
M$181 \$278 \$278 Vss sky130_gnd sky130_fd_pr__nfet_01v8_lvt L=1 W=0.6 AS=0.174
+ AD=0.174 PS=1.78 PD=1.78
M$182 \$61 \$116 \$144 sky130_gnd sky130_fd_pr__nfet_01v8_lvt L=1 W=1 AS=0.29
+ AD=0.29 PS=2.58 PD=2.58
M$183 \$61 \$116 \$144 sky130_gnd sky130_fd_pr__nfet_01v8_lvt L=1 W=1 AS=0.29
+ AD=0.29 PS=2.58 PD=2.58
M$184 \$115 \$116 \$152 sky130_gnd sky130_fd_pr__nfet_01v8_lvt L=1 W=1 AS=0.29
+ AD=0.29 PS=2.58 PD=2.58
M$185 \$115 \$116 \$152 sky130_gnd sky130_fd_pr__nfet_01v8_lvt L=1 W=1 AS=0.29
+ AD=0.29 PS=2.58 PD=2.58
M$186 Vss Vss Vss sky130_gnd sky130_fd_pr__nfet_01v8_lvt L=1 W=1 AS=0.29
+ AD=0.29 PS=2.58 PD=2.58
M$187 Vss Vss Vss sky130_gnd sky130_fd_pr__nfet_01v8_lvt L=1 W=1 AS=0.29
+ AD=0.29 PS=2.58 PD=2.58
M$188 \$125 \$116 \$124 sky130_gnd sky130_fd_pr__nfet_01v8_lvt L=1 W=1 AS=0.29
+ AD=0.29 PS=2.58 PD=2.58
M$189 \$125 \$116 \$124 sky130_gnd sky130_fd_pr__nfet_01v8_lvt L=1 W=1 AS=0.29
+ AD=0.29 PS=2.58 PD=2.58
M$190 \$115 \$116 \$114 sky130_gnd sky130_fd_pr__nfet_01v8_lvt L=1 W=1 AS=0.29
+ AD=0.29 PS=2.58 PD=2.58
M$191 \$115 \$116 \$114 sky130_gnd sky130_fd_pr__nfet_01v8_lvt L=1 W=1 AS=0.29
+ AD=0.29 PS=2.58 PD=2.58
M$192 Vss Vss Vss sky130_gnd sky130_fd_pr__nfet_01v8_lvt L=1 W=1 AS=0.29
+ AD=0.29 PS=2.58 PD=2.58
M$193 Vss Vss Vss sky130_gnd sky130_fd_pr__nfet_01v8_lvt L=1 W=1 AS=0.29
+ AD=0.29 PS=2.58 PD=2.58
M$194 Vop \$13 Vss sky130_gnd sky130_fd_pr__nfet_01v8_lvt L=1 W=1 AS=0.29
+ AD=0.29 PS=2.58 PD=2.58
M$195 Vop \$13 Vss sky130_gnd sky130_fd_pr__nfet_01v8_lvt L=1 W=1 AS=0.29
+ AD=0.29 PS=2.58 PD=2.58
M$196 Vop \$13 Vss sky130_gnd sky130_fd_pr__nfet_01v8_lvt L=1 W=1 AS=0.29
+ AD=0.29 PS=2.58 PD=2.58
M$197 Vop \$13 Vss sky130_gnd sky130_fd_pr__nfet_01v8_lvt L=1 W=1 AS=0.29
+ AD=0.29 PS=2.58 PD=2.58
M$198 Vop \$13 Vss sky130_gnd sky130_fd_pr__nfet_01v8_lvt L=1 W=1 AS=0.29
+ AD=0.29 PS=2.58 PD=2.58
M$199 Vop \$13 Vss sky130_gnd sky130_fd_pr__nfet_01v8_lvt L=1 W=1 AS=0.29
+ AD=0.29 PS=2.58 PD=2.58
M$200 Vop \$13 Vss sky130_gnd sky130_fd_pr__nfet_01v8_lvt L=1 W=1 AS=0.29
+ AD=0.29 PS=2.58 PD=2.58
M$201 Vop \$13 Vss sky130_gnd sky130_fd_pr__nfet_01v8_lvt L=1 W=1 AS=0.29
+ AD=0.29 PS=2.58 PD=2.58
M$202 Vop \$13 Vss sky130_gnd sky130_fd_pr__nfet_01v8_lvt L=1 W=1 AS=0.29
+ AD=0.29 PS=2.58 PD=2.58
M$203 Vss Vss Vss sky130_gnd sky130_fd_pr__nfet_01v8_lvt L=1 W=1 AS=0.29
+ AD=0.29 PS=2.58 PD=2.58
M$204 Vom \$13 Vss sky130_gnd sky130_fd_pr__nfet_01v8_lvt L=1 W=1 AS=0.29
+ AD=0.29 PS=2.58 PD=2.58
M$205 Vom \$13 Vss sky130_gnd sky130_fd_pr__nfet_01v8_lvt L=1 W=1 AS=0.29
+ AD=0.29 PS=2.58 PD=2.58
M$206 Vom \$13 Vss sky130_gnd sky130_fd_pr__nfet_01v8_lvt L=1 W=1 AS=0.29
+ AD=0.29 PS=2.58 PD=2.58
M$207 Vom \$13 Vss sky130_gnd sky130_fd_pr__nfet_01v8_lvt L=1 W=1 AS=0.29
+ AD=0.29 PS=2.58 PD=2.58
M$208 Vom \$13 Vss sky130_gnd sky130_fd_pr__nfet_01v8_lvt L=1 W=1 AS=0.29
+ AD=0.29 PS=2.58 PD=2.58
M$209 Vss Vss Vss sky130_gnd sky130_fd_pr__nfet_01v8_lvt L=1 W=1 AS=0.29
+ AD=0.29 PS=2.58 PD=2.58
M$210 Vom \$13 Vss sky130_gnd sky130_fd_pr__nfet_01v8_lvt L=1 W=1 AS=0.29
+ AD=0.29 PS=2.58 PD=2.58
M$211 Vom \$13 Vss sky130_gnd sky130_fd_pr__nfet_01v8_lvt L=1 W=1 AS=0.29
+ AD=0.29 PS=2.58 PD=2.58
M$212 Vom \$13 Vss sky130_gnd sky130_fd_pr__nfet_01v8_lvt L=1 W=1 AS=0.29
+ AD=0.29 PS=2.58 PD=2.58
M$213 Vom \$13 Vss sky130_gnd sky130_fd_pr__nfet_01v8_lvt L=1 W=1 AS=0.29
+ AD=0.29 PS=2.58 PD=2.58
M$214 \$83 \$55 Vdd Vdd sky130_fd_pr__pfet_01v8_lvt L=5 W=1 AS=0.29 AD=0.29
+ PS=2.58 PD=2.58
M$215 Vdd Vdd Vdd Vdd sky130_fd_pr__pfet_01v8_lvt L=5 W=1 AS=0.29 AD=0.29
+ PS=2.58 PD=2.58
M$216 \$83 \$55 Vdd Vdd sky130_fd_pr__pfet_01v8_lvt L=5 W=1 AS=0.29 AD=0.29
+ PS=2.58 PD=2.58
M$217 Vdd Vdd Vdd Vdd sky130_fd_pr__pfet_01v8_lvt L=1 W=6 AS=1.74 AD=1.74
+ PS=12.58 PD=12.58
M$218 \$55 \$55 Vdd Vdd sky130_fd_pr__pfet_01v8_lvt L=1 W=6 AS=1.74 AD=1.74
+ PS=12.58 PD=12.58
M$219 \$55 \$55 Vdd Vdd sky130_fd_pr__pfet_01v8_lvt L=1 W=6 AS=1.74 AD=1.74
+ PS=12.58 PD=12.58
M$220 Vdd \$61 Vom Vdd sky130_fd_pr__pfet_01v8_lvt L=1 W=1 AS=0.29 AD=0.145
+ PS=2.58 PD=1.29
M$221 Vom \$61 Vdd Vdd sky130_fd_pr__pfet_01v8_lvt L=1 W=1 AS=0.145 AD=0.29
+ PS=1.29 PD=2.58
M$222 Vdd \$61 Vom Vdd sky130_fd_pr__pfet_01v8_lvt L=1 W=1 AS=0.29 AD=0.145
+ PS=2.58 PD=1.29
M$223 Vom \$61 Vdd Vdd sky130_fd_pr__pfet_01v8_lvt L=1 W=1 AS=0.145 AD=0.29
+ PS=1.29 PD=2.58
M$224 Vdd \$61 Vom Vdd sky130_fd_pr__pfet_01v8_lvt L=1 W=1 AS=0.29 AD=0.145
+ PS=2.58 PD=1.29
M$225 Vom \$61 Vdd Vdd sky130_fd_pr__pfet_01v8_lvt L=1 W=1 AS=0.145 AD=0.29
+ PS=1.29 PD=2.58
M$226 Vdd \$61 Vom Vdd sky130_fd_pr__pfet_01v8_lvt L=1 W=1 AS=0.29 AD=0.145
+ PS=2.58 PD=1.29
M$227 Vom \$61 Vdd Vdd sky130_fd_pr__pfet_01v8_lvt L=1 W=1 AS=0.145 AD=0.29
+ PS=1.29 PD=2.58
M$228 Vdd \$61 Vom Vdd sky130_fd_pr__pfet_01v8_lvt L=1 W=1 AS=0.29 AD=0.145
+ PS=2.58 PD=1.29
M$229 Vom \$61 Vdd Vdd sky130_fd_pr__pfet_01v8_lvt L=1 W=1 AS=0.145 AD=0.29
+ PS=1.29 PD=2.58
M$230 Vdd \$61 Vom Vdd sky130_fd_pr__pfet_01v8_lvt L=1 W=1 AS=0.29 AD=0.145
+ PS=2.58 PD=1.29
M$231 Vom \$61 Vdd Vdd sky130_fd_pr__pfet_01v8_lvt L=1 W=1 AS=0.145 AD=0.29
+ PS=1.29 PD=2.58
M$232 Vdd \$61 Vom Vdd sky130_fd_pr__pfet_01v8_lvt L=1 W=1 AS=0.29 AD=0.145
+ PS=2.58 PD=1.29
M$233 Vom \$61 Vdd Vdd sky130_fd_pr__pfet_01v8_lvt L=1 W=1 AS=0.145 AD=0.29
+ PS=1.29 PD=2.58
M$234 Vdd \$61 Vom Vdd sky130_fd_pr__pfet_01v8_lvt L=1 W=1 AS=0.29 AD=0.145
+ PS=2.58 PD=1.29
M$235 Vom \$61 Vdd Vdd sky130_fd_pr__pfet_01v8_lvt L=1 W=1 AS=0.145 AD=0.29
+ PS=1.29 PD=2.58
M$236 Vdd \$61 Vom Vdd sky130_fd_pr__pfet_01v8_lvt L=1 W=1 AS=0.29 AD=0.145
+ PS=2.58 PD=1.29
M$237 Vom \$61 Vdd Vdd sky130_fd_pr__pfet_01v8_lvt L=1 W=1 AS=0.145 AD=0.29
+ PS=1.29 PD=2.58
M$238 Vdd \$125 Vop Vdd sky130_fd_pr__pfet_01v8_lvt L=1 W=1 AS=0.29 AD=0.145
+ PS=2.58 PD=1.29
M$239 Vop \$125 Vdd Vdd sky130_fd_pr__pfet_01v8_lvt L=1 W=1 AS=0.145 AD=0.29
+ PS=1.29 PD=2.58
M$240 Vdd \$125 Vop Vdd sky130_fd_pr__pfet_01v8_lvt L=1 W=1 AS=0.29 AD=0.145
+ PS=2.58 PD=1.29
M$241 Vop \$125 Vdd Vdd sky130_fd_pr__pfet_01v8_lvt L=1 W=1 AS=0.145 AD=0.29
+ PS=1.29 PD=2.58
M$242 Vdd \$125 Vop Vdd sky130_fd_pr__pfet_01v8_lvt L=1 W=1 AS=0.29 AD=0.145
+ PS=2.58 PD=1.29
M$243 Vop \$125 Vdd Vdd sky130_fd_pr__pfet_01v8_lvt L=1 W=1 AS=0.145 AD=0.29
+ PS=1.29 PD=2.58
M$244 Vdd \$125 Vop Vdd sky130_fd_pr__pfet_01v8_lvt L=1 W=1 AS=0.29 AD=0.145
+ PS=2.58 PD=1.29
M$245 Vop \$125 Vdd Vdd sky130_fd_pr__pfet_01v8_lvt L=1 W=1 AS=0.145 AD=0.29
+ PS=1.29 PD=2.58
M$246 Vdd \$125 Vop Vdd sky130_fd_pr__pfet_01v8_lvt L=1 W=1 AS=0.29 AD=0.145
+ PS=2.58 PD=1.29
M$247 Vop \$125 Vdd Vdd sky130_fd_pr__pfet_01v8_lvt L=1 W=1 AS=0.145 AD=0.29
+ PS=1.29 PD=2.58
M$248 Vdd \$125 Vop Vdd sky130_fd_pr__pfet_01v8_lvt L=1 W=1 AS=0.29 AD=0.145
+ PS=2.58 PD=1.29
M$249 Vop \$125 Vdd Vdd sky130_fd_pr__pfet_01v8_lvt L=1 W=1 AS=0.145 AD=0.29
+ PS=1.29 PD=2.58
M$250 Vdd \$125 Vop Vdd sky130_fd_pr__pfet_01v8_lvt L=1 W=1 AS=0.29 AD=0.145
+ PS=2.58 PD=1.29
M$251 Vop \$125 Vdd Vdd sky130_fd_pr__pfet_01v8_lvt L=1 W=1 AS=0.145 AD=0.29
+ PS=1.29 PD=2.58
M$252 Vdd \$125 Vop Vdd sky130_fd_pr__pfet_01v8_lvt L=1 W=1 AS=0.29 AD=0.145
+ PS=2.58 PD=1.29
M$253 Vop \$125 Vdd Vdd sky130_fd_pr__pfet_01v8_lvt L=1 W=1 AS=0.145 AD=0.29
+ PS=1.29 PD=2.58
M$254 Vdd \$125 Vop Vdd sky130_fd_pr__pfet_01v8_lvt L=1 W=1 AS=0.29 AD=0.145
+ PS=2.58 PD=1.29
M$255 Vop \$125 Vdd Vdd sky130_fd_pr__pfet_01v8_lvt L=1 W=1 AS=0.145 AD=0.29
+ PS=1.29 PD=2.58
M$256 Vdd Vdd Vdd Vdd sky130_fd_pr__pfet_01v8_lvt L=10 W=1 AS=0.29 AD=0.29
+ PS=2.58 PD=2.58
M$257 Vdd Vdd Vdd Vdd sky130_fd_pr__pfet_01v8_lvt L=10 W=1 AS=0.29 AD=0.29
+ PS=2.58 PD=2.58
M$258 \$279 \$279 Vdd Vdd sky130_fd_pr__pfet_01v8_lvt L=10 W=1 AS=0.29 AD=0.29
+ PS=2.58 PD=2.58
M$259 \$289 \$279 Vdd Vdd sky130_fd_pr__pfet_01v8_lvt L=10 W=1 AS=0.29 AD=0.29
+ PS=2.58 PD=2.58
M$260 \$279 \$279 Vdd Vdd sky130_fd_pr__pfet_01v8_lvt L=10 W=1 AS=0.29 AD=0.29
+ PS=2.58 PD=2.58
M$261 \$289 \$279 Vdd Vdd sky130_fd_pr__pfet_01v8_lvt L=10 W=1 AS=0.29 AD=0.29
+ PS=2.58 PD=2.58
M$262 Vdd Vdd Vdd Vdd sky130_fd_pr__pfet_01v8_lvt L=10 W=1 AS=0.29 AD=0.29
+ PS=2.58 PD=2.58
M$263 \$14 \$3 \$83 Vdd sky130_fd_pr__pfet_01v8_lvt L=10 W=1 AS=0.29 AD=0.29
+ PS=2.58 PD=2.58
M$264 \$13 VREF \$83 Vdd sky130_fd_pr__pfet_01v8_lvt L=10 W=1 AS=0.29 AD=0.29
+ PS=2.58 PD=2.58
M$265 \$13 VREF \$83 Vdd sky130_fd_pr__pfet_01v8_lvt L=10 W=1 AS=0.29 AD=0.29
+ PS=2.58 PD=2.58
M$266 \$14 \$3 \$83 Vdd sky130_fd_pr__pfet_01v8_lvt L=10 W=1 AS=0.29 AD=0.29
+ PS=2.58 PD=2.58
M$267 Vdd Vdd Vdd Vdd sky130_fd_pr__pfet_01v8_lvt L=10 W=1 AS=0.29 AD=0.29
+ PS=2.58 PD=2.58
.ENDS ttsky25a_fd_routed
