* NGSPICE file created from ota5t_gui_copy_routed_flat.ext - technology: sky130A

.subckt ota5t_gui_copy_routed_flat OUTP INN INP VBIAS VDD VSS pmos_current_mirror_load__AB_0.net3
+ nmos_current_mirror_bias__A_0.net1
X0 nmos_current_mirror_bias__A_0.net1 INN OUTP VSS sky130_fd_pr__nfet_01v8 ad=3.48 pd=24.58 as=3.48 ps=24.58 w=12 l=0.5
X1 VDD VDD VDD VDD sky130_fd_pr__pfet_01v8 ad=2.32 pd=16.58 as=13.92 ps=99.48 w=8 l=1
X2 nmos_current_mirror_bias__A_0.net1 VBIAS VSS VSS sky130_fd_pr__nfet_01v8 ad=3.48 pd=24.58 as=1.74 ps=12.29 w=12 l=1
X3 OUTP INN nmos_current_mirror_bias__A_0.net1 VSS sky130_fd_pr__nfet_01v8 ad=3.48 pd=24.58 as=3.48 ps=24.58 w=12 l=0.5
X4 OUTP pmos_current_mirror_load__AB_0.net3 VDD VDD sky130_fd_pr__pfet_01v8 ad=2.32 pd=16.58 as=2.32 ps=16.58 w=8 l=1
X5 VDD VDD VDD VDD sky130_fd_pr__pfet_01v8 ad=2.32 pd=16.58 as=0 ps=0 w=8 l=1
X6 pmos_current_mirror_load__AB_0.net3 INP nmos_current_mirror_bias__A_0.net1 VSS sky130_fd_pr__nfet_01v8 ad=3.48 pd=24.58 as=3.48 ps=24.58 w=12 l=0.5
X7 nmos_current_mirror_bias__A_0.net1 INP pmos_current_mirror_load__AB_0.net3 VSS sky130_fd_pr__nfet_01v8 ad=3.48 pd=24.58 as=3.48 ps=24.58 w=12 l=0.5
X8 VDD pmos_current_mirror_load__AB_0.net3 pmos_current_mirror_load__AB_0.net3 VDD sky130_fd_pr__pfet_01v8 ad=2.32 pd=16.58 as=2.32 ps=16.58 w=8 l=1
X9 VSS VSS VSS VSS sky130_fd_pr__nfet_01v8 ad=3.48 pd=24.58 as=17.4 ps=122.9 w=12 l=0.5
X10 VSS VBIAS nmos_current_mirror_bias__A_0.net1 VSS sky130_fd_pr__nfet_01v8 ad=1.74 pd=12.29 as=3.48 ps=24.58 w=12 l=1
X11 VSS VSS VSS VSS sky130_fd_pr__nfet_01v8 ad=3.48 pd=24.58 as=0 ps=0 w=12 l=0.5
.ends
