*********************************************************
*** NGSPICE file created by KLayout-PEX 0.6.8
*** -----------------------------------------------------
***     Extraction Engine: KPEX/2.5D
***     Technology: sky130a
***     Date: 2026-11-04 17:20:07
*********************************************************

.SUBCKT ota5t_gui_copy_routed INN INP OUTP VBIAS VDD VSS sky130_gnd
X$1 VDD VDD VDD VDD sky130_fd_pr__pfet_01v8 l=1 w=8 as=2.32 ad=2.32 ps=16.58
+ pd=16.58
X$2 VDD VDD VDD VDD sky130_fd_pr__pfet_01v8 l=1 w=8 as=2.32 ad=2.32 ps=16.58
+ pd=16.58
X$3 VDD \$5 OUTP VDD sky130_fd_pr__pfet_01v8 l=1 w=8 as=2.32 ad=2.32 ps=16.58
+ pd=16.58
X$4 VDD \$5 \$5 VDD sky130_fd_pr__pfet_01v8 l=1 w=8 as=2.32 ad=2.32 ps=16.58
+ pd=16.58
X$5 \$7 INP \$5 sky130_gnd sky130_fd_pr__nfet_01v8 l=0.5 w=12 as=3.48 ad=3.48
+ ps=24.58 pd=24.58
X$6 \$7 INP \$5 sky130_gnd sky130_fd_pr__nfet_01v8 l=0.5 w=12 as=3.48 ad=3.48
+ ps=24.58 pd=24.58
X$7 \$7 INN OUTP sky130_gnd sky130_fd_pr__nfet_01v8 l=0.5 w=12 as=3.48 ad=3.48
+ ps=24.58 pd=24.58
X$8 \$7 INN OUTP sky130_gnd sky130_fd_pr__nfet_01v8 l=0.5 w=12 as=3.48 ad=3.48
+ ps=24.58 pd=24.58
X$9 VSS VSS VSS sky130_gnd sky130_fd_pr__nfet_01v8 l=0.5 w=12 as=3.48 ad=3.48
+ ps=24.58 pd=24.58
X$10 VSS VSS VSS sky130_gnd sky130_fd_pr__nfet_01v8 l=0.5 w=12 as=3.48 ad=3.48
+ ps=24.58 pd=24.58
X$11 VSS VBIAS \$7 sky130_gnd sky130_fd_pr__nfet_01v8 l=1 w=12 as=3.48 ad=1.74
+ ps=24.58 pd=12.29
X$12 \$7 VBIAS VSS sky130_gnd sky130_fd_pr__nfet_01v8 l=1 w=12 as=1.74 ad=3.48
+ ps=12.29 pd=24.58
Cext_1 \$5 \$7 2.2764f
Cext_2 \$5 INN 8.31547a
Cext_3 \$5 INP 1.05048f
Cext_4 \$5 OUTP 1.73353f
Cext_5 \$5 VDD 6.40762f
Cext_6 \$5 VSS 1.78414f
Cext_7 \$5 sky130_gnd 2.39161f
Cext_8 \$7 INN 1.12836f
Cext_9 \$7 INP 1.08038f
Cext_10 \$7 OUTP 3.08484f
Cext_11 \$7 VBIAS 1.72194f
Cext_12 \$7 VDD 10.0844a
Cext_13 \$7 VSS 2.44904f
Cext_14 \$7 sky130_gnd 4.20235f
Cext_15 INN INP 986.214a
Cext_16 INN OUTP 1.0491f
Cext_17 INN VBIAS 6.2297a
Cext_18 INN VSS 295.285a
Cext_19 INN sky130_gnd 1.53531f
Cext_20 INP OUTP 26.797a
Cext_21 INP VSS 1.15947f
Cext_22 INP sky130_gnd 900.999a
Cext_23 OUTP VDD 1.64067f
Cext_24 OUTP VSS 674.299a
Cext_25 OUTP sky130_gnd 2.01531f
Cext_26 VBIAS VSS 2.46233f
Cext_27 VBIAS sky130_gnd 1.20462f
Cext_28 VDD VSS 113.314a
Cext_29 VDD sky130_gnd 2.4472f
Cext_30 VSS sky130_gnd 15.0809f
.ENDS ota5t_gui_copy_routed
