* Extracted by KLayout with SKY130 LVS runset on : 04/11/2026 17:19

.SUBCKT ota5t_gui_copy_routed INN INP OUTP VBIAS VDD VSS sky130_gnd
M$1 VDD VDD VDD VDD sky130_fd_pr__pfet_01v8 L=1 W=8 AS=2.32 AD=2.32 PS=16.58
+ PD=16.58
M$2 VDD VDD VDD VDD sky130_fd_pr__pfet_01v8 L=1 W=8 AS=2.32 AD=2.32 PS=16.58
+ PD=16.58
M$3 OUTP \$5 VDD VDD sky130_fd_pr__pfet_01v8 L=1 W=8 AS=2.32 AD=2.32 PS=16.58
+ PD=16.58
M$4 \$5 \$5 VDD VDD sky130_fd_pr__pfet_01v8 L=1 W=8 AS=2.32 AD=2.32 PS=16.58
+ PD=16.58
M$5 \$5 INP \$7 sky130_gnd sky130_fd_pr__nfet_01v8 L=0.5 W=12 AS=3.48 AD=3.48
+ PS=24.58 PD=24.58
M$6 \$5 INP \$7 sky130_gnd sky130_fd_pr__nfet_01v8 L=0.5 W=12 AS=3.48 AD=3.48
+ PS=24.58 PD=24.58
M$7 OUTP INN \$7 sky130_gnd sky130_fd_pr__nfet_01v8 L=0.5 W=12 AS=3.48 AD=3.48
+ PS=24.58 PD=24.58
M$8 OUTP INN \$7 sky130_gnd sky130_fd_pr__nfet_01v8 L=0.5 W=12 AS=3.48 AD=3.48
+ PS=24.58 PD=24.58
M$9 VSS VSS VSS sky130_gnd sky130_fd_pr__nfet_01v8 L=0.5 W=12 AS=3.48 AD=3.48
+ PS=24.58 PD=24.58
M$10 VSS VSS VSS sky130_gnd sky130_fd_pr__nfet_01v8 L=0.5 W=12 AS=3.48 AD=3.48
+ PS=24.58 PD=24.58
M$11 \$7 VBIAS VSS sky130_gnd sky130_fd_pr__nfet_01v8 L=1 W=12 AS=3.48 AD=1.74
+ PS=24.58 PD=12.29
M$12 VSS VBIAS \$7 sky130_gnd sky130_fd_pr__nfet_01v8 L=1 W=12 AS=1.74 AD=3.48
+ PS=12.29 PD=24.58
.ENDS ota5t_gui_copy_routed
