* NGSPICE file created from XC4__A_flat.ext - technology: sky130A

.subckt XC4__A_flat on cmc
X0 on cmc sky130_fd_pr__cap_mim_m3_1 l=4.8 w=4.8
X1 on cmc sky130_fd_pr__cap_mim_m3_1 l=4.8 w=4.8
X2 on cmc sky130_fd_pr__cap_mim_m3_1 l=4.8 w=4.8
X3 on cmc sky130_fd_pr__cap_mim_m3_1 l=4.8 w=4.8
C0 on cmc 10.4389f
C1 cmc VSUBS 11.2502f
.ends
