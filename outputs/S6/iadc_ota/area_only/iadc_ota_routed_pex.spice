* NGSPICE file created from iadc_ota_routed_flat.ext - technology: sky130A

.subckt iadc_ota_routed_flat on op bias_a cm IBIAS VDD VSS cmc in ip nmos_dummy_9__A_0.x1_m5d
+ nmos_matched_cascode_pair_3__AB_0.x1_net2 nmos_matched_cascode_pair_3__AB_0.x1_net3
+ nmos_matched_cascode_pair_5__AB_0.x1_net5 nmos_matched_cascode_pair_5__AB_0.x1_net6
+ nmos_matched_cascode_pair_7__AB_0.x1_net8 nmos_matched_cascode_pair_7__AB_0.x1_net9
+ nmos_matched_cascode_pair_9__AB_0.x1_net11 nmos_matched_cascode_pair_9__AB_0.x1_net12
+ nmos_matched_cascode_pair_4__AB_0.x1_net4 nmos_matched_cascode_pair_6__AB_0.x1_net7
+ nmos_matched_cascode_pair_8__AB_0.x1_net10 nmos_matched_cascode_pair_11__AB_0.x1_net14
+ nmos_matched_cascode_pair_11__AB_0.x1_net15 nmos_diode__A_0.bias_b nmos_diode__A_0.bias_c
+ nmos_matched_cascode_pair_10__AB_0.x1_net13 nmos_matched_cascode_pair_2__AB_0.x1_net1
+ nmos_single__A_0.x1_m2d nmos_single__A_0.bias_d pmos_dummy_6__A_0.x1_m21d pmos_dummy_7__A_0.x1_m25d
+ pmos_single__A_0.x1_m31d nmos_single_5__A_0.x2_tail nmos_dummy_19__A_0.x2_m3d nmos_dummy_18__A_0.x2_m4d
+ pmos_dummy_16__A_0.x2_foldn pmos_dummy_17__A_0.x2_foldp
X0 VDD nmos_diode__A_0.bias_b pmos_dummy_17__A_0.x2_foldp VDD sky130_fd_pr__pfet_01v8_lvt ad=0.406 pd=3.38 as=0.406 ps=3.38 w=1.4 l=0.6
X1 nmos_dummy_18__A_0.x2_m4d nmos_single__A_0.bias_d op VSS sky130_fd_pr__nfet_01v8 ad=0.406 pd=3.38 as=0.406 ps=3.38 w=1.4 l=0.6
X2 on nmos_single__A_0.bias_d nmos_dummy_19__A_0.x2_m3d VSS sky130_fd_pr__nfet_01v8 ad=0.406 pd=3.38 as=0.406 ps=3.38 w=1.4 l=0.6
X3 VSS cmc nmos_single_5__A_0.x2_tail VSS sky130_fd_pr__nfet_01v8 ad=0.406 pd=3.38 as=0.406 ps=3.38 w=1.4 l=0.6
X4 pmos_dummy_7__A_0.x1_m25d nmos_diode__A_0.bias_c nmos_single__A_0.x1_m2d VDD sky130_fd_pr__pfet_01v8 ad=0.406 pd=3.38 as=0.406 ps=3.38 w=1.4 l=0.6
X5 VSS cmc nmos_single_5__A_0.x2_tail VSS sky130_fd_pr__nfet_01v8 ad=0.406 pd=3.38 as=0.406 ps=3.38 w=1.4 l=0.6
X6 VDD nmos_diode__A_0.bias_b pmos_dummy_16__A_0.x2_foldn VDD sky130_fd_pr__pfet_01v8_lvt ad=0.406 pd=3.38 as=0.406 ps=3.38 w=1.4 l=0.6
X7 VSS VSS nmos_dummy_19__A_0.x2_m3d VSS sky130_fd_pr__nfet_01v8 ad=0.406 pd=3.38 as=0.406 ps=3.38 w=1.4 l=0.6
X8 nmos_diode__A_0.bias_c nmos_diode__A_0.bias_c nmos_diode__A_0.bias_c VSS sky130_fd_pr__nfet_01v8_lvt ad=0.406 pd=3.38 as=38.164 ps=317.72 w=1.4 l=0.6
X9 nmos_dummy_9__A_0.x1_m5d nmos_single__A_0.bias_d bias_a VSS sky130_fd_pr__nfet_01v8 ad=0.406 pd=3.38 as=0.406 ps=3.38 w=1.4 l=0.6
X10 VSS VSS nmos_dummy_9__A_0.x1_m5d VSS sky130_fd_pr__nfet_01v8 ad=0.406 pd=3.38 as=0.406 ps=3.38 w=1.4 l=0.6
X11 VSS VSS VSS VSS sky130_fd_pr__nfet_01v8 ad=0.406 pd=3.38 as=182.87399 ps=1.52278k w=1.4 l=0.6
X12 nmos_single__A_0.bias_d nmos_single__A_0.x1_m2d nmos_single__A_0.x1_m2d VSS sky130_fd_pr__nfet_01v8 ad=0.406 pd=3.38 as=0.406 ps=3.38 w=1.4 l=0.6
X13 pmos_dummy_6__A_0.x1_m21d nmos_diode__A_0.bias_c nmos_diode__A_0.bias_b VDD sky130_fd_pr__pfet_01v8 ad=0.406 pd=3.38 as=0.406 ps=3.38 w=1.4 l=0.6
X14 nmos_dummy_18__A_0.x2_m4d nmos_single__A_0.bias_d op VSS sky130_fd_pr__nfet_01v8 ad=0.406 pd=3.38 as=0.406 ps=3.38 w=1.4 l=0.6
X15 VSS cmc nmos_single_5__A_0.x2_tail VSS sky130_fd_pr__nfet_01v8 ad=0.406 pd=3.38 as=0.406 ps=3.38 w=1.4 l=0.6
X16 VSS bias_a nmos_single_5__A_0.x2_tail VSS sky130_fd_pr__nfet_01v8 ad=0.406 pd=3.38 as=0.406 ps=3.38 w=1.4 l=0.6
X17 nmos_diode__A_0.bias_c nmos_diode__A_0.bias_b nmos_diode__A_0.bias_b VSS sky130_fd_pr__nfet_01v8_lvt ad=0.406 pd=3.38 as=0.406 ps=3.38 w=1.4 l=0.6
X18 VSS cmc nmos_single_5__A_0.x2_tail VSS sky130_fd_pr__nfet_01v8 ad=0.406 pd=3.38 as=0.406 ps=3.38 w=1.4 l=0.6
X19 nmos_diode__A_0.bias_c nmos_diode__A_0.bias_c nmos_diode__A_0.bias_c VSS sky130_fd_pr__nfet_01v8_lvt ad=0.406 pd=3.38 as=0 ps=0 w=1.4 l=0.6
X20 VSS bias_a nmos_dummy_19__A_0.x2_m3d VSS sky130_fd_pr__nfet_01v8 ad=0.406 pd=3.38 as=0.406 ps=3.38 w=1.4 l=0.6
X21 VSS bias_a nmos_single_5__A_0.x2_tail VSS sky130_fd_pr__nfet_01v8 ad=0.406 pd=3.38 as=0.406 ps=3.38 w=1.4 l=0.6
X22 VSS IBIAS IBIAS VSS sky130_fd_pr__nfet_01v8 ad=0.406 pd=3.38 as=0.406 ps=3.38 w=1.4 l=0.6
X23 VSS bias_a nmos_single_5__A_0.x2_tail VSS sky130_fd_pr__nfet_01v8 ad=0.406 pd=3.38 as=0.406 ps=3.38 w=1.4 l=0.6
X24 nmos_dummy_9__A_0.x1_m5d nmos_single__A_0.bias_d bias_a VSS sky130_fd_pr__nfet_01v8 ad=0.406 pd=3.38 as=0.406 ps=3.38 w=1.4 l=0.6
X25 VSS bias_a nmos_dummy_18__A_0.x2_m4d VSS sky130_fd_pr__nfet_01v8 ad=0.406 pd=3.38 as=0.406 ps=3.38 w=1.4 l=0.6
X26 VSS bias_a nmos_dummy_9__A_0.x1_m5d VSS sky130_fd_pr__nfet_01v8 ad=0.406 pd=3.38 as=0.406 ps=3.38 w=1.4 l=0.6
X27 nmos_single__A_0.bias_d nmos_single__A_0.x1_m2d nmos_single__A_0.x1_m2d VSS sky130_fd_pr__nfet_01v8 ad=0.406 pd=3.38 as=0.406 ps=3.38 w=1.4 l=0.6
X28 nmos_single__A_0.bias_d nmos_single__A_0.x1_m2d nmos_single__A_0.x1_m2d VSS sky130_fd_pr__nfet_01v8 ad=0.406 pd=3.38 as=0.406 ps=3.38 w=1.4 l=0.6
X29 nmos_diode__A_0.bias_c nmos_diode__A_0.bias_b nmos_diode__A_0.bias_b VSS sky130_fd_pr__nfet_01v8_lvt ad=0.406 pd=3.38 as=0.406 ps=3.38 w=1.4 l=0.6
X30 VSS bias_a nmos_dummy_9__A_0.x1_m5d VSS sky130_fd_pr__nfet_01v8 ad=0.406 pd=3.38 as=0.406 ps=3.38 w=1.4 l=0.6
X31 VSS bias_a nmos_dummy_18__A_0.x2_m4d VSS sky130_fd_pr__nfet_01v8 ad=0.406 pd=3.38 as=0.406 ps=3.38 w=1.4 l=0.6
X32 VSS bias_a nmos_single_5__A_0.x2_tail VSS sky130_fd_pr__nfet_01v8 ad=0.406 pd=3.38 as=0.406 ps=3.38 w=1.4 l=0.6
X33 pmos_dummy_6__A_0.x1_m21d pmos_dummy_6__A_0.x1_m21d pmos_dummy_6__A_0.x1_m21d VDD sky130_fd_pr__pfet_01v8 ad=0.406 pd=3.38 as=8.12 ps=67.6 w=1.4 l=0.6
X34 VDD nmos_diode__A_0.bias_b pmos_dummy_17__A_0.x2_foldp VDD sky130_fd_pr__pfet_01v8_lvt ad=0.406 pd=3.38 as=0.406 ps=3.38 w=1.4 l=0.6
X35 op nmos_single__A_0.bias_d nmos_dummy_18__A_0.x2_m4d VSS sky130_fd_pr__nfet_01v8 ad=0.406 pd=3.38 as=0.406 ps=3.38 w=1.4 l=0.6
X36 VSS bias_a nmos_single_5__A_0.x2_tail VSS sky130_fd_pr__nfet_01v8 ad=0.406 pd=3.38 as=0.406 ps=3.38 w=1.4 l=0.6
X37 VSS cmc nmos_single_5__A_0.x2_tail VSS sky130_fd_pr__nfet_01v8 ad=0.406 pd=3.38 as=0.406 ps=3.38 w=1.4 l=0.6
X38 VDD VDD VDD VDD sky130_fd_pr__pfet_01v8 ad=0.406 pd=3.38 as=52.78 ps=439.39999 w=1.4 l=0.6
X39 VDD nmos_diode__A_0.bias_b pmos_dummy_16__A_0.x2_foldn VDD sky130_fd_pr__pfet_01v8_lvt ad=0.406 pd=3.38 as=0.406 ps=3.38 w=1.4 l=0.6
X40 on nmos_single__A_0.bias_d nmos_dummy_19__A_0.x2_m3d VSS sky130_fd_pr__nfet_01v8 ad=0.406 pd=3.38 as=0.406 ps=3.38 w=1.4 l=0.6
X41 nmos_single_5__A_0.x2_tail ip pmos_dummy_17__A_0.x2_foldp VSS sky130_fd_pr__nfet_01v8_lvt ad=0.348 pd=2.98 as=0.348 ps=2.98 w=1.2 l=0.2
X42 VSS VSS VSS VSS sky130_fd_pr__nfet_01v8 ad=0.406 pd=3.38 as=0 ps=0 w=1.4 l=0.6
X43 VSS bias_a nmos_single_5__A_0.x2_tail VSS sky130_fd_pr__nfet_01v8 ad=0.406 pd=3.38 as=0.406 ps=3.38 w=1.4 l=0.6
X44 nmos_single__A_0.bias_d nmos_single__A_0.x1_m2d nmos_single__A_0.x1_m2d VSS sky130_fd_pr__nfet_01v8 ad=0.406 pd=3.38 as=0.406 ps=3.38 w=1.4 l=0.6
X45 nmos_diode__A_0.bias_c IBIAS VSS VSS sky130_fd_pr__nfet_01v8 ad=0.406 pd=3.38 as=0.406 ps=3.38 w=1.4 l=0.6
X46 pmos_dummy_17__A_0.x2_foldp nmos_diode__A_0.bias_c on VDD sky130_fd_pr__pfet_01v8 ad=0.406 pd=3.38 as=0.406 ps=3.38 w=1.4 l=0.6
X47 nmos_single__A_0.bias_d nmos_single__A_0.bias_d nmos_single__A_0.bias_d VSS sky130_fd_pr__nfet_01v8 ad=0.406 pd=3.38 as=27.608 ps=229.84 w=1.4 l=0.6
X48 nmos_matched_cascode_pair_5__AB_0.x1_net6 cm VSS VSS sky130_fd_pr__nfet_01v8 ad=0.406 pd=3.38 as=0.406 ps=3.38 w=1.4 l=0.6
X49 nmos_diode__A_0.bias_c nmos_diode__A_0.bias_b nmos_diode__A_0.bias_b VSS sky130_fd_pr__nfet_01v8_lvt ad=0.406 pd=3.38 as=0.406 ps=3.38 w=1.4 l=0.6
X50 VSS bias_a nmos_dummy_19__A_0.x2_m3d VSS sky130_fd_pr__nfet_01v8 ad=0.406 pd=3.38 as=0.406 ps=3.38 w=1.4 l=0.6
X51 VSS bias_a nmos_single_5__A_0.x2_tail VSS sky130_fd_pr__nfet_01v8 ad=0.406 pd=3.38 as=0.406 ps=3.38 w=1.4 l=0.6
X52 VSS bias_a nmos_single_5__A_0.x2_tail VSS sky130_fd_pr__nfet_01v8 ad=0.406 pd=3.38 as=0.406 ps=3.38 w=1.4 l=0.6
X53 nmos_single__A_0.bias_d nmos_single__A_0.x1_m2d nmos_single__A_0.x1_m2d VSS sky130_fd_pr__nfet_01v8 ad=0.406 pd=3.38 as=0.406 ps=3.38 w=1.4 l=0.6
X54 on nmos_single__A_0.bias_d nmos_dummy_19__A_0.x2_m3d VSS sky130_fd_pr__nfet_01v8 ad=0.406 pd=3.38 as=0.406 ps=3.38 w=1.4 l=0.6
X55 nmos_single__A_0.bias_d nmos_single__A_0.x1_m2d nmos_single__A_0.x1_m2d VSS sky130_fd_pr__nfet_01v8 ad=0.406 pd=3.38 as=0.406 ps=3.38 w=1.4 l=0.6
X56 nmos_diode__A_0.bias_c nmos_diode__A_0.bias_b nmos_diode__A_0.bias_b VSS sky130_fd_pr__nfet_01v8_lvt ad=0.406 pd=3.38 as=0.406 ps=3.38 w=1.4 l=0.6
X57 VSS cmc nmos_single_5__A_0.x2_tail VSS sky130_fd_pr__nfet_01v8 ad=0.406 pd=3.38 as=0.406 ps=3.38 w=1.4 l=0.6
X58 nmos_matched_cascode_pair_2__AB_0.x1_net1 cm cm VSS sky130_fd_pr__nfet_01v8 ad=0.406 pd=3.38 as=0.406 ps=3.38 w=1.4 l=0.6
X59 VSS cmc nmos_single_5__A_0.x2_tail VSS sky130_fd_pr__nfet_01v8 ad=0.406 pd=3.38 as=0.406 ps=3.38 w=1.4 l=0.6
X60 VSS VSS op VSS sky130_fd_pr__nfet_01v8 ad=0.406 pd=3.38 as=0.406 ps=3.38 w=1.4 l=0.6
X61 VSS bias_a nmos_dummy_19__A_0.x2_m3d VSS sky130_fd_pr__nfet_01v8 ad=0.406 pd=3.38 as=0.406 ps=3.38 w=1.4 l=0.6
X62 VSS bias_a nmos_single_5__A_0.x2_tail VSS sky130_fd_pr__nfet_01v8 ad=0.406 pd=3.38 as=0.406 ps=3.38 w=1.4 l=0.6
X63 pmos_dummy_16__A_0.x2_foldn pmos_dummy_16__A_0.x2_foldn pmos_dummy_16__A_0.x2_foldn VDD sky130_fd_pr__pfet_01v8 ad=0.406 pd=3.38 as=20.3 ps=169 w=1.4 l=0.6
X64 VSS VSS VSS VSS sky130_fd_pr__nfet_01v8 ad=0.406 pd=3.38 as=0 ps=0 w=1.4 l=0.6
X65 VSS cmc nmos_single_5__A_0.x2_tail VSS sky130_fd_pr__nfet_01v8 ad=0.406 pd=3.38 as=0.406 ps=3.38 w=1.4 l=0.6
X66 nmos_single__A_0.x1_m2d nmos_diode__A_0.bias_c pmos_dummy_7__A_0.x1_m25d VDD sky130_fd_pr__pfet_01v8 ad=0.406 pd=3.38 as=0.406 ps=3.38 w=1.4 l=0.6
X67 VSS VSS VSS VSS sky130_fd_pr__nfet_01v8 ad=0.406 pd=3.38 as=0 ps=0 w=1.4 l=0.6
X68 pmos_dummy_17__A_0.x2_foldp nmos_diode__A_0.bias_c on VDD sky130_fd_pr__pfet_01v8 ad=0.406 pd=3.38 as=0.406 ps=3.38 w=1.4 l=0.6
X69 VSS bias_a nmos_single_5__A_0.x2_tail VSS sky130_fd_pr__nfet_01v8 ad=0.406 pd=3.38 as=0.406 ps=3.38 w=1.4 l=0.6
X70 VSS cmc nmos_single_5__A_0.x2_tail VSS sky130_fd_pr__nfet_01v8 ad=0.406 pd=3.38 as=0.406 ps=3.38 w=1.4 l=0.6
X71 VSS bias_a nmos_dummy_19__A_0.x2_m3d VSS sky130_fd_pr__nfet_01v8 ad=0.406 pd=3.38 as=0.406 ps=3.38 w=1.4 l=0.6
X72 VSS bias_a nmos_single_5__A_0.x2_tail VSS sky130_fd_pr__nfet_01v8 ad=0.406 pd=3.38 as=0.406 ps=3.38 w=1.4 l=0.6
X73 VDD nmos_diode__A_0.bias_b pmos_dummy_7__A_0.x1_m25d VDD sky130_fd_pr__pfet_01v8_lvt ad=0.406 pd=3.38 as=0.406 ps=3.38 w=1.4 l=0.6
X74 VSS VSS nmos_dummy_19__A_0.x2_m3d VSS sky130_fd_pr__nfet_01v8 ad=0.406 pd=3.38 as=0.406 ps=3.38 w=1.4 l=0.6
X75 nmos_single__A_0.x1_m2d nmos_single__A_0.x1_m2d nmos_single__A_0.x1_m2d VSS sky130_fd_pr__nfet_01v8 ad=0.406 pd=3.38 as=21.924 ps=182.52 w=1.4 l=0.6
X76 VDD VDD VDD VDD sky130_fd_pr__pfet_01v8_lvt ad=0.406 pd=3.38 as=0 ps=0 w=1.4 l=0.6
X77 op nmos_single__A_0.bias_d nmos_dummy_18__A_0.x2_m4d VSS sky130_fd_pr__nfet_01v8 ad=0.406 pd=3.38 as=0.406 ps=3.38 w=1.4 l=0.6
X78 nmos_diode__A_0.bias_b nmos_diode__A_0.bias_b nmos_diode__A_0.bias_b VSS sky130_fd_pr__nfet_01v8_lvt ad=0.406 pd=3.38 as=29.232 ps=243.36 w=1.4 l=0.6
X79 VSS bias_a nmos_dummy_18__A_0.x2_m4d VSS sky130_fd_pr__nfet_01v8 ad=0.406 pd=3.38 as=0.406 ps=3.38 w=1.4 l=0.6
X80 nmos_matched_cascode_pair_10__AB_0.x1_net13 cm nmos_matched_cascode_pair_11__AB_0.x1_net14 VSS sky130_fd_pr__nfet_01v8 ad=0.406 pd=3.38 as=0.406 ps=3.38 w=1.4 l=0.6
X81 nmos_diode__A_0.bias_c nmos_diode__A_0.bias_b nmos_diode__A_0.bias_b VSS sky130_fd_pr__nfet_01v8_lvt ad=0.406 pd=3.38 as=0.406 ps=3.38 w=1.4 l=0.6
X82 pmos_dummy_16__A_0.x2_foldn pmos_dummy_16__A_0.x2_foldn pmos_dummy_16__A_0.x2_foldn VSS sky130_fd_pr__nfet_01v8_lvt ad=0.348 pd=2.98 as=3.48 ps=29.8 w=1.2 l=0.2
X83 VSS bias_a nmos_single_5__A_0.x2_tail VSS sky130_fd_pr__nfet_01v8 ad=0.406 pd=3.38 as=0.406 ps=3.38 w=1.4 l=0.6
X84 VSS cmc nmos_single_5__A_0.x2_tail VSS sky130_fd_pr__nfet_01v8 ad=0.406 pd=3.38 as=0.406 ps=3.38 w=1.4 l=0.6
X85 VSS cmc nmos_single_5__A_0.x2_tail VSS sky130_fd_pr__nfet_01v8 ad=0.406 pd=3.38 as=0.406 ps=3.38 w=1.4 l=0.6
X86 nmos_dummy_9__A_0.x1_m5d nmos_dummy_9__A_0.x1_m5d nmos_dummy_9__A_0.x1_m5d VSS sky130_fd_pr__nfet_01v8 ad=0.406 pd=3.38 as=21.924 ps=182.52 w=1.4 l=0.6
X87 nmos_dummy_9__A_0.x1_m5d nmos_single__A_0.bias_d bias_a VSS sky130_fd_pr__nfet_01v8 ad=0.406 pd=3.38 as=0.406 ps=3.38 w=1.4 l=0.6
X88 nmos_single__A_0.bias_d nmos_single__A_0.x1_m2d nmos_single__A_0.x1_m2d VSS sky130_fd_pr__nfet_01v8 ad=0.406 pd=3.38 as=0.406 ps=3.38 w=1.4 l=0.6
X89 VSS VSS on VSS sky130_fd_pr__nfet_01v8 ad=0.406 pd=3.38 as=0.406 ps=3.38 w=1.4 l=0.6
X90 VSS bias_a nmos_single_5__A_0.x2_tail VSS sky130_fd_pr__nfet_01v8 ad=0.406 pd=3.38 as=0.406 ps=3.38 w=1.4 l=0.6
X91 pmos_dummy_7__A_0.x1_m25d nmos_diode__A_0.bias_c nmos_single__A_0.x1_m2d VDD sky130_fd_pr__pfet_01v8 ad=0.406 pd=3.38 as=0.406 ps=3.38 w=1.4 l=0.6
X92 nmos_dummy_19__A_0.x2_m3d nmos_single__A_0.bias_d on VSS sky130_fd_pr__nfet_01v8 ad=0.406 pd=3.38 as=0.406 ps=3.38 w=1.4 l=0.6
X93 VSS bias_a nmos_dummy_18__A_0.x2_m4d VSS sky130_fd_pr__nfet_01v8 ad=0.406 pd=3.38 as=0.406 ps=3.38 w=1.4 l=0.6
X94 VSS VSS VSS VSS sky130_fd_pr__nfet_01v8 ad=0.406 pd=3.38 as=0 ps=0 w=1.4 l=0.6
X95 VSS IBIAS nmos_diode__A_0.bias_c VSS sky130_fd_pr__nfet_01v8 ad=0.406 pd=3.38 as=0.406 ps=3.38 w=1.4 l=0.6
X96 VSS bias_a nmos_dummy_18__A_0.x2_m4d VSS sky130_fd_pr__nfet_01v8 ad=0.406 pd=3.38 as=0.406 ps=3.38 w=1.4 l=0.6
X97 VDD nmos_diode__A_0.bias_b pmos_dummy_6__A_0.x1_m21d VDD sky130_fd_pr__pfet_01v8_lvt ad=0.406 pd=3.38 as=0.406 ps=3.38 w=1.4 l=0.6
X98 nmos_diode__A_0.bias_c nmos_diode__A_0.bias_b nmos_diode__A_0.bias_b VSS sky130_fd_pr__nfet_01v8_lvt ad=0.406 pd=3.38 as=0.406 ps=3.38 w=1.4 l=0.6
X99 nmos_dummy_19__A_0.x2_m3d nmos_single__A_0.bias_d on VSS sky130_fd_pr__nfet_01v8 ad=0.406 pd=3.38 as=0.406 ps=3.38 w=1.4 l=0.6
X100 nmos_single_5__A_0.x2_tail nmos_single_5__A_0.x2_tail nmos_single_5__A_0.x2_tail VSS sky130_fd_pr__nfet_01v8 ad=0.406 pd=3.38 as=87.812 ps=732.03998 w=1.4 l=0.6
X101 VSS cmc nmos_single_5__A_0.x2_tail VSS sky130_fd_pr__nfet_01v8 ad=0.406 pd=3.38 as=0.406 ps=3.38 w=1.4 l=0.6
X102 VDD VDD VDD VDD sky130_fd_pr__pfet_01v8 ad=0.406 pd=3.38 as=0 ps=0 w=1.4 l=0.6
X103 VSS VSS nmos_dummy_18__A_0.x2_m4d VSS sky130_fd_pr__nfet_01v8 ad=0.406 pd=3.38 as=0.406 ps=3.38 w=1.4 l=0.6
X104 pmos_dummy_16__A_0.x2_foldn nmos_diode__A_0.bias_c op VDD sky130_fd_pr__pfet_01v8 ad=0.406 pd=3.38 as=0.406 ps=3.38 w=1.4 l=0.6
X105 on nmos_single__A_0.bias_d nmos_dummy_19__A_0.x2_m3d VSS sky130_fd_pr__nfet_01v8 ad=0.406 pd=3.38 as=0.406 ps=3.38 w=1.4 l=0.6
X106 VDD nmos_diode__A_0.bias_b pmos_dummy_17__A_0.x2_foldp VDD sky130_fd_pr__pfet_01v8_lvt ad=0.406 pd=3.38 as=0.406 ps=3.38 w=1.4 l=0.6
X107 VSS cmc nmos_single_5__A_0.x2_tail VSS sky130_fd_pr__nfet_01v8 ad=0.406 pd=3.38 as=0.406 ps=3.38 w=1.4 l=0.6
X108 VSS VSS VSS VSS sky130_fd_pr__nfet_01v8 ad=0.406 pd=3.38 as=0 ps=0 w=1.4 l=0.6
X109 nmos_diode__A_0.bias_c nmos_diode__A_0.bias_c nmos_diode__A_0.bias_c VSS sky130_fd_pr__nfet_01v8_lvt ad=0.406 pd=3.38 as=0 ps=0 w=1.4 l=0.6
X110 VDD VDD pmos_dummy_17__A_0.x2_foldp VDD sky130_fd_pr__pfet_01v8 ad=0.406 pd=3.38 as=0.406 ps=3.38 w=1.4 l=0.6
X111 VDD nmos_diode__A_0.bias_b pmos_dummy_17__A_0.x2_foldp VDD sky130_fd_pr__pfet_01v8_lvt ad=0.406 pd=3.38 as=0.406 ps=3.38 w=1.4 l=0.6
X112 nmos_dummy_18__A_0.x2_m4d nmos_single__A_0.bias_d op VSS sky130_fd_pr__nfet_01v8 ad=0.406 pd=3.38 as=0.406 ps=3.38 w=1.4 l=0.6
X113 VSS VSS nmos_dummy_9__A_0.x1_m5d VSS sky130_fd_pr__nfet_01v8 ad=0.406 pd=3.38 as=0.406 ps=3.38 w=1.4 l=0.6
X114 VSS VSS VSS VSS sky130_fd_pr__nfet_01v8 ad=0.406 pd=3.38 as=0 ps=0 w=1.4 l=0.6
X115 on nmos_single__A_0.bias_d nmos_dummy_19__A_0.x2_m3d VSS sky130_fd_pr__nfet_01v8 ad=0.406 pd=3.38 as=0.406 ps=3.38 w=1.4 l=0.6
X116 VSS cmc nmos_single_5__A_0.x2_tail VSS sky130_fd_pr__nfet_01v8 ad=0.406 pd=3.38 as=0.406 ps=3.38 w=1.4 l=0.6
X117 cm cm cm VSS sky130_fd_pr__nfet_01v8 ad=0.406 pd=3.38 as=8.526 ps=70.98 w=1.4 l=0.6
X118 nmos_dummy_9__A_0.x1_m5d nmos_single__A_0.bias_d bias_a VSS sky130_fd_pr__nfet_01v8 ad=0.406 pd=3.38 as=0.406 ps=3.38 w=1.4 l=0.6
X119 nmos_diode__A_0.bias_c nmos_diode__A_0.bias_b nmos_diode__A_0.bias_b VSS sky130_fd_pr__nfet_01v8_lvt ad=0.406 pd=3.38 as=0.406 ps=3.38 w=1.4 l=0.6
X120 VDD VDD op VDD sky130_fd_pr__pfet_01v8 ad=0.406 pd=3.38 as=0.406 ps=3.38 w=1.4 l=0.6
X121 VSS VSS VSS VSS sky130_fd_pr__nfet_01v8 ad=0.406 pd=3.38 as=0 ps=0 w=1.4 l=0.6
X122 pmos_dummy_16__A_0.x2_foldn nmos_diode__A_0.bias_c op VDD sky130_fd_pr__pfet_01v8 ad=0.406 pd=3.38 as=0.406 ps=3.38 w=1.4 l=0.6
X123 VSS bias_a nmos_dummy_9__A_0.x1_m5d VSS sky130_fd_pr__nfet_01v8 ad=0.406 pd=3.38 as=0.406 ps=3.38 w=1.4 l=0.6
X124 VSS cmc nmos_single_5__A_0.x2_tail VSS sky130_fd_pr__nfet_01v8 ad=0.406 pd=3.38 as=0.406 ps=3.38 w=1.4 l=0.6
X125 nmos_single__A_0.bias_d nmos_single__A_0.x1_m2d nmos_single__A_0.x1_m2d VSS sky130_fd_pr__nfet_01v8 ad=0.406 pd=3.38 as=0.406 ps=3.38 w=1.4 l=0.6
X126 nmos_matched_cascode_pair_11__AB_0.x1_net15 cm VSS VSS sky130_fd_pr__nfet_01v8 ad=0.406 pd=3.38 as=0.406 ps=3.38 w=1.4 l=0.6
X127 nmos_diode__A_0.bias_c IBIAS VSS VSS sky130_fd_pr__nfet_01v8 ad=0.406 pd=3.38 as=0.406 ps=3.38 w=1.4 l=0.6
X128 VDD nmos_diode__A_0.bias_b pmos_dummy_17__A_0.x2_foldp VDD sky130_fd_pr__pfet_01v8_lvt ad=0.406 pd=3.38 as=0.406 ps=3.38 w=1.4 l=0.6
X129 VSS bias_a nmos_dummy_19__A_0.x2_m3d VSS sky130_fd_pr__nfet_01v8 ad=0.406 pd=3.38 as=0.406 ps=3.38 w=1.4 l=0.6
X130 on cmc sky130_fd_pr__cap_mim_m3_1 l=4.8 w=4.8
X131 nmos_matched_cascode_pair_7__AB_0.x1_net9 cm nmos_matched_cascode_pair_7__AB_0.x1_net8 VSS sky130_fd_pr__nfet_01v8 ad=0.406 pd=3.38 as=0.406 ps=3.38 w=1.4 l=0.6
X132 op op op VSS sky130_fd_pr__nfet_01v8 ad=0.406 pd=3.38 as=17.052 ps=141.96001 w=1.4 l=0.6
X133 nmos_diode__A_0.bias_c nmos_diode__A_0.bias_b nmos_diode__A_0.bias_b VSS sky130_fd_pr__nfet_01v8_lvt ad=0.406 pd=3.38 as=0.406 ps=3.38 w=1.4 l=0.6
X134 VSS cmc nmos_single_5__A_0.x2_tail VSS sky130_fd_pr__nfet_01v8 ad=0.406 pd=3.38 as=0.406 ps=3.38 w=1.4 l=0.6
X135 cm cm cm VSS sky130_fd_pr__nfet_01v8 ad=0.406 pd=3.38 as=0 ps=0 w=1.4 l=0.6
X136 VSS bias_a nmos_single_5__A_0.x2_tail VSS sky130_fd_pr__nfet_01v8 ad=0.406 pd=3.38 as=0.406 ps=3.38 w=1.4 l=0.6
X137 VSS bias_a nmos_dummy_9__A_0.x1_m5d VSS sky130_fd_pr__nfet_01v8 ad=0.406 pd=3.38 as=0.406 ps=3.38 w=1.4 l=0.6
X138 nmos_single__A_0.bias_d nmos_single__A_0.bias_d nmos_single__A_0.bias_d VSS sky130_fd_pr__nfet_01v8 ad=0.406 pd=3.38 as=0 ps=0 w=1.4 l=0.6
X139 nmos_diode__A_0.bias_b nmos_diode__A_0.bias_b nmos_diode__A_0.bias_b VSS sky130_fd_pr__nfet_01v8_lvt ad=0.406 pd=3.38 as=0 ps=0 w=1.4 l=0.6
X140 VDD VDD VDD VDD sky130_fd_pr__pfet_01v8 ad=0.406 pd=3.38 as=0 ps=0 w=1.4 l=0.6
X141 VDD VDD nmos_diode__A_0.bias_b VDD sky130_fd_pr__pfet_01v8 ad=0.406 pd=3.38 as=0.406 ps=3.38 w=1.4 l=0.6
X142 VSS bias_a nmos_single_5__A_0.x2_tail VSS sky130_fd_pr__nfet_01v8 ad=0.406 pd=3.38 as=0.406 ps=3.38 w=1.4 l=0.6
X143 nmos_dummy_19__A_0.x2_m3d nmos_single__A_0.bias_d on VSS sky130_fd_pr__nfet_01v8 ad=0.406 pd=3.38 as=0.406 ps=3.38 w=1.4 l=0.6
X144 VSS bias_a nmos_dummy_9__A_0.x1_m5d VSS sky130_fd_pr__nfet_01v8 ad=0.406 pd=3.38 as=0.406 ps=3.38 w=1.4 l=0.6
X145 VSS bias_a nmos_dummy_19__A_0.x2_m3d VSS sky130_fd_pr__nfet_01v8 ad=0.406 pd=3.38 as=0.406 ps=3.38 w=1.4 l=0.6
X146 VSS bias_a nmos_single_5__A_0.x2_tail VSS sky130_fd_pr__nfet_01v8 ad=0.406 pd=3.38 as=0.406 ps=3.38 w=1.4 l=0.6
X147 nmos_single__A_0.bias_d nmos_single__A_0.bias_d nmos_single__A_0.bias_d VSS sky130_fd_pr__nfet_01v8 ad=0.406 pd=3.38 as=0 ps=0 w=1.4 l=0.6
X148 nmos_single__A_0.bias_d nmos_single__A_0.x1_m2d nmos_single__A_0.x1_m2d VSS sky130_fd_pr__nfet_01v8 ad=0.406 pd=3.38 as=0.406 ps=3.38 w=1.4 l=0.6
X149 VDD nmos_diode__A_0.bias_b pmos_dummy_16__A_0.x2_foldn VDD sky130_fd_pr__pfet_01v8_lvt ad=0.406 pd=3.38 as=0.406 ps=3.38 w=1.4 l=0.6
X150 VSS VSS VSS VSS sky130_fd_pr__nfet_01v8 ad=0.406 pd=3.38 as=0 ps=0 w=1.4 l=0.6
X151 VDD nmos_diode__A_0.bias_b pmos_dummy_16__A_0.x2_foldn VDD sky130_fd_pr__pfet_01v8_lvt ad=0.406 pd=3.38 as=0.406 ps=3.38 w=1.4 l=0.6
X152 VSS bias_a nmos_dummy_18__A_0.x2_m4d VSS sky130_fd_pr__nfet_01v8 ad=0.406 pd=3.38 as=0.406 ps=3.38 w=1.4 l=0.6
X153 VSS bias_a nmos_dummy_9__A_0.x1_m5d VSS sky130_fd_pr__nfet_01v8 ad=0.406 pd=3.38 as=0.406 ps=3.38 w=1.4 l=0.6
X154 VSS bias_a nmos_dummy_19__A_0.x2_m3d VSS sky130_fd_pr__nfet_01v8 ad=0.406 pd=3.38 as=0.406 ps=3.38 w=1.4 l=0.6
X155 VSS cmc nmos_single_5__A_0.x2_tail VSS sky130_fd_pr__nfet_01v8 ad=0.406 pd=3.38 as=0.406 ps=3.38 w=1.4 l=0.6
X156 VSS VSS nmos_single_5__A_0.x2_tail VSS sky130_fd_pr__nfet_01v8 ad=0.406 pd=3.38 as=0.406 ps=3.38 w=1.4 l=0.6
X157 nmos_single__A_0.bias_d nmos_single__A_0.x1_m2d nmos_single__A_0.x1_m2d VSS sky130_fd_pr__nfet_01v8 ad=0.406 pd=3.38 as=0.406 ps=3.38 w=1.4 l=0.6
X158 nmos_diode__A_0.bias_c nmos_diode__A_0.bias_b nmos_diode__A_0.bias_b VSS sky130_fd_pr__nfet_01v8_lvt ad=0.406 pd=3.38 as=0.406 ps=3.38 w=1.4 l=0.6
X159 VSS VSS nmos_dummy_19__A_0.x2_m3d VSS sky130_fd_pr__nfet_01v8 ad=0.406 pd=3.38 as=0.406 ps=3.38 w=1.4 l=0.6
X160 VSS IBIAS nmos_diode__A_0.bias_c VSS sky130_fd_pr__nfet_01v8 ad=0.406 pd=3.38 as=0.406 ps=3.38 w=1.4 l=0.6
X161 pmos_dummy_6__A_0.x1_m21d nmos_diode__A_0.bias_b VDD VDD sky130_fd_pr__pfet_01v8_lvt ad=0.406 pd=3.38 as=0.406 ps=3.38 w=1.4 l=0.6
X162 VSS VSS VSS VSS sky130_fd_pr__nfet_01v8 ad=0.406 pd=3.38 as=0 ps=0 w=1.4 l=0.6
X163 pmos_dummy_16__A_0.x2_foldn nmos_diode__A_0.bias_c op VDD sky130_fd_pr__pfet_01v8 ad=0.406 pd=3.38 as=0.406 ps=3.38 w=1.4 l=0.6
X164 VSS bias_a nmos_dummy_19__A_0.x2_m3d VSS sky130_fd_pr__nfet_01v8 ad=0.406 pd=3.38 as=0.406 ps=3.38 w=1.4 l=0.6
X165 VSS cmc nmos_single_5__A_0.x2_tail VSS sky130_fd_pr__nfet_01v8 ad=0.406 pd=3.38 as=0.406 ps=3.38 w=1.4 l=0.6
X166 VSS VSS VSS VSS sky130_fd_pr__nfet_01v8 ad=0.406 pd=3.38 as=0 ps=0 w=1.4 l=0.6
X167 nmos_dummy_19__A_0.x2_m3d nmos_single__A_0.bias_d on VSS sky130_fd_pr__nfet_01v8 ad=0.406 pd=3.38 as=0.406 ps=3.38 w=1.4 l=0.6
X168 VSS bias_a nmos_dummy_19__A_0.x2_m3d VSS sky130_fd_pr__nfet_01v8 ad=0.406 pd=3.38 as=0.406 ps=3.38 w=1.4 l=0.6
X169 IBIAS IBIAS VSS VSS sky130_fd_pr__nfet_01v8 ad=0.406 pd=3.38 as=0.406 ps=3.38 w=1.4 l=0.6
X170 VSS VSS nmos_dummy_18__A_0.x2_m4d VSS sky130_fd_pr__nfet_01v8 ad=0.406 pd=3.38 as=0.406 ps=3.38 w=1.4 l=0.6
X171 nmos_single__A_0.bias_d nmos_single__A_0.x1_m2d nmos_single__A_0.x1_m2d VSS sky130_fd_pr__nfet_01v8 ad=0.406 pd=3.38 as=0.406 ps=3.38 w=1.4 l=0.6
X172 nmos_diode__A_0.bias_c nmos_diode__A_0.bias_b nmos_diode__A_0.bias_b VSS sky130_fd_pr__nfet_01v8_lvt ad=0.406 pd=3.38 as=0.406 ps=3.38 w=1.4 l=0.6
X173 VDD nmos_diode__A_0.bias_b pmos_dummy_16__A_0.x2_foldn VDD sky130_fd_pr__pfet_01v8_lvt ad=0.406 pd=3.38 as=0.406 ps=3.38 w=1.4 l=0.6
X174 VSS VSS VSS VSS sky130_fd_pr__nfet_01v8 ad=0.406 pd=3.38 as=0 ps=0 w=1.4 l=0.6
X175 VDD VDD pmos_dummy_16__A_0.x2_foldn VDD sky130_fd_pr__pfet_01v8 ad=0.406 pd=3.38 as=0.406 ps=3.38 w=1.4 l=0.6
X176 VDD VDD on VDD sky130_fd_pr__pfet_01v8 ad=0.406 pd=3.38 as=0.406 ps=3.38 w=1.4 l=0.6
X177 on nmos_single__A_0.bias_d nmos_dummy_19__A_0.x2_m3d VSS sky130_fd_pr__nfet_01v8 ad=0.406 pd=3.38 as=0.406 ps=3.38 w=1.4 l=0.6
X178 VSS VSS VSS VSS sky130_fd_pr__nfet_01v8_lvt ad=0.348 pd=2.98 as=0 ps=0 w=1.2 l=0.2
X179 VSS cmc nmos_single_5__A_0.x2_tail VSS sky130_fd_pr__nfet_01v8 ad=0.406 pd=3.38 as=0.406 ps=3.38 w=1.4 l=0.6
X180 VSS cmc nmos_single_5__A_0.x2_tail VSS sky130_fd_pr__nfet_01v8 ad=0.406 pd=3.38 as=0.406 ps=3.38 w=1.4 l=0.6
X181 VDD VDD VDD VDD sky130_fd_pr__pfet_01v8_lvt ad=0.406 pd=3.38 as=0 ps=0 w=1.4 l=0.6
X182 nmos_single__A_0.bias_d nmos_single__A_0.x1_m2d nmos_single__A_0.x1_m2d VSS sky130_fd_pr__nfet_01v8 ad=0.406 pd=3.38 as=0.406 ps=3.38 w=1.4 l=0.6
X183 pmos_dummy_17__A_0.x2_foldp nmos_diode__A_0.bias_c on VDD sky130_fd_pr__pfet_01v8 ad=0.406 pd=3.38 as=0.406 ps=3.38 w=1.4 l=0.6
X184 VSS cmc nmos_single_5__A_0.x2_tail VSS sky130_fd_pr__nfet_01v8 ad=0.406 pd=3.38 as=0.406 ps=3.38 w=1.4 l=0.6
X185 nmos_single__A_0.x1_m2d nmos_single__A_0.x1_m2d nmos_single__A_0.x1_m2d VSS sky130_fd_pr__nfet_01v8 ad=0.406 pd=3.38 as=0 ps=0 w=1.4 l=0.6
X186 nmos_diode__A_0.bias_c nmos_diode__A_0.bias_c nmos_diode__A_0.bias_c VSS sky130_fd_pr__nfet_01v8_lvt ad=0.406 pd=3.38 as=0 ps=0 w=1.4 l=0.6
X187 VDD nmos_diode__A_0.bias_b pmos_dummy_6__A_0.x1_m21d VDD sky130_fd_pr__pfet_01v8_lvt ad=0.406 pd=3.38 as=0.406 ps=3.38 w=1.4 l=0.6
X188 VSS VSS nmos_dummy_19__A_0.x2_m3d VSS sky130_fd_pr__nfet_01v8 ad=0.406 pd=3.38 as=0.406 ps=3.38 w=1.4 l=0.6
X189 op nmos_single__A_0.bias_d nmos_dummy_18__A_0.x2_m4d VSS sky130_fd_pr__nfet_01v8 ad=0.406 pd=3.38 as=0.406 ps=3.38 w=1.4 l=0.6
X190 VSS bias_a nmos_dummy_19__A_0.x2_m3d VSS sky130_fd_pr__nfet_01v8 ad=0.406 pd=3.38 as=0.406 ps=3.38 w=1.4 l=0.6
X191 VSS bias_a nmos_single_5__A_0.x2_tail VSS sky130_fd_pr__nfet_01v8 ad=0.406 pd=3.38 as=0.406 ps=3.38 w=1.4 l=0.6
X192 pmos_dummy_16__A_0.x2_foldn nmos_diode__A_0.bias_c op VDD sky130_fd_pr__pfet_01v8 ad=0.406 pd=3.38 as=0.406 ps=3.38 w=1.4 l=0.6
X193 nmos_dummy_9__A_0.x1_m5d nmos_single__A_0.bias_d bias_a VSS sky130_fd_pr__nfet_01v8 ad=0.406 pd=3.38 as=0.406 ps=3.38 w=1.4 l=0.6
X194 VSS cmc nmos_single_5__A_0.x2_tail VSS sky130_fd_pr__nfet_01v8 ad=0.406 pd=3.38 as=0.406 ps=3.38 w=1.4 l=0.6
X195 nmos_dummy_9__A_0.x1_m5d nmos_single__A_0.bias_d bias_a VSS sky130_fd_pr__nfet_01v8 ad=0.406 pd=3.38 as=0.406 ps=3.38 w=1.4 l=0.6
X196 VSS IBIAS nmos_diode__A_0.bias_c VSS sky130_fd_pr__nfet_01v8 ad=0.406 pd=3.38 as=0.406 ps=3.38 w=1.4 l=0.6
X197 VSS bias_a nmos_single_5__A_0.x2_tail VSS sky130_fd_pr__nfet_01v8 ad=0.406 pd=3.38 as=0.406 ps=3.38 w=1.4 l=0.6
X198 nmos_dummy_19__A_0.x2_m3d nmos_single__A_0.bias_d on VSS sky130_fd_pr__nfet_01v8 ad=0.406 pd=3.38 as=0.406 ps=3.38 w=1.4 l=0.6
X199 nmos_single_5__A_0.x2_tail nmos_single_5__A_0.x2_tail nmos_single_5__A_0.x2_tail VSS sky130_fd_pr__nfet_01v8 ad=0.406 pd=3.38 as=0 ps=0 w=1.4 l=0.6
X200 nmos_single__A_0.bias_d nmos_single__A_0.x1_m2d nmos_single__A_0.x1_m2d VSS sky130_fd_pr__nfet_01v8 ad=0.406 pd=3.38 as=0.406 ps=3.38 w=1.4 l=0.6
X201 op nmos_single__A_0.bias_d nmos_dummy_18__A_0.x2_m4d VSS sky130_fd_pr__nfet_01v8 ad=0.406 pd=3.38 as=0.406 ps=3.38 w=1.4 l=0.6
X202 nmos_single__A_0.bias_d nmos_single__A_0.x1_m2d nmos_single__A_0.x1_m2d VSS sky130_fd_pr__nfet_01v8 ad=0.406 pd=3.38 as=0.406 ps=3.38 w=1.4 l=0.6
X203 nmos_diode__A_0.bias_c nmos_diode__A_0.bias_b nmos_diode__A_0.bias_b VSS sky130_fd_pr__nfet_01v8_lvt ad=0.406 pd=3.38 as=0.406 ps=3.38 w=1.4 l=0.6
X204 nmos_single_5__A_0.x2_tail nmos_single_5__A_0.x2_tail nmos_single_5__A_0.x2_tail VSS sky130_fd_pr__nfet_01v8 ad=0.406 pd=3.38 as=0 ps=0 w=1.4 l=0.6
X205 VSS cmc nmos_single_5__A_0.x2_tail VSS sky130_fd_pr__nfet_01v8 ad=0.406 pd=3.38 as=0.406 ps=3.38 w=1.4 l=0.6
X206 VSS cmc nmos_single_5__A_0.x2_tail VSS sky130_fd_pr__nfet_01v8 ad=0.406 pd=3.38 as=0.406 ps=3.38 w=1.4 l=0.6
X207 nmos_diode__A_0.bias_c nmos_diode__A_0.bias_b nmos_diode__A_0.bias_b VSS sky130_fd_pr__nfet_01v8_lvt ad=0.406 pd=3.38 as=0.406 ps=3.38 w=1.4 l=0.6
X208 VDD VDD VDD VDD sky130_fd_pr__pfet_01v8_lvt ad=0.406 pd=3.38 as=0 ps=0 w=1.4 l=0.6
X209 VSS bias_a nmos_single_5__A_0.x2_tail VSS sky130_fd_pr__nfet_01v8 ad=0.406 pd=3.38 as=0.406 ps=3.38 w=1.4 l=0.6
X210 nmos_single__A_0.bias_d nmos_single__A_0.x1_m2d nmos_single__A_0.x1_m2d VSS sky130_fd_pr__nfet_01v8 ad=0.406 pd=3.38 as=0.406 ps=3.38 w=1.4 l=0.6
X211 VSS bias_a nmos_single_5__A_0.x2_tail VSS sky130_fd_pr__nfet_01v8 ad=0.406 pd=3.38 as=0.406 ps=3.38 w=1.4 l=0.6
X212 VSS bias_a nmos_single_5__A_0.x2_tail VSS sky130_fd_pr__nfet_01v8 ad=0.406 pd=3.38 as=0.406 ps=3.38 w=1.4 l=0.6
X213 nmos_dummy_9__A_0.x1_m5d nmos_single__A_0.bias_d bias_a VSS sky130_fd_pr__nfet_01v8 ad=0.406 pd=3.38 as=0.406 ps=3.38 w=1.4 l=0.6
X214 VDD VDD VDD VDD sky130_fd_pr__pfet_01v8_lvt ad=0.406 pd=3.38 as=0 ps=0 w=1.4 l=0.6
X215 nmos_dummy_19__A_0.x2_m3d nmos_single__A_0.bias_d on VSS sky130_fd_pr__nfet_01v8 ad=0.406 pd=3.38 as=0.406 ps=3.38 w=1.4 l=0.6
X216 on on on VSS sky130_fd_pr__nfet_01v8 ad=0.406 pd=3.38 as=17.052 ps=141.96001 w=1.4 l=0.6
X217 nmos_diode__A_0.bias_c IBIAS VSS VSS sky130_fd_pr__nfet_01v8 ad=0.406 pd=3.38 as=0.406 ps=3.38 w=1.4 l=0.6
X218 op cmc sky130_fd_pr__cap_mim_m3_1 l=4.8 w=4.8
X219 pmos_dummy_17__A_0.x2_foldp nmos_diode__A_0.bias_c on VDD sky130_fd_pr__pfet_01v8 ad=0.406 pd=3.38 as=0.406 ps=3.38 w=1.4 l=0.6
X220 nmos_single__A_0.bias_d nmos_single__A_0.x1_m2d nmos_single__A_0.x1_m2d VSS sky130_fd_pr__nfet_01v8 ad=0.406 pd=3.38 as=0.406 ps=3.38 w=1.4 l=0.6
X221 nmos_diode__A_0.bias_c nmos_diode__A_0.bias_b nmos_diode__A_0.bias_b VSS sky130_fd_pr__nfet_01v8_lvt ad=0.406 pd=3.38 as=0.406 ps=3.38 w=1.4 l=0.6
X222 VDD nmos_diode__A_0.bias_b pmos_dummy_16__A_0.x2_foldn VDD sky130_fd_pr__pfet_01v8_lvt ad=0.406 pd=3.38 as=0.406 ps=3.38 w=1.4 l=0.6
X223 VSS bias_a nmos_dummy_19__A_0.x2_m3d VSS sky130_fd_pr__nfet_01v8 ad=0.406 pd=3.38 as=0.406 ps=3.38 w=1.4 l=0.6
X224 pmos_dummy_16__A_0.x2_foldn nmos_diode__A_0.bias_c op VDD sky130_fd_pr__pfet_01v8 ad=0.406 pd=3.38 as=0.406 ps=3.38 w=1.4 l=0.6
X225 VSS bias_a nmos_single_5__A_0.x2_tail VSS sky130_fd_pr__nfet_01v8 ad=0.406 pd=3.38 as=0.406 ps=3.38 w=1.4 l=0.6
X226 nmos_dummy_9__A_0.x1_m5d nmos_single__A_0.bias_d bias_a VSS sky130_fd_pr__nfet_01v8 ad=0.406 pd=3.38 as=0.406 ps=3.38 w=1.4 l=0.6
X227 pmos_dummy_6__A_0.x1_m21d pmos_dummy_6__A_0.x1_m21d pmos_dummy_6__A_0.x1_m21d VDD sky130_fd_pr__pfet_01v8 ad=0.406 pd=3.38 as=0 ps=0 w=1.4 l=0.6
X228 nmos_single_5__A_0.x2_tail in pmos_dummy_16__A_0.x2_foldn VSS sky130_fd_pr__nfet_01v8_lvt ad=0.348 pd=2.98 as=0.348 ps=2.98 w=1.2 l=0.2
X229 VSS cmc nmos_single_5__A_0.x2_tail VSS sky130_fd_pr__nfet_01v8 ad=0.406 pd=3.38 as=0.406 ps=3.38 w=1.4 l=0.6
X230 VSS bias_a nmos_dummy_18__A_0.x2_m4d VSS sky130_fd_pr__nfet_01v8 ad=0.406 pd=3.38 as=0.406 ps=3.38 w=1.4 l=0.6
X231 nmos_matched_cascode_pair_11__AB_0.x1_net15 cm nmos_matched_cascode_pair_11__AB_0.x1_net14 VSS sky130_fd_pr__nfet_01v8 ad=0.406 pd=3.38 as=0.406 ps=3.38 w=1.4 l=0.6
X232 nmos_diode__A_0.bias_c nmos_diode__A_0.bias_c nmos_diode__A_0.bias_c VSS sky130_fd_pr__nfet_01v8 ad=0.406 pd=3.38 as=0 ps=0 w=1.4 l=0.6
X233 VSS cmc nmos_single_5__A_0.x2_tail VSS sky130_fd_pr__nfet_01v8 ad=0.406 pd=3.38 as=0.406 ps=3.38 w=1.4 l=0.6
X234 nmos_single__A_0.bias_d nmos_single__A_0.bias_d nmos_single__A_0.bias_d VSS sky130_fd_pr__nfet_01v8 ad=0.406 pd=3.38 as=0 ps=0 w=1.4 l=0.6
X235 VDD nmos_diode__A_0.bias_b pmos_dummy_17__A_0.x2_foldp VDD sky130_fd_pr__pfet_01v8_lvt ad=0.406 pd=3.38 as=0.406 ps=3.38 w=1.4 l=0.6
X236 VSS bias_a nmos_dummy_18__A_0.x2_m4d VSS sky130_fd_pr__nfet_01v8 ad=0.406 pd=3.38 as=0.406 ps=3.38 w=1.4 l=0.6
X237 VSS cmc nmos_single_5__A_0.x2_tail VSS sky130_fd_pr__nfet_01v8 ad=0.406 pd=3.38 as=0.406 ps=3.38 w=1.4 l=0.6
X238 pmos_dummy_17__A_0.x2_foldp nmos_diode__A_0.bias_c on VDD sky130_fd_pr__pfet_01v8 ad=0.406 pd=3.38 as=0.406 ps=3.38 w=1.4 l=0.6
X239 nmos_diode__A_0.bias_c nmos_diode__A_0.bias_b nmos_diode__A_0.bias_b VSS sky130_fd_pr__nfet_01v8_lvt ad=0.406 pd=3.38 as=0.406 ps=3.38 w=1.4 l=0.6
X240 nmos_single__A_0.bias_d nmos_single__A_0.x1_m2d nmos_single__A_0.x1_m2d VSS sky130_fd_pr__nfet_01v8 ad=0.406 pd=3.38 as=0.406 ps=3.38 w=1.4 l=0.6
X241 VDD nmos_diode__A_0.bias_b pmos_dummy_16__A_0.x2_foldn VDD sky130_fd_pr__pfet_01v8_lvt ad=0.406 pd=3.38 as=0.406 ps=3.38 w=1.4 l=0.6
X242 VSS bias_a nmos_dummy_9__A_0.x1_m5d VSS sky130_fd_pr__nfet_01v8 ad=0.406 pd=3.38 as=0.406 ps=3.38 w=1.4 l=0.6
X243 VSS cmc nmos_single_5__A_0.x2_tail VSS sky130_fd_pr__nfet_01v8 ad=0.406 pd=3.38 as=0.406 ps=3.38 w=1.4 l=0.6
X244 op nmos_single__A_0.bias_d nmos_dummy_18__A_0.x2_m4d VSS sky130_fd_pr__nfet_01v8 ad=0.406 pd=3.38 as=0.406 ps=3.38 w=1.4 l=0.6
X245 VSS bias_a nmos_dummy_18__A_0.x2_m4d VSS sky130_fd_pr__nfet_01v8 ad=0.406 pd=3.38 as=0.406 ps=3.38 w=1.4 l=0.6
X246 pmos_dummy_17__A_0.x2_foldp nmos_diode__A_0.bias_c on VDD sky130_fd_pr__pfet_01v8 ad=0.406 pd=3.38 as=0.406 ps=3.38 w=1.4 l=0.6
X247 VSS cmc nmos_single_5__A_0.x2_tail VSS sky130_fd_pr__nfet_01v8 ad=0.406 pd=3.38 as=0.406 ps=3.38 w=1.4 l=0.6
X248 nmos_dummy_18__A_0.x2_m4d nmos_single__A_0.bias_d op VSS sky130_fd_pr__nfet_01v8 ad=0.406 pd=3.38 as=0.406 ps=3.38 w=1.4 l=0.6
X249 VSS bias_a nmos_dummy_18__A_0.x2_m4d VSS sky130_fd_pr__nfet_01v8 ad=0.406 pd=3.38 as=0.406 ps=3.38 w=1.4 l=0.6
X250 VSS bias_a nmos_dummy_18__A_0.x2_m4d VSS sky130_fd_pr__nfet_01v8 ad=0.406 pd=3.38 as=0.406 ps=3.38 w=1.4 l=0.6
X251 VSS cmc nmos_single_5__A_0.x2_tail VSS sky130_fd_pr__nfet_01v8 ad=0.406 pd=3.38 as=0.406 ps=3.38 w=1.4 l=0.6
X252 IBIAS IBIAS IBIAS VSS sky130_fd_pr__nfet_01v8 ad=0.406 pd=3.38 as=8.932 ps=74.36 w=1.4 l=0.6
X253 VSS bias_a nmos_dummy_19__A_0.x2_m3d VSS sky130_fd_pr__nfet_01v8 ad=0.406 pd=3.38 as=0.406 ps=3.38 w=1.4 l=0.6
X254 on nmos_single__A_0.bias_d nmos_dummy_19__A_0.x2_m3d VSS sky130_fd_pr__nfet_01v8 ad=0.406 pd=3.38 as=0.406 ps=3.38 w=1.4 l=0.6
X255 nmos_diode__A_0.bias_b nmos_diode__A_0.bias_b nmos_diode__A_0.bias_b VSS sky130_fd_pr__nfet_01v8_lvt ad=0.406 pd=3.38 as=0 ps=0 w=1.4 l=0.6
X256 on cmc sky130_fd_pr__cap_mim_m3_1 l=4.8 w=4.8
X257 VSS VSS VSS VSS sky130_fd_pr__nfet_01v8 ad=0.406 pd=3.38 as=0 ps=0 w=1.4 l=0.6
X258 on nmos_single__A_0.bias_d nmos_dummy_19__A_0.x2_m3d VSS sky130_fd_pr__nfet_01v8 ad=0.406 pd=3.38 as=0.406 ps=3.38 w=1.4 l=0.6
X259 VSS bias_a nmos_dummy_18__A_0.x2_m4d VSS sky130_fd_pr__nfet_01v8 ad=0.406 pd=3.38 as=0.406 ps=3.38 w=1.4 l=0.6
X260 VSS bias_a nmos_single_5__A_0.x2_tail VSS sky130_fd_pr__nfet_01v8 ad=0.406 pd=3.38 as=0.406 ps=3.38 w=1.4 l=0.6
X261 nmos_diode__A_0.bias_c nmos_diode__A_0.bias_b nmos_diode__A_0.bias_b VSS sky130_fd_pr__nfet_01v8_lvt ad=0.406 pd=3.38 as=0.406 ps=3.38 w=1.4 l=0.6
X262 VDD nmos_diode__A_0.bias_b pmos_dummy_17__A_0.x2_foldp VDD sky130_fd_pr__pfet_01v8_lvt ad=0.406 pd=3.38 as=0.406 ps=3.38 w=1.4 l=0.6
X263 VSS VSS nmos_dummy_19__A_0.x2_m3d VSS sky130_fd_pr__nfet_01v8 ad=0.406 pd=3.38 as=0.406 ps=3.38 w=1.4 l=0.6
X264 VSS bias_a nmos_single_5__A_0.x2_tail VSS sky130_fd_pr__nfet_01v8 ad=0.406 pd=3.38 as=0.406 ps=3.38 w=1.4 l=0.6
X265 nmos_single__A_0.bias_d nmos_single__A_0.x1_m2d nmos_single__A_0.x1_m2d VSS sky130_fd_pr__nfet_01v8 ad=0.406 pd=3.38 as=0.406 ps=3.38 w=1.4 l=0.6
X266 pmos_dummy_7__A_0.x1_m25d nmos_diode__A_0.bias_b VDD VDD sky130_fd_pr__pfet_01v8_lvt ad=0.406 pd=3.38 as=0.406 ps=3.38 w=1.4 l=0.6
X267 VSS VSS VSS VSS sky130_fd_pr__nfet_01v8 ad=0.406 pd=3.38 as=0 ps=0 w=1.4 l=0.6
X268 VDD nmos_diode__A_0.bias_b pmos_dummy_16__A_0.x2_foldn VDD sky130_fd_pr__pfet_01v8_lvt ad=0.406 pd=3.38 as=0.406 ps=3.38 w=1.4 l=0.6
X269 pmos_dummy_16__A_0.x2_foldn nmos_diode__A_0.bias_c op VDD sky130_fd_pr__pfet_01v8 ad=0.406 pd=3.38 as=0.406 ps=3.38 w=1.4 l=0.6
X270 nmos_dummy_18__A_0.x2_m4d nmos_single__A_0.bias_d op VSS sky130_fd_pr__nfet_01v8 ad=0.406 pd=3.38 as=0.406 ps=3.38 w=1.4 l=0.6
X271 on nmos_single__A_0.bias_d nmos_dummy_19__A_0.x2_m3d VSS sky130_fd_pr__nfet_01v8 ad=0.406 pd=3.38 as=0.406 ps=3.38 w=1.4 l=0.6
X272 nmos_single_5__A_0.x2_tail ip pmos_dummy_17__A_0.x2_foldp VSS sky130_fd_pr__nfet_01v8_lvt ad=0.348 pd=2.98 as=0.348 ps=2.98 w=1.2 l=0.2
X273 VSS VSS VSS VSS sky130_fd_pr__nfet_01v8 ad=0.406 pd=3.38 as=0 ps=0 w=1.4 l=0.6
X274 nmos_dummy_19__A_0.x2_m3d nmos_single__A_0.bias_d on VSS sky130_fd_pr__nfet_01v8 ad=0.406 pd=3.38 as=0.406 ps=3.38 w=1.4 l=0.6
X275 VDD VDD cm VDD sky130_fd_pr__pfet_01v8 ad=0.406 pd=3.38 as=0.406 ps=3.38 w=1.4 l=0.6
X276 VSS VSS VSS VSS sky130_fd_pr__nfet_01v8 ad=0.406 pd=3.38 as=0 ps=0 w=1.4 l=0.6
X277 VSS bias_a nmos_single_5__A_0.x2_tail VSS sky130_fd_pr__nfet_01v8 ad=0.406 pd=3.38 as=0.406 ps=3.38 w=1.4 l=0.6
X278 pmos_dummy_17__A_0.x2_foldp nmos_diode__A_0.bias_c on VDD sky130_fd_pr__pfet_01v8 ad=0.406 pd=3.38 as=0.406 ps=3.38 w=1.4 l=0.6
X279 nmos_diode__A_0.bias_c nmos_diode__A_0.bias_b nmos_diode__A_0.bias_b VSS sky130_fd_pr__nfet_01v8_lvt ad=0.406 pd=3.38 as=0.406 ps=3.38 w=1.4 l=0.6
X280 VSS VSS VSS VSS sky130_fd_pr__nfet_01v8 ad=0.406 pd=3.38 as=0 ps=0 w=1.4 l=0.6
X281 VSS IBIAS IBIAS VSS sky130_fd_pr__nfet_01v8 ad=0.406 pd=3.38 as=0.406 ps=3.38 w=1.4 l=0.6
X282 pmos_dummy_7__A_0.x1_m25d nmos_diode__A_0.bias_c nmos_single__A_0.x1_m2d VDD sky130_fd_pr__pfet_01v8 ad=0.406 pd=3.38 as=0.406 ps=3.38 w=1.4 l=0.6
X283 VDD nmos_diode__A_0.bias_b pmos_dummy_16__A_0.x2_foldn VDD sky130_fd_pr__pfet_01v8_lvt ad=0.406 pd=3.38 as=0.406 ps=3.38 w=1.4 l=0.6
X284 pmos_dummy_16__A_0.x2_foldn nmos_diode__A_0.bias_c op VDD sky130_fd_pr__pfet_01v8 ad=0.406 pd=3.38 as=0.406 ps=3.38 w=1.4 l=0.6
X285 nmos_single_5__A_0.x2_tail in pmos_dummy_16__A_0.x2_foldn VSS sky130_fd_pr__nfet_01v8_lvt ad=0.348 pd=2.98 as=0.348 ps=2.98 w=1.2 l=0.2
X286 VSS VSS VSS VSS sky130_fd_pr__nfet_01v8 ad=0.406 pd=3.38 as=0 ps=0 w=1.4 l=0.6
X287 VDD VDD VDD VDD sky130_fd_pr__pfet_01v8_lvt ad=0.406 pd=3.38 as=0 ps=0 w=1.4 l=0.6
X288 nmos_dummy_18__A_0.x2_m4d nmos_single__A_0.bias_d op VSS sky130_fd_pr__nfet_01v8 ad=0.406 pd=3.38 as=0.406 ps=3.38 w=1.4 l=0.6
X289 VSS cmc nmos_single_5__A_0.x2_tail VSS sky130_fd_pr__nfet_01v8 ad=0.406 pd=3.38 as=0.406 ps=3.38 w=1.4 l=0.6
X290 VDD nmos_diode__A_0.bias_b pmos_dummy_17__A_0.x2_foldp VDD sky130_fd_pr__pfet_01v8_lvt ad=0.406 pd=3.38 as=0.406 ps=3.38 w=1.4 l=0.6
X291 VSS bias_a nmos_dummy_18__A_0.x2_m4d VSS sky130_fd_pr__nfet_01v8 ad=0.406 pd=3.38 as=0.406 ps=3.38 w=1.4 l=0.6
X292 VDD nmos_diode__A_0.bias_b pmos_dummy_7__A_0.x1_m25d VDD sky130_fd_pr__pfet_01v8_lvt ad=0.406 pd=3.38 as=0.406 ps=3.38 w=1.4 l=0.6
X293 nmos_single_5__A_0.x2_tail in pmos_dummy_16__A_0.x2_foldn VSS sky130_fd_pr__nfet_01v8_lvt ad=0.348 pd=2.98 as=0.348 ps=2.98 w=1.2 l=0.2
X294 VSS VSS nmos_dummy_9__A_0.x1_m5d VSS sky130_fd_pr__nfet_01v8 ad=0.406 pd=3.38 as=0.406 ps=3.38 w=1.4 l=0.6
X295 VSS cmc nmos_single_5__A_0.x2_tail VSS sky130_fd_pr__nfet_01v8 ad=0.406 pd=3.38 as=0.406 ps=3.38 w=1.4 l=0.6
X296 VSS cmc nmos_single_5__A_0.x2_tail VSS sky130_fd_pr__nfet_01v8 ad=0.406 pd=3.38 as=0.406 ps=3.38 w=1.4 l=0.6
X297 VSS VSS VSS VSS sky130_fd_pr__nfet_01v8 ad=0.406 pd=3.38 as=0 ps=0 w=1.4 l=0.6
X298 nmos_matched_cascode_pair_4__AB_0.x1_net4 cm cm VSS sky130_fd_pr__nfet_01v8 ad=0.406 pd=3.38 as=0.406 ps=3.38 w=1.4 l=0.6
X299 VSS IBIAS IBIAS VSS sky130_fd_pr__nfet_01v8 ad=0.406 pd=3.38 as=0.406 ps=3.38 w=1.4 l=0.6
X300 nmos_diode__A_0.bias_c nmos_diode__A_0.bias_c nmos_diode__A_0.bias_c VSS sky130_fd_pr__nfet_01v8_lvt ad=0.406 pd=3.38 as=0 ps=0 w=1.4 l=0.6
X301 nmos_diode__A_0.bias_c nmos_diode__A_0.bias_b nmos_diode__A_0.bias_b VSS sky130_fd_pr__nfet_01v8_lvt ad=0.406 pd=3.38 as=0.406 ps=3.38 w=1.4 l=0.6
X302 VDD nmos_diode__A_0.bias_b pmos_dummy_17__A_0.x2_foldp VDD sky130_fd_pr__pfet_01v8_lvt ad=0.406 pd=3.38 as=0.406 ps=3.38 w=1.4 l=0.6
X303 VSS VSS VSS VSS sky130_fd_pr__nfet_01v8 ad=0.406 pd=3.38 as=0 ps=0 w=1.4 l=0.6
X304 bias_a bias_a bias_a VSS sky130_fd_pr__nfet_01v8 ad=0.406 pd=3.38 as=11.368 ps=94.64 w=1.4 l=0.6
X305 cm cm cm VSS sky130_fd_pr__nfet_01v8 ad=0.406 pd=3.38 as=0 ps=0 w=1.4 l=0.6
X306 nmos_diode__A_0.bias_c nmos_diode__A_0.bias_b nmos_diode__A_0.bias_b VSS sky130_fd_pr__nfet_01v8_lvt ad=0.406 pd=3.38 as=0.406 ps=3.38 w=1.4 l=0.6
X307 nmos_single_5__A_0.x2_tail in pmos_dummy_16__A_0.x2_foldn VSS sky130_fd_pr__nfet_01v8_lvt ad=0.348 pd=2.98 as=0.348 ps=2.98 w=1.2 l=0.2
X308 VSS bias_a nmos_dummy_9__A_0.x1_m5d VSS sky130_fd_pr__nfet_01v8 ad=0.406 pd=3.38 as=0.406 ps=3.38 w=1.4 l=0.6
X309 VDD VDD nmos_single__A_0.x1_m2d VDD sky130_fd_pr__pfet_01v8 ad=0.406 pd=3.38 as=0.406 ps=3.38 w=1.4 l=0.6
X310 VSS cmc nmos_single_5__A_0.x2_tail VSS sky130_fd_pr__nfet_01v8 ad=0.406 pd=3.38 as=0.406 ps=3.38 w=1.4 l=0.6
X311 VSS cmc nmos_single_5__A_0.x2_tail VSS sky130_fd_pr__nfet_01v8 ad=0.406 pd=3.38 as=0.406 ps=3.38 w=1.4 l=0.6
X312 VSS IBIAS IBIAS VSS sky130_fd_pr__nfet_01v8 ad=0.406 pd=3.38 as=0.406 ps=3.38 w=1.4 l=0.6
X313 VSS bias_a nmos_single_5__A_0.x2_tail VSS sky130_fd_pr__nfet_01v8 ad=0.406 pd=3.38 as=0.406 ps=3.38 w=1.4 l=0.6
X314 IBIAS IBIAS VSS VSS sky130_fd_pr__nfet_01v8 ad=0.406 pd=3.38 as=0.406 ps=3.38 w=1.4 l=0.6
X315 nmos_single__A_0.bias_d nmos_single__A_0.x1_m2d nmos_single__A_0.x1_m2d VSS sky130_fd_pr__nfet_01v8 ad=0.406 pd=3.38 as=0.406 ps=3.38 w=1.4 l=0.6
X316 pmos_dummy_16__A_0.x2_foldn nmos_diode__A_0.bias_c op VDD sky130_fd_pr__pfet_01v8 ad=0.406 pd=3.38 as=0.406 ps=3.38 w=1.4 l=0.6
X317 VSS VSS nmos_dummy_9__A_0.x1_m5d VSS sky130_fd_pr__nfet_01v8 ad=0.406 pd=3.38 as=0.406 ps=3.38 w=1.4 l=0.6
X318 nmos_matched_cascode_pair_7__AB_0.x1_net9 cm VSS VSS sky130_fd_pr__nfet_01v8 ad=0.406 pd=3.38 as=0.406 ps=3.38 w=1.4 l=0.6
X319 nmos_dummy_18__A_0.x2_m4d nmos_single__A_0.bias_d op VSS sky130_fd_pr__nfet_01v8 ad=0.406 pd=3.38 as=0.406 ps=3.38 w=1.4 l=0.6
X320 VSS bias_a nmos_dummy_9__A_0.x1_m5d VSS sky130_fd_pr__nfet_01v8 ad=0.406 pd=3.38 as=0.406 ps=3.38 w=1.4 l=0.6
X321 nmos_single__A_0.bias_d nmos_single__A_0.x1_m2d nmos_single__A_0.x1_m2d VSS sky130_fd_pr__nfet_01v8 ad=0.406 pd=3.38 as=0.406 ps=3.38 w=1.4 l=0.6
X322 op op op VSS sky130_fd_pr__nfet_01v8 ad=0.406 pd=3.38 as=0 ps=0 w=1.4 l=0.6
X323 IBIAS IBIAS VSS VSS sky130_fd_pr__nfet_01v8 ad=0.406 pd=3.38 as=0.406 ps=3.38 w=1.4 l=0.6
X324 nmos_diode__A_0.bias_c nmos_diode__A_0.bias_b nmos_diode__A_0.bias_b VSS sky130_fd_pr__nfet_01v8_lvt ad=0.406 pd=3.38 as=0.406 ps=3.38 w=1.4 l=0.6
X325 pmos_single__A_0.x1_m31d nmos_diode__A_0.bias_c cm VDD sky130_fd_pr__pfet_01v8 ad=0.406 pd=3.38 as=0.406 ps=3.38 w=1.4 l=0.6
X326 VSS cmc nmos_single_5__A_0.x2_tail VSS sky130_fd_pr__nfet_01v8 ad=0.406 pd=3.38 as=0.406 ps=3.38 w=1.4 l=0.6
X327 nmos_single__A_0.bias_d nmos_single__A_0.x1_m2d nmos_single__A_0.x1_m2d VSS sky130_fd_pr__nfet_01v8 ad=0.406 pd=3.38 as=0.406 ps=3.38 w=1.4 l=0.6
X328 VSS cmc nmos_single_5__A_0.x2_tail VSS sky130_fd_pr__nfet_01v8 ad=0.406 pd=3.38 as=0.406 ps=3.38 w=1.4 l=0.6
X329 VSS bias_a nmos_single_5__A_0.x2_tail VSS sky130_fd_pr__nfet_01v8 ad=0.406 pd=3.38 as=0.406 ps=3.38 w=1.4 l=0.6
X330 pmos_dummy_17__A_0.x2_foldp nmos_diode__A_0.bias_c on VDD sky130_fd_pr__pfet_01v8 ad=0.406 pd=3.38 as=0.406 ps=3.38 w=1.4 l=0.6
X331 nmos_diode__A_0.bias_c IBIAS VSS VSS sky130_fd_pr__nfet_01v8 ad=0.406 pd=3.38 as=0.406 ps=3.38 w=1.4 l=0.6
X332 VDD nmos_diode__A_0.bias_b pmos_dummy_16__A_0.x2_foldn VDD sky130_fd_pr__pfet_01v8_lvt ad=0.406 pd=3.38 as=0.406 ps=3.38 w=1.4 l=0.6
X333 pmos_dummy_16__A_0.x2_foldn nmos_diode__A_0.bias_c op VDD sky130_fd_pr__pfet_01v8 ad=0.406 pd=3.38 as=0.406 ps=3.38 w=1.4 l=0.6
X334 VDD nmos_diode__A_0.bias_b pmos_single__A_0.x1_m31d VDD sky130_fd_pr__pfet_01v8_lvt ad=0.406 pd=3.38 as=0.406 ps=3.38 w=1.4 l=0.6
X335 VDD nmos_diode__A_0.bias_b pmos_dummy_17__A_0.x2_foldp VDD sky130_fd_pr__pfet_01v8_lvt ad=0.406 pd=3.38 as=0.406 ps=3.38 w=1.4 l=0.6
X336 VSS bias_a nmos_single_5__A_0.x2_tail VSS sky130_fd_pr__nfet_01v8 ad=0.406 pd=3.38 as=0.406 ps=3.38 w=1.4 l=0.6
X337 nmos_single__A_0.bias_d nmos_single__A_0.x1_m2d nmos_single__A_0.x1_m2d VSS sky130_fd_pr__nfet_01v8 ad=0.406 pd=3.38 as=0.406 ps=3.38 w=1.4 l=0.6
X338 pmos_single__A_0.x1_m31d nmos_diode__A_0.bias_c cm VDD sky130_fd_pr__pfet_01v8 ad=0.406 pd=3.38 as=0.406 ps=3.38 w=1.4 l=0.6
X339 pmos_dummy_17__A_0.x2_foldp nmos_diode__A_0.bias_c on VDD sky130_fd_pr__pfet_01v8 ad=0.406 pd=3.38 as=0.406 ps=3.38 w=1.4 l=0.6
X340 nmos_diode__A_0.bias_c IBIAS VSS VSS sky130_fd_pr__nfet_01v8 ad=0.406 pd=3.38 as=0.406 ps=3.38 w=1.4 l=0.6
X341 pmos_dummy_17__A_0.x2_foldp pmos_dummy_17__A_0.x2_foldp pmos_dummy_17__A_0.x2_foldp VDD sky130_fd_pr__pfet_01v8 ad=0.406 pd=3.38 as=20.3 ps=169 w=1.4 l=0.6
X342 VDD nmos_diode__A_0.bias_b pmos_dummy_16__A_0.x2_foldn VDD sky130_fd_pr__pfet_01v8_lvt ad=0.406 pd=3.38 as=0.406 ps=3.38 w=1.4 l=0.6
X343 VSS bias_a nmos_single_5__A_0.x2_tail VSS sky130_fd_pr__nfet_01v8 ad=0.406 pd=3.38 as=0.406 ps=3.38 w=1.4 l=0.6
X344 VDD nmos_diode__A_0.bias_b pmos_single__A_0.x1_m31d VDD sky130_fd_pr__pfet_01v8_lvt ad=0.406 pd=3.38 as=0.406 ps=3.38 w=1.4 l=0.6
X345 VSS bias_a nmos_single_5__A_0.x2_tail VSS sky130_fd_pr__nfet_01v8 ad=0.406 pd=3.38 as=0.406 ps=3.38 w=1.4 l=0.6
X346 VSS cmc nmos_single_5__A_0.x2_tail VSS sky130_fd_pr__nfet_01v8 ad=0.406 pd=3.38 as=0.406 ps=3.38 w=1.4 l=0.6
X347 nmos_single__A_0.bias_d nmos_single__A_0.x1_m2d nmos_single__A_0.x1_m2d VSS sky130_fd_pr__nfet_01v8 ad=0.406 pd=3.38 as=0.406 ps=3.38 w=1.4 l=0.6
X348 VSS bias_a nmos_dummy_19__A_0.x2_m3d VSS sky130_fd_pr__nfet_01v8 ad=0.406 pd=3.38 as=0.406 ps=3.38 w=1.4 l=0.6
X349 nmos_diode__A_0.bias_c nmos_diode__A_0.bias_b nmos_diode__A_0.bias_b VSS sky130_fd_pr__nfet_01v8_lvt ad=0.406 pd=3.38 as=0.406 ps=3.38 w=1.4 l=0.6
X350 VSS bias_a nmos_dummy_18__A_0.x2_m4d VSS sky130_fd_pr__nfet_01v8 ad=0.406 pd=3.38 as=0.406 ps=3.38 w=1.4 l=0.6
X351 VSS cmc nmos_single_5__A_0.x2_tail VSS sky130_fd_pr__nfet_01v8 ad=0.406 pd=3.38 as=0.406 ps=3.38 w=1.4 l=0.6
X352 VDD nmos_diode__A_0.bias_b pmos_single__A_0.x1_m31d VDD sky130_fd_pr__pfet_01v8_lvt ad=0.406 pd=3.38 as=0.406 ps=3.38 w=1.4 l=0.6
X353 VSS bias_a nmos_dummy_9__A_0.x1_m5d VSS sky130_fd_pr__nfet_01v8 ad=0.406 pd=3.38 as=0.406 ps=3.38 w=1.4 l=0.6
X354 VSS cmc nmos_single_5__A_0.x2_tail VSS sky130_fd_pr__nfet_01v8 ad=0.406 pd=3.38 as=0.406 ps=3.38 w=1.4 l=0.6
X355 op cmc sky130_fd_pr__cap_mim_m3_1 l=4.8 w=4.8
X356 VDD nmos_diode__A_0.bias_b pmos_dummy_17__A_0.x2_foldp VDD sky130_fd_pr__pfet_01v8_lvt ad=0.406 pd=3.38 as=0.406 ps=3.38 w=1.4 l=0.6
X357 VSS VSS nmos_single_5__A_0.x2_tail VSS sky130_fd_pr__nfet_01v8 ad=0.406 pd=3.38 as=0.406 ps=3.38 w=1.4 l=0.6
X358 VSS bias_a nmos_single_5__A_0.x2_tail VSS sky130_fd_pr__nfet_01v8 ad=0.406 pd=3.38 as=0.406 ps=3.38 w=1.4 l=0.6
X359 nmos_single__A_0.bias_d nmos_single__A_0.x1_m2d nmos_single__A_0.x1_m2d VSS sky130_fd_pr__nfet_01v8 ad=0.406 pd=3.38 as=0.406 ps=3.38 w=1.4 l=0.6
X360 pmos_dummy_7__A_0.x1_m25d pmos_dummy_7__A_0.x1_m25d pmos_dummy_7__A_0.x1_m25d VDD sky130_fd_pr__pfet_01v8 ad=0.406 pd=3.38 as=8.12 ps=67.6 w=1.4 l=0.6
X361 VSS bias_a nmos_dummy_18__A_0.x2_m4d VSS sky130_fd_pr__nfet_01v8 ad=0.406 pd=3.38 as=0.406 ps=3.38 w=1.4 l=0.6
X362 VSS bias_a nmos_single_5__A_0.x2_tail VSS sky130_fd_pr__nfet_01v8 ad=0.406 pd=3.38 as=0.406 ps=3.38 w=1.4 l=0.6
X363 VSS cmc nmos_single_5__A_0.x2_tail VSS sky130_fd_pr__nfet_01v8 ad=0.406 pd=3.38 as=0.406 ps=3.38 w=1.4 l=0.6
X364 VSS bias_a nmos_single_5__A_0.x2_tail VSS sky130_fd_pr__nfet_01v8 ad=0.406 pd=3.38 as=0.406 ps=3.38 w=1.4 l=0.6
X365 VSS cmc nmos_single_5__A_0.x2_tail VSS sky130_fd_pr__nfet_01v8 ad=0.406 pd=3.38 as=0.406 ps=3.38 w=1.4 l=0.6
X366 VSS VSS VSS VSS sky130_fd_pr__nfet_01v8 ad=0.406 pd=3.38 as=0 ps=0 w=1.4 l=0.6
X367 nmos_single__A_0.x1_m2d nmos_diode__A_0.bias_c pmos_dummy_7__A_0.x1_m25d VDD sky130_fd_pr__pfet_01v8 ad=0.406 pd=3.38 as=0.406 ps=3.38 w=1.4 l=0.6
X368 VDD nmos_diode__A_0.bias_b pmos_dummy_16__A_0.x2_foldn VDD sky130_fd_pr__pfet_01v8_lvt ad=0.406 pd=3.38 as=0.406 ps=3.38 w=1.4 l=0.6
X369 nmos_single__A_0.bias_d nmos_single__A_0.bias_d nmos_single__A_0.bias_d VSS sky130_fd_pr__nfet_01v8 ad=0.406 pd=3.38 as=0 ps=0 w=1.4 l=0.6
X370 nmos_dummy_19__A_0.x2_m3d nmos_single__A_0.bias_d on VSS sky130_fd_pr__nfet_01v8 ad=0.406 pd=3.38 as=0.406 ps=3.38 w=1.4 l=0.6
X371 VSS bias_a nmos_dummy_19__A_0.x2_m3d VSS sky130_fd_pr__nfet_01v8 ad=0.406 pd=3.38 as=0.406 ps=3.38 w=1.4 l=0.6
X372 nmos_dummy_9__A_0.x1_m5d nmos_single__A_0.bias_d bias_a VSS sky130_fd_pr__nfet_01v8 ad=0.406 pd=3.38 as=0.406 ps=3.38 w=1.4 l=0.6
X373 VSS VSS VSS VSS sky130_fd_pr__nfet_01v8 ad=0.406 pd=3.38 as=0 ps=0 w=1.4 l=0.6
X374 nmos_dummy_18__A_0.x2_m4d nmos_single__A_0.bias_d op VSS sky130_fd_pr__nfet_01v8 ad=0.406 pd=3.38 as=0.406 ps=3.38 w=1.4 l=0.6
X375 VSS cmc nmos_single_5__A_0.x2_tail VSS sky130_fd_pr__nfet_01v8 ad=0.406 pd=3.38 as=0.406 ps=3.38 w=1.4 l=0.6
X376 VSS cmc nmos_single_5__A_0.x2_tail VSS sky130_fd_pr__nfet_01v8 ad=0.406 pd=3.38 as=0.406 ps=3.38 w=1.4 l=0.6
X377 VSS IBIAS IBIAS VSS sky130_fd_pr__nfet_01v8 ad=0.406 pd=3.38 as=0.406 ps=3.38 w=1.4 l=0.6
X378 nmos_dummy_9__A_0.x1_m5d nmos_dummy_9__A_0.x1_m5d nmos_dummy_9__A_0.x1_m5d VSS sky130_fd_pr__nfet_01v8 ad=0.406 pd=3.38 as=0 ps=0 w=1.4 l=0.6
X379 nmos_diode__A_0.bias_b nmos_diode__A_0.bias_c pmos_dummy_6__A_0.x1_m21d VDD sky130_fd_pr__pfet_01v8 ad=0.406 pd=3.38 as=0.406 ps=3.38 w=1.4 l=0.6
X380 pmos_dummy_16__A_0.x2_foldn nmos_diode__A_0.bias_c op VDD sky130_fd_pr__pfet_01v8 ad=0.406 pd=3.38 as=0.406 ps=3.38 w=1.4 l=0.6
X381 VSS bias_a nmos_dummy_19__A_0.x2_m3d VSS sky130_fd_pr__nfet_01v8 ad=0.406 pd=3.38 as=0.406 ps=3.38 w=1.4 l=0.6
X382 VDD nmos_diode__A_0.bias_b pmos_dummy_17__A_0.x2_foldp VDD sky130_fd_pr__pfet_01v8_lvt ad=0.406 pd=3.38 as=0.406 ps=3.38 w=1.4 l=0.6
X383 on nmos_single__A_0.bias_d nmos_dummy_19__A_0.x2_m3d VSS sky130_fd_pr__nfet_01v8 ad=0.406 pd=3.38 as=0.406 ps=3.38 w=1.4 l=0.6
X384 nmos_diode__A_0.bias_c nmos_diode__A_0.bias_b nmos_diode__A_0.bias_b VSS sky130_fd_pr__nfet_01v8_lvt ad=0.406 pd=3.38 as=0.406 ps=3.38 w=1.4 l=0.6
X385 VDD nmos_diode__A_0.bias_b pmos_dummy_16__A_0.x2_foldn VDD sky130_fd_pr__pfet_01v8_lvt ad=0.406 pd=3.38 as=0.406 ps=3.38 w=1.4 l=0.6
X386 nmos_single_5__A_0.x2_tail nmos_single_5__A_0.x2_tail nmos_single_5__A_0.x2_tail VSS sky130_fd_pr__nfet_01v8 ad=0.406 pd=3.38 as=0 ps=0 w=1.4 l=0.6
X387 VSS bias_a nmos_single_5__A_0.x2_tail VSS sky130_fd_pr__nfet_01v8 ad=0.406 pd=3.38 as=0.406 ps=3.38 w=1.4 l=0.6
X388 VSS cmc nmos_single_5__A_0.x2_tail VSS sky130_fd_pr__nfet_01v8 ad=0.406 pd=3.38 as=0.406 ps=3.38 w=1.4 l=0.6
X389 nmos_single__A_0.bias_d nmos_single__A_0.x1_m2d nmos_single__A_0.x1_m2d VSS sky130_fd_pr__nfet_01v8 ad=0.406 pd=3.38 as=0.406 ps=3.38 w=1.4 l=0.6
X390 nmos_diode__A_0.bias_c nmos_diode__A_0.bias_b nmos_diode__A_0.bias_b VSS sky130_fd_pr__nfet_01v8_lvt ad=0.406 pd=3.38 as=0.406 ps=3.38 w=1.4 l=0.6
X391 VDD VDD cm VDD sky130_fd_pr__pfet_01v8 ad=0.406 pd=3.38 as=0.406 ps=3.38 w=1.4 l=0.6
X392 nmos_single__A_0.bias_d nmos_single__A_0.x1_m2d nmos_single__A_0.x1_m2d VSS sky130_fd_pr__nfet_01v8 ad=0.406 pd=3.38 as=0.406 ps=3.38 w=1.4 l=0.6
X393 VDD VDD on VDD sky130_fd_pr__pfet_01v8 ad=0.406 pd=3.38 as=0.406 ps=3.38 w=1.4 l=0.6
X394 VDD VDD VDD VDD sky130_fd_pr__pfet_01v8 ad=0.406 pd=3.38 as=0 ps=0 w=1.4 l=0.6
X395 VSS VSS nmos_dummy_18__A_0.x2_m4d VSS sky130_fd_pr__nfet_01v8 ad=0.406 pd=3.38 as=0.406 ps=3.38 w=1.4 l=0.6
X396 VDD nmos_diode__A_0.bias_b pmos_dummy_17__A_0.x2_foldp VDD sky130_fd_pr__pfet_01v8_lvt ad=0.406 pd=3.38 as=0.406 ps=3.38 w=1.4 l=0.6
X397 nmos_dummy_19__A_0.x2_m3d nmos_single__A_0.bias_d on VSS sky130_fd_pr__nfet_01v8 ad=0.406 pd=3.38 as=0.406 ps=3.38 w=1.4 l=0.6
X398 pmos_dummy_6__A_0.x1_m21d nmos_diode__A_0.bias_c nmos_diode__A_0.bias_b VDD sky130_fd_pr__pfet_01v8 ad=0.406 pd=3.38 as=0.406 ps=3.38 w=1.4 l=0.6
X399 pmos_dummy_16__A_0.x2_foldn nmos_diode__A_0.bias_c op VDD sky130_fd_pr__pfet_01v8 ad=0.406 pd=3.38 as=0.406 ps=3.38 w=1.4 l=0.6
X400 VSS bias_a nmos_dummy_18__A_0.x2_m4d VSS sky130_fd_pr__nfet_01v8 ad=0.406 pd=3.38 as=0.406 ps=3.38 w=1.4 l=0.6
X401 VDD VDD VDD VDD sky130_fd_pr__pfet_01v8_lvt ad=0.406 pd=3.38 as=0 ps=0 w=1.4 l=0.6
X402 VSS bias_a nmos_single_5__A_0.x2_tail VSS sky130_fd_pr__nfet_01v8 ad=0.406 pd=3.38 as=0.406 ps=3.38 w=1.4 l=0.6
X403 VSS bias_a nmos_single_5__A_0.x2_tail VSS sky130_fd_pr__nfet_01v8 ad=0.406 pd=3.38 as=0.406 ps=3.38 w=1.4 l=0.6
X404 nmos_diode__A_0.bias_c nmos_diode__A_0.bias_c nmos_diode__A_0.bias_c VSS sky130_fd_pr__nfet_01v8_lvt ad=0.406 pd=3.38 as=0 ps=0 w=1.4 l=0.6
X405 op nmos_single__A_0.bias_d nmos_dummy_18__A_0.x2_m4d VSS sky130_fd_pr__nfet_01v8 ad=0.406 pd=3.38 as=0.406 ps=3.38 w=1.4 l=0.6
X406 on on on VSS sky130_fd_pr__nfet_01v8 ad=0.406 pd=3.38 as=0 ps=0 w=1.4 l=0.6
X407 nmos_matched_cascode_pair_4__AB_0.x1_net4 cm nmos_matched_cascode_pair_5__AB_0.x1_net5 VSS sky130_fd_pr__nfet_01v8 ad=0.406 pd=3.38 as=0.406 ps=3.38 w=1.4 l=0.6
X408 nmos_diode__A_0.bias_c nmos_diode__A_0.bias_b nmos_diode__A_0.bias_b VSS sky130_fd_pr__nfet_01v8_lvt ad=0.406 pd=3.38 as=0.406 ps=3.38 w=1.4 l=0.6
X409 VSS cmc nmos_single_5__A_0.x2_tail VSS sky130_fd_pr__nfet_01v8 ad=0.406 pd=3.38 as=0.406 ps=3.38 w=1.4 l=0.6
X410 VSS VSS VSS VSS sky130_fd_pr__nfet_01v8 ad=0.406 pd=3.38 as=0 ps=0 w=1.4 l=0.6
X411 VSS bias_a nmos_single_5__A_0.x2_tail VSS sky130_fd_pr__nfet_01v8 ad=0.406 pd=3.38 as=0.406 ps=3.38 w=1.4 l=0.6
X412 VSS cmc nmos_single_5__A_0.x2_tail VSS sky130_fd_pr__nfet_01v8 ad=0.406 pd=3.38 as=0.406 ps=3.38 w=1.4 l=0.6
X413 nmos_dummy_9__A_0.x1_m5d nmos_single__A_0.bias_d bias_a VSS sky130_fd_pr__nfet_01v8 ad=0.406 pd=3.38 as=0.406 ps=3.38 w=1.4 l=0.6
X414 nmos_diode__A_0.bias_c nmos_diode__A_0.bias_b nmos_diode__A_0.bias_b VSS sky130_fd_pr__nfet_01v8_lvt ad=0.406 pd=3.38 as=0.406 ps=3.38 w=1.4 l=0.6
X415 VSS cmc nmos_single_5__A_0.x2_tail VSS sky130_fd_pr__nfet_01v8 ad=0.406 pd=3.38 as=0.406 ps=3.38 w=1.4 l=0.6
X416 nmos_diode__A_0.bias_c nmos_diode__A_0.bias_c nmos_diode__A_0.bias_c VSS sky130_fd_pr__nfet_01v8 ad=0.406 pd=3.38 as=0 ps=0 w=1.4 l=0.6
X417 VSS VSS VSS VSS sky130_fd_pr__nfet_01v8 ad=0.406 pd=3.38 as=0 ps=0 w=1.4 l=0.6
X418 VSS cmc nmos_single_5__A_0.x2_tail VSS sky130_fd_pr__nfet_01v8 ad=0.406 pd=3.38 as=0.406 ps=3.38 w=1.4 l=0.6
X419 nmos_diode__A_0.bias_c nmos_diode__A_0.bias_c nmos_diode__A_0.bias_c VSS sky130_fd_pr__nfet_01v8_lvt ad=0.406 pd=3.38 as=0 ps=0 w=1.4 l=0.6
X420 VSS IBIAS nmos_diode__A_0.bias_c VSS sky130_fd_pr__nfet_01v8 ad=0.406 pd=3.38 as=0.406 ps=3.38 w=1.4 l=0.6
X421 nmos_dummy_18__A_0.x2_m4d nmos_single__A_0.bias_d op VSS sky130_fd_pr__nfet_01v8 ad=0.406 pd=3.38 as=0.406 ps=3.38 w=1.4 l=0.6
X422 VSS VSS VSS VSS sky130_fd_pr__nfet_01v8 ad=0.406 pd=3.38 as=0 ps=0 w=1.4 l=0.6
X423 cm cm cm VSS sky130_fd_pr__nfet_01v8 ad=0.406 pd=3.38 as=0 ps=0 w=1.4 l=0.6
X424 nmos_diode__A_0.bias_c nmos_diode__A_0.bias_b nmos_diode__A_0.bias_b VSS sky130_fd_pr__nfet_01v8_lvt ad=0.406 pd=3.38 as=0.406 ps=3.38 w=1.4 l=0.6
X425 VDD VDD op VDD sky130_fd_pr__pfet_01v8 ad=0.406 pd=3.38 as=0.406 ps=3.38 w=1.4 l=0.6
X426 VSS cmc nmos_single_5__A_0.x2_tail VSS sky130_fd_pr__nfet_01v8 ad=0.406 pd=3.38 as=0.406 ps=3.38 w=1.4 l=0.6
X427 VSS bias_a nmos_dummy_9__A_0.x1_m5d VSS sky130_fd_pr__nfet_01v8 ad=0.406 pd=3.38 as=0.406 ps=3.38 w=1.4 l=0.6
X428 pmos_dummy_17__A_0.x2_foldp nmos_diode__A_0.bias_c on VDD sky130_fd_pr__pfet_01v8 ad=0.406 pd=3.38 as=0.406 ps=3.38 w=1.4 l=0.6
X429 VSS cmc nmos_single_5__A_0.x2_tail VSS sky130_fd_pr__nfet_01v8 ad=0.406 pd=3.38 as=0.406 ps=3.38 w=1.4 l=0.6
X430 VSS cmc nmos_single_5__A_0.x2_tail VSS sky130_fd_pr__nfet_01v8 ad=0.406 pd=3.38 as=0.406 ps=3.38 w=1.4 l=0.6
X431 nmos_dummy_9__A_0.x1_m5d nmos_single__A_0.bias_d bias_a VSS sky130_fd_pr__nfet_01v8 ad=0.406 pd=3.38 as=0.406 ps=3.38 w=1.4 l=0.6
X432 VSS VSS VSS VSS sky130_fd_pr__nfet_01v8 ad=0.406 pd=3.38 as=0 ps=0 w=1.4 l=0.6
X433 pmos_single__A_0.x1_m31d nmos_diode__A_0.bias_c cm VDD sky130_fd_pr__pfet_01v8 ad=0.406 pd=3.38 as=0.406 ps=3.38 w=1.4 l=0.6
X434 VDD VDD VDD VDD sky130_fd_pr__pfet_01v8 ad=0.406 pd=3.38 as=0 ps=0 w=1.4 l=0.6
X435 VSS bias_a nmos_dummy_9__A_0.x1_m5d VSS sky130_fd_pr__nfet_01v8 ad=0.406 pd=3.38 as=0.406 ps=3.38 w=1.4 l=0.6
X436 VDD nmos_diode__A_0.bias_b pmos_dummy_16__A_0.x2_foldn VDD sky130_fd_pr__pfet_01v8_lvt ad=0.406 pd=3.38 as=0.406 ps=3.38 w=1.4 l=0.6
X437 VSS bias_a nmos_dummy_19__A_0.x2_m3d VSS sky130_fd_pr__nfet_01v8 ad=0.406 pd=3.38 as=0.406 ps=3.38 w=1.4 l=0.6
X438 VSS bias_a nmos_dummy_19__A_0.x2_m3d VSS sky130_fd_pr__nfet_01v8 ad=0.406 pd=3.38 as=0.406 ps=3.38 w=1.4 l=0.6
X439 VDD nmos_diode__A_0.bias_b pmos_dummy_16__A_0.x2_foldn VDD sky130_fd_pr__pfet_01v8_lvt ad=0.406 pd=3.38 as=0.406 ps=3.38 w=1.4 l=0.6
X440 VSS bias_a nmos_dummy_18__A_0.x2_m4d VSS sky130_fd_pr__nfet_01v8 ad=0.406 pd=3.38 as=0.406 ps=3.38 w=1.4 l=0.6
X441 VSS bias_a nmos_dummy_19__A_0.x2_m3d VSS sky130_fd_pr__nfet_01v8 ad=0.406 pd=3.38 as=0.406 ps=3.38 w=1.4 l=0.6
X442 VSS bias_a nmos_single_5__A_0.x2_tail VSS sky130_fd_pr__nfet_01v8 ad=0.406 pd=3.38 as=0.406 ps=3.38 w=1.4 l=0.6
X443 VDD nmos_diode__A_0.bias_b pmos_single__A_0.x1_m31d VDD sky130_fd_pr__pfet_01v8_lvt ad=0.406 pd=3.38 as=0.406 ps=3.38 w=1.4 l=0.6
X444 VDD nmos_diode__A_0.bias_b pmos_dummy_17__A_0.x2_foldp VDD sky130_fd_pr__pfet_01v8_lvt ad=0.406 pd=3.38 as=0.406 ps=3.38 w=1.4 l=0.6
X445 nmos_single_5__A_0.x2_tail ip pmos_dummy_17__A_0.x2_foldp VSS sky130_fd_pr__nfet_01v8_lvt ad=0.348 pd=2.98 as=0.348 ps=2.98 w=1.2 l=0.2
X446 IBIAS IBIAS VSS VSS sky130_fd_pr__nfet_01v8 ad=0.406 pd=3.38 as=0.406 ps=3.38 w=1.4 l=0.6
X447 nmos_matched_cascode_pair_5__AB_0.x1_net6 cm nmos_matched_cascode_pair_5__AB_0.x1_net5 VSS sky130_fd_pr__nfet_01v8 ad=0.406 pd=3.38 as=0.406 ps=3.38 w=1.4 l=0.6
X448 VDD nmos_diode__A_0.bias_b pmos_dummy_16__A_0.x2_foldn VDD sky130_fd_pr__pfet_01v8_lvt ad=0.406 pd=3.38 as=0.406 ps=3.38 w=1.4 l=0.6
X449 VSS cmc nmos_single_5__A_0.x2_tail VSS sky130_fd_pr__nfet_01v8 ad=0.406 pd=3.38 as=0.406 ps=3.38 w=1.4 l=0.6
X450 nmos_diode__A_0.bias_b nmos_diode__A_0.bias_b nmos_diode__A_0.bias_b VSS sky130_fd_pr__nfet_01v8_lvt ad=0.406 pd=3.38 as=0 ps=0 w=1.4 l=0.6
X451 nmos_diode__A_0.bias_c nmos_diode__A_0.bias_b nmos_diode__A_0.bias_b VSS sky130_fd_pr__nfet_01v8_lvt ad=0.406 pd=3.38 as=0.406 ps=3.38 w=1.4 l=0.6
X452 VDD nmos_diode__A_0.bias_b pmos_single__A_0.x1_m31d VDD sky130_fd_pr__pfet_01v8_lvt ad=0.406 pd=3.38 as=0.406 ps=3.38 w=1.4 l=0.6
X453 nmos_dummy_19__A_0.x2_m3d nmos_single__A_0.bias_d on VSS sky130_fd_pr__nfet_01v8 ad=0.406 pd=3.38 as=0.406 ps=3.38 w=1.4 l=0.6
X454 VSS bias_a nmos_dummy_19__A_0.x2_m3d VSS sky130_fd_pr__nfet_01v8 ad=0.406 pd=3.38 as=0.406 ps=3.38 w=1.4 l=0.6
X455 VSS bias_a nmos_dummy_19__A_0.x2_m3d VSS sky130_fd_pr__nfet_01v8 ad=0.406 pd=3.38 as=0.406 ps=3.38 w=1.4 l=0.6
X456 IBIAS IBIAS VSS VSS sky130_fd_pr__nfet_01v8 ad=0.406 pd=3.38 as=0.406 ps=3.38 w=1.4 l=0.6
X457 nmos_single__A_0.bias_d nmos_single__A_0.x1_m2d nmos_single__A_0.x1_m2d VSS sky130_fd_pr__nfet_01v8 ad=0.406 pd=3.38 as=0.406 ps=3.38 w=1.4 l=0.6
X458 VDD VDD pmos_dummy_17__A_0.x2_foldp VDD sky130_fd_pr__pfet_01v8 ad=0.406 pd=3.38 as=0.406 ps=3.38 w=1.4 l=0.6
X459 op nmos_single__A_0.bias_d nmos_dummy_18__A_0.x2_m4d VSS sky130_fd_pr__nfet_01v8 ad=0.406 pd=3.38 as=0.406 ps=3.38 w=1.4 l=0.6
X460 on nmos_single__A_0.bias_d nmos_dummy_19__A_0.x2_m3d VSS sky130_fd_pr__nfet_01v8 ad=0.406 pd=3.38 as=0.406 ps=3.38 w=1.4 l=0.6
X461 VSS VSS op VSS sky130_fd_pr__nfet_01v8 ad=0.406 pd=3.38 as=0.406 ps=3.38 w=1.4 l=0.6
X462 op nmos_single__A_0.bias_d nmos_dummy_18__A_0.x2_m4d VSS sky130_fd_pr__nfet_01v8 ad=0.406 pd=3.38 as=0.406 ps=3.38 w=1.4 l=0.6
X463 nmos_single__A_0.bias_d nmos_single__A_0.x1_m2d nmos_single__A_0.x1_m2d VSS sky130_fd_pr__nfet_01v8 ad=0.406 pd=3.38 as=0.406 ps=3.38 w=1.4 l=0.6
X464 nmos_diode__A_0.bias_c nmos_diode__A_0.bias_b nmos_diode__A_0.bias_b VSS sky130_fd_pr__nfet_01v8_lvt ad=0.406 pd=3.38 as=0.406 ps=3.38 w=1.4 l=0.6
X465 nmos_single_5__A_0.x2_tail in pmos_dummy_16__A_0.x2_foldn VSS sky130_fd_pr__nfet_01v8_lvt ad=0.348 pd=2.98 as=0.348 ps=2.98 w=1.2 l=0.2
X466 nmos_matched_cascode_pair_9__AB_0.x1_net12 cm VSS VSS sky130_fd_pr__nfet_01v8 ad=0.406 pd=3.38 as=0.406 ps=3.38 w=1.4 l=0.6
X467 VSS VSS nmos_dummy_19__A_0.x2_m3d VSS sky130_fd_pr__nfet_01v8 ad=0.406 pd=3.38 as=0.406 ps=3.38 w=1.4 l=0.6
X468 VSS bias_a nmos_single_5__A_0.x2_tail VSS sky130_fd_pr__nfet_01v8 ad=0.406 pd=3.38 as=0.406 ps=3.38 w=1.4 l=0.6
X469 nmos_dummy_19__A_0.x2_m3d nmos_single__A_0.bias_d on VSS sky130_fd_pr__nfet_01v8 ad=0.406 pd=3.38 as=0.406 ps=3.38 w=1.4 l=0.6
X470 op nmos_single__A_0.bias_d nmos_dummy_18__A_0.x2_m4d VSS sky130_fd_pr__nfet_01v8 ad=0.406 pd=3.38 as=0.406 ps=3.38 w=1.4 l=0.6
X471 VSS bias_a nmos_single_5__A_0.x2_tail VSS sky130_fd_pr__nfet_01v8 ad=0.406 pd=3.38 as=0.406 ps=3.38 w=1.4 l=0.6
X472 nmos_dummy_9__A_0.x1_m5d nmos_single__A_0.bias_d bias_a VSS sky130_fd_pr__nfet_01v8 ad=0.406 pd=3.38 as=0.406 ps=3.38 w=1.4 l=0.6
X473 VSS cmc nmos_single_5__A_0.x2_tail VSS sky130_fd_pr__nfet_01v8 ad=0.406 pd=3.38 as=0.406 ps=3.38 w=1.4 l=0.6
X474 VSS VSS VSS VSS sky130_fd_pr__nfet_01v8 ad=0.406 pd=3.38 as=0 ps=0 w=1.4 l=0.6
X475 VDD nmos_diode__A_0.bias_b pmos_dummy_17__A_0.x2_foldp VDD sky130_fd_pr__pfet_01v8_lvt ad=0.406 pd=3.38 as=0.406 ps=3.38 w=1.4 l=0.6
X476 VSS bias_a nmos_single_5__A_0.x2_tail VSS sky130_fd_pr__nfet_01v8 ad=0.406 pd=3.38 as=0.406 ps=3.38 w=1.4 l=0.6
X477 VSS cmc nmos_single_5__A_0.x2_tail VSS sky130_fd_pr__nfet_01v8 ad=0.406 pd=3.38 as=0.406 ps=3.38 w=1.4 l=0.6
X478 nmos_single__A_0.bias_d nmos_single__A_0.x1_m2d nmos_single__A_0.x1_m2d VSS sky130_fd_pr__nfet_01v8 ad=0.406 pd=3.38 as=0.406 ps=3.38 w=1.4 l=0.6
X479 nmos_diode__A_0.bias_c nmos_diode__A_0.bias_b nmos_diode__A_0.bias_b VSS sky130_fd_pr__nfet_01v8_lvt ad=0.406 pd=3.38 as=0.406 ps=3.38 w=1.4 l=0.6
X480 nmos_single__A_0.x1_m2d nmos_diode__A_0.bias_c pmos_dummy_7__A_0.x1_m25d VDD sky130_fd_pr__pfet_01v8 ad=0.406 pd=3.38 as=0.406 ps=3.38 w=1.4 l=0.6
X481 bias_a bias_a bias_a VSS sky130_fd_pr__nfet_01v8 ad=0.406 pd=3.38 as=0 ps=0 w=1.4 l=0.6
X482 op cmc sky130_fd_pr__cap_mim_m3_1 l=4.8 w=4.8
X483 nmos_single__A_0.bias_d nmos_single__A_0.x1_m2d nmos_single__A_0.x1_m2d VSS sky130_fd_pr__nfet_01v8 ad=0.406 pd=3.38 as=0.406 ps=3.38 w=1.4 l=0.6
X484 pmos_dummy_17__A_0.x2_foldp nmos_diode__A_0.bias_c on VDD sky130_fd_pr__pfet_01v8 ad=0.406 pd=3.38 as=0.406 ps=3.38 w=1.4 l=0.6
X485 VSS bias_a nmos_dummy_19__A_0.x2_m3d VSS sky130_fd_pr__nfet_01v8 ad=0.406 pd=3.38 as=0.406 ps=3.38 w=1.4 l=0.6
X486 VSS cmc nmos_single_5__A_0.x2_tail VSS sky130_fd_pr__nfet_01v8 ad=0.406 pd=3.38 as=0.406 ps=3.38 w=1.4 l=0.6
X487 VSS cmc nmos_single_5__A_0.x2_tail VSS sky130_fd_pr__nfet_01v8 ad=0.406 pd=3.38 as=0.406 ps=3.38 w=1.4 l=0.6
X488 nmos_diode__A_0.bias_c nmos_diode__A_0.bias_b nmos_diode__A_0.bias_b VSS sky130_fd_pr__nfet_01v8_lvt ad=0.406 pd=3.38 as=0.406 ps=3.38 w=1.4 l=0.6
X489 VSS bias_a nmos_single_5__A_0.x2_tail VSS sky130_fd_pr__nfet_01v8 ad=0.406 pd=3.38 as=0.406 ps=3.38 w=1.4 l=0.6
X490 VSS IBIAS nmos_diode__A_0.bias_c VSS sky130_fd_pr__nfet_01v8 ad=0.406 pd=3.38 as=0.406 ps=3.38 w=1.4 l=0.6
X491 VSS bias_a nmos_single_5__A_0.x2_tail VSS sky130_fd_pr__nfet_01v8 ad=0.406 pd=3.38 as=0.406 ps=3.38 w=1.4 l=0.6
X492 VDD nmos_diode__A_0.bias_b pmos_dummy_17__A_0.x2_foldp VDD sky130_fd_pr__pfet_01v8_lvt ad=0.406 pd=3.38 as=0.406 ps=3.38 w=1.4 l=0.6
X493 VSS bias_a nmos_single_5__A_0.x2_tail VSS sky130_fd_pr__nfet_01v8 ad=0.406 pd=3.38 as=0.406 ps=3.38 w=1.4 l=0.6
X494 nmos_diode__A_0.bias_c nmos_diode__A_0.bias_b nmos_diode__A_0.bias_b VSS sky130_fd_pr__nfet_01v8_lvt ad=0.406 pd=3.38 as=0.406 ps=3.38 w=1.4 l=0.6
X495 VSS cmc nmos_single_5__A_0.x2_tail VSS sky130_fd_pr__nfet_01v8 ad=0.406 pd=3.38 as=0.406 ps=3.38 w=1.4 l=0.6
X496 nmos_single__A_0.bias_d nmos_single__A_0.x1_m2d nmos_single__A_0.x1_m2d VSS sky130_fd_pr__nfet_01v8 ad=0.406 pd=3.38 as=0.406 ps=3.38 w=1.4 l=0.6
X497 nmos_single__A_0.bias_d nmos_single__A_0.x1_m2d nmos_single__A_0.x1_m2d VSS sky130_fd_pr__nfet_01v8 ad=0.406 pd=3.38 as=0.406 ps=3.38 w=1.4 l=0.6
X498 VSS cmc nmos_single_5__A_0.x2_tail VSS sky130_fd_pr__nfet_01v8 ad=0.406 pd=3.38 as=0.406 ps=3.38 w=1.4 l=0.6
X499 nmos_dummy_19__A_0.x2_m3d nmos_single__A_0.bias_d on VSS sky130_fd_pr__nfet_01v8 ad=0.406 pd=3.38 as=0.406 ps=3.38 w=1.4 l=0.6
X500 VSS bias_a nmos_dummy_18__A_0.x2_m4d VSS sky130_fd_pr__nfet_01v8 ad=0.406 pd=3.38 as=0.406 ps=3.38 w=1.4 l=0.6
X501 VSS bias_a nmos_single_5__A_0.x2_tail VSS sky130_fd_pr__nfet_01v8 ad=0.406 pd=3.38 as=0.406 ps=3.38 w=1.4 l=0.6
X502 cm cm cm VSS sky130_fd_pr__nfet_01v8 ad=0.406 pd=3.38 as=0 ps=0 w=1.4 l=0.6
X503 IBIAS IBIAS VSS VSS sky130_fd_pr__nfet_01v8 ad=0.406 pd=3.38 as=0.406 ps=3.38 w=1.4 l=0.6
X504 nmos_matched_cascode_pair_8__AB_0.x1_net10 cm nmos_matched_cascode_pair_9__AB_0.x1_net11 VSS sky130_fd_pr__nfet_01v8 ad=0.406 pd=3.38 as=0.406 ps=3.38 w=1.4 l=0.6
X505 VSS bias_a nmos_dummy_18__A_0.x2_m4d VSS sky130_fd_pr__nfet_01v8 ad=0.406 pd=3.38 as=0.406 ps=3.38 w=1.4 l=0.6
X506 VSS cmc nmos_single_5__A_0.x2_tail VSS sky130_fd_pr__nfet_01v8 ad=0.406 pd=3.38 as=0.406 ps=3.38 w=1.4 l=0.6
X507 VSS cmc nmos_single_5__A_0.x2_tail VSS sky130_fd_pr__nfet_01v8 ad=0.406 pd=3.38 as=0.406 ps=3.38 w=1.4 l=0.6
X508 VSS bias_a nmos_single_5__A_0.x2_tail VSS sky130_fd_pr__nfet_01v8 ad=0.406 pd=3.38 as=0.406 ps=3.38 w=1.4 l=0.6
X509 cm cm cm VSS sky130_fd_pr__nfet_01v8 ad=0.406 pd=3.38 as=0 ps=0 w=1.4 l=0.6
X510 VSS VSS VSS VSS sky130_fd_pr__nfet_01v8 ad=0.406 pd=3.38 as=0 ps=0 w=1.4 l=0.6
X511 nmos_diode__A_0.bias_c nmos_diode__A_0.bias_b nmos_diode__A_0.bias_b VSS sky130_fd_pr__nfet_01v8_lvt ad=0.406 pd=3.38 as=0.406 ps=3.38 w=1.4 l=0.6
X512 VSS bias_a nmos_single_5__A_0.x2_tail VSS sky130_fd_pr__nfet_01v8 ad=0.406 pd=3.38 as=0.406 ps=3.38 w=1.4 l=0.6
X513 VSS bias_a nmos_single_5__A_0.x2_tail VSS sky130_fd_pr__nfet_01v8 ad=0.406 pd=3.38 as=0.406 ps=3.38 w=1.4 l=0.6
X514 nmos_single__A_0.bias_d nmos_single__A_0.x1_m2d nmos_single__A_0.x1_m2d VSS sky130_fd_pr__nfet_01v8 ad=0.406 pd=3.38 as=0.406 ps=3.38 w=1.4 l=0.6
X515 VSS bias_a nmos_single_5__A_0.x2_tail VSS sky130_fd_pr__nfet_01v8 ad=0.406 pd=3.38 as=0.406 ps=3.38 w=1.4 l=0.6
X516 pmos_dummy_16__A_0.x2_foldn nmos_diode__A_0.bias_c op VDD sky130_fd_pr__pfet_01v8 ad=0.406 pd=3.38 as=0.406 ps=3.38 w=1.4 l=0.6
X517 VSS bias_a nmos_dummy_19__A_0.x2_m3d VSS sky130_fd_pr__nfet_01v8 ad=0.406 pd=3.38 as=0.406 ps=3.38 w=1.4 l=0.6
X518 VSS cmc nmos_single_5__A_0.x2_tail VSS sky130_fd_pr__nfet_01v8 ad=0.406 pd=3.38 as=0.406 ps=3.38 w=1.4 l=0.6
X519 nmos_diode__A_0.bias_c nmos_diode__A_0.bias_b nmos_diode__A_0.bias_b VSS sky130_fd_pr__nfet_01v8_lvt ad=0.406 pd=3.38 as=0.406 ps=3.38 w=1.4 l=0.6
X520 VSS bias_a nmos_dummy_18__A_0.x2_m4d VSS sky130_fd_pr__nfet_01v8 ad=0.406 pd=3.38 as=0.406 ps=3.38 w=1.4 l=0.6
X521 VSS cmc nmos_single_5__A_0.x2_tail VSS sky130_fd_pr__nfet_01v8 ad=0.406 pd=3.38 as=0.406 ps=3.38 w=1.4 l=0.6
X522 cm cm cm VSS sky130_fd_pr__nfet_01v8 ad=0.406 pd=3.38 as=0 ps=0 w=1.4 l=0.6
X523 VSS bias_a nmos_single_5__A_0.x2_tail VSS sky130_fd_pr__nfet_01v8 ad=0.406 pd=3.38 as=0.406 ps=3.38 w=1.4 l=0.6
X524 VSS cmc nmos_single_5__A_0.x2_tail VSS sky130_fd_pr__nfet_01v8 ad=0.406 pd=3.38 as=0.406 ps=3.38 w=1.4 l=0.6
X525 on nmos_single__A_0.bias_d nmos_dummy_19__A_0.x2_m3d VSS sky130_fd_pr__nfet_01v8 ad=0.406 pd=3.38 as=0.406 ps=3.38 w=1.4 l=0.6
X526 nmos_single__A_0.bias_d nmos_single__A_0.bias_d nmos_single__A_0.bias_d VSS sky130_fd_pr__nfet_01v8 ad=0.406 pd=3.38 as=0 ps=0 w=1.4 l=0.6
X527 VDD VDD VDD VDD sky130_fd_pr__pfet_01v8 ad=0.406 pd=3.38 as=0 ps=0 w=1.4 l=0.6
X528 pmos_dummy_16__A_0.x2_foldn nmos_diode__A_0.bias_c op VDD sky130_fd_pr__pfet_01v8 ad=0.406 pd=3.38 as=0.406 ps=3.38 w=1.4 l=0.6
X529 VSS bias_a nmos_single_5__A_0.x2_tail VSS sky130_fd_pr__nfet_01v8 ad=0.406 pd=3.38 as=0.406 ps=3.38 w=1.4 l=0.6
X530 nmos_diode__A_0.bias_c nmos_diode__A_0.bias_b nmos_diode__A_0.bias_b VSS sky130_fd_pr__nfet_01v8_lvt ad=0.406 pd=3.38 as=0.406 ps=3.38 w=1.4 l=0.6
X531 VDD nmos_diode__A_0.bias_b pmos_dummy_17__A_0.x2_foldp VDD sky130_fd_pr__pfet_01v8_lvt ad=0.406 pd=3.38 as=0.406 ps=3.38 w=1.4 l=0.6
X532 on nmos_single__A_0.bias_d nmos_dummy_19__A_0.x2_m3d VSS sky130_fd_pr__nfet_01v8 ad=0.406 pd=3.38 as=0.406 ps=3.38 w=1.4 l=0.6
X533 VSS bias_a nmos_single_5__A_0.x2_tail VSS sky130_fd_pr__nfet_01v8 ad=0.406 pd=3.38 as=0.406 ps=3.38 w=1.4 l=0.6
X534 VSS cmc nmos_single_5__A_0.x2_tail VSS sky130_fd_pr__nfet_01v8 ad=0.406 pd=3.38 as=0.406 ps=3.38 w=1.4 l=0.6
X535 VSS cmc nmos_single_5__A_0.x2_tail VSS sky130_fd_pr__nfet_01v8 ad=0.406 pd=3.38 as=0.406 ps=3.38 w=1.4 l=0.6
X536 VSS bias_a nmos_dummy_18__A_0.x2_m4d VSS sky130_fd_pr__nfet_01v8 ad=0.406 pd=3.38 as=0.406 ps=3.38 w=1.4 l=0.6
X537 VSS bias_a nmos_single_5__A_0.x2_tail VSS sky130_fd_pr__nfet_01v8 ad=0.406 pd=3.38 as=0.406 ps=3.38 w=1.4 l=0.6
X538 pmos_dummy_17__A_0.x2_foldp nmos_diode__A_0.bias_c on VDD sky130_fd_pr__pfet_01v8 ad=0.406 pd=3.38 as=0.406 ps=3.38 w=1.4 l=0.6
X539 VSS bias_a nmos_dummy_9__A_0.x1_m5d VSS sky130_fd_pr__nfet_01v8 ad=0.406 pd=3.38 as=0.406 ps=3.38 w=1.4 l=0.6
X540 VSS bias_a nmos_dummy_19__A_0.x2_m3d VSS sky130_fd_pr__nfet_01v8 ad=0.406 pd=3.38 as=0.406 ps=3.38 w=1.4 l=0.6
X541 nmos_diode__A_0.bias_b nmos_diode__A_0.bias_b nmos_diode__A_0.bias_b VSS sky130_fd_pr__nfet_01v8_lvt ad=0.406 pd=3.38 as=0 ps=0 w=1.4 l=0.6
X542 nmos_single_5__A_0.x2_tail ip pmos_dummy_17__A_0.x2_foldp VSS sky130_fd_pr__nfet_01v8_lvt ad=0.348 pd=2.98 as=0.348 ps=2.98 w=1.2 l=0.2
X543 op nmos_single__A_0.bias_d nmos_dummy_18__A_0.x2_m4d VSS sky130_fd_pr__nfet_01v8 ad=0.406 pd=3.38 as=0.406 ps=3.38 w=1.4 l=0.6
X544 VDD VDD op VDD sky130_fd_pr__pfet_01v8 ad=0.406 pd=3.38 as=0.406 ps=3.38 w=1.4 l=0.6
X545 VSS bias_a nmos_single_5__A_0.x2_tail VSS sky130_fd_pr__nfet_01v8 ad=0.406 pd=3.38 as=0.406 ps=3.38 w=1.4 l=0.6
X546 nmos_diode__A_0.bias_c nmos_diode__A_0.bias_b nmos_diode__A_0.bias_b VSS sky130_fd_pr__nfet_01v8_lvt ad=0.406 pd=3.38 as=0.406 ps=3.38 w=1.4 l=0.6
X547 nmos_dummy_18__A_0.x2_m4d nmos_single__A_0.bias_d op VSS sky130_fd_pr__nfet_01v8 ad=0.406 pd=3.38 as=0.406 ps=3.38 w=1.4 l=0.6
X548 nmos_dummy_9__A_0.x1_m5d nmos_dummy_9__A_0.x1_m5d nmos_dummy_9__A_0.x1_m5d VSS sky130_fd_pr__nfet_01v8 ad=0.406 pd=3.38 as=0 ps=0 w=1.4 l=0.6
X549 pmos_dummy_17__A_0.x2_foldp nmos_diode__A_0.bias_c on VDD sky130_fd_pr__pfet_01v8 ad=0.406 pd=3.38 as=0.406 ps=3.38 w=1.4 l=0.6
X550 VSS VSS VSS VSS sky130_fd_pr__nfet_01v8 ad=0.406 pd=3.38 as=0 ps=0 w=1.4 l=0.6
X551 VSS IBIAS IBIAS VSS sky130_fd_pr__nfet_01v8 ad=0.406 pd=3.38 as=0.406 ps=3.38 w=1.4 l=0.6
X552 VSS VSS VSS VSS sky130_fd_pr__nfet_01v8 ad=0.406 pd=3.38 as=0 ps=0 w=1.4 l=0.6
X553 nmos_diode__A_0.bias_c nmos_diode__A_0.bias_b nmos_diode__A_0.bias_b VSS sky130_fd_pr__nfet_01v8_lvt ad=0.406 pd=3.38 as=0.406 ps=3.38 w=1.4 l=0.6
X554 nmos_dummy_18__A_0.x2_m4d nmos_single__A_0.bias_d op VSS sky130_fd_pr__nfet_01v8 ad=0.406 pd=3.38 as=0.406 ps=3.38 w=1.4 l=0.6
X555 VSS cmc nmos_single_5__A_0.x2_tail VSS sky130_fd_pr__nfet_01v8 ad=0.406 pd=3.38 as=0.406 ps=3.38 w=1.4 l=0.6
X556 nmos_dummy_19__A_0.x2_m3d nmos_single__A_0.bias_d on VSS sky130_fd_pr__nfet_01v8 ad=0.406 pd=3.38 as=0.406 ps=3.38 w=1.4 l=0.6
X557 VSS bias_a nmos_dummy_18__A_0.x2_m4d VSS sky130_fd_pr__nfet_01v8 ad=0.406 pd=3.38 as=0.406 ps=3.38 w=1.4 l=0.6
X558 VSS VSS nmos_dummy_18__A_0.x2_m4d VSS sky130_fd_pr__nfet_01v8 ad=0.406 pd=3.38 as=0.406 ps=3.38 w=1.4 l=0.6
X559 VSS IBIAS IBIAS VSS sky130_fd_pr__nfet_01v8 ad=0.406 pd=3.38 as=0.406 ps=3.38 w=1.4 l=0.6
X560 VSS bias_a nmos_dummy_18__A_0.x2_m4d VSS sky130_fd_pr__nfet_01v8 ad=0.406 pd=3.38 as=0.406 ps=3.38 w=1.4 l=0.6
X561 VSS VSS VSS VSS sky130_fd_pr__nfet_01v8 ad=0.406 pd=3.38 as=0 ps=0 w=1.4 l=0.6
X562 nmos_single__A_0.bias_d nmos_single__A_0.x1_m2d nmos_single__A_0.x1_m2d VSS sky130_fd_pr__nfet_01v8 ad=0.406 pd=3.38 as=0.406 ps=3.38 w=1.4 l=0.6
X563 VSS cmc nmos_single_5__A_0.x2_tail VSS sky130_fd_pr__nfet_01v8 ad=0.406 pd=3.38 as=0.406 ps=3.38 w=1.4 l=0.6
X564 VSS VSS VSS VSS sky130_fd_pr__nfet_01v8 ad=0.406 pd=3.38 as=0 ps=0 w=1.4 l=0.6
X565 VSS VSS nmos_dummy_18__A_0.x2_m4d VSS sky130_fd_pr__nfet_01v8 ad=0.406 pd=3.38 as=0.406 ps=3.38 w=1.4 l=0.6
X566 VDD nmos_diode__A_0.bias_b pmos_dummy_16__A_0.x2_foldn VDD sky130_fd_pr__pfet_01v8_lvt ad=0.406 pd=3.38 as=0.406 ps=3.38 w=1.4 l=0.6
X567 VSS VSS VSS VSS sky130_fd_pr__nfet_01v8 ad=0.406 pd=3.38 as=0 ps=0 w=1.4 l=0.6
X568 nmos_diode__A_0.bias_c nmos_diode__A_0.bias_b nmos_diode__A_0.bias_b VSS sky130_fd_pr__nfet_01v8_lvt ad=0.406 pd=3.38 as=0.406 ps=3.38 w=1.4 l=0.6
X569 VSS IBIAS IBIAS VSS sky130_fd_pr__nfet_01v8 ad=0.406 pd=3.38 as=0.406 ps=3.38 w=1.4 l=0.6
X570 nmos_diode__A_0.bias_c nmos_diode__A_0.bias_c nmos_diode__A_0.bias_c VSS sky130_fd_pr__nfet_01v8_lvt ad=0.406 pd=3.38 as=0 ps=0 w=1.4 l=0.6
X571 nmos_matched_cascode_pair_3__AB_0.x1_net3 cm nmos_matched_cascode_pair_3__AB_0.x1_net2 VSS sky130_fd_pr__nfet_01v8 ad=0.406 pd=3.38 as=0.406 ps=3.38 w=1.4 l=0.6
X572 nmos_dummy_9__A_0.x1_m5d nmos_single__A_0.bias_d bias_a VSS sky130_fd_pr__nfet_01v8 ad=0.406 pd=3.38 as=0.406 ps=3.38 w=1.4 l=0.6
X573 nmos_diode__A_0.bias_c nmos_diode__A_0.bias_b nmos_diode__A_0.bias_b VSS sky130_fd_pr__nfet_01v8_lvt ad=0.406 pd=3.38 as=0.406 ps=3.38 w=1.4 l=0.6
X574 VDD nmos_diode__A_0.bias_b pmos_dummy_16__A_0.x2_foldn VDD sky130_fd_pr__pfet_01v8_lvt ad=0.406 pd=3.38 as=0.406 ps=3.38 w=1.4 l=0.6
X575 nmos_dummy_18__A_0.x2_m4d nmos_single__A_0.bias_d op VSS sky130_fd_pr__nfet_01v8 ad=0.406 pd=3.38 as=0.406 ps=3.38 w=1.4 l=0.6
X576 VSS cmc nmos_single_5__A_0.x2_tail VSS sky130_fd_pr__nfet_01v8 ad=0.406 pd=3.38 as=0.406 ps=3.38 w=1.4 l=0.6
X577 bias_a nmos_single__A_0.x1_m2d nmos_single__A_0.bias_d VSS sky130_fd_pr__nfet_01v8 ad=0.406 pd=3.38 as=0.406 ps=3.38 w=1.4 l=0.6
X578 on nmos_single__A_0.bias_d nmos_dummy_19__A_0.x2_m3d VSS sky130_fd_pr__nfet_01v8 ad=0.406 pd=3.38 as=0.406 ps=3.38 w=1.4 l=0.6
X579 nmos_single__A_0.bias_d nmos_single__A_0.x1_m2d nmos_single__A_0.x1_m2d VSS sky130_fd_pr__nfet_01v8 ad=0.406 pd=3.38 as=0.406 ps=3.38 w=1.4 l=0.6
X580 VSS bias_a nmos_single_5__A_0.x2_tail VSS sky130_fd_pr__nfet_01v8 ad=0.406 pd=3.38 as=0.406 ps=3.38 w=1.4 l=0.6
X581 VSS cmc nmos_single_5__A_0.x2_tail VSS sky130_fd_pr__nfet_01v8 ad=0.406 pd=3.38 as=0.406 ps=3.38 w=1.4 l=0.6
X582 VSS VSS VSS VSS sky130_fd_pr__nfet_01v8 ad=0.406 pd=3.38 as=0 ps=0 w=1.4 l=0.6
X583 nmos_single_5__A_0.x2_tail in pmos_dummy_16__A_0.x2_foldn VSS sky130_fd_pr__nfet_01v8_lvt ad=0.348 pd=2.98 as=0.348 ps=2.98 w=1.2 l=0.2
X584 nmos_single__A_0.bias_d nmos_single__A_0.x1_m2d nmos_single__A_0.x1_m2d VSS sky130_fd_pr__nfet_01v8 ad=0.406 pd=3.38 as=0.406 ps=3.38 w=1.4 l=0.6
X585 VDD nmos_diode__A_0.bias_b pmos_dummy_17__A_0.x2_foldp VDD sky130_fd_pr__pfet_01v8_lvt ad=0.406 pd=3.38 as=0.406 ps=3.38 w=1.4 l=0.6
X586 nmos_matched_cascode_pair_6__AB_0.x1_net7 cm nmos_matched_cascode_pair_7__AB_0.x1_net8 VSS sky130_fd_pr__nfet_01v8 ad=0.406 pd=3.38 as=0.406 ps=3.38 w=1.4 l=0.6
X587 nmos_single__A_0.bias_d nmos_single__A_0.x1_m2d nmos_single__A_0.x1_m2d VSS sky130_fd_pr__nfet_01v8 ad=0.406 pd=3.38 as=0.406 ps=3.38 w=1.4 l=0.6
X588 nmos_diode__A_0.bias_c nmos_diode__A_0.bias_b nmos_diode__A_0.bias_b VSS sky130_fd_pr__nfet_01v8_lvt ad=0.406 pd=3.38 as=0.406 ps=3.38 w=1.4 l=0.6
X589 VSS cmc nmos_single_5__A_0.x2_tail VSS sky130_fd_pr__nfet_01v8 ad=0.406 pd=3.38 as=0.406 ps=3.38 w=1.4 l=0.6
X590 VSS IBIAS IBIAS VSS sky130_fd_pr__nfet_01v8 ad=0.406 pd=3.38 as=0.406 ps=3.38 w=1.4 l=0.6
X591 VSS bias_a nmos_single_5__A_0.x2_tail VSS sky130_fd_pr__nfet_01v8 ad=0.406 pd=3.38 as=0.406 ps=3.38 w=1.4 l=0.6
X592 pmos_dummy_17__A_0.x2_foldp nmos_diode__A_0.bias_c on VDD sky130_fd_pr__pfet_01v8 ad=0.406 pd=3.38 as=0.406 ps=3.38 w=1.4 l=0.6
X593 VSS bias_a nmos_single_5__A_0.x2_tail VSS sky130_fd_pr__nfet_01v8 ad=0.406 pd=3.38 as=0.406 ps=3.38 w=1.4 l=0.6
X594 pmos_single__A_0.x1_m31d nmos_diode__A_0.bias_c cm VDD sky130_fd_pr__pfet_01v8 ad=0.406 pd=3.38 as=0.406 ps=3.38 w=1.4 l=0.6
X595 IBIAS IBIAS VSS VSS sky130_fd_pr__nfet_01v8 ad=0.406 pd=3.38 as=0.406 ps=3.38 w=1.4 l=0.6
X596 VDD VDD pmos_dummy_16__A_0.x2_foldn VDD sky130_fd_pr__pfet_01v8 ad=0.406 pd=3.38 as=0.406 ps=3.38 w=1.4 l=0.6
X597 VSS bias_a nmos_dummy_19__A_0.x2_m3d VSS sky130_fd_pr__nfet_01v8 ad=0.406 pd=3.38 as=0.406 ps=3.38 w=1.4 l=0.6
X598 VDD nmos_diode__A_0.bias_b pmos_dummy_17__A_0.x2_foldp VDD sky130_fd_pr__pfet_01v8_lvt ad=0.406 pd=3.38 as=0.406 ps=3.38 w=1.4 l=0.6
X599 VSS bias_a nmos_single_5__A_0.x2_tail VSS sky130_fd_pr__nfet_01v8 ad=0.406 pd=3.38 as=0.406 ps=3.38 w=1.4 l=0.6
X600 nmos_dummy_9__A_0.x1_m5d nmos_single__A_0.bias_d bias_a VSS sky130_fd_pr__nfet_01v8 ad=0.406 pd=3.38 as=0.406 ps=3.38 w=1.4 l=0.6
X601 nmos_diode__A_0.bias_c nmos_diode__A_0.bias_b nmos_diode__A_0.bias_b VSS sky130_fd_pr__nfet_01v8_lvt ad=0.406 pd=3.38 as=0.406 ps=3.38 w=1.4 l=0.6
X602 pmos_dummy_17__A_0.x2_foldp nmos_diode__A_0.bias_c on VDD sky130_fd_pr__pfet_01v8 ad=0.406 pd=3.38 as=0.406 ps=3.38 w=1.4 l=0.6
X603 VSS bias_a nmos_single_5__A_0.x2_tail VSS sky130_fd_pr__nfet_01v8 ad=0.406 pd=3.38 as=0.406 ps=3.38 w=1.4 l=0.6
X604 VSS bias_a nmos_single_5__A_0.x2_tail VSS sky130_fd_pr__nfet_01v8 ad=0.406 pd=3.38 as=0.406 ps=3.38 w=1.4 l=0.6
X605 VSS bias_a nmos_dummy_9__A_0.x1_m5d VSS sky130_fd_pr__nfet_01v8 ad=0.406 pd=3.38 as=0.406 ps=3.38 w=1.4 l=0.6
X606 VDD VDD on VDD sky130_fd_pr__pfet_01v8 ad=0.406 pd=3.38 as=0.406 ps=3.38 w=1.4 l=0.6
X607 VDD VDD VDD VDD sky130_fd_pr__pfet_01v8 ad=0.406 pd=3.38 as=0 ps=0 w=1.4 l=0.6
X608 VSS bias_a nmos_dummy_19__A_0.x2_m3d VSS sky130_fd_pr__nfet_01v8 ad=0.406 pd=3.38 as=0.406 ps=3.38 w=1.4 l=0.6
X609 VSS bias_a nmos_dummy_18__A_0.x2_m4d VSS sky130_fd_pr__nfet_01v8 ad=0.406 pd=3.38 as=0.406 ps=3.38 w=1.4 l=0.6
X610 VSS bias_a nmos_single_5__A_0.x2_tail VSS sky130_fd_pr__nfet_01v8 ad=0.406 pd=3.38 as=0.406 ps=3.38 w=1.4 l=0.6
X611 pmos_single__A_0.x1_m31d pmos_single__A_0.x1_m31d pmos_single__A_0.x1_m31d VDD sky130_fd_pr__pfet_01v8_lvt ad=0.406 pd=3.38 as=7.308 ps=60.84 w=1.4 l=0.6
X612 pmos_dummy_16__A_0.x2_foldn pmos_dummy_16__A_0.x2_foldn pmos_dummy_16__A_0.x2_foldn VDD sky130_fd_pr__pfet_01v8 ad=0.406 pd=3.38 as=0 ps=0 w=1.4 l=0.6
X613 VSS bias_a nmos_dummy_18__A_0.x2_m4d VSS sky130_fd_pr__nfet_01v8 ad=0.406 pd=3.38 as=0.406 ps=3.38 w=1.4 l=0.6
X614 VSS bias_a nmos_single_5__A_0.x2_tail VSS sky130_fd_pr__nfet_01v8 ad=0.406 pd=3.38 as=0.406 ps=3.38 w=1.4 l=0.6
X615 VSS cmc nmos_single_5__A_0.x2_tail VSS sky130_fd_pr__nfet_01v8 ad=0.406 pd=3.38 as=0.406 ps=3.38 w=1.4 l=0.6
X616 nmos_single__A_0.bias_d nmos_single__A_0.x1_m2d nmos_single__A_0.x1_m2d VSS sky130_fd_pr__nfet_01v8 ad=0.406 pd=3.38 as=0.406 ps=3.38 w=1.4 l=0.6
X617 nmos_diode__A_0.bias_c nmos_diode__A_0.bias_b nmos_diode__A_0.bias_b VSS sky130_fd_pr__nfet_01v8_lvt ad=0.406 pd=3.38 as=0.406 ps=3.38 w=1.4 l=0.6
X618 nmos_dummy_19__A_0.x2_m3d nmos_single__A_0.bias_d on VSS sky130_fd_pr__nfet_01v8 ad=0.406 pd=3.38 as=0.406 ps=3.38 w=1.4 l=0.6
X619 on cmc sky130_fd_pr__cap_mim_m3_1 l=4.8 w=4.8
X620 nmos_diode__A_0.bias_c IBIAS VSS VSS sky130_fd_pr__nfet_01v8 ad=0.406 pd=3.38 as=0.406 ps=3.38 w=1.4 l=0.6
X621 VSS VSS VSS VSS sky130_fd_pr__nfet_01v8 ad=0.406 pd=3.38 as=0 ps=0 w=1.4 l=0.6
X622 VSS bias_a nmos_dummy_18__A_0.x2_m4d VSS sky130_fd_pr__nfet_01v8 ad=0.406 pd=3.38 as=0.406 ps=3.38 w=1.4 l=0.6
X623 VSS cmc nmos_single_5__A_0.x2_tail VSS sky130_fd_pr__nfet_01v8 ad=0.406 pd=3.38 as=0.406 ps=3.38 w=1.4 l=0.6
X624 VSS cmc nmos_single_5__A_0.x2_tail VSS sky130_fd_pr__nfet_01v8 ad=0.406 pd=3.38 as=0.406 ps=3.38 w=1.4 l=0.6
X625 VSS bias_a nmos_dummy_9__A_0.x1_m5d VSS sky130_fd_pr__nfet_01v8 ad=0.406 pd=3.38 as=0.406 ps=3.38 w=1.4 l=0.6
X626 VSS cmc nmos_single_5__A_0.x2_tail VSS sky130_fd_pr__nfet_01v8 ad=0.406 pd=3.38 as=0.406 ps=3.38 w=1.4 l=0.6
X627 nmos_diode__A_0.bias_c nmos_diode__A_0.bias_b nmos_diode__A_0.bias_b VSS sky130_fd_pr__nfet_01v8_lvt ad=0.406 pd=3.38 as=0.406 ps=3.38 w=1.4 l=0.6
X628 nmos_single__A_0.bias_d nmos_single__A_0.x1_m2d nmos_single__A_0.x1_m2d VSS sky130_fd_pr__nfet_01v8 ad=0.406 pd=3.38 as=0.406 ps=3.38 w=1.4 l=0.6
X629 VDD VDD pmos_single__A_0.x1_m31d VDD sky130_fd_pr__pfet_01v8 ad=0.406 pd=3.38 as=0.406 ps=3.38 w=1.4 l=0.6
X630 nmos_diode__A_0.bias_c nmos_diode__A_0.bias_b nmos_diode__A_0.bias_b VSS sky130_fd_pr__nfet_01v8_lvt ad=0.406 pd=3.38 as=0.406 ps=3.38 w=1.4 l=0.6
X631 VSS bias_a nmos_single_5__A_0.x2_tail VSS sky130_fd_pr__nfet_01v8 ad=0.406 pd=3.38 as=0.406 ps=3.38 w=1.4 l=0.6
X632 VSS cmc nmos_single_5__A_0.x2_tail VSS sky130_fd_pr__nfet_01v8 ad=0.406 pd=3.38 as=0.406 ps=3.38 w=1.4 l=0.6
X633 op nmos_single__A_0.bias_d nmos_dummy_18__A_0.x2_m4d VSS sky130_fd_pr__nfet_01v8 ad=0.406 pd=3.38 as=0.406 ps=3.38 w=1.4 l=0.6
X634 VSS VSS VSS VSS sky130_fd_pr__nfet_01v8 ad=0.406 pd=3.38 as=0 ps=0 w=1.4 l=0.6
X635 nmos_dummy_18__A_0.x2_m4d nmos_single__A_0.bias_d op VSS sky130_fd_pr__nfet_01v8 ad=0.406 pd=3.38 as=0.406 ps=3.38 w=1.4 l=0.6
X636 VSS cmc nmos_single_5__A_0.x2_tail VSS sky130_fd_pr__nfet_01v8 ad=0.406 pd=3.38 as=0.406 ps=3.38 w=1.4 l=0.6
X637 IBIAS IBIAS IBIAS VSS sky130_fd_pr__nfet_01v8 ad=0.406 pd=3.38 as=0 ps=0 w=1.4 l=0.6
X638 VSS bias_a nmos_dummy_19__A_0.x2_m3d VSS sky130_fd_pr__nfet_01v8 ad=0.406 pd=3.38 as=0.406 ps=3.38 w=1.4 l=0.6
X639 on nmos_single__A_0.bias_d nmos_dummy_19__A_0.x2_m3d VSS sky130_fd_pr__nfet_01v8 ad=0.406 pd=3.38 as=0.406 ps=3.38 w=1.4 l=0.6
X640 VSS bias_a nmos_single_5__A_0.x2_tail VSS sky130_fd_pr__nfet_01v8 ad=0.406 pd=3.38 as=0.406 ps=3.38 w=1.4 l=0.6
X641 VSS bias_a nmos_single_5__A_0.x2_tail VSS sky130_fd_pr__nfet_01v8 ad=0.406 pd=3.38 as=0.406 ps=3.38 w=1.4 l=0.6
X642 pmos_dummy_7__A_0.x1_m25d nmos_diode__A_0.bias_b VDD VDD sky130_fd_pr__pfet_01v8_lvt ad=0.406 pd=3.38 as=0.406 ps=3.38 w=1.4 l=0.6
X643 VSS bias_a nmos_single_5__A_0.x2_tail VSS sky130_fd_pr__nfet_01v8 ad=0.406 pd=3.38 as=0.406 ps=3.38 w=1.4 l=0.6
X644 nmos_dummy_9__A_0.x1_m5d nmos_single__A_0.bias_d bias_a VSS sky130_fd_pr__nfet_01v8 ad=0.406 pd=3.38 as=0.406 ps=3.38 w=1.4 l=0.6
X645 pmos_dummy_16__A_0.x2_foldn nmos_diode__A_0.bias_c op VDD sky130_fd_pr__pfet_01v8 ad=0.406 pd=3.38 as=0.406 ps=3.38 w=1.4 l=0.6
X646 VSS cmc nmos_single_5__A_0.x2_tail VSS sky130_fd_pr__nfet_01v8 ad=0.406 pd=3.38 as=0.406 ps=3.38 w=1.4 l=0.6
X647 VSS cmc nmos_single_5__A_0.x2_tail VSS sky130_fd_pr__nfet_01v8 ad=0.406 pd=3.38 as=0.406 ps=3.38 w=1.4 l=0.6
X648 on nmos_single__A_0.bias_d nmos_dummy_19__A_0.x2_m3d VSS sky130_fd_pr__nfet_01v8 ad=0.406 pd=3.38 as=0.406 ps=3.38 w=1.4 l=0.6
X649 nmos_dummy_9__A_0.x1_m5d nmos_dummy_9__A_0.x1_m5d nmos_dummy_9__A_0.x1_m5d VSS sky130_fd_pr__nfet_01v8 ad=0.406 pd=3.38 as=0 ps=0 w=1.4 l=0.6
X650 pmos_dummy_6__A_0.x1_m21d pmos_dummy_6__A_0.x1_m21d pmos_dummy_6__A_0.x1_m21d VDD sky130_fd_pr__pfet_01v8_lvt ad=0.406 pd=3.38 as=0 ps=0 w=1.4 l=0.6
X651 VSS bias_a nmos_single_5__A_0.x2_tail VSS sky130_fd_pr__nfet_01v8 ad=0.406 pd=3.38 as=0.406 ps=3.38 w=1.4 l=0.6
X652 VSS cmc nmos_single_5__A_0.x2_tail VSS sky130_fd_pr__nfet_01v8 ad=0.406 pd=3.38 as=0.406 ps=3.38 w=1.4 l=0.6
X653 VDD nmos_diode__A_0.bias_b pmos_dummy_17__A_0.x2_foldp VDD sky130_fd_pr__pfet_01v8_lvt ad=0.406 pd=3.38 as=0.406 ps=3.38 w=1.4 l=0.6
X654 VSS VSS nmos_dummy_19__A_0.x2_m3d VSS sky130_fd_pr__nfet_01v8 ad=0.406 pd=3.38 as=0.406 ps=3.38 w=1.4 l=0.6
X655 nmos_diode__A_0.bias_c nmos_diode__A_0.bias_b nmos_diode__A_0.bias_b VSS sky130_fd_pr__nfet_01v8_lvt ad=0.406 pd=3.38 as=0.406 ps=3.38 w=1.4 l=0.6
X656 pmos_dummy_17__A_0.x2_foldp nmos_diode__A_0.bias_c on VDD sky130_fd_pr__pfet_01v8 ad=0.406 pd=3.38 as=0.406 ps=3.38 w=1.4 l=0.6
X657 VSS bias_a nmos_single_5__A_0.x2_tail VSS sky130_fd_pr__nfet_01v8 ad=0.406 pd=3.38 as=0.406 ps=3.38 w=1.4 l=0.6
X658 VSS bias_a nmos_dummy_18__A_0.x2_m4d VSS sky130_fd_pr__nfet_01v8 ad=0.406 pd=3.38 as=0.406 ps=3.38 w=1.4 l=0.6
X659 bias_a bias_a bias_a VSS sky130_fd_pr__nfet_01v8 ad=0.406 pd=3.38 as=0 ps=0 w=1.4 l=0.6
X660 pmos_dummy_16__A_0.x2_foldn nmos_diode__A_0.bias_c op VDD sky130_fd_pr__pfet_01v8 ad=0.406 pd=3.38 as=0.406 ps=3.38 w=1.4 l=0.6
X661 nmos_diode__A_0.bias_c nmos_diode__A_0.bias_b nmos_diode__A_0.bias_b VSS sky130_fd_pr__nfet_01v8_lvt ad=0.406 pd=3.38 as=0.406 ps=3.38 w=1.4 l=0.6
X662 VSS bias_a nmos_dummy_19__A_0.x2_m3d VSS sky130_fd_pr__nfet_01v8 ad=0.406 pd=3.38 as=0.406 ps=3.38 w=1.4 l=0.6
X663 VSS bias_a nmos_single_5__A_0.x2_tail VSS sky130_fd_pr__nfet_01v8 ad=0.406 pd=3.38 as=0.406 ps=3.38 w=1.4 l=0.6
X664 VDD VDD VDD VDD sky130_fd_pr__pfet_01v8_lvt ad=0.406 pd=3.38 as=0 ps=0 w=1.4 l=0.6
X665 nmos_diode__A_0.bias_c nmos_diode__A_0.bias_b nmos_diode__A_0.bias_b VSS sky130_fd_pr__nfet_01v8_lvt ad=0.406 pd=3.38 as=0.406 ps=3.38 w=1.4 l=0.6
X666 pmos_dummy_6__A_0.x1_m21d pmos_dummy_6__A_0.x1_m21d pmos_dummy_6__A_0.x1_m21d VDD sky130_fd_pr__pfet_01v8_lvt ad=0.406 pd=3.38 as=0 ps=0 w=1.4 l=0.6
X667 VDD nmos_diode__A_0.bias_b pmos_dummy_17__A_0.x2_foldp VDD sky130_fd_pr__pfet_01v8_lvt ad=0.406 pd=3.38 as=0.406 ps=3.38 w=1.4 l=0.6
X668 nmos_single_5__A_0.x2_tail nmos_single_5__A_0.x2_tail nmos_single_5__A_0.x2_tail VSS sky130_fd_pr__nfet_01v8 ad=0.406 pd=3.38 as=0 ps=0 w=1.4 l=0.6
X669 VSS bias_a nmos_single_5__A_0.x2_tail VSS sky130_fd_pr__nfet_01v8 ad=0.406 pd=3.38 as=0.406 ps=3.38 w=1.4 l=0.6
X670 nmos_single__A_0.bias_d nmos_single__A_0.x1_m2d nmos_single__A_0.x1_m2d VSS sky130_fd_pr__nfet_01v8 ad=0.406 pd=3.38 as=0.406 ps=3.38 w=1.4 l=0.6
X671 op nmos_single__A_0.bias_d nmos_dummy_18__A_0.x2_m4d VSS sky130_fd_pr__nfet_01v8 ad=0.406 pd=3.38 as=0.406 ps=3.38 w=1.4 l=0.6
X672 nmos_single_5__A_0.x2_tail ip pmos_dummy_17__A_0.x2_foldp VSS sky130_fd_pr__nfet_01v8_lvt ad=0.348 pd=2.98 as=0.348 ps=2.98 w=1.2 l=0.2
X673 VSS bias_a nmos_single_5__A_0.x2_tail VSS sky130_fd_pr__nfet_01v8 ad=0.406 pd=3.38 as=0.406 ps=3.38 w=1.4 l=0.6
X674 VDD nmos_diode__A_0.bias_b pmos_dummy_6__A_0.x1_m21d VDD sky130_fd_pr__pfet_01v8_lvt ad=0.406 pd=3.38 as=0.406 ps=3.38 w=1.4 l=0.6
X675 VSS IBIAS nmos_diode__A_0.bias_c VSS sky130_fd_pr__nfet_01v8 ad=0.406 pd=3.38 as=0.406 ps=3.38 w=1.4 l=0.6
X676 nmos_matched_cascode_pair_10__AB_0.x1_net13 cm cm VSS sky130_fd_pr__nfet_01v8 ad=0.406 pd=3.38 as=0.406 ps=3.38 w=1.4 l=0.6
X677 pmos_dummy_16__A_0.x2_foldn nmos_diode__A_0.bias_c op VDD sky130_fd_pr__pfet_01v8 ad=0.406 pd=3.38 as=0.406 ps=3.38 w=1.4 l=0.6
X678 VSS VSS VSS VSS sky130_fd_pr__nfet_01v8 ad=0.406 pd=3.38 as=0 ps=0 w=1.4 l=0.6
X679 VSS VSS VSS VSS sky130_fd_pr__nfet_01v8 ad=0.406 pd=3.38 as=0 ps=0 w=1.4 l=0.6
X680 VSS bias_a nmos_dummy_19__A_0.x2_m3d VSS sky130_fd_pr__nfet_01v8 ad=0.406 pd=3.38 as=0.406 ps=3.38 w=1.4 l=0.6
X681 VSS bias_a nmos_single_5__A_0.x2_tail VSS sky130_fd_pr__nfet_01v8 ad=0.406 pd=3.38 as=0.406 ps=3.38 w=1.4 l=0.6
X682 VSS bias_a nmos_single_5__A_0.x2_tail VSS sky130_fd_pr__nfet_01v8 ad=0.406 pd=3.38 as=0.406 ps=3.38 w=1.4 l=0.6
X683 VSS cmc nmos_single_5__A_0.x2_tail VSS sky130_fd_pr__nfet_01v8 ad=0.406 pd=3.38 as=0.406 ps=3.38 w=1.4 l=0.6
X684 VSS bias_a nmos_dummy_18__A_0.x2_m4d VSS sky130_fd_pr__nfet_01v8 ad=0.406 pd=3.38 as=0.406 ps=3.38 w=1.4 l=0.6
X685 VDD VDD VDD VDD sky130_fd_pr__pfet_01v8_lvt ad=0.406 pd=3.38 as=0 ps=0 w=1.4 l=0.6
X686 on nmos_single__A_0.bias_d nmos_dummy_19__A_0.x2_m3d VSS sky130_fd_pr__nfet_01v8 ad=0.406 pd=3.38 as=0.406 ps=3.38 w=1.4 l=0.6
X687 nmos_diode__A_0.bias_c nmos_diode__A_0.bias_b nmos_diode__A_0.bias_b VSS sky130_fd_pr__nfet_01v8_lvt ad=0.406 pd=3.38 as=0.406 ps=3.38 w=1.4 l=0.6
X688 VSS VSS VSS VSS sky130_fd_pr__nfet_01v8 ad=0.406 pd=3.38 as=0 ps=0 w=1.4 l=0.6
X689 nmos_dummy_19__A_0.x2_m3d nmos_single__A_0.bias_d on VSS sky130_fd_pr__nfet_01v8 ad=0.406 pd=3.38 as=0.406 ps=3.38 w=1.4 l=0.6
X690 VSS cmc nmos_single_5__A_0.x2_tail VSS sky130_fd_pr__nfet_01v8 ad=0.406 pd=3.38 as=0.406 ps=3.38 w=1.4 l=0.6
X691 VDD VDD VDD VDD sky130_fd_pr__pfet_01v8 ad=0.406 pd=3.38 as=0 ps=0 w=1.4 l=0.6
X692 VSS VSS nmos_dummy_9__A_0.x1_m5d VSS sky130_fd_pr__nfet_01v8 ad=0.406 pd=3.38 as=0.406 ps=3.38 w=1.4 l=0.6
X693 VDD VDD VDD VDD sky130_fd_pr__pfet_01v8_lvt ad=0.406 pd=3.38 as=0 ps=0 w=1.4 l=0.6
X694 VDD VDD nmos_single__A_0.x1_m2d VDD sky130_fd_pr__pfet_01v8 ad=0.406 pd=3.38 as=0.406 ps=3.38 w=1.4 l=0.6
X695 VSS IBIAS nmos_diode__A_0.bias_c VSS sky130_fd_pr__nfet_01v8 ad=0.406 pd=3.38 as=0.406 ps=3.38 w=1.4 l=0.6
X696 nmos_matched_cascode_pair_8__AB_0.x1_net10 cm cm VSS sky130_fd_pr__nfet_01v8 ad=0.406 pd=3.38 as=0.406 ps=3.38 w=1.4 l=0.6
X697 VSS cmc nmos_single_5__A_0.x2_tail VSS sky130_fd_pr__nfet_01v8 ad=0.406 pd=3.38 as=0.406 ps=3.38 w=1.4 l=0.6
X698 op nmos_single__A_0.bias_d nmos_dummy_18__A_0.x2_m4d VSS sky130_fd_pr__nfet_01v8 ad=0.406 pd=3.38 as=0.406 ps=3.38 w=1.4 l=0.6
X699 cm cm cm VSS sky130_fd_pr__nfet_01v8 ad=0.406 pd=3.38 as=0 ps=0 w=1.4 l=0.6
X700 nmos_dummy_9__A_0.x1_m5d nmos_single__A_0.bias_d bias_a VSS sky130_fd_pr__nfet_01v8 ad=0.406 pd=3.38 as=0.406 ps=3.38 w=1.4 l=0.6
X701 nmos_diode__A_0.bias_c nmos_diode__A_0.bias_b nmos_diode__A_0.bias_b VSS sky130_fd_pr__nfet_01v8_lvt ad=0.406 pd=3.38 as=0.406 ps=3.38 w=1.4 l=0.6
X702 nmos_dummy_18__A_0.x2_m4d nmos_single__A_0.bias_d op VSS sky130_fd_pr__nfet_01v8 ad=0.406 pd=3.38 as=0.406 ps=3.38 w=1.4 l=0.6
X703 pmos_dummy_17__A_0.x2_foldp pmos_dummy_17__A_0.x2_foldp pmos_dummy_17__A_0.x2_foldp VSS sky130_fd_pr__nfet_01v8_lvt ad=0.348 pd=2.98 as=3.48 ps=29.8 w=1.2 l=0.2
X704 VSS bias_a nmos_single_5__A_0.x2_tail VSS sky130_fd_pr__nfet_01v8 ad=0.406 pd=3.38 as=0.406 ps=3.38 w=1.4 l=0.6
X705 VSS bias_a nmos_dummy_9__A_0.x1_m5d VSS sky130_fd_pr__nfet_01v8 ad=0.406 pd=3.38 as=0.406 ps=3.38 w=1.4 l=0.6
X706 VSS VSS VSS VSS sky130_fd_pr__nfet_01v8 ad=0.406 pd=3.38 as=0 ps=0 w=1.4 l=0.6
X707 VDD VDD on VDD sky130_fd_pr__pfet_01v8 ad=0.406 pd=3.38 as=0.406 ps=3.38 w=1.4 l=0.6
X708 VSS bias_a nmos_dummy_19__A_0.x2_m3d VSS sky130_fd_pr__nfet_01v8 ad=0.406 pd=3.38 as=0.406 ps=3.38 w=1.4 l=0.6
X709 VSS cmc nmos_single_5__A_0.x2_tail VSS sky130_fd_pr__nfet_01v8 ad=0.406 pd=3.38 as=0.406 ps=3.38 w=1.4 l=0.6
X710 VSS cmc nmos_single_5__A_0.x2_tail VSS sky130_fd_pr__nfet_01v8 ad=0.406 pd=3.38 as=0.406 ps=3.38 w=1.4 l=0.6
X711 nmos_single__A_0.bias_d nmos_single__A_0.bias_d nmos_single__A_0.bias_d VSS sky130_fd_pr__nfet_01v8 ad=0.406 pd=3.38 as=0 ps=0 w=1.4 l=0.6
X712 nmos_diode__A_0.bias_c IBIAS VSS VSS sky130_fd_pr__nfet_01v8 ad=0.406 pd=3.38 as=0.406 ps=3.38 w=1.4 l=0.6
X713 nmos_single__A_0.bias_d nmos_single__A_0.x1_m2d nmos_single__A_0.x1_m2d VSS sky130_fd_pr__nfet_01v8 ad=0.406 pd=3.38 as=0.406 ps=3.38 w=1.4 l=0.6
X714 VDD nmos_diode__A_0.bias_b pmos_dummy_16__A_0.x2_foldn VDD sky130_fd_pr__pfet_01v8_lvt ad=0.406 pd=3.38 as=0.406 ps=3.38 w=1.4 l=0.6
X715 pmos_dummy_16__A_0.x2_foldn pmos_dummy_16__A_0.x2_foldn pmos_dummy_16__A_0.x2_foldn VSS sky130_fd_pr__nfet_01v8_lvt ad=0.348 pd=2.98 as=0 ps=0 w=1.2 l=0.2
X716 nmos_single__A_0.bias_d nmos_single__A_0.x1_m2d nmos_single__A_0.x1_m2d VSS sky130_fd_pr__nfet_01v8 ad=0.406 pd=3.38 as=0.406 ps=3.38 w=1.4 l=0.6
X717 VSS cmc nmos_single_5__A_0.x2_tail VSS sky130_fd_pr__nfet_01v8 ad=0.406 pd=3.38 as=0.406 ps=3.38 w=1.4 l=0.6
X718 VDD nmos_diode__A_0.bias_b pmos_dummy_17__A_0.x2_foldp VDD sky130_fd_pr__pfet_01v8_lvt ad=0.406 pd=3.38 as=0.406 ps=3.38 w=1.4 l=0.6
X719 VSS bias_a nmos_dummy_19__A_0.x2_m3d VSS sky130_fd_pr__nfet_01v8 ad=0.406 pd=3.38 as=0.406 ps=3.38 w=1.4 l=0.6
X720 pmos_single__A_0.x1_m31d nmos_diode__A_0.bias_c cm VDD sky130_fd_pr__pfet_01v8 ad=0.406 pd=3.38 as=0.406 ps=3.38 w=1.4 l=0.6
X721 VDD nmos_diode__A_0.bias_b pmos_dummy_16__A_0.x2_foldn VDD sky130_fd_pr__pfet_01v8_lvt ad=0.406 pd=3.38 as=0.406 ps=3.38 w=1.4 l=0.6
X722 nmos_diode__A_0.bias_c nmos_diode__A_0.bias_b nmos_diode__A_0.bias_b VSS sky130_fd_pr__nfet_01v8_lvt ad=0.406 pd=3.38 as=0.406 ps=3.38 w=1.4 l=0.6
X723 pmos_dummy_16__A_0.x2_foldn nmos_diode__A_0.bias_c op VDD sky130_fd_pr__pfet_01v8 ad=0.406 pd=3.38 as=0.406 ps=3.38 w=1.4 l=0.6
X724 VSS bias_a nmos_dummy_19__A_0.x2_m3d VSS sky130_fd_pr__nfet_01v8 ad=0.406 pd=3.38 as=0.406 ps=3.38 w=1.4 l=0.6
X725 VDD nmos_diode__A_0.bias_b pmos_single__A_0.x1_m31d VDD sky130_fd_pr__pfet_01v8_lvt ad=0.406 pd=3.38 as=0.406 ps=3.38 w=1.4 l=0.6
X726 nmos_single_5__A_0.x2_tail ip pmos_dummy_17__A_0.x2_foldp VSS sky130_fd_pr__nfet_01v8_lvt ad=0.348 pd=2.98 as=0.348 ps=2.98 w=1.2 l=0.2
X727 VSS bias_a nmos_dummy_18__A_0.x2_m4d VSS sky130_fd_pr__nfet_01v8 ad=0.406 pd=3.38 as=0.406 ps=3.38 w=1.4 l=0.6
X728 VSS bias_a nmos_single_5__A_0.x2_tail VSS sky130_fd_pr__nfet_01v8 ad=0.406 pd=3.38 as=0.406 ps=3.38 w=1.4 l=0.6
X729 pmos_single__A_0.x1_m31d nmos_diode__A_0.bias_c cm VDD sky130_fd_pr__pfet_01v8 ad=0.406 pd=3.38 as=0.406 ps=3.38 w=1.4 l=0.6
X730 nmos_diode__A_0.bias_b nmos_diode__A_0.bias_b nmos_diode__A_0.bias_b VSS sky130_fd_pr__nfet_01v8_lvt ad=0.406 pd=3.38 as=0 ps=0 w=1.4 l=0.6
X731 IBIAS IBIAS VSS VSS sky130_fd_pr__nfet_01v8 ad=0.406 pd=3.38 as=0.406 ps=3.38 w=1.4 l=0.6
X732 VDD nmos_diode__A_0.bias_b pmos_dummy_16__A_0.x2_foldn VDD sky130_fd_pr__pfet_01v8_lvt ad=0.406 pd=3.38 as=0.406 ps=3.38 w=1.4 l=0.6
X733 op nmos_single__A_0.bias_d nmos_dummy_18__A_0.x2_m4d VSS sky130_fd_pr__nfet_01v8 ad=0.406 pd=3.38 as=0.406 ps=3.38 w=1.4 l=0.6
X734 VSS VSS VSS VSS sky130_fd_pr__nfet_01v8 ad=0.406 pd=3.38 as=0 ps=0 w=1.4 l=0.6
X735 nmos_diode__A_0.bias_c nmos_diode__A_0.bias_b nmos_diode__A_0.bias_b VSS sky130_fd_pr__nfet_01v8_lvt ad=0.406 pd=3.38 as=0.406 ps=3.38 w=1.4 l=0.6
X736 VDD VDD VDD VDD sky130_fd_pr__pfet_01v8_lvt ad=0.406 pd=3.38 as=0 ps=0 w=1.4 l=0.6
X737 VSS bias_a nmos_single_5__A_0.x2_tail VSS sky130_fd_pr__nfet_01v8 ad=0.406 pd=3.38 as=0.406 ps=3.38 w=1.4 l=0.6
X738 VSS bias_a nmos_single_5__A_0.x2_tail VSS sky130_fd_pr__nfet_01v8 ad=0.406 pd=3.38 as=0.406 ps=3.38 w=1.4 l=0.6
X739 nmos_diode__A_0.bias_b nmos_diode__A_0.bias_b nmos_diode__A_0.bias_b VSS sky130_fd_pr__nfet_01v8_lvt ad=0.406 pd=3.38 as=0 ps=0 w=1.4 l=0.6
X740 op nmos_single__A_0.bias_d nmos_dummy_18__A_0.x2_m4d VSS sky130_fd_pr__nfet_01v8 ad=0.406 pd=3.38 as=0.406 ps=3.38 w=1.4 l=0.6
X741 nmos_single__A_0.bias_d nmos_single__A_0.x1_m2d nmos_single__A_0.x1_m2d VSS sky130_fd_pr__nfet_01v8 ad=0.406 pd=3.38 as=0.406 ps=3.38 w=1.4 l=0.6
X742 nmos_dummy_19__A_0.x2_m3d nmos_single__A_0.bias_d on VSS sky130_fd_pr__nfet_01v8 ad=0.406 pd=3.38 as=0.406 ps=3.38 w=1.4 l=0.6
X743 VSS bias_a nmos_single_5__A_0.x2_tail VSS sky130_fd_pr__nfet_01v8 ad=0.406 pd=3.38 as=0.406 ps=3.38 w=1.4 l=0.6
X744 nmos_dummy_18__A_0.x2_m4d nmos_single__A_0.bias_d op VSS sky130_fd_pr__nfet_01v8 ad=0.406 pd=3.38 as=0.406 ps=3.38 w=1.4 l=0.6
X745 VSS bias_a nmos_single_5__A_0.x2_tail VSS sky130_fd_pr__nfet_01v8 ad=0.406 pd=3.38 as=0.406 ps=3.38 w=1.4 l=0.6
X746 nmos_single__A_0.bias_d nmos_single__A_0.x1_m2d nmos_single__A_0.x1_m2d VSS sky130_fd_pr__nfet_01v8 ad=0.406 pd=3.38 as=0.406 ps=3.38 w=1.4 l=0.6
X747 pmos_dummy_7__A_0.x1_m25d pmos_dummy_7__A_0.x1_m25d pmos_dummy_7__A_0.x1_m25d VDD sky130_fd_pr__pfet_01v8 ad=0.406 pd=3.38 as=0 ps=0 w=1.4 l=0.6
X748 VSS bias_a nmos_dummy_18__A_0.x2_m4d VSS sky130_fd_pr__nfet_01v8 ad=0.406 pd=3.38 as=0.406 ps=3.38 w=1.4 l=0.6
X749 VSS bias_a nmos_single_5__A_0.x2_tail VSS sky130_fd_pr__nfet_01v8 ad=0.406 pd=3.38 as=0.406 ps=3.38 w=1.4 l=0.6
X750 nmos_diode__A_0.bias_c nmos_diode__A_0.bias_b nmos_diode__A_0.bias_b VSS sky130_fd_pr__nfet_01v8_lvt ad=0.406 pd=3.38 as=0.406 ps=3.38 w=1.4 l=0.6
X751 VDD VDD pmos_single__A_0.x1_m31d VDD sky130_fd_pr__pfet_01v8 ad=0.406 pd=3.38 as=0.406 ps=3.38 w=1.4 l=0.6
X752 VSS IBIAS nmos_diode__A_0.bias_c VSS sky130_fd_pr__nfet_01v8 ad=0.406 pd=3.38 as=0.406 ps=3.38 w=1.4 l=0.6
X753 pmos_dummy_17__A_0.x2_foldp nmos_diode__A_0.bias_c on VDD sky130_fd_pr__pfet_01v8 ad=0.406 pd=3.38 as=0.406 ps=3.38 w=1.4 l=0.6
X754 VSS bias_a nmos_single_5__A_0.x2_tail VSS sky130_fd_pr__nfet_01v8 ad=0.406 pd=3.38 as=0.406 ps=3.38 w=1.4 l=0.6
X755 VSS cmc nmos_single_5__A_0.x2_tail VSS sky130_fd_pr__nfet_01v8 ad=0.406 pd=3.38 as=0.406 ps=3.38 w=1.4 l=0.6
X756 VSS VSS VSS VSS sky130_fd_pr__nfet_01v8 ad=0.406 pd=3.38 as=0 ps=0 w=1.4 l=0.6
X757 nmos_matched_cascode_pair_2__AB_0.x1_net1 cm nmos_matched_cascode_pair_3__AB_0.x1_net2 VSS sky130_fd_pr__nfet_01v8 ad=0.406 pd=3.38 as=0.406 ps=3.38 w=1.4 l=0.6
X758 pmos_dummy_6__A_0.x1_m21d nmos_diode__A_0.bias_b VDD VDD sky130_fd_pr__pfet_01v8_lvt ad=0.406 pd=3.38 as=0.406 ps=3.38 w=1.4 l=0.6
X759 nmos_diode__A_0.bias_b nmos_diode__A_0.bias_c pmos_dummy_6__A_0.x1_m21d VDD sky130_fd_pr__pfet_01v8 ad=0.406 pd=3.38 as=0.406 ps=3.38 w=1.4 l=0.6
X760 VSS bias_a nmos_dummy_19__A_0.x2_m3d VSS sky130_fd_pr__nfet_01v8 ad=0.406 pd=3.38 as=0.406 ps=3.38 w=1.4 l=0.6
X761 VSS bias_a nmos_single_5__A_0.x2_tail VSS sky130_fd_pr__nfet_01v8 ad=0.406 pd=3.38 as=0.406 ps=3.38 w=1.4 l=0.6
X762 pmos_dummy_17__A_0.x2_foldp pmos_dummy_17__A_0.x2_foldp pmos_dummy_17__A_0.x2_foldp VSS sky130_fd_pr__nfet_01v8_lvt ad=0.348 pd=2.98 as=0 ps=0 w=1.2 l=0.2
X763 VSS bias_a nmos_single_5__A_0.x2_tail VSS sky130_fd_pr__nfet_01v8 ad=0.406 pd=3.38 as=0.406 ps=3.38 w=1.4 l=0.6
X764 VSS cmc nmos_single_5__A_0.x2_tail VSS sky130_fd_pr__nfet_01v8 ad=0.406 pd=3.38 as=0.406 ps=3.38 w=1.4 l=0.6
X765 VSS bias_a nmos_dummy_19__A_0.x2_m3d VSS sky130_fd_pr__nfet_01v8 ad=0.406 pd=3.38 as=0.406 ps=3.38 w=1.4 l=0.6
X766 VSS cmc nmos_single_5__A_0.x2_tail VSS sky130_fd_pr__nfet_01v8 ad=0.406 pd=3.38 as=0.406 ps=3.38 w=1.4 l=0.6
X767 VSS VSS VSS VSS sky130_fd_pr__nfet_01v8 ad=0.406 pd=3.38 as=0 ps=0 w=1.4 l=0.6
X768 nmos_dummy_9__A_0.x1_m5d nmos_dummy_9__A_0.x1_m5d nmos_dummy_9__A_0.x1_m5d VSS sky130_fd_pr__nfet_01v8 ad=0.406 pd=3.38 as=0 ps=0 w=1.4 l=0.6
X769 nmos_single__A_0.bias_d nmos_single__A_0.x1_m2d nmos_single__A_0.x1_m2d VSS sky130_fd_pr__nfet_01v8 ad=0.406 pd=3.38 as=0.406 ps=3.38 w=1.4 l=0.6
X770 VSS bias_a nmos_dummy_19__A_0.x2_m3d VSS sky130_fd_pr__nfet_01v8 ad=0.406 pd=3.38 as=0.406 ps=3.38 w=1.4 l=0.6
X771 nmos_matched_cascode_pair_3__AB_0.x1_net3 cm VSS VSS sky130_fd_pr__nfet_01v8 ad=0.406 pd=3.38 as=0.406 ps=3.38 w=1.4 l=0.6
X772 nmos_diode__A_0.bias_c nmos_diode__A_0.bias_b nmos_diode__A_0.bias_b VSS sky130_fd_pr__nfet_01v8_lvt ad=0.406 pd=3.38 as=0.406 ps=3.38 w=1.4 l=0.6
X773 pmos_dummy_17__A_0.x2_foldp nmos_diode__A_0.bias_c on VDD sky130_fd_pr__pfet_01v8 ad=0.406 pd=3.38 as=0.406 ps=3.38 w=1.4 l=0.6
X774 nmos_dummy_18__A_0.x2_m4d nmos_single__A_0.bias_d op VSS sky130_fd_pr__nfet_01v8 ad=0.406 pd=3.38 as=0.406 ps=3.38 w=1.4 l=0.6
X775 bias_a bias_a bias_a VSS sky130_fd_pr__nfet_01v8 ad=0.406 pd=3.38 as=0 ps=0 w=1.4 l=0.6
X776 pmos_dummy_6__A_0.x1_m21d nmos_diode__A_0.bias_c nmos_diode__A_0.bias_b VDD sky130_fd_pr__pfet_01v8 ad=0.406 pd=3.38 as=0.406 ps=3.38 w=1.4 l=0.6
X777 VDD nmos_diode__A_0.bias_b pmos_dummy_16__A_0.x2_foldn VDD sky130_fd_pr__pfet_01v8_lvt ad=0.406 pd=3.38 as=0.406 ps=3.38 w=1.4 l=0.6
X778 VSS cmc nmos_single_5__A_0.x2_tail VSS sky130_fd_pr__nfet_01v8 ad=0.406 pd=3.38 as=0.406 ps=3.38 w=1.4 l=0.6
X779 nmos_dummy_9__A_0.x1_m5d nmos_dummy_9__A_0.x1_m5d nmos_dummy_9__A_0.x1_m5d VSS sky130_fd_pr__nfet_01v8 ad=0.406 pd=3.38 as=0 ps=0 w=1.4 l=0.6
X780 VSS IBIAS nmos_diode__A_0.bias_c VSS sky130_fd_pr__nfet_01v8 ad=0.406 pd=3.38 as=0.406 ps=3.38 w=1.4 l=0.6
X781 VSS bias_a nmos_single_5__A_0.x2_tail VSS sky130_fd_pr__nfet_01v8 ad=0.406 pd=3.38 as=0.406 ps=3.38 w=1.4 l=0.6
X782 VSS bias_a nmos_single_5__A_0.x2_tail VSS sky130_fd_pr__nfet_01v8 ad=0.406 pd=3.38 as=0.406 ps=3.38 w=1.4 l=0.6
X783 VDD VDD VDD VDD sky130_fd_pr__pfet_01v8_lvt ad=0.406 pd=3.38 as=0 ps=0 w=1.4 l=0.6
X784 nmos_dummy_9__A_0.x1_m5d nmos_single__A_0.bias_d bias_a VSS sky130_fd_pr__nfet_01v8 ad=0.406 pd=3.38 as=0.406 ps=3.38 w=1.4 l=0.6
X785 VSS VSS on VSS sky130_fd_pr__nfet_01v8 ad=0.406 pd=3.38 as=0.406 ps=3.38 w=1.4 l=0.6
X786 pmos_dummy_17__A_0.x2_foldp pmos_dummy_17__A_0.x2_foldp pmos_dummy_17__A_0.x2_foldp VDD sky130_fd_pr__pfet_01v8 ad=0.406 pd=3.38 as=0 ps=0 w=1.4 l=0.6
X787 op nmos_single__A_0.bias_d nmos_dummy_18__A_0.x2_m4d VSS sky130_fd_pr__nfet_01v8 ad=0.406 pd=3.38 as=0.406 ps=3.38 w=1.4 l=0.6
X788 VDD nmos_diode__A_0.bias_b pmos_dummy_7__A_0.x1_m25d VDD sky130_fd_pr__pfet_01v8_lvt ad=0.406 pd=3.38 as=0.406 ps=3.38 w=1.4 l=0.6
X789 VSS VSS VSS VSS sky130_fd_pr__nfet_01v8 ad=0.406 pd=3.38 as=0 ps=0 w=1.4 l=0.6
X790 bias_a nmos_single__A_0.x1_m2d nmos_single__A_0.bias_d VSS sky130_fd_pr__nfet_01v8 ad=0.406 pd=3.38 as=0.406 ps=3.38 w=1.4 l=0.6
X791 VSS bias_a nmos_dummy_9__A_0.x1_m5d VSS sky130_fd_pr__nfet_01v8 ad=0.406 pd=3.38 as=0.406 ps=3.38 w=1.4 l=0.6
X792 nmos_single__A_0.bias_d nmos_single__A_0.x1_m2d nmos_single__A_0.x1_m2d VSS sky130_fd_pr__nfet_01v8 ad=0.406 pd=3.38 as=0.406 ps=3.38 w=1.4 l=0.6
X793 VDD nmos_diode__A_0.bias_b pmos_dummy_16__A_0.x2_foldn VDD sky130_fd_pr__pfet_01v8_lvt ad=0.406 pd=3.38 as=0.406 ps=3.38 w=1.4 l=0.6
X794 VSS bias_a nmos_single_5__A_0.x2_tail VSS sky130_fd_pr__nfet_01v8 ad=0.406 pd=3.38 as=0.406 ps=3.38 w=1.4 l=0.6
X795 nmos_diode__A_0.bias_c IBIAS VSS VSS sky130_fd_pr__nfet_01v8 ad=0.406 pd=3.38 as=0.406 ps=3.38 w=1.4 l=0.6
X796 nmos_diode__A_0.bias_c nmos_diode__A_0.bias_b nmos_diode__A_0.bias_b VSS sky130_fd_pr__nfet_01v8_lvt ad=0.406 pd=3.38 as=0.406 ps=3.38 w=1.4 l=0.6
X797 nmos_dummy_19__A_0.x2_m3d nmos_single__A_0.bias_d on VSS sky130_fd_pr__nfet_01v8 ad=0.406 pd=3.38 as=0.406 ps=3.38 w=1.4 l=0.6
X798 nmos_single_5__A_0.x2_tail nmos_single_5__A_0.x2_tail nmos_single_5__A_0.x2_tail VSS sky130_fd_pr__nfet_01v8 ad=0.406 pd=3.38 as=0 ps=0 w=1.4 l=0.6
X799 VSS cmc nmos_single_5__A_0.x2_tail VSS sky130_fd_pr__nfet_01v8 ad=0.406 pd=3.38 as=0.406 ps=3.38 w=1.4 l=0.6
X800 nmos_single__A_0.bias_d nmos_single__A_0.x1_m2d nmos_single__A_0.x1_m2d VSS sky130_fd_pr__nfet_01v8 ad=0.406 pd=3.38 as=0.406 ps=3.38 w=1.4 l=0.6
X801 VSS bias_a nmos_single_5__A_0.x2_tail VSS sky130_fd_pr__nfet_01v8 ad=0.406 pd=3.38 as=0.406 ps=3.38 w=1.4 l=0.6
X802 op nmos_single__A_0.bias_d nmos_dummy_18__A_0.x2_m4d VSS sky130_fd_pr__nfet_01v8 ad=0.406 pd=3.38 as=0.406 ps=3.38 w=1.4 l=0.6
X803 VSS bias_a nmos_single_5__A_0.x2_tail VSS sky130_fd_pr__nfet_01v8 ad=0.406 pd=3.38 as=0.406 ps=3.38 w=1.4 l=0.6
X804 VSS VSS nmos_dummy_9__A_0.x1_m5d VSS sky130_fd_pr__nfet_01v8 ad=0.406 pd=3.38 as=0.406 ps=3.38 w=1.4 l=0.6
X805 VSS VSS VSS VSS sky130_fd_pr__nfet_01v8 ad=0.406 pd=3.38 as=0 ps=0 w=1.4 l=0.6
X806 VSS bias_a nmos_single_5__A_0.x2_tail VSS sky130_fd_pr__nfet_01v8 ad=0.406 pd=3.38 as=0.406 ps=3.38 w=1.4 l=0.6
X807 VSS bias_a nmos_single_5__A_0.x2_tail VSS sky130_fd_pr__nfet_01v8 ad=0.406 pd=3.38 as=0.406 ps=3.38 w=1.4 l=0.6
X808 VSS bias_a nmos_dummy_18__A_0.x2_m4d VSS sky130_fd_pr__nfet_01v8 ad=0.406 pd=3.38 as=0.406 ps=3.38 w=1.4 l=0.6
X809 IBIAS IBIAS VSS VSS sky130_fd_pr__nfet_01v8 ad=0.406 pd=3.38 as=0.406 ps=3.38 w=1.4 l=0.6
X810 VSS VSS VSS VSS sky130_fd_pr__nfet_01v8 ad=0.406 pd=3.38 as=0 ps=0 w=1.4 l=0.6
X811 VDD nmos_diode__A_0.bias_b pmos_dummy_17__A_0.x2_foldp VDD sky130_fd_pr__pfet_01v8_lvt ad=0.406 pd=3.38 as=0.406 ps=3.38 w=1.4 l=0.6
X812 VSS VSS VSS VSS sky130_fd_pr__nfet_01v8_lvt ad=0.348 pd=2.98 as=0 ps=0 w=1.2 l=0.2
X813 VSS bias_a nmos_dummy_18__A_0.x2_m4d VSS sky130_fd_pr__nfet_01v8 ad=0.406 pd=3.38 as=0.406 ps=3.38 w=1.4 l=0.6
X814 VSS bias_a nmos_single_5__A_0.x2_tail VSS sky130_fd_pr__nfet_01v8 ad=0.406 pd=3.38 as=0.406 ps=3.38 w=1.4 l=0.6
X815 VDD VDD VDD VDD sky130_fd_pr__pfet_01v8 ad=0.406 pd=3.38 as=0 ps=0 w=1.4 l=0.6
X816 nmos_dummy_9__A_0.x1_m5d nmos_single__A_0.bias_d bias_a VSS sky130_fd_pr__nfet_01v8 ad=0.406 pd=3.38 as=0.406 ps=3.38 w=1.4 l=0.6
X817 nmos_diode__A_0.bias_c nmos_diode__A_0.bias_b nmos_diode__A_0.bias_b VSS sky130_fd_pr__nfet_01v8_lvt ad=0.406 pd=3.38 as=0.406 ps=3.38 w=1.4 l=0.6
X818 pmos_dummy_16__A_0.x2_foldn nmos_diode__A_0.bias_c op VDD sky130_fd_pr__pfet_01v8 ad=0.406 pd=3.38 as=0.406 ps=3.38 w=1.4 l=0.6
X819 VSS bias_a nmos_single_5__A_0.x2_tail VSS sky130_fd_pr__nfet_01v8 ad=0.406 pd=3.38 as=0.406 ps=3.38 w=1.4 l=0.6
X820 nmos_single__A_0.bias_d nmos_single__A_0.x1_m2d nmos_single__A_0.x1_m2d VSS sky130_fd_pr__nfet_01v8 ad=0.406 pd=3.38 as=0.406 ps=3.38 w=1.4 l=0.6
X821 pmos_single__A_0.x1_m31d pmos_single__A_0.x1_m31d pmos_single__A_0.x1_m31d VDD sky130_fd_pr__pfet_01v8_lvt ad=0.406 pd=3.38 as=0 ps=0 w=1.4 l=0.6
X822 nmos_diode__A_0.bias_c nmos_diode__A_0.bias_b nmos_diode__A_0.bias_b VSS sky130_fd_pr__nfet_01v8_lvt ad=0.406 pd=3.38 as=0.406 ps=3.38 w=1.4 l=0.6
X823 pmos_dummy_17__A_0.x2_foldp nmos_diode__A_0.bias_c on VDD sky130_fd_pr__pfet_01v8 ad=0.406 pd=3.38 as=0.406 ps=3.38 w=1.4 l=0.6
X824 VSS VSS VSS VSS sky130_fd_pr__nfet_01v8 ad=0.406 pd=3.38 as=0 ps=0 w=1.4 l=0.6
X825 pmos_dummy_16__A_0.x2_foldn nmos_diode__A_0.bias_c op VDD sky130_fd_pr__pfet_01v8 ad=0.406 pd=3.38 as=0.406 ps=3.38 w=1.4 l=0.6
X826 VSS bias_a nmos_dummy_18__A_0.x2_m4d VSS sky130_fd_pr__nfet_01v8 ad=0.406 pd=3.38 as=0.406 ps=3.38 w=1.4 l=0.6
X827 VSS cmc nmos_single_5__A_0.x2_tail VSS sky130_fd_pr__nfet_01v8 ad=0.406 pd=3.38 as=0.406 ps=3.38 w=1.4 l=0.6
X828 VSS cmc nmos_single_5__A_0.x2_tail VSS sky130_fd_pr__nfet_01v8 ad=0.406 pd=3.38 as=0.406 ps=3.38 w=1.4 l=0.6
X829 nmos_diode__A_0.bias_c nmos_diode__A_0.bias_b nmos_diode__A_0.bias_b VSS sky130_fd_pr__nfet_01v8_lvt ad=0.406 pd=3.38 as=0.406 ps=3.38 w=1.4 l=0.6
X830 pmos_dummy_7__A_0.x1_m25d pmos_dummy_7__A_0.x1_m25d pmos_dummy_7__A_0.x1_m25d VDD sky130_fd_pr__pfet_01v8_lvt ad=0.406 pd=3.38 as=0 ps=0 w=1.4 l=0.6
X831 VDD nmos_diode__A_0.bias_b pmos_dummy_17__A_0.x2_foldp VDD sky130_fd_pr__pfet_01v8_lvt ad=0.406 pd=3.38 as=0.406 ps=3.38 w=1.4 l=0.6
X832 nmos_dummy_18__A_0.x2_m4d nmos_single__A_0.bias_d op VSS sky130_fd_pr__nfet_01v8 ad=0.406 pd=3.38 as=0.406 ps=3.38 w=1.4 l=0.6
X833 VSS bias_a nmos_dummy_19__A_0.x2_m3d VSS sky130_fd_pr__nfet_01v8 ad=0.406 pd=3.38 as=0.406 ps=3.38 w=1.4 l=0.6
X834 VSS bias_a nmos_dummy_19__A_0.x2_m3d VSS sky130_fd_pr__nfet_01v8 ad=0.406 pd=3.38 as=0.406 ps=3.38 w=1.4 l=0.6
X835 VSS bias_a nmos_single_5__A_0.x2_tail VSS sky130_fd_pr__nfet_01v8 ad=0.406 pd=3.38 as=0.406 ps=3.38 w=1.4 l=0.6
X836 VSS cmc nmos_single_5__A_0.x2_tail VSS sky130_fd_pr__nfet_01v8 ad=0.406 pd=3.38 as=0.406 ps=3.38 w=1.4 l=0.6
X837 VSS cmc nmos_single_5__A_0.x2_tail VSS sky130_fd_pr__nfet_01v8 ad=0.406 pd=3.38 as=0.406 ps=3.38 w=1.4 l=0.6
X838 VDD VDD nmos_diode__A_0.bias_b VDD sky130_fd_pr__pfet_01v8 ad=0.406 pd=3.38 as=0.406 ps=3.38 w=1.4 l=0.6
X839 nmos_dummy_18__A_0.x2_m4d nmos_single__A_0.bias_d op VSS sky130_fd_pr__nfet_01v8 ad=0.406 pd=3.38 as=0.406 ps=3.38 w=1.4 l=0.6
X840 VSS bias_a nmos_single_5__A_0.x2_tail VSS sky130_fd_pr__nfet_01v8 ad=0.406 pd=3.38 as=0.406 ps=3.38 w=1.4 l=0.6
X841 VSS bias_a nmos_dummy_9__A_0.x1_m5d VSS sky130_fd_pr__nfet_01v8 ad=0.406 pd=3.38 as=0.406 ps=3.38 w=1.4 l=0.6
X842 pmos_dummy_7__A_0.x1_m25d pmos_dummy_7__A_0.x1_m25d pmos_dummy_7__A_0.x1_m25d VDD sky130_fd_pr__pfet_01v8_lvt ad=0.406 pd=3.38 as=0 ps=0 w=1.4 l=0.6
X843 nmos_diode__A_0.bias_b nmos_diode__A_0.bias_b nmos_diode__A_0.bias_b VSS sky130_fd_pr__nfet_01v8_lvt ad=0.406 pd=3.38 as=0 ps=0 w=1.4 l=0.6
X844 VSS bias_a nmos_single_5__A_0.x2_tail VSS sky130_fd_pr__nfet_01v8 ad=0.406 pd=3.38 as=0.406 ps=3.38 w=1.4 l=0.6
X845 VSS cmc nmos_single_5__A_0.x2_tail VSS sky130_fd_pr__nfet_01v8 ad=0.406 pd=3.38 as=0.406 ps=3.38 w=1.4 l=0.6
X846 on nmos_single__A_0.bias_d nmos_dummy_19__A_0.x2_m3d VSS sky130_fd_pr__nfet_01v8 ad=0.406 pd=3.38 as=0.406 ps=3.38 w=1.4 l=0.6
X847 nmos_single__A_0.bias_d nmos_single__A_0.bias_d nmos_single__A_0.bias_d VSS sky130_fd_pr__nfet_01v8 ad=0.406 pd=3.38 as=0 ps=0 w=1.4 l=0.6
X848 pmos_dummy_6__A_0.x1_m21d nmos_diode__A_0.bias_b VDD VDD sky130_fd_pr__pfet_01v8_lvt ad=0.406 pd=3.38 as=0.406 ps=3.38 w=1.4 l=0.6
X849 VSS bias_a nmos_dummy_18__A_0.x2_m4d VSS sky130_fd_pr__nfet_01v8 ad=0.406 pd=3.38 as=0.406 ps=3.38 w=1.4 l=0.6
X850 nmos_dummy_19__A_0.x2_m3d nmos_single__A_0.bias_d on VSS sky130_fd_pr__nfet_01v8 ad=0.406 pd=3.38 as=0.406 ps=3.38 w=1.4 l=0.6
X851 nmos_diode__A_0.bias_c IBIAS VSS VSS sky130_fd_pr__nfet_01v8 ad=0.406 pd=3.38 as=0.406 ps=3.38 w=1.4 l=0.6
X852 nmos_matched_cascode_pair_6__AB_0.x1_net7 cm cm VSS sky130_fd_pr__nfet_01v8 ad=0.406 pd=3.38 as=0.406 ps=3.38 w=1.4 l=0.6
X853 VDD VDD VDD VDD sky130_fd_pr__pfet_01v8_lvt ad=0.406 pd=3.38 as=0 ps=0 w=1.4 l=0.6
X854 VSS bias_a nmos_dummy_18__A_0.x2_m4d VSS sky130_fd_pr__nfet_01v8 ad=0.406 pd=3.38 as=0.406 ps=3.38 w=1.4 l=0.6
X855 VSS VSS VSS VSS sky130_fd_pr__nfet_01v8 ad=0.406 pd=3.38 as=0 ps=0 w=1.4 l=0.6
X856 op nmos_single__A_0.bias_d nmos_dummy_18__A_0.x2_m4d VSS sky130_fd_pr__nfet_01v8 ad=0.406 pd=3.38 as=0.406 ps=3.38 w=1.4 l=0.6
X857 nmos_diode__A_0.bias_c nmos_diode__A_0.bias_b nmos_diode__A_0.bias_b VSS sky130_fd_pr__nfet_01v8_lvt ad=0.406 pd=3.38 as=0.406 ps=3.38 w=1.4 l=0.6
X858 VDD VDD VDD VDD sky130_fd_pr__pfet_01v8 ad=0.406 pd=3.38 as=0 ps=0 w=1.4 l=0.6
X859 VSS VSS nmos_dummy_19__A_0.x2_m3d VSS sky130_fd_pr__nfet_01v8 ad=0.406 pd=3.38 as=0.406 ps=3.38 w=1.4 l=0.6
X860 VSS VSS nmos_dummy_18__A_0.x2_m4d VSS sky130_fd_pr__nfet_01v8 ad=0.406 pd=3.38 as=0.406 ps=3.38 w=1.4 l=0.6
X861 op cmc sky130_fd_pr__cap_mim_m3_1 l=4.8 w=4.8
X862 nmos_single__A_0.bias_d nmos_single__A_0.x1_m2d nmos_single__A_0.x1_m2d VSS sky130_fd_pr__nfet_01v8 ad=0.406 pd=3.38 as=0.406 ps=3.38 w=1.4 l=0.6
X863 pmos_dummy_17__A_0.x2_foldp nmos_diode__A_0.bias_c on VDD sky130_fd_pr__pfet_01v8 ad=0.406 pd=3.38 as=0.406 ps=3.38 w=1.4 l=0.6
X864 VSS bias_a nmos_dummy_18__A_0.x2_m4d VSS sky130_fd_pr__nfet_01v8 ad=0.406 pd=3.38 as=0.406 ps=3.38 w=1.4 l=0.6
X865 pmos_dummy_7__A_0.x1_m25d nmos_diode__A_0.bias_b VDD VDD sky130_fd_pr__pfet_01v8_lvt ad=0.406 pd=3.38 as=0.406 ps=3.38 w=1.4 l=0.6
X866 nmos_diode__A_0.bias_b nmos_diode__A_0.bias_c pmos_dummy_6__A_0.x1_m21d VDD sky130_fd_pr__pfet_01v8 ad=0.406 pd=3.38 as=0.406 ps=3.38 w=1.4 l=0.6
X867 nmos_matched_cascode_pair_9__AB_0.x1_net12 cm nmos_matched_cascode_pair_9__AB_0.x1_net11 VSS sky130_fd_pr__nfet_01v8 ad=0.406 pd=3.38 as=0.406 ps=3.38 w=1.4 l=0.6
X868 VDD VDD op VDD sky130_fd_pr__pfet_01v8 ad=0.406 pd=3.38 as=0.406 ps=3.38 w=1.4 l=0.6
X869 VDD nmos_diode__A_0.bias_b pmos_dummy_16__A_0.x2_foldn VDD sky130_fd_pr__pfet_01v8_lvt ad=0.406 pd=3.38 as=0.406 ps=3.38 w=1.4 l=0.6
X870 pmos_dummy_16__A_0.x2_foldn nmos_diode__A_0.bias_c op VDD sky130_fd_pr__pfet_01v8 ad=0.406 pd=3.38 as=0.406 ps=3.38 w=1.4 l=0.6
X871 VSS bias_a nmos_single_5__A_0.x2_tail VSS sky130_fd_pr__nfet_01v8 ad=0.406 pd=3.38 as=0.406 ps=3.38 w=1.4 l=0.6
X872 on cmc sky130_fd_pr__cap_mim_m3_1 l=4.8 w=4.8
X873 nmos_single__A_0.bias_d nmos_single__A_0.x1_m2d nmos_single__A_0.x1_m2d VSS sky130_fd_pr__nfet_01v8 ad=0.406 pd=3.38 as=0.406 ps=3.38 w=1.4 l=0.6
X874 VSS VSS VSS VSS sky130_fd_pr__nfet_01v8 ad=0.406 pd=3.38 as=0 ps=0 w=1.4 l=0.6
C0 nmos_matched_cascode_pair_7__AB_0.x1_net9 cm 0.19441f
C1 nmos_diode__A_0.bias_c nmos_matched_cascode_pair_9__AB_0.x1_net11 0.09303f
C2 nmos_diode__A_0.bias_b in 0.11904f
C3 nmos_diode__A_0.bias_b nmos_single_5__A_0.x2_tail 0.64725f
C4 pmos_dummy_17__A_0.x2_foldp nmos_single__A_0.x1_m2d 0
C5 nmos_diode__A_0.bias_b pmos_dummy_6__A_0.x1_m21d 3.1994f
C6 nmos_matched_cascode_pair_3__AB_0.x1_net2 nmos_matched_cascode_pair_4__AB_0.x1_net4 0
C7 nmos_matched_cascode_pair_5__AB_0.x1_net5 cm 1.29196f
C8 nmos_matched_cascode_pair_9__AB_0.x1_net12 nmos_matched_cascode_pair_7__AB_0.x1_net8 0
C9 nmos_dummy_9__A_0.x1_m5d nmos_matched_cascode_pair_5__AB_0.x1_net5 0
C10 nmos_diode__A_0.bias_c nmos_diode__A_0.bias_b 28.493f
C11 nmos_dummy_9__A_0.x1_m5d cm 0.33061f
C12 nmos_matched_cascode_pair_7__AB_0.x1_net8 nmos_matched_cascode_pair_6__AB_0.x1_net7 0.256f
C13 nmos_matched_cascode_pair_9__AB_0.x1_net11 nmos_matched_cascode_pair_4__AB_0.x1_net4 0
C14 nmos_single__A_0.x1_m2d bias_a 0.79987f
C15 nmos_single__A_0.bias_d pmos_dummy_7__A_0.x1_m25d 0.2697f
C16 nmos_matched_cascode_pair_5__AB_0.x1_net6 nmos_diode__A_0.bias_b 0.01725f
C17 VDD nmos_single__A_0.x1_m2d 4.67622f
C18 nmos_matched_cascode_pair_6__AB_0.x1_net7 nmos_matched_cascode_pair_11__AB_0.x1_net14 0.00128f
C19 nmos_matched_cascode_pair_11__AB_0.x1_net15 bias_a 0
C20 nmos_matched_cascode_pair_11__AB_0.x1_net14 nmos_matched_cascode_pair_10__AB_0.x1_net13 0.256f
C21 nmos_matched_cascode_pair_8__AB_0.x1_net10 cm 0.31503f
C22 nmos_matched_cascode_pair_3__AB_0.x1_net2 nmos_matched_cascode_pair_7__AB_0.x1_net8 0
C23 nmos_diode__A_0.bias_b ip 0.10931f
C24 nmos_matched_cascode_pair_3__AB_0.x1_net2 nmos_matched_cascode_pair_11__AB_0.x1_net14 0.62237f
C25 nmos_matched_cascode_pair_3__AB_0.x1_net2 nmos_matched_cascode_pair_2__AB_0.x1_net1 0.256f
C26 IBIAS nmos_matched_cascode_pair_6__AB_0.x1_net7 0
C27 nmos_single__A_0.x1_m2d pmos_dummy_6__A_0.x1_m21d 2.46885f
C28 on nmos_diode__A_0.bias_b 0.19029f
C29 pmos_dummy_16__A_0.x2_foldn pmos_dummy_17__A_0.x2_foldp 11.5389f
C30 IBIAS nmos_matched_cascode_pair_3__AB_0.x1_net2 0.17891f
C31 nmos_matched_cascode_pair_9__AB_0.x1_net11 nmos_matched_cascode_pair_7__AB_0.x1_net8 0.39748f
C32 nmos_diode__A_0.bias_b pmos_single__A_0.x1_m31d 1.41161f
C33 nmos_matched_cascode_pair_9__AB_0.x1_net11 nmos_matched_cascode_pair_11__AB_0.x1_net14 0.13131f
C34 nmos_matched_cascode_pair_7__AB_0.x1_net9 bias_a 0.00209f
C35 nmos_diode__A_0.bias_c nmos_single__A_0.x1_m2d 1.42528f
C36 IBIAS nmos_matched_cascode_pair_9__AB_0.x1_net11 1.23972f
C37 pmos_dummy_16__A_0.x2_foldn nmos_dummy_19__A_0.x2_m3d 0.35619f
C38 nmos_dummy_18__A_0.x2_m4d pmos_dummy_16__A_0.x2_foldn 0.42661f
C39 pmos_dummy_16__A_0.x2_foldn bias_a 0.25852f
C40 nmos_matched_cascode_pair_5__AB_0.x1_net5 bias_a 0.08732f
C41 pmos_dummy_16__A_0.x2_foldn VDD 26.6043f
C42 cm bias_a 0.45364f
C43 VDD cm 3.45871f
C44 nmos_matched_cascode_pair_3__AB_0.x1_net2 nmos_single__A_0.bias_d 0.1883f
C45 nmos_dummy_9__A_0.x1_m5d bias_a 8.80895f
C46 nmos_matched_cascode_pair_4__AB_0.x1_net4 nmos_single__A_0.x1_m2d 0
C47 nmos_diode__A_0.bias_b IBIAS 0.21748f
C48 pmos_dummy_16__A_0.x2_foldn in 0.39521f
C49 pmos_dummy_16__A_0.x2_foldn nmos_single_5__A_0.x2_tail 3.86448f
C50 on nmos_single__A_0.x1_m2d 0
C51 nmos_matched_cascode_pair_7__AB_0.x1_net9 nmos_diode__A_0.bias_c 0
C52 cm pmos_dummy_6__A_0.x1_m21d 0.20832f
C53 pmos_single__A_0.x1_m31d nmos_single__A_0.x1_m2d 0.42392f
C54 cmc bias_a 0.30197f
C55 nmos_matched_cascode_pair_8__AB_0.x1_net10 bias_a 0.00387f
C56 nmos_matched_cascode_pair_9__AB_0.x1_net11 nmos_single__A_0.bias_d 0.50091f
C57 VDD cmc 1.01759f
C58 pmos_dummy_16__A_0.x2_foldn nmos_diode__A_0.bias_c 1.7217f
C59 nmos_diode__A_0.bias_c nmos_matched_cascode_pair_5__AB_0.x1_net5 0.09846f
C60 nmos_diode__A_0.bias_c cm 1.87413f
C61 nmos_matched_cascode_pair_7__AB_0.x1_net8 nmos_single__A_0.x1_m2d 0.00968f
C62 op nmos_diode__A_0.bias_b 0.43445f
C63 cmc nmos_single_5__A_0.x2_tail 11.6146f
C64 nmos_matched_cascode_pair_5__AB_0.x1_net6 nmos_matched_cascode_pair_5__AB_0.x1_net5 0.12708f
C65 cmc pmos_dummy_6__A_0.x1_m21d 0
C66 nmos_matched_cascode_pair_11__AB_0.x1_net14 nmos_single__A_0.x1_m2d 0.24598f
C67 nmos_dummy_18__A_0.x2_m4d pmos_dummy_17__A_0.x2_foldp 0.16669f
C68 pmos_dummy_17__A_0.x2_foldp nmos_dummy_19__A_0.x2_m3d 0.18416f
C69 nmos_diode__A_0.bias_c nmos_dummy_9__A_0.x1_m5d 0.19544f
C70 pmos_dummy_17__A_0.x2_foldp bias_a 0.18893f
C71 nmos_diode__A_0.bias_b nmos_single__A_0.bias_d 0.43168f
C72 nmos_matched_cascode_pair_11__AB_0.x1_net15 nmos_matched_cascode_pair_11__AB_0.x1_net14 0.12705f
C73 nmos_matched_cascode_pair_5__AB_0.x1_net6 cm 0.18787f
C74 VDD pmos_dummy_17__A_0.x2_foldp 27.5788f
C75 nmos_matched_cascode_pair_3__AB_0.x1_net3 nmos_matched_cascode_pair_3__AB_0.x1_net2 0.13284f
C76 pmos_dummy_16__A_0.x2_foldn ip 0.05875f
C77 IBIAS nmos_single__A_0.x1_m2d 0.0403f
C78 nmos_diode__A_0.bias_c cmc 0.31551f
C79 nmos_matched_cascode_pair_5__AB_0.x1_net5 nmos_matched_cascode_pair_4__AB_0.x1_net4 0.256f
C80 pmos_dummy_17__A_0.x2_foldp in 0.11714f
C81 pmos_dummy_16__A_0.x2_foldn on 3.22198f
C82 pmos_dummy_17__A_0.x2_foldp nmos_single_5__A_0.x2_tail 3.77354f
C83 pmos_dummy_17__A_0.x2_foldp pmos_dummy_6__A_0.x1_m21d 0
C84 nmos_matched_cascode_pair_4__AB_0.x1_net4 cm 0.41415f
C85 nmos_dummy_18__A_0.x2_m4d nmos_dummy_19__A_0.x2_m3d 11.6319f
C86 nmos_dummy_18__A_0.x2_m4d bias_a 3.07494f
C87 nmos_dummy_19__A_0.x2_m3d bias_a 3.67865f
C88 nmos_matched_cascode_pair_7__AB_0.x1_net9 nmos_matched_cascode_pair_7__AB_0.x1_net8 0.12705f
C89 VDD nmos_dummy_19__A_0.x2_m3d 0.23117f
C90 nmos_dummy_18__A_0.x2_m4d VDD 0.21326f
C91 VDD bias_a 1.07159f
C92 cm pmos_single__A_0.x1_m31d 2.25629f
C93 nmos_diode__A_0.bias_c pmos_dummy_17__A_0.x2_foldp 1.90353f
C94 nmos_dummy_18__A_0.x2_m4d in 0.00293f
C95 nmos_dummy_19__A_0.x2_m3d in 0
C96 nmos_diode__A_0.bias_b pmos_dummy_7__A_0.x1_m25d 1.24291f
C97 nmos_dummy_19__A_0.x2_m3d nmos_single_5__A_0.x2_tail 0
C98 nmos_dummy_18__A_0.x2_m4d nmos_single_5__A_0.x2_tail 0.00548f
C99 in bias_a 0.20508f
C100 nmos_single_5__A_0.x2_tail bias_a 12.6436f
C101 nmos_matched_cascode_pair_7__AB_0.x1_net8 nmos_matched_cascode_pair_5__AB_0.x1_net5 0.93941f
C102 pmos_dummy_6__A_0.x1_m21d bias_a 0
C103 nmos_single__A_0.bias_d nmos_single__A_0.x1_m2d 26.8076f
C104 on cmc 12.2551f
C105 VDD nmos_single_5__A_0.x2_tail 0.00637f
C106 VDD pmos_dummy_6__A_0.x1_m21d 11.3128f
C107 nmos_matched_cascode_pair_7__AB_0.x1_net8 cm 2.11688f
C108 nmos_matched_cascode_pair_11__AB_0.x1_net15 nmos_single__A_0.bias_d 0
C109 nmos_matched_cascode_pair_11__AB_0.x1_net14 cm 1.24202f
C110 nmos_matched_cascode_pair_3__AB_0.x1_net2 nmos_matched_cascode_pair_6__AB_0.x1_net7 0
C111 nmos_matched_cascode_pair_2__AB_0.x1_net1 cm 0.32427f
C112 nmos_matched_cascode_pair_9__AB_0.x1_net12 nmos_matched_cascode_pair_9__AB_0.x1_net11 0.13275f
C113 nmos_dummy_9__A_0.x1_m5d nmos_matched_cascode_pair_7__AB_0.x1_net8 0
C114 pmos_dummy_17__A_0.x2_foldp ip 0.43102f
C115 nmos_matched_cascode_pair_3__AB_0.x1_net2 nmos_matched_cascode_pair_10__AB_0.x1_net13 0
C116 nmos_dummy_18__A_0.x2_m4d nmos_diode__A_0.bias_c 0.20616f
C117 nmos_diode__A_0.bias_c nmos_dummy_19__A_0.x2_m3d 0.15012f
C118 nmos_dummy_9__A_0.x1_m5d nmos_matched_cascode_pair_11__AB_0.x1_net14 0
C119 nmos_single_5__A_0.x2_tail in 0.36941f
C120 nmos_diode__A_0.bias_c bias_a 0.23828f
C121 IBIAS nmos_matched_cascode_pair_5__AB_0.x1_net5 0.43646f
C122 nmos_diode__A_0.bias_c VDD 38.1583f
C123 IBIAS cm 0.55051f
C124 on pmos_dummy_17__A_0.x2_foldp 7.9474f
C125 nmos_matched_cascode_pair_5__AB_0.x1_net6 bias_a 0
C126 nmos_matched_cascode_pair_9__AB_0.x1_net11 nmos_matched_cascode_pair_6__AB_0.x1_net7 0
C127 IBIAS nmos_dummy_9__A_0.x1_m5d 0.18518f
C128 nmos_matched_cascode_pair_8__AB_0.x1_net10 nmos_matched_cascode_pair_11__AB_0.x1_net14 0
C129 nmos_diode__A_0.bias_c nmos_single_5__A_0.x2_tail 0.27251f
C130 nmos_diode__A_0.bias_c pmos_dummy_6__A_0.x1_m21d 0.54672f
C131 nmos_dummy_18__A_0.x2_m4d ip 0.00209f
C132 nmos_dummy_19__A_0.x2_m3d ip 0
C133 ip bias_a 0.00595f
C134 pmos_dummy_7__A_0.x1_m25d nmos_single__A_0.x1_m2d 3.42444f
C135 pmos_dummy_16__A_0.x2_foldn op 9.19949f
C136 on nmos_dummy_19__A_0.x2_m3d 13.3288f
C137 nmos_dummy_18__A_0.x2_m4d on 5.61153f
C138 on bias_a 0.61145f
C139 pmos_dummy_16__A_0.x2_foldn nmos_single__A_0.bias_d 0.3411f
C140 nmos_matched_cascode_pair_5__AB_0.x1_net5 nmos_single__A_0.bias_d 0.77728f
C141 on VDD 15.5181f
C142 cm nmos_single__A_0.bias_d 0.7278f
C143 ip in 2.01906f
C144 nmos_single_5__A_0.x2_tail ip 0.36967f
C145 VDD pmos_single__A_0.x1_m31d 11.1556f
C146 nmos_diode__A_0.bias_b nmos_matched_cascode_pair_3__AB_0.x1_net2 0.1162f
C147 nmos_matched_cascode_pair_5__AB_0.x1_net6 nmos_diode__A_0.bias_c 0
C148 nmos_dummy_9__A_0.x1_m5d nmos_single__A_0.bias_d 1.73529f
C149 on nmos_single_5__A_0.x2_tail 0.87465f
C150 on pmos_dummy_6__A_0.x1_m21d 0
C151 nmos_matched_cascode_pair_7__AB_0.x1_net8 bias_a 0.08964f
C152 pmos_single__A_0.x1_m31d pmos_dummy_6__A_0.x1_m21d 0.97086f
C153 op cmc 10.6074f
C154 nmos_matched_cascode_pair_11__AB_0.x1_net14 bias_a 0.06879f
C155 cmc nmos_single__A_0.bias_d 0.27727f
C156 nmos_matched_cascode_pair_8__AB_0.x1_net10 nmos_single__A_0.bias_d 0.05386f
C157 on nmos_diode__A_0.bias_c 4.91799f
C158 nmos_diode__A_0.bias_c pmos_single__A_0.x1_m31d 0.60956f
C159 IBIAS bias_a 0.13103f
C160 nmos_matched_cascode_pair_6__AB_0.x1_net7 nmos_single__A_0.x1_m2d 0
C161 op pmos_dummy_17__A_0.x2_foldp 7.45594f
C162 cm pmos_dummy_7__A_0.x1_m25d 0.12568f
C163 pmos_dummy_17__A_0.x2_foldp nmos_single__A_0.bias_d 0.14075f
C164 nmos_matched_cascode_pair_3__AB_0.x1_net3 cm 0.18787f
C165 nmos_matched_cascode_pair_3__AB_0.x1_net2 nmos_single__A_0.x1_m2d 1.61237f
C166 nmos_diode__A_0.bias_c nmos_matched_cascode_pair_7__AB_0.x1_net8 0.11355f
C167 nmos_diode__A_0.bias_c nmos_matched_cascode_pair_11__AB_0.x1_net14 0.01089f
C168 cmc pmos_dummy_7__A_0.x1_m25d 0
C169 op nmos_dummy_19__A_0.x2_m3d 12.8136f
C170 nmos_dummy_18__A_0.x2_m4d op 15.251f
C171 nmos_matched_cascode_pair_9__AB_0.x1_net11 nmos_single__A_0.x1_m2d 0.09255f
C172 op bias_a 0.43583f
C173 nmos_dummy_18__A_0.x2_m4d nmos_single__A_0.bias_d 3.44627f
C174 nmos_dummy_19__A_0.x2_m3d nmos_single__A_0.bias_d 3.11624f
C175 VDD op 10.7176f
C176 nmos_single__A_0.bias_d bias_a 8.31295f
C177 nmos_matched_cascode_pair_11__AB_0.x1_net15 nmos_matched_cascode_pair_9__AB_0.x1_net11 0
C178 nmos_diode__A_0.bias_c IBIAS 6.41219f
C179 VDD nmos_single__A_0.bias_d 1.49659f
C180 nmos_matched_cascode_pair_9__AB_0.x1_net12 cm 0.18787f
C181 nmos_matched_cascode_pair_7__AB_0.x1_net8 nmos_matched_cascode_pair_4__AB_0.x1_net4 0
C182 op nmos_single_5__A_0.x2_tail 0.25691f
C183 nmos_diode__A_0.bias_b nmos_single__A_0.x1_m2d 1.51299f
C184 pmos_dummy_17__A_0.x2_foldp pmos_dummy_7__A_0.x1_m25d 0
C185 nmos_single__A_0.bias_d in 0
C186 nmos_single__A_0.bias_d nmos_single_5__A_0.x2_tail 0.44787f
C187 nmos_single__A_0.bias_d pmos_dummy_6__A_0.x1_m21d 0.00176f
C188 nmos_matched_cascode_pair_6__AB_0.x1_net7 cm 0.31492f
C189 nmos_matched_cascode_pair_10__AB_0.x1_net13 cm 0.31896f
C190 nmos_matched_cascode_pair_3__AB_0.x1_net2 nmos_matched_cascode_pair_5__AB_0.x1_net5 0.00541f
C191 IBIAS nmos_matched_cascode_pair_4__AB_0.x1_net4 0
C192 nmos_diode__A_0.bias_c op 1.79206f
C193 nmos_matched_cascode_pair_3__AB_0.x1_net2 cm 2.54501f
C194 nmos_diode__A_0.bias_c nmos_single__A_0.bias_d 1.89519f
C195 nmos_dummy_9__A_0.x1_m5d nmos_matched_cascode_pair_3__AB_0.x1_net2 0
C196 pmos_dummy_7__A_0.x1_m25d bias_a 0.20244f
C197 VDD pmos_dummy_7__A_0.x1_m25d 11.4772f
C198 nmos_matched_cascode_pair_7__AB_0.x1_net8 nmos_matched_cascode_pair_11__AB_0.x1_net14 0.00343f
C199 nmos_matched_cascode_pair_3__AB_0.x1_net3 bias_a 0
C200 nmos_matched_cascode_pair_9__AB_0.x1_net11 nmos_matched_cascode_pair_5__AB_0.x1_net5 0.00184f
C201 nmos_matched_cascode_pair_9__AB_0.x1_net11 cm 2.29854f
C202 nmos_matched_cascode_pair_2__AB_0.x1_net1 nmos_matched_cascode_pair_11__AB_0.x1_net14 0
C203 IBIAS nmos_matched_cascode_pair_7__AB_0.x1_net8 0.42574f
C204 nmos_dummy_9__A_0.x1_m5d nmos_matched_cascode_pair_9__AB_0.x1_net11 0.00694f
C205 nmos_single__A_0.bias_d ip 0
C206 pmos_dummy_7__A_0.x1_m25d pmos_dummy_6__A_0.x1_m21d 3.79213f
C207 IBIAS nmos_matched_cascode_pair_11__AB_0.x1_net14 0.00749f
C208 on op 3.97288f
C209 pmos_dummy_16__A_0.x2_foldn nmos_diode__A_0.bias_b 2.93364f
C210 nmos_matched_cascode_pair_11__AB_0.x1_net15 nmos_single__A_0.x1_m2d 0.01603f
C211 nmos_diode__A_0.bias_b nmos_matched_cascode_pair_5__AB_0.x1_net5 0.48148f
C212 on nmos_single__A_0.bias_d 3.2815f
C213 nmos_diode__A_0.bias_b cm 0.93896f
C214 nmos_matched_cascode_pair_9__AB_0.x1_net12 bias_a 0
C215 nmos_matched_cascode_pair_9__AB_0.x1_net11 nmos_matched_cascode_pair_8__AB_0.x1_net10 0.256f
C216 nmos_diode__A_0.bias_c pmos_dummy_7__A_0.x1_m25d 0.63411f
C217 nmos_diode__A_0.bias_b nmos_dummy_9__A_0.x1_m5d 0.15182f
C218 nmos_matched_cascode_pair_3__AB_0.x1_net3 nmos_diode__A_0.bias_c 0
C219 nmos_matched_cascode_pair_7__AB_0.x1_net8 nmos_single__A_0.bias_d 0.44108f
C220 nmos_diode__A_0.bias_b cmc 0.54805f
C221 nmos_matched_cascode_pair_11__AB_0.x1_net14 nmos_single__A_0.bias_d 0.1222f
C222 nmos_matched_cascode_pair_3__AB_0.x1_net2 bias_a 0.06301f
C223 on pmos_dummy_7__A_0.x1_m25d 0
C224 nmos_matched_cascode_pair_9__AB_0.x1_net12 nmos_diode__A_0.bias_c 0
C225 nmos_matched_cascode_pair_5__AB_0.x1_net5 nmos_single__A_0.x1_m2d 0.01713f
C226 IBIAS nmos_single__A_0.bias_d 0.69782f
C227 nmos_diode__A_0.bias_b pmos_dummy_17__A_0.x2_foldp 2.69343f
C228 pmos_single__A_0.x1_m31d pmos_dummy_7__A_0.x1_m25d 1.45239f
C229 cm nmos_single__A_0.x1_m2d 1.32309f
C230 nmos_matched_cascode_pair_11__AB_0.x1_net15 cm 0.18787f
C231 nmos_matched_cascode_pair_9__AB_0.x1_net11 bias_a 0.19567f
C232 nmos_dummy_9__A_0.x1_m5d nmos_single__A_0.x1_m2d 0.16581f
C233 cmc nmos_single__A_0.x1_m2d 0
C234 nmos_diode__A_0.bias_b nmos_dummy_19__A_0.x2_m3d 0.21646f
C235 nmos_diode__A_0.bias_c nmos_matched_cascode_pair_3__AB_0.x1_net2 0.82372f
C236 nmos_dummy_18__A_0.x2_m4d nmos_diode__A_0.bias_b 0.21712f
C237 nmos_matched_cascode_pair_8__AB_0.x1_net10 nmos_single__A_0.x1_m2d 0.08816f
C238 nmos_diode__A_0.bias_b bias_a 0.64413f
C239 op nmos_single__A_0.bias_d 3.13593f
C240 VDD nmos_diode__A_0.bias_b 54.6861f
C241 nmos_matched_cascode_pair_9__AB_0.x1_net12 VSS 0.86154f
C242 nmos_matched_cascode_pair_7__AB_0.x1_net9 VSS 0.85566f
C243 nmos_matched_cascode_pair_5__AB_0.x1_net6 VSS 26.05521f
C244 nmos_matched_cascode_pair_3__AB_0.x1_net3 VSS 0.86444f
C245 nmos_matched_cascode_pair_11__AB_0.x1_net15 VSS 0.86141f
C246 nmos_matched_cascode_pair_9__AB_0.x1_net11 VSS 4.56262f
C247 nmos_matched_cascode_pair_8__AB_0.x1_net10 VSS 0.60369f
C248 nmos_matched_cascode_pair_7__AB_0.x1_net8 VSS 4.53296f
C249 nmos_matched_cascode_pair_6__AB_0.x1_net7 VSS 0.59573f
C250 nmos_matched_cascode_pair_5__AB_0.x1_net5 VSS 4.3241f
C251 nmos_matched_cascode_pair_4__AB_0.x1_net4 VSS 0.60184f
C252 nmos_matched_cascode_pair_3__AB_0.x1_net2 VSS 6.92984f
C253 nmos_matched_cascode_pair_2__AB_0.x1_net1 VSS 0.58913f
C254 nmos_matched_cascode_pair_11__AB_0.x1_net14 VSS 4.5282f
C255 nmos_matched_cascode_pair_10__AB_0.x1_net13 VSS 0.5898f
C256 nmos_dummy_18__A_0.x2_m4d VSS 98.75587f
C257 nmos_dummy_19__A_0.x2_m3d VSS 58.3812f
.ends
