* Extracted by KLayout with SKY130 LVS runset on : 04/11/2026 21:07

.SUBCKT iadc_ota_routed \$14.x1_net3 \$15.x1_net6 \$16.x1_net9 \$17.x1_net12
+ \$19.x1_net15 \$20.x1_net7 \$22.x1_net4 \$23.x1_net10 \$26.x1_net13
+ \$27.x1_net1 IBIAS VDD VSS bias_a cm cmc in ip on op sky130_gnd
C$1 cmc on sky130_fd_pr__model__cap_mim C=4.608e-14 A=23.04 P=19.2
C$2 cmc on sky130_fd_pr__model__cap_mim C=4.608e-14 A=23.04 P=19.2
C$3 cmc on sky130_fd_pr__model__cap_mim C=4.608e-14 A=23.04 P=19.2
C$4 cmc on sky130_fd_pr__model__cap_mim C=4.608e-14 A=23.04 P=19.2
C$5 cmc op sky130_fd_pr__model__cap_mim C=4.608e-14 A=23.04 P=19.2
C$6 cmc op sky130_fd_pr__model__cap_mim C=4.608e-14 A=23.04 P=19.2
C$7 cmc op sky130_fd_pr__model__cap_mim C=4.608e-14 A=23.04 P=19.2
C$8 cmc op sky130_fd_pr__model__cap_mim C=4.608e-14 A=23.04 P=19.2
M$9 op VDD VDD VDD sky130_fd_pr__pfet_01v8 L=0.6 W=1.4 AS=0.406 AD=0.406
+ PS=3.38 PD=3.38
M$10 op VDD VDD VDD sky130_fd_pr__pfet_01v8 L=0.6 W=1.4 AS=0.406 AD=0.406
+ PS=3.38 PD=3.38
M$11 op VDD VDD VDD sky130_fd_pr__pfet_01v8 L=0.6 W=1.4 AS=0.406 AD=0.406
+ PS=3.38 PD=3.38
M$12 op VDD VDD VDD sky130_fd_pr__pfet_01v8 L=0.6 W=1.4 AS=0.406 AD=0.406
+ PS=3.38 PD=3.38
M$13 on VDD VDD VDD sky130_fd_pr__pfet_01v8 L=0.6 W=1.4 AS=0.406 AD=0.406
+ PS=3.38 PD=3.38
M$14 on VDD VDD VDD sky130_fd_pr__pfet_01v8 L=0.6 W=1.4 AS=0.406 AD=0.406
+ PS=3.38 PD=3.38
M$15 on VDD VDD VDD sky130_fd_pr__pfet_01v8 L=0.6 W=1.4 AS=0.406 AD=0.406
+ PS=3.38 PD=3.38
M$16 on VDD VDD VDD sky130_fd_pr__pfet_01v8 L=0.6 W=1.4 AS=0.406 AD=0.406
+ PS=3.38 PD=3.38
M$17 \$536 ip \$558 sky130_gnd sky130_fd_pr__nfet_01v8_lvt L=0.2 W=1.2 AS=0.348
+ AD=0.348 PS=2.98 PD=2.98
M$18 \$536 ip \$558 sky130_gnd sky130_fd_pr__nfet_01v8_lvt L=0.2 W=1.2 AS=0.348
+ AD=0.348 PS=2.98 PD=2.98
M$19 \$536 ip \$558 sky130_gnd sky130_fd_pr__nfet_01v8_lvt L=0.2 W=1.2 AS=0.348
+ AD=0.348 PS=2.98 PD=2.98
M$20 \$536 ip \$558 sky130_gnd sky130_fd_pr__nfet_01v8_lvt L=0.2 W=1.2 AS=0.348
+ AD=0.348 PS=2.98 PD=2.98
M$21 \$536 ip \$558 sky130_gnd sky130_fd_pr__nfet_01v8_lvt L=0.2 W=1.2 AS=0.348
+ AD=0.348 PS=2.98 PD=2.98
M$22 \$536 ip \$558 sky130_gnd sky130_fd_pr__nfet_01v8_lvt L=0.2 W=1.2 AS=0.348
+ AD=0.348 PS=2.98 PD=2.98
M$23 \$586 in \$558 sky130_gnd sky130_fd_pr__nfet_01v8_lvt L=0.2 W=1.2 AS=0.348
+ AD=0.348 PS=2.98 PD=2.98
M$24 \$586 in \$558 sky130_gnd sky130_fd_pr__nfet_01v8_lvt L=0.2 W=1.2 AS=0.348
+ AD=0.348 PS=2.98 PD=2.98
M$25 \$586 in \$558 sky130_gnd sky130_fd_pr__nfet_01v8_lvt L=0.2 W=1.2 AS=0.348
+ AD=0.348 PS=2.98 PD=2.98
M$26 \$586 in \$558 sky130_gnd sky130_fd_pr__nfet_01v8_lvt L=0.2 W=1.2 AS=0.348
+ AD=0.348 PS=2.98 PD=2.98
M$27 \$586 in \$558 sky130_gnd sky130_fd_pr__nfet_01v8_lvt L=0.2 W=1.2 AS=0.348
+ AD=0.348 PS=2.98 PD=2.98
M$28 \$586 in \$558 sky130_gnd sky130_fd_pr__nfet_01v8_lvt L=0.2 W=1.2 AS=0.348
+ AD=0.348 PS=2.98 PD=2.98
M$29 VSS VSS VSS sky130_gnd sky130_fd_pr__nfet_01v8_lvt L=0.2 W=1.2 AS=0.348
+ AD=0.348 PS=2.98 PD=2.98
M$30 VSS VSS VSS sky130_gnd sky130_fd_pr__nfet_01v8_lvt L=0.2 W=1.2 AS=0.348
+ AD=0.348 PS=2.98 PD=2.98
M$31 \$586 \$586 \$586 sky130_gnd sky130_fd_pr__nfet_01v8_lvt L=0.2 W=1.2
+ AS=0.348 AD=0.348 PS=2.98 PD=2.98
M$32 \$586 \$586 \$586 sky130_gnd sky130_fd_pr__nfet_01v8_lvt L=0.2 W=1.2
+ AS=0.348 AD=0.348 PS=2.98 PD=2.98
M$33 \$536 \$536 \$536 sky130_gnd sky130_fd_pr__nfet_01v8_lvt L=0.2 W=1.2
+ AS=0.348 AD=0.348 PS=2.98 PD=2.98
M$34 \$536 \$536 \$536 sky130_gnd sky130_fd_pr__nfet_01v8_lvt L=0.2 W=1.2
+ AS=0.348 AD=0.348 PS=2.98 PD=2.98
M$35 VDD VDD VDD VDD sky130_fd_pr__pfet_01v8_lvt L=0.6 W=1.4 AS=0.406 AD=0.406
+ PS=3.38 PD=3.38
M$36 \$586 \$17 VDD VDD sky130_fd_pr__pfet_01v8_lvt L=0.6 W=1.4 AS=0.406
+ AD=0.406 PS=3.38 PD=3.38
M$37 \$536 \$17 VDD VDD sky130_fd_pr__pfet_01v8_lvt L=0.6 W=1.4 AS=0.406
+ AD=0.406 PS=3.38 PD=3.38
M$38 \$586 \$17 VDD VDD sky130_fd_pr__pfet_01v8_lvt L=0.6 W=1.4 AS=0.406
+ AD=0.406 PS=3.38 PD=3.38
M$39 \$536 \$17 VDD VDD sky130_fd_pr__pfet_01v8_lvt L=0.6 W=1.4 AS=0.406
+ AD=0.406 PS=3.38 PD=3.38
M$40 \$586 \$17 VDD VDD sky130_fd_pr__pfet_01v8_lvt L=0.6 W=1.4 AS=0.406
+ AD=0.406 PS=3.38 PD=3.38
M$41 \$536 \$17 VDD VDD sky130_fd_pr__pfet_01v8_lvt L=0.6 W=1.4 AS=0.406
+ AD=0.406 PS=3.38 PD=3.38
M$42 \$586 \$17 VDD VDD sky130_fd_pr__pfet_01v8_lvt L=0.6 W=1.4 AS=0.406
+ AD=0.406 PS=3.38 PD=3.38
M$43 \$536 \$17 VDD VDD sky130_fd_pr__pfet_01v8_lvt L=0.6 W=1.4 AS=0.406
+ AD=0.406 PS=3.38 PD=3.38
M$44 \$586 \$17 VDD VDD sky130_fd_pr__pfet_01v8_lvt L=0.6 W=1.4 AS=0.406
+ AD=0.406 PS=3.38 PD=3.38
M$45 \$536 \$17 VDD VDD sky130_fd_pr__pfet_01v8_lvt L=0.6 W=1.4 AS=0.406
+ AD=0.406 PS=3.38 PD=3.38
M$46 \$586 \$17 VDD VDD sky130_fd_pr__pfet_01v8_lvt L=0.6 W=1.4 AS=0.406
+ AD=0.406 PS=3.38 PD=3.38
M$47 \$586 \$17 VDD VDD sky130_fd_pr__pfet_01v8_lvt L=0.6 W=1.4 AS=0.406
+ AD=0.406 PS=3.38 PD=3.38
M$48 \$536 \$17 VDD VDD sky130_fd_pr__pfet_01v8_lvt L=0.6 W=1.4 AS=0.406
+ AD=0.406 PS=3.38 PD=3.38
M$49 \$586 \$17 VDD VDD sky130_fd_pr__pfet_01v8_lvt L=0.6 W=1.4 AS=0.406
+ AD=0.406 PS=3.38 PD=3.38
M$50 \$536 \$17 VDD VDD sky130_fd_pr__pfet_01v8_lvt L=0.6 W=1.4 AS=0.406
+ AD=0.406 PS=3.38 PD=3.38
M$51 \$586 \$17 VDD VDD sky130_fd_pr__pfet_01v8_lvt L=0.6 W=1.4 AS=0.406
+ AD=0.406 PS=3.38 PD=3.38
M$52 \$536 \$17 VDD VDD sky130_fd_pr__pfet_01v8_lvt L=0.6 W=1.4 AS=0.406
+ AD=0.406 PS=3.38 PD=3.38
M$53 \$586 \$17 VDD VDD sky130_fd_pr__pfet_01v8_lvt L=0.6 W=1.4 AS=0.406
+ AD=0.406 PS=3.38 PD=3.38
M$54 \$536 \$17 VDD VDD sky130_fd_pr__pfet_01v8_lvt L=0.6 W=1.4 AS=0.406
+ AD=0.406 PS=3.38 PD=3.38
M$55 \$586 \$17 VDD VDD sky130_fd_pr__pfet_01v8_lvt L=0.6 W=1.4 AS=0.406
+ AD=0.406 PS=3.38 PD=3.38
M$56 \$536 \$17 VDD VDD sky130_fd_pr__pfet_01v8_lvt L=0.6 W=1.4 AS=0.406
+ AD=0.406 PS=3.38 PD=3.38
M$57 \$586 \$17 VDD VDD sky130_fd_pr__pfet_01v8_lvt L=0.6 W=1.4 AS=0.406
+ AD=0.406 PS=3.38 PD=3.38
M$58 \$536 \$17 VDD VDD sky130_fd_pr__pfet_01v8_lvt L=0.6 W=1.4 AS=0.406
+ AD=0.406 PS=3.38 PD=3.38
M$59 \$536 \$17 VDD VDD sky130_fd_pr__pfet_01v8_lvt L=0.6 W=1.4 AS=0.406
+ AD=0.406 PS=3.38 PD=3.38
M$60 VDD VDD VDD VDD sky130_fd_pr__pfet_01v8_lvt L=0.6 W=1.4 AS=0.406 AD=0.406
+ PS=3.38 PD=3.38
M$61 \$586 \$17 VDD VDD sky130_fd_pr__pfet_01v8_lvt L=0.6 W=1.4 AS=0.406
+ AD=0.406 PS=3.38 PD=3.38
M$62 \$536 \$17 VDD VDD sky130_fd_pr__pfet_01v8_lvt L=0.6 W=1.4 AS=0.406
+ AD=0.406 PS=3.38 PD=3.38
M$63 \$586 \$17 VDD VDD sky130_fd_pr__pfet_01v8_lvt L=0.6 W=1.4 AS=0.406
+ AD=0.406 PS=3.38 PD=3.38
M$64 \$536 \$17 VDD VDD sky130_fd_pr__pfet_01v8_lvt L=0.6 W=1.4 AS=0.406
+ AD=0.406 PS=3.38 PD=3.38
M$65 \$586 \$17 VDD VDD sky130_fd_pr__pfet_01v8_lvt L=0.6 W=1.4 AS=0.406
+ AD=0.406 PS=3.38 PD=3.38
M$66 \$536 \$17 VDD VDD sky130_fd_pr__pfet_01v8_lvt L=0.6 W=1.4 AS=0.406
+ AD=0.406 PS=3.38 PD=3.38
M$67 \$586 \$17 VDD VDD sky130_fd_pr__pfet_01v8_lvt L=0.6 W=1.4 AS=0.406
+ AD=0.406 PS=3.38 PD=3.38
M$68 \$536 \$17 VDD VDD sky130_fd_pr__pfet_01v8_lvt L=0.6 W=1.4 AS=0.406
+ AD=0.406 PS=3.38 PD=3.38
M$69 \$586 \$17 VDD VDD sky130_fd_pr__pfet_01v8_lvt L=0.6 W=1.4 AS=0.406
+ AD=0.406 PS=3.38 PD=3.38
M$70 \$536 \$17 VDD VDD sky130_fd_pr__pfet_01v8_lvt L=0.6 W=1.4 AS=0.406
+ AD=0.406 PS=3.38 PD=3.38
M$71 \$536 \$17 VDD VDD sky130_fd_pr__pfet_01v8_lvt L=0.6 W=1.4 AS=0.406
+ AD=0.406 PS=3.38 PD=3.38
M$72 \$536 \$17 VDD VDD sky130_fd_pr__pfet_01v8_lvt L=0.6 W=1.4 AS=0.406
+ AD=0.406 PS=3.38 PD=3.38
M$73 \$586 \$17 VDD VDD sky130_fd_pr__pfet_01v8_lvt L=0.6 W=1.4 AS=0.406
+ AD=0.406 PS=3.38 PD=3.38
M$74 \$536 \$17 VDD VDD sky130_fd_pr__pfet_01v8_lvt L=0.6 W=1.4 AS=0.406
+ AD=0.406 PS=3.38 PD=3.38
M$75 \$586 \$17 VDD VDD sky130_fd_pr__pfet_01v8_lvt L=0.6 W=1.4 AS=0.406
+ AD=0.406 PS=3.38 PD=3.38
M$76 \$536 \$17 VDD VDD sky130_fd_pr__pfet_01v8_lvt L=0.6 W=1.4 AS=0.406
+ AD=0.406 PS=3.38 PD=3.38
M$77 \$586 \$17 VDD VDD sky130_fd_pr__pfet_01v8_lvt L=0.6 W=1.4 AS=0.406
+ AD=0.406 PS=3.38 PD=3.38
M$78 \$536 \$17 VDD VDD sky130_fd_pr__pfet_01v8_lvt L=0.6 W=1.4 AS=0.406
+ AD=0.406 PS=3.38 PD=3.38
M$79 \$586 \$17 VDD VDD sky130_fd_pr__pfet_01v8_lvt L=0.6 W=1.4 AS=0.406
+ AD=0.406 PS=3.38 PD=3.38
M$80 \$536 \$17 VDD VDD sky130_fd_pr__pfet_01v8_lvt L=0.6 W=1.4 AS=0.406
+ AD=0.406 PS=3.38 PD=3.38
M$81 \$586 \$17 VDD VDD sky130_fd_pr__pfet_01v8_lvt L=0.6 W=1.4 AS=0.406
+ AD=0.406 PS=3.38 PD=3.38
M$82 \$536 \$17 VDD VDD sky130_fd_pr__pfet_01v8_lvt L=0.6 W=1.4 AS=0.406
+ AD=0.406 PS=3.38 PD=3.38
M$83 \$586 \$17 VDD VDD sky130_fd_pr__pfet_01v8_lvt L=0.6 W=1.4 AS=0.406
+ AD=0.406 PS=3.38 PD=3.38
M$84 \$586 \$17 VDD VDD sky130_fd_pr__pfet_01v8_lvt L=0.6 W=1.4 AS=0.406
+ AD=0.406 PS=3.38 PD=3.38
M$85 \$340 \$17 VDD VDD sky130_fd_pr__pfet_01v8_lvt L=0.6 W=1.4 AS=0.406
+ AD=0.406 PS=3.38 PD=3.38
M$86 \$340 \$17 VDD VDD sky130_fd_pr__pfet_01v8_lvt L=0.6 W=1.4 AS=0.406
+ AD=0.406 PS=3.38 PD=3.38
M$87 \$340 \$17 VDD VDD sky130_fd_pr__pfet_01v8_lvt L=0.6 W=1.4 AS=0.406
+ AD=0.406 PS=3.38 PD=3.38
M$88 \$340 \$17 VDD VDD sky130_fd_pr__pfet_01v8_lvt L=0.6 W=1.4 AS=0.406
+ AD=0.406 PS=3.38 PD=3.38
M$89 \$340 \$17 VDD VDD sky130_fd_pr__pfet_01v8_lvt L=0.6 W=1.4 AS=0.406
+ AD=0.406 PS=3.38 PD=3.38
M$90 \$340 \$17 VDD VDD sky130_fd_pr__pfet_01v8_lvt L=0.6 W=1.4 AS=0.406
+ AD=0.406 PS=3.38 PD=3.38
M$91 \$365 \$17 VDD VDD sky130_fd_pr__pfet_01v8_lvt L=0.6 W=1.4 AS=0.406
+ AD=0.406 PS=3.38 PD=3.38
M$92 \$408 \$17 VDD VDD sky130_fd_pr__pfet_01v8_lvt L=0.6 W=1.4 AS=0.406
+ AD=0.406 PS=3.38 PD=3.38
M$93 \$365 \$17 VDD VDD sky130_fd_pr__pfet_01v8_lvt L=0.6 W=1.4 AS=0.406
+ AD=0.406 PS=3.38 PD=3.38
M$94 \$408 \$17 VDD VDD sky130_fd_pr__pfet_01v8_lvt L=0.6 W=1.4 AS=0.406
+ AD=0.406 PS=3.38 PD=3.38
M$95 \$365 \$17 VDD VDD sky130_fd_pr__pfet_01v8_lvt L=0.6 W=1.4 AS=0.406
+ AD=0.406 PS=3.38 PD=3.38
M$96 \$408 \$17 VDD VDD sky130_fd_pr__pfet_01v8_lvt L=0.6 W=1.4 AS=0.406
+ AD=0.406 PS=3.38 PD=3.38
M$97 VDD VDD VDD VDD sky130_fd_pr__pfet_01v8_lvt L=0.6 W=1.4 AS=0.406 AD=0.406
+ PS=3.38 PD=3.38
M$98 VDD VDD VDD VDD sky130_fd_pr__pfet_01v8_lvt L=0.6 W=1.4 AS=0.406 AD=0.406
+ PS=3.38 PD=3.38
M$99 \$408 \$17 VDD VDD sky130_fd_pr__pfet_01v8_lvt L=0.6 W=1.4 AS=0.406
+ AD=0.406 PS=3.38 PD=3.38
M$100 \$365 \$17 VDD VDD sky130_fd_pr__pfet_01v8_lvt L=0.6 W=1.4 AS=0.406
+ AD=0.406 PS=3.38 PD=3.38
M$101 \$408 \$17 VDD VDD sky130_fd_pr__pfet_01v8_lvt L=0.6 W=1.4 AS=0.406
+ AD=0.406 PS=3.38 PD=3.38
M$102 \$365 \$17 VDD VDD sky130_fd_pr__pfet_01v8_lvt L=0.6 W=1.4 AS=0.406
+ AD=0.406 PS=3.38 PD=3.38
M$103 \$408 \$17 VDD VDD sky130_fd_pr__pfet_01v8_lvt L=0.6 W=1.4 AS=0.406
+ AD=0.406 PS=3.38 PD=3.38
M$104 \$365 \$17 VDD VDD sky130_fd_pr__pfet_01v8_lvt L=0.6 W=1.4 AS=0.406
+ AD=0.406 PS=3.38 PD=3.38
M$105 \$586 VDD VDD VDD sky130_fd_pr__pfet_01v8 L=0.6 W=1.4 AS=0.406 AD=0.406
+ PS=3.38 PD=3.38
M$106 \$586 VDD VDD VDD sky130_fd_pr__pfet_01v8 L=0.6 W=1.4 AS=0.406 AD=0.406
+ PS=3.38 PD=3.38
M$107 \$536 VDD VDD VDD sky130_fd_pr__pfet_01v8 L=0.6 W=1.4 AS=0.406 AD=0.406
+ PS=3.38 PD=3.38
M$108 \$536 VDD VDD VDD sky130_fd_pr__pfet_01v8 L=0.6 W=1.4 AS=0.406 AD=0.406
+ PS=3.38 PD=3.38
M$109 \$536 \$536 \$536 VDD sky130_fd_pr__pfet_01v8 L=0.6 W=1.4 AS=0.406
+ AD=0.406 PS=3.38 PD=3.38
M$110 \$536 \$536 \$536 VDD sky130_fd_pr__pfet_01v8 L=0.6 W=1.4 AS=0.406
+ AD=0.406 PS=3.38 PD=3.38
M$111 \$586 \$586 \$586 VDD sky130_fd_pr__pfet_01v8 L=0.6 W=1.4 AS=0.406
+ AD=0.406 PS=3.38 PD=3.38
M$112 \$586 \$586 \$586 VDD sky130_fd_pr__pfet_01v8 L=0.6 W=1.4 AS=0.406
+ AD=0.406 PS=3.38 PD=3.38
M$113 cm VDD VDD VDD sky130_fd_pr__pfet_01v8 L=0.6 W=1.4 AS=0.406 AD=0.406
+ PS=3.38 PD=3.38
M$114 cm VDD VDD VDD sky130_fd_pr__pfet_01v8 L=0.6 W=1.4 AS=0.406 AD=0.406
+ PS=3.38 PD=3.38
M$115 \$365 \$365 \$365 VDD sky130_fd_pr__pfet_01v8 L=0.6 W=1.4 AS=0.406
+ AD=0.406 PS=3.38 PD=3.38
M$116 \$365 \$365 \$365 VDD sky130_fd_pr__pfet_01v8 L=0.6 W=1.4 AS=0.406
+ AD=0.406 PS=3.38 PD=3.38
M$117 \$408 \$408 \$408 VDD sky130_fd_pr__pfet_01v8 L=0.6 W=1.4 AS=0.406
+ AD=0.406 PS=3.38 PD=3.38
M$118 \$408 \$408 \$408 VDD sky130_fd_pr__pfet_01v8 L=0.6 W=1.4 AS=0.406
+ AD=0.406 PS=3.38 PD=3.38
M$119 \$247 VDD VDD VDD sky130_fd_pr__pfet_01v8 L=0.6 W=1.4 AS=0.406 AD=0.406
+ PS=3.38 PD=3.38
M$120 \$247 VDD VDD VDD sky130_fd_pr__pfet_01v8 L=0.6 W=1.4 AS=0.406 AD=0.406
+ PS=3.38 PD=3.38
M$121 \$17 VDD VDD VDD sky130_fd_pr__pfet_01v8 L=0.6 W=1.4 AS=0.406 AD=0.406
+ PS=3.38 PD=3.38
M$122 \$17 VDD VDD VDD sky130_fd_pr__pfet_01v8 L=0.6 W=1.4 AS=0.406 AD=0.406
+ PS=3.38 PD=3.38
M$123 \$340 VDD VDD VDD sky130_fd_pr__pfet_01v8 L=0.6 W=1.4 AS=0.406 AD=0.406
+ PS=3.38 PD=3.38
M$124 \$340 VDD VDD VDD sky130_fd_pr__pfet_01v8 L=0.6 W=1.4 AS=0.406 AD=0.406
+ PS=3.38 PD=3.38
M$125 \$17 \$17 \$16 sky130_gnd sky130_fd_pr__nfet_01v8_lvt L=0.6 W=1.4
+ AS=0.406 AD=0.406 PS=3.38 PD=3.38
M$126 \$17 \$17 \$16 sky130_gnd sky130_fd_pr__nfet_01v8_lvt L=0.6 W=1.4
+ AS=0.406 AD=0.406 PS=3.38 PD=3.38
M$127 \$17 \$17 \$16 sky130_gnd sky130_fd_pr__nfet_01v8_lvt L=0.6 W=1.4
+ AS=0.406 AD=0.406 PS=3.38 PD=3.38
M$128 \$17 \$17 \$16 sky130_gnd sky130_fd_pr__nfet_01v8_lvt L=0.6 W=1.4
+ AS=0.406 AD=0.406 PS=3.38 PD=3.38
M$129 \$17 \$17 \$16 sky130_gnd sky130_fd_pr__nfet_01v8_lvt L=0.6 W=1.4
+ AS=0.406 AD=0.406 PS=3.38 PD=3.38
M$130 \$17 \$17 \$16 sky130_gnd sky130_fd_pr__nfet_01v8_lvt L=0.6 W=1.4
+ AS=0.406 AD=0.406 PS=3.38 PD=3.38
M$131 \$17 \$17 \$16 sky130_gnd sky130_fd_pr__nfet_01v8_lvt L=0.6 W=1.4
+ AS=0.406 AD=0.406 PS=3.38 PD=3.38
M$132 \$17 \$17 \$16 sky130_gnd sky130_fd_pr__nfet_01v8_lvt L=0.6 W=1.4
+ AS=0.406 AD=0.406 PS=3.38 PD=3.38
M$133 \$17 \$17 \$16 sky130_gnd sky130_fd_pr__nfet_01v8_lvt L=0.6 W=1.4
+ AS=0.406 AD=0.406 PS=3.38 PD=3.38
M$134 \$17 \$17 \$16 sky130_gnd sky130_fd_pr__nfet_01v8_lvt L=0.6 W=1.4
+ AS=0.406 AD=0.406 PS=3.38 PD=3.38
M$135 \$17 \$17 \$16 sky130_gnd sky130_fd_pr__nfet_01v8_lvt L=0.6 W=1.4
+ AS=0.406 AD=0.406 PS=3.38 PD=3.38
M$136 \$17 \$17 \$16 sky130_gnd sky130_fd_pr__nfet_01v8_lvt L=0.6 W=1.4
+ AS=0.406 AD=0.406 PS=3.38 PD=3.38
M$137 \$17 \$17 \$16 sky130_gnd sky130_fd_pr__nfet_01v8_lvt L=0.6 W=1.4
+ AS=0.406 AD=0.406 PS=3.38 PD=3.38
M$138 \$17 \$17 \$16 sky130_gnd sky130_fd_pr__nfet_01v8_lvt L=0.6 W=1.4
+ AS=0.406 AD=0.406 PS=3.38 PD=3.38
M$139 \$17 \$17 \$16 sky130_gnd sky130_fd_pr__nfet_01v8_lvt L=0.6 W=1.4
+ AS=0.406 AD=0.406 PS=3.38 PD=3.38
M$140 \$17 \$17 \$16 sky130_gnd sky130_fd_pr__nfet_01v8_lvt L=0.6 W=1.4
+ AS=0.406 AD=0.406 PS=3.38 PD=3.38
M$141 \$17 \$17 \$16 sky130_gnd sky130_fd_pr__nfet_01v8_lvt L=0.6 W=1.4
+ AS=0.406 AD=0.406 PS=3.38 PD=3.38
M$142 \$17 \$17 \$16 sky130_gnd sky130_fd_pr__nfet_01v8_lvt L=0.6 W=1.4
+ AS=0.406 AD=0.406 PS=3.38 PD=3.38
M$143 \$17 \$17 \$16 sky130_gnd sky130_fd_pr__nfet_01v8_lvt L=0.6 W=1.4
+ AS=0.406 AD=0.406 PS=3.38 PD=3.38
M$144 \$17 \$17 \$16 sky130_gnd sky130_fd_pr__nfet_01v8_lvt L=0.6 W=1.4
+ AS=0.406 AD=0.406 PS=3.38 PD=3.38
M$145 \$17 \$17 \$16 sky130_gnd sky130_fd_pr__nfet_01v8_lvt L=0.6 W=1.4
+ AS=0.406 AD=0.406 PS=3.38 PD=3.38
M$146 \$17 \$17 \$16 sky130_gnd sky130_fd_pr__nfet_01v8_lvt L=0.6 W=1.4
+ AS=0.406 AD=0.406 PS=3.38 PD=3.38
M$147 \$17 \$17 \$16 sky130_gnd sky130_fd_pr__nfet_01v8_lvt L=0.6 W=1.4
+ AS=0.406 AD=0.406 PS=3.38 PD=3.38
M$148 \$17 \$17 \$16 sky130_gnd sky130_fd_pr__nfet_01v8_lvt L=0.6 W=1.4
+ AS=0.406 AD=0.406 PS=3.38 PD=3.38
M$149 \$17 \$17 \$16 sky130_gnd sky130_fd_pr__nfet_01v8_lvt L=0.6 W=1.4
+ AS=0.406 AD=0.406 PS=3.38 PD=3.38
M$150 \$17 \$17 \$16 sky130_gnd sky130_fd_pr__nfet_01v8_lvt L=0.6 W=1.4
+ AS=0.406 AD=0.406 PS=3.38 PD=3.38
M$151 \$17 \$17 \$16 sky130_gnd sky130_fd_pr__nfet_01v8_lvt L=0.6 W=1.4
+ AS=0.406 AD=0.406 PS=3.38 PD=3.38
M$152 \$17 \$17 \$16 sky130_gnd sky130_fd_pr__nfet_01v8_lvt L=0.6 W=1.4
+ AS=0.406 AD=0.406 PS=3.38 PD=3.38
M$153 \$17 \$17 \$16 sky130_gnd sky130_fd_pr__nfet_01v8_lvt L=0.6 W=1.4
+ AS=0.406 AD=0.406 PS=3.38 PD=3.38
M$154 \$17 \$17 \$16 sky130_gnd sky130_fd_pr__nfet_01v8_lvt L=0.6 W=1.4
+ AS=0.406 AD=0.406 PS=3.38 PD=3.38
M$155 \$17 \$17 \$16 sky130_gnd sky130_fd_pr__nfet_01v8_lvt L=0.6 W=1.4
+ AS=0.406 AD=0.406 PS=3.38 PD=3.38
M$156 \$17 \$17 \$16 sky130_gnd sky130_fd_pr__nfet_01v8_lvt L=0.6 W=1.4
+ AS=0.406 AD=0.406 PS=3.38 PD=3.38
M$157 \$17 \$17 \$16 sky130_gnd sky130_fd_pr__nfet_01v8_lvt L=0.6 W=1.4
+ AS=0.406 AD=0.406 PS=3.38 PD=3.38
M$158 \$17 \$17 \$16 sky130_gnd sky130_fd_pr__nfet_01v8_lvt L=0.6 W=1.4
+ AS=0.406 AD=0.406 PS=3.38 PD=3.38
M$159 \$17 \$17 \$16 sky130_gnd sky130_fd_pr__nfet_01v8_lvt L=0.6 W=1.4
+ AS=0.406 AD=0.406 PS=3.38 PD=3.38
M$160 \$17 \$17 \$16 sky130_gnd sky130_fd_pr__nfet_01v8_lvt L=0.6 W=1.4
+ AS=0.406 AD=0.406 PS=3.38 PD=3.38
M$161 \$17 \$17 \$16 sky130_gnd sky130_fd_pr__nfet_01v8_lvt L=0.6 W=1.4
+ AS=0.406 AD=0.406 PS=3.38 PD=3.38
M$162 \$17 \$17 \$16 sky130_gnd sky130_fd_pr__nfet_01v8_lvt L=0.6 W=1.4
+ AS=0.406 AD=0.406 PS=3.38 PD=3.38
M$163 \$17 \$17 \$16 sky130_gnd sky130_fd_pr__nfet_01v8_lvt L=0.6 W=1.4
+ AS=0.406 AD=0.406 PS=3.38 PD=3.38
M$164 \$17 \$17 \$16 sky130_gnd sky130_fd_pr__nfet_01v8_lvt L=0.6 W=1.4
+ AS=0.406 AD=0.406 PS=3.38 PD=3.38
M$165 \$17 \$17 \$16 sky130_gnd sky130_fd_pr__nfet_01v8_lvt L=0.6 W=1.4
+ AS=0.406 AD=0.406 PS=3.38 PD=3.38
M$166 \$17 \$17 \$16 sky130_gnd sky130_fd_pr__nfet_01v8_lvt L=0.6 W=1.4
+ AS=0.406 AD=0.406 PS=3.38 PD=3.38
M$167 \$17 \$17 \$16 sky130_gnd sky130_fd_pr__nfet_01v8_lvt L=0.6 W=1.4
+ AS=0.406 AD=0.406 PS=3.38 PD=3.38
M$168 \$17 \$17 \$16 sky130_gnd sky130_fd_pr__nfet_01v8_lvt L=0.6 W=1.4
+ AS=0.406 AD=0.406 PS=3.38 PD=3.38
M$169 \$17 \$17 \$16 sky130_gnd sky130_fd_pr__nfet_01v8_lvt L=0.6 W=1.4
+ AS=0.406 AD=0.406 PS=3.38 PD=3.38
M$170 \$17 \$17 \$16 sky130_gnd sky130_fd_pr__nfet_01v8_lvt L=0.6 W=1.4
+ AS=0.406 AD=0.406 PS=3.38 PD=3.38
M$171 \$17 \$17 \$16 sky130_gnd sky130_fd_pr__nfet_01v8_lvt L=0.6 W=1.4
+ AS=0.406 AD=0.406 PS=3.38 PD=3.38
M$172 \$17 \$17 \$16 sky130_gnd sky130_fd_pr__nfet_01v8_lvt L=0.6 W=1.4
+ AS=0.406 AD=0.406 PS=3.38 PD=3.38
M$173 \$17 \$17 \$16 sky130_gnd sky130_fd_pr__nfet_01v8_lvt L=0.6 W=1.4
+ AS=0.406 AD=0.406 PS=3.38 PD=3.38
M$174 \$17 \$17 \$16 sky130_gnd sky130_fd_pr__nfet_01v8_lvt L=0.6 W=1.4
+ AS=0.406 AD=0.406 PS=3.38 PD=3.38
M$175 \$17 \$17 \$16 sky130_gnd sky130_fd_pr__nfet_01v8_lvt L=0.6 W=1.4
+ AS=0.406 AD=0.406 PS=3.38 PD=3.38
M$176 \$17 \$17 \$16 sky130_gnd sky130_fd_pr__nfet_01v8_lvt L=0.6 W=1.4
+ AS=0.406 AD=0.406 PS=3.38 PD=3.38
M$177 \$17 \$17 \$16 sky130_gnd sky130_fd_pr__nfet_01v8_lvt L=0.6 W=1.4
+ AS=0.406 AD=0.406 PS=3.38 PD=3.38
M$178 \$17 \$17 \$16 sky130_gnd sky130_fd_pr__nfet_01v8_lvt L=0.6 W=1.4
+ AS=0.406 AD=0.406 PS=3.38 PD=3.38
M$179 \$17 \$17 \$16 sky130_gnd sky130_fd_pr__nfet_01v8_lvt L=0.6 W=1.4
+ AS=0.406 AD=0.406 PS=3.38 PD=3.38
M$180 \$17 \$17 \$16 sky130_gnd sky130_fd_pr__nfet_01v8_lvt L=0.6 W=1.4
+ AS=0.406 AD=0.406 PS=3.38 PD=3.38
M$181 VDD VDD VDD VDD sky130_fd_pr__pfet_01v8 L=0.6 W=1.4 AS=0.406 AD=0.406
+ PS=3.38 PD=3.38
M$182 op \$16 \$586 VDD sky130_fd_pr__pfet_01v8 L=0.6 W=1.4 AS=0.406 AD=0.406
+ PS=3.38 PD=3.38
M$183 on \$16 \$536 VDD sky130_fd_pr__pfet_01v8 L=0.6 W=1.4 AS=0.406 AD=0.406
+ PS=3.38 PD=3.38
M$184 op \$16 \$586 VDD sky130_fd_pr__pfet_01v8 L=0.6 W=1.4 AS=0.406 AD=0.406
+ PS=3.38 PD=3.38
M$185 on \$16 \$536 VDD sky130_fd_pr__pfet_01v8 L=0.6 W=1.4 AS=0.406 AD=0.406
+ PS=3.38 PD=3.38
M$186 op \$16 \$586 VDD sky130_fd_pr__pfet_01v8 L=0.6 W=1.4 AS=0.406 AD=0.406
+ PS=3.38 PD=3.38
M$187 on \$16 \$536 VDD sky130_fd_pr__pfet_01v8 L=0.6 W=1.4 AS=0.406 AD=0.406
+ PS=3.38 PD=3.38
M$188 op \$16 \$586 VDD sky130_fd_pr__pfet_01v8 L=0.6 W=1.4 AS=0.406 AD=0.406
+ PS=3.38 PD=3.38
M$189 on \$16 \$536 VDD sky130_fd_pr__pfet_01v8 L=0.6 W=1.4 AS=0.406 AD=0.406
+ PS=3.38 PD=3.38
M$190 op \$16 \$586 VDD sky130_fd_pr__pfet_01v8 L=0.6 W=1.4 AS=0.406 AD=0.406
+ PS=3.38 PD=3.38
M$191 op \$16 \$586 VDD sky130_fd_pr__pfet_01v8 L=0.6 W=1.4 AS=0.406 AD=0.406
+ PS=3.38 PD=3.38
M$192 on \$16 \$536 VDD sky130_fd_pr__pfet_01v8 L=0.6 W=1.4 AS=0.406 AD=0.406
+ PS=3.38 PD=3.38
M$193 op \$16 \$586 VDD sky130_fd_pr__pfet_01v8 L=0.6 W=1.4 AS=0.406 AD=0.406
+ PS=3.38 PD=3.38
M$194 on \$16 \$536 VDD sky130_fd_pr__pfet_01v8 L=0.6 W=1.4 AS=0.406 AD=0.406
+ PS=3.38 PD=3.38
M$195 op \$16 \$586 VDD sky130_fd_pr__pfet_01v8 L=0.6 W=1.4 AS=0.406 AD=0.406
+ PS=3.38 PD=3.38
M$196 on \$16 \$536 VDD sky130_fd_pr__pfet_01v8 L=0.6 W=1.4 AS=0.406 AD=0.406
+ PS=3.38 PD=3.38
M$197 op \$16 \$586 VDD sky130_fd_pr__pfet_01v8 L=0.6 W=1.4 AS=0.406 AD=0.406
+ PS=3.38 PD=3.38
M$198 on \$16 \$536 VDD sky130_fd_pr__pfet_01v8 L=0.6 W=1.4 AS=0.406 AD=0.406
+ PS=3.38 PD=3.38
M$199 op \$16 \$586 VDD sky130_fd_pr__pfet_01v8 L=0.6 W=1.4 AS=0.406 AD=0.406
+ PS=3.38 PD=3.38
M$200 on \$16 \$536 VDD sky130_fd_pr__pfet_01v8 L=0.6 W=1.4 AS=0.406 AD=0.406
+ PS=3.38 PD=3.38
M$201 on \$16 \$536 VDD sky130_fd_pr__pfet_01v8 L=0.6 W=1.4 AS=0.406 AD=0.406
+ PS=3.38 PD=3.38
M$202 VDD VDD VDD VDD sky130_fd_pr__pfet_01v8 L=0.6 W=1.4 AS=0.406 AD=0.406
+ PS=3.38 PD=3.38
M$203 op \$16 \$586 VDD sky130_fd_pr__pfet_01v8 L=0.6 W=1.4 AS=0.406 AD=0.406
+ PS=3.38 PD=3.38
M$204 on \$16 \$536 VDD sky130_fd_pr__pfet_01v8 L=0.6 W=1.4 AS=0.406 AD=0.406
+ PS=3.38 PD=3.38
M$205 op \$16 \$586 VDD sky130_fd_pr__pfet_01v8 L=0.6 W=1.4 AS=0.406 AD=0.406
+ PS=3.38 PD=3.38
M$206 on \$16 \$536 VDD sky130_fd_pr__pfet_01v8 L=0.6 W=1.4 AS=0.406 AD=0.406
+ PS=3.38 PD=3.38
M$207 op \$16 \$586 VDD sky130_fd_pr__pfet_01v8 L=0.6 W=1.4 AS=0.406 AD=0.406
+ PS=3.38 PD=3.38
M$208 on \$16 \$536 VDD sky130_fd_pr__pfet_01v8 L=0.6 W=1.4 AS=0.406 AD=0.406
+ PS=3.38 PD=3.38
M$209 op \$16 \$586 VDD sky130_fd_pr__pfet_01v8 L=0.6 W=1.4 AS=0.406 AD=0.406
+ PS=3.38 PD=3.38
M$210 on \$16 \$536 VDD sky130_fd_pr__pfet_01v8 L=0.6 W=1.4 AS=0.406 AD=0.406
+ PS=3.38 PD=3.38
M$211 on \$16 \$536 VDD sky130_fd_pr__pfet_01v8 L=0.6 W=1.4 AS=0.406 AD=0.406
+ PS=3.38 PD=3.38
M$212 on \$16 \$536 VDD sky130_fd_pr__pfet_01v8 L=0.6 W=1.4 AS=0.406 AD=0.406
+ PS=3.38 PD=3.38
M$213 op \$16 \$586 VDD sky130_fd_pr__pfet_01v8 L=0.6 W=1.4 AS=0.406 AD=0.406
+ PS=3.38 PD=3.38
M$214 on \$16 \$536 VDD sky130_fd_pr__pfet_01v8 L=0.6 W=1.4 AS=0.406 AD=0.406
+ PS=3.38 PD=3.38
M$215 op \$16 \$586 VDD sky130_fd_pr__pfet_01v8 L=0.6 W=1.4 AS=0.406 AD=0.406
+ PS=3.38 PD=3.38
M$216 on \$16 \$536 VDD sky130_fd_pr__pfet_01v8 L=0.6 W=1.4 AS=0.406 AD=0.406
+ PS=3.38 PD=3.38
M$217 op \$16 \$586 VDD sky130_fd_pr__pfet_01v8 L=0.6 W=1.4 AS=0.406 AD=0.406
+ PS=3.38 PD=3.38
M$218 on \$16 \$536 VDD sky130_fd_pr__pfet_01v8 L=0.6 W=1.4 AS=0.406 AD=0.406
+ PS=3.38 PD=3.38
M$219 op \$16 \$586 VDD sky130_fd_pr__pfet_01v8 L=0.6 W=1.4 AS=0.406 AD=0.406
+ PS=3.38 PD=3.38
M$220 on \$16 \$536 VDD sky130_fd_pr__pfet_01v8 L=0.6 W=1.4 AS=0.406 AD=0.406
+ PS=3.38 PD=3.38
M$221 op \$16 \$586 VDD sky130_fd_pr__pfet_01v8 L=0.6 W=1.4 AS=0.406 AD=0.406
+ PS=3.38 PD=3.38
M$222 op \$16 \$586 VDD sky130_fd_pr__pfet_01v8 L=0.6 W=1.4 AS=0.406 AD=0.406
+ PS=3.38 PD=3.38
M$223 VDD VDD VDD VDD sky130_fd_pr__pfet_01v8 L=0.6 W=1.4 AS=0.406 AD=0.406
+ PS=3.38 PD=3.38
M$224 \$247 \$16 \$365 VDD sky130_fd_pr__pfet_01v8 L=0.6 W=1.4 AS=0.406
+ AD=0.406 PS=3.38 PD=3.38
M$225 \$17 \$16 \$408 VDD sky130_fd_pr__pfet_01v8 L=0.6 W=1.4 AS=0.406 AD=0.406
+ PS=3.38 PD=3.38
M$226 \$247 \$16 \$365 VDD sky130_fd_pr__pfet_01v8 L=0.6 W=1.4 AS=0.406
+ AD=0.406 PS=3.38 PD=3.38
M$227 \$17 \$16 \$408 VDD sky130_fd_pr__pfet_01v8 L=0.6 W=1.4 AS=0.406 AD=0.406
+ PS=3.38 PD=3.38
M$228 \$247 \$16 \$365 VDD sky130_fd_pr__pfet_01v8 L=0.6 W=1.4 AS=0.406
+ AD=0.406 PS=3.38 PD=3.38
M$229 \$17 \$16 \$408 VDD sky130_fd_pr__pfet_01v8 L=0.6 W=1.4 AS=0.406 AD=0.406
+ PS=3.38 PD=3.38
M$230 VDD VDD VDD VDD sky130_fd_pr__pfet_01v8 L=0.6 W=1.4 AS=0.406 AD=0.406
+ PS=3.38 PD=3.38
M$231 \$17 \$16 \$408 VDD sky130_fd_pr__pfet_01v8 L=0.6 W=1.4 AS=0.406 AD=0.406
+ PS=3.38 PD=3.38
M$232 \$247 \$16 \$365 VDD sky130_fd_pr__pfet_01v8 L=0.6 W=1.4 AS=0.406
+ AD=0.406 PS=3.38 PD=3.38
M$233 \$17 \$16 \$408 VDD sky130_fd_pr__pfet_01v8 L=0.6 W=1.4 AS=0.406 AD=0.406
+ PS=3.38 PD=3.38
M$234 \$247 \$16 \$365 VDD sky130_fd_pr__pfet_01v8 L=0.6 W=1.4 AS=0.406
+ AD=0.406 PS=3.38 PD=3.38
M$235 \$17 \$16 \$408 VDD sky130_fd_pr__pfet_01v8 L=0.6 W=1.4 AS=0.406 AD=0.406
+ PS=3.38 PD=3.38
M$236 \$247 \$16 \$365 VDD sky130_fd_pr__pfet_01v8 L=0.6 W=1.4 AS=0.406
+ AD=0.406 PS=3.38 PD=3.38
M$237 cm \$16 \$340 VDD sky130_fd_pr__pfet_01v8 L=0.6 W=1.4 AS=0.406 AD=0.406
+ PS=3.38 PD=3.38
M$238 cm \$16 \$340 VDD sky130_fd_pr__pfet_01v8 L=0.6 W=1.4 AS=0.406 AD=0.406
+ PS=3.38 PD=3.38
M$239 cm \$16 \$340 VDD sky130_fd_pr__pfet_01v8 L=0.6 W=1.4 AS=0.406 AD=0.406
+ PS=3.38 PD=3.38
M$240 cm \$16 \$340 VDD sky130_fd_pr__pfet_01v8 L=0.6 W=1.4 AS=0.406 AD=0.406
+ PS=3.38 PD=3.38
M$241 cm \$16 \$340 VDD sky130_fd_pr__pfet_01v8 L=0.6 W=1.4 AS=0.406 AD=0.406
+ PS=3.38 PD=3.38
M$242 cm \$16 \$340 VDD sky130_fd_pr__pfet_01v8 L=0.6 W=1.4 AS=0.406 AD=0.406
+ PS=3.38 PD=3.38
M$243 VDD VDD VDD VDD sky130_fd_pr__pfet_01v8 L=0.6 W=1.4 AS=0.406 AD=0.406
+ PS=3.38 PD=3.38
M$244 VDD VDD VDD VDD sky130_fd_pr__pfet_01v8 L=0.6 W=1.4 AS=0.406 AD=0.406
+ PS=3.38 PD=3.38
M$245 VDD VDD VDD VDD sky130_fd_pr__pfet_01v8 L=0.6 W=1.4 AS=0.406 AD=0.406
+ PS=3.38 PD=3.38
M$246 VDD VDD VDD VDD sky130_fd_pr__pfet_01v8 L=0.6 W=1.4 AS=0.406 AD=0.406
+ PS=3.38 PD=3.38
M$247 VDD VDD VDD VDD sky130_fd_pr__pfet_01v8 L=0.6 W=1.4 AS=0.406 AD=0.406
+ PS=3.38 PD=3.38
M$248 VDD VDD VDD VDD sky130_fd_pr__pfet_01v8 L=0.6 W=1.4 AS=0.406 AD=0.406
+ PS=3.38 PD=3.38
M$249 \$340 \$340 \$340 VDD sky130_fd_pr__pfet_01v8_lvt L=0.6 W=1.4 AS=0.406
+ AD=0.406 PS=3.38 PD=3.38
M$250 \$340 \$340 \$340 VDD sky130_fd_pr__pfet_01v8_lvt L=0.6 W=1.4 AS=0.406
+ AD=0.406 PS=3.38 PD=3.38
M$251 \$365 \$365 \$365 VDD sky130_fd_pr__pfet_01v8_lvt L=0.6 W=1.4 AS=0.406
+ AD=0.406 PS=3.38 PD=3.38
M$252 \$365 \$365 \$365 VDD sky130_fd_pr__pfet_01v8_lvt L=0.6 W=1.4 AS=0.406
+ AD=0.406 PS=3.38 PD=3.38
M$253 \$408 \$408 \$408 VDD sky130_fd_pr__pfet_01v8_lvt L=0.6 W=1.4 AS=0.406
+ AD=0.406 PS=3.38 PD=3.38
M$254 \$408 \$408 \$408 VDD sky130_fd_pr__pfet_01v8_lvt L=0.6 W=1.4 AS=0.406
+ AD=0.406 PS=3.38 PD=3.38
M$255 VDD VDD VDD VDD sky130_fd_pr__pfet_01v8_lvt L=0.6 W=1.4 AS=0.406 AD=0.406
+ PS=3.38 PD=3.38
M$256 VDD VDD VDD VDD sky130_fd_pr__pfet_01v8_lvt L=0.6 W=1.4 AS=0.406 AD=0.406
+ PS=3.38 PD=3.38
M$257 VDD VDD VDD VDD sky130_fd_pr__pfet_01v8_lvt L=0.6 W=1.4 AS=0.406 AD=0.406
+ PS=3.38 PD=3.38
M$258 VDD VDD VDD VDD sky130_fd_pr__pfet_01v8_lvt L=0.6 W=1.4 AS=0.406 AD=0.406
+ PS=3.38 PD=3.38
M$259 VDD VDD VDD VDD sky130_fd_pr__pfet_01v8_lvt L=0.6 W=1.4 AS=0.406 AD=0.406
+ PS=3.38 PD=3.38
M$260 VDD VDD VDD VDD sky130_fd_pr__pfet_01v8_lvt L=0.6 W=1.4 AS=0.406 AD=0.406
+ PS=3.38 PD=3.38
M$261 VDD VDD VDD VDD sky130_fd_pr__pfet_01v8_lvt L=0.6 W=1.4 AS=0.406 AD=0.406
+ PS=3.38 PD=3.38
M$262 VDD VDD VDD VDD sky130_fd_pr__pfet_01v8_lvt L=0.6 W=1.4 AS=0.406 AD=0.406
+ PS=3.38 PD=3.38
M$263 on \$19 \$621 sky130_gnd sky130_fd_pr__nfet_01v8 L=0.6 W=1.4 AS=0.406
+ AD=0.406 PS=3.38 PD=3.38
M$264 on \$19 \$621 sky130_gnd sky130_fd_pr__nfet_01v8 L=0.6 W=1.4 AS=0.406
+ AD=0.406 PS=3.38 PD=3.38
M$265 on \$19 \$621 sky130_gnd sky130_fd_pr__nfet_01v8 L=0.6 W=1.4 AS=0.406
+ AD=0.406 PS=3.38 PD=3.38
M$266 on \$19 \$621 sky130_gnd sky130_fd_pr__nfet_01v8 L=0.6 W=1.4 AS=0.406
+ AD=0.406 PS=3.38 PD=3.38
M$267 on \$19 \$621 sky130_gnd sky130_fd_pr__nfet_01v8 L=0.6 W=1.4 AS=0.406
+ AD=0.406 PS=3.38 PD=3.38
M$268 on \$19 \$621 sky130_gnd sky130_fd_pr__nfet_01v8 L=0.6 W=1.4 AS=0.406
+ AD=0.406 PS=3.38 PD=3.38
M$269 on \$19 \$621 sky130_gnd sky130_fd_pr__nfet_01v8 L=0.6 W=1.4 AS=0.406
+ AD=0.406 PS=3.38 PD=3.38
M$270 on \$19 \$621 sky130_gnd sky130_fd_pr__nfet_01v8 L=0.6 W=1.4 AS=0.406
+ AD=0.406 PS=3.38 PD=3.38
M$271 on \$19 \$621 sky130_gnd sky130_fd_pr__nfet_01v8 L=0.6 W=1.4 AS=0.406
+ AD=0.406 PS=3.38 PD=3.38
M$272 on \$19 \$621 sky130_gnd sky130_fd_pr__nfet_01v8 L=0.6 W=1.4 AS=0.406
+ AD=0.406 PS=3.38 PD=3.38
M$273 on \$19 \$621 sky130_gnd sky130_fd_pr__nfet_01v8 L=0.6 W=1.4 AS=0.406
+ AD=0.406 PS=3.38 PD=3.38
M$274 on \$19 \$621 sky130_gnd sky130_fd_pr__nfet_01v8 L=0.6 W=1.4 AS=0.406
+ AD=0.406 PS=3.38 PD=3.38
M$275 on \$19 \$621 sky130_gnd sky130_fd_pr__nfet_01v8 L=0.6 W=1.4 AS=0.406
+ AD=0.406 PS=3.38 PD=3.38
M$276 on \$19 \$621 sky130_gnd sky130_fd_pr__nfet_01v8 L=0.6 W=1.4 AS=0.406
+ AD=0.406 PS=3.38 PD=3.38
M$277 on \$19 \$621 sky130_gnd sky130_fd_pr__nfet_01v8 L=0.6 W=1.4 AS=0.406
+ AD=0.406 PS=3.38 PD=3.38
M$278 on \$19 \$621 sky130_gnd sky130_fd_pr__nfet_01v8 L=0.6 W=1.4 AS=0.406
+ AD=0.406 PS=3.38 PD=3.38
M$279 on \$19 \$621 sky130_gnd sky130_fd_pr__nfet_01v8 L=0.6 W=1.4 AS=0.406
+ AD=0.406 PS=3.38 PD=3.38
M$280 on \$19 \$621 sky130_gnd sky130_fd_pr__nfet_01v8 L=0.6 W=1.4 AS=0.406
+ AD=0.406 PS=3.38 PD=3.38
M$281 on \$19 \$621 sky130_gnd sky130_fd_pr__nfet_01v8 L=0.6 W=1.4 AS=0.406
+ AD=0.406 PS=3.38 PD=3.38
M$282 on \$19 \$621 sky130_gnd sky130_fd_pr__nfet_01v8 L=0.6 W=1.4 AS=0.406
+ AD=0.406 PS=3.38 PD=3.38
M$283 on \$19 \$621 sky130_gnd sky130_fd_pr__nfet_01v8 L=0.6 W=1.4 AS=0.406
+ AD=0.406 PS=3.38 PD=3.38
M$284 on \$19 \$621 sky130_gnd sky130_fd_pr__nfet_01v8 L=0.6 W=1.4 AS=0.406
+ AD=0.406 PS=3.38 PD=3.38
M$285 on \$19 \$621 sky130_gnd sky130_fd_pr__nfet_01v8 L=0.6 W=1.4 AS=0.406
+ AD=0.406 PS=3.38 PD=3.38
M$286 on \$19 \$621 sky130_gnd sky130_fd_pr__nfet_01v8 L=0.6 W=1.4 AS=0.406
+ AD=0.406 PS=3.38 PD=3.38
M$287 on \$19 \$621 sky130_gnd sky130_fd_pr__nfet_01v8 L=0.6 W=1.4 AS=0.406
+ AD=0.406 PS=3.38 PD=3.38
M$288 on \$19 \$621 sky130_gnd sky130_fd_pr__nfet_01v8 L=0.6 W=1.4 AS=0.406
+ AD=0.406 PS=3.38 PD=3.38
M$289 on \$19 \$621 sky130_gnd sky130_fd_pr__nfet_01v8 L=0.6 W=1.4 AS=0.406
+ AD=0.406 PS=3.38 PD=3.38
M$290 on \$19 \$621 sky130_gnd sky130_fd_pr__nfet_01v8 L=0.6 W=1.4 AS=0.406
+ AD=0.406 PS=3.38 PD=3.38
M$291 on \$19 \$621 sky130_gnd sky130_fd_pr__nfet_01v8 L=0.6 W=1.4 AS=0.406
+ AD=0.406 PS=3.38 PD=3.38
M$292 on \$19 \$621 sky130_gnd sky130_fd_pr__nfet_01v8 L=0.6 W=1.4 AS=0.406
+ AD=0.406 PS=3.38 PD=3.38
M$293 on \$19 \$621 sky130_gnd sky130_fd_pr__nfet_01v8 L=0.6 W=1.4 AS=0.406
+ AD=0.406 PS=3.38 PD=3.38
M$294 on \$19 \$621 sky130_gnd sky130_fd_pr__nfet_01v8 L=0.6 W=1.4 AS=0.406
+ AD=0.406 PS=3.38 PD=3.38
M$295 on \$19 \$621 sky130_gnd sky130_fd_pr__nfet_01v8 L=0.6 W=1.4 AS=0.406
+ AD=0.406 PS=3.38 PD=3.38
M$296 on \$19 \$621 sky130_gnd sky130_fd_pr__nfet_01v8 L=0.6 W=1.4 AS=0.406
+ AD=0.406 PS=3.38 PD=3.38
M$297 on \$19 \$621 sky130_gnd sky130_fd_pr__nfet_01v8 L=0.6 W=1.4 AS=0.406
+ AD=0.406 PS=3.38 PD=3.38
M$298 on \$19 \$621 sky130_gnd sky130_fd_pr__nfet_01v8 L=0.6 W=1.4 AS=0.406
+ AD=0.406 PS=3.38 PD=3.38
M$299 op \$19 \$623 sky130_gnd sky130_fd_pr__nfet_01v8 L=0.6 W=1.4 AS=0.406
+ AD=0.406 PS=3.38 PD=3.38
M$300 op \$19 \$623 sky130_gnd sky130_fd_pr__nfet_01v8 L=0.6 W=1.4 AS=0.406
+ AD=0.406 PS=3.38 PD=3.38
M$301 op \$19 \$623 sky130_gnd sky130_fd_pr__nfet_01v8 L=0.6 W=1.4 AS=0.406
+ AD=0.406 PS=3.38 PD=3.38
M$302 op \$19 \$623 sky130_gnd sky130_fd_pr__nfet_01v8 L=0.6 W=1.4 AS=0.406
+ AD=0.406 PS=3.38 PD=3.38
M$303 op \$19 \$623 sky130_gnd sky130_fd_pr__nfet_01v8 L=0.6 W=1.4 AS=0.406
+ AD=0.406 PS=3.38 PD=3.38
M$304 op \$19 \$623 sky130_gnd sky130_fd_pr__nfet_01v8 L=0.6 W=1.4 AS=0.406
+ AD=0.406 PS=3.38 PD=3.38
M$305 op \$19 \$623 sky130_gnd sky130_fd_pr__nfet_01v8 L=0.6 W=1.4 AS=0.406
+ AD=0.406 PS=3.38 PD=3.38
M$306 op \$19 \$623 sky130_gnd sky130_fd_pr__nfet_01v8 L=0.6 W=1.4 AS=0.406
+ AD=0.406 PS=3.38 PD=3.38
M$307 op \$19 \$623 sky130_gnd sky130_fd_pr__nfet_01v8 L=0.6 W=1.4 AS=0.406
+ AD=0.406 PS=3.38 PD=3.38
M$308 op \$19 \$623 sky130_gnd sky130_fd_pr__nfet_01v8 L=0.6 W=1.4 AS=0.406
+ AD=0.406 PS=3.38 PD=3.38
M$309 op \$19 \$623 sky130_gnd sky130_fd_pr__nfet_01v8 L=0.6 W=1.4 AS=0.406
+ AD=0.406 PS=3.38 PD=3.38
M$310 op \$19 \$623 sky130_gnd sky130_fd_pr__nfet_01v8 L=0.6 W=1.4 AS=0.406
+ AD=0.406 PS=3.38 PD=3.38
M$311 op \$19 \$623 sky130_gnd sky130_fd_pr__nfet_01v8 L=0.6 W=1.4 AS=0.406
+ AD=0.406 PS=3.38 PD=3.38
M$312 op \$19 \$623 sky130_gnd sky130_fd_pr__nfet_01v8 L=0.6 W=1.4 AS=0.406
+ AD=0.406 PS=3.38 PD=3.38
M$313 op \$19 \$623 sky130_gnd sky130_fd_pr__nfet_01v8 L=0.6 W=1.4 AS=0.406
+ AD=0.406 PS=3.38 PD=3.38
M$314 op \$19 \$623 sky130_gnd sky130_fd_pr__nfet_01v8 L=0.6 W=1.4 AS=0.406
+ AD=0.406 PS=3.38 PD=3.38
M$315 op \$19 \$623 sky130_gnd sky130_fd_pr__nfet_01v8 L=0.6 W=1.4 AS=0.406
+ AD=0.406 PS=3.38 PD=3.38
M$316 op \$19 \$623 sky130_gnd sky130_fd_pr__nfet_01v8 L=0.6 W=1.4 AS=0.406
+ AD=0.406 PS=3.38 PD=3.38
M$317 op \$19 \$623 sky130_gnd sky130_fd_pr__nfet_01v8 L=0.6 W=1.4 AS=0.406
+ AD=0.406 PS=3.38 PD=3.38
M$318 op \$19 \$623 sky130_gnd sky130_fd_pr__nfet_01v8 L=0.6 W=1.4 AS=0.406
+ AD=0.406 PS=3.38 PD=3.38
M$319 op \$19 \$623 sky130_gnd sky130_fd_pr__nfet_01v8 L=0.6 W=1.4 AS=0.406
+ AD=0.406 PS=3.38 PD=3.38
M$320 op \$19 \$623 sky130_gnd sky130_fd_pr__nfet_01v8 L=0.6 W=1.4 AS=0.406
+ AD=0.406 PS=3.38 PD=3.38
M$321 op \$19 \$623 sky130_gnd sky130_fd_pr__nfet_01v8 L=0.6 W=1.4 AS=0.406
+ AD=0.406 PS=3.38 PD=3.38
M$322 op \$19 \$623 sky130_gnd sky130_fd_pr__nfet_01v8 L=0.6 W=1.4 AS=0.406
+ AD=0.406 PS=3.38 PD=3.38
M$323 op \$19 \$623 sky130_gnd sky130_fd_pr__nfet_01v8 L=0.6 W=1.4 AS=0.406
+ AD=0.406 PS=3.38 PD=3.38
M$324 op \$19 \$623 sky130_gnd sky130_fd_pr__nfet_01v8 L=0.6 W=1.4 AS=0.406
+ AD=0.406 PS=3.38 PD=3.38
M$325 op \$19 \$623 sky130_gnd sky130_fd_pr__nfet_01v8 L=0.6 W=1.4 AS=0.406
+ AD=0.406 PS=3.38 PD=3.38
M$326 op \$19 \$623 sky130_gnd sky130_fd_pr__nfet_01v8 L=0.6 W=1.4 AS=0.406
+ AD=0.406 PS=3.38 PD=3.38
M$327 op \$19 \$623 sky130_gnd sky130_fd_pr__nfet_01v8 L=0.6 W=1.4 AS=0.406
+ AD=0.406 PS=3.38 PD=3.38
M$328 op \$19 \$623 sky130_gnd sky130_fd_pr__nfet_01v8 L=0.6 W=1.4 AS=0.406
+ AD=0.406 PS=3.38 PD=3.38
M$329 op \$19 \$623 sky130_gnd sky130_fd_pr__nfet_01v8 L=0.6 W=1.4 AS=0.406
+ AD=0.406 PS=3.38 PD=3.38
M$330 op \$19 \$623 sky130_gnd sky130_fd_pr__nfet_01v8 L=0.6 W=1.4 AS=0.406
+ AD=0.406 PS=3.38 PD=3.38
M$331 op \$19 \$623 sky130_gnd sky130_fd_pr__nfet_01v8 L=0.6 W=1.4 AS=0.406
+ AD=0.406 PS=3.38 PD=3.38
M$332 op \$19 \$623 sky130_gnd sky130_fd_pr__nfet_01v8 L=0.6 W=1.4 AS=0.406
+ AD=0.406 PS=3.38 PD=3.38
M$333 op \$19 \$623 sky130_gnd sky130_fd_pr__nfet_01v8 L=0.6 W=1.4 AS=0.406
+ AD=0.406 PS=3.38 PD=3.38
M$334 op \$19 \$623 sky130_gnd sky130_fd_pr__nfet_01v8 L=0.6 W=1.4 AS=0.406
+ AD=0.406 PS=3.38 PD=3.38
M$335 VSS VSS VSS sky130_gnd sky130_fd_pr__nfet_01v8 L=0.6 W=1.4 AS=0.406
+ AD=0.406 PS=3.38 PD=3.38
M$336 VSS VSS VSS sky130_gnd sky130_fd_pr__nfet_01v8 L=0.6 W=1.4 AS=0.406
+ AD=0.406 PS=3.38 PD=3.38
M$337 \$621 bias_a VSS sky130_gnd sky130_fd_pr__nfet_01v8 L=0.6 W=1.4 AS=0.406
+ AD=0.406 PS=3.38 PD=3.38
M$338 \$621 bias_a VSS sky130_gnd sky130_fd_pr__nfet_01v8 L=0.6 W=1.4 AS=0.406
+ AD=0.406 PS=3.38 PD=3.38
M$339 \$621 bias_a VSS sky130_gnd sky130_fd_pr__nfet_01v8 L=0.6 W=1.4 AS=0.406
+ AD=0.406 PS=3.38 PD=3.38
M$340 \$621 bias_a VSS sky130_gnd sky130_fd_pr__nfet_01v8 L=0.6 W=1.4 AS=0.406
+ AD=0.406 PS=3.38 PD=3.38
M$341 \$621 bias_a VSS sky130_gnd sky130_fd_pr__nfet_01v8 L=0.6 W=1.4 AS=0.406
+ AD=0.406 PS=3.38 PD=3.38
M$342 \$621 bias_a VSS sky130_gnd sky130_fd_pr__nfet_01v8 L=0.6 W=1.4 AS=0.406
+ AD=0.406 PS=3.38 PD=3.38
M$343 \$621 bias_a VSS sky130_gnd sky130_fd_pr__nfet_01v8 L=0.6 W=1.4 AS=0.406
+ AD=0.406 PS=3.38 PD=3.38
M$344 \$621 bias_a VSS sky130_gnd sky130_fd_pr__nfet_01v8 L=0.6 W=1.4 AS=0.406
+ AD=0.406 PS=3.38 PD=3.38
M$345 \$621 bias_a VSS sky130_gnd sky130_fd_pr__nfet_01v8 L=0.6 W=1.4 AS=0.406
+ AD=0.406 PS=3.38 PD=3.38
M$346 \$621 bias_a VSS sky130_gnd sky130_fd_pr__nfet_01v8 L=0.6 W=1.4 AS=0.406
+ AD=0.406 PS=3.38 PD=3.38
M$347 \$621 bias_a VSS sky130_gnd sky130_fd_pr__nfet_01v8 L=0.6 W=1.4 AS=0.406
+ AD=0.406 PS=3.38 PD=3.38
M$348 \$621 bias_a VSS sky130_gnd sky130_fd_pr__nfet_01v8 L=0.6 W=1.4 AS=0.406
+ AD=0.406 PS=3.38 PD=3.38
M$349 \$621 bias_a VSS sky130_gnd sky130_fd_pr__nfet_01v8 L=0.6 W=1.4 AS=0.406
+ AD=0.406 PS=3.38 PD=3.38
M$350 \$621 bias_a VSS sky130_gnd sky130_fd_pr__nfet_01v8 L=0.6 W=1.4 AS=0.406
+ AD=0.406 PS=3.38 PD=3.38
M$351 \$621 bias_a VSS sky130_gnd sky130_fd_pr__nfet_01v8 L=0.6 W=1.4 AS=0.406
+ AD=0.406 PS=3.38 PD=3.38
M$352 \$621 bias_a VSS sky130_gnd sky130_fd_pr__nfet_01v8 L=0.6 W=1.4 AS=0.406
+ AD=0.406 PS=3.38 PD=3.38
M$353 \$621 bias_a VSS sky130_gnd sky130_fd_pr__nfet_01v8 L=0.6 W=1.4 AS=0.406
+ AD=0.406 PS=3.38 PD=3.38
M$354 \$621 bias_a VSS sky130_gnd sky130_fd_pr__nfet_01v8 L=0.6 W=1.4 AS=0.406
+ AD=0.406 PS=3.38 PD=3.38
M$355 \$621 bias_a VSS sky130_gnd sky130_fd_pr__nfet_01v8 L=0.6 W=1.4 AS=0.406
+ AD=0.406 PS=3.38 PD=3.38
M$356 \$621 bias_a VSS sky130_gnd sky130_fd_pr__nfet_01v8 L=0.6 W=1.4 AS=0.406
+ AD=0.406 PS=3.38 PD=3.38
M$357 \$621 bias_a VSS sky130_gnd sky130_fd_pr__nfet_01v8 L=0.6 W=1.4 AS=0.406
+ AD=0.406 PS=3.38 PD=3.38
M$358 \$621 bias_a VSS sky130_gnd sky130_fd_pr__nfet_01v8 L=0.6 W=1.4 AS=0.406
+ AD=0.406 PS=3.38 PD=3.38
M$359 \$621 bias_a VSS sky130_gnd sky130_fd_pr__nfet_01v8 L=0.6 W=1.4 AS=0.406
+ AD=0.406 PS=3.38 PD=3.38
M$360 \$621 bias_a VSS sky130_gnd sky130_fd_pr__nfet_01v8 L=0.6 W=1.4 AS=0.406
+ AD=0.406 PS=3.38 PD=3.38
M$361 \$621 bias_a VSS sky130_gnd sky130_fd_pr__nfet_01v8 L=0.6 W=1.4 AS=0.406
+ AD=0.406 PS=3.38 PD=3.38
M$362 \$621 bias_a VSS sky130_gnd sky130_fd_pr__nfet_01v8 L=0.6 W=1.4 AS=0.406
+ AD=0.406 PS=3.38 PD=3.38
M$363 \$621 bias_a VSS sky130_gnd sky130_fd_pr__nfet_01v8 L=0.6 W=1.4 AS=0.406
+ AD=0.406 PS=3.38 PD=3.38
M$364 \$621 bias_a VSS sky130_gnd sky130_fd_pr__nfet_01v8 L=0.6 W=1.4 AS=0.406
+ AD=0.406 PS=3.38 PD=3.38
M$365 \$621 bias_a VSS sky130_gnd sky130_fd_pr__nfet_01v8 L=0.6 W=1.4 AS=0.406
+ AD=0.406 PS=3.38 PD=3.38
M$366 \$621 bias_a VSS sky130_gnd sky130_fd_pr__nfet_01v8 L=0.6 W=1.4 AS=0.406
+ AD=0.406 PS=3.38 PD=3.38
M$367 \$621 bias_a VSS sky130_gnd sky130_fd_pr__nfet_01v8 L=0.6 W=1.4 AS=0.406
+ AD=0.406 PS=3.38 PD=3.38
M$368 \$621 bias_a VSS sky130_gnd sky130_fd_pr__nfet_01v8 L=0.6 W=1.4 AS=0.406
+ AD=0.406 PS=3.38 PD=3.38
M$369 \$621 bias_a VSS sky130_gnd sky130_fd_pr__nfet_01v8 L=0.6 W=1.4 AS=0.406
+ AD=0.406 PS=3.38 PD=3.38
M$370 \$621 bias_a VSS sky130_gnd sky130_fd_pr__nfet_01v8 L=0.6 W=1.4 AS=0.406
+ AD=0.406 PS=3.38 PD=3.38
M$371 \$621 bias_a VSS sky130_gnd sky130_fd_pr__nfet_01v8 L=0.6 W=1.4 AS=0.406
+ AD=0.406 PS=3.38 PD=3.38
M$372 \$621 bias_a VSS sky130_gnd sky130_fd_pr__nfet_01v8 L=0.6 W=1.4 AS=0.406
+ AD=0.406 PS=3.38 PD=3.38
M$373 \$623 bias_a VSS sky130_gnd sky130_fd_pr__nfet_01v8 L=0.6 W=1.4 AS=0.406
+ AD=0.406 PS=3.38 PD=3.38
M$374 \$623 bias_a VSS sky130_gnd sky130_fd_pr__nfet_01v8 L=0.6 W=1.4 AS=0.406
+ AD=0.406 PS=3.38 PD=3.38
M$375 \$623 bias_a VSS sky130_gnd sky130_fd_pr__nfet_01v8 L=0.6 W=1.4 AS=0.406
+ AD=0.406 PS=3.38 PD=3.38
M$376 \$623 bias_a VSS sky130_gnd sky130_fd_pr__nfet_01v8 L=0.6 W=1.4 AS=0.406
+ AD=0.406 PS=3.38 PD=3.38
M$377 \$623 bias_a VSS sky130_gnd sky130_fd_pr__nfet_01v8 L=0.6 W=1.4 AS=0.406
+ AD=0.406 PS=3.38 PD=3.38
M$378 \$623 bias_a VSS sky130_gnd sky130_fd_pr__nfet_01v8 L=0.6 W=1.4 AS=0.406
+ AD=0.406 PS=3.38 PD=3.38
M$379 \$623 bias_a VSS sky130_gnd sky130_fd_pr__nfet_01v8 L=0.6 W=1.4 AS=0.406
+ AD=0.406 PS=3.38 PD=3.38
M$380 \$623 bias_a VSS sky130_gnd sky130_fd_pr__nfet_01v8 L=0.6 W=1.4 AS=0.406
+ AD=0.406 PS=3.38 PD=3.38
M$381 \$623 bias_a VSS sky130_gnd sky130_fd_pr__nfet_01v8 L=0.6 W=1.4 AS=0.406
+ AD=0.406 PS=3.38 PD=3.38
M$382 \$623 bias_a VSS sky130_gnd sky130_fd_pr__nfet_01v8 L=0.6 W=1.4 AS=0.406
+ AD=0.406 PS=3.38 PD=3.38
M$383 \$623 bias_a VSS sky130_gnd sky130_fd_pr__nfet_01v8 L=0.6 W=1.4 AS=0.406
+ AD=0.406 PS=3.38 PD=3.38
M$384 \$623 bias_a VSS sky130_gnd sky130_fd_pr__nfet_01v8 L=0.6 W=1.4 AS=0.406
+ AD=0.406 PS=3.38 PD=3.38
M$385 \$623 bias_a VSS sky130_gnd sky130_fd_pr__nfet_01v8 L=0.6 W=1.4 AS=0.406
+ AD=0.406 PS=3.38 PD=3.38
M$386 \$623 bias_a VSS sky130_gnd sky130_fd_pr__nfet_01v8 L=0.6 W=1.4 AS=0.406
+ AD=0.406 PS=3.38 PD=3.38
M$387 \$623 bias_a VSS sky130_gnd sky130_fd_pr__nfet_01v8 L=0.6 W=1.4 AS=0.406
+ AD=0.406 PS=3.38 PD=3.38
M$388 \$623 bias_a VSS sky130_gnd sky130_fd_pr__nfet_01v8 L=0.6 W=1.4 AS=0.406
+ AD=0.406 PS=3.38 PD=3.38
M$389 \$623 bias_a VSS sky130_gnd sky130_fd_pr__nfet_01v8 L=0.6 W=1.4 AS=0.406
+ AD=0.406 PS=3.38 PD=3.38
M$390 \$623 bias_a VSS sky130_gnd sky130_fd_pr__nfet_01v8 L=0.6 W=1.4 AS=0.406
+ AD=0.406 PS=3.38 PD=3.38
M$391 \$623 bias_a VSS sky130_gnd sky130_fd_pr__nfet_01v8 L=0.6 W=1.4 AS=0.406
+ AD=0.406 PS=3.38 PD=3.38
M$392 \$623 bias_a VSS sky130_gnd sky130_fd_pr__nfet_01v8 L=0.6 W=1.4 AS=0.406
+ AD=0.406 PS=3.38 PD=3.38
M$393 \$623 bias_a VSS sky130_gnd sky130_fd_pr__nfet_01v8 L=0.6 W=1.4 AS=0.406
+ AD=0.406 PS=3.38 PD=3.38
M$394 \$623 bias_a VSS sky130_gnd sky130_fd_pr__nfet_01v8 L=0.6 W=1.4 AS=0.406
+ AD=0.406 PS=3.38 PD=3.38
M$395 \$623 bias_a VSS sky130_gnd sky130_fd_pr__nfet_01v8 L=0.6 W=1.4 AS=0.406
+ AD=0.406 PS=3.38 PD=3.38
M$396 \$623 bias_a VSS sky130_gnd sky130_fd_pr__nfet_01v8 L=0.6 W=1.4 AS=0.406
+ AD=0.406 PS=3.38 PD=3.38
M$397 \$623 bias_a VSS sky130_gnd sky130_fd_pr__nfet_01v8 L=0.6 W=1.4 AS=0.406
+ AD=0.406 PS=3.38 PD=3.38
M$398 \$623 bias_a VSS sky130_gnd sky130_fd_pr__nfet_01v8 L=0.6 W=1.4 AS=0.406
+ AD=0.406 PS=3.38 PD=3.38
M$399 \$623 bias_a VSS sky130_gnd sky130_fd_pr__nfet_01v8 L=0.6 W=1.4 AS=0.406
+ AD=0.406 PS=3.38 PD=3.38
M$400 \$623 bias_a VSS sky130_gnd sky130_fd_pr__nfet_01v8 L=0.6 W=1.4 AS=0.406
+ AD=0.406 PS=3.38 PD=3.38
M$401 \$623 bias_a VSS sky130_gnd sky130_fd_pr__nfet_01v8 L=0.6 W=1.4 AS=0.406
+ AD=0.406 PS=3.38 PD=3.38
M$402 \$623 bias_a VSS sky130_gnd sky130_fd_pr__nfet_01v8 L=0.6 W=1.4 AS=0.406
+ AD=0.406 PS=3.38 PD=3.38
M$403 \$623 bias_a VSS sky130_gnd sky130_fd_pr__nfet_01v8 L=0.6 W=1.4 AS=0.406
+ AD=0.406 PS=3.38 PD=3.38
M$404 \$623 bias_a VSS sky130_gnd sky130_fd_pr__nfet_01v8 L=0.6 W=1.4 AS=0.406
+ AD=0.406 PS=3.38 PD=3.38
M$405 \$623 bias_a VSS sky130_gnd sky130_fd_pr__nfet_01v8 L=0.6 W=1.4 AS=0.406
+ AD=0.406 PS=3.38 PD=3.38
M$406 \$623 bias_a VSS sky130_gnd sky130_fd_pr__nfet_01v8 L=0.6 W=1.4 AS=0.406
+ AD=0.406 PS=3.38 PD=3.38
M$407 \$623 bias_a VSS sky130_gnd sky130_fd_pr__nfet_01v8 L=0.6 W=1.4 AS=0.406
+ AD=0.406 PS=3.38 PD=3.38
M$408 \$623 bias_a VSS sky130_gnd sky130_fd_pr__nfet_01v8 L=0.6 W=1.4 AS=0.406
+ AD=0.406 PS=3.38 PD=3.38
M$409 VSS VSS VSS sky130_gnd sky130_fd_pr__nfet_01v8 L=0.6 W=1.4 AS=0.406
+ AD=0.406 PS=3.38 PD=3.38
M$410 VSS VSS VSS sky130_gnd sky130_fd_pr__nfet_01v8 L=0.6 W=1.4 AS=0.406
+ AD=0.406 PS=3.38 PD=3.38
M$411 \$558 bias_a VSS sky130_gnd sky130_fd_pr__nfet_01v8 L=0.6 W=1.4 AS=0.406
+ AD=0.406 PS=3.38 PD=3.38
M$412 \$558 bias_a VSS sky130_gnd sky130_fd_pr__nfet_01v8 L=0.6 W=1.4 AS=0.406
+ AD=0.406 PS=3.38 PD=3.38
M$413 \$558 bias_a VSS sky130_gnd sky130_fd_pr__nfet_01v8 L=0.6 W=1.4 AS=0.406
+ AD=0.406 PS=3.38 PD=3.38
M$414 \$558 bias_a VSS sky130_gnd sky130_fd_pr__nfet_01v8 L=0.6 W=1.4 AS=0.406
+ AD=0.406 PS=3.38 PD=3.38
M$415 \$558 bias_a VSS sky130_gnd sky130_fd_pr__nfet_01v8 L=0.6 W=1.4 AS=0.406
+ AD=0.406 PS=3.38 PD=3.38
M$416 \$558 bias_a VSS sky130_gnd sky130_fd_pr__nfet_01v8 L=0.6 W=1.4 AS=0.406
+ AD=0.406 PS=3.38 PD=3.38
M$417 \$558 bias_a VSS sky130_gnd sky130_fd_pr__nfet_01v8 L=0.6 W=1.4 AS=0.406
+ AD=0.406 PS=3.38 PD=3.38
M$418 \$558 bias_a VSS sky130_gnd sky130_fd_pr__nfet_01v8 L=0.6 W=1.4 AS=0.406
+ AD=0.406 PS=3.38 PD=3.38
M$419 \$558 bias_a VSS sky130_gnd sky130_fd_pr__nfet_01v8 L=0.6 W=1.4 AS=0.406
+ AD=0.406 PS=3.38 PD=3.38
M$420 \$558 bias_a VSS sky130_gnd sky130_fd_pr__nfet_01v8 L=0.6 W=1.4 AS=0.406
+ AD=0.406 PS=3.38 PD=3.38
M$421 \$558 bias_a VSS sky130_gnd sky130_fd_pr__nfet_01v8 L=0.6 W=1.4 AS=0.406
+ AD=0.406 PS=3.38 PD=3.38
M$422 \$558 bias_a VSS sky130_gnd sky130_fd_pr__nfet_01v8 L=0.6 W=1.4 AS=0.406
+ AD=0.406 PS=3.38 PD=3.38
M$423 \$558 bias_a VSS sky130_gnd sky130_fd_pr__nfet_01v8 L=0.6 W=1.4 AS=0.406
+ AD=0.406 PS=3.38 PD=3.38
M$424 \$558 bias_a VSS sky130_gnd sky130_fd_pr__nfet_01v8 L=0.6 W=1.4 AS=0.406
+ AD=0.406 PS=3.38 PD=3.38
M$425 \$558 bias_a VSS sky130_gnd sky130_fd_pr__nfet_01v8 L=0.6 W=1.4 AS=0.406
+ AD=0.406 PS=3.38 PD=3.38
M$426 \$558 bias_a VSS sky130_gnd sky130_fd_pr__nfet_01v8 L=0.6 W=1.4 AS=0.406
+ AD=0.406 PS=3.38 PD=3.38
M$427 \$558 bias_a VSS sky130_gnd sky130_fd_pr__nfet_01v8 L=0.6 W=1.4 AS=0.406
+ AD=0.406 PS=3.38 PD=3.38
M$428 \$558 bias_a VSS sky130_gnd sky130_fd_pr__nfet_01v8 L=0.6 W=1.4 AS=0.406
+ AD=0.406 PS=3.38 PD=3.38
M$429 \$558 bias_a VSS sky130_gnd sky130_fd_pr__nfet_01v8 L=0.6 W=1.4 AS=0.406
+ AD=0.406 PS=3.38 PD=3.38
M$430 \$558 bias_a VSS sky130_gnd sky130_fd_pr__nfet_01v8 L=0.6 W=1.4 AS=0.406
+ AD=0.406 PS=3.38 PD=3.38
M$431 \$558 bias_a VSS sky130_gnd sky130_fd_pr__nfet_01v8 L=0.6 W=1.4 AS=0.406
+ AD=0.406 PS=3.38 PD=3.38
M$432 \$558 bias_a VSS sky130_gnd sky130_fd_pr__nfet_01v8 L=0.6 W=1.4 AS=0.406
+ AD=0.406 PS=3.38 PD=3.38
M$433 \$558 bias_a VSS sky130_gnd sky130_fd_pr__nfet_01v8 L=0.6 W=1.4 AS=0.406
+ AD=0.406 PS=3.38 PD=3.38
M$434 \$558 bias_a VSS sky130_gnd sky130_fd_pr__nfet_01v8 L=0.6 W=1.4 AS=0.406
+ AD=0.406 PS=3.38 PD=3.38
M$435 \$558 bias_a VSS sky130_gnd sky130_fd_pr__nfet_01v8 L=0.6 W=1.4 AS=0.406
+ AD=0.406 PS=3.38 PD=3.38
M$436 \$558 bias_a VSS sky130_gnd sky130_fd_pr__nfet_01v8 L=0.6 W=1.4 AS=0.406
+ AD=0.406 PS=3.38 PD=3.38
M$437 \$558 bias_a VSS sky130_gnd sky130_fd_pr__nfet_01v8 L=0.6 W=1.4 AS=0.406
+ AD=0.406 PS=3.38 PD=3.38
M$438 \$558 bias_a VSS sky130_gnd sky130_fd_pr__nfet_01v8 L=0.6 W=1.4 AS=0.406
+ AD=0.406 PS=3.38 PD=3.38
M$439 \$558 bias_a VSS sky130_gnd sky130_fd_pr__nfet_01v8 L=0.6 W=1.4 AS=0.406
+ AD=0.406 PS=3.38 PD=3.38
M$440 \$558 bias_a VSS sky130_gnd sky130_fd_pr__nfet_01v8 L=0.6 W=1.4 AS=0.406
+ AD=0.406 PS=3.38 PD=3.38
M$441 \$558 bias_a VSS sky130_gnd sky130_fd_pr__nfet_01v8 L=0.6 W=1.4 AS=0.406
+ AD=0.406 PS=3.38 PD=3.38
M$442 \$558 bias_a VSS sky130_gnd sky130_fd_pr__nfet_01v8 L=0.6 W=1.4 AS=0.406
+ AD=0.406 PS=3.38 PD=3.38
M$443 \$558 bias_a VSS sky130_gnd sky130_fd_pr__nfet_01v8 L=0.6 W=1.4 AS=0.406
+ AD=0.406 PS=3.38 PD=3.38
M$444 \$558 bias_a VSS sky130_gnd sky130_fd_pr__nfet_01v8 L=0.6 W=1.4 AS=0.406
+ AD=0.406 PS=3.38 PD=3.38
M$445 \$558 bias_a VSS sky130_gnd sky130_fd_pr__nfet_01v8 L=0.6 W=1.4 AS=0.406
+ AD=0.406 PS=3.38 PD=3.38
M$446 \$558 bias_a VSS sky130_gnd sky130_fd_pr__nfet_01v8 L=0.6 W=1.4 AS=0.406
+ AD=0.406 PS=3.38 PD=3.38
M$447 \$558 bias_a VSS sky130_gnd sky130_fd_pr__nfet_01v8 L=0.6 W=1.4 AS=0.406
+ AD=0.406 PS=3.38 PD=3.38
M$448 \$558 bias_a VSS sky130_gnd sky130_fd_pr__nfet_01v8 L=0.6 W=1.4 AS=0.406
+ AD=0.406 PS=3.38 PD=3.38
M$449 \$558 bias_a VSS sky130_gnd sky130_fd_pr__nfet_01v8 L=0.6 W=1.4 AS=0.406
+ AD=0.406 PS=3.38 PD=3.38
M$450 \$558 bias_a VSS sky130_gnd sky130_fd_pr__nfet_01v8 L=0.6 W=1.4 AS=0.406
+ AD=0.406 PS=3.38 PD=3.38
M$451 \$558 bias_a VSS sky130_gnd sky130_fd_pr__nfet_01v8 L=0.6 W=1.4 AS=0.406
+ AD=0.406 PS=3.38 PD=3.38
M$452 \$558 bias_a VSS sky130_gnd sky130_fd_pr__nfet_01v8 L=0.6 W=1.4 AS=0.406
+ AD=0.406 PS=3.38 PD=3.38
M$453 \$558 bias_a VSS sky130_gnd sky130_fd_pr__nfet_01v8 L=0.6 W=1.4 AS=0.406
+ AD=0.406 PS=3.38 PD=3.38
M$454 \$558 bias_a VSS sky130_gnd sky130_fd_pr__nfet_01v8 L=0.6 W=1.4 AS=0.406
+ AD=0.406 PS=3.38 PD=3.38
M$455 \$558 bias_a VSS sky130_gnd sky130_fd_pr__nfet_01v8 L=0.6 W=1.4 AS=0.406
+ AD=0.406 PS=3.38 PD=3.38
M$456 \$558 bias_a VSS sky130_gnd sky130_fd_pr__nfet_01v8 L=0.6 W=1.4 AS=0.406
+ AD=0.406 PS=3.38 PD=3.38
M$457 \$558 bias_a VSS sky130_gnd sky130_fd_pr__nfet_01v8 L=0.6 W=1.4 AS=0.406
+ AD=0.406 PS=3.38 PD=3.38
M$458 \$558 bias_a VSS sky130_gnd sky130_fd_pr__nfet_01v8 L=0.6 W=1.4 AS=0.406
+ AD=0.406 PS=3.38 PD=3.38
M$459 \$558 bias_a VSS sky130_gnd sky130_fd_pr__nfet_01v8 L=0.6 W=1.4 AS=0.406
+ AD=0.406 PS=3.38 PD=3.38
M$460 \$558 bias_a VSS sky130_gnd sky130_fd_pr__nfet_01v8 L=0.6 W=1.4 AS=0.406
+ AD=0.406 PS=3.38 PD=3.38
M$461 \$558 bias_a VSS sky130_gnd sky130_fd_pr__nfet_01v8 L=0.6 W=1.4 AS=0.406
+ AD=0.406 PS=3.38 PD=3.38
M$462 \$558 bias_a VSS sky130_gnd sky130_fd_pr__nfet_01v8 L=0.6 W=1.4 AS=0.406
+ AD=0.406 PS=3.38 PD=3.38
M$463 \$558 bias_a VSS sky130_gnd sky130_fd_pr__nfet_01v8 L=0.6 W=1.4 AS=0.406
+ AD=0.406 PS=3.38 PD=3.38
M$464 \$558 bias_a VSS sky130_gnd sky130_fd_pr__nfet_01v8 L=0.6 W=1.4 AS=0.406
+ AD=0.406 PS=3.38 PD=3.38
M$465 \$558 bias_a VSS sky130_gnd sky130_fd_pr__nfet_01v8 L=0.6 W=1.4 AS=0.406
+ AD=0.406 PS=3.38 PD=3.38
M$466 \$558 bias_a VSS sky130_gnd sky130_fd_pr__nfet_01v8 L=0.6 W=1.4 AS=0.406
+ AD=0.406 PS=3.38 PD=3.38
M$467 \$558 bias_a VSS sky130_gnd sky130_fd_pr__nfet_01v8 L=0.6 W=1.4 AS=0.406
+ AD=0.406 PS=3.38 PD=3.38
M$468 \$558 bias_a VSS sky130_gnd sky130_fd_pr__nfet_01v8 L=0.6 W=1.4 AS=0.406
+ AD=0.406 PS=3.38 PD=3.38
M$469 \$558 bias_a VSS sky130_gnd sky130_fd_pr__nfet_01v8 L=0.6 W=1.4 AS=0.406
+ AD=0.406 PS=3.38 PD=3.38
M$470 \$558 bias_a VSS sky130_gnd sky130_fd_pr__nfet_01v8 L=0.6 W=1.4 AS=0.406
+ AD=0.406 PS=3.38 PD=3.38
M$471 \$558 bias_a VSS sky130_gnd sky130_fd_pr__nfet_01v8 L=0.6 W=1.4 AS=0.406
+ AD=0.406 PS=3.38 PD=3.38
M$472 \$558 bias_a VSS sky130_gnd sky130_fd_pr__nfet_01v8 L=0.6 W=1.4 AS=0.406
+ AD=0.406 PS=3.38 PD=3.38
M$473 \$558 bias_a VSS sky130_gnd sky130_fd_pr__nfet_01v8 L=0.6 W=1.4 AS=0.406
+ AD=0.406 PS=3.38 PD=3.38
M$474 \$558 bias_a VSS sky130_gnd sky130_fd_pr__nfet_01v8 L=0.6 W=1.4 AS=0.406
+ AD=0.406 PS=3.38 PD=3.38
M$475 \$558 bias_a VSS sky130_gnd sky130_fd_pr__nfet_01v8 L=0.6 W=1.4 AS=0.406
+ AD=0.406 PS=3.38 PD=3.38
M$476 \$558 bias_a VSS sky130_gnd sky130_fd_pr__nfet_01v8 L=0.6 W=1.4 AS=0.406
+ AD=0.406 PS=3.38 PD=3.38
M$477 \$558 bias_a VSS sky130_gnd sky130_fd_pr__nfet_01v8 L=0.6 W=1.4 AS=0.406
+ AD=0.406 PS=3.38 PD=3.38
M$478 \$558 bias_a VSS sky130_gnd sky130_fd_pr__nfet_01v8 L=0.6 W=1.4 AS=0.406
+ AD=0.406 PS=3.38 PD=3.38
M$479 \$558 bias_a VSS sky130_gnd sky130_fd_pr__nfet_01v8 L=0.6 W=1.4 AS=0.406
+ AD=0.406 PS=3.38 PD=3.38
M$480 \$558 bias_a VSS sky130_gnd sky130_fd_pr__nfet_01v8 L=0.6 W=1.4 AS=0.406
+ AD=0.406 PS=3.38 PD=3.38
M$481 \$558 bias_a VSS sky130_gnd sky130_fd_pr__nfet_01v8 L=0.6 W=1.4 AS=0.406
+ AD=0.406 PS=3.38 PD=3.38
M$482 \$558 bias_a VSS sky130_gnd sky130_fd_pr__nfet_01v8 L=0.6 W=1.4 AS=0.406
+ AD=0.406 PS=3.38 PD=3.38
M$483 \$558 bias_a VSS sky130_gnd sky130_fd_pr__nfet_01v8 L=0.6 W=1.4 AS=0.406
+ AD=0.406 PS=3.38 PD=3.38
M$484 \$558 bias_a VSS sky130_gnd sky130_fd_pr__nfet_01v8 L=0.6 W=1.4 AS=0.406
+ AD=0.406 PS=3.38 PD=3.38
M$485 \$558 bias_a VSS sky130_gnd sky130_fd_pr__nfet_01v8 L=0.6 W=1.4 AS=0.406
+ AD=0.406 PS=3.38 PD=3.38
M$486 \$558 bias_a VSS sky130_gnd sky130_fd_pr__nfet_01v8 L=0.6 W=1.4 AS=0.406
+ AD=0.406 PS=3.38 PD=3.38
M$487 \$558 bias_a VSS sky130_gnd sky130_fd_pr__nfet_01v8 L=0.6 W=1.4 AS=0.406
+ AD=0.406 PS=3.38 PD=3.38
M$488 \$558 bias_a VSS sky130_gnd sky130_fd_pr__nfet_01v8 L=0.6 W=1.4 AS=0.406
+ AD=0.406 PS=3.38 PD=3.38
M$489 \$558 bias_a VSS sky130_gnd sky130_fd_pr__nfet_01v8 L=0.6 W=1.4 AS=0.406
+ AD=0.406 PS=3.38 PD=3.38
M$490 \$558 bias_a VSS sky130_gnd sky130_fd_pr__nfet_01v8 L=0.6 W=1.4 AS=0.406
+ AD=0.406 PS=3.38 PD=3.38
M$491 \$558 bias_a VSS sky130_gnd sky130_fd_pr__nfet_01v8 L=0.6 W=1.4 AS=0.406
+ AD=0.406 PS=3.38 PD=3.38
M$492 \$558 bias_a VSS sky130_gnd sky130_fd_pr__nfet_01v8 L=0.6 W=1.4 AS=0.406
+ AD=0.406 PS=3.38 PD=3.38
M$493 \$558 bias_a VSS sky130_gnd sky130_fd_pr__nfet_01v8 L=0.6 W=1.4 AS=0.406
+ AD=0.406 PS=3.38 PD=3.38
M$494 \$558 bias_a VSS sky130_gnd sky130_fd_pr__nfet_01v8 L=0.6 W=1.4 AS=0.406
+ AD=0.406 PS=3.38 PD=3.38
M$495 \$558 bias_a VSS sky130_gnd sky130_fd_pr__nfet_01v8 L=0.6 W=1.4 AS=0.406
+ AD=0.406 PS=3.38 PD=3.38
M$496 \$558 bias_a VSS sky130_gnd sky130_fd_pr__nfet_01v8 L=0.6 W=1.4 AS=0.406
+ AD=0.406 PS=3.38 PD=3.38
M$497 \$558 bias_a VSS sky130_gnd sky130_fd_pr__nfet_01v8 L=0.6 W=1.4 AS=0.406
+ AD=0.406 PS=3.38 PD=3.38
M$498 \$558 bias_a VSS sky130_gnd sky130_fd_pr__nfet_01v8 L=0.6 W=1.4 AS=0.406
+ AD=0.406 PS=3.38 PD=3.38
M$499 \$558 bias_a VSS sky130_gnd sky130_fd_pr__nfet_01v8 L=0.6 W=1.4 AS=0.406
+ AD=0.406 PS=3.38 PD=3.38
M$500 \$558 bias_a VSS sky130_gnd sky130_fd_pr__nfet_01v8 L=0.6 W=1.4 AS=0.406
+ AD=0.406 PS=3.38 PD=3.38
M$501 \$558 bias_a VSS sky130_gnd sky130_fd_pr__nfet_01v8 L=0.6 W=1.4 AS=0.406
+ AD=0.406 PS=3.38 PD=3.38
M$502 \$558 bias_a VSS sky130_gnd sky130_fd_pr__nfet_01v8 L=0.6 W=1.4 AS=0.406
+ AD=0.406 PS=3.38 PD=3.38
M$503 \$558 bias_a VSS sky130_gnd sky130_fd_pr__nfet_01v8 L=0.6 W=1.4 AS=0.406
+ AD=0.406 PS=3.38 PD=3.38
M$504 \$558 bias_a VSS sky130_gnd sky130_fd_pr__nfet_01v8 L=0.6 W=1.4 AS=0.406
+ AD=0.406 PS=3.38 PD=3.38
M$505 \$558 bias_a VSS sky130_gnd sky130_fd_pr__nfet_01v8 L=0.6 W=1.4 AS=0.406
+ AD=0.406 PS=3.38 PD=3.38
M$506 \$558 bias_a VSS sky130_gnd sky130_fd_pr__nfet_01v8 L=0.6 W=1.4 AS=0.406
+ AD=0.406 PS=3.38 PD=3.38
M$507 \$558 cmc VSS sky130_gnd sky130_fd_pr__nfet_01v8 L=0.6 W=1.4 AS=0.406
+ AD=0.406 PS=3.38 PD=3.38
M$508 \$558 cmc VSS sky130_gnd sky130_fd_pr__nfet_01v8 L=0.6 W=1.4 AS=0.406
+ AD=0.406 PS=3.38 PD=3.38
M$509 \$558 cmc VSS sky130_gnd sky130_fd_pr__nfet_01v8 L=0.6 W=1.4 AS=0.406
+ AD=0.406 PS=3.38 PD=3.38
M$510 \$558 cmc VSS sky130_gnd sky130_fd_pr__nfet_01v8 L=0.6 W=1.4 AS=0.406
+ AD=0.406 PS=3.38 PD=3.38
M$511 \$558 cmc VSS sky130_gnd sky130_fd_pr__nfet_01v8 L=0.6 W=1.4 AS=0.406
+ AD=0.406 PS=3.38 PD=3.38
M$512 \$558 cmc VSS sky130_gnd sky130_fd_pr__nfet_01v8 L=0.6 W=1.4 AS=0.406
+ AD=0.406 PS=3.38 PD=3.38
M$513 \$558 cmc VSS sky130_gnd sky130_fd_pr__nfet_01v8 L=0.6 W=1.4 AS=0.406
+ AD=0.406 PS=3.38 PD=3.38
M$514 \$558 cmc VSS sky130_gnd sky130_fd_pr__nfet_01v8 L=0.6 W=1.4 AS=0.406
+ AD=0.406 PS=3.38 PD=3.38
M$515 \$558 cmc VSS sky130_gnd sky130_fd_pr__nfet_01v8 L=0.6 W=1.4 AS=0.406
+ AD=0.406 PS=3.38 PD=3.38
M$516 \$558 cmc VSS sky130_gnd sky130_fd_pr__nfet_01v8 L=0.6 W=1.4 AS=0.406
+ AD=0.406 PS=3.38 PD=3.38
M$517 \$558 cmc VSS sky130_gnd sky130_fd_pr__nfet_01v8 L=0.6 W=1.4 AS=0.406
+ AD=0.406 PS=3.38 PD=3.38
M$518 \$558 cmc VSS sky130_gnd sky130_fd_pr__nfet_01v8 L=0.6 W=1.4 AS=0.406
+ AD=0.406 PS=3.38 PD=3.38
M$519 \$558 cmc VSS sky130_gnd sky130_fd_pr__nfet_01v8 L=0.6 W=1.4 AS=0.406
+ AD=0.406 PS=3.38 PD=3.38
M$520 \$558 cmc VSS sky130_gnd sky130_fd_pr__nfet_01v8 L=0.6 W=1.4 AS=0.406
+ AD=0.406 PS=3.38 PD=3.38
M$521 \$558 cmc VSS sky130_gnd sky130_fd_pr__nfet_01v8 L=0.6 W=1.4 AS=0.406
+ AD=0.406 PS=3.38 PD=3.38
M$522 \$558 cmc VSS sky130_gnd sky130_fd_pr__nfet_01v8 L=0.6 W=1.4 AS=0.406
+ AD=0.406 PS=3.38 PD=3.38
M$523 \$558 cmc VSS sky130_gnd sky130_fd_pr__nfet_01v8 L=0.6 W=1.4 AS=0.406
+ AD=0.406 PS=3.38 PD=3.38
M$524 \$558 cmc VSS sky130_gnd sky130_fd_pr__nfet_01v8 L=0.6 W=1.4 AS=0.406
+ AD=0.406 PS=3.38 PD=3.38
M$525 \$558 cmc VSS sky130_gnd sky130_fd_pr__nfet_01v8 L=0.6 W=1.4 AS=0.406
+ AD=0.406 PS=3.38 PD=3.38
M$526 \$558 cmc VSS sky130_gnd sky130_fd_pr__nfet_01v8 L=0.6 W=1.4 AS=0.406
+ AD=0.406 PS=3.38 PD=3.38
M$527 \$558 cmc VSS sky130_gnd sky130_fd_pr__nfet_01v8 L=0.6 W=1.4 AS=0.406
+ AD=0.406 PS=3.38 PD=3.38
M$528 \$558 cmc VSS sky130_gnd sky130_fd_pr__nfet_01v8 L=0.6 W=1.4 AS=0.406
+ AD=0.406 PS=3.38 PD=3.38
M$529 \$558 cmc VSS sky130_gnd sky130_fd_pr__nfet_01v8 L=0.6 W=1.4 AS=0.406
+ AD=0.406 PS=3.38 PD=3.38
M$530 \$558 cmc VSS sky130_gnd sky130_fd_pr__nfet_01v8 L=0.6 W=1.4 AS=0.406
+ AD=0.406 PS=3.38 PD=3.38
M$531 \$558 cmc VSS sky130_gnd sky130_fd_pr__nfet_01v8 L=0.6 W=1.4 AS=0.406
+ AD=0.406 PS=3.38 PD=3.38
M$532 \$558 cmc VSS sky130_gnd sky130_fd_pr__nfet_01v8 L=0.6 W=1.4 AS=0.406
+ AD=0.406 PS=3.38 PD=3.38
M$533 \$558 cmc VSS sky130_gnd sky130_fd_pr__nfet_01v8 L=0.6 W=1.4 AS=0.406
+ AD=0.406 PS=3.38 PD=3.38
M$534 \$558 cmc VSS sky130_gnd sky130_fd_pr__nfet_01v8 L=0.6 W=1.4 AS=0.406
+ AD=0.406 PS=3.38 PD=3.38
M$535 \$558 cmc VSS sky130_gnd sky130_fd_pr__nfet_01v8 L=0.6 W=1.4 AS=0.406
+ AD=0.406 PS=3.38 PD=3.38
M$536 \$558 cmc VSS sky130_gnd sky130_fd_pr__nfet_01v8 L=0.6 W=1.4 AS=0.406
+ AD=0.406 PS=3.38 PD=3.38
M$537 \$558 cmc VSS sky130_gnd sky130_fd_pr__nfet_01v8 L=0.6 W=1.4 AS=0.406
+ AD=0.406 PS=3.38 PD=3.38
M$538 \$558 cmc VSS sky130_gnd sky130_fd_pr__nfet_01v8 L=0.6 W=1.4 AS=0.406
+ AD=0.406 PS=3.38 PD=3.38
M$539 \$558 cmc VSS sky130_gnd sky130_fd_pr__nfet_01v8 L=0.6 W=1.4 AS=0.406
+ AD=0.406 PS=3.38 PD=3.38
M$540 \$558 cmc VSS sky130_gnd sky130_fd_pr__nfet_01v8 L=0.6 W=1.4 AS=0.406
+ AD=0.406 PS=3.38 PD=3.38
M$541 \$558 cmc VSS sky130_gnd sky130_fd_pr__nfet_01v8 L=0.6 W=1.4 AS=0.406
+ AD=0.406 PS=3.38 PD=3.38
M$542 \$558 cmc VSS sky130_gnd sky130_fd_pr__nfet_01v8 L=0.6 W=1.4 AS=0.406
+ AD=0.406 PS=3.38 PD=3.38
M$543 \$558 cmc VSS sky130_gnd sky130_fd_pr__nfet_01v8 L=0.6 W=1.4 AS=0.406
+ AD=0.406 PS=3.38 PD=3.38
M$544 \$558 cmc VSS sky130_gnd sky130_fd_pr__nfet_01v8 L=0.6 W=1.4 AS=0.406
+ AD=0.406 PS=3.38 PD=3.38
M$545 \$558 cmc VSS sky130_gnd sky130_fd_pr__nfet_01v8 L=0.6 W=1.4 AS=0.406
+ AD=0.406 PS=3.38 PD=3.38
M$546 \$558 cmc VSS sky130_gnd sky130_fd_pr__nfet_01v8 L=0.6 W=1.4 AS=0.406
+ AD=0.406 PS=3.38 PD=3.38
M$547 \$558 cmc VSS sky130_gnd sky130_fd_pr__nfet_01v8 L=0.6 W=1.4 AS=0.406
+ AD=0.406 PS=3.38 PD=3.38
M$548 \$558 cmc VSS sky130_gnd sky130_fd_pr__nfet_01v8 L=0.6 W=1.4 AS=0.406
+ AD=0.406 PS=3.38 PD=3.38
M$549 \$558 cmc VSS sky130_gnd sky130_fd_pr__nfet_01v8 L=0.6 W=1.4 AS=0.406
+ AD=0.406 PS=3.38 PD=3.38
M$550 \$558 cmc VSS sky130_gnd sky130_fd_pr__nfet_01v8 L=0.6 W=1.4 AS=0.406
+ AD=0.406 PS=3.38 PD=3.38
M$551 \$558 cmc VSS sky130_gnd sky130_fd_pr__nfet_01v8 L=0.6 W=1.4 AS=0.406
+ AD=0.406 PS=3.38 PD=3.38
M$552 \$558 cmc VSS sky130_gnd sky130_fd_pr__nfet_01v8 L=0.6 W=1.4 AS=0.406
+ AD=0.406 PS=3.38 PD=3.38
M$553 \$558 cmc VSS sky130_gnd sky130_fd_pr__nfet_01v8 L=0.6 W=1.4 AS=0.406
+ AD=0.406 PS=3.38 PD=3.38
M$554 \$558 cmc VSS sky130_gnd sky130_fd_pr__nfet_01v8 L=0.6 W=1.4 AS=0.406
+ AD=0.406 PS=3.38 PD=3.38
M$555 \$558 cmc VSS sky130_gnd sky130_fd_pr__nfet_01v8 L=0.6 W=1.4 AS=0.406
+ AD=0.406 PS=3.38 PD=3.38
M$556 \$558 cmc VSS sky130_gnd sky130_fd_pr__nfet_01v8 L=0.6 W=1.4 AS=0.406
+ AD=0.406 PS=3.38 PD=3.38
M$557 \$558 cmc VSS sky130_gnd sky130_fd_pr__nfet_01v8 L=0.6 W=1.4 AS=0.406
+ AD=0.406 PS=3.38 PD=3.38
M$558 \$558 cmc VSS sky130_gnd sky130_fd_pr__nfet_01v8 L=0.6 W=1.4 AS=0.406
+ AD=0.406 PS=3.38 PD=3.38
M$559 \$558 cmc VSS sky130_gnd sky130_fd_pr__nfet_01v8 L=0.6 W=1.4 AS=0.406
+ AD=0.406 PS=3.38 PD=3.38
M$560 \$558 cmc VSS sky130_gnd sky130_fd_pr__nfet_01v8 L=0.6 W=1.4 AS=0.406
+ AD=0.406 PS=3.38 PD=3.38
M$561 \$558 cmc VSS sky130_gnd sky130_fd_pr__nfet_01v8 L=0.6 W=1.4 AS=0.406
+ AD=0.406 PS=3.38 PD=3.38
M$562 \$558 cmc VSS sky130_gnd sky130_fd_pr__nfet_01v8 L=0.6 W=1.4 AS=0.406
+ AD=0.406 PS=3.38 PD=3.38
M$563 \$558 cmc VSS sky130_gnd sky130_fd_pr__nfet_01v8 L=0.6 W=1.4 AS=0.406
+ AD=0.406 PS=3.38 PD=3.38
M$564 \$558 cmc VSS sky130_gnd sky130_fd_pr__nfet_01v8 L=0.6 W=1.4 AS=0.406
+ AD=0.406 PS=3.38 PD=3.38
M$565 \$558 cmc VSS sky130_gnd sky130_fd_pr__nfet_01v8 L=0.6 W=1.4 AS=0.406
+ AD=0.406 PS=3.38 PD=3.38
M$566 \$558 cmc VSS sky130_gnd sky130_fd_pr__nfet_01v8 L=0.6 W=1.4 AS=0.406
+ AD=0.406 PS=3.38 PD=3.38
M$567 \$558 cmc VSS sky130_gnd sky130_fd_pr__nfet_01v8 L=0.6 W=1.4 AS=0.406
+ AD=0.406 PS=3.38 PD=3.38
M$568 \$558 cmc VSS sky130_gnd sky130_fd_pr__nfet_01v8 L=0.6 W=1.4 AS=0.406
+ AD=0.406 PS=3.38 PD=3.38
M$569 \$558 cmc VSS sky130_gnd sky130_fd_pr__nfet_01v8 L=0.6 W=1.4 AS=0.406
+ AD=0.406 PS=3.38 PD=3.38
M$570 \$558 cmc VSS sky130_gnd sky130_fd_pr__nfet_01v8 L=0.6 W=1.4 AS=0.406
+ AD=0.406 PS=3.38 PD=3.38
M$571 \$558 cmc VSS sky130_gnd sky130_fd_pr__nfet_01v8 L=0.6 W=1.4 AS=0.406
+ AD=0.406 PS=3.38 PD=3.38
M$572 \$558 cmc VSS sky130_gnd sky130_fd_pr__nfet_01v8 L=0.6 W=1.4 AS=0.406
+ AD=0.406 PS=3.38 PD=3.38
M$573 \$558 cmc VSS sky130_gnd sky130_fd_pr__nfet_01v8 L=0.6 W=1.4 AS=0.406
+ AD=0.406 PS=3.38 PD=3.38
M$574 \$558 cmc VSS sky130_gnd sky130_fd_pr__nfet_01v8 L=0.6 W=1.4 AS=0.406
+ AD=0.406 PS=3.38 PD=3.38
M$575 \$558 cmc VSS sky130_gnd sky130_fd_pr__nfet_01v8 L=0.6 W=1.4 AS=0.406
+ AD=0.406 PS=3.38 PD=3.38
M$576 \$558 cmc VSS sky130_gnd sky130_fd_pr__nfet_01v8 L=0.6 W=1.4 AS=0.406
+ AD=0.406 PS=3.38 PD=3.38
M$577 \$558 cmc VSS sky130_gnd sky130_fd_pr__nfet_01v8 L=0.6 W=1.4 AS=0.406
+ AD=0.406 PS=3.38 PD=3.38
M$578 \$558 cmc VSS sky130_gnd sky130_fd_pr__nfet_01v8 L=0.6 W=1.4 AS=0.406
+ AD=0.406 PS=3.38 PD=3.38
M$579 \$558 cmc VSS sky130_gnd sky130_fd_pr__nfet_01v8 L=0.6 W=1.4 AS=0.406
+ AD=0.406 PS=3.38 PD=3.38
M$580 \$558 cmc VSS sky130_gnd sky130_fd_pr__nfet_01v8 L=0.6 W=1.4 AS=0.406
+ AD=0.406 PS=3.38 PD=3.38
M$581 \$558 cmc VSS sky130_gnd sky130_fd_pr__nfet_01v8 L=0.6 W=1.4 AS=0.406
+ AD=0.406 PS=3.38 PD=3.38
M$582 \$558 cmc VSS sky130_gnd sky130_fd_pr__nfet_01v8 L=0.6 W=1.4 AS=0.406
+ AD=0.406 PS=3.38 PD=3.38
M$583 \$558 cmc VSS sky130_gnd sky130_fd_pr__nfet_01v8 L=0.6 W=1.4 AS=0.406
+ AD=0.406 PS=3.38 PD=3.38
M$584 \$558 cmc VSS sky130_gnd sky130_fd_pr__nfet_01v8 L=0.6 W=1.4 AS=0.406
+ AD=0.406 PS=3.38 PD=3.38
M$585 \$558 cmc VSS sky130_gnd sky130_fd_pr__nfet_01v8 L=0.6 W=1.4 AS=0.406
+ AD=0.406 PS=3.38 PD=3.38
M$586 \$558 cmc VSS sky130_gnd sky130_fd_pr__nfet_01v8 L=0.6 W=1.4 AS=0.406
+ AD=0.406 PS=3.38 PD=3.38
M$587 \$558 cmc VSS sky130_gnd sky130_fd_pr__nfet_01v8 L=0.6 W=1.4 AS=0.406
+ AD=0.406 PS=3.38 PD=3.38
M$588 \$558 cmc VSS sky130_gnd sky130_fd_pr__nfet_01v8 L=0.6 W=1.4 AS=0.406
+ AD=0.406 PS=3.38 PD=3.38
M$589 \$558 cmc VSS sky130_gnd sky130_fd_pr__nfet_01v8 L=0.6 W=1.4 AS=0.406
+ AD=0.406 PS=3.38 PD=3.38
M$590 \$558 cmc VSS sky130_gnd sky130_fd_pr__nfet_01v8 L=0.6 W=1.4 AS=0.406
+ AD=0.406 PS=3.38 PD=3.38
M$591 \$558 cmc VSS sky130_gnd sky130_fd_pr__nfet_01v8 L=0.6 W=1.4 AS=0.406
+ AD=0.406 PS=3.38 PD=3.38
M$592 \$558 cmc VSS sky130_gnd sky130_fd_pr__nfet_01v8 L=0.6 W=1.4 AS=0.406
+ AD=0.406 PS=3.38 PD=3.38
M$593 \$558 cmc VSS sky130_gnd sky130_fd_pr__nfet_01v8 L=0.6 W=1.4 AS=0.406
+ AD=0.406 PS=3.38 PD=3.38
M$594 \$558 cmc VSS sky130_gnd sky130_fd_pr__nfet_01v8 L=0.6 W=1.4 AS=0.406
+ AD=0.406 PS=3.38 PD=3.38
M$595 \$558 cmc VSS sky130_gnd sky130_fd_pr__nfet_01v8 L=0.6 W=1.4 AS=0.406
+ AD=0.406 PS=3.38 PD=3.38
M$596 \$558 cmc VSS sky130_gnd sky130_fd_pr__nfet_01v8 L=0.6 W=1.4 AS=0.406
+ AD=0.406 PS=3.38 PD=3.38
M$597 \$558 cmc VSS sky130_gnd sky130_fd_pr__nfet_01v8 L=0.6 W=1.4 AS=0.406
+ AD=0.406 PS=3.38 PD=3.38
M$598 \$558 cmc VSS sky130_gnd sky130_fd_pr__nfet_01v8 L=0.6 W=1.4 AS=0.406
+ AD=0.406 PS=3.38 PD=3.38
M$599 \$558 cmc VSS sky130_gnd sky130_fd_pr__nfet_01v8 L=0.6 W=1.4 AS=0.406
+ AD=0.406 PS=3.38 PD=3.38
M$600 \$558 cmc VSS sky130_gnd sky130_fd_pr__nfet_01v8 L=0.6 W=1.4 AS=0.406
+ AD=0.406 PS=3.38 PD=3.38
M$601 \$558 cmc VSS sky130_gnd sky130_fd_pr__nfet_01v8 L=0.6 W=1.4 AS=0.406
+ AD=0.406 PS=3.38 PD=3.38
M$602 \$558 cmc VSS sky130_gnd sky130_fd_pr__nfet_01v8 L=0.6 W=1.4 AS=0.406
+ AD=0.406 PS=3.38 PD=3.38
M$603 \$247 \$247 \$19 sky130_gnd sky130_fd_pr__nfet_01v8 L=0.6 W=1.4 AS=0.406
+ AD=0.406 PS=3.38 PD=3.38
M$604 \$247 \$247 \$19 sky130_gnd sky130_fd_pr__nfet_01v8 L=0.6 W=1.4 AS=0.406
+ AD=0.406 PS=3.38 PD=3.38
M$605 \$247 \$247 \$19 sky130_gnd sky130_fd_pr__nfet_01v8 L=0.6 W=1.4 AS=0.406
+ AD=0.406 PS=3.38 PD=3.38
M$606 \$247 \$247 \$19 sky130_gnd sky130_fd_pr__nfet_01v8 L=0.6 W=1.4 AS=0.406
+ AD=0.406 PS=3.38 PD=3.38
M$607 \$247 \$247 \$19 sky130_gnd sky130_fd_pr__nfet_01v8 L=0.6 W=1.4 AS=0.406
+ AD=0.406 PS=3.38 PD=3.38
M$608 \$247 \$247 \$19 sky130_gnd sky130_fd_pr__nfet_01v8 L=0.6 W=1.4 AS=0.406
+ AD=0.406 PS=3.38 PD=3.38
M$609 \$247 \$247 \$19 sky130_gnd sky130_fd_pr__nfet_01v8 L=0.6 W=1.4 AS=0.406
+ AD=0.406 PS=3.38 PD=3.38
M$610 \$247 \$247 \$19 sky130_gnd sky130_fd_pr__nfet_01v8 L=0.6 W=1.4 AS=0.406
+ AD=0.406 PS=3.38 PD=3.38
M$611 \$247 \$247 \$19 sky130_gnd sky130_fd_pr__nfet_01v8 L=0.6 W=1.4 AS=0.406
+ AD=0.406 PS=3.38 PD=3.38
M$612 \$247 \$247 \$19 sky130_gnd sky130_fd_pr__nfet_01v8 L=0.6 W=1.4 AS=0.406
+ AD=0.406 PS=3.38 PD=3.38
M$613 \$247 \$247 \$19 sky130_gnd sky130_fd_pr__nfet_01v8 L=0.6 W=1.4 AS=0.406
+ AD=0.406 PS=3.38 PD=3.38
M$614 \$247 \$247 \$19 sky130_gnd sky130_fd_pr__nfet_01v8 L=0.6 W=1.4 AS=0.406
+ AD=0.406 PS=3.38 PD=3.38
M$615 \$247 \$247 \$19 sky130_gnd sky130_fd_pr__nfet_01v8 L=0.6 W=1.4 AS=0.406
+ AD=0.406 PS=3.38 PD=3.38
M$616 \$247 \$247 \$19 sky130_gnd sky130_fd_pr__nfet_01v8 L=0.6 W=1.4 AS=0.406
+ AD=0.406 PS=3.38 PD=3.38
M$617 \$247 \$247 \$19 sky130_gnd sky130_fd_pr__nfet_01v8 L=0.6 W=1.4 AS=0.406
+ AD=0.406 PS=3.38 PD=3.38
M$618 \$247 \$247 \$19 sky130_gnd sky130_fd_pr__nfet_01v8 L=0.6 W=1.4 AS=0.406
+ AD=0.406 PS=3.38 PD=3.38
M$619 \$247 \$247 \$19 sky130_gnd sky130_fd_pr__nfet_01v8 L=0.6 W=1.4 AS=0.406
+ AD=0.406 PS=3.38 PD=3.38
M$620 \$247 \$247 \$19 sky130_gnd sky130_fd_pr__nfet_01v8 L=0.6 W=1.4 AS=0.406
+ AD=0.406 PS=3.38 PD=3.38
M$621 \$247 \$247 \$19 sky130_gnd sky130_fd_pr__nfet_01v8 L=0.6 W=1.4 AS=0.406
+ AD=0.406 PS=3.38 PD=3.38
M$622 \$247 \$247 \$19 sky130_gnd sky130_fd_pr__nfet_01v8 L=0.6 W=1.4 AS=0.406
+ AD=0.406 PS=3.38 PD=3.38
M$623 \$247 \$247 \$19 sky130_gnd sky130_fd_pr__nfet_01v8 L=0.6 W=1.4 AS=0.406
+ AD=0.406 PS=3.38 PD=3.38
M$624 \$247 \$247 \$19 sky130_gnd sky130_fd_pr__nfet_01v8 L=0.6 W=1.4 AS=0.406
+ AD=0.406 PS=3.38 PD=3.38
M$625 \$247 \$247 \$19 sky130_gnd sky130_fd_pr__nfet_01v8 L=0.6 W=1.4 AS=0.406
+ AD=0.406 PS=3.38 PD=3.38
M$626 \$247 \$247 \$19 sky130_gnd sky130_fd_pr__nfet_01v8 L=0.6 W=1.4 AS=0.406
+ AD=0.406 PS=3.38 PD=3.38
M$627 \$247 \$247 \$19 sky130_gnd sky130_fd_pr__nfet_01v8 L=0.6 W=1.4 AS=0.406
+ AD=0.406 PS=3.38 PD=3.38
M$628 \$247 \$247 \$19 sky130_gnd sky130_fd_pr__nfet_01v8 L=0.6 W=1.4 AS=0.406
+ AD=0.406 PS=3.38 PD=3.38
M$629 \$247 \$247 \$19 sky130_gnd sky130_fd_pr__nfet_01v8 L=0.6 W=1.4 AS=0.406
+ AD=0.406 PS=3.38 PD=3.38
M$630 \$247 \$247 \$19 sky130_gnd sky130_fd_pr__nfet_01v8 L=0.6 W=1.4 AS=0.406
+ AD=0.406 PS=3.38 PD=3.38
M$631 \$247 \$247 \$19 sky130_gnd sky130_fd_pr__nfet_01v8 L=0.6 W=1.4 AS=0.406
+ AD=0.406 PS=3.38 PD=3.38
M$632 \$247 \$247 \$19 sky130_gnd sky130_fd_pr__nfet_01v8 L=0.6 W=1.4 AS=0.406
+ AD=0.406 PS=3.38 PD=3.38
M$633 \$247 \$247 \$19 sky130_gnd sky130_fd_pr__nfet_01v8 L=0.6 W=1.4 AS=0.406
+ AD=0.406 PS=3.38 PD=3.38
M$634 \$247 \$247 \$19 sky130_gnd sky130_fd_pr__nfet_01v8 L=0.6 W=1.4 AS=0.406
+ AD=0.406 PS=3.38 PD=3.38
M$635 \$247 \$247 \$19 sky130_gnd sky130_fd_pr__nfet_01v8 L=0.6 W=1.4 AS=0.406
+ AD=0.406 PS=3.38 PD=3.38
M$636 \$247 \$247 \$19 sky130_gnd sky130_fd_pr__nfet_01v8 L=0.6 W=1.4 AS=0.406
+ AD=0.406 PS=3.38 PD=3.38
M$637 \$247 \$247 \$19 sky130_gnd sky130_fd_pr__nfet_01v8 L=0.6 W=1.4 AS=0.406
+ AD=0.406 PS=3.38 PD=3.38
M$638 \$247 \$247 \$19 sky130_gnd sky130_fd_pr__nfet_01v8 L=0.6 W=1.4 AS=0.406
+ AD=0.406 PS=3.38 PD=3.38
M$639 \$247 \$247 \$19 sky130_gnd sky130_fd_pr__nfet_01v8 L=0.6 W=1.4 AS=0.406
+ AD=0.406 PS=3.38 PD=3.38
M$640 \$247 \$247 \$19 sky130_gnd sky130_fd_pr__nfet_01v8 L=0.6 W=1.4 AS=0.406
+ AD=0.406 PS=3.38 PD=3.38
M$641 \$247 \$247 \$19 sky130_gnd sky130_fd_pr__nfet_01v8 L=0.6 W=1.4 AS=0.406
+ AD=0.406 PS=3.38 PD=3.38
M$642 \$247 \$247 \$19 sky130_gnd sky130_fd_pr__nfet_01v8 L=0.6 W=1.4 AS=0.406
+ AD=0.406 PS=3.38 PD=3.38
M$643 \$247 \$247 \$19 sky130_gnd sky130_fd_pr__nfet_01v8 L=0.6 W=1.4 AS=0.406
+ AD=0.406 PS=3.38 PD=3.38
M$644 \$247 \$247 \$19 sky130_gnd sky130_fd_pr__nfet_01v8 L=0.6 W=1.4 AS=0.406
+ AD=0.406 PS=3.38 PD=3.38
M$645 \$247 \$247 \$19 sky130_gnd sky130_fd_pr__nfet_01v8 L=0.6 W=1.4 AS=0.406
+ AD=0.406 PS=3.38 PD=3.38
M$646 \$247 \$247 \$19 sky130_gnd sky130_fd_pr__nfet_01v8 L=0.6 W=1.4 AS=0.406
+ AD=0.406 PS=3.38 PD=3.38
M$647 \$247 \$247 \$19 sky130_gnd sky130_fd_pr__nfet_01v8 L=0.6 W=1.4 AS=0.406
+ AD=0.406 PS=3.38 PD=3.38
M$648 \$247 \$247 \$19 sky130_gnd sky130_fd_pr__nfet_01v8 L=0.6 W=1.4 AS=0.406
+ AD=0.406 PS=3.38 PD=3.38
M$649 \$247 \$247 \$19 sky130_gnd sky130_fd_pr__nfet_01v8 L=0.6 W=1.4 AS=0.406
+ AD=0.406 PS=3.38 PD=3.38
M$650 \$247 \$247 \$19 sky130_gnd sky130_fd_pr__nfet_01v8 L=0.6 W=1.4 AS=0.406
+ AD=0.406 PS=3.38 PD=3.38
M$651 \$247 \$247 \$19 sky130_gnd sky130_fd_pr__nfet_01v8 L=0.6 W=1.4 AS=0.406
+ AD=0.406 PS=3.38 PD=3.38
M$652 \$247 \$247 \$19 sky130_gnd sky130_fd_pr__nfet_01v8 L=0.6 W=1.4 AS=0.406
+ AD=0.406 PS=3.38 PD=3.38
M$653 \$27.x1_net1 cm \$130 sky130_gnd sky130_fd_pr__nfet_01v8 L=0.6 W=1.4
+ AS=0.406 AD=0.406 PS=3.38 PD=3.38
M$654 VSS VSS VSS sky130_gnd sky130_fd_pr__nfet_01v8 L=0.6 W=1.4 AS=0.406
+ AD=0.406 PS=3.38 PD=3.38
M$655 VSS VSS VSS sky130_gnd sky130_fd_pr__nfet_01v8 L=0.6 W=1.4 AS=0.406
+ AD=0.406 PS=3.38 PD=3.38
M$656 cm cm \$27.x1_net1 sky130_gnd sky130_fd_pr__nfet_01v8 L=0.6 W=1.4
+ AS=0.406 AD=0.406 PS=3.38 PD=3.38
M$657 \$26.x1_net13 cm \$291 sky130_gnd sky130_fd_pr__nfet_01v8 L=0.6 W=1.4
+ AS=0.406 AD=0.406 PS=3.38 PD=3.38
M$658 VSS VSS VSS sky130_gnd sky130_fd_pr__nfet_01v8 L=0.6 W=1.4 AS=0.406
+ AD=0.406 PS=3.38 PD=3.38
M$659 VSS VSS VSS sky130_gnd sky130_fd_pr__nfet_01v8 L=0.6 W=1.4 AS=0.406
+ AD=0.406 PS=3.38 PD=3.38
M$660 cm cm \$26.x1_net13 sky130_gnd sky130_fd_pr__nfet_01v8 L=0.6 W=1.4
+ AS=0.406 AD=0.406 PS=3.38 PD=3.38
M$661 \$291 cm \$19.x1_net15 sky130_gnd sky130_fd_pr__nfet_01v8 L=0.6 W=1.4
+ AS=0.406 AD=0.406 PS=3.38 PD=3.38
M$662 VSS VSS VSS sky130_gnd sky130_fd_pr__nfet_01v8 L=0.6 W=1.4 AS=0.406
+ AD=0.406 PS=3.38 PD=3.38
M$663 VSS VSS VSS sky130_gnd sky130_fd_pr__nfet_01v8 L=0.6 W=1.4 AS=0.406
+ AD=0.406 PS=3.38 PD=3.38
M$664 \$19.x1_net15 cm VSS sky130_gnd sky130_fd_pr__nfet_01v8 L=0.6 W=1.4
+ AS=0.406 AD=0.406 PS=3.38 PD=3.38
M$665 \$23.x1_net10 cm \$133 sky130_gnd sky130_fd_pr__nfet_01v8 L=0.6 W=1.4
+ AS=0.406 AD=0.406 PS=3.38 PD=3.38
M$666 VSS VSS VSS sky130_gnd sky130_fd_pr__nfet_01v8 L=0.6 W=1.4 AS=0.406
+ AD=0.406 PS=3.38 PD=3.38
M$667 VSS VSS VSS sky130_gnd sky130_fd_pr__nfet_01v8 L=0.6 W=1.4 AS=0.406
+ AD=0.406 PS=3.38 PD=3.38
M$668 cm cm \$23.x1_net10 sky130_gnd sky130_fd_pr__nfet_01v8 L=0.6 W=1.4
+ AS=0.406 AD=0.406 PS=3.38 PD=3.38
M$669 \$20.x1_net7 cm \$132 sky130_gnd sky130_fd_pr__nfet_01v8 L=0.6 W=1.4
+ AS=0.406 AD=0.406 PS=3.38 PD=3.38
M$670 VSS VSS VSS sky130_gnd sky130_fd_pr__nfet_01v8 L=0.6 W=1.4 AS=0.406
+ AD=0.406 PS=3.38 PD=3.38
M$671 VSS VSS VSS sky130_gnd sky130_fd_pr__nfet_01v8 L=0.6 W=1.4 AS=0.406
+ AD=0.406 PS=3.38 PD=3.38
M$672 cm cm \$20.x1_net7 sky130_gnd sky130_fd_pr__nfet_01v8 L=0.6 W=1.4
+ AS=0.406 AD=0.406 PS=3.38 PD=3.38
M$673 \$22.x1_net4 cm \$131 sky130_gnd sky130_fd_pr__nfet_01v8 L=0.6 W=1.4
+ AS=0.406 AD=0.406 PS=3.38 PD=3.38
M$674 VSS VSS VSS sky130_gnd sky130_fd_pr__nfet_01v8 L=0.6 W=1.4 AS=0.406
+ AD=0.406 PS=3.38 PD=3.38
M$675 VSS VSS VSS sky130_gnd sky130_fd_pr__nfet_01v8 L=0.6 W=1.4 AS=0.406
+ AD=0.406 PS=3.38 PD=3.38
M$676 cm cm \$22.x1_net4 sky130_gnd sky130_fd_pr__nfet_01v8 L=0.6 W=1.4
+ AS=0.406 AD=0.406 PS=3.38 PD=3.38
M$677 \$133 cm \$17.x1_net12 sky130_gnd sky130_fd_pr__nfet_01v8 L=0.6 W=1.4
+ AS=0.406 AD=0.406 PS=3.38 PD=3.38
M$678 VSS VSS VSS sky130_gnd sky130_fd_pr__nfet_01v8 L=0.6 W=1.4 AS=0.406
+ AD=0.406 PS=3.38 PD=3.38
M$679 VSS VSS VSS sky130_gnd sky130_fd_pr__nfet_01v8 L=0.6 W=1.4 AS=0.406
+ AD=0.406 PS=3.38 PD=3.38
M$680 \$17.x1_net12 cm VSS sky130_gnd sky130_fd_pr__nfet_01v8 L=0.6 W=1.4
+ AS=0.406 AD=0.406 PS=3.38 PD=3.38
M$681 \$132 cm \$16.x1_net9 sky130_gnd sky130_fd_pr__nfet_01v8 L=0.6 W=1.4
+ AS=0.406 AD=0.406 PS=3.38 PD=3.38
M$682 VSS VSS VSS sky130_gnd sky130_fd_pr__nfet_01v8 L=0.6 W=1.4 AS=0.406
+ AD=0.406 PS=3.38 PD=3.38
M$683 VSS VSS VSS sky130_gnd sky130_fd_pr__nfet_01v8 L=0.6 W=1.4 AS=0.406
+ AD=0.406 PS=3.38 PD=3.38
M$684 \$16.x1_net9 cm VSS sky130_gnd sky130_fd_pr__nfet_01v8 L=0.6 W=1.4
+ AS=0.406 AD=0.406 PS=3.38 PD=3.38
M$685 \$131 cm \$15.x1_net6 sky130_gnd sky130_fd_pr__nfet_01v8 L=0.6 W=1.4
+ AS=0.406 AD=0.406 PS=3.38 PD=3.38
M$686 VSS VSS VSS sky130_gnd sky130_fd_pr__nfet_01v8 L=0.6 W=1.4 AS=0.406
+ AD=0.406 PS=3.38 PD=3.38
M$687 VSS VSS VSS sky130_gnd sky130_fd_pr__nfet_01v8 L=0.6 W=1.4 AS=0.406
+ AD=0.406 PS=3.38 PD=3.38
M$688 \$15.x1_net6 cm VSS sky130_gnd sky130_fd_pr__nfet_01v8 L=0.6 W=1.4
+ AS=0.406 AD=0.406 PS=3.38 PD=3.38
M$689 \$130 cm \$14.x1_net3 sky130_gnd sky130_fd_pr__nfet_01v8 L=0.6 W=1.4
+ AS=0.406 AD=0.406 PS=3.38 PD=3.38
M$690 VSS VSS VSS sky130_gnd sky130_fd_pr__nfet_01v8 L=0.6 W=1.4 AS=0.406
+ AD=0.406 PS=3.38 PD=3.38
M$691 VSS VSS VSS sky130_gnd sky130_fd_pr__nfet_01v8 L=0.6 W=1.4 AS=0.406
+ AD=0.406 PS=3.38 PD=3.38
M$692 \$14.x1_net3 cm VSS sky130_gnd sky130_fd_pr__nfet_01v8 L=0.6 W=1.4
+ AS=0.406 AD=0.406 PS=3.38 PD=3.38
M$693 on VSS VSS sky130_gnd sky130_fd_pr__nfet_01v8 L=0.6 W=1.4 AS=0.406
+ AD=0.406 PS=3.38 PD=3.38
M$694 on VSS VSS sky130_gnd sky130_fd_pr__nfet_01v8 L=0.6 W=1.4 AS=0.406
+ AD=0.406 PS=3.38 PD=3.38
M$695 \$558 VSS VSS sky130_gnd sky130_fd_pr__nfet_01v8 L=0.6 W=1.4 AS=0.406
+ AD=0.406 PS=3.38 PD=3.38
M$696 \$558 VSS VSS sky130_gnd sky130_fd_pr__nfet_01v8 L=0.6 W=1.4 AS=0.406
+ AD=0.406 PS=3.38 PD=3.38
M$697 op VSS VSS sky130_gnd sky130_fd_pr__nfet_01v8 L=0.6 W=1.4 AS=0.406
+ AD=0.406 PS=3.38 PD=3.38
M$698 op VSS VSS sky130_gnd sky130_fd_pr__nfet_01v8 L=0.6 W=1.4 AS=0.406
+ AD=0.406 PS=3.38 PD=3.38
M$699 op op op sky130_gnd sky130_fd_pr__nfet_01v8 L=0.6 W=1.4 AS=0.406 AD=0.406
+ PS=3.38 PD=3.38
M$700 op op op sky130_gnd sky130_fd_pr__nfet_01v8 L=0.6 W=1.4 AS=0.406 AD=0.406
+ PS=3.38 PD=3.38
M$701 on on on sky130_gnd sky130_fd_pr__nfet_01v8 L=0.6 W=1.4 AS=0.406 AD=0.406
+ PS=3.38 PD=3.38
M$702 on on on sky130_gnd sky130_fd_pr__nfet_01v8 L=0.6 W=1.4 AS=0.406 AD=0.406
+ PS=3.38 PD=3.38
M$703 \$19 \$247 bias_a sky130_gnd sky130_fd_pr__nfet_01v8 L=0.6 W=1.4 AS=0.406
+ AD=0.406 PS=3.38 PD=3.38
M$704 \$19 \$247 bias_a sky130_gnd sky130_fd_pr__nfet_01v8 L=0.6 W=1.4 AS=0.406
+ AD=0.406 PS=3.38 PD=3.38
M$705 \$247 \$247 \$247 sky130_gnd sky130_fd_pr__nfet_01v8 L=0.6 W=1.4 AS=0.406
+ AD=0.406 PS=3.38 PD=3.38
M$706 \$247 \$247 \$247 sky130_gnd sky130_fd_pr__nfet_01v8 L=0.6 W=1.4 AS=0.406
+ AD=0.406 PS=3.38 PD=3.38
M$707 IBIAS IBIAS IBIAS sky130_gnd sky130_fd_pr__nfet_01v8 L=0.6 W=1.4 AS=0.406
+ AD=0.406 PS=3.38 PD=3.38
M$708 IBIAS IBIAS IBIAS sky130_gnd sky130_fd_pr__nfet_01v8 L=0.6 W=1.4 AS=0.406
+ AD=0.406 PS=3.38 PD=3.38
M$709 \$16 \$16 \$16 sky130_gnd sky130_fd_pr__nfet_01v8 L=0.6 W=1.4 AS=0.406
+ AD=0.406 PS=3.38 PD=3.38
M$710 \$16 \$16 \$16 sky130_gnd sky130_fd_pr__nfet_01v8 L=0.6 W=1.4 AS=0.406
+ AD=0.406 PS=3.38 PD=3.38
M$711 \$16 IBIAS VSS sky130_gnd sky130_fd_pr__nfet_01v8 L=0.6 W=1.4 AS=0.406
+ AD=0.406 PS=3.38 PD=3.38
M$712 \$16 IBIAS VSS sky130_gnd sky130_fd_pr__nfet_01v8 L=0.6 W=1.4 AS=0.406
+ AD=0.406 PS=3.38 PD=3.38
M$713 \$16 IBIAS VSS sky130_gnd sky130_fd_pr__nfet_01v8 L=0.6 W=1.4 AS=0.406
+ AD=0.406 PS=3.38 PD=3.38
M$714 \$16 IBIAS VSS sky130_gnd sky130_fd_pr__nfet_01v8 L=0.6 W=1.4 AS=0.406
+ AD=0.406 PS=3.38 PD=3.38
M$715 \$16 IBIAS VSS sky130_gnd sky130_fd_pr__nfet_01v8 L=0.6 W=1.4 AS=0.406
+ AD=0.406 PS=3.38 PD=3.38
M$716 \$16 IBIAS VSS sky130_gnd sky130_fd_pr__nfet_01v8 L=0.6 W=1.4 AS=0.406
+ AD=0.406 PS=3.38 PD=3.38
M$717 \$16 IBIAS VSS sky130_gnd sky130_fd_pr__nfet_01v8 L=0.6 W=1.4 AS=0.406
+ AD=0.406 PS=3.38 PD=3.38
M$718 \$16 IBIAS VSS sky130_gnd sky130_fd_pr__nfet_01v8 L=0.6 W=1.4 AS=0.406
+ AD=0.406 PS=3.38 PD=3.38
M$719 \$16 IBIAS VSS sky130_gnd sky130_fd_pr__nfet_01v8 L=0.6 W=1.4 AS=0.406
+ AD=0.406 PS=3.38 PD=3.38
M$720 \$16 IBIAS VSS sky130_gnd sky130_fd_pr__nfet_01v8 L=0.6 W=1.4 AS=0.406
+ AD=0.406 PS=3.38 PD=3.38
M$721 \$16 IBIAS VSS sky130_gnd sky130_fd_pr__nfet_01v8 L=0.6 W=1.4 AS=0.406
+ AD=0.406 PS=3.38 PD=3.38
M$722 \$16 IBIAS VSS sky130_gnd sky130_fd_pr__nfet_01v8 L=0.6 W=1.4 AS=0.406
+ AD=0.406 PS=3.38 PD=3.38
M$723 \$16 IBIAS VSS sky130_gnd sky130_fd_pr__nfet_01v8 L=0.6 W=1.4 AS=0.406
+ AD=0.406 PS=3.38 PD=3.38
M$724 \$16 IBIAS VSS sky130_gnd sky130_fd_pr__nfet_01v8 L=0.6 W=1.4 AS=0.406
+ AD=0.406 PS=3.38 PD=3.38
M$725 \$16 IBIAS VSS sky130_gnd sky130_fd_pr__nfet_01v8 L=0.6 W=1.4 AS=0.406
+ AD=0.406 PS=3.38 PD=3.38
M$726 \$16 IBIAS VSS sky130_gnd sky130_fd_pr__nfet_01v8 L=0.6 W=1.4 AS=0.406
+ AD=0.406 PS=3.38 PD=3.38
M$727 \$16 IBIAS VSS sky130_gnd sky130_fd_pr__nfet_01v8 L=0.6 W=1.4 AS=0.406
+ AD=0.406 PS=3.38 PD=3.38
M$728 \$16 IBIAS VSS sky130_gnd sky130_fd_pr__nfet_01v8 L=0.6 W=1.4 AS=0.406
+ AD=0.406 PS=3.38 PD=3.38
M$729 VSS VSS VSS sky130_gnd sky130_fd_pr__nfet_01v8 L=0.6 W=1.4 AS=0.406
+ AD=0.406 PS=3.38 PD=3.38
M$730 IBIAS IBIAS VSS sky130_gnd sky130_fd_pr__nfet_01v8 L=0.6 W=1.4 AS=0.406
+ AD=0.406 PS=3.38 PD=3.38
M$731 IBIAS IBIAS VSS sky130_gnd sky130_fd_pr__nfet_01v8 L=0.6 W=1.4 AS=0.406
+ AD=0.406 PS=3.38 PD=3.38
M$732 IBIAS IBIAS VSS sky130_gnd sky130_fd_pr__nfet_01v8 L=0.6 W=1.4 AS=0.406
+ AD=0.406 PS=3.38 PD=3.38
M$733 IBIAS IBIAS VSS sky130_gnd sky130_fd_pr__nfet_01v8 L=0.6 W=1.4 AS=0.406
+ AD=0.406 PS=3.38 PD=3.38
M$734 VSS VSS VSS sky130_gnd sky130_fd_pr__nfet_01v8 L=0.6 W=1.4 AS=0.406
+ AD=0.406 PS=3.38 PD=3.38
M$735 IBIAS IBIAS VSS sky130_gnd sky130_fd_pr__nfet_01v8 L=0.6 W=1.4 AS=0.406
+ AD=0.406 PS=3.38 PD=3.38
M$736 IBIAS IBIAS VSS sky130_gnd sky130_fd_pr__nfet_01v8 L=0.6 W=1.4 AS=0.406
+ AD=0.406 PS=3.38 PD=3.38
M$737 IBIAS IBIAS VSS sky130_gnd sky130_fd_pr__nfet_01v8 L=0.6 W=1.4 AS=0.406
+ AD=0.406 PS=3.38 PD=3.38
M$738 IBIAS IBIAS VSS sky130_gnd sky130_fd_pr__nfet_01v8 L=0.6 W=1.4 AS=0.406
+ AD=0.406 PS=3.38 PD=3.38
M$739 IBIAS IBIAS VSS sky130_gnd sky130_fd_pr__nfet_01v8 L=0.6 W=1.4 AS=0.406
+ AD=0.406 PS=3.38 PD=3.38
M$740 IBIAS IBIAS VSS sky130_gnd sky130_fd_pr__nfet_01v8 L=0.6 W=1.4 AS=0.406
+ AD=0.406 PS=3.38 PD=3.38
M$741 IBIAS IBIAS VSS sky130_gnd sky130_fd_pr__nfet_01v8 L=0.6 W=1.4 AS=0.406
+ AD=0.406 PS=3.38 PD=3.38
M$742 IBIAS IBIAS VSS sky130_gnd sky130_fd_pr__nfet_01v8 L=0.6 W=1.4 AS=0.406
+ AD=0.406 PS=3.38 PD=3.38
M$743 IBIAS IBIAS VSS sky130_gnd sky130_fd_pr__nfet_01v8 L=0.6 W=1.4 AS=0.406
+ AD=0.406 PS=3.38 PD=3.38
M$744 IBIAS IBIAS VSS sky130_gnd sky130_fd_pr__nfet_01v8 L=0.6 W=1.4 AS=0.406
+ AD=0.406 PS=3.38 PD=3.38
M$745 IBIAS IBIAS VSS sky130_gnd sky130_fd_pr__nfet_01v8 L=0.6 W=1.4 AS=0.406
+ AD=0.406 PS=3.38 PD=3.38
M$746 IBIAS IBIAS VSS sky130_gnd sky130_fd_pr__nfet_01v8 L=0.6 W=1.4 AS=0.406
+ AD=0.406 PS=3.38 PD=3.38
M$747 IBIAS IBIAS VSS sky130_gnd sky130_fd_pr__nfet_01v8 L=0.6 W=1.4 AS=0.406
+ AD=0.406 PS=3.38 PD=3.38
M$748 IBIAS IBIAS VSS sky130_gnd sky130_fd_pr__nfet_01v8 L=0.6 W=1.4 AS=0.406
+ AD=0.406 PS=3.38 PD=3.38
M$749 bias_a \$19 \$18 sky130_gnd sky130_fd_pr__nfet_01v8 L=0.6 W=1.4 AS=0.406
+ AD=0.406 PS=3.38 PD=3.38
M$750 bias_a \$19 \$18 sky130_gnd sky130_fd_pr__nfet_01v8 L=0.6 W=1.4 AS=0.406
+ AD=0.406 PS=3.38 PD=3.38
M$751 bias_a \$19 \$18 sky130_gnd sky130_fd_pr__nfet_01v8 L=0.6 W=1.4 AS=0.406
+ AD=0.406 PS=3.38 PD=3.38
M$752 bias_a \$19 \$18 sky130_gnd sky130_fd_pr__nfet_01v8 L=0.6 W=1.4 AS=0.406
+ AD=0.406 PS=3.38 PD=3.38
M$753 bias_a \$19 \$18 sky130_gnd sky130_fd_pr__nfet_01v8 L=0.6 W=1.4 AS=0.406
+ AD=0.406 PS=3.38 PD=3.38
M$754 bias_a \$19 \$18 sky130_gnd sky130_fd_pr__nfet_01v8 L=0.6 W=1.4 AS=0.406
+ AD=0.406 PS=3.38 PD=3.38
M$755 bias_a \$19 \$18 sky130_gnd sky130_fd_pr__nfet_01v8 L=0.6 W=1.4 AS=0.406
+ AD=0.406 PS=3.38 PD=3.38
M$756 bias_a \$19 \$18 sky130_gnd sky130_fd_pr__nfet_01v8 L=0.6 W=1.4 AS=0.406
+ AD=0.406 PS=3.38 PD=3.38
M$757 bias_a \$19 \$18 sky130_gnd sky130_fd_pr__nfet_01v8 L=0.6 W=1.4 AS=0.406
+ AD=0.406 PS=3.38 PD=3.38
M$758 bias_a \$19 \$18 sky130_gnd sky130_fd_pr__nfet_01v8 L=0.6 W=1.4 AS=0.406
+ AD=0.406 PS=3.38 PD=3.38
M$759 bias_a \$19 \$18 sky130_gnd sky130_fd_pr__nfet_01v8 L=0.6 W=1.4 AS=0.406
+ AD=0.406 PS=3.38 PD=3.38
M$760 bias_a \$19 \$18 sky130_gnd sky130_fd_pr__nfet_01v8 L=0.6 W=1.4 AS=0.406
+ AD=0.406 PS=3.38 PD=3.38
M$761 bias_a \$19 \$18 sky130_gnd sky130_fd_pr__nfet_01v8 L=0.6 W=1.4 AS=0.406
+ AD=0.406 PS=3.38 PD=3.38
M$762 bias_a \$19 \$18 sky130_gnd sky130_fd_pr__nfet_01v8 L=0.6 W=1.4 AS=0.406
+ AD=0.406 PS=3.38 PD=3.38
M$763 bias_a \$19 \$18 sky130_gnd sky130_fd_pr__nfet_01v8 L=0.6 W=1.4 AS=0.406
+ AD=0.406 PS=3.38 PD=3.38
M$764 bias_a \$19 \$18 sky130_gnd sky130_fd_pr__nfet_01v8 L=0.6 W=1.4 AS=0.406
+ AD=0.406 PS=3.38 PD=3.38
M$765 bias_a \$19 \$18 sky130_gnd sky130_fd_pr__nfet_01v8 L=0.6 W=1.4 AS=0.406
+ AD=0.406 PS=3.38 PD=3.38
M$766 bias_a \$19 \$18 sky130_gnd sky130_fd_pr__nfet_01v8 L=0.6 W=1.4 AS=0.406
+ AD=0.406 PS=3.38 PD=3.38
M$767 \$18 bias_a VSS sky130_gnd sky130_fd_pr__nfet_01v8 L=0.6 W=1.4 AS=0.406
+ AD=0.406 PS=3.38 PD=3.38
M$768 \$18 bias_a VSS sky130_gnd sky130_fd_pr__nfet_01v8 L=0.6 W=1.4 AS=0.406
+ AD=0.406 PS=3.38 PD=3.38
M$769 \$18 bias_a VSS sky130_gnd sky130_fd_pr__nfet_01v8 L=0.6 W=1.4 AS=0.406
+ AD=0.406 PS=3.38 PD=3.38
M$770 \$18 bias_a VSS sky130_gnd sky130_fd_pr__nfet_01v8 L=0.6 W=1.4 AS=0.406
+ AD=0.406 PS=3.38 PD=3.38
M$771 \$18 bias_a VSS sky130_gnd sky130_fd_pr__nfet_01v8 L=0.6 W=1.4 AS=0.406
+ AD=0.406 PS=3.38 PD=3.38
M$772 \$18 bias_a VSS sky130_gnd sky130_fd_pr__nfet_01v8 L=0.6 W=1.4 AS=0.406
+ AD=0.406 PS=3.38 PD=3.38
M$773 \$18 bias_a VSS sky130_gnd sky130_fd_pr__nfet_01v8 L=0.6 W=1.4 AS=0.406
+ AD=0.406 PS=3.38 PD=3.38
M$774 \$18 bias_a VSS sky130_gnd sky130_fd_pr__nfet_01v8 L=0.6 W=1.4 AS=0.406
+ AD=0.406 PS=3.38 PD=3.38
M$775 \$18 bias_a VSS sky130_gnd sky130_fd_pr__nfet_01v8 L=0.6 W=1.4 AS=0.406
+ AD=0.406 PS=3.38 PD=3.38
M$776 \$18 bias_a VSS sky130_gnd sky130_fd_pr__nfet_01v8 L=0.6 W=1.4 AS=0.406
+ AD=0.406 PS=3.38 PD=3.38
M$777 \$18 bias_a VSS sky130_gnd sky130_fd_pr__nfet_01v8 L=0.6 W=1.4 AS=0.406
+ AD=0.406 PS=3.38 PD=3.38
M$778 \$18 bias_a VSS sky130_gnd sky130_fd_pr__nfet_01v8 L=0.6 W=1.4 AS=0.406
+ AD=0.406 PS=3.38 PD=3.38
M$779 \$18 bias_a VSS sky130_gnd sky130_fd_pr__nfet_01v8 L=0.6 W=1.4 AS=0.406
+ AD=0.406 PS=3.38 PD=3.38
M$780 \$18 bias_a VSS sky130_gnd sky130_fd_pr__nfet_01v8 L=0.6 W=1.4 AS=0.406
+ AD=0.406 PS=3.38 PD=3.38
M$781 \$18 bias_a VSS sky130_gnd sky130_fd_pr__nfet_01v8 L=0.6 W=1.4 AS=0.406
+ AD=0.406 PS=3.38 PD=3.38
M$782 \$18 bias_a VSS sky130_gnd sky130_fd_pr__nfet_01v8 L=0.6 W=1.4 AS=0.406
+ AD=0.406 PS=3.38 PD=3.38
M$783 \$18 bias_a VSS sky130_gnd sky130_fd_pr__nfet_01v8 L=0.6 W=1.4 AS=0.406
+ AD=0.406 PS=3.38 PD=3.38
M$784 \$18 bias_a VSS sky130_gnd sky130_fd_pr__nfet_01v8 L=0.6 W=1.4 AS=0.406
+ AD=0.406 PS=3.38 PD=3.38
M$785 VSS VSS VSS sky130_gnd sky130_fd_pr__nfet_01v8 L=0.6 W=1.4 AS=0.406
+ AD=0.406 PS=3.38 PD=3.38
M$786 VSS VSS VSS sky130_gnd sky130_fd_pr__nfet_01v8 L=0.6 W=1.4 AS=0.406
+ AD=0.406 PS=3.38 PD=3.38
M$787 VSS VSS VSS sky130_gnd sky130_fd_pr__nfet_01v8 L=0.6 W=1.4 AS=0.406
+ AD=0.406 PS=3.38 PD=3.38
M$788 VSS VSS VSS sky130_gnd sky130_fd_pr__nfet_01v8 L=0.6 W=1.4 AS=0.406
+ AD=0.406 PS=3.38 PD=3.38
M$789 VSS VSS VSS sky130_gnd sky130_fd_pr__nfet_01v8 L=0.6 W=1.4 AS=0.406
+ AD=0.406 PS=3.38 PD=3.38
M$790 VSS VSS VSS sky130_gnd sky130_fd_pr__nfet_01v8 L=0.6 W=1.4 AS=0.406
+ AD=0.406 PS=3.38 PD=3.38
M$791 VSS VSS VSS sky130_gnd sky130_fd_pr__nfet_01v8 L=0.6 W=1.4 AS=0.406
+ AD=0.406 PS=3.38 PD=3.38
M$792 VSS VSS VSS sky130_gnd sky130_fd_pr__nfet_01v8 L=0.6 W=1.4 AS=0.406
+ AD=0.406 PS=3.38 PD=3.38
M$793 VSS VSS VSS sky130_gnd sky130_fd_pr__nfet_01v8 L=0.6 W=1.4 AS=0.406
+ AD=0.406 PS=3.38 PD=3.38
M$794 VSS VSS VSS sky130_gnd sky130_fd_pr__nfet_01v8 L=0.6 W=1.4 AS=0.406
+ AD=0.406 PS=3.38 PD=3.38
M$795 VSS VSS VSS sky130_gnd sky130_fd_pr__nfet_01v8 L=0.6 W=1.4 AS=0.406
+ AD=0.406 PS=3.38 PD=3.38
M$796 VSS VSS VSS sky130_gnd sky130_fd_pr__nfet_01v8 L=0.6 W=1.4 AS=0.406
+ AD=0.406 PS=3.38 PD=3.38
M$797 VSS VSS VSS sky130_gnd sky130_fd_pr__nfet_01v8 L=0.6 W=1.4 AS=0.406
+ AD=0.406 PS=3.38 PD=3.38
M$798 VSS VSS VSS sky130_gnd sky130_fd_pr__nfet_01v8 L=0.6 W=1.4 AS=0.406
+ AD=0.406 PS=3.38 PD=3.38
M$799 VSS VSS VSS sky130_gnd sky130_fd_pr__nfet_01v8 L=0.6 W=1.4 AS=0.406
+ AD=0.406 PS=3.38 PD=3.38
M$800 VSS VSS VSS sky130_gnd sky130_fd_pr__nfet_01v8 L=0.6 W=1.4 AS=0.406
+ AD=0.406 PS=3.38 PD=3.38
M$801 VSS VSS VSS sky130_gnd sky130_fd_pr__nfet_01v8 L=0.6 W=1.4 AS=0.406
+ AD=0.406 PS=3.38 PD=3.38
M$802 VSS VSS VSS sky130_gnd sky130_fd_pr__nfet_01v8 L=0.6 W=1.4 AS=0.406
+ AD=0.406 PS=3.38 PD=3.38
M$803 VSS VSS VSS sky130_gnd sky130_fd_pr__nfet_01v8 L=0.6 W=1.4 AS=0.406
+ AD=0.406 PS=3.38 PD=3.38
M$804 VSS VSS VSS sky130_gnd sky130_fd_pr__nfet_01v8 L=0.6 W=1.4 AS=0.406
+ AD=0.406 PS=3.38 PD=3.38
M$805 VSS VSS VSS sky130_gnd sky130_fd_pr__nfet_01v8 L=0.6 W=1.4 AS=0.406
+ AD=0.406 PS=3.38 PD=3.38
M$806 VSS VSS VSS sky130_gnd sky130_fd_pr__nfet_01v8 L=0.6 W=1.4 AS=0.406
+ AD=0.406 PS=3.38 PD=3.38
M$807 VSS VSS VSS sky130_gnd sky130_fd_pr__nfet_01v8 L=0.6 W=1.4 AS=0.406
+ AD=0.406 PS=3.38 PD=3.38
M$808 bias_a bias_a bias_a sky130_gnd sky130_fd_pr__nfet_01v8 L=0.6 W=1.4
+ AS=0.406 AD=0.406 PS=3.38 PD=3.38
M$809 bias_a bias_a bias_a sky130_gnd sky130_fd_pr__nfet_01v8 L=0.6 W=1.4
+ AS=0.406 AD=0.406 PS=3.38 PD=3.38
M$810 bias_a bias_a bias_a sky130_gnd sky130_fd_pr__nfet_01v8 L=0.6 W=1.4
+ AS=0.406 AD=0.406 PS=3.38 PD=3.38
M$811 bias_a bias_a bias_a sky130_gnd sky130_fd_pr__nfet_01v8 L=0.6 W=1.4
+ AS=0.406 AD=0.406 PS=3.38 PD=3.38
M$812 \$621 VSS VSS sky130_gnd sky130_fd_pr__nfet_01v8 L=0.6 W=1.4 AS=0.406
+ AD=0.406 PS=3.38 PD=3.38
M$813 \$621 VSS VSS sky130_gnd sky130_fd_pr__nfet_01v8 L=0.6 W=1.4 AS=0.406
+ AD=0.406 PS=3.38 PD=3.38
M$814 \$621 VSS VSS sky130_gnd sky130_fd_pr__nfet_01v8 L=0.6 W=1.4 AS=0.406
+ AD=0.406 PS=3.38 PD=3.38
M$815 \$621 VSS VSS sky130_gnd sky130_fd_pr__nfet_01v8 L=0.6 W=1.4 AS=0.406
+ AD=0.406 PS=3.38 PD=3.38
M$816 \$621 VSS VSS sky130_gnd sky130_fd_pr__nfet_01v8 L=0.6 W=1.4 AS=0.406
+ AD=0.406 PS=3.38 PD=3.38
M$817 \$621 VSS VSS sky130_gnd sky130_fd_pr__nfet_01v8 L=0.6 W=1.4 AS=0.406
+ AD=0.406 PS=3.38 PD=3.38
M$818 \$621 VSS VSS sky130_gnd sky130_fd_pr__nfet_01v8 L=0.6 W=1.4 AS=0.406
+ AD=0.406 PS=3.38 PD=3.38
M$819 \$621 VSS VSS sky130_gnd sky130_fd_pr__nfet_01v8 L=0.6 W=1.4 AS=0.406
+ AD=0.406 PS=3.38 PD=3.38
M$820 cm cm cm sky130_gnd sky130_fd_pr__nfet_01v8 L=0.6 W=1.4 AS=0.406 AD=0.406
+ PS=3.38 PD=3.38
M$821 cm cm cm sky130_gnd sky130_fd_pr__nfet_01v8 L=0.6 W=1.4 AS=0.406 AD=0.406
+ PS=3.38 PD=3.38
M$822 cm cm cm sky130_gnd sky130_fd_pr__nfet_01v8 L=0.6 W=1.4 AS=0.406 AD=0.406
+ PS=3.38 PD=3.38
M$823 cm cm cm sky130_gnd sky130_fd_pr__nfet_01v8 L=0.6 W=1.4 AS=0.406 AD=0.406
+ PS=3.38 PD=3.38
M$824 cm cm cm sky130_gnd sky130_fd_pr__nfet_01v8 L=0.6 W=1.4 AS=0.406 AD=0.406
+ PS=3.38 PD=3.38
M$825 cm cm cm sky130_gnd sky130_fd_pr__nfet_01v8 L=0.6 W=1.4 AS=0.406 AD=0.406
+ PS=3.38 PD=3.38
M$826 cm cm cm sky130_gnd sky130_fd_pr__nfet_01v8 L=0.6 W=1.4 AS=0.406 AD=0.406
+ PS=3.38 PD=3.38
M$827 cm cm cm sky130_gnd sky130_fd_pr__nfet_01v8 L=0.6 W=1.4 AS=0.406 AD=0.406
+ PS=3.38 PD=3.38
M$828 \$19 \$19 \$19 sky130_gnd sky130_fd_pr__nfet_01v8 L=0.6 W=1.4 AS=0.406
+ AD=0.406 PS=3.38 PD=3.38
M$829 \$19 \$19 \$19 sky130_gnd sky130_fd_pr__nfet_01v8 L=0.6 W=1.4 AS=0.406
+ AD=0.406 PS=3.38 PD=3.38
M$830 \$19 \$19 \$19 sky130_gnd sky130_fd_pr__nfet_01v8 L=0.6 W=1.4 AS=0.406
+ AD=0.406 PS=3.38 PD=3.38
M$831 \$19 \$19 \$19 sky130_gnd sky130_fd_pr__nfet_01v8 L=0.6 W=1.4 AS=0.406
+ AD=0.406 PS=3.38 PD=3.38
M$832 \$19 \$19 \$19 sky130_gnd sky130_fd_pr__nfet_01v8 L=0.6 W=1.4 AS=0.406
+ AD=0.406 PS=3.38 PD=3.38
M$833 \$19 \$19 \$19 sky130_gnd sky130_fd_pr__nfet_01v8 L=0.6 W=1.4 AS=0.406
+ AD=0.406 PS=3.38 PD=3.38
M$834 \$19 \$19 \$19 sky130_gnd sky130_fd_pr__nfet_01v8 L=0.6 W=1.4 AS=0.406
+ AD=0.406 PS=3.38 PD=3.38
M$835 \$19 \$19 \$19 sky130_gnd sky130_fd_pr__nfet_01v8 L=0.6 W=1.4 AS=0.406
+ AD=0.406 PS=3.38 PD=3.38
M$836 \$558 \$558 \$558 sky130_gnd sky130_fd_pr__nfet_01v8 L=0.6 W=1.4 AS=0.406
+ AD=0.406 PS=3.38 PD=3.38
M$837 \$558 \$558 \$558 sky130_gnd sky130_fd_pr__nfet_01v8 L=0.6 W=1.4 AS=0.406
+ AD=0.406 PS=3.38 PD=3.38
M$838 \$558 \$558 \$558 sky130_gnd sky130_fd_pr__nfet_01v8 L=0.6 W=1.4 AS=0.406
+ AD=0.406 PS=3.38 PD=3.38
M$839 \$558 \$558 \$558 sky130_gnd sky130_fd_pr__nfet_01v8 L=0.6 W=1.4 AS=0.406
+ AD=0.406 PS=3.38 PD=3.38
M$840 \$558 \$558 \$558 sky130_gnd sky130_fd_pr__nfet_01v8 L=0.6 W=1.4 AS=0.406
+ AD=0.406 PS=3.38 PD=3.38
M$841 \$558 \$558 \$558 sky130_gnd sky130_fd_pr__nfet_01v8 L=0.6 W=1.4 AS=0.406
+ AD=0.406 PS=3.38 PD=3.38
M$842 \$623 VSS VSS sky130_gnd sky130_fd_pr__nfet_01v8 L=0.6 W=1.4 AS=0.406
+ AD=0.406 PS=3.38 PD=3.38
M$843 \$623 VSS VSS sky130_gnd sky130_fd_pr__nfet_01v8 L=0.6 W=1.4 AS=0.406
+ AD=0.406 PS=3.38 PD=3.38
M$844 \$623 VSS VSS sky130_gnd sky130_fd_pr__nfet_01v8 L=0.6 W=1.4 AS=0.406
+ AD=0.406 PS=3.38 PD=3.38
M$845 \$623 VSS VSS sky130_gnd sky130_fd_pr__nfet_01v8 L=0.6 W=1.4 AS=0.406
+ AD=0.406 PS=3.38 PD=3.38
M$846 \$623 VSS VSS sky130_gnd sky130_fd_pr__nfet_01v8 L=0.6 W=1.4 AS=0.406
+ AD=0.406 PS=3.38 PD=3.38
M$847 \$623 VSS VSS sky130_gnd sky130_fd_pr__nfet_01v8 L=0.6 W=1.4 AS=0.406
+ AD=0.406 PS=3.38 PD=3.38
M$848 \$18 VSS VSS sky130_gnd sky130_fd_pr__nfet_01v8 L=0.6 W=1.4 AS=0.406
+ AD=0.406 PS=3.38 PD=3.38
M$849 \$18 VSS VSS sky130_gnd sky130_fd_pr__nfet_01v8 L=0.6 W=1.4 AS=0.406
+ AD=0.406 PS=3.38 PD=3.38
M$850 \$18 VSS VSS sky130_gnd sky130_fd_pr__nfet_01v8 L=0.6 W=1.4 AS=0.406
+ AD=0.406 PS=3.38 PD=3.38
M$851 \$18 VSS VSS sky130_gnd sky130_fd_pr__nfet_01v8 L=0.6 W=1.4 AS=0.406
+ AD=0.406 PS=3.38 PD=3.38
M$852 \$18 VSS VSS sky130_gnd sky130_fd_pr__nfet_01v8 L=0.6 W=1.4 AS=0.406
+ AD=0.406 PS=3.38 PD=3.38
M$853 \$18 VSS VSS sky130_gnd sky130_fd_pr__nfet_01v8 L=0.6 W=1.4 AS=0.406
+ AD=0.406 PS=3.38 PD=3.38
M$854 \$18 \$18 \$18 sky130_gnd sky130_fd_pr__nfet_01v8 L=0.6 W=1.4 AS=0.406
+ AD=0.406 PS=3.38 PD=3.38
M$855 \$18 \$18 \$18 sky130_gnd sky130_fd_pr__nfet_01v8 L=0.6 W=1.4 AS=0.406
+ AD=0.406 PS=3.38 PD=3.38
M$856 \$18 \$18 \$18 sky130_gnd sky130_fd_pr__nfet_01v8 L=0.6 W=1.4 AS=0.406
+ AD=0.406 PS=3.38 PD=3.38
M$857 \$18 \$18 \$18 sky130_gnd sky130_fd_pr__nfet_01v8 L=0.6 W=1.4 AS=0.406
+ AD=0.406 PS=3.38 PD=3.38
M$858 \$18 \$18 \$18 sky130_gnd sky130_fd_pr__nfet_01v8 L=0.6 W=1.4 AS=0.406
+ AD=0.406 PS=3.38 PD=3.38
M$859 \$18 \$18 \$18 sky130_gnd sky130_fd_pr__nfet_01v8 L=0.6 W=1.4 AS=0.406
+ AD=0.406 PS=3.38 PD=3.38
M$860 \$17 \$17 \$17 sky130_gnd sky130_fd_pr__nfet_01v8_lvt L=0.6 W=1.4
+ AS=0.406 AD=0.406 PS=3.38 PD=3.38
M$861 \$17 \$17 \$17 sky130_gnd sky130_fd_pr__nfet_01v8_lvt L=0.6 W=1.4
+ AS=0.406 AD=0.406 PS=3.38 PD=3.38
M$862 \$17 \$17 \$17 sky130_gnd sky130_fd_pr__nfet_01v8_lvt L=0.6 W=1.4
+ AS=0.406 AD=0.406 PS=3.38 PD=3.38
M$863 \$17 \$17 \$17 sky130_gnd sky130_fd_pr__nfet_01v8_lvt L=0.6 W=1.4
+ AS=0.406 AD=0.406 PS=3.38 PD=3.38
M$864 \$17 \$17 \$17 sky130_gnd sky130_fd_pr__nfet_01v8_lvt L=0.6 W=1.4
+ AS=0.406 AD=0.406 PS=3.38 PD=3.38
M$865 \$17 \$17 \$17 sky130_gnd sky130_fd_pr__nfet_01v8_lvt L=0.6 W=1.4
+ AS=0.406 AD=0.406 PS=3.38 PD=3.38
M$866 \$17 \$17 \$17 sky130_gnd sky130_fd_pr__nfet_01v8_lvt L=0.6 W=1.4
+ AS=0.406 AD=0.406 PS=3.38 PD=3.38
M$867 \$17 \$17 \$17 sky130_gnd sky130_fd_pr__nfet_01v8_lvt L=0.6 W=1.4
+ AS=0.406 AD=0.406 PS=3.38 PD=3.38
M$868 \$16 \$16 \$16 sky130_gnd sky130_fd_pr__nfet_01v8_lvt L=0.6 W=1.4
+ AS=0.406 AD=0.406 PS=3.38 PD=3.38
M$869 \$16 \$16 \$16 sky130_gnd sky130_fd_pr__nfet_01v8_lvt L=0.6 W=1.4
+ AS=0.406 AD=0.406 PS=3.38 PD=3.38
M$870 \$16 \$16 \$16 sky130_gnd sky130_fd_pr__nfet_01v8_lvt L=0.6 W=1.4
+ AS=0.406 AD=0.406 PS=3.38 PD=3.38
M$871 \$16 \$16 \$16 sky130_gnd sky130_fd_pr__nfet_01v8_lvt L=0.6 W=1.4
+ AS=0.406 AD=0.406 PS=3.38 PD=3.38
M$872 \$16 \$16 \$16 sky130_gnd sky130_fd_pr__nfet_01v8_lvt L=0.6 W=1.4
+ AS=0.406 AD=0.406 PS=3.38 PD=3.38
M$873 \$16 \$16 \$16 sky130_gnd sky130_fd_pr__nfet_01v8_lvt L=0.6 W=1.4
+ AS=0.406 AD=0.406 PS=3.38 PD=3.38
M$874 \$16 \$16 \$16 sky130_gnd sky130_fd_pr__nfet_01v8_lvt L=0.6 W=1.4
+ AS=0.406 AD=0.406 PS=3.38 PD=3.38
M$875 \$16 \$16 \$16 sky130_gnd sky130_fd_pr__nfet_01v8_lvt L=0.6 W=1.4
+ AS=0.406 AD=0.406 PS=3.38 PD=3.38
.ENDS iadc_ota_routed
