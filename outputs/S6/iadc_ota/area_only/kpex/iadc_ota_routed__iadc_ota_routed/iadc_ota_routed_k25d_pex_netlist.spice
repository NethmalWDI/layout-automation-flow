*********************************************************
*** NGSPICE file created by KLayout-PEX 0.6.8
*** -----------------------------------------------------
***     Extraction Engine: KPEX/2.5D
***     Technology: sky130a
***     Date: 2026-11-04 21:16:49
*********************************************************

.SUBCKT iadc_ota_routed \$14.x1_net3 \$15.x1_net6 \$16.x1_net9 \$17.x1_net12
+ \$19.x1_net15 \$20.x1_net7 \$22.x1_net4 \$23.x1_net10 \$26.x1_net13
+ \$27.x1_net1 IBIAS VDD VSS bias_a cm cmc in ip on op sky130_gnd
X$9 VDD VDD op VDD sky130_fd_pr__pfet_01v8 l=0.6 w=1.4 as=0.406 ad=0.406
+ ps=3.38 pd=3.38
X$10 VDD VDD op VDD sky130_fd_pr__pfet_01v8 l=0.6 w=1.4 as=0.406 ad=0.406
+ ps=3.38 pd=3.38
X$11 VDD VDD op VDD sky130_fd_pr__pfet_01v8 l=0.6 w=1.4 as=0.406 ad=0.406
+ ps=3.38 pd=3.38
X$12 VDD VDD op VDD sky130_fd_pr__pfet_01v8 l=0.6 w=1.4 as=0.406 ad=0.406
+ ps=3.38 pd=3.38
X$13 VDD VDD on VDD sky130_fd_pr__pfet_01v8 l=0.6 w=1.4 as=0.406 ad=0.406
+ ps=3.38 pd=3.38
X$14 VDD VDD on VDD sky130_fd_pr__pfet_01v8 l=0.6 w=1.4 as=0.406 ad=0.406
+ ps=3.38 pd=3.38
X$15 VDD VDD on VDD sky130_fd_pr__pfet_01v8 l=0.6 w=1.4 as=0.406 ad=0.406
+ ps=3.38 pd=3.38
X$16 VDD VDD on VDD sky130_fd_pr__pfet_01v8 l=0.6 w=1.4 as=0.406 ad=0.406
+ ps=3.38 pd=3.38
X$17 \$558 ip \$536 sky130_gnd sky130_fd_pr__nfet_01v8_lvt l=0.2 w=1.2 as=0.348
+ ad=0.348 ps=2.98 pd=2.98
X$18 \$558 ip \$536 sky130_gnd sky130_fd_pr__nfet_01v8_lvt l=0.2 w=1.2 as=0.348
+ ad=0.348 ps=2.98 pd=2.98
X$19 \$558 ip \$536 sky130_gnd sky130_fd_pr__nfet_01v8_lvt l=0.2 w=1.2 as=0.348
+ ad=0.348 ps=2.98 pd=2.98
X$20 \$558 ip \$536 sky130_gnd sky130_fd_pr__nfet_01v8_lvt l=0.2 w=1.2 as=0.348
+ ad=0.348 ps=2.98 pd=2.98
X$21 \$558 ip \$536 sky130_gnd sky130_fd_pr__nfet_01v8_lvt l=0.2 w=1.2 as=0.348
+ ad=0.348 ps=2.98 pd=2.98
X$22 \$558 ip \$536 sky130_gnd sky130_fd_pr__nfet_01v8_lvt l=0.2 w=1.2 as=0.348
+ ad=0.348 ps=2.98 pd=2.98
X$23 \$558 in \$586 sky130_gnd sky130_fd_pr__nfet_01v8_lvt l=0.2 w=1.2 as=0.348
+ ad=0.348 ps=2.98 pd=2.98
X$24 \$558 in \$586 sky130_gnd sky130_fd_pr__nfet_01v8_lvt l=0.2 w=1.2 as=0.348
+ ad=0.348 ps=2.98 pd=2.98
X$25 \$558 in \$586 sky130_gnd sky130_fd_pr__nfet_01v8_lvt l=0.2 w=1.2 as=0.348
+ ad=0.348 ps=2.98 pd=2.98
X$26 \$558 in \$586 sky130_gnd sky130_fd_pr__nfet_01v8_lvt l=0.2 w=1.2 as=0.348
+ ad=0.348 ps=2.98 pd=2.98
X$27 \$558 in \$586 sky130_gnd sky130_fd_pr__nfet_01v8_lvt l=0.2 w=1.2 as=0.348
+ ad=0.348 ps=2.98 pd=2.98
X$28 \$558 in \$586 sky130_gnd sky130_fd_pr__nfet_01v8_lvt l=0.2 w=1.2 as=0.348
+ ad=0.348 ps=2.98 pd=2.98
X$29 VSS VSS VSS sky130_gnd sky130_fd_pr__nfet_01v8_lvt l=0.2 w=1.2 as=0.348
+ ad=0.348 ps=2.98 pd=2.98
X$30 VSS VSS VSS sky130_gnd sky130_fd_pr__nfet_01v8_lvt l=0.2 w=1.2 as=0.348
+ ad=0.348 ps=2.98 pd=2.98
X$31 \$586 \$586 \$586 sky130_gnd sky130_fd_pr__nfet_01v8_lvt l=0.2 w=1.2
+ as=0.348 ad=0.348 ps=2.98 pd=2.98
X$32 \$586 \$586 \$586 sky130_gnd sky130_fd_pr__nfet_01v8_lvt l=0.2 w=1.2
+ as=0.348 ad=0.348 ps=2.98 pd=2.98
X$33 \$536 \$536 \$536 sky130_gnd sky130_fd_pr__nfet_01v8_lvt l=0.2 w=1.2
+ as=0.348 ad=0.348 ps=2.98 pd=2.98
X$34 \$536 \$536 \$536 sky130_gnd sky130_fd_pr__nfet_01v8_lvt l=0.2 w=1.2
+ as=0.348 ad=0.348 ps=2.98 pd=2.98
X$35 VDD VDD VDD VDD sky130_fd_pr__pfet_01v8_lvt l=0.6 w=1.4 as=0.406 ad=0.406
+ ps=3.38 pd=3.38
X$36 VDD \$17 \$586 VDD sky130_fd_pr__pfet_01v8_lvt l=0.6 w=1.4 as=0.406
+ ad=0.406 ps=3.38 pd=3.38
X$37 VDD \$17 \$536 VDD sky130_fd_pr__pfet_01v8_lvt l=0.6 w=1.4 as=0.406
+ ad=0.406 ps=3.38 pd=3.38
X$38 VDD \$17 \$586 VDD sky130_fd_pr__pfet_01v8_lvt l=0.6 w=1.4 as=0.406
+ ad=0.406 ps=3.38 pd=3.38
X$39 VDD \$17 \$536 VDD sky130_fd_pr__pfet_01v8_lvt l=0.6 w=1.4 as=0.406
+ ad=0.406 ps=3.38 pd=3.38
X$40 VDD \$17 \$586 VDD sky130_fd_pr__pfet_01v8_lvt l=0.6 w=1.4 as=0.406
+ ad=0.406 ps=3.38 pd=3.38
X$41 VDD \$17 \$536 VDD sky130_fd_pr__pfet_01v8_lvt l=0.6 w=1.4 as=0.406
+ ad=0.406 ps=3.38 pd=3.38
X$42 VDD \$17 \$586 VDD sky130_fd_pr__pfet_01v8_lvt l=0.6 w=1.4 as=0.406
+ ad=0.406 ps=3.38 pd=3.38
X$43 VDD \$17 \$536 VDD sky130_fd_pr__pfet_01v8_lvt l=0.6 w=1.4 as=0.406
+ ad=0.406 ps=3.38 pd=3.38
X$44 VDD \$17 \$586 VDD sky130_fd_pr__pfet_01v8_lvt l=0.6 w=1.4 as=0.406
+ ad=0.406 ps=3.38 pd=3.38
X$45 VDD \$17 \$536 VDD sky130_fd_pr__pfet_01v8_lvt l=0.6 w=1.4 as=0.406
+ ad=0.406 ps=3.38 pd=3.38
X$46 VDD \$17 \$586 VDD sky130_fd_pr__pfet_01v8_lvt l=0.6 w=1.4 as=0.406
+ ad=0.406 ps=3.38 pd=3.38
X$47 VDD \$17 \$586 VDD sky130_fd_pr__pfet_01v8_lvt l=0.6 w=1.4 as=0.406
+ ad=0.406 ps=3.38 pd=3.38
X$48 VDD \$17 \$536 VDD sky130_fd_pr__pfet_01v8_lvt l=0.6 w=1.4 as=0.406
+ ad=0.406 ps=3.38 pd=3.38
X$49 VDD \$17 \$586 VDD sky130_fd_pr__pfet_01v8_lvt l=0.6 w=1.4 as=0.406
+ ad=0.406 ps=3.38 pd=3.38
X$50 VDD \$17 \$536 VDD sky130_fd_pr__pfet_01v8_lvt l=0.6 w=1.4 as=0.406
+ ad=0.406 ps=3.38 pd=3.38
X$51 VDD \$17 \$586 VDD sky130_fd_pr__pfet_01v8_lvt l=0.6 w=1.4 as=0.406
+ ad=0.406 ps=3.38 pd=3.38
X$52 VDD \$17 \$536 VDD sky130_fd_pr__pfet_01v8_lvt l=0.6 w=1.4 as=0.406
+ ad=0.406 ps=3.38 pd=3.38
X$53 VDD \$17 \$586 VDD sky130_fd_pr__pfet_01v8_lvt l=0.6 w=1.4 as=0.406
+ ad=0.406 ps=3.38 pd=3.38
X$54 VDD \$17 \$536 VDD sky130_fd_pr__pfet_01v8_lvt l=0.6 w=1.4 as=0.406
+ ad=0.406 ps=3.38 pd=3.38
X$55 VDD \$17 \$586 VDD sky130_fd_pr__pfet_01v8_lvt l=0.6 w=1.4 as=0.406
+ ad=0.406 ps=3.38 pd=3.38
X$56 VDD \$17 \$536 VDD sky130_fd_pr__pfet_01v8_lvt l=0.6 w=1.4 as=0.406
+ ad=0.406 ps=3.38 pd=3.38
X$57 VDD \$17 \$586 VDD sky130_fd_pr__pfet_01v8_lvt l=0.6 w=1.4 as=0.406
+ ad=0.406 ps=3.38 pd=3.38
X$58 VDD \$17 \$536 VDD sky130_fd_pr__pfet_01v8_lvt l=0.6 w=1.4 as=0.406
+ ad=0.406 ps=3.38 pd=3.38
X$59 VDD \$17 \$536 VDD sky130_fd_pr__pfet_01v8_lvt l=0.6 w=1.4 as=0.406
+ ad=0.406 ps=3.38 pd=3.38
X$60 VDD VDD VDD VDD sky130_fd_pr__pfet_01v8_lvt l=0.6 w=1.4 as=0.406 ad=0.406
+ ps=3.38 pd=3.38
X$61 VDD \$17 \$586 VDD sky130_fd_pr__pfet_01v8_lvt l=0.6 w=1.4 as=0.406
+ ad=0.406 ps=3.38 pd=3.38
X$62 VDD \$17 \$536 VDD sky130_fd_pr__pfet_01v8_lvt l=0.6 w=1.4 as=0.406
+ ad=0.406 ps=3.38 pd=3.38
X$63 VDD \$17 \$586 VDD sky130_fd_pr__pfet_01v8_lvt l=0.6 w=1.4 as=0.406
+ ad=0.406 ps=3.38 pd=3.38
X$64 VDD \$17 \$536 VDD sky130_fd_pr__pfet_01v8_lvt l=0.6 w=1.4 as=0.406
+ ad=0.406 ps=3.38 pd=3.38
X$65 VDD \$17 \$586 VDD sky130_fd_pr__pfet_01v8_lvt l=0.6 w=1.4 as=0.406
+ ad=0.406 ps=3.38 pd=3.38
X$66 VDD \$17 \$536 VDD sky130_fd_pr__pfet_01v8_lvt l=0.6 w=1.4 as=0.406
+ ad=0.406 ps=3.38 pd=3.38
X$67 VDD \$17 \$586 VDD sky130_fd_pr__pfet_01v8_lvt l=0.6 w=1.4 as=0.406
+ ad=0.406 ps=3.38 pd=3.38
X$68 VDD \$17 \$536 VDD sky130_fd_pr__pfet_01v8_lvt l=0.6 w=1.4 as=0.406
+ ad=0.406 ps=3.38 pd=3.38
X$69 VDD \$17 \$586 VDD sky130_fd_pr__pfet_01v8_lvt l=0.6 w=1.4 as=0.406
+ ad=0.406 ps=3.38 pd=3.38
X$70 VDD \$17 \$536 VDD sky130_fd_pr__pfet_01v8_lvt l=0.6 w=1.4 as=0.406
+ ad=0.406 ps=3.38 pd=3.38
X$71 VDD \$17 \$536 VDD sky130_fd_pr__pfet_01v8_lvt l=0.6 w=1.4 as=0.406
+ ad=0.406 ps=3.38 pd=3.38
X$72 VDD \$17 \$536 VDD sky130_fd_pr__pfet_01v8_lvt l=0.6 w=1.4 as=0.406
+ ad=0.406 ps=3.38 pd=3.38
X$73 VDD \$17 \$586 VDD sky130_fd_pr__pfet_01v8_lvt l=0.6 w=1.4 as=0.406
+ ad=0.406 ps=3.38 pd=3.38
X$74 VDD \$17 \$536 VDD sky130_fd_pr__pfet_01v8_lvt l=0.6 w=1.4 as=0.406
+ ad=0.406 ps=3.38 pd=3.38
X$75 VDD \$17 \$586 VDD sky130_fd_pr__pfet_01v8_lvt l=0.6 w=1.4 as=0.406
+ ad=0.406 ps=3.38 pd=3.38
X$76 VDD \$17 \$536 VDD sky130_fd_pr__pfet_01v8_lvt l=0.6 w=1.4 as=0.406
+ ad=0.406 ps=3.38 pd=3.38
X$77 VDD \$17 \$586 VDD sky130_fd_pr__pfet_01v8_lvt l=0.6 w=1.4 as=0.406
+ ad=0.406 ps=3.38 pd=3.38
X$78 VDD \$17 \$536 VDD sky130_fd_pr__pfet_01v8_lvt l=0.6 w=1.4 as=0.406
+ ad=0.406 ps=3.38 pd=3.38
X$79 VDD \$17 \$586 VDD sky130_fd_pr__pfet_01v8_lvt l=0.6 w=1.4 as=0.406
+ ad=0.406 ps=3.38 pd=3.38
X$80 VDD \$17 \$536 VDD sky130_fd_pr__pfet_01v8_lvt l=0.6 w=1.4 as=0.406
+ ad=0.406 ps=3.38 pd=3.38
X$81 VDD \$17 \$586 VDD sky130_fd_pr__pfet_01v8_lvt l=0.6 w=1.4 as=0.406
+ ad=0.406 ps=3.38 pd=3.38
X$82 VDD \$17 \$536 VDD sky130_fd_pr__pfet_01v8_lvt l=0.6 w=1.4 as=0.406
+ ad=0.406 ps=3.38 pd=3.38
X$83 VDD \$17 \$586 VDD sky130_fd_pr__pfet_01v8_lvt l=0.6 w=1.4 as=0.406
+ ad=0.406 ps=3.38 pd=3.38
X$84 VDD \$17 \$586 VDD sky130_fd_pr__pfet_01v8_lvt l=0.6 w=1.4 as=0.406
+ ad=0.406 ps=3.38 pd=3.38
X$85 VDD \$17 \$340 VDD sky130_fd_pr__pfet_01v8_lvt l=0.6 w=1.4 as=0.406
+ ad=0.406 ps=3.38 pd=3.38
X$86 VDD \$17 \$340 VDD sky130_fd_pr__pfet_01v8_lvt l=0.6 w=1.4 as=0.406
+ ad=0.406 ps=3.38 pd=3.38
X$87 VDD \$17 \$340 VDD sky130_fd_pr__pfet_01v8_lvt l=0.6 w=1.4 as=0.406
+ ad=0.406 ps=3.38 pd=3.38
X$88 VDD \$17 \$340 VDD sky130_fd_pr__pfet_01v8_lvt l=0.6 w=1.4 as=0.406
+ ad=0.406 ps=3.38 pd=3.38
X$89 VDD \$17 \$340 VDD sky130_fd_pr__pfet_01v8_lvt l=0.6 w=1.4 as=0.406
+ ad=0.406 ps=3.38 pd=3.38
X$90 VDD \$17 \$340 VDD sky130_fd_pr__pfet_01v8_lvt l=0.6 w=1.4 as=0.406
+ ad=0.406 ps=3.38 pd=3.38
X$91 VDD \$17 \$365 VDD sky130_fd_pr__pfet_01v8_lvt l=0.6 w=1.4 as=0.406
+ ad=0.406 ps=3.38 pd=3.38
X$92 VDD \$17 \$408 VDD sky130_fd_pr__pfet_01v8_lvt l=0.6 w=1.4 as=0.406
+ ad=0.406 ps=3.38 pd=3.38
X$93 VDD \$17 \$365 VDD sky130_fd_pr__pfet_01v8_lvt l=0.6 w=1.4 as=0.406
+ ad=0.406 ps=3.38 pd=3.38
X$94 VDD \$17 \$408 VDD sky130_fd_pr__pfet_01v8_lvt l=0.6 w=1.4 as=0.406
+ ad=0.406 ps=3.38 pd=3.38
X$95 VDD \$17 \$365 VDD sky130_fd_pr__pfet_01v8_lvt l=0.6 w=1.4 as=0.406
+ ad=0.406 ps=3.38 pd=3.38
X$96 VDD \$17 \$408 VDD sky130_fd_pr__pfet_01v8_lvt l=0.6 w=1.4 as=0.406
+ ad=0.406 ps=3.38 pd=3.38
X$97 VDD VDD VDD VDD sky130_fd_pr__pfet_01v8_lvt l=0.6 w=1.4 as=0.406 ad=0.406
+ ps=3.38 pd=3.38
X$98 VDD VDD VDD VDD sky130_fd_pr__pfet_01v8_lvt l=0.6 w=1.4 as=0.406 ad=0.406
+ ps=3.38 pd=3.38
X$99 VDD \$17 \$408 VDD sky130_fd_pr__pfet_01v8_lvt l=0.6 w=1.4 as=0.406
+ ad=0.406 ps=3.38 pd=3.38
X$100 VDD \$17 \$365 VDD sky130_fd_pr__pfet_01v8_lvt l=0.6 w=1.4 as=0.406
+ ad=0.406 ps=3.38 pd=3.38
X$101 VDD \$17 \$408 VDD sky130_fd_pr__pfet_01v8_lvt l=0.6 w=1.4 as=0.406
+ ad=0.406 ps=3.38 pd=3.38
X$102 VDD \$17 \$365 VDD sky130_fd_pr__pfet_01v8_lvt l=0.6 w=1.4 as=0.406
+ ad=0.406 ps=3.38 pd=3.38
X$103 VDD \$17 \$408 VDD sky130_fd_pr__pfet_01v8_lvt l=0.6 w=1.4 as=0.406
+ ad=0.406 ps=3.38 pd=3.38
X$104 VDD \$17 \$365 VDD sky130_fd_pr__pfet_01v8_lvt l=0.6 w=1.4 as=0.406
+ ad=0.406 ps=3.38 pd=3.38
X$105 VDD VDD \$586 VDD sky130_fd_pr__pfet_01v8 l=0.6 w=1.4 as=0.406 ad=0.406
+ ps=3.38 pd=3.38
X$106 VDD VDD \$586 VDD sky130_fd_pr__pfet_01v8 l=0.6 w=1.4 as=0.406 ad=0.406
+ ps=3.38 pd=3.38
X$107 VDD VDD \$536 VDD sky130_fd_pr__pfet_01v8 l=0.6 w=1.4 as=0.406 ad=0.406
+ ps=3.38 pd=3.38
X$108 VDD VDD \$536 VDD sky130_fd_pr__pfet_01v8 l=0.6 w=1.4 as=0.406 ad=0.406
+ ps=3.38 pd=3.38
X$109 \$536 \$536 \$536 VDD sky130_fd_pr__pfet_01v8 l=0.6 w=1.4 as=0.406
+ ad=0.406 ps=3.38 pd=3.38
X$110 \$536 \$536 \$536 VDD sky130_fd_pr__pfet_01v8 l=0.6 w=1.4 as=0.406
+ ad=0.406 ps=3.38 pd=3.38
X$111 \$586 \$586 \$586 VDD sky130_fd_pr__pfet_01v8 l=0.6 w=1.4 as=0.406
+ ad=0.406 ps=3.38 pd=3.38
X$112 \$586 \$586 \$586 VDD sky130_fd_pr__pfet_01v8 l=0.6 w=1.4 as=0.406
+ ad=0.406 ps=3.38 pd=3.38
X$113 VDD VDD cm VDD sky130_fd_pr__pfet_01v8 l=0.6 w=1.4 as=0.406 ad=0.406
+ ps=3.38 pd=3.38
X$114 VDD VDD cm VDD sky130_fd_pr__pfet_01v8 l=0.6 w=1.4 as=0.406 ad=0.406
+ ps=3.38 pd=3.38
X$115 \$365 \$365 \$365 VDD sky130_fd_pr__pfet_01v8 l=0.6 w=1.4 as=0.406
+ ad=0.406 ps=3.38 pd=3.38
X$116 \$365 \$365 \$365 VDD sky130_fd_pr__pfet_01v8 l=0.6 w=1.4 as=0.406
+ ad=0.406 ps=3.38 pd=3.38
X$117 \$408 \$408 \$408 VDD sky130_fd_pr__pfet_01v8 l=0.6 w=1.4 as=0.406
+ ad=0.406 ps=3.38 pd=3.38
X$118 \$408 \$408 \$408 VDD sky130_fd_pr__pfet_01v8 l=0.6 w=1.4 as=0.406
+ ad=0.406 ps=3.38 pd=3.38
X$119 VDD VDD \$247 VDD sky130_fd_pr__pfet_01v8 l=0.6 w=1.4 as=0.406 ad=0.406
+ ps=3.38 pd=3.38
X$120 VDD VDD \$247 VDD sky130_fd_pr__pfet_01v8 l=0.6 w=1.4 as=0.406 ad=0.406
+ ps=3.38 pd=3.38
X$121 VDD VDD \$17 VDD sky130_fd_pr__pfet_01v8 l=0.6 w=1.4 as=0.406 ad=0.406
+ ps=3.38 pd=3.38
X$122 VDD VDD \$17 VDD sky130_fd_pr__pfet_01v8 l=0.6 w=1.4 as=0.406 ad=0.406
+ ps=3.38 pd=3.38
X$123 VDD VDD \$340 VDD sky130_fd_pr__pfet_01v8 l=0.6 w=1.4 as=0.406 ad=0.406
+ ps=3.38 pd=3.38
X$124 VDD VDD \$340 VDD sky130_fd_pr__pfet_01v8 l=0.6 w=1.4 as=0.406 ad=0.406
+ ps=3.38 pd=3.38
X$125 \$16 \$17 \$17 sky130_gnd sky130_fd_pr__nfet_01v8_lvt l=0.6 w=1.4
+ as=0.406 ad=0.406 ps=3.38 pd=3.38
X$126 \$16 \$17 \$17 sky130_gnd sky130_fd_pr__nfet_01v8_lvt l=0.6 w=1.4
+ as=0.406 ad=0.406 ps=3.38 pd=3.38
X$127 \$16 \$17 \$17 sky130_gnd sky130_fd_pr__nfet_01v8_lvt l=0.6 w=1.4
+ as=0.406 ad=0.406 ps=3.38 pd=3.38
X$128 \$16 \$17 \$17 sky130_gnd sky130_fd_pr__nfet_01v8_lvt l=0.6 w=1.4
+ as=0.406 ad=0.406 ps=3.38 pd=3.38
X$129 \$16 \$17 \$17 sky130_gnd sky130_fd_pr__nfet_01v8_lvt l=0.6 w=1.4
+ as=0.406 ad=0.406 ps=3.38 pd=3.38
X$130 \$16 \$17 \$17 sky130_gnd sky130_fd_pr__nfet_01v8_lvt l=0.6 w=1.4
+ as=0.406 ad=0.406 ps=3.38 pd=3.38
X$131 \$16 \$17 \$17 sky130_gnd sky130_fd_pr__nfet_01v8_lvt l=0.6 w=1.4
+ as=0.406 ad=0.406 ps=3.38 pd=3.38
X$132 \$16 \$17 \$17 sky130_gnd sky130_fd_pr__nfet_01v8_lvt l=0.6 w=1.4
+ as=0.406 ad=0.406 ps=3.38 pd=3.38
X$133 \$16 \$17 \$17 sky130_gnd sky130_fd_pr__nfet_01v8_lvt l=0.6 w=1.4
+ as=0.406 ad=0.406 ps=3.38 pd=3.38
X$134 \$16 \$17 \$17 sky130_gnd sky130_fd_pr__nfet_01v8_lvt l=0.6 w=1.4
+ as=0.406 ad=0.406 ps=3.38 pd=3.38
X$135 \$16 \$17 \$17 sky130_gnd sky130_fd_pr__nfet_01v8_lvt l=0.6 w=1.4
+ as=0.406 ad=0.406 ps=3.38 pd=3.38
X$136 \$16 \$17 \$17 sky130_gnd sky130_fd_pr__nfet_01v8_lvt l=0.6 w=1.4
+ as=0.406 ad=0.406 ps=3.38 pd=3.38
X$137 \$16 \$17 \$17 sky130_gnd sky130_fd_pr__nfet_01v8_lvt l=0.6 w=1.4
+ as=0.406 ad=0.406 ps=3.38 pd=3.38
X$138 \$16 \$17 \$17 sky130_gnd sky130_fd_pr__nfet_01v8_lvt l=0.6 w=1.4
+ as=0.406 ad=0.406 ps=3.38 pd=3.38
X$139 \$16 \$17 \$17 sky130_gnd sky130_fd_pr__nfet_01v8_lvt l=0.6 w=1.4
+ as=0.406 ad=0.406 ps=3.38 pd=3.38
X$140 \$16 \$17 \$17 sky130_gnd sky130_fd_pr__nfet_01v8_lvt l=0.6 w=1.4
+ as=0.406 ad=0.406 ps=3.38 pd=3.38
X$141 \$16 \$17 \$17 sky130_gnd sky130_fd_pr__nfet_01v8_lvt l=0.6 w=1.4
+ as=0.406 ad=0.406 ps=3.38 pd=3.38
X$142 \$16 \$17 \$17 sky130_gnd sky130_fd_pr__nfet_01v8_lvt l=0.6 w=1.4
+ as=0.406 ad=0.406 ps=3.38 pd=3.38
X$143 \$16 \$17 \$17 sky130_gnd sky130_fd_pr__nfet_01v8_lvt l=0.6 w=1.4
+ as=0.406 ad=0.406 ps=3.38 pd=3.38
X$144 \$16 \$17 \$17 sky130_gnd sky130_fd_pr__nfet_01v8_lvt l=0.6 w=1.4
+ as=0.406 ad=0.406 ps=3.38 pd=3.38
X$145 \$16 \$17 \$17 sky130_gnd sky130_fd_pr__nfet_01v8_lvt l=0.6 w=1.4
+ as=0.406 ad=0.406 ps=3.38 pd=3.38
X$146 \$16 \$17 \$17 sky130_gnd sky130_fd_pr__nfet_01v8_lvt l=0.6 w=1.4
+ as=0.406 ad=0.406 ps=3.38 pd=3.38
X$147 \$16 \$17 \$17 sky130_gnd sky130_fd_pr__nfet_01v8_lvt l=0.6 w=1.4
+ as=0.406 ad=0.406 ps=3.38 pd=3.38
X$148 \$16 \$17 \$17 sky130_gnd sky130_fd_pr__nfet_01v8_lvt l=0.6 w=1.4
+ as=0.406 ad=0.406 ps=3.38 pd=3.38
X$149 \$16 \$17 \$17 sky130_gnd sky130_fd_pr__nfet_01v8_lvt l=0.6 w=1.4
+ as=0.406 ad=0.406 ps=3.38 pd=3.38
X$150 \$16 \$17 \$17 sky130_gnd sky130_fd_pr__nfet_01v8_lvt l=0.6 w=1.4
+ as=0.406 ad=0.406 ps=3.38 pd=3.38
X$151 \$16 \$17 \$17 sky130_gnd sky130_fd_pr__nfet_01v8_lvt l=0.6 w=1.4
+ as=0.406 ad=0.406 ps=3.38 pd=3.38
X$152 \$16 \$17 \$17 sky130_gnd sky130_fd_pr__nfet_01v8_lvt l=0.6 w=1.4
+ as=0.406 ad=0.406 ps=3.38 pd=3.38
X$153 \$16 \$17 \$17 sky130_gnd sky130_fd_pr__nfet_01v8_lvt l=0.6 w=1.4
+ as=0.406 ad=0.406 ps=3.38 pd=3.38
X$154 \$16 \$17 \$17 sky130_gnd sky130_fd_pr__nfet_01v8_lvt l=0.6 w=1.4
+ as=0.406 ad=0.406 ps=3.38 pd=3.38
X$155 \$16 \$17 \$17 sky130_gnd sky130_fd_pr__nfet_01v8_lvt l=0.6 w=1.4
+ as=0.406 ad=0.406 ps=3.38 pd=3.38
X$156 \$16 \$17 \$17 sky130_gnd sky130_fd_pr__nfet_01v8_lvt l=0.6 w=1.4
+ as=0.406 ad=0.406 ps=3.38 pd=3.38
X$157 \$16 \$17 \$17 sky130_gnd sky130_fd_pr__nfet_01v8_lvt l=0.6 w=1.4
+ as=0.406 ad=0.406 ps=3.38 pd=3.38
X$158 \$16 \$17 \$17 sky130_gnd sky130_fd_pr__nfet_01v8_lvt l=0.6 w=1.4
+ as=0.406 ad=0.406 ps=3.38 pd=3.38
X$159 \$16 \$17 \$17 sky130_gnd sky130_fd_pr__nfet_01v8_lvt l=0.6 w=1.4
+ as=0.406 ad=0.406 ps=3.38 pd=3.38
X$160 \$16 \$17 \$17 sky130_gnd sky130_fd_pr__nfet_01v8_lvt l=0.6 w=1.4
+ as=0.406 ad=0.406 ps=3.38 pd=3.38
X$161 \$16 \$17 \$17 sky130_gnd sky130_fd_pr__nfet_01v8_lvt l=0.6 w=1.4
+ as=0.406 ad=0.406 ps=3.38 pd=3.38
X$162 \$16 \$17 \$17 sky130_gnd sky130_fd_pr__nfet_01v8_lvt l=0.6 w=1.4
+ as=0.406 ad=0.406 ps=3.38 pd=3.38
X$163 \$16 \$17 \$17 sky130_gnd sky130_fd_pr__nfet_01v8_lvt l=0.6 w=1.4
+ as=0.406 ad=0.406 ps=3.38 pd=3.38
X$164 \$16 \$17 \$17 sky130_gnd sky130_fd_pr__nfet_01v8_lvt l=0.6 w=1.4
+ as=0.406 ad=0.406 ps=3.38 pd=3.38
X$165 \$16 \$17 \$17 sky130_gnd sky130_fd_pr__nfet_01v8_lvt l=0.6 w=1.4
+ as=0.406 ad=0.406 ps=3.38 pd=3.38
X$166 \$16 \$17 \$17 sky130_gnd sky130_fd_pr__nfet_01v8_lvt l=0.6 w=1.4
+ as=0.406 ad=0.406 ps=3.38 pd=3.38
X$167 \$16 \$17 \$17 sky130_gnd sky130_fd_pr__nfet_01v8_lvt l=0.6 w=1.4
+ as=0.406 ad=0.406 ps=3.38 pd=3.38
X$168 \$16 \$17 \$17 sky130_gnd sky130_fd_pr__nfet_01v8_lvt l=0.6 w=1.4
+ as=0.406 ad=0.406 ps=3.38 pd=3.38
X$169 \$16 \$17 \$17 sky130_gnd sky130_fd_pr__nfet_01v8_lvt l=0.6 w=1.4
+ as=0.406 ad=0.406 ps=3.38 pd=3.38
X$170 \$16 \$17 \$17 sky130_gnd sky130_fd_pr__nfet_01v8_lvt l=0.6 w=1.4
+ as=0.406 ad=0.406 ps=3.38 pd=3.38
X$171 \$16 \$17 \$17 sky130_gnd sky130_fd_pr__nfet_01v8_lvt l=0.6 w=1.4
+ as=0.406 ad=0.406 ps=3.38 pd=3.38
X$172 \$16 \$17 \$17 sky130_gnd sky130_fd_pr__nfet_01v8_lvt l=0.6 w=1.4
+ as=0.406 ad=0.406 ps=3.38 pd=3.38
X$173 \$16 \$17 \$17 sky130_gnd sky130_fd_pr__nfet_01v8_lvt l=0.6 w=1.4
+ as=0.406 ad=0.406 ps=3.38 pd=3.38
X$174 \$16 \$17 \$17 sky130_gnd sky130_fd_pr__nfet_01v8_lvt l=0.6 w=1.4
+ as=0.406 ad=0.406 ps=3.38 pd=3.38
X$175 \$16 \$17 \$17 sky130_gnd sky130_fd_pr__nfet_01v8_lvt l=0.6 w=1.4
+ as=0.406 ad=0.406 ps=3.38 pd=3.38
X$176 \$16 \$17 \$17 sky130_gnd sky130_fd_pr__nfet_01v8_lvt l=0.6 w=1.4
+ as=0.406 ad=0.406 ps=3.38 pd=3.38
X$177 \$16 \$17 \$17 sky130_gnd sky130_fd_pr__nfet_01v8_lvt l=0.6 w=1.4
+ as=0.406 ad=0.406 ps=3.38 pd=3.38
X$178 \$16 \$17 \$17 sky130_gnd sky130_fd_pr__nfet_01v8_lvt l=0.6 w=1.4
+ as=0.406 ad=0.406 ps=3.38 pd=3.38
X$179 \$16 \$17 \$17 sky130_gnd sky130_fd_pr__nfet_01v8_lvt l=0.6 w=1.4
+ as=0.406 ad=0.406 ps=3.38 pd=3.38
X$180 \$16 \$17 \$17 sky130_gnd sky130_fd_pr__nfet_01v8_lvt l=0.6 w=1.4
+ as=0.406 ad=0.406 ps=3.38 pd=3.38
X$181 VDD VDD VDD VDD sky130_fd_pr__pfet_01v8 l=0.6 w=1.4 as=0.406 ad=0.406
+ ps=3.38 pd=3.38
X$182 \$586 \$16 op VDD sky130_fd_pr__pfet_01v8 l=0.6 w=1.4 as=0.406 ad=0.406
+ ps=3.38 pd=3.38
X$183 \$536 \$16 on VDD sky130_fd_pr__pfet_01v8 l=0.6 w=1.4 as=0.406 ad=0.406
+ ps=3.38 pd=3.38
X$184 \$586 \$16 op VDD sky130_fd_pr__pfet_01v8 l=0.6 w=1.4 as=0.406 ad=0.406
+ ps=3.38 pd=3.38
X$185 \$536 \$16 on VDD sky130_fd_pr__pfet_01v8 l=0.6 w=1.4 as=0.406 ad=0.406
+ ps=3.38 pd=3.38
X$186 \$586 \$16 op VDD sky130_fd_pr__pfet_01v8 l=0.6 w=1.4 as=0.406 ad=0.406
+ ps=3.38 pd=3.38
X$187 \$536 \$16 on VDD sky130_fd_pr__pfet_01v8 l=0.6 w=1.4 as=0.406 ad=0.406
+ ps=3.38 pd=3.38
X$188 \$586 \$16 op VDD sky130_fd_pr__pfet_01v8 l=0.6 w=1.4 as=0.406 ad=0.406
+ ps=3.38 pd=3.38
X$189 \$536 \$16 on VDD sky130_fd_pr__pfet_01v8 l=0.6 w=1.4 as=0.406 ad=0.406
+ ps=3.38 pd=3.38
X$190 \$586 \$16 op VDD sky130_fd_pr__pfet_01v8 l=0.6 w=1.4 as=0.406 ad=0.406
+ ps=3.38 pd=3.38
X$191 \$586 \$16 op VDD sky130_fd_pr__pfet_01v8 l=0.6 w=1.4 as=0.406 ad=0.406
+ ps=3.38 pd=3.38
X$192 \$536 \$16 on VDD sky130_fd_pr__pfet_01v8 l=0.6 w=1.4 as=0.406 ad=0.406
+ ps=3.38 pd=3.38
X$193 \$586 \$16 op VDD sky130_fd_pr__pfet_01v8 l=0.6 w=1.4 as=0.406 ad=0.406
+ ps=3.38 pd=3.38
X$194 \$536 \$16 on VDD sky130_fd_pr__pfet_01v8 l=0.6 w=1.4 as=0.406 ad=0.406
+ ps=3.38 pd=3.38
X$195 \$586 \$16 op VDD sky130_fd_pr__pfet_01v8 l=0.6 w=1.4 as=0.406 ad=0.406
+ ps=3.38 pd=3.38
X$196 \$536 \$16 on VDD sky130_fd_pr__pfet_01v8 l=0.6 w=1.4 as=0.406 ad=0.406
+ ps=3.38 pd=3.38
X$197 \$586 \$16 op VDD sky130_fd_pr__pfet_01v8 l=0.6 w=1.4 as=0.406 ad=0.406
+ ps=3.38 pd=3.38
X$198 \$536 \$16 on VDD sky130_fd_pr__pfet_01v8 l=0.6 w=1.4 as=0.406 ad=0.406
+ ps=3.38 pd=3.38
X$199 \$586 \$16 op VDD sky130_fd_pr__pfet_01v8 l=0.6 w=1.4 as=0.406 ad=0.406
+ ps=3.38 pd=3.38
X$200 \$536 \$16 on VDD sky130_fd_pr__pfet_01v8 l=0.6 w=1.4 as=0.406 ad=0.406
+ ps=3.38 pd=3.38
X$201 \$536 \$16 on VDD sky130_fd_pr__pfet_01v8 l=0.6 w=1.4 as=0.406 ad=0.406
+ ps=3.38 pd=3.38
X$202 VDD VDD VDD VDD sky130_fd_pr__pfet_01v8 l=0.6 w=1.4 as=0.406 ad=0.406
+ ps=3.38 pd=3.38
X$203 \$586 \$16 op VDD sky130_fd_pr__pfet_01v8 l=0.6 w=1.4 as=0.406 ad=0.406
+ ps=3.38 pd=3.38
X$204 \$536 \$16 on VDD sky130_fd_pr__pfet_01v8 l=0.6 w=1.4 as=0.406 ad=0.406
+ ps=3.38 pd=3.38
X$205 \$586 \$16 op VDD sky130_fd_pr__pfet_01v8 l=0.6 w=1.4 as=0.406 ad=0.406
+ ps=3.38 pd=3.38
X$206 \$536 \$16 on VDD sky130_fd_pr__pfet_01v8 l=0.6 w=1.4 as=0.406 ad=0.406
+ ps=3.38 pd=3.38
X$207 \$586 \$16 op VDD sky130_fd_pr__pfet_01v8 l=0.6 w=1.4 as=0.406 ad=0.406
+ ps=3.38 pd=3.38
X$208 \$536 \$16 on VDD sky130_fd_pr__pfet_01v8 l=0.6 w=1.4 as=0.406 ad=0.406
+ ps=3.38 pd=3.38
X$209 \$586 \$16 op VDD sky130_fd_pr__pfet_01v8 l=0.6 w=1.4 as=0.406 ad=0.406
+ ps=3.38 pd=3.38
X$210 \$536 \$16 on VDD sky130_fd_pr__pfet_01v8 l=0.6 w=1.4 as=0.406 ad=0.406
+ ps=3.38 pd=3.38
X$211 \$536 \$16 on VDD sky130_fd_pr__pfet_01v8 l=0.6 w=1.4 as=0.406 ad=0.406
+ ps=3.38 pd=3.38
X$212 \$536 \$16 on VDD sky130_fd_pr__pfet_01v8 l=0.6 w=1.4 as=0.406 ad=0.406
+ ps=3.38 pd=3.38
X$213 \$586 \$16 op VDD sky130_fd_pr__pfet_01v8 l=0.6 w=1.4 as=0.406 ad=0.406
+ ps=3.38 pd=3.38
X$214 \$536 \$16 on VDD sky130_fd_pr__pfet_01v8 l=0.6 w=1.4 as=0.406 ad=0.406
+ ps=3.38 pd=3.38
X$215 \$586 \$16 op VDD sky130_fd_pr__pfet_01v8 l=0.6 w=1.4 as=0.406 ad=0.406
+ ps=3.38 pd=3.38
X$216 \$536 \$16 on VDD sky130_fd_pr__pfet_01v8 l=0.6 w=1.4 as=0.406 ad=0.406
+ ps=3.38 pd=3.38
X$217 \$586 \$16 op VDD sky130_fd_pr__pfet_01v8 l=0.6 w=1.4 as=0.406 ad=0.406
+ ps=3.38 pd=3.38
X$218 \$536 \$16 on VDD sky130_fd_pr__pfet_01v8 l=0.6 w=1.4 as=0.406 ad=0.406
+ ps=3.38 pd=3.38
X$219 \$586 \$16 op VDD sky130_fd_pr__pfet_01v8 l=0.6 w=1.4 as=0.406 ad=0.406
+ ps=3.38 pd=3.38
X$220 \$536 \$16 on VDD sky130_fd_pr__pfet_01v8 l=0.6 w=1.4 as=0.406 ad=0.406
+ ps=3.38 pd=3.38
X$221 \$586 \$16 op VDD sky130_fd_pr__pfet_01v8 l=0.6 w=1.4 as=0.406 ad=0.406
+ ps=3.38 pd=3.38
X$222 \$586 \$16 op VDD sky130_fd_pr__pfet_01v8 l=0.6 w=1.4 as=0.406 ad=0.406
+ ps=3.38 pd=3.38
X$223 VDD VDD VDD VDD sky130_fd_pr__pfet_01v8 l=0.6 w=1.4 as=0.406 ad=0.406
+ ps=3.38 pd=3.38
X$224 \$365 \$16 \$247 VDD sky130_fd_pr__pfet_01v8 l=0.6 w=1.4 as=0.406
+ ad=0.406 ps=3.38 pd=3.38
X$225 \$408 \$16 \$17 VDD sky130_fd_pr__pfet_01v8 l=0.6 w=1.4 as=0.406 ad=0.406
+ ps=3.38 pd=3.38
X$226 \$365 \$16 \$247 VDD sky130_fd_pr__pfet_01v8 l=0.6 w=1.4 as=0.406
+ ad=0.406 ps=3.38 pd=3.38
X$227 \$408 \$16 \$17 VDD sky130_fd_pr__pfet_01v8 l=0.6 w=1.4 as=0.406 ad=0.406
+ ps=3.38 pd=3.38
X$228 \$365 \$16 \$247 VDD sky130_fd_pr__pfet_01v8 l=0.6 w=1.4 as=0.406
+ ad=0.406 ps=3.38 pd=3.38
X$229 \$408 \$16 \$17 VDD sky130_fd_pr__pfet_01v8 l=0.6 w=1.4 as=0.406 ad=0.406
+ ps=3.38 pd=3.38
X$230 VDD VDD VDD VDD sky130_fd_pr__pfet_01v8 l=0.6 w=1.4 as=0.406 ad=0.406
+ ps=3.38 pd=3.38
X$231 \$408 \$16 \$17 VDD sky130_fd_pr__pfet_01v8 l=0.6 w=1.4 as=0.406 ad=0.406
+ ps=3.38 pd=3.38
X$232 \$365 \$16 \$247 VDD sky130_fd_pr__pfet_01v8 l=0.6 w=1.4 as=0.406
+ ad=0.406 ps=3.38 pd=3.38
X$233 \$408 \$16 \$17 VDD sky130_fd_pr__pfet_01v8 l=0.6 w=1.4 as=0.406 ad=0.406
+ ps=3.38 pd=3.38
X$234 \$365 \$16 \$247 VDD sky130_fd_pr__pfet_01v8 l=0.6 w=1.4 as=0.406
+ ad=0.406 ps=3.38 pd=3.38
X$235 \$408 \$16 \$17 VDD sky130_fd_pr__pfet_01v8 l=0.6 w=1.4 as=0.406 ad=0.406
+ ps=3.38 pd=3.38
X$236 \$365 \$16 \$247 VDD sky130_fd_pr__pfet_01v8 l=0.6 w=1.4 as=0.406
+ ad=0.406 ps=3.38 pd=3.38
X$237 \$340 \$16 cm VDD sky130_fd_pr__pfet_01v8 l=0.6 w=1.4 as=0.406 ad=0.406
+ ps=3.38 pd=3.38
X$238 \$340 \$16 cm VDD sky130_fd_pr__pfet_01v8 l=0.6 w=1.4 as=0.406 ad=0.406
+ ps=3.38 pd=3.38
X$239 \$340 \$16 cm VDD sky130_fd_pr__pfet_01v8 l=0.6 w=1.4 as=0.406 ad=0.406
+ ps=3.38 pd=3.38
X$240 \$340 \$16 cm VDD sky130_fd_pr__pfet_01v8 l=0.6 w=1.4 as=0.406 ad=0.406
+ ps=3.38 pd=3.38
X$241 \$340 \$16 cm VDD sky130_fd_pr__pfet_01v8 l=0.6 w=1.4 as=0.406 ad=0.406
+ ps=3.38 pd=3.38
X$242 \$340 \$16 cm VDD sky130_fd_pr__pfet_01v8 l=0.6 w=1.4 as=0.406 ad=0.406
+ ps=3.38 pd=3.38
X$243 VDD VDD VDD VDD sky130_fd_pr__pfet_01v8 l=0.6 w=1.4 as=0.406 ad=0.406
+ ps=3.38 pd=3.38
X$244 VDD VDD VDD VDD sky130_fd_pr__pfet_01v8 l=0.6 w=1.4 as=0.406 ad=0.406
+ ps=3.38 pd=3.38
X$245 VDD VDD VDD VDD sky130_fd_pr__pfet_01v8 l=0.6 w=1.4 as=0.406 ad=0.406
+ ps=3.38 pd=3.38
X$246 VDD VDD VDD VDD sky130_fd_pr__pfet_01v8 l=0.6 w=1.4 as=0.406 ad=0.406
+ ps=3.38 pd=3.38
X$247 VDD VDD VDD VDD sky130_fd_pr__pfet_01v8 l=0.6 w=1.4 as=0.406 ad=0.406
+ ps=3.38 pd=3.38
X$248 VDD VDD VDD VDD sky130_fd_pr__pfet_01v8 l=0.6 w=1.4 as=0.406 ad=0.406
+ ps=3.38 pd=3.38
X$249 \$340 \$340 \$340 VDD sky130_fd_pr__pfet_01v8_lvt l=0.6 w=1.4 as=0.406
+ ad=0.406 ps=3.38 pd=3.38
X$250 \$340 \$340 \$340 VDD sky130_fd_pr__pfet_01v8_lvt l=0.6 w=1.4 as=0.406
+ ad=0.406 ps=3.38 pd=3.38
X$251 \$365 \$365 \$365 VDD sky130_fd_pr__pfet_01v8_lvt l=0.6 w=1.4 as=0.406
+ ad=0.406 ps=3.38 pd=3.38
X$252 \$365 \$365 \$365 VDD sky130_fd_pr__pfet_01v8_lvt l=0.6 w=1.4 as=0.406
+ ad=0.406 ps=3.38 pd=3.38
X$253 \$408 \$408 \$408 VDD sky130_fd_pr__pfet_01v8_lvt l=0.6 w=1.4 as=0.406
+ ad=0.406 ps=3.38 pd=3.38
X$254 \$408 \$408 \$408 VDD sky130_fd_pr__pfet_01v8_lvt l=0.6 w=1.4 as=0.406
+ ad=0.406 ps=3.38 pd=3.38
X$255 VDD VDD VDD VDD sky130_fd_pr__pfet_01v8_lvt l=0.6 w=1.4 as=0.406 ad=0.406
+ ps=3.38 pd=3.38
X$256 VDD VDD VDD VDD sky130_fd_pr__pfet_01v8_lvt l=0.6 w=1.4 as=0.406 ad=0.406
+ ps=3.38 pd=3.38
X$257 VDD VDD VDD VDD sky130_fd_pr__pfet_01v8_lvt l=0.6 w=1.4 as=0.406 ad=0.406
+ ps=3.38 pd=3.38
X$258 VDD VDD VDD VDD sky130_fd_pr__pfet_01v8_lvt l=0.6 w=1.4 as=0.406 ad=0.406
+ ps=3.38 pd=3.38
X$259 VDD VDD VDD VDD sky130_fd_pr__pfet_01v8_lvt l=0.6 w=1.4 as=0.406 ad=0.406
+ ps=3.38 pd=3.38
X$260 VDD VDD VDD VDD sky130_fd_pr__pfet_01v8_lvt l=0.6 w=1.4 as=0.406 ad=0.406
+ ps=3.38 pd=3.38
X$261 VDD VDD VDD VDD sky130_fd_pr__pfet_01v8_lvt l=0.6 w=1.4 as=0.406 ad=0.406
+ ps=3.38 pd=3.38
X$262 VDD VDD VDD VDD sky130_fd_pr__pfet_01v8_lvt l=0.6 w=1.4 as=0.406 ad=0.406
+ ps=3.38 pd=3.38
X$263 \$621 \$19 on sky130_gnd sky130_fd_pr__nfet_01v8 l=0.6 w=1.4 as=0.406
+ ad=0.406 ps=3.38 pd=3.38
X$264 \$621 \$19 on sky130_gnd sky130_fd_pr__nfet_01v8 l=0.6 w=1.4 as=0.406
+ ad=0.406 ps=3.38 pd=3.38
X$265 \$621 \$19 on sky130_gnd sky130_fd_pr__nfet_01v8 l=0.6 w=1.4 as=0.406
+ ad=0.406 ps=3.38 pd=3.38
X$266 \$621 \$19 on sky130_gnd sky130_fd_pr__nfet_01v8 l=0.6 w=1.4 as=0.406
+ ad=0.406 ps=3.38 pd=3.38
X$267 \$621 \$19 on sky130_gnd sky130_fd_pr__nfet_01v8 l=0.6 w=1.4 as=0.406
+ ad=0.406 ps=3.38 pd=3.38
X$268 \$621 \$19 on sky130_gnd sky130_fd_pr__nfet_01v8 l=0.6 w=1.4 as=0.406
+ ad=0.406 ps=3.38 pd=3.38
X$269 \$621 \$19 on sky130_gnd sky130_fd_pr__nfet_01v8 l=0.6 w=1.4 as=0.406
+ ad=0.406 ps=3.38 pd=3.38
X$270 \$621 \$19 on sky130_gnd sky130_fd_pr__nfet_01v8 l=0.6 w=1.4 as=0.406
+ ad=0.406 ps=3.38 pd=3.38
X$271 \$621 \$19 on sky130_gnd sky130_fd_pr__nfet_01v8 l=0.6 w=1.4 as=0.406
+ ad=0.406 ps=3.38 pd=3.38
X$272 \$621 \$19 on sky130_gnd sky130_fd_pr__nfet_01v8 l=0.6 w=1.4 as=0.406
+ ad=0.406 ps=3.38 pd=3.38
X$273 \$621 \$19 on sky130_gnd sky130_fd_pr__nfet_01v8 l=0.6 w=1.4 as=0.406
+ ad=0.406 ps=3.38 pd=3.38
X$274 \$621 \$19 on sky130_gnd sky130_fd_pr__nfet_01v8 l=0.6 w=1.4 as=0.406
+ ad=0.406 ps=3.38 pd=3.38
X$275 \$621 \$19 on sky130_gnd sky130_fd_pr__nfet_01v8 l=0.6 w=1.4 as=0.406
+ ad=0.406 ps=3.38 pd=3.38
X$276 \$621 \$19 on sky130_gnd sky130_fd_pr__nfet_01v8 l=0.6 w=1.4 as=0.406
+ ad=0.406 ps=3.38 pd=3.38
X$277 \$621 \$19 on sky130_gnd sky130_fd_pr__nfet_01v8 l=0.6 w=1.4 as=0.406
+ ad=0.406 ps=3.38 pd=3.38
X$278 \$621 \$19 on sky130_gnd sky130_fd_pr__nfet_01v8 l=0.6 w=1.4 as=0.406
+ ad=0.406 ps=3.38 pd=3.38
X$279 \$621 \$19 on sky130_gnd sky130_fd_pr__nfet_01v8 l=0.6 w=1.4 as=0.406
+ ad=0.406 ps=3.38 pd=3.38
X$280 \$621 \$19 on sky130_gnd sky130_fd_pr__nfet_01v8 l=0.6 w=1.4 as=0.406
+ ad=0.406 ps=3.38 pd=3.38
X$281 \$621 \$19 on sky130_gnd sky130_fd_pr__nfet_01v8 l=0.6 w=1.4 as=0.406
+ ad=0.406 ps=3.38 pd=3.38
X$282 \$621 \$19 on sky130_gnd sky130_fd_pr__nfet_01v8 l=0.6 w=1.4 as=0.406
+ ad=0.406 ps=3.38 pd=3.38
X$283 \$621 \$19 on sky130_gnd sky130_fd_pr__nfet_01v8 l=0.6 w=1.4 as=0.406
+ ad=0.406 ps=3.38 pd=3.38
X$284 \$621 \$19 on sky130_gnd sky130_fd_pr__nfet_01v8 l=0.6 w=1.4 as=0.406
+ ad=0.406 ps=3.38 pd=3.38
X$285 \$621 \$19 on sky130_gnd sky130_fd_pr__nfet_01v8 l=0.6 w=1.4 as=0.406
+ ad=0.406 ps=3.38 pd=3.38
X$286 \$621 \$19 on sky130_gnd sky130_fd_pr__nfet_01v8 l=0.6 w=1.4 as=0.406
+ ad=0.406 ps=3.38 pd=3.38
X$287 \$621 \$19 on sky130_gnd sky130_fd_pr__nfet_01v8 l=0.6 w=1.4 as=0.406
+ ad=0.406 ps=3.38 pd=3.38
X$288 \$621 \$19 on sky130_gnd sky130_fd_pr__nfet_01v8 l=0.6 w=1.4 as=0.406
+ ad=0.406 ps=3.38 pd=3.38
X$289 \$621 \$19 on sky130_gnd sky130_fd_pr__nfet_01v8 l=0.6 w=1.4 as=0.406
+ ad=0.406 ps=3.38 pd=3.38
X$290 \$621 \$19 on sky130_gnd sky130_fd_pr__nfet_01v8 l=0.6 w=1.4 as=0.406
+ ad=0.406 ps=3.38 pd=3.38
X$291 \$621 \$19 on sky130_gnd sky130_fd_pr__nfet_01v8 l=0.6 w=1.4 as=0.406
+ ad=0.406 ps=3.38 pd=3.38
X$292 \$621 \$19 on sky130_gnd sky130_fd_pr__nfet_01v8 l=0.6 w=1.4 as=0.406
+ ad=0.406 ps=3.38 pd=3.38
X$293 \$621 \$19 on sky130_gnd sky130_fd_pr__nfet_01v8 l=0.6 w=1.4 as=0.406
+ ad=0.406 ps=3.38 pd=3.38
X$294 \$621 \$19 on sky130_gnd sky130_fd_pr__nfet_01v8 l=0.6 w=1.4 as=0.406
+ ad=0.406 ps=3.38 pd=3.38
X$295 \$621 \$19 on sky130_gnd sky130_fd_pr__nfet_01v8 l=0.6 w=1.4 as=0.406
+ ad=0.406 ps=3.38 pd=3.38
X$296 \$621 \$19 on sky130_gnd sky130_fd_pr__nfet_01v8 l=0.6 w=1.4 as=0.406
+ ad=0.406 ps=3.38 pd=3.38
X$297 \$621 \$19 on sky130_gnd sky130_fd_pr__nfet_01v8 l=0.6 w=1.4 as=0.406
+ ad=0.406 ps=3.38 pd=3.38
X$298 \$621 \$19 on sky130_gnd sky130_fd_pr__nfet_01v8 l=0.6 w=1.4 as=0.406
+ ad=0.406 ps=3.38 pd=3.38
X$299 \$623 \$19 op sky130_gnd sky130_fd_pr__nfet_01v8 l=0.6 w=1.4 as=0.406
+ ad=0.406 ps=3.38 pd=3.38
X$300 \$623 \$19 op sky130_gnd sky130_fd_pr__nfet_01v8 l=0.6 w=1.4 as=0.406
+ ad=0.406 ps=3.38 pd=3.38
X$301 \$623 \$19 op sky130_gnd sky130_fd_pr__nfet_01v8 l=0.6 w=1.4 as=0.406
+ ad=0.406 ps=3.38 pd=3.38
X$302 \$623 \$19 op sky130_gnd sky130_fd_pr__nfet_01v8 l=0.6 w=1.4 as=0.406
+ ad=0.406 ps=3.38 pd=3.38
X$303 \$623 \$19 op sky130_gnd sky130_fd_pr__nfet_01v8 l=0.6 w=1.4 as=0.406
+ ad=0.406 ps=3.38 pd=3.38
X$304 \$623 \$19 op sky130_gnd sky130_fd_pr__nfet_01v8 l=0.6 w=1.4 as=0.406
+ ad=0.406 ps=3.38 pd=3.38
X$305 \$623 \$19 op sky130_gnd sky130_fd_pr__nfet_01v8 l=0.6 w=1.4 as=0.406
+ ad=0.406 ps=3.38 pd=3.38
X$306 \$623 \$19 op sky130_gnd sky130_fd_pr__nfet_01v8 l=0.6 w=1.4 as=0.406
+ ad=0.406 ps=3.38 pd=3.38
X$307 \$623 \$19 op sky130_gnd sky130_fd_pr__nfet_01v8 l=0.6 w=1.4 as=0.406
+ ad=0.406 ps=3.38 pd=3.38
X$308 \$623 \$19 op sky130_gnd sky130_fd_pr__nfet_01v8 l=0.6 w=1.4 as=0.406
+ ad=0.406 ps=3.38 pd=3.38
X$309 \$623 \$19 op sky130_gnd sky130_fd_pr__nfet_01v8 l=0.6 w=1.4 as=0.406
+ ad=0.406 ps=3.38 pd=3.38
X$310 \$623 \$19 op sky130_gnd sky130_fd_pr__nfet_01v8 l=0.6 w=1.4 as=0.406
+ ad=0.406 ps=3.38 pd=3.38
X$311 \$623 \$19 op sky130_gnd sky130_fd_pr__nfet_01v8 l=0.6 w=1.4 as=0.406
+ ad=0.406 ps=3.38 pd=3.38
X$312 \$623 \$19 op sky130_gnd sky130_fd_pr__nfet_01v8 l=0.6 w=1.4 as=0.406
+ ad=0.406 ps=3.38 pd=3.38
X$313 \$623 \$19 op sky130_gnd sky130_fd_pr__nfet_01v8 l=0.6 w=1.4 as=0.406
+ ad=0.406 ps=3.38 pd=3.38
X$314 \$623 \$19 op sky130_gnd sky130_fd_pr__nfet_01v8 l=0.6 w=1.4 as=0.406
+ ad=0.406 ps=3.38 pd=3.38
X$315 \$623 \$19 op sky130_gnd sky130_fd_pr__nfet_01v8 l=0.6 w=1.4 as=0.406
+ ad=0.406 ps=3.38 pd=3.38
X$316 \$623 \$19 op sky130_gnd sky130_fd_pr__nfet_01v8 l=0.6 w=1.4 as=0.406
+ ad=0.406 ps=3.38 pd=3.38
X$317 \$623 \$19 op sky130_gnd sky130_fd_pr__nfet_01v8 l=0.6 w=1.4 as=0.406
+ ad=0.406 ps=3.38 pd=3.38
X$318 \$623 \$19 op sky130_gnd sky130_fd_pr__nfet_01v8 l=0.6 w=1.4 as=0.406
+ ad=0.406 ps=3.38 pd=3.38
X$319 \$623 \$19 op sky130_gnd sky130_fd_pr__nfet_01v8 l=0.6 w=1.4 as=0.406
+ ad=0.406 ps=3.38 pd=3.38
X$320 \$623 \$19 op sky130_gnd sky130_fd_pr__nfet_01v8 l=0.6 w=1.4 as=0.406
+ ad=0.406 ps=3.38 pd=3.38
X$321 \$623 \$19 op sky130_gnd sky130_fd_pr__nfet_01v8 l=0.6 w=1.4 as=0.406
+ ad=0.406 ps=3.38 pd=3.38
X$322 \$623 \$19 op sky130_gnd sky130_fd_pr__nfet_01v8 l=0.6 w=1.4 as=0.406
+ ad=0.406 ps=3.38 pd=3.38
X$323 \$623 \$19 op sky130_gnd sky130_fd_pr__nfet_01v8 l=0.6 w=1.4 as=0.406
+ ad=0.406 ps=3.38 pd=3.38
X$324 \$623 \$19 op sky130_gnd sky130_fd_pr__nfet_01v8 l=0.6 w=1.4 as=0.406
+ ad=0.406 ps=3.38 pd=3.38
X$325 \$623 \$19 op sky130_gnd sky130_fd_pr__nfet_01v8 l=0.6 w=1.4 as=0.406
+ ad=0.406 ps=3.38 pd=3.38
X$326 \$623 \$19 op sky130_gnd sky130_fd_pr__nfet_01v8 l=0.6 w=1.4 as=0.406
+ ad=0.406 ps=3.38 pd=3.38
X$327 \$623 \$19 op sky130_gnd sky130_fd_pr__nfet_01v8 l=0.6 w=1.4 as=0.406
+ ad=0.406 ps=3.38 pd=3.38
X$328 \$623 \$19 op sky130_gnd sky130_fd_pr__nfet_01v8 l=0.6 w=1.4 as=0.406
+ ad=0.406 ps=3.38 pd=3.38
X$329 \$623 \$19 op sky130_gnd sky130_fd_pr__nfet_01v8 l=0.6 w=1.4 as=0.406
+ ad=0.406 ps=3.38 pd=3.38
X$330 \$623 \$19 op sky130_gnd sky130_fd_pr__nfet_01v8 l=0.6 w=1.4 as=0.406
+ ad=0.406 ps=3.38 pd=3.38
X$331 \$623 \$19 op sky130_gnd sky130_fd_pr__nfet_01v8 l=0.6 w=1.4 as=0.406
+ ad=0.406 ps=3.38 pd=3.38
X$332 \$623 \$19 op sky130_gnd sky130_fd_pr__nfet_01v8 l=0.6 w=1.4 as=0.406
+ ad=0.406 ps=3.38 pd=3.38
X$333 \$623 \$19 op sky130_gnd sky130_fd_pr__nfet_01v8 l=0.6 w=1.4 as=0.406
+ ad=0.406 ps=3.38 pd=3.38
X$334 \$623 \$19 op sky130_gnd sky130_fd_pr__nfet_01v8 l=0.6 w=1.4 as=0.406
+ ad=0.406 ps=3.38 pd=3.38
X$335 VSS VSS VSS sky130_gnd sky130_fd_pr__nfet_01v8 l=0.6 w=1.4 as=0.406
+ ad=0.406 ps=3.38 pd=3.38
X$336 VSS VSS VSS sky130_gnd sky130_fd_pr__nfet_01v8 l=0.6 w=1.4 as=0.406
+ ad=0.406 ps=3.38 pd=3.38
X$337 VSS bias_a \$621 sky130_gnd sky130_fd_pr__nfet_01v8 l=0.6 w=1.4 as=0.406
+ ad=0.406 ps=3.38 pd=3.38
X$338 VSS bias_a \$621 sky130_gnd sky130_fd_pr__nfet_01v8 l=0.6 w=1.4 as=0.406
+ ad=0.406 ps=3.38 pd=3.38
X$339 VSS bias_a \$621 sky130_gnd sky130_fd_pr__nfet_01v8 l=0.6 w=1.4 as=0.406
+ ad=0.406 ps=3.38 pd=3.38
X$340 VSS bias_a \$621 sky130_gnd sky130_fd_pr__nfet_01v8 l=0.6 w=1.4 as=0.406
+ ad=0.406 ps=3.38 pd=3.38
X$341 VSS bias_a \$621 sky130_gnd sky130_fd_pr__nfet_01v8 l=0.6 w=1.4 as=0.406
+ ad=0.406 ps=3.38 pd=3.38
X$342 VSS bias_a \$621 sky130_gnd sky130_fd_pr__nfet_01v8 l=0.6 w=1.4 as=0.406
+ ad=0.406 ps=3.38 pd=3.38
X$343 VSS bias_a \$621 sky130_gnd sky130_fd_pr__nfet_01v8 l=0.6 w=1.4 as=0.406
+ ad=0.406 ps=3.38 pd=3.38
X$344 VSS bias_a \$621 sky130_gnd sky130_fd_pr__nfet_01v8 l=0.6 w=1.4 as=0.406
+ ad=0.406 ps=3.38 pd=3.38
X$345 VSS bias_a \$621 sky130_gnd sky130_fd_pr__nfet_01v8 l=0.6 w=1.4 as=0.406
+ ad=0.406 ps=3.38 pd=3.38
X$346 VSS bias_a \$621 sky130_gnd sky130_fd_pr__nfet_01v8 l=0.6 w=1.4 as=0.406
+ ad=0.406 ps=3.38 pd=3.38
X$347 VSS bias_a \$621 sky130_gnd sky130_fd_pr__nfet_01v8 l=0.6 w=1.4 as=0.406
+ ad=0.406 ps=3.38 pd=3.38
X$348 VSS bias_a \$621 sky130_gnd sky130_fd_pr__nfet_01v8 l=0.6 w=1.4 as=0.406
+ ad=0.406 ps=3.38 pd=3.38
X$349 VSS bias_a \$621 sky130_gnd sky130_fd_pr__nfet_01v8 l=0.6 w=1.4 as=0.406
+ ad=0.406 ps=3.38 pd=3.38
X$350 VSS bias_a \$621 sky130_gnd sky130_fd_pr__nfet_01v8 l=0.6 w=1.4 as=0.406
+ ad=0.406 ps=3.38 pd=3.38
X$351 VSS bias_a \$621 sky130_gnd sky130_fd_pr__nfet_01v8 l=0.6 w=1.4 as=0.406
+ ad=0.406 ps=3.38 pd=3.38
X$352 VSS bias_a \$621 sky130_gnd sky130_fd_pr__nfet_01v8 l=0.6 w=1.4 as=0.406
+ ad=0.406 ps=3.38 pd=3.38
X$353 VSS bias_a \$621 sky130_gnd sky130_fd_pr__nfet_01v8 l=0.6 w=1.4 as=0.406
+ ad=0.406 ps=3.38 pd=3.38
X$354 VSS bias_a \$621 sky130_gnd sky130_fd_pr__nfet_01v8 l=0.6 w=1.4 as=0.406
+ ad=0.406 ps=3.38 pd=3.38
X$355 VSS bias_a \$621 sky130_gnd sky130_fd_pr__nfet_01v8 l=0.6 w=1.4 as=0.406
+ ad=0.406 ps=3.38 pd=3.38
X$356 VSS bias_a \$621 sky130_gnd sky130_fd_pr__nfet_01v8 l=0.6 w=1.4 as=0.406
+ ad=0.406 ps=3.38 pd=3.38
X$357 VSS bias_a \$621 sky130_gnd sky130_fd_pr__nfet_01v8 l=0.6 w=1.4 as=0.406
+ ad=0.406 ps=3.38 pd=3.38
X$358 VSS bias_a \$621 sky130_gnd sky130_fd_pr__nfet_01v8 l=0.6 w=1.4 as=0.406
+ ad=0.406 ps=3.38 pd=3.38
X$359 VSS bias_a \$621 sky130_gnd sky130_fd_pr__nfet_01v8 l=0.6 w=1.4 as=0.406
+ ad=0.406 ps=3.38 pd=3.38
X$360 VSS bias_a \$621 sky130_gnd sky130_fd_pr__nfet_01v8 l=0.6 w=1.4 as=0.406
+ ad=0.406 ps=3.38 pd=3.38
X$361 VSS bias_a \$621 sky130_gnd sky130_fd_pr__nfet_01v8 l=0.6 w=1.4 as=0.406
+ ad=0.406 ps=3.38 pd=3.38
X$362 VSS bias_a \$621 sky130_gnd sky130_fd_pr__nfet_01v8 l=0.6 w=1.4 as=0.406
+ ad=0.406 ps=3.38 pd=3.38
X$363 VSS bias_a \$621 sky130_gnd sky130_fd_pr__nfet_01v8 l=0.6 w=1.4 as=0.406
+ ad=0.406 ps=3.38 pd=3.38
X$364 VSS bias_a \$621 sky130_gnd sky130_fd_pr__nfet_01v8 l=0.6 w=1.4 as=0.406
+ ad=0.406 ps=3.38 pd=3.38
X$365 VSS bias_a \$621 sky130_gnd sky130_fd_pr__nfet_01v8 l=0.6 w=1.4 as=0.406
+ ad=0.406 ps=3.38 pd=3.38
X$366 VSS bias_a \$621 sky130_gnd sky130_fd_pr__nfet_01v8 l=0.6 w=1.4 as=0.406
+ ad=0.406 ps=3.38 pd=3.38
X$367 VSS bias_a \$621 sky130_gnd sky130_fd_pr__nfet_01v8 l=0.6 w=1.4 as=0.406
+ ad=0.406 ps=3.38 pd=3.38
X$368 VSS bias_a \$621 sky130_gnd sky130_fd_pr__nfet_01v8 l=0.6 w=1.4 as=0.406
+ ad=0.406 ps=3.38 pd=3.38
X$369 VSS bias_a \$621 sky130_gnd sky130_fd_pr__nfet_01v8 l=0.6 w=1.4 as=0.406
+ ad=0.406 ps=3.38 pd=3.38
X$370 VSS bias_a \$621 sky130_gnd sky130_fd_pr__nfet_01v8 l=0.6 w=1.4 as=0.406
+ ad=0.406 ps=3.38 pd=3.38
X$371 VSS bias_a \$621 sky130_gnd sky130_fd_pr__nfet_01v8 l=0.6 w=1.4 as=0.406
+ ad=0.406 ps=3.38 pd=3.38
X$372 VSS bias_a \$621 sky130_gnd sky130_fd_pr__nfet_01v8 l=0.6 w=1.4 as=0.406
+ ad=0.406 ps=3.38 pd=3.38
X$373 VSS bias_a \$623 sky130_gnd sky130_fd_pr__nfet_01v8 l=0.6 w=1.4 as=0.406
+ ad=0.406 ps=3.38 pd=3.38
X$374 VSS bias_a \$623 sky130_gnd sky130_fd_pr__nfet_01v8 l=0.6 w=1.4 as=0.406
+ ad=0.406 ps=3.38 pd=3.38
X$375 VSS bias_a \$623 sky130_gnd sky130_fd_pr__nfet_01v8 l=0.6 w=1.4 as=0.406
+ ad=0.406 ps=3.38 pd=3.38
X$376 VSS bias_a \$623 sky130_gnd sky130_fd_pr__nfet_01v8 l=0.6 w=1.4 as=0.406
+ ad=0.406 ps=3.38 pd=3.38
X$377 VSS bias_a \$623 sky130_gnd sky130_fd_pr__nfet_01v8 l=0.6 w=1.4 as=0.406
+ ad=0.406 ps=3.38 pd=3.38
X$378 VSS bias_a \$623 sky130_gnd sky130_fd_pr__nfet_01v8 l=0.6 w=1.4 as=0.406
+ ad=0.406 ps=3.38 pd=3.38
X$379 VSS bias_a \$623 sky130_gnd sky130_fd_pr__nfet_01v8 l=0.6 w=1.4 as=0.406
+ ad=0.406 ps=3.38 pd=3.38
X$380 VSS bias_a \$623 sky130_gnd sky130_fd_pr__nfet_01v8 l=0.6 w=1.4 as=0.406
+ ad=0.406 ps=3.38 pd=3.38
X$381 VSS bias_a \$623 sky130_gnd sky130_fd_pr__nfet_01v8 l=0.6 w=1.4 as=0.406
+ ad=0.406 ps=3.38 pd=3.38
X$382 VSS bias_a \$623 sky130_gnd sky130_fd_pr__nfet_01v8 l=0.6 w=1.4 as=0.406
+ ad=0.406 ps=3.38 pd=3.38
X$383 VSS bias_a \$623 sky130_gnd sky130_fd_pr__nfet_01v8 l=0.6 w=1.4 as=0.406
+ ad=0.406 ps=3.38 pd=3.38
X$384 VSS bias_a \$623 sky130_gnd sky130_fd_pr__nfet_01v8 l=0.6 w=1.4 as=0.406
+ ad=0.406 ps=3.38 pd=3.38
X$385 VSS bias_a \$623 sky130_gnd sky130_fd_pr__nfet_01v8 l=0.6 w=1.4 as=0.406
+ ad=0.406 ps=3.38 pd=3.38
X$386 VSS bias_a \$623 sky130_gnd sky130_fd_pr__nfet_01v8 l=0.6 w=1.4 as=0.406
+ ad=0.406 ps=3.38 pd=3.38
X$387 VSS bias_a \$623 sky130_gnd sky130_fd_pr__nfet_01v8 l=0.6 w=1.4 as=0.406
+ ad=0.406 ps=3.38 pd=3.38
X$388 VSS bias_a \$623 sky130_gnd sky130_fd_pr__nfet_01v8 l=0.6 w=1.4 as=0.406
+ ad=0.406 ps=3.38 pd=3.38
X$389 VSS bias_a \$623 sky130_gnd sky130_fd_pr__nfet_01v8 l=0.6 w=1.4 as=0.406
+ ad=0.406 ps=3.38 pd=3.38
X$390 VSS bias_a \$623 sky130_gnd sky130_fd_pr__nfet_01v8 l=0.6 w=1.4 as=0.406
+ ad=0.406 ps=3.38 pd=3.38
X$391 VSS bias_a \$623 sky130_gnd sky130_fd_pr__nfet_01v8 l=0.6 w=1.4 as=0.406
+ ad=0.406 ps=3.38 pd=3.38
X$392 VSS bias_a \$623 sky130_gnd sky130_fd_pr__nfet_01v8 l=0.6 w=1.4 as=0.406
+ ad=0.406 ps=3.38 pd=3.38
X$393 VSS bias_a \$623 sky130_gnd sky130_fd_pr__nfet_01v8 l=0.6 w=1.4 as=0.406
+ ad=0.406 ps=3.38 pd=3.38
X$394 VSS bias_a \$623 sky130_gnd sky130_fd_pr__nfet_01v8 l=0.6 w=1.4 as=0.406
+ ad=0.406 ps=3.38 pd=3.38
X$395 VSS bias_a \$623 sky130_gnd sky130_fd_pr__nfet_01v8 l=0.6 w=1.4 as=0.406
+ ad=0.406 ps=3.38 pd=3.38
X$396 VSS bias_a \$623 sky130_gnd sky130_fd_pr__nfet_01v8 l=0.6 w=1.4 as=0.406
+ ad=0.406 ps=3.38 pd=3.38
X$397 VSS bias_a \$623 sky130_gnd sky130_fd_pr__nfet_01v8 l=0.6 w=1.4 as=0.406
+ ad=0.406 ps=3.38 pd=3.38
X$398 VSS bias_a \$623 sky130_gnd sky130_fd_pr__nfet_01v8 l=0.6 w=1.4 as=0.406
+ ad=0.406 ps=3.38 pd=3.38
X$399 VSS bias_a \$623 sky130_gnd sky130_fd_pr__nfet_01v8 l=0.6 w=1.4 as=0.406
+ ad=0.406 ps=3.38 pd=3.38
X$400 VSS bias_a \$623 sky130_gnd sky130_fd_pr__nfet_01v8 l=0.6 w=1.4 as=0.406
+ ad=0.406 ps=3.38 pd=3.38
X$401 VSS bias_a \$623 sky130_gnd sky130_fd_pr__nfet_01v8 l=0.6 w=1.4 as=0.406
+ ad=0.406 ps=3.38 pd=3.38
X$402 VSS bias_a \$623 sky130_gnd sky130_fd_pr__nfet_01v8 l=0.6 w=1.4 as=0.406
+ ad=0.406 ps=3.38 pd=3.38
X$403 VSS bias_a \$623 sky130_gnd sky130_fd_pr__nfet_01v8 l=0.6 w=1.4 as=0.406
+ ad=0.406 ps=3.38 pd=3.38
X$404 VSS bias_a \$623 sky130_gnd sky130_fd_pr__nfet_01v8 l=0.6 w=1.4 as=0.406
+ ad=0.406 ps=3.38 pd=3.38
X$405 VSS bias_a \$623 sky130_gnd sky130_fd_pr__nfet_01v8 l=0.6 w=1.4 as=0.406
+ ad=0.406 ps=3.38 pd=3.38
X$406 VSS bias_a \$623 sky130_gnd sky130_fd_pr__nfet_01v8 l=0.6 w=1.4 as=0.406
+ ad=0.406 ps=3.38 pd=3.38
X$407 VSS bias_a \$623 sky130_gnd sky130_fd_pr__nfet_01v8 l=0.6 w=1.4 as=0.406
+ ad=0.406 ps=3.38 pd=3.38
X$408 VSS bias_a \$623 sky130_gnd sky130_fd_pr__nfet_01v8 l=0.6 w=1.4 as=0.406
+ ad=0.406 ps=3.38 pd=3.38
X$409 VSS VSS VSS sky130_gnd sky130_fd_pr__nfet_01v8 l=0.6 w=1.4 as=0.406
+ ad=0.406 ps=3.38 pd=3.38
X$410 VSS VSS VSS sky130_gnd sky130_fd_pr__nfet_01v8 l=0.6 w=1.4 as=0.406
+ ad=0.406 ps=3.38 pd=3.38
X$411 VSS bias_a \$558 sky130_gnd sky130_fd_pr__nfet_01v8 l=0.6 w=1.4 as=0.406
+ ad=0.406 ps=3.38 pd=3.38
X$412 VSS bias_a \$558 sky130_gnd sky130_fd_pr__nfet_01v8 l=0.6 w=1.4 as=0.406
+ ad=0.406 ps=3.38 pd=3.38
X$413 VSS bias_a \$558 sky130_gnd sky130_fd_pr__nfet_01v8 l=0.6 w=1.4 as=0.406
+ ad=0.406 ps=3.38 pd=3.38
X$414 VSS bias_a \$558 sky130_gnd sky130_fd_pr__nfet_01v8 l=0.6 w=1.4 as=0.406
+ ad=0.406 ps=3.38 pd=3.38
X$415 VSS bias_a \$558 sky130_gnd sky130_fd_pr__nfet_01v8 l=0.6 w=1.4 as=0.406
+ ad=0.406 ps=3.38 pd=3.38
X$416 VSS bias_a \$558 sky130_gnd sky130_fd_pr__nfet_01v8 l=0.6 w=1.4 as=0.406
+ ad=0.406 ps=3.38 pd=3.38
X$417 VSS bias_a \$558 sky130_gnd sky130_fd_pr__nfet_01v8 l=0.6 w=1.4 as=0.406
+ ad=0.406 ps=3.38 pd=3.38
X$418 VSS bias_a \$558 sky130_gnd sky130_fd_pr__nfet_01v8 l=0.6 w=1.4 as=0.406
+ ad=0.406 ps=3.38 pd=3.38
X$419 VSS bias_a \$558 sky130_gnd sky130_fd_pr__nfet_01v8 l=0.6 w=1.4 as=0.406
+ ad=0.406 ps=3.38 pd=3.38
X$420 VSS bias_a \$558 sky130_gnd sky130_fd_pr__nfet_01v8 l=0.6 w=1.4 as=0.406
+ ad=0.406 ps=3.38 pd=3.38
X$421 VSS bias_a \$558 sky130_gnd sky130_fd_pr__nfet_01v8 l=0.6 w=1.4 as=0.406
+ ad=0.406 ps=3.38 pd=3.38
X$422 VSS bias_a \$558 sky130_gnd sky130_fd_pr__nfet_01v8 l=0.6 w=1.4 as=0.406
+ ad=0.406 ps=3.38 pd=3.38
X$423 VSS bias_a \$558 sky130_gnd sky130_fd_pr__nfet_01v8 l=0.6 w=1.4 as=0.406
+ ad=0.406 ps=3.38 pd=3.38
X$424 VSS bias_a \$558 sky130_gnd sky130_fd_pr__nfet_01v8 l=0.6 w=1.4 as=0.406
+ ad=0.406 ps=3.38 pd=3.38
X$425 VSS bias_a \$558 sky130_gnd sky130_fd_pr__nfet_01v8 l=0.6 w=1.4 as=0.406
+ ad=0.406 ps=3.38 pd=3.38
X$426 VSS bias_a \$558 sky130_gnd sky130_fd_pr__nfet_01v8 l=0.6 w=1.4 as=0.406
+ ad=0.406 ps=3.38 pd=3.38
X$427 VSS bias_a \$558 sky130_gnd sky130_fd_pr__nfet_01v8 l=0.6 w=1.4 as=0.406
+ ad=0.406 ps=3.38 pd=3.38
X$428 VSS bias_a \$558 sky130_gnd sky130_fd_pr__nfet_01v8 l=0.6 w=1.4 as=0.406
+ ad=0.406 ps=3.38 pd=3.38
X$429 VSS bias_a \$558 sky130_gnd sky130_fd_pr__nfet_01v8 l=0.6 w=1.4 as=0.406
+ ad=0.406 ps=3.38 pd=3.38
X$430 VSS bias_a \$558 sky130_gnd sky130_fd_pr__nfet_01v8 l=0.6 w=1.4 as=0.406
+ ad=0.406 ps=3.38 pd=3.38
X$431 VSS bias_a \$558 sky130_gnd sky130_fd_pr__nfet_01v8 l=0.6 w=1.4 as=0.406
+ ad=0.406 ps=3.38 pd=3.38
X$432 VSS bias_a \$558 sky130_gnd sky130_fd_pr__nfet_01v8 l=0.6 w=1.4 as=0.406
+ ad=0.406 ps=3.38 pd=3.38
X$433 VSS bias_a \$558 sky130_gnd sky130_fd_pr__nfet_01v8 l=0.6 w=1.4 as=0.406
+ ad=0.406 ps=3.38 pd=3.38
X$434 VSS bias_a \$558 sky130_gnd sky130_fd_pr__nfet_01v8 l=0.6 w=1.4 as=0.406
+ ad=0.406 ps=3.38 pd=3.38
X$435 VSS bias_a \$558 sky130_gnd sky130_fd_pr__nfet_01v8 l=0.6 w=1.4 as=0.406
+ ad=0.406 ps=3.38 pd=3.38
X$436 VSS bias_a \$558 sky130_gnd sky130_fd_pr__nfet_01v8 l=0.6 w=1.4 as=0.406
+ ad=0.406 ps=3.38 pd=3.38
X$437 VSS bias_a \$558 sky130_gnd sky130_fd_pr__nfet_01v8 l=0.6 w=1.4 as=0.406
+ ad=0.406 ps=3.38 pd=3.38
X$438 VSS bias_a \$558 sky130_gnd sky130_fd_pr__nfet_01v8 l=0.6 w=1.4 as=0.406
+ ad=0.406 ps=3.38 pd=3.38
X$439 VSS bias_a \$558 sky130_gnd sky130_fd_pr__nfet_01v8 l=0.6 w=1.4 as=0.406
+ ad=0.406 ps=3.38 pd=3.38
X$440 VSS bias_a \$558 sky130_gnd sky130_fd_pr__nfet_01v8 l=0.6 w=1.4 as=0.406
+ ad=0.406 ps=3.38 pd=3.38
X$441 VSS bias_a \$558 sky130_gnd sky130_fd_pr__nfet_01v8 l=0.6 w=1.4 as=0.406
+ ad=0.406 ps=3.38 pd=3.38
X$442 VSS bias_a \$558 sky130_gnd sky130_fd_pr__nfet_01v8 l=0.6 w=1.4 as=0.406
+ ad=0.406 ps=3.38 pd=3.38
X$443 VSS bias_a \$558 sky130_gnd sky130_fd_pr__nfet_01v8 l=0.6 w=1.4 as=0.406
+ ad=0.406 ps=3.38 pd=3.38
X$444 VSS bias_a \$558 sky130_gnd sky130_fd_pr__nfet_01v8 l=0.6 w=1.4 as=0.406
+ ad=0.406 ps=3.38 pd=3.38
X$445 VSS bias_a \$558 sky130_gnd sky130_fd_pr__nfet_01v8 l=0.6 w=1.4 as=0.406
+ ad=0.406 ps=3.38 pd=3.38
X$446 VSS bias_a \$558 sky130_gnd sky130_fd_pr__nfet_01v8 l=0.6 w=1.4 as=0.406
+ ad=0.406 ps=3.38 pd=3.38
X$447 VSS bias_a \$558 sky130_gnd sky130_fd_pr__nfet_01v8 l=0.6 w=1.4 as=0.406
+ ad=0.406 ps=3.38 pd=3.38
X$448 VSS bias_a \$558 sky130_gnd sky130_fd_pr__nfet_01v8 l=0.6 w=1.4 as=0.406
+ ad=0.406 ps=3.38 pd=3.38
X$449 VSS bias_a \$558 sky130_gnd sky130_fd_pr__nfet_01v8 l=0.6 w=1.4 as=0.406
+ ad=0.406 ps=3.38 pd=3.38
X$450 VSS bias_a \$558 sky130_gnd sky130_fd_pr__nfet_01v8 l=0.6 w=1.4 as=0.406
+ ad=0.406 ps=3.38 pd=3.38
X$451 VSS bias_a \$558 sky130_gnd sky130_fd_pr__nfet_01v8 l=0.6 w=1.4 as=0.406
+ ad=0.406 ps=3.38 pd=3.38
X$452 VSS bias_a \$558 sky130_gnd sky130_fd_pr__nfet_01v8 l=0.6 w=1.4 as=0.406
+ ad=0.406 ps=3.38 pd=3.38
X$453 VSS bias_a \$558 sky130_gnd sky130_fd_pr__nfet_01v8 l=0.6 w=1.4 as=0.406
+ ad=0.406 ps=3.38 pd=3.38
X$454 VSS bias_a \$558 sky130_gnd sky130_fd_pr__nfet_01v8 l=0.6 w=1.4 as=0.406
+ ad=0.406 ps=3.38 pd=3.38
X$455 VSS bias_a \$558 sky130_gnd sky130_fd_pr__nfet_01v8 l=0.6 w=1.4 as=0.406
+ ad=0.406 ps=3.38 pd=3.38
X$456 VSS bias_a \$558 sky130_gnd sky130_fd_pr__nfet_01v8 l=0.6 w=1.4 as=0.406
+ ad=0.406 ps=3.38 pd=3.38
X$457 VSS bias_a \$558 sky130_gnd sky130_fd_pr__nfet_01v8 l=0.6 w=1.4 as=0.406
+ ad=0.406 ps=3.38 pd=3.38
X$458 VSS bias_a \$558 sky130_gnd sky130_fd_pr__nfet_01v8 l=0.6 w=1.4 as=0.406
+ ad=0.406 ps=3.38 pd=3.38
X$459 VSS bias_a \$558 sky130_gnd sky130_fd_pr__nfet_01v8 l=0.6 w=1.4 as=0.406
+ ad=0.406 ps=3.38 pd=3.38
X$460 VSS bias_a \$558 sky130_gnd sky130_fd_pr__nfet_01v8 l=0.6 w=1.4 as=0.406
+ ad=0.406 ps=3.38 pd=3.38
X$461 VSS bias_a \$558 sky130_gnd sky130_fd_pr__nfet_01v8 l=0.6 w=1.4 as=0.406
+ ad=0.406 ps=3.38 pd=3.38
X$462 VSS bias_a \$558 sky130_gnd sky130_fd_pr__nfet_01v8 l=0.6 w=1.4 as=0.406
+ ad=0.406 ps=3.38 pd=3.38
X$463 VSS bias_a \$558 sky130_gnd sky130_fd_pr__nfet_01v8 l=0.6 w=1.4 as=0.406
+ ad=0.406 ps=3.38 pd=3.38
X$464 VSS bias_a \$558 sky130_gnd sky130_fd_pr__nfet_01v8 l=0.6 w=1.4 as=0.406
+ ad=0.406 ps=3.38 pd=3.38
X$465 VSS bias_a \$558 sky130_gnd sky130_fd_pr__nfet_01v8 l=0.6 w=1.4 as=0.406
+ ad=0.406 ps=3.38 pd=3.38
X$466 VSS bias_a \$558 sky130_gnd sky130_fd_pr__nfet_01v8 l=0.6 w=1.4 as=0.406
+ ad=0.406 ps=3.38 pd=3.38
X$467 VSS bias_a \$558 sky130_gnd sky130_fd_pr__nfet_01v8 l=0.6 w=1.4 as=0.406
+ ad=0.406 ps=3.38 pd=3.38
X$468 VSS bias_a \$558 sky130_gnd sky130_fd_pr__nfet_01v8 l=0.6 w=1.4 as=0.406
+ ad=0.406 ps=3.38 pd=3.38
X$469 VSS bias_a \$558 sky130_gnd sky130_fd_pr__nfet_01v8 l=0.6 w=1.4 as=0.406
+ ad=0.406 ps=3.38 pd=3.38
X$470 VSS bias_a \$558 sky130_gnd sky130_fd_pr__nfet_01v8 l=0.6 w=1.4 as=0.406
+ ad=0.406 ps=3.38 pd=3.38
X$471 VSS bias_a \$558 sky130_gnd sky130_fd_pr__nfet_01v8 l=0.6 w=1.4 as=0.406
+ ad=0.406 ps=3.38 pd=3.38
X$472 VSS bias_a \$558 sky130_gnd sky130_fd_pr__nfet_01v8 l=0.6 w=1.4 as=0.406
+ ad=0.406 ps=3.38 pd=3.38
X$473 VSS bias_a \$558 sky130_gnd sky130_fd_pr__nfet_01v8 l=0.6 w=1.4 as=0.406
+ ad=0.406 ps=3.38 pd=3.38
X$474 VSS bias_a \$558 sky130_gnd sky130_fd_pr__nfet_01v8 l=0.6 w=1.4 as=0.406
+ ad=0.406 ps=3.38 pd=3.38
X$475 VSS bias_a \$558 sky130_gnd sky130_fd_pr__nfet_01v8 l=0.6 w=1.4 as=0.406
+ ad=0.406 ps=3.38 pd=3.38
X$476 VSS bias_a \$558 sky130_gnd sky130_fd_pr__nfet_01v8 l=0.6 w=1.4 as=0.406
+ ad=0.406 ps=3.38 pd=3.38
X$477 VSS bias_a \$558 sky130_gnd sky130_fd_pr__nfet_01v8 l=0.6 w=1.4 as=0.406
+ ad=0.406 ps=3.38 pd=3.38
X$478 VSS bias_a \$558 sky130_gnd sky130_fd_pr__nfet_01v8 l=0.6 w=1.4 as=0.406
+ ad=0.406 ps=3.38 pd=3.38
X$479 VSS bias_a \$558 sky130_gnd sky130_fd_pr__nfet_01v8 l=0.6 w=1.4 as=0.406
+ ad=0.406 ps=3.38 pd=3.38
X$480 VSS bias_a \$558 sky130_gnd sky130_fd_pr__nfet_01v8 l=0.6 w=1.4 as=0.406
+ ad=0.406 ps=3.38 pd=3.38
X$481 VSS bias_a \$558 sky130_gnd sky130_fd_pr__nfet_01v8 l=0.6 w=1.4 as=0.406
+ ad=0.406 ps=3.38 pd=3.38
X$482 VSS bias_a \$558 sky130_gnd sky130_fd_pr__nfet_01v8 l=0.6 w=1.4 as=0.406
+ ad=0.406 ps=3.38 pd=3.38
X$483 VSS bias_a \$558 sky130_gnd sky130_fd_pr__nfet_01v8 l=0.6 w=1.4 as=0.406
+ ad=0.406 ps=3.38 pd=3.38
X$484 VSS bias_a \$558 sky130_gnd sky130_fd_pr__nfet_01v8 l=0.6 w=1.4 as=0.406
+ ad=0.406 ps=3.38 pd=3.38
X$485 VSS bias_a \$558 sky130_gnd sky130_fd_pr__nfet_01v8 l=0.6 w=1.4 as=0.406
+ ad=0.406 ps=3.38 pd=3.38
X$486 VSS bias_a \$558 sky130_gnd sky130_fd_pr__nfet_01v8 l=0.6 w=1.4 as=0.406
+ ad=0.406 ps=3.38 pd=3.38
X$487 VSS bias_a \$558 sky130_gnd sky130_fd_pr__nfet_01v8 l=0.6 w=1.4 as=0.406
+ ad=0.406 ps=3.38 pd=3.38
X$488 VSS bias_a \$558 sky130_gnd sky130_fd_pr__nfet_01v8 l=0.6 w=1.4 as=0.406
+ ad=0.406 ps=3.38 pd=3.38
X$489 VSS bias_a \$558 sky130_gnd sky130_fd_pr__nfet_01v8 l=0.6 w=1.4 as=0.406
+ ad=0.406 ps=3.38 pd=3.38
X$490 VSS bias_a \$558 sky130_gnd sky130_fd_pr__nfet_01v8 l=0.6 w=1.4 as=0.406
+ ad=0.406 ps=3.38 pd=3.38
X$491 VSS bias_a \$558 sky130_gnd sky130_fd_pr__nfet_01v8 l=0.6 w=1.4 as=0.406
+ ad=0.406 ps=3.38 pd=3.38
X$492 VSS bias_a \$558 sky130_gnd sky130_fd_pr__nfet_01v8 l=0.6 w=1.4 as=0.406
+ ad=0.406 ps=3.38 pd=3.38
X$493 VSS bias_a \$558 sky130_gnd sky130_fd_pr__nfet_01v8 l=0.6 w=1.4 as=0.406
+ ad=0.406 ps=3.38 pd=3.38
X$494 VSS bias_a \$558 sky130_gnd sky130_fd_pr__nfet_01v8 l=0.6 w=1.4 as=0.406
+ ad=0.406 ps=3.38 pd=3.38
X$495 VSS bias_a \$558 sky130_gnd sky130_fd_pr__nfet_01v8 l=0.6 w=1.4 as=0.406
+ ad=0.406 ps=3.38 pd=3.38
X$496 VSS bias_a \$558 sky130_gnd sky130_fd_pr__nfet_01v8 l=0.6 w=1.4 as=0.406
+ ad=0.406 ps=3.38 pd=3.38
X$497 VSS bias_a \$558 sky130_gnd sky130_fd_pr__nfet_01v8 l=0.6 w=1.4 as=0.406
+ ad=0.406 ps=3.38 pd=3.38
X$498 VSS bias_a \$558 sky130_gnd sky130_fd_pr__nfet_01v8 l=0.6 w=1.4 as=0.406
+ ad=0.406 ps=3.38 pd=3.38
X$499 VSS bias_a \$558 sky130_gnd sky130_fd_pr__nfet_01v8 l=0.6 w=1.4 as=0.406
+ ad=0.406 ps=3.38 pd=3.38
X$500 VSS bias_a \$558 sky130_gnd sky130_fd_pr__nfet_01v8 l=0.6 w=1.4 as=0.406
+ ad=0.406 ps=3.38 pd=3.38
X$501 VSS bias_a \$558 sky130_gnd sky130_fd_pr__nfet_01v8 l=0.6 w=1.4 as=0.406
+ ad=0.406 ps=3.38 pd=3.38
X$502 VSS bias_a \$558 sky130_gnd sky130_fd_pr__nfet_01v8 l=0.6 w=1.4 as=0.406
+ ad=0.406 ps=3.38 pd=3.38
X$503 VSS bias_a \$558 sky130_gnd sky130_fd_pr__nfet_01v8 l=0.6 w=1.4 as=0.406
+ ad=0.406 ps=3.38 pd=3.38
X$504 VSS bias_a \$558 sky130_gnd sky130_fd_pr__nfet_01v8 l=0.6 w=1.4 as=0.406
+ ad=0.406 ps=3.38 pd=3.38
X$505 VSS bias_a \$558 sky130_gnd sky130_fd_pr__nfet_01v8 l=0.6 w=1.4 as=0.406
+ ad=0.406 ps=3.38 pd=3.38
X$506 VSS bias_a \$558 sky130_gnd sky130_fd_pr__nfet_01v8 l=0.6 w=1.4 as=0.406
+ ad=0.406 ps=3.38 pd=3.38
X$507 VSS cmc \$558 sky130_gnd sky130_fd_pr__nfet_01v8 l=0.6 w=1.4 as=0.406
+ ad=0.406 ps=3.38 pd=3.38
X$508 VSS cmc \$558 sky130_gnd sky130_fd_pr__nfet_01v8 l=0.6 w=1.4 as=0.406
+ ad=0.406 ps=3.38 pd=3.38
X$509 VSS cmc \$558 sky130_gnd sky130_fd_pr__nfet_01v8 l=0.6 w=1.4 as=0.406
+ ad=0.406 ps=3.38 pd=3.38
X$510 VSS cmc \$558 sky130_gnd sky130_fd_pr__nfet_01v8 l=0.6 w=1.4 as=0.406
+ ad=0.406 ps=3.38 pd=3.38
X$511 VSS cmc \$558 sky130_gnd sky130_fd_pr__nfet_01v8 l=0.6 w=1.4 as=0.406
+ ad=0.406 ps=3.38 pd=3.38
X$512 VSS cmc \$558 sky130_gnd sky130_fd_pr__nfet_01v8 l=0.6 w=1.4 as=0.406
+ ad=0.406 ps=3.38 pd=3.38
X$513 VSS cmc \$558 sky130_gnd sky130_fd_pr__nfet_01v8 l=0.6 w=1.4 as=0.406
+ ad=0.406 ps=3.38 pd=3.38
X$514 VSS cmc \$558 sky130_gnd sky130_fd_pr__nfet_01v8 l=0.6 w=1.4 as=0.406
+ ad=0.406 ps=3.38 pd=3.38
X$515 VSS cmc \$558 sky130_gnd sky130_fd_pr__nfet_01v8 l=0.6 w=1.4 as=0.406
+ ad=0.406 ps=3.38 pd=3.38
X$516 VSS cmc \$558 sky130_gnd sky130_fd_pr__nfet_01v8 l=0.6 w=1.4 as=0.406
+ ad=0.406 ps=3.38 pd=3.38
X$517 VSS cmc \$558 sky130_gnd sky130_fd_pr__nfet_01v8 l=0.6 w=1.4 as=0.406
+ ad=0.406 ps=3.38 pd=3.38
X$518 VSS cmc \$558 sky130_gnd sky130_fd_pr__nfet_01v8 l=0.6 w=1.4 as=0.406
+ ad=0.406 ps=3.38 pd=3.38
X$519 VSS cmc \$558 sky130_gnd sky130_fd_pr__nfet_01v8 l=0.6 w=1.4 as=0.406
+ ad=0.406 ps=3.38 pd=3.38
X$520 VSS cmc \$558 sky130_gnd sky130_fd_pr__nfet_01v8 l=0.6 w=1.4 as=0.406
+ ad=0.406 ps=3.38 pd=3.38
X$521 VSS cmc \$558 sky130_gnd sky130_fd_pr__nfet_01v8 l=0.6 w=1.4 as=0.406
+ ad=0.406 ps=3.38 pd=3.38
X$522 VSS cmc \$558 sky130_gnd sky130_fd_pr__nfet_01v8 l=0.6 w=1.4 as=0.406
+ ad=0.406 ps=3.38 pd=3.38
X$523 VSS cmc \$558 sky130_gnd sky130_fd_pr__nfet_01v8 l=0.6 w=1.4 as=0.406
+ ad=0.406 ps=3.38 pd=3.38
X$524 VSS cmc \$558 sky130_gnd sky130_fd_pr__nfet_01v8 l=0.6 w=1.4 as=0.406
+ ad=0.406 ps=3.38 pd=3.38
X$525 VSS cmc \$558 sky130_gnd sky130_fd_pr__nfet_01v8 l=0.6 w=1.4 as=0.406
+ ad=0.406 ps=3.38 pd=3.38
X$526 VSS cmc \$558 sky130_gnd sky130_fd_pr__nfet_01v8 l=0.6 w=1.4 as=0.406
+ ad=0.406 ps=3.38 pd=3.38
X$527 VSS cmc \$558 sky130_gnd sky130_fd_pr__nfet_01v8 l=0.6 w=1.4 as=0.406
+ ad=0.406 ps=3.38 pd=3.38
X$528 VSS cmc \$558 sky130_gnd sky130_fd_pr__nfet_01v8 l=0.6 w=1.4 as=0.406
+ ad=0.406 ps=3.38 pd=3.38
X$529 VSS cmc \$558 sky130_gnd sky130_fd_pr__nfet_01v8 l=0.6 w=1.4 as=0.406
+ ad=0.406 ps=3.38 pd=3.38
X$530 VSS cmc \$558 sky130_gnd sky130_fd_pr__nfet_01v8 l=0.6 w=1.4 as=0.406
+ ad=0.406 ps=3.38 pd=3.38
X$531 VSS cmc \$558 sky130_gnd sky130_fd_pr__nfet_01v8 l=0.6 w=1.4 as=0.406
+ ad=0.406 ps=3.38 pd=3.38
X$532 VSS cmc \$558 sky130_gnd sky130_fd_pr__nfet_01v8 l=0.6 w=1.4 as=0.406
+ ad=0.406 ps=3.38 pd=3.38
X$533 VSS cmc \$558 sky130_gnd sky130_fd_pr__nfet_01v8 l=0.6 w=1.4 as=0.406
+ ad=0.406 ps=3.38 pd=3.38
X$534 VSS cmc \$558 sky130_gnd sky130_fd_pr__nfet_01v8 l=0.6 w=1.4 as=0.406
+ ad=0.406 ps=3.38 pd=3.38
X$535 VSS cmc \$558 sky130_gnd sky130_fd_pr__nfet_01v8 l=0.6 w=1.4 as=0.406
+ ad=0.406 ps=3.38 pd=3.38
X$536 VSS cmc \$558 sky130_gnd sky130_fd_pr__nfet_01v8 l=0.6 w=1.4 as=0.406
+ ad=0.406 ps=3.38 pd=3.38
X$537 VSS cmc \$558 sky130_gnd sky130_fd_pr__nfet_01v8 l=0.6 w=1.4 as=0.406
+ ad=0.406 ps=3.38 pd=3.38
X$538 VSS cmc \$558 sky130_gnd sky130_fd_pr__nfet_01v8 l=0.6 w=1.4 as=0.406
+ ad=0.406 ps=3.38 pd=3.38
X$539 VSS cmc \$558 sky130_gnd sky130_fd_pr__nfet_01v8 l=0.6 w=1.4 as=0.406
+ ad=0.406 ps=3.38 pd=3.38
X$540 VSS cmc \$558 sky130_gnd sky130_fd_pr__nfet_01v8 l=0.6 w=1.4 as=0.406
+ ad=0.406 ps=3.38 pd=3.38
X$541 VSS cmc \$558 sky130_gnd sky130_fd_pr__nfet_01v8 l=0.6 w=1.4 as=0.406
+ ad=0.406 ps=3.38 pd=3.38
X$542 VSS cmc \$558 sky130_gnd sky130_fd_pr__nfet_01v8 l=0.6 w=1.4 as=0.406
+ ad=0.406 ps=3.38 pd=3.38
X$543 VSS cmc \$558 sky130_gnd sky130_fd_pr__nfet_01v8 l=0.6 w=1.4 as=0.406
+ ad=0.406 ps=3.38 pd=3.38
X$544 VSS cmc \$558 sky130_gnd sky130_fd_pr__nfet_01v8 l=0.6 w=1.4 as=0.406
+ ad=0.406 ps=3.38 pd=3.38
X$545 VSS cmc \$558 sky130_gnd sky130_fd_pr__nfet_01v8 l=0.6 w=1.4 as=0.406
+ ad=0.406 ps=3.38 pd=3.38
X$546 VSS cmc \$558 sky130_gnd sky130_fd_pr__nfet_01v8 l=0.6 w=1.4 as=0.406
+ ad=0.406 ps=3.38 pd=3.38
X$547 VSS cmc \$558 sky130_gnd sky130_fd_pr__nfet_01v8 l=0.6 w=1.4 as=0.406
+ ad=0.406 ps=3.38 pd=3.38
X$548 VSS cmc \$558 sky130_gnd sky130_fd_pr__nfet_01v8 l=0.6 w=1.4 as=0.406
+ ad=0.406 ps=3.38 pd=3.38
X$549 VSS cmc \$558 sky130_gnd sky130_fd_pr__nfet_01v8 l=0.6 w=1.4 as=0.406
+ ad=0.406 ps=3.38 pd=3.38
X$550 VSS cmc \$558 sky130_gnd sky130_fd_pr__nfet_01v8 l=0.6 w=1.4 as=0.406
+ ad=0.406 ps=3.38 pd=3.38
X$551 VSS cmc \$558 sky130_gnd sky130_fd_pr__nfet_01v8 l=0.6 w=1.4 as=0.406
+ ad=0.406 ps=3.38 pd=3.38
X$552 VSS cmc \$558 sky130_gnd sky130_fd_pr__nfet_01v8 l=0.6 w=1.4 as=0.406
+ ad=0.406 ps=3.38 pd=3.38
X$553 VSS cmc \$558 sky130_gnd sky130_fd_pr__nfet_01v8 l=0.6 w=1.4 as=0.406
+ ad=0.406 ps=3.38 pd=3.38
X$554 VSS cmc \$558 sky130_gnd sky130_fd_pr__nfet_01v8 l=0.6 w=1.4 as=0.406
+ ad=0.406 ps=3.38 pd=3.38
X$555 VSS cmc \$558 sky130_gnd sky130_fd_pr__nfet_01v8 l=0.6 w=1.4 as=0.406
+ ad=0.406 ps=3.38 pd=3.38
X$556 VSS cmc \$558 sky130_gnd sky130_fd_pr__nfet_01v8 l=0.6 w=1.4 as=0.406
+ ad=0.406 ps=3.38 pd=3.38
X$557 VSS cmc \$558 sky130_gnd sky130_fd_pr__nfet_01v8 l=0.6 w=1.4 as=0.406
+ ad=0.406 ps=3.38 pd=3.38
X$558 VSS cmc \$558 sky130_gnd sky130_fd_pr__nfet_01v8 l=0.6 w=1.4 as=0.406
+ ad=0.406 ps=3.38 pd=3.38
X$559 VSS cmc \$558 sky130_gnd sky130_fd_pr__nfet_01v8 l=0.6 w=1.4 as=0.406
+ ad=0.406 ps=3.38 pd=3.38
X$560 VSS cmc \$558 sky130_gnd sky130_fd_pr__nfet_01v8 l=0.6 w=1.4 as=0.406
+ ad=0.406 ps=3.38 pd=3.38
X$561 VSS cmc \$558 sky130_gnd sky130_fd_pr__nfet_01v8 l=0.6 w=1.4 as=0.406
+ ad=0.406 ps=3.38 pd=3.38
X$562 VSS cmc \$558 sky130_gnd sky130_fd_pr__nfet_01v8 l=0.6 w=1.4 as=0.406
+ ad=0.406 ps=3.38 pd=3.38
X$563 VSS cmc \$558 sky130_gnd sky130_fd_pr__nfet_01v8 l=0.6 w=1.4 as=0.406
+ ad=0.406 ps=3.38 pd=3.38
X$564 VSS cmc \$558 sky130_gnd sky130_fd_pr__nfet_01v8 l=0.6 w=1.4 as=0.406
+ ad=0.406 ps=3.38 pd=3.38
X$565 VSS cmc \$558 sky130_gnd sky130_fd_pr__nfet_01v8 l=0.6 w=1.4 as=0.406
+ ad=0.406 ps=3.38 pd=3.38
X$566 VSS cmc \$558 sky130_gnd sky130_fd_pr__nfet_01v8 l=0.6 w=1.4 as=0.406
+ ad=0.406 ps=3.38 pd=3.38
X$567 VSS cmc \$558 sky130_gnd sky130_fd_pr__nfet_01v8 l=0.6 w=1.4 as=0.406
+ ad=0.406 ps=3.38 pd=3.38
X$568 VSS cmc \$558 sky130_gnd sky130_fd_pr__nfet_01v8 l=0.6 w=1.4 as=0.406
+ ad=0.406 ps=3.38 pd=3.38
X$569 VSS cmc \$558 sky130_gnd sky130_fd_pr__nfet_01v8 l=0.6 w=1.4 as=0.406
+ ad=0.406 ps=3.38 pd=3.38
X$570 VSS cmc \$558 sky130_gnd sky130_fd_pr__nfet_01v8 l=0.6 w=1.4 as=0.406
+ ad=0.406 ps=3.38 pd=3.38
X$571 VSS cmc \$558 sky130_gnd sky130_fd_pr__nfet_01v8 l=0.6 w=1.4 as=0.406
+ ad=0.406 ps=3.38 pd=3.38
X$572 VSS cmc \$558 sky130_gnd sky130_fd_pr__nfet_01v8 l=0.6 w=1.4 as=0.406
+ ad=0.406 ps=3.38 pd=3.38
X$573 VSS cmc \$558 sky130_gnd sky130_fd_pr__nfet_01v8 l=0.6 w=1.4 as=0.406
+ ad=0.406 ps=3.38 pd=3.38
X$574 VSS cmc \$558 sky130_gnd sky130_fd_pr__nfet_01v8 l=0.6 w=1.4 as=0.406
+ ad=0.406 ps=3.38 pd=3.38
X$575 VSS cmc \$558 sky130_gnd sky130_fd_pr__nfet_01v8 l=0.6 w=1.4 as=0.406
+ ad=0.406 ps=3.38 pd=3.38
X$576 VSS cmc \$558 sky130_gnd sky130_fd_pr__nfet_01v8 l=0.6 w=1.4 as=0.406
+ ad=0.406 ps=3.38 pd=3.38
X$577 VSS cmc \$558 sky130_gnd sky130_fd_pr__nfet_01v8 l=0.6 w=1.4 as=0.406
+ ad=0.406 ps=3.38 pd=3.38
X$578 VSS cmc \$558 sky130_gnd sky130_fd_pr__nfet_01v8 l=0.6 w=1.4 as=0.406
+ ad=0.406 ps=3.38 pd=3.38
X$579 VSS cmc \$558 sky130_gnd sky130_fd_pr__nfet_01v8 l=0.6 w=1.4 as=0.406
+ ad=0.406 ps=3.38 pd=3.38
X$580 VSS cmc \$558 sky130_gnd sky130_fd_pr__nfet_01v8 l=0.6 w=1.4 as=0.406
+ ad=0.406 ps=3.38 pd=3.38
X$581 VSS cmc \$558 sky130_gnd sky130_fd_pr__nfet_01v8 l=0.6 w=1.4 as=0.406
+ ad=0.406 ps=3.38 pd=3.38
X$582 VSS cmc \$558 sky130_gnd sky130_fd_pr__nfet_01v8 l=0.6 w=1.4 as=0.406
+ ad=0.406 ps=3.38 pd=3.38
X$583 VSS cmc \$558 sky130_gnd sky130_fd_pr__nfet_01v8 l=0.6 w=1.4 as=0.406
+ ad=0.406 ps=3.38 pd=3.38
X$584 VSS cmc \$558 sky130_gnd sky130_fd_pr__nfet_01v8 l=0.6 w=1.4 as=0.406
+ ad=0.406 ps=3.38 pd=3.38
X$585 VSS cmc \$558 sky130_gnd sky130_fd_pr__nfet_01v8 l=0.6 w=1.4 as=0.406
+ ad=0.406 ps=3.38 pd=3.38
X$586 VSS cmc \$558 sky130_gnd sky130_fd_pr__nfet_01v8 l=0.6 w=1.4 as=0.406
+ ad=0.406 ps=3.38 pd=3.38
X$587 VSS cmc \$558 sky130_gnd sky130_fd_pr__nfet_01v8 l=0.6 w=1.4 as=0.406
+ ad=0.406 ps=3.38 pd=3.38
X$588 VSS cmc \$558 sky130_gnd sky130_fd_pr__nfet_01v8 l=0.6 w=1.4 as=0.406
+ ad=0.406 ps=3.38 pd=3.38
X$589 VSS cmc \$558 sky130_gnd sky130_fd_pr__nfet_01v8 l=0.6 w=1.4 as=0.406
+ ad=0.406 ps=3.38 pd=3.38
X$590 VSS cmc \$558 sky130_gnd sky130_fd_pr__nfet_01v8 l=0.6 w=1.4 as=0.406
+ ad=0.406 ps=3.38 pd=3.38
X$591 VSS cmc \$558 sky130_gnd sky130_fd_pr__nfet_01v8 l=0.6 w=1.4 as=0.406
+ ad=0.406 ps=3.38 pd=3.38
X$592 VSS cmc \$558 sky130_gnd sky130_fd_pr__nfet_01v8 l=0.6 w=1.4 as=0.406
+ ad=0.406 ps=3.38 pd=3.38
X$593 VSS cmc \$558 sky130_gnd sky130_fd_pr__nfet_01v8 l=0.6 w=1.4 as=0.406
+ ad=0.406 ps=3.38 pd=3.38
X$594 VSS cmc \$558 sky130_gnd sky130_fd_pr__nfet_01v8 l=0.6 w=1.4 as=0.406
+ ad=0.406 ps=3.38 pd=3.38
X$595 VSS cmc \$558 sky130_gnd sky130_fd_pr__nfet_01v8 l=0.6 w=1.4 as=0.406
+ ad=0.406 ps=3.38 pd=3.38
X$596 VSS cmc \$558 sky130_gnd sky130_fd_pr__nfet_01v8 l=0.6 w=1.4 as=0.406
+ ad=0.406 ps=3.38 pd=3.38
X$597 VSS cmc \$558 sky130_gnd sky130_fd_pr__nfet_01v8 l=0.6 w=1.4 as=0.406
+ ad=0.406 ps=3.38 pd=3.38
X$598 VSS cmc \$558 sky130_gnd sky130_fd_pr__nfet_01v8 l=0.6 w=1.4 as=0.406
+ ad=0.406 ps=3.38 pd=3.38
X$599 VSS cmc \$558 sky130_gnd sky130_fd_pr__nfet_01v8 l=0.6 w=1.4 as=0.406
+ ad=0.406 ps=3.38 pd=3.38
X$600 VSS cmc \$558 sky130_gnd sky130_fd_pr__nfet_01v8 l=0.6 w=1.4 as=0.406
+ ad=0.406 ps=3.38 pd=3.38
X$601 VSS cmc \$558 sky130_gnd sky130_fd_pr__nfet_01v8 l=0.6 w=1.4 as=0.406
+ ad=0.406 ps=3.38 pd=3.38
X$602 VSS cmc \$558 sky130_gnd sky130_fd_pr__nfet_01v8 l=0.6 w=1.4 as=0.406
+ ad=0.406 ps=3.38 pd=3.38
X$603 \$19 \$247 \$247 sky130_gnd sky130_fd_pr__nfet_01v8 l=0.6 w=1.4 as=0.406
+ ad=0.406 ps=3.38 pd=3.38
X$604 \$19 \$247 \$247 sky130_gnd sky130_fd_pr__nfet_01v8 l=0.6 w=1.4 as=0.406
+ ad=0.406 ps=3.38 pd=3.38
X$605 \$19 \$247 \$247 sky130_gnd sky130_fd_pr__nfet_01v8 l=0.6 w=1.4 as=0.406
+ ad=0.406 ps=3.38 pd=3.38
X$606 \$19 \$247 \$247 sky130_gnd sky130_fd_pr__nfet_01v8 l=0.6 w=1.4 as=0.406
+ ad=0.406 ps=3.38 pd=3.38
X$607 \$19 \$247 \$247 sky130_gnd sky130_fd_pr__nfet_01v8 l=0.6 w=1.4 as=0.406
+ ad=0.406 ps=3.38 pd=3.38
X$608 \$19 \$247 \$247 sky130_gnd sky130_fd_pr__nfet_01v8 l=0.6 w=1.4 as=0.406
+ ad=0.406 ps=3.38 pd=3.38
X$609 \$19 \$247 \$247 sky130_gnd sky130_fd_pr__nfet_01v8 l=0.6 w=1.4 as=0.406
+ ad=0.406 ps=3.38 pd=3.38
X$610 \$19 \$247 \$247 sky130_gnd sky130_fd_pr__nfet_01v8 l=0.6 w=1.4 as=0.406
+ ad=0.406 ps=3.38 pd=3.38
X$611 \$19 \$247 \$247 sky130_gnd sky130_fd_pr__nfet_01v8 l=0.6 w=1.4 as=0.406
+ ad=0.406 ps=3.38 pd=3.38
X$612 \$19 \$247 \$247 sky130_gnd sky130_fd_pr__nfet_01v8 l=0.6 w=1.4 as=0.406
+ ad=0.406 ps=3.38 pd=3.38
X$613 \$19 \$247 \$247 sky130_gnd sky130_fd_pr__nfet_01v8 l=0.6 w=1.4 as=0.406
+ ad=0.406 ps=3.38 pd=3.38
X$614 \$19 \$247 \$247 sky130_gnd sky130_fd_pr__nfet_01v8 l=0.6 w=1.4 as=0.406
+ ad=0.406 ps=3.38 pd=3.38
X$615 \$19 \$247 \$247 sky130_gnd sky130_fd_pr__nfet_01v8 l=0.6 w=1.4 as=0.406
+ ad=0.406 ps=3.38 pd=3.38
X$616 \$19 \$247 \$247 sky130_gnd sky130_fd_pr__nfet_01v8 l=0.6 w=1.4 as=0.406
+ ad=0.406 ps=3.38 pd=3.38
X$617 \$19 \$247 \$247 sky130_gnd sky130_fd_pr__nfet_01v8 l=0.6 w=1.4 as=0.406
+ ad=0.406 ps=3.38 pd=3.38
X$618 \$19 \$247 \$247 sky130_gnd sky130_fd_pr__nfet_01v8 l=0.6 w=1.4 as=0.406
+ ad=0.406 ps=3.38 pd=3.38
X$619 \$19 \$247 \$247 sky130_gnd sky130_fd_pr__nfet_01v8 l=0.6 w=1.4 as=0.406
+ ad=0.406 ps=3.38 pd=3.38
X$620 \$19 \$247 \$247 sky130_gnd sky130_fd_pr__nfet_01v8 l=0.6 w=1.4 as=0.406
+ ad=0.406 ps=3.38 pd=3.38
X$621 \$19 \$247 \$247 sky130_gnd sky130_fd_pr__nfet_01v8 l=0.6 w=1.4 as=0.406
+ ad=0.406 ps=3.38 pd=3.38
X$622 \$19 \$247 \$247 sky130_gnd sky130_fd_pr__nfet_01v8 l=0.6 w=1.4 as=0.406
+ ad=0.406 ps=3.38 pd=3.38
X$623 \$19 \$247 \$247 sky130_gnd sky130_fd_pr__nfet_01v8 l=0.6 w=1.4 as=0.406
+ ad=0.406 ps=3.38 pd=3.38
X$624 \$19 \$247 \$247 sky130_gnd sky130_fd_pr__nfet_01v8 l=0.6 w=1.4 as=0.406
+ ad=0.406 ps=3.38 pd=3.38
X$625 \$19 \$247 \$247 sky130_gnd sky130_fd_pr__nfet_01v8 l=0.6 w=1.4 as=0.406
+ ad=0.406 ps=3.38 pd=3.38
X$626 \$19 \$247 \$247 sky130_gnd sky130_fd_pr__nfet_01v8 l=0.6 w=1.4 as=0.406
+ ad=0.406 ps=3.38 pd=3.38
X$627 \$19 \$247 \$247 sky130_gnd sky130_fd_pr__nfet_01v8 l=0.6 w=1.4 as=0.406
+ ad=0.406 ps=3.38 pd=3.38
X$628 \$19 \$247 \$247 sky130_gnd sky130_fd_pr__nfet_01v8 l=0.6 w=1.4 as=0.406
+ ad=0.406 ps=3.38 pd=3.38
X$629 \$19 \$247 \$247 sky130_gnd sky130_fd_pr__nfet_01v8 l=0.6 w=1.4 as=0.406
+ ad=0.406 ps=3.38 pd=3.38
X$630 \$19 \$247 \$247 sky130_gnd sky130_fd_pr__nfet_01v8 l=0.6 w=1.4 as=0.406
+ ad=0.406 ps=3.38 pd=3.38
X$631 \$19 \$247 \$247 sky130_gnd sky130_fd_pr__nfet_01v8 l=0.6 w=1.4 as=0.406
+ ad=0.406 ps=3.38 pd=3.38
X$632 \$19 \$247 \$247 sky130_gnd sky130_fd_pr__nfet_01v8 l=0.6 w=1.4 as=0.406
+ ad=0.406 ps=3.38 pd=3.38
X$633 \$19 \$247 \$247 sky130_gnd sky130_fd_pr__nfet_01v8 l=0.6 w=1.4 as=0.406
+ ad=0.406 ps=3.38 pd=3.38
X$634 \$19 \$247 \$247 sky130_gnd sky130_fd_pr__nfet_01v8 l=0.6 w=1.4 as=0.406
+ ad=0.406 ps=3.38 pd=3.38
X$635 \$19 \$247 \$247 sky130_gnd sky130_fd_pr__nfet_01v8 l=0.6 w=1.4 as=0.406
+ ad=0.406 ps=3.38 pd=3.38
X$636 \$19 \$247 \$247 sky130_gnd sky130_fd_pr__nfet_01v8 l=0.6 w=1.4 as=0.406
+ ad=0.406 ps=3.38 pd=3.38
X$637 \$19 \$247 \$247 sky130_gnd sky130_fd_pr__nfet_01v8 l=0.6 w=1.4 as=0.406
+ ad=0.406 ps=3.38 pd=3.38
X$638 \$19 \$247 \$247 sky130_gnd sky130_fd_pr__nfet_01v8 l=0.6 w=1.4 as=0.406
+ ad=0.406 ps=3.38 pd=3.38
X$639 \$19 \$247 \$247 sky130_gnd sky130_fd_pr__nfet_01v8 l=0.6 w=1.4 as=0.406
+ ad=0.406 ps=3.38 pd=3.38
X$640 \$19 \$247 \$247 sky130_gnd sky130_fd_pr__nfet_01v8 l=0.6 w=1.4 as=0.406
+ ad=0.406 ps=3.38 pd=3.38
X$641 \$19 \$247 \$247 sky130_gnd sky130_fd_pr__nfet_01v8 l=0.6 w=1.4 as=0.406
+ ad=0.406 ps=3.38 pd=3.38
X$642 \$19 \$247 \$247 sky130_gnd sky130_fd_pr__nfet_01v8 l=0.6 w=1.4 as=0.406
+ ad=0.406 ps=3.38 pd=3.38
X$643 \$19 \$247 \$247 sky130_gnd sky130_fd_pr__nfet_01v8 l=0.6 w=1.4 as=0.406
+ ad=0.406 ps=3.38 pd=3.38
X$644 \$19 \$247 \$247 sky130_gnd sky130_fd_pr__nfet_01v8 l=0.6 w=1.4 as=0.406
+ ad=0.406 ps=3.38 pd=3.38
X$645 \$19 \$247 \$247 sky130_gnd sky130_fd_pr__nfet_01v8 l=0.6 w=1.4 as=0.406
+ ad=0.406 ps=3.38 pd=3.38
X$646 \$19 \$247 \$247 sky130_gnd sky130_fd_pr__nfet_01v8 l=0.6 w=1.4 as=0.406
+ ad=0.406 ps=3.38 pd=3.38
X$647 \$19 \$247 \$247 sky130_gnd sky130_fd_pr__nfet_01v8 l=0.6 w=1.4 as=0.406
+ ad=0.406 ps=3.38 pd=3.38
X$648 \$19 \$247 \$247 sky130_gnd sky130_fd_pr__nfet_01v8 l=0.6 w=1.4 as=0.406
+ ad=0.406 ps=3.38 pd=3.38
X$649 \$19 \$247 \$247 sky130_gnd sky130_fd_pr__nfet_01v8 l=0.6 w=1.4 as=0.406
+ ad=0.406 ps=3.38 pd=3.38
X$650 \$19 \$247 \$247 sky130_gnd sky130_fd_pr__nfet_01v8 l=0.6 w=1.4 as=0.406
+ ad=0.406 ps=3.38 pd=3.38
X$651 \$19 \$247 \$247 sky130_gnd sky130_fd_pr__nfet_01v8 l=0.6 w=1.4 as=0.406
+ ad=0.406 ps=3.38 pd=3.38
X$652 \$19 \$247 \$247 sky130_gnd sky130_fd_pr__nfet_01v8 l=0.6 w=1.4 as=0.406
+ ad=0.406 ps=3.38 pd=3.38
X$653 \$130 cm \$27.x1_net1 sky130_gnd sky130_fd_pr__nfet_01v8 l=0.6 w=1.4
+ as=0.406 ad=0.406 ps=3.38 pd=3.38
X$654 VSS VSS VSS sky130_gnd sky130_fd_pr__nfet_01v8 l=0.6 w=1.4 as=0.406
+ ad=0.406 ps=3.38 pd=3.38
X$655 VSS VSS VSS sky130_gnd sky130_fd_pr__nfet_01v8 l=0.6 w=1.4 as=0.406
+ ad=0.406 ps=3.38 pd=3.38
X$656 \$27.x1_net1 cm cm sky130_gnd sky130_fd_pr__nfet_01v8 l=0.6 w=1.4
+ as=0.406 ad=0.406 ps=3.38 pd=3.38
X$657 \$291 cm \$26.x1_net13 sky130_gnd sky130_fd_pr__nfet_01v8 l=0.6 w=1.4
+ as=0.406 ad=0.406 ps=3.38 pd=3.38
X$658 VSS VSS VSS sky130_gnd sky130_fd_pr__nfet_01v8 l=0.6 w=1.4 as=0.406
+ ad=0.406 ps=3.38 pd=3.38
X$659 VSS VSS VSS sky130_gnd sky130_fd_pr__nfet_01v8 l=0.6 w=1.4 as=0.406
+ ad=0.406 ps=3.38 pd=3.38
X$660 \$26.x1_net13 cm cm sky130_gnd sky130_fd_pr__nfet_01v8 l=0.6 w=1.4
+ as=0.406 ad=0.406 ps=3.38 pd=3.38
X$661 \$19.x1_net15 cm \$291 sky130_gnd sky130_fd_pr__nfet_01v8 l=0.6 w=1.4
+ as=0.406 ad=0.406 ps=3.38 pd=3.38
X$662 VSS VSS VSS sky130_gnd sky130_fd_pr__nfet_01v8 l=0.6 w=1.4 as=0.406
+ ad=0.406 ps=3.38 pd=3.38
X$663 VSS VSS VSS sky130_gnd sky130_fd_pr__nfet_01v8 l=0.6 w=1.4 as=0.406
+ ad=0.406 ps=3.38 pd=3.38
X$664 VSS cm \$19.x1_net15 sky130_gnd sky130_fd_pr__nfet_01v8 l=0.6 w=1.4
+ as=0.406 ad=0.406 ps=3.38 pd=3.38
X$665 \$133 cm \$23.x1_net10 sky130_gnd sky130_fd_pr__nfet_01v8 l=0.6 w=1.4
+ as=0.406 ad=0.406 ps=3.38 pd=3.38
X$666 VSS VSS VSS sky130_gnd sky130_fd_pr__nfet_01v8 l=0.6 w=1.4 as=0.406
+ ad=0.406 ps=3.38 pd=3.38
X$667 VSS VSS VSS sky130_gnd sky130_fd_pr__nfet_01v8 l=0.6 w=1.4 as=0.406
+ ad=0.406 ps=3.38 pd=3.38
X$668 \$23.x1_net10 cm cm sky130_gnd sky130_fd_pr__nfet_01v8 l=0.6 w=1.4
+ as=0.406 ad=0.406 ps=3.38 pd=3.38
X$669 \$132 cm \$20.x1_net7 sky130_gnd sky130_fd_pr__nfet_01v8 l=0.6 w=1.4
+ as=0.406 ad=0.406 ps=3.38 pd=3.38
X$670 VSS VSS VSS sky130_gnd sky130_fd_pr__nfet_01v8 l=0.6 w=1.4 as=0.406
+ ad=0.406 ps=3.38 pd=3.38
X$671 VSS VSS VSS sky130_gnd sky130_fd_pr__nfet_01v8 l=0.6 w=1.4 as=0.406
+ ad=0.406 ps=3.38 pd=3.38
X$672 \$20.x1_net7 cm cm sky130_gnd sky130_fd_pr__nfet_01v8 l=0.6 w=1.4
+ as=0.406 ad=0.406 ps=3.38 pd=3.38
X$673 \$131 cm \$22.x1_net4 sky130_gnd sky130_fd_pr__nfet_01v8 l=0.6 w=1.4
+ as=0.406 ad=0.406 ps=3.38 pd=3.38
X$674 VSS VSS VSS sky130_gnd sky130_fd_pr__nfet_01v8 l=0.6 w=1.4 as=0.406
+ ad=0.406 ps=3.38 pd=3.38
X$675 VSS VSS VSS sky130_gnd sky130_fd_pr__nfet_01v8 l=0.6 w=1.4 as=0.406
+ ad=0.406 ps=3.38 pd=3.38
X$676 \$22.x1_net4 cm cm sky130_gnd sky130_fd_pr__nfet_01v8 l=0.6 w=1.4
+ as=0.406 ad=0.406 ps=3.38 pd=3.38
X$677 \$17.x1_net12 cm \$133 sky130_gnd sky130_fd_pr__nfet_01v8 l=0.6 w=1.4
+ as=0.406 ad=0.406 ps=3.38 pd=3.38
X$678 VSS VSS VSS sky130_gnd sky130_fd_pr__nfet_01v8 l=0.6 w=1.4 as=0.406
+ ad=0.406 ps=3.38 pd=3.38
X$679 VSS VSS VSS sky130_gnd sky130_fd_pr__nfet_01v8 l=0.6 w=1.4 as=0.406
+ ad=0.406 ps=3.38 pd=3.38
X$680 VSS cm \$17.x1_net12 sky130_gnd sky130_fd_pr__nfet_01v8 l=0.6 w=1.4
+ as=0.406 ad=0.406 ps=3.38 pd=3.38
X$681 \$16.x1_net9 cm \$132 sky130_gnd sky130_fd_pr__nfet_01v8 l=0.6 w=1.4
+ as=0.406 ad=0.406 ps=3.38 pd=3.38
X$682 VSS VSS VSS sky130_gnd sky130_fd_pr__nfet_01v8 l=0.6 w=1.4 as=0.406
+ ad=0.406 ps=3.38 pd=3.38
X$683 VSS VSS VSS sky130_gnd sky130_fd_pr__nfet_01v8 l=0.6 w=1.4 as=0.406
+ ad=0.406 ps=3.38 pd=3.38
X$684 VSS cm \$16.x1_net9 sky130_gnd sky130_fd_pr__nfet_01v8 l=0.6 w=1.4
+ as=0.406 ad=0.406 ps=3.38 pd=3.38
X$685 \$15.x1_net6 cm \$131 sky130_gnd sky130_fd_pr__nfet_01v8 l=0.6 w=1.4
+ as=0.406 ad=0.406 ps=3.38 pd=3.38
X$686 VSS VSS VSS sky130_gnd sky130_fd_pr__nfet_01v8 l=0.6 w=1.4 as=0.406
+ ad=0.406 ps=3.38 pd=3.38
X$687 VSS VSS VSS sky130_gnd sky130_fd_pr__nfet_01v8 l=0.6 w=1.4 as=0.406
+ ad=0.406 ps=3.38 pd=3.38
X$688 VSS cm \$15.x1_net6 sky130_gnd sky130_fd_pr__nfet_01v8 l=0.6 w=1.4
+ as=0.406 ad=0.406 ps=3.38 pd=3.38
X$689 \$14.x1_net3 cm \$130 sky130_gnd sky130_fd_pr__nfet_01v8 l=0.6 w=1.4
+ as=0.406 ad=0.406 ps=3.38 pd=3.38
X$690 VSS VSS VSS sky130_gnd sky130_fd_pr__nfet_01v8 l=0.6 w=1.4 as=0.406
+ ad=0.406 ps=3.38 pd=3.38
X$691 VSS VSS VSS sky130_gnd sky130_fd_pr__nfet_01v8 l=0.6 w=1.4 as=0.406
+ ad=0.406 ps=3.38 pd=3.38
X$692 VSS cm \$14.x1_net3 sky130_gnd sky130_fd_pr__nfet_01v8 l=0.6 w=1.4
+ as=0.406 ad=0.406 ps=3.38 pd=3.38
X$693 VSS VSS on sky130_gnd sky130_fd_pr__nfet_01v8 l=0.6 w=1.4 as=0.406
+ ad=0.406 ps=3.38 pd=3.38
X$694 VSS VSS on sky130_gnd sky130_fd_pr__nfet_01v8 l=0.6 w=1.4 as=0.406
+ ad=0.406 ps=3.38 pd=3.38
X$695 VSS VSS \$558 sky130_gnd sky130_fd_pr__nfet_01v8 l=0.6 w=1.4 as=0.406
+ ad=0.406 ps=3.38 pd=3.38
X$696 VSS VSS \$558 sky130_gnd sky130_fd_pr__nfet_01v8 l=0.6 w=1.4 as=0.406
+ ad=0.406 ps=3.38 pd=3.38
X$697 VSS VSS op sky130_gnd sky130_fd_pr__nfet_01v8 l=0.6 w=1.4 as=0.406
+ ad=0.406 ps=3.38 pd=3.38
X$698 VSS VSS op sky130_gnd sky130_fd_pr__nfet_01v8 l=0.6 w=1.4 as=0.406
+ ad=0.406 ps=3.38 pd=3.38
X$699 op op op sky130_gnd sky130_fd_pr__nfet_01v8 l=0.6 w=1.4 as=0.406 ad=0.406
+ ps=3.38 pd=3.38
X$700 op op op sky130_gnd sky130_fd_pr__nfet_01v8 l=0.6 w=1.4 as=0.406 ad=0.406
+ ps=3.38 pd=3.38
X$701 on on on sky130_gnd sky130_fd_pr__nfet_01v8 l=0.6 w=1.4 as=0.406 ad=0.406
+ ps=3.38 pd=3.38
X$702 on on on sky130_gnd sky130_fd_pr__nfet_01v8 l=0.6 w=1.4 as=0.406 ad=0.406
+ ps=3.38 pd=3.38
X$703 bias_a \$247 \$19 sky130_gnd sky130_fd_pr__nfet_01v8 l=0.6 w=1.4 as=0.406
+ ad=0.406 ps=3.38 pd=3.38
X$704 bias_a \$247 \$19 sky130_gnd sky130_fd_pr__nfet_01v8 l=0.6 w=1.4 as=0.406
+ ad=0.406 ps=3.38 pd=3.38
X$705 \$247 \$247 \$247 sky130_gnd sky130_fd_pr__nfet_01v8 l=0.6 w=1.4 as=0.406
+ ad=0.406 ps=3.38 pd=3.38
X$706 \$247 \$247 \$247 sky130_gnd sky130_fd_pr__nfet_01v8 l=0.6 w=1.4 as=0.406
+ ad=0.406 ps=3.38 pd=3.38
X$707 IBIAS IBIAS IBIAS sky130_gnd sky130_fd_pr__nfet_01v8 l=0.6 w=1.4 as=0.406
+ ad=0.406 ps=3.38 pd=3.38
X$708 IBIAS IBIAS IBIAS sky130_gnd sky130_fd_pr__nfet_01v8 l=0.6 w=1.4 as=0.406
+ ad=0.406 ps=3.38 pd=3.38
X$709 \$16 \$16 \$16 sky130_gnd sky130_fd_pr__nfet_01v8 l=0.6 w=1.4 as=0.406
+ ad=0.406 ps=3.38 pd=3.38
X$710 \$16 \$16 \$16 sky130_gnd sky130_fd_pr__nfet_01v8 l=0.6 w=1.4 as=0.406
+ ad=0.406 ps=3.38 pd=3.38
X$711 VSS IBIAS \$16 sky130_gnd sky130_fd_pr__nfet_01v8 l=0.6 w=1.4 as=0.406
+ ad=0.406 ps=3.38 pd=3.38
X$712 VSS IBIAS \$16 sky130_gnd sky130_fd_pr__nfet_01v8 l=0.6 w=1.4 as=0.406
+ ad=0.406 ps=3.38 pd=3.38
X$713 VSS IBIAS \$16 sky130_gnd sky130_fd_pr__nfet_01v8 l=0.6 w=1.4 as=0.406
+ ad=0.406 ps=3.38 pd=3.38
X$714 VSS IBIAS \$16 sky130_gnd sky130_fd_pr__nfet_01v8 l=0.6 w=1.4 as=0.406
+ ad=0.406 ps=3.38 pd=3.38
X$715 VSS IBIAS \$16 sky130_gnd sky130_fd_pr__nfet_01v8 l=0.6 w=1.4 as=0.406
+ ad=0.406 ps=3.38 pd=3.38
X$716 VSS IBIAS \$16 sky130_gnd sky130_fd_pr__nfet_01v8 l=0.6 w=1.4 as=0.406
+ ad=0.406 ps=3.38 pd=3.38
X$717 VSS IBIAS \$16 sky130_gnd sky130_fd_pr__nfet_01v8 l=0.6 w=1.4 as=0.406
+ ad=0.406 ps=3.38 pd=3.38
X$718 VSS IBIAS \$16 sky130_gnd sky130_fd_pr__nfet_01v8 l=0.6 w=1.4 as=0.406
+ ad=0.406 ps=3.38 pd=3.38
X$719 VSS IBIAS \$16 sky130_gnd sky130_fd_pr__nfet_01v8 l=0.6 w=1.4 as=0.406
+ ad=0.406 ps=3.38 pd=3.38
X$720 VSS IBIAS \$16 sky130_gnd sky130_fd_pr__nfet_01v8 l=0.6 w=1.4 as=0.406
+ ad=0.406 ps=3.38 pd=3.38
X$721 VSS IBIAS \$16 sky130_gnd sky130_fd_pr__nfet_01v8 l=0.6 w=1.4 as=0.406
+ ad=0.406 ps=3.38 pd=3.38
X$722 VSS IBIAS \$16 sky130_gnd sky130_fd_pr__nfet_01v8 l=0.6 w=1.4 as=0.406
+ ad=0.406 ps=3.38 pd=3.38
X$723 VSS IBIAS \$16 sky130_gnd sky130_fd_pr__nfet_01v8 l=0.6 w=1.4 as=0.406
+ ad=0.406 ps=3.38 pd=3.38
X$724 VSS IBIAS \$16 sky130_gnd sky130_fd_pr__nfet_01v8 l=0.6 w=1.4 as=0.406
+ ad=0.406 ps=3.38 pd=3.38
X$725 VSS IBIAS \$16 sky130_gnd sky130_fd_pr__nfet_01v8 l=0.6 w=1.4 as=0.406
+ ad=0.406 ps=3.38 pd=3.38
X$726 VSS IBIAS \$16 sky130_gnd sky130_fd_pr__nfet_01v8 l=0.6 w=1.4 as=0.406
+ ad=0.406 ps=3.38 pd=3.38
X$727 VSS IBIAS \$16 sky130_gnd sky130_fd_pr__nfet_01v8 l=0.6 w=1.4 as=0.406
+ ad=0.406 ps=3.38 pd=3.38
X$728 VSS IBIAS \$16 sky130_gnd sky130_fd_pr__nfet_01v8 l=0.6 w=1.4 as=0.406
+ ad=0.406 ps=3.38 pd=3.38
X$729 VSS VSS VSS sky130_gnd sky130_fd_pr__nfet_01v8 l=0.6 w=1.4 as=0.406
+ ad=0.406 ps=3.38 pd=3.38
X$730 VSS IBIAS IBIAS sky130_gnd sky130_fd_pr__nfet_01v8 l=0.6 w=1.4 as=0.406
+ ad=0.406 ps=3.38 pd=3.38
X$731 VSS IBIAS IBIAS sky130_gnd sky130_fd_pr__nfet_01v8 l=0.6 w=1.4 as=0.406
+ ad=0.406 ps=3.38 pd=3.38
X$732 VSS IBIAS IBIAS sky130_gnd sky130_fd_pr__nfet_01v8 l=0.6 w=1.4 as=0.406
+ ad=0.406 ps=3.38 pd=3.38
X$733 VSS IBIAS IBIAS sky130_gnd sky130_fd_pr__nfet_01v8 l=0.6 w=1.4 as=0.406
+ ad=0.406 ps=3.38 pd=3.38
X$734 VSS VSS VSS sky130_gnd sky130_fd_pr__nfet_01v8 l=0.6 w=1.4 as=0.406
+ ad=0.406 ps=3.38 pd=3.38
X$735 VSS IBIAS IBIAS sky130_gnd sky130_fd_pr__nfet_01v8 l=0.6 w=1.4 as=0.406
+ ad=0.406 ps=3.38 pd=3.38
X$736 VSS IBIAS IBIAS sky130_gnd sky130_fd_pr__nfet_01v8 l=0.6 w=1.4 as=0.406
+ ad=0.406 ps=3.38 pd=3.38
X$737 VSS IBIAS IBIAS sky130_gnd sky130_fd_pr__nfet_01v8 l=0.6 w=1.4 as=0.406
+ ad=0.406 ps=3.38 pd=3.38
X$738 VSS IBIAS IBIAS sky130_gnd sky130_fd_pr__nfet_01v8 l=0.6 w=1.4 as=0.406
+ ad=0.406 ps=3.38 pd=3.38
X$739 VSS IBIAS IBIAS sky130_gnd sky130_fd_pr__nfet_01v8 l=0.6 w=1.4 as=0.406
+ ad=0.406 ps=3.38 pd=3.38
X$740 VSS IBIAS IBIAS sky130_gnd sky130_fd_pr__nfet_01v8 l=0.6 w=1.4 as=0.406
+ ad=0.406 ps=3.38 pd=3.38
X$741 VSS IBIAS IBIAS sky130_gnd sky130_fd_pr__nfet_01v8 l=0.6 w=1.4 as=0.406
+ ad=0.406 ps=3.38 pd=3.38
X$742 VSS IBIAS IBIAS sky130_gnd sky130_fd_pr__nfet_01v8 l=0.6 w=1.4 as=0.406
+ ad=0.406 ps=3.38 pd=3.38
X$743 VSS IBIAS IBIAS sky130_gnd sky130_fd_pr__nfet_01v8 l=0.6 w=1.4 as=0.406
+ ad=0.406 ps=3.38 pd=3.38
X$744 VSS IBIAS IBIAS sky130_gnd sky130_fd_pr__nfet_01v8 l=0.6 w=1.4 as=0.406
+ ad=0.406 ps=3.38 pd=3.38
X$745 VSS IBIAS IBIAS sky130_gnd sky130_fd_pr__nfet_01v8 l=0.6 w=1.4 as=0.406
+ ad=0.406 ps=3.38 pd=3.38
X$746 VSS IBIAS IBIAS sky130_gnd sky130_fd_pr__nfet_01v8 l=0.6 w=1.4 as=0.406
+ ad=0.406 ps=3.38 pd=3.38
X$747 VSS IBIAS IBIAS sky130_gnd sky130_fd_pr__nfet_01v8 l=0.6 w=1.4 as=0.406
+ ad=0.406 ps=3.38 pd=3.38
X$748 VSS IBIAS IBIAS sky130_gnd sky130_fd_pr__nfet_01v8 l=0.6 w=1.4 as=0.406
+ ad=0.406 ps=3.38 pd=3.38
X$749 \$18 \$19 bias_a sky130_gnd sky130_fd_pr__nfet_01v8 l=0.6 w=1.4 as=0.406
+ ad=0.406 ps=3.38 pd=3.38
X$750 \$18 \$19 bias_a sky130_gnd sky130_fd_pr__nfet_01v8 l=0.6 w=1.4 as=0.406
+ ad=0.406 ps=3.38 pd=3.38
X$751 \$18 \$19 bias_a sky130_gnd sky130_fd_pr__nfet_01v8 l=0.6 w=1.4 as=0.406
+ ad=0.406 ps=3.38 pd=3.38
X$752 \$18 \$19 bias_a sky130_gnd sky130_fd_pr__nfet_01v8 l=0.6 w=1.4 as=0.406
+ ad=0.406 ps=3.38 pd=3.38
X$753 \$18 \$19 bias_a sky130_gnd sky130_fd_pr__nfet_01v8 l=0.6 w=1.4 as=0.406
+ ad=0.406 ps=3.38 pd=3.38
X$754 \$18 \$19 bias_a sky130_gnd sky130_fd_pr__nfet_01v8 l=0.6 w=1.4 as=0.406
+ ad=0.406 ps=3.38 pd=3.38
X$755 \$18 \$19 bias_a sky130_gnd sky130_fd_pr__nfet_01v8 l=0.6 w=1.4 as=0.406
+ ad=0.406 ps=3.38 pd=3.38
X$756 \$18 \$19 bias_a sky130_gnd sky130_fd_pr__nfet_01v8 l=0.6 w=1.4 as=0.406
+ ad=0.406 ps=3.38 pd=3.38
X$757 \$18 \$19 bias_a sky130_gnd sky130_fd_pr__nfet_01v8 l=0.6 w=1.4 as=0.406
+ ad=0.406 ps=3.38 pd=3.38
X$758 \$18 \$19 bias_a sky130_gnd sky130_fd_pr__nfet_01v8 l=0.6 w=1.4 as=0.406
+ ad=0.406 ps=3.38 pd=3.38
X$759 \$18 \$19 bias_a sky130_gnd sky130_fd_pr__nfet_01v8 l=0.6 w=1.4 as=0.406
+ ad=0.406 ps=3.38 pd=3.38
X$760 \$18 \$19 bias_a sky130_gnd sky130_fd_pr__nfet_01v8 l=0.6 w=1.4 as=0.406
+ ad=0.406 ps=3.38 pd=3.38
X$761 \$18 \$19 bias_a sky130_gnd sky130_fd_pr__nfet_01v8 l=0.6 w=1.4 as=0.406
+ ad=0.406 ps=3.38 pd=3.38
X$762 \$18 \$19 bias_a sky130_gnd sky130_fd_pr__nfet_01v8 l=0.6 w=1.4 as=0.406
+ ad=0.406 ps=3.38 pd=3.38
X$763 \$18 \$19 bias_a sky130_gnd sky130_fd_pr__nfet_01v8 l=0.6 w=1.4 as=0.406
+ ad=0.406 ps=3.38 pd=3.38
X$764 \$18 \$19 bias_a sky130_gnd sky130_fd_pr__nfet_01v8 l=0.6 w=1.4 as=0.406
+ ad=0.406 ps=3.38 pd=3.38
X$765 \$18 \$19 bias_a sky130_gnd sky130_fd_pr__nfet_01v8 l=0.6 w=1.4 as=0.406
+ ad=0.406 ps=3.38 pd=3.38
X$766 \$18 \$19 bias_a sky130_gnd sky130_fd_pr__nfet_01v8 l=0.6 w=1.4 as=0.406
+ ad=0.406 ps=3.38 pd=3.38
X$767 VSS bias_a \$18 sky130_gnd sky130_fd_pr__nfet_01v8 l=0.6 w=1.4 as=0.406
+ ad=0.406 ps=3.38 pd=3.38
X$768 VSS bias_a \$18 sky130_gnd sky130_fd_pr__nfet_01v8 l=0.6 w=1.4 as=0.406
+ ad=0.406 ps=3.38 pd=3.38
X$769 VSS bias_a \$18 sky130_gnd sky130_fd_pr__nfet_01v8 l=0.6 w=1.4 as=0.406
+ ad=0.406 ps=3.38 pd=3.38
X$770 VSS bias_a \$18 sky130_gnd sky130_fd_pr__nfet_01v8 l=0.6 w=1.4 as=0.406
+ ad=0.406 ps=3.38 pd=3.38
X$771 VSS bias_a \$18 sky130_gnd sky130_fd_pr__nfet_01v8 l=0.6 w=1.4 as=0.406
+ ad=0.406 ps=3.38 pd=3.38
X$772 VSS bias_a \$18 sky130_gnd sky130_fd_pr__nfet_01v8 l=0.6 w=1.4 as=0.406
+ ad=0.406 ps=3.38 pd=3.38
X$773 VSS bias_a \$18 sky130_gnd sky130_fd_pr__nfet_01v8 l=0.6 w=1.4 as=0.406
+ ad=0.406 ps=3.38 pd=3.38
X$774 VSS bias_a \$18 sky130_gnd sky130_fd_pr__nfet_01v8 l=0.6 w=1.4 as=0.406
+ ad=0.406 ps=3.38 pd=3.38
X$775 VSS bias_a \$18 sky130_gnd sky130_fd_pr__nfet_01v8 l=0.6 w=1.4 as=0.406
+ ad=0.406 ps=3.38 pd=3.38
X$776 VSS bias_a \$18 sky130_gnd sky130_fd_pr__nfet_01v8 l=0.6 w=1.4 as=0.406
+ ad=0.406 ps=3.38 pd=3.38
X$777 VSS bias_a \$18 sky130_gnd sky130_fd_pr__nfet_01v8 l=0.6 w=1.4 as=0.406
+ ad=0.406 ps=3.38 pd=3.38
X$778 VSS bias_a \$18 sky130_gnd sky130_fd_pr__nfet_01v8 l=0.6 w=1.4 as=0.406
+ ad=0.406 ps=3.38 pd=3.38
X$779 VSS bias_a \$18 sky130_gnd sky130_fd_pr__nfet_01v8 l=0.6 w=1.4 as=0.406
+ ad=0.406 ps=3.38 pd=3.38
X$780 VSS bias_a \$18 sky130_gnd sky130_fd_pr__nfet_01v8 l=0.6 w=1.4 as=0.406
+ ad=0.406 ps=3.38 pd=3.38
X$781 VSS bias_a \$18 sky130_gnd sky130_fd_pr__nfet_01v8 l=0.6 w=1.4 as=0.406
+ ad=0.406 ps=3.38 pd=3.38
X$782 VSS bias_a \$18 sky130_gnd sky130_fd_pr__nfet_01v8 l=0.6 w=1.4 as=0.406
+ ad=0.406 ps=3.38 pd=3.38
X$783 VSS bias_a \$18 sky130_gnd sky130_fd_pr__nfet_01v8 l=0.6 w=1.4 as=0.406
+ ad=0.406 ps=3.38 pd=3.38
X$784 VSS bias_a \$18 sky130_gnd sky130_fd_pr__nfet_01v8 l=0.6 w=1.4 as=0.406
+ ad=0.406 ps=3.38 pd=3.38
X$785 VSS VSS VSS sky130_gnd sky130_fd_pr__nfet_01v8 l=0.6 w=1.4 as=0.406
+ ad=0.406 ps=3.38 pd=3.38
X$786 VSS VSS VSS sky130_gnd sky130_fd_pr__nfet_01v8 l=0.6 w=1.4 as=0.406
+ ad=0.406 ps=3.38 pd=3.38
X$787 VSS VSS VSS sky130_gnd sky130_fd_pr__nfet_01v8 l=0.6 w=1.4 as=0.406
+ ad=0.406 ps=3.38 pd=3.38
X$788 VSS VSS VSS sky130_gnd sky130_fd_pr__nfet_01v8 l=0.6 w=1.4 as=0.406
+ ad=0.406 ps=3.38 pd=3.38
X$789 VSS VSS VSS sky130_gnd sky130_fd_pr__nfet_01v8 l=0.6 w=1.4 as=0.406
+ ad=0.406 ps=3.38 pd=3.38
X$790 VSS VSS VSS sky130_gnd sky130_fd_pr__nfet_01v8 l=0.6 w=1.4 as=0.406
+ ad=0.406 ps=3.38 pd=3.38
X$791 VSS VSS VSS sky130_gnd sky130_fd_pr__nfet_01v8 l=0.6 w=1.4 as=0.406
+ ad=0.406 ps=3.38 pd=3.38
X$792 VSS VSS VSS sky130_gnd sky130_fd_pr__nfet_01v8 l=0.6 w=1.4 as=0.406
+ ad=0.406 ps=3.38 pd=3.38
X$793 VSS VSS VSS sky130_gnd sky130_fd_pr__nfet_01v8 l=0.6 w=1.4 as=0.406
+ ad=0.406 ps=3.38 pd=3.38
X$794 VSS VSS VSS sky130_gnd sky130_fd_pr__nfet_01v8 l=0.6 w=1.4 as=0.406
+ ad=0.406 ps=3.38 pd=3.38
X$795 VSS VSS VSS sky130_gnd sky130_fd_pr__nfet_01v8 l=0.6 w=1.4 as=0.406
+ ad=0.406 ps=3.38 pd=3.38
X$796 VSS VSS VSS sky130_gnd sky130_fd_pr__nfet_01v8 l=0.6 w=1.4 as=0.406
+ ad=0.406 ps=3.38 pd=3.38
X$797 VSS VSS VSS sky130_gnd sky130_fd_pr__nfet_01v8 l=0.6 w=1.4 as=0.406
+ ad=0.406 ps=3.38 pd=3.38
X$798 VSS VSS VSS sky130_gnd sky130_fd_pr__nfet_01v8 l=0.6 w=1.4 as=0.406
+ ad=0.406 ps=3.38 pd=3.38
X$799 VSS VSS VSS sky130_gnd sky130_fd_pr__nfet_01v8 l=0.6 w=1.4 as=0.406
+ ad=0.406 ps=3.38 pd=3.38
X$800 VSS VSS VSS sky130_gnd sky130_fd_pr__nfet_01v8 l=0.6 w=1.4 as=0.406
+ ad=0.406 ps=3.38 pd=3.38
X$801 VSS VSS VSS sky130_gnd sky130_fd_pr__nfet_01v8 l=0.6 w=1.4 as=0.406
+ ad=0.406 ps=3.38 pd=3.38
X$802 VSS VSS VSS sky130_gnd sky130_fd_pr__nfet_01v8 l=0.6 w=1.4 as=0.406
+ ad=0.406 ps=3.38 pd=3.38
X$803 VSS VSS VSS sky130_gnd sky130_fd_pr__nfet_01v8 l=0.6 w=1.4 as=0.406
+ ad=0.406 ps=3.38 pd=3.38
X$804 VSS VSS VSS sky130_gnd sky130_fd_pr__nfet_01v8 l=0.6 w=1.4 as=0.406
+ ad=0.406 ps=3.38 pd=3.38
X$805 VSS VSS VSS sky130_gnd sky130_fd_pr__nfet_01v8 l=0.6 w=1.4 as=0.406
+ ad=0.406 ps=3.38 pd=3.38
X$806 VSS VSS VSS sky130_gnd sky130_fd_pr__nfet_01v8 l=0.6 w=1.4 as=0.406
+ ad=0.406 ps=3.38 pd=3.38
X$807 VSS VSS VSS sky130_gnd sky130_fd_pr__nfet_01v8 l=0.6 w=1.4 as=0.406
+ ad=0.406 ps=3.38 pd=3.38
X$808 bias_a bias_a bias_a sky130_gnd sky130_fd_pr__nfet_01v8 l=0.6 w=1.4
+ as=0.406 ad=0.406 ps=3.38 pd=3.38
X$809 bias_a bias_a bias_a sky130_gnd sky130_fd_pr__nfet_01v8 l=0.6 w=1.4
+ as=0.406 ad=0.406 ps=3.38 pd=3.38
X$810 bias_a bias_a bias_a sky130_gnd sky130_fd_pr__nfet_01v8 l=0.6 w=1.4
+ as=0.406 ad=0.406 ps=3.38 pd=3.38
X$811 bias_a bias_a bias_a sky130_gnd sky130_fd_pr__nfet_01v8 l=0.6 w=1.4
+ as=0.406 ad=0.406 ps=3.38 pd=3.38
X$812 VSS VSS \$621 sky130_gnd sky130_fd_pr__nfet_01v8 l=0.6 w=1.4 as=0.406
+ ad=0.406 ps=3.38 pd=3.38
X$813 VSS VSS \$621 sky130_gnd sky130_fd_pr__nfet_01v8 l=0.6 w=1.4 as=0.406
+ ad=0.406 ps=3.38 pd=3.38
X$814 VSS VSS \$621 sky130_gnd sky130_fd_pr__nfet_01v8 l=0.6 w=1.4 as=0.406
+ ad=0.406 ps=3.38 pd=3.38
X$815 VSS VSS \$621 sky130_gnd sky130_fd_pr__nfet_01v8 l=0.6 w=1.4 as=0.406
+ ad=0.406 ps=3.38 pd=3.38
X$816 VSS VSS \$621 sky130_gnd sky130_fd_pr__nfet_01v8 l=0.6 w=1.4 as=0.406
+ ad=0.406 ps=3.38 pd=3.38
X$817 VSS VSS \$621 sky130_gnd sky130_fd_pr__nfet_01v8 l=0.6 w=1.4 as=0.406
+ ad=0.406 ps=3.38 pd=3.38
X$818 VSS VSS \$621 sky130_gnd sky130_fd_pr__nfet_01v8 l=0.6 w=1.4 as=0.406
+ ad=0.406 ps=3.38 pd=3.38
X$819 VSS VSS \$621 sky130_gnd sky130_fd_pr__nfet_01v8 l=0.6 w=1.4 as=0.406
+ ad=0.406 ps=3.38 pd=3.38
X$820 cm cm cm sky130_gnd sky130_fd_pr__nfet_01v8 l=0.6 w=1.4 as=0.406 ad=0.406
+ ps=3.38 pd=3.38
X$821 cm cm cm sky130_gnd sky130_fd_pr__nfet_01v8 l=0.6 w=1.4 as=0.406 ad=0.406
+ ps=3.38 pd=3.38
X$822 cm cm cm sky130_gnd sky130_fd_pr__nfet_01v8 l=0.6 w=1.4 as=0.406 ad=0.406
+ ps=3.38 pd=3.38
X$823 cm cm cm sky130_gnd sky130_fd_pr__nfet_01v8 l=0.6 w=1.4 as=0.406 ad=0.406
+ ps=3.38 pd=3.38
X$824 cm cm cm sky130_gnd sky130_fd_pr__nfet_01v8 l=0.6 w=1.4 as=0.406 ad=0.406
+ ps=3.38 pd=3.38
X$825 cm cm cm sky130_gnd sky130_fd_pr__nfet_01v8 l=0.6 w=1.4 as=0.406 ad=0.406
+ ps=3.38 pd=3.38
X$826 cm cm cm sky130_gnd sky130_fd_pr__nfet_01v8 l=0.6 w=1.4 as=0.406 ad=0.406
+ ps=3.38 pd=3.38
X$827 cm cm cm sky130_gnd sky130_fd_pr__nfet_01v8 l=0.6 w=1.4 as=0.406 ad=0.406
+ ps=3.38 pd=3.38
X$828 \$19 \$19 \$19 sky130_gnd sky130_fd_pr__nfet_01v8 l=0.6 w=1.4 as=0.406
+ ad=0.406 ps=3.38 pd=3.38
X$829 \$19 \$19 \$19 sky130_gnd sky130_fd_pr__nfet_01v8 l=0.6 w=1.4 as=0.406
+ ad=0.406 ps=3.38 pd=3.38
X$830 \$19 \$19 \$19 sky130_gnd sky130_fd_pr__nfet_01v8 l=0.6 w=1.4 as=0.406
+ ad=0.406 ps=3.38 pd=3.38
X$831 \$19 \$19 \$19 sky130_gnd sky130_fd_pr__nfet_01v8 l=0.6 w=1.4 as=0.406
+ ad=0.406 ps=3.38 pd=3.38
X$832 \$19 \$19 \$19 sky130_gnd sky130_fd_pr__nfet_01v8 l=0.6 w=1.4 as=0.406
+ ad=0.406 ps=3.38 pd=3.38
X$833 \$19 \$19 \$19 sky130_gnd sky130_fd_pr__nfet_01v8 l=0.6 w=1.4 as=0.406
+ ad=0.406 ps=3.38 pd=3.38
X$834 \$19 \$19 \$19 sky130_gnd sky130_fd_pr__nfet_01v8 l=0.6 w=1.4 as=0.406
+ ad=0.406 ps=3.38 pd=3.38
X$835 \$19 \$19 \$19 sky130_gnd sky130_fd_pr__nfet_01v8 l=0.6 w=1.4 as=0.406
+ ad=0.406 ps=3.38 pd=3.38
X$836 \$558 \$558 \$558 sky130_gnd sky130_fd_pr__nfet_01v8 l=0.6 w=1.4 as=0.406
+ ad=0.406 ps=3.38 pd=3.38
X$837 \$558 \$558 \$558 sky130_gnd sky130_fd_pr__nfet_01v8 l=0.6 w=1.4 as=0.406
+ ad=0.406 ps=3.38 pd=3.38
X$838 \$558 \$558 \$558 sky130_gnd sky130_fd_pr__nfet_01v8 l=0.6 w=1.4 as=0.406
+ ad=0.406 ps=3.38 pd=3.38
X$839 \$558 \$558 \$558 sky130_gnd sky130_fd_pr__nfet_01v8 l=0.6 w=1.4 as=0.406
+ ad=0.406 ps=3.38 pd=3.38
X$840 \$558 \$558 \$558 sky130_gnd sky130_fd_pr__nfet_01v8 l=0.6 w=1.4 as=0.406
+ ad=0.406 ps=3.38 pd=3.38
X$841 \$558 \$558 \$558 sky130_gnd sky130_fd_pr__nfet_01v8 l=0.6 w=1.4 as=0.406
+ ad=0.406 ps=3.38 pd=3.38
X$842 VSS VSS \$623 sky130_gnd sky130_fd_pr__nfet_01v8 l=0.6 w=1.4 as=0.406
+ ad=0.406 ps=3.38 pd=3.38
X$843 VSS VSS \$623 sky130_gnd sky130_fd_pr__nfet_01v8 l=0.6 w=1.4 as=0.406
+ ad=0.406 ps=3.38 pd=3.38
X$844 VSS VSS \$623 sky130_gnd sky130_fd_pr__nfet_01v8 l=0.6 w=1.4 as=0.406
+ ad=0.406 ps=3.38 pd=3.38
X$845 VSS VSS \$623 sky130_gnd sky130_fd_pr__nfet_01v8 l=0.6 w=1.4 as=0.406
+ ad=0.406 ps=3.38 pd=3.38
X$846 VSS VSS \$623 sky130_gnd sky130_fd_pr__nfet_01v8 l=0.6 w=1.4 as=0.406
+ ad=0.406 ps=3.38 pd=3.38
X$847 VSS VSS \$623 sky130_gnd sky130_fd_pr__nfet_01v8 l=0.6 w=1.4 as=0.406
+ ad=0.406 ps=3.38 pd=3.38
X$848 VSS VSS \$18 sky130_gnd sky130_fd_pr__nfet_01v8 l=0.6 w=1.4 as=0.406
+ ad=0.406 ps=3.38 pd=3.38
X$849 VSS VSS \$18 sky130_gnd sky130_fd_pr__nfet_01v8 l=0.6 w=1.4 as=0.406
+ ad=0.406 ps=3.38 pd=3.38
X$850 VSS VSS \$18 sky130_gnd sky130_fd_pr__nfet_01v8 l=0.6 w=1.4 as=0.406
+ ad=0.406 ps=3.38 pd=3.38
X$851 VSS VSS \$18 sky130_gnd sky130_fd_pr__nfet_01v8 l=0.6 w=1.4 as=0.406
+ ad=0.406 ps=3.38 pd=3.38
X$852 VSS VSS \$18 sky130_gnd sky130_fd_pr__nfet_01v8 l=0.6 w=1.4 as=0.406
+ ad=0.406 ps=3.38 pd=3.38
X$853 VSS VSS \$18 sky130_gnd sky130_fd_pr__nfet_01v8 l=0.6 w=1.4 as=0.406
+ ad=0.406 ps=3.38 pd=3.38
X$854 \$18 \$18 \$18 sky130_gnd sky130_fd_pr__nfet_01v8 l=0.6 w=1.4 as=0.406
+ ad=0.406 ps=3.38 pd=3.38
X$855 \$18 \$18 \$18 sky130_gnd sky130_fd_pr__nfet_01v8 l=0.6 w=1.4 as=0.406
+ ad=0.406 ps=3.38 pd=3.38
X$856 \$18 \$18 \$18 sky130_gnd sky130_fd_pr__nfet_01v8 l=0.6 w=1.4 as=0.406
+ ad=0.406 ps=3.38 pd=3.38
X$857 \$18 \$18 \$18 sky130_gnd sky130_fd_pr__nfet_01v8 l=0.6 w=1.4 as=0.406
+ ad=0.406 ps=3.38 pd=3.38
X$858 \$18 \$18 \$18 sky130_gnd sky130_fd_pr__nfet_01v8 l=0.6 w=1.4 as=0.406
+ ad=0.406 ps=3.38 pd=3.38
X$859 \$18 \$18 \$18 sky130_gnd sky130_fd_pr__nfet_01v8 l=0.6 w=1.4 as=0.406
+ ad=0.406 ps=3.38 pd=3.38
X$860 \$17 \$17 \$17 sky130_gnd sky130_fd_pr__nfet_01v8_lvt l=0.6 w=1.4
+ as=0.406 ad=0.406 ps=3.38 pd=3.38
X$861 \$17 \$17 \$17 sky130_gnd sky130_fd_pr__nfet_01v8_lvt l=0.6 w=1.4
+ as=0.406 ad=0.406 ps=3.38 pd=3.38
X$862 \$17 \$17 \$17 sky130_gnd sky130_fd_pr__nfet_01v8_lvt l=0.6 w=1.4
+ as=0.406 ad=0.406 ps=3.38 pd=3.38
X$863 \$17 \$17 \$17 sky130_gnd sky130_fd_pr__nfet_01v8_lvt l=0.6 w=1.4
+ as=0.406 ad=0.406 ps=3.38 pd=3.38
X$864 \$17 \$17 \$17 sky130_gnd sky130_fd_pr__nfet_01v8_lvt l=0.6 w=1.4
+ as=0.406 ad=0.406 ps=3.38 pd=3.38
X$865 \$17 \$17 \$17 sky130_gnd sky130_fd_pr__nfet_01v8_lvt l=0.6 w=1.4
+ as=0.406 ad=0.406 ps=3.38 pd=3.38
X$866 \$17 \$17 \$17 sky130_gnd sky130_fd_pr__nfet_01v8_lvt l=0.6 w=1.4
+ as=0.406 ad=0.406 ps=3.38 pd=3.38
X$867 \$17 \$17 \$17 sky130_gnd sky130_fd_pr__nfet_01v8_lvt l=0.6 w=1.4
+ as=0.406 ad=0.406 ps=3.38 pd=3.38
X$868 \$16 \$16 \$16 sky130_gnd sky130_fd_pr__nfet_01v8_lvt l=0.6 w=1.4
+ as=0.406 ad=0.406 ps=3.38 pd=3.38
X$869 \$16 \$16 \$16 sky130_gnd sky130_fd_pr__nfet_01v8_lvt l=0.6 w=1.4
+ as=0.406 ad=0.406 ps=3.38 pd=3.38
X$870 \$16 \$16 \$16 sky130_gnd sky130_fd_pr__nfet_01v8_lvt l=0.6 w=1.4
+ as=0.406 ad=0.406 ps=3.38 pd=3.38
X$871 \$16 \$16 \$16 sky130_gnd sky130_fd_pr__nfet_01v8_lvt l=0.6 w=1.4
+ as=0.406 ad=0.406 ps=3.38 pd=3.38
X$872 \$16 \$16 \$16 sky130_gnd sky130_fd_pr__nfet_01v8_lvt l=0.6 w=1.4
+ as=0.406 ad=0.406 ps=3.38 pd=3.38
X$873 \$16 \$16 \$16 sky130_gnd sky130_fd_pr__nfet_01v8_lvt l=0.6 w=1.4
+ as=0.406 ad=0.406 ps=3.38 pd=3.38
X$874 \$16 \$16 \$16 sky130_gnd sky130_fd_pr__nfet_01v8_lvt l=0.6 w=1.4
+ as=0.406 ad=0.406 ps=3.38 pd=3.38
X$875 \$16 \$16 \$16 sky130_gnd sky130_fd_pr__nfet_01v8_lvt l=0.6 w=1.4
+ as=0.406 ad=0.406 ps=3.38 pd=3.38
Cext_1 \$130 \$131 5.43394a
Cext_2 \$130 \$14.x1_net3 133.013a
Cext_3 \$130 \$16 822.919a
Cext_4 \$130 \$17 110.182a
Cext_5 \$130 \$19 195.921a
Cext_6 \$130 \$247 1.62418f
Cext_7 \$130 \$27.x1_net1 255.961a
Cext_8 \$130 \$291 625.395a
Cext_9 \$130 bias_a 61.878a
Cext_10 \$130 cm 2.57954f
Cext_11 \$130 IBIAS 193.738a
Cext_12 \$130 VSS 2.4463f
Cext_13 \$130 sky130_gnd 5.36799f
Cext_14 \$131 \$132 939.813a
Cext_15 \$131 \$133 1.54389a
Cext_16 \$131 \$15.x1_net6 127.203a
Cext_17 \$131 \$16 103.104a
Cext_18 \$131 \$17 485.666a
Cext_19 \$131 \$19 772.84a
Cext_20 \$131 \$22.x1_net4 255.961a
Cext_21 \$131 \$247 14.9561a
Cext_22 \$131 bias_a 85.1727a
Cext_23 \$131 cm 1.33115f
Cext_24 \$131 IBIAS 448.684a
Cext_25 \$131 VSS 1.78605f
Cext_26 \$131 sky130_gnd 3.04076f
Cext_27 \$132 \$133 396.955a
Cext_28 \$132 \$16 120.289a
Cext_29 \$132 \$16.x1_net9 126.837a
Cext_30 \$132 \$19 442.139a
Cext_31 \$132 \$20.x1_net7 255.961a
Cext_32 \$132 \$22.x1_net4 0.112544a
Cext_33 \$132 \$247 8.26651a
Cext_34 \$132 \$291 3.31521a
Cext_35 \$132 bias_a 87.4073a
Cext_36 \$132 cm 2.16073f
Cext_37 \$132 IBIAS 440.102a
Cext_38 \$132 VSS 1.78157f
Cext_39 \$132 sky130_gnd 3.20008f
Cext_40 \$133 \$16 98.6338a
Cext_41 \$133 \$17.x1_net12 133.404a
Cext_42 \$133 \$18 6.41532a
Cext_43 \$133 \$19 506.951a
Cext_44 \$133 \$23.x1_net10 255.95a
Cext_45 \$133 \$247 99.5028a
Cext_46 \$133 \$291 134.034a
Cext_47 \$133 bias_a 197.988a
Cext_48 \$133 cm 2.33683f
Cext_49 \$133 IBIAS 1.24835f
Cext_50 \$133 VSS 1.95006f
Cext_51 \$133 sky130_gnd 3.11279f
Cext_52 \$14.x1_net3 \$16 0.402274a
Cext_53 \$14.x1_net3 cm 206.579a
Cext_54 \$14.x1_net3 VSS 552.443a
Cext_55 \$14.x1_net3 sky130_gnd 369.719a
Cext_56 \$15.x1_net6 \$17 19.2209a
Cext_57 \$15.x1_net6 cm 206.806a
Cext_58 \$15.x1_net6 VSS 543.795a
Cext_59 \$15.x1_net6 sky130_gnd 375.343a
Cext_60 \$16 \$17 29.2434f
Cext_61 \$16 \$18 200.667a
Cext_62 \$16 \$19 1.91556f
Cext_63 \$16 \$247 1.54641f
Cext_64 \$16 \$291 10.9975a
Cext_65 \$16 \$340 685.46a
Cext_66 \$16 \$365 707.809a
Cext_67 \$16 \$408 620.989a
Cext_68 \$16 \$536 2.16287f
Cext_69 \$16 \$558 287.543a
Cext_70 \$16 \$586 1.97827f
Cext_71 \$16 \$621 157.078a
Cext_72 \$16 \$623 217.694a
Cext_73 \$16 bias_a 255.389a
Cext_74 \$16 cm 1.96295f
Cext_75 \$16 cmc 338.875a
Cext_76 \$16 IBIAS 6.67294f
Cext_77 \$16 on 5.17275f
Cext_78 \$16 op 2.04404f
Cext_79 \$16 VDD 40.2708f
Cext_80 \$16 VSS 11.0193f
Cext_81 \$16 sky130_gnd 41.452f
Cext_82 \$16.x1_net9 bias_a 1.84405a
Cext_83 \$16.x1_net9 cm 213.93a
Cext_84 \$16.x1_net9 VSS 541.009a
Cext_85 \$16.x1_net9 sky130_gnd 373.305a
Cext_86 \$17 \$18 156.725a
Cext_87 \$17 \$19 461.779a
Cext_88 \$17 \$247 1.59218f
Cext_89 \$17 \$340 1.46334f
Cext_90 \$17 \$365 1.3248f
Cext_91 \$17 \$408 3.28145f
Cext_92 \$17 \$536 3.0078f
Cext_93 \$17 \$558 686.79a
Cext_94 \$17 \$586 3.24074f
Cext_95 \$17 \$621 229.364a
Cext_96 \$17 \$623 232.109a
Cext_97 \$17 bias_a 705.722a
Cext_98 \$17 cm 1.01682f
Cext_99 \$17 cmc 575.312a
Cext_100 \$17 IBIAS 235.971a
Cext_101 \$17 in 125.475a
Cext_102 \$17 ip 114.634a
Cext_103 \$17 on 201.384a
Cext_104 \$17 op 443.433a
Cext_105 \$17 VDD 58.5018f
Cext_106 \$17 VSS 5.0122f
Cext_107 \$17 sky130_gnd 58.4482f
Cext_108 \$17.x1_net12 cm 206.748a
Cext_109 \$17.x1_net12 VSS 542.7a
Cext_110 \$17.x1_net12 sky130_gnd 375.56a
Cext_111 \$18 \$19 1.96355f
Cext_112 \$18 \$247 173.826a
Cext_113 \$18 bias_a 8.97598f
Cext_114 \$18 cm 328.836a
Cext_115 \$18 IBIAS 194.738a
Cext_116 \$18 VSS 11.9634f
Cext_117 \$18 sky130_gnd 15.8981f
Cext_118 \$19 \$19.x1_net15 0.619506a
Cext_119 \$19 \$23.x1_net10 57.9595a
Cext_120 \$19 \$247 27.4018f
Cext_121 \$19 \$291 122.939a
Cext_122 \$19 \$365 280.378a
Cext_123 \$19 \$408 1.79246a
Cext_124 \$19 \$536 145.202a
Cext_125 \$19 \$558 476.266a
Cext_126 \$19 \$586 368.479a
Cext_127 \$19 \$621 3.57588f
Cext_128 \$19 \$623 3.92f
Cext_129 \$19 bias_a 8.53882f
Cext_130 \$19 cm 758.706a
Cext_131 \$19 cmc 298.104a
Cext_132 \$19 IBIAS 718.86a
Cext_133 \$19 on 3.75085f
Cext_134 \$19 op 3.60206f
Cext_135 \$19 VDD 1.59787f
Cext_136 \$19 VSS 18.3069f
Cext_137 \$19 sky130_gnd 70.2865f
Cext_138 \$19.x1_net15 \$247 17.9141a
Cext_139 \$19.x1_net15 \$291 127.177a
Cext_140 \$19.x1_net15 bias_a 0.329172a
Cext_141 \$19.x1_net15 cm 206.527a
Cext_142 \$19.x1_net15 VSS 547.796a
Cext_143 \$19.x1_net15 sky130_gnd 375.248a
Cext_144 \$20.x1_net7 \$291 1.1371a
Cext_145 \$20.x1_net7 cm 333.977a
Cext_146 \$20.x1_net7 VSS 275.623a
Cext_147 \$20.x1_net7 sky130_gnd 376.861a
Cext_148 \$22.x1_net4 cm 438.333a
Cext_149 \$22.x1_net4 VSS 282.049a
Cext_150 \$22.x1_net4 sky130_gnd 376.859a
Cext_151 \$23.x1_net10 \$247 94.567a
Cext_152 \$23.x1_net10 bias_a 3.87341a
Cext_153 \$23.x1_net10 cm 333.652a
Cext_154 \$23.x1_net10 VSS 284.5a
Cext_155 \$23.x1_net10 sky130_gnd 376.699a
Cext_156 \$247 \$291 253.182a
Cext_157 \$247 \$340 430.897a
Cext_158 \$247 \$365 3.4381f
Cext_159 \$247 \$408 2.47975f
Cext_160 \$247 bias_a 848.99a
Cext_161 \$247 cm 1.37941f
Cext_162 \$247 IBIAS 29.1495a
Cext_163 \$247 VDD 4.98227f
Cext_164 \$247 VSS 3.16284f
Cext_165 \$247 sky130_gnd 42.9868f
Cext_166 \$26.x1_net13 \$291 255.961a
Cext_167 \$26.x1_net13 cm 337.798a
Cext_168 \$26.x1_net13 VSS 274.829a
Cext_169 \$26.x1_net13 sky130_gnd 373.532a
Cext_170 \$27.x1_net1 \$291 0.270845a
Cext_171 \$27.x1_net1 cm 343.38a
Cext_172 \$27.x1_net1 VSS 275.187a
Cext_173 \$27.x1_net1 sky130_gnd 372.64a
Cext_174 \$291 bias_a 71.5704a
Cext_175 \$291 cm 1.27753f
Cext_176 \$291 IBIAS 7.49394a
Cext_177 \$291 VSS 2.06885f
Cext_178 \$291 sky130_gnd 3.06086f
Cext_179 \$340 \$365 1.47647f
Cext_180 \$340 \$408 987.722a
Cext_181 \$340 cm 2.268f
Cext_182 \$340 VDD 11.9024f
Cext_183 \$340 VSS 152.141a
Cext_184 \$340 sky130_gnd 3.64871f
Cext_185 \$365 \$408 3.82689f
Cext_186 \$365 bias_a 220.474a
Cext_187 \$365 cm 129.362a
Cext_188 \$365 VDD 12.5704f
Cext_189 \$365 VSS 108.519a
Cext_190 \$365 sky130_gnd 4.5613f
Cext_191 \$408 bias_a 0.303853a
Cext_192 \$408 cm 223.922a
Cext_193 \$408 VDD 12.0745f
Cext_194 \$408 VSS 110.984a
Cext_195 \$408 sky130_gnd 3.37773f
Cext_196 \$536 \$558 3.76322f
Cext_197 \$536 \$586 11.6488f
Cext_198 \$536 \$621 193.006a
Cext_199 \$536 \$623 175.475a
Cext_200 \$536 bias_a 199.174a
Cext_201 \$536 in 120.538a
Cext_202 \$536 ip 465.949a
Cext_203 \$536 on 7.99113f
Cext_204 \$536 op 7.49743f
Cext_205 \$536 VDD 29.0801f
Cext_206 \$536 VSS 4.06795f
Cext_207 \$536 sky130_gnd 11.69f
Cext_208 \$558 \$586 3.84568f
Cext_209 \$558 \$623 4.77207a
Cext_210 \$558 bias_a 13.3575f
Cext_211 \$558 cmc 12.3062f
Cext_212 \$558 in 400.306a
Cext_213 \$558 ip 400.766a
Cext_214 \$558 on 916.429a
Cext_215 \$558 op 274.865a
Cext_216 \$558 VDD 3.18317a
Cext_217 \$558 VSS 72.1934f
Cext_218 \$558 sky130_gnd 46.5743f
Cext_219 \$586 \$621 377.804a
Cext_220 \$586 \$623 455.822a
Cext_221 \$586 bias_a 286.269a
Cext_222 \$586 in 427.959a
Cext_223 \$586 ip 60.3736a
Cext_224 \$586 on 3.26047f
Cext_225 \$586 op 9.25672f
Cext_226 \$586 VDD 29.1063f
Cext_227 \$586 VSS 2.43383f
Cext_228 \$586 sky130_gnd 17.1602f
Cext_229 \$621 \$623 11.7347f
Cext_230 \$621 bias_a 4.15424f
Cext_231 \$621 on 13.3836f
Cext_232 \$621 op 12.8648f
Cext_233 \$621 VDD 230.069a
Cext_234 \$621 VSS 23.2896f
Cext_235 \$621 sky130_gnd 19.0401f
Cext_236 \$623 bias_a 3.53094f
Cext_237 \$623 in 2.19056a
Cext_238 \$623 ip 2.19056a
Cext_239 \$623 on 5.66591f
Cext_240 \$623 op 15.31f
Cext_241 \$623 VDD 213.59a
Cext_242 \$623 VSS 16.7131f
Cext_243 \$623 sky130_gnd 31.5175f
Cext_244 bias_a cm 480.573a
Cext_245 bias_a cmc 313.779a
Cext_246 bias_a in 200.588a
Cext_247 bias_a ip 3.00483a
Cext_248 bias_a on 672.536a
Cext_249 bias_a op 487.871a
Cext_250 cmc on 202.995f
Cext_251 cmc op 201.235f
Cext_252 IBIAS bias_a 139.206a
Cext_253 IBIAS cm 570.759a
Cext_254 IBIAS VSS 19.752f
Cext_255 IBIAS sky130_gnd 26.1056f
Cext_256 in ip 2.09021f
Cext_257 on op 4.16926f
Cext_258 VDD bias_a 1.13382f
Cext_259 VDD cm 3.7653f
Cext_260 VDD cmc 1.17072f
Cext_261 VDD on 16.0852f
Cext_262 VDD op 11.5521f
Cext_263 VDD VSS 4.28949f
Cext_264 VDD sky130_gnd 63.5673f
Cext_265 VSS bias_a 44.0368f
Cext_266 VSS cm 21.0123f
Cext_267 VSS cmc 15.3556f
Cext_268 VSS in 576.23a
Cext_269 VSS ip 1.61656f
Cext_270 VSS on 13.3506f
Cext_271 VSS op 6.02659f
Cext_272 VSS sky130_gnd 405.13f
Cext_273 sky130_gnd bias_a 107.441f
Cext_274 sky130_gnd cm 33.831f
Cext_275 sky130_gnd cmc 67.8749f
Cext_276 sky130_gnd in 3.35626f
Cext_277 sky130_gnd ip 2.37527f
Cext_278 sky130_gnd on 26.2645f
Cext_279 sky130_gnd op 28.6696f
.ENDS iadc_ota_routed
