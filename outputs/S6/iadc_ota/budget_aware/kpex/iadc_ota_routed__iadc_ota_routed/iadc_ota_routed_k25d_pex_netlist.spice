*********************************************************
*** NGSPICE file created by KLayout-PEX 0.6.8
*** -----------------------------------------------------
***     Extraction Engine: KPEX/2.5D
***     Technology: sky130a
***     Date: 2026-11-04 21:07:09
*********************************************************

.SUBCKT iadc_ota_routed \$22.x1_net6 \$25.x1_net9 \$36.x1_net12 \$37.x1_net15
+ \$38.x1_net3 \$39.x1_net4 \$40.x1_net7 \$41.x1_net10 \$45.x1_net13
+ \$46.x1_net1 IBIAS VDD VSS bias_a cm cmc in ip on op sky130_gnd
X$9 \$213 \$280 \$280 sky130_gnd sky130_fd_pr__nfet_01v8_lvt l=0.6 w=1.4
+ as=0.406 ad=0.406 ps=3.38 pd=3.38
X$10 \$213 \$280 \$280 sky130_gnd sky130_fd_pr__nfet_01v8_lvt l=0.6 w=1.4
+ as=0.406 ad=0.406 ps=3.38 pd=3.38
X$11 \$213 \$280 \$280 sky130_gnd sky130_fd_pr__nfet_01v8_lvt l=0.6 w=1.4
+ as=0.406 ad=0.406 ps=3.38 pd=3.38
X$12 \$213 \$280 \$280 sky130_gnd sky130_fd_pr__nfet_01v8_lvt l=0.6 w=1.4
+ as=0.406 ad=0.406 ps=3.38 pd=3.38
X$13 \$213 \$280 \$280 sky130_gnd sky130_fd_pr__nfet_01v8_lvt l=0.6 w=1.4
+ as=0.406 ad=0.406 ps=3.38 pd=3.38
X$14 \$213 \$280 \$280 sky130_gnd sky130_fd_pr__nfet_01v8_lvt l=0.6 w=1.4
+ as=0.406 ad=0.406 ps=3.38 pd=3.38
X$15 \$213 \$280 \$280 sky130_gnd sky130_fd_pr__nfet_01v8_lvt l=0.6 w=1.4
+ as=0.406 ad=0.406 ps=3.38 pd=3.38
X$16 \$213 \$280 \$280 sky130_gnd sky130_fd_pr__nfet_01v8_lvt l=0.6 w=1.4
+ as=0.406 ad=0.406 ps=3.38 pd=3.38
X$17 \$213 \$280 \$280 sky130_gnd sky130_fd_pr__nfet_01v8_lvt l=0.6 w=1.4
+ as=0.406 ad=0.406 ps=3.38 pd=3.38
X$18 \$213 \$280 \$280 sky130_gnd sky130_fd_pr__nfet_01v8_lvt l=0.6 w=1.4
+ as=0.406 ad=0.406 ps=3.38 pd=3.38
X$19 \$213 \$280 \$280 sky130_gnd sky130_fd_pr__nfet_01v8_lvt l=0.6 w=1.4
+ as=0.406 ad=0.406 ps=3.38 pd=3.38
X$20 \$213 \$280 \$280 sky130_gnd sky130_fd_pr__nfet_01v8_lvt l=0.6 w=1.4
+ as=0.406 ad=0.406 ps=3.38 pd=3.38
X$21 \$213 \$280 \$280 sky130_gnd sky130_fd_pr__nfet_01v8_lvt l=0.6 w=1.4
+ as=0.406 ad=0.406 ps=3.38 pd=3.38
X$22 \$213 \$280 \$280 sky130_gnd sky130_fd_pr__nfet_01v8_lvt l=0.6 w=1.4
+ as=0.406 ad=0.406 ps=3.38 pd=3.38
X$23 \$213 \$280 \$280 sky130_gnd sky130_fd_pr__nfet_01v8_lvt l=0.6 w=1.4
+ as=0.406 ad=0.406 ps=3.38 pd=3.38
X$24 \$213 \$280 \$280 sky130_gnd sky130_fd_pr__nfet_01v8_lvt l=0.6 w=1.4
+ as=0.406 ad=0.406 ps=3.38 pd=3.38
X$25 \$213 \$280 \$280 sky130_gnd sky130_fd_pr__nfet_01v8_lvt l=0.6 w=1.4
+ as=0.406 ad=0.406 ps=3.38 pd=3.38
X$26 \$213 \$280 \$280 sky130_gnd sky130_fd_pr__nfet_01v8_lvt l=0.6 w=1.4
+ as=0.406 ad=0.406 ps=3.38 pd=3.38
X$27 \$213 \$280 \$280 sky130_gnd sky130_fd_pr__nfet_01v8_lvt l=0.6 w=1.4
+ as=0.406 ad=0.406 ps=3.38 pd=3.38
X$28 \$213 \$280 \$280 sky130_gnd sky130_fd_pr__nfet_01v8_lvt l=0.6 w=1.4
+ as=0.406 ad=0.406 ps=3.38 pd=3.38
X$29 \$213 \$280 \$280 sky130_gnd sky130_fd_pr__nfet_01v8_lvt l=0.6 w=1.4
+ as=0.406 ad=0.406 ps=3.38 pd=3.38
X$30 \$213 \$280 \$280 sky130_gnd sky130_fd_pr__nfet_01v8_lvt l=0.6 w=1.4
+ as=0.406 ad=0.406 ps=3.38 pd=3.38
X$31 \$213 \$280 \$280 sky130_gnd sky130_fd_pr__nfet_01v8_lvt l=0.6 w=1.4
+ as=0.406 ad=0.406 ps=3.38 pd=3.38
X$32 \$213 \$280 \$280 sky130_gnd sky130_fd_pr__nfet_01v8_lvt l=0.6 w=1.4
+ as=0.406 ad=0.406 ps=3.38 pd=3.38
X$33 \$213 \$280 \$280 sky130_gnd sky130_fd_pr__nfet_01v8_lvt l=0.6 w=1.4
+ as=0.406 ad=0.406 ps=3.38 pd=3.38
X$34 \$213 \$280 \$280 sky130_gnd sky130_fd_pr__nfet_01v8_lvt l=0.6 w=1.4
+ as=0.406 ad=0.406 ps=3.38 pd=3.38
X$35 \$213 \$280 \$280 sky130_gnd sky130_fd_pr__nfet_01v8_lvt l=0.6 w=1.4
+ as=0.406 ad=0.406 ps=3.38 pd=3.38
X$36 \$213 \$280 \$280 sky130_gnd sky130_fd_pr__nfet_01v8_lvt l=0.6 w=1.4
+ as=0.406 ad=0.406 ps=3.38 pd=3.38
X$37 \$213 \$280 \$280 sky130_gnd sky130_fd_pr__nfet_01v8_lvt l=0.6 w=1.4
+ as=0.406 ad=0.406 ps=3.38 pd=3.38
X$38 \$213 \$280 \$280 sky130_gnd sky130_fd_pr__nfet_01v8_lvt l=0.6 w=1.4
+ as=0.406 ad=0.406 ps=3.38 pd=3.38
X$39 \$213 \$280 \$280 sky130_gnd sky130_fd_pr__nfet_01v8_lvt l=0.6 w=1.4
+ as=0.406 ad=0.406 ps=3.38 pd=3.38
X$40 \$213 \$280 \$280 sky130_gnd sky130_fd_pr__nfet_01v8_lvt l=0.6 w=1.4
+ as=0.406 ad=0.406 ps=3.38 pd=3.38
X$41 \$213 \$280 \$280 sky130_gnd sky130_fd_pr__nfet_01v8_lvt l=0.6 w=1.4
+ as=0.406 ad=0.406 ps=3.38 pd=3.38
X$42 \$213 \$280 \$280 sky130_gnd sky130_fd_pr__nfet_01v8_lvt l=0.6 w=1.4
+ as=0.406 ad=0.406 ps=3.38 pd=3.38
X$43 \$213 \$280 \$280 sky130_gnd sky130_fd_pr__nfet_01v8_lvt l=0.6 w=1.4
+ as=0.406 ad=0.406 ps=3.38 pd=3.38
X$44 \$213 \$280 \$280 sky130_gnd sky130_fd_pr__nfet_01v8_lvt l=0.6 w=1.4
+ as=0.406 ad=0.406 ps=3.38 pd=3.38
X$45 \$213 \$280 \$280 sky130_gnd sky130_fd_pr__nfet_01v8_lvt l=0.6 w=1.4
+ as=0.406 ad=0.406 ps=3.38 pd=3.38
X$46 \$213 \$280 \$280 sky130_gnd sky130_fd_pr__nfet_01v8_lvt l=0.6 w=1.4
+ as=0.406 ad=0.406 ps=3.38 pd=3.38
X$47 \$213 \$280 \$280 sky130_gnd sky130_fd_pr__nfet_01v8_lvt l=0.6 w=1.4
+ as=0.406 ad=0.406 ps=3.38 pd=3.38
X$48 \$213 \$280 \$280 sky130_gnd sky130_fd_pr__nfet_01v8_lvt l=0.6 w=1.4
+ as=0.406 ad=0.406 ps=3.38 pd=3.38
X$49 \$213 \$280 \$280 sky130_gnd sky130_fd_pr__nfet_01v8_lvt l=0.6 w=1.4
+ as=0.406 ad=0.406 ps=3.38 pd=3.38
X$50 \$213 \$280 \$280 sky130_gnd sky130_fd_pr__nfet_01v8_lvt l=0.6 w=1.4
+ as=0.406 ad=0.406 ps=3.38 pd=3.38
X$51 \$213 \$280 \$280 sky130_gnd sky130_fd_pr__nfet_01v8_lvt l=0.6 w=1.4
+ as=0.406 ad=0.406 ps=3.38 pd=3.38
X$52 \$213 \$280 \$280 sky130_gnd sky130_fd_pr__nfet_01v8_lvt l=0.6 w=1.4
+ as=0.406 ad=0.406 ps=3.38 pd=3.38
X$53 \$213 \$280 \$280 sky130_gnd sky130_fd_pr__nfet_01v8_lvt l=0.6 w=1.4
+ as=0.406 ad=0.406 ps=3.38 pd=3.38
X$54 \$213 \$280 \$280 sky130_gnd sky130_fd_pr__nfet_01v8_lvt l=0.6 w=1.4
+ as=0.406 ad=0.406 ps=3.38 pd=3.38
X$55 \$213 \$280 \$280 sky130_gnd sky130_fd_pr__nfet_01v8_lvt l=0.6 w=1.4
+ as=0.406 ad=0.406 ps=3.38 pd=3.38
X$56 \$213 \$280 \$280 sky130_gnd sky130_fd_pr__nfet_01v8_lvt l=0.6 w=1.4
+ as=0.406 ad=0.406 ps=3.38 pd=3.38
X$57 \$213 \$280 \$280 sky130_gnd sky130_fd_pr__nfet_01v8_lvt l=0.6 w=1.4
+ as=0.406 ad=0.406 ps=3.38 pd=3.38
X$58 \$213 \$280 \$280 sky130_gnd sky130_fd_pr__nfet_01v8_lvt l=0.6 w=1.4
+ as=0.406 ad=0.406 ps=3.38 pd=3.38
X$59 \$213 \$280 \$280 sky130_gnd sky130_fd_pr__nfet_01v8_lvt l=0.6 w=1.4
+ as=0.406 ad=0.406 ps=3.38 pd=3.38
X$60 \$213 \$280 \$280 sky130_gnd sky130_fd_pr__nfet_01v8_lvt l=0.6 w=1.4
+ as=0.406 ad=0.406 ps=3.38 pd=3.38
X$61 \$213 \$280 \$280 sky130_gnd sky130_fd_pr__nfet_01v8_lvt l=0.6 w=1.4
+ as=0.406 ad=0.406 ps=3.38 pd=3.38
X$62 \$213 \$280 \$280 sky130_gnd sky130_fd_pr__nfet_01v8_lvt l=0.6 w=1.4
+ as=0.406 ad=0.406 ps=3.38 pd=3.38
X$63 \$213 \$280 \$280 sky130_gnd sky130_fd_pr__nfet_01v8_lvt l=0.6 w=1.4
+ as=0.406 ad=0.406 ps=3.38 pd=3.38
X$64 \$213 \$280 \$280 sky130_gnd sky130_fd_pr__nfet_01v8_lvt l=0.6 w=1.4
+ as=0.406 ad=0.406 ps=3.38 pd=3.38
X$65 \$280 \$280 \$280 sky130_gnd sky130_fd_pr__nfet_01v8_lvt l=0.6 w=1.4
+ as=0.406 ad=0.406 ps=3.38 pd=3.38
X$66 \$280 \$280 \$280 sky130_gnd sky130_fd_pr__nfet_01v8_lvt l=0.6 w=1.4
+ as=0.406 ad=0.406 ps=3.38 pd=3.38
X$67 \$280 \$280 \$280 sky130_gnd sky130_fd_pr__nfet_01v8_lvt l=0.6 w=1.4
+ as=0.406 ad=0.406 ps=3.38 pd=3.38
X$68 \$280 \$280 \$280 sky130_gnd sky130_fd_pr__nfet_01v8_lvt l=0.6 w=1.4
+ as=0.406 ad=0.406 ps=3.38 pd=3.38
X$69 \$280 \$280 \$280 sky130_gnd sky130_fd_pr__nfet_01v8_lvt l=0.6 w=1.4
+ as=0.406 ad=0.406 ps=3.38 pd=3.38
X$70 \$280 \$280 \$280 sky130_gnd sky130_fd_pr__nfet_01v8_lvt l=0.6 w=1.4
+ as=0.406 ad=0.406 ps=3.38 pd=3.38
X$71 \$280 \$280 \$280 sky130_gnd sky130_fd_pr__nfet_01v8_lvt l=0.6 w=1.4
+ as=0.406 ad=0.406 ps=3.38 pd=3.38
X$72 \$280 \$280 \$280 sky130_gnd sky130_fd_pr__nfet_01v8_lvt l=0.6 w=1.4
+ as=0.406 ad=0.406 ps=3.38 pd=3.38
X$73 \$213 \$213 \$213 sky130_gnd sky130_fd_pr__nfet_01v8_lvt l=0.6 w=1.4
+ as=0.406 ad=0.406 ps=3.38 pd=3.38
X$74 \$213 \$213 \$213 sky130_gnd sky130_fd_pr__nfet_01v8_lvt l=0.6 w=1.4
+ as=0.406 ad=0.406 ps=3.38 pd=3.38
X$75 \$213 \$213 \$213 sky130_gnd sky130_fd_pr__nfet_01v8_lvt l=0.6 w=1.4
+ as=0.406 ad=0.406 ps=3.38 pd=3.38
X$76 \$213 \$213 \$213 sky130_gnd sky130_fd_pr__nfet_01v8_lvt l=0.6 w=1.4
+ as=0.406 ad=0.406 ps=3.38 pd=3.38
X$77 \$213 \$213 \$213 sky130_gnd sky130_fd_pr__nfet_01v8_lvt l=0.6 w=1.4
+ as=0.406 ad=0.406 ps=3.38 pd=3.38
X$78 \$213 \$213 \$213 sky130_gnd sky130_fd_pr__nfet_01v8_lvt l=0.6 w=1.4
+ as=0.406 ad=0.406 ps=3.38 pd=3.38
X$79 \$213 \$213 \$213 sky130_gnd sky130_fd_pr__nfet_01v8_lvt l=0.6 w=1.4
+ as=0.406 ad=0.406 ps=3.38 pd=3.38
X$80 \$213 \$213 \$213 sky130_gnd sky130_fd_pr__nfet_01v8_lvt l=0.6 w=1.4
+ as=0.406 ad=0.406 ps=3.38 pd=3.38
X$81 VDD \$280 \$649 VDD sky130_fd_pr__pfet_01v8_lvt l=0.6 w=1.4 as=0.406
+ ad=0.406 ps=3.38 pd=3.38
X$82 VDD \$280 \$649 VDD sky130_fd_pr__pfet_01v8_lvt l=0.6 w=1.4 as=0.406
+ ad=0.406 ps=3.38 pd=3.38
X$83 VDD \$280 \$649 VDD sky130_fd_pr__pfet_01v8_lvt l=0.6 w=1.4 as=0.406
+ ad=0.406 ps=3.38 pd=3.38
X$84 VDD \$280 \$649 VDD sky130_fd_pr__pfet_01v8_lvt l=0.6 w=1.4 as=0.406
+ ad=0.406 ps=3.38 pd=3.38
X$85 VDD \$280 \$649 VDD sky130_fd_pr__pfet_01v8_lvt l=0.6 w=1.4 as=0.406
+ ad=0.406 ps=3.38 pd=3.38
X$86 VDD \$280 \$649 VDD sky130_fd_pr__pfet_01v8_lvt l=0.6 w=1.4 as=0.406
+ ad=0.406 ps=3.38 pd=3.38
X$87 VDD \$280 \$643 VDD sky130_fd_pr__pfet_01v8_lvt l=0.6 w=1.4 as=0.406
+ ad=0.406 ps=3.38 pd=3.38
X$88 VDD \$280 \$644 VDD sky130_fd_pr__pfet_01v8_lvt l=0.6 w=1.4 as=0.406
+ ad=0.406 ps=3.38 pd=3.38
X$89 VDD \$280 \$643 VDD sky130_fd_pr__pfet_01v8_lvt l=0.6 w=1.4 as=0.406
+ ad=0.406 ps=3.38 pd=3.38
X$90 VDD \$280 \$644 VDD sky130_fd_pr__pfet_01v8_lvt l=0.6 w=1.4 as=0.406
+ ad=0.406 ps=3.38 pd=3.38
X$91 VDD \$280 \$643 VDD sky130_fd_pr__pfet_01v8_lvt l=0.6 w=1.4 as=0.406
+ ad=0.406 ps=3.38 pd=3.38
X$92 VDD \$280 \$644 VDD sky130_fd_pr__pfet_01v8_lvt l=0.6 w=1.4 as=0.406
+ ad=0.406 ps=3.38 pd=3.38
X$93 VDD VDD VDD VDD sky130_fd_pr__pfet_01v8_lvt l=0.6 w=1.4 as=0.406 ad=0.406
+ ps=3.38 pd=3.38
X$94 VDD VDD VDD VDD sky130_fd_pr__pfet_01v8_lvt l=0.6 w=1.4 as=0.406 ad=0.406
+ ps=3.38 pd=3.38
X$95 VDD \$280 \$644 VDD sky130_fd_pr__pfet_01v8_lvt l=0.6 w=1.4 as=0.406
+ ad=0.406 ps=3.38 pd=3.38
X$96 VDD \$280 \$643 VDD sky130_fd_pr__pfet_01v8_lvt l=0.6 w=1.4 as=0.406
+ ad=0.406 ps=3.38 pd=3.38
X$97 VDD \$280 \$644 VDD sky130_fd_pr__pfet_01v8_lvt l=0.6 w=1.4 as=0.406
+ ad=0.406 ps=3.38 pd=3.38
X$98 VDD \$280 \$643 VDD sky130_fd_pr__pfet_01v8_lvt l=0.6 w=1.4 as=0.406
+ ad=0.406 ps=3.38 pd=3.38
X$99 VDD \$280 \$644 VDD sky130_fd_pr__pfet_01v8_lvt l=0.6 w=1.4 as=0.406
+ ad=0.406 ps=3.38 pd=3.38
X$100 VDD \$280 \$643 VDD sky130_fd_pr__pfet_01v8_lvt l=0.6 w=1.4 as=0.406
+ ad=0.406 ps=3.38 pd=3.38
X$101 VDD VDD VDD VDD sky130_fd_pr__pfet_01v8_lvt l=0.6 w=1.4 as=0.406 ad=0.406
+ ps=3.38 pd=3.38
X$102 VDD \$280 \$89 VDD sky130_fd_pr__pfet_01v8_lvt l=0.6 w=1.4 as=0.406
+ ad=0.406 ps=3.38 pd=3.38
X$103 VDD \$280 \$42 VDD sky130_fd_pr__pfet_01v8_lvt l=0.6 w=1.4 as=0.406
+ ad=0.406 ps=3.38 pd=3.38
X$104 VDD \$280 \$89 VDD sky130_fd_pr__pfet_01v8_lvt l=0.6 w=1.4 as=0.406
+ ad=0.406 ps=3.38 pd=3.38
X$105 VDD \$280 \$42 VDD sky130_fd_pr__pfet_01v8_lvt l=0.6 w=1.4 as=0.406
+ ad=0.406 ps=3.38 pd=3.38
X$106 VDD \$280 \$89 VDD sky130_fd_pr__pfet_01v8_lvt l=0.6 w=1.4 as=0.406
+ ad=0.406 ps=3.38 pd=3.38
X$107 VDD \$280 \$42 VDD sky130_fd_pr__pfet_01v8_lvt l=0.6 w=1.4 as=0.406
+ ad=0.406 ps=3.38 pd=3.38
X$108 VDD \$280 \$89 VDD sky130_fd_pr__pfet_01v8_lvt l=0.6 w=1.4 as=0.406
+ ad=0.406 ps=3.38 pd=3.38
X$109 VDD \$280 \$42 VDD sky130_fd_pr__pfet_01v8_lvt l=0.6 w=1.4 as=0.406
+ ad=0.406 ps=3.38 pd=3.38
X$110 VDD \$280 \$89 VDD sky130_fd_pr__pfet_01v8_lvt l=0.6 w=1.4 as=0.406
+ ad=0.406 ps=3.38 pd=3.38
X$111 VDD \$280 \$42 VDD sky130_fd_pr__pfet_01v8_lvt l=0.6 w=1.4 as=0.406
+ ad=0.406 ps=3.38 pd=3.38
X$112 VDD \$280 \$89 VDD sky130_fd_pr__pfet_01v8_lvt l=0.6 w=1.4 as=0.406
+ ad=0.406 ps=3.38 pd=3.38
X$113 VDD \$280 \$89 VDD sky130_fd_pr__pfet_01v8_lvt l=0.6 w=1.4 as=0.406
+ ad=0.406 ps=3.38 pd=3.38
X$114 VDD \$280 \$42 VDD sky130_fd_pr__pfet_01v8_lvt l=0.6 w=1.4 as=0.406
+ ad=0.406 ps=3.38 pd=3.38
X$115 VDD \$280 \$89 VDD sky130_fd_pr__pfet_01v8_lvt l=0.6 w=1.4 as=0.406
+ ad=0.406 ps=3.38 pd=3.38
X$116 VDD \$280 \$42 VDD sky130_fd_pr__pfet_01v8_lvt l=0.6 w=1.4 as=0.406
+ ad=0.406 ps=3.38 pd=3.38
X$117 VDD \$280 \$89 VDD sky130_fd_pr__pfet_01v8_lvt l=0.6 w=1.4 as=0.406
+ ad=0.406 ps=3.38 pd=3.38
X$118 VDD \$280 \$42 VDD sky130_fd_pr__pfet_01v8_lvt l=0.6 w=1.4 as=0.406
+ ad=0.406 ps=3.38 pd=3.38
X$119 VDD \$280 \$89 VDD sky130_fd_pr__pfet_01v8_lvt l=0.6 w=1.4 as=0.406
+ ad=0.406 ps=3.38 pd=3.38
X$120 VDD \$280 \$42 VDD sky130_fd_pr__pfet_01v8_lvt l=0.6 w=1.4 as=0.406
+ ad=0.406 ps=3.38 pd=3.38
X$121 VDD \$280 \$89 VDD sky130_fd_pr__pfet_01v8_lvt l=0.6 w=1.4 as=0.406
+ ad=0.406 ps=3.38 pd=3.38
X$122 VDD \$280 \$42 VDD sky130_fd_pr__pfet_01v8_lvt l=0.6 w=1.4 as=0.406
+ ad=0.406 ps=3.38 pd=3.38
X$123 VDD \$280 \$89 VDD sky130_fd_pr__pfet_01v8_lvt l=0.6 w=1.4 as=0.406
+ ad=0.406 ps=3.38 pd=3.38
X$124 VDD \$280 \$42 VDD sky130_fd_pr__pfet_01v8_lvt l=0.6 w=1.4 as=0.406
+ ad=0.406 ps=3.38 pd=3.38
X$125 VDD \$280 \$42 VDD sky130_fd_pr__pfet_01v8_lvt l=0.6 w=1.4 as=0.406
+ ad=0.406 ps=3.38 pd=3.38
X$126 VDD VDD VDD VDD sky130_fd_pr__pfet_01v8_lvt l=0.6 w=1.4 as=0.406 ad=0.406
+ ps=3.38 pd=3.38
X$127 VDD \$280 \$89 VDD sky130_fd_pr__pfet_01v8_lvt l=0.6 w=1.4 as=0.406
+ ad=0.406 ps=3.38 pd=3.38
X$128 VDD \$280 \$42 VDD sky130_fd_pr__pfet_01v8_lvt l=0.6 w=1.4 as=0.406
+ ad=0.406 ps=3.38 pd=3.38
X$129 VDD \$280 \$89 VDD sky130_fd_pr__pfet_01v8_lvt l=0.6 w=1.4 as=0.406
+ ad=0.406 ps=3.38 pd=3.38
X$130 VDD \$280 \$42 VDD sky130_fd_pr__pfet_01v8_lvt l=0.6 w=1.4 as=0.406
+ ad=0.406 ps=3.38 pd=3.38
X$131 VDD \$280 \$89 VDD sky130_fd_pr__pfet_01v8_lvt l=0.6 w=1.4 as=0.406
+ ad=0.406 ps=3.38 pd=3.38
X$132 VDD \$280 \$42 VDD sky130_fd_pr__pfet_01v8_lvt l=0.6 w=1.4 as=0.406
+ ad=0.406 ps=3.38 pd=3.38
X$133 VDD \$280 \$89 VDD sky130_fd_pr__pfet_01v8_lvt l=0.6 w=1.4 as=0.406
+ ad=0.406 ps=3.38 pd=3.38
X$134 VDD \$280 \$42 VDD sky130_fd_pr__pfet_01v8_lvt l=0.6 w=1.4 as=0.406
+ ad=0.406 ps=3.38 pd=3.38
X$135 VDD \$280 \$89 VDD sky130_fd_pr__pfet_01v8_lvt l=0.6 w=1.4 as=0.406
+ ad=0.406 ps=3.38 pd=3.38
X$136 VDD \$280 \$42 VDD sky130_fd_pr__pfet_01v8_lvt l=0.6 w=1.4 as=0.406
+ ad=0.406 ps=3.38 pd=3.38
X$137 VDD \$280 \$42 VDD sky130_fd_pr__pfet_01v8_lvt l=0.6 w=1.4 as=0.406
+ ad=0.406 ps=3.38 pd=3.38
X$138 VDD \$280 \$42 VDD sky130_fd_pr__pfet_01v8_lvt l=0.6 w=1.4 as=0.406
+ ad=0.406 ps=3.38 pd=3.38
X$139 VDD \$280 \$89 VDD sky130_fd_pr__pfet_01v8_lvt l=0.6 w=1.4 as=0.406
+ ad=0.406 ps=3.38 pd=3.38
X$140 VDD \$280 \$42 VDD sky130_fd_pr__pfet_01v8_lvt l=0.6 w=1.4 as=0.406
+ ad=0.406 ps=3.38 pd=3.38
X$141 VDD \$280 \$89 VDD sky130_fd_pr__pfet_01v8_lvt l=0.6 w=1.4 as=0.406
+ ad=0.406 ps=3.38 pd=3.38
X$142 VDD \$280 \$42 VDD sky130_fd_pr__pfet_01v8_lvt l=0.6 w=1.4 as=0.406
+ ad=0.406 ps=3.38 pd=3.38
X$143 VDD \$280 \$89 VDD sky130_fd_pr__pfet_01v8_lvt l=0.6 w=1.4 as=0.406
+ ad=0.406 ps=3.38 pd=3.38
X$144 VDD \$280 \$42 VDD sky130_fd_pr__pfet_01v8_lvt l=0.6 w=1.4 as=0.406
+ ad=0.406 ps=3.38 pd=3.38
X$145 VDD \$280 \$89 VDD sky130_fd_pr__pfet_01v8_lvt l=0.6 w=1.4 as=0.406
+ ad=0.406 ps=3.38 pd=3.38
X$146 VDD \$280 \$42 VDD sky130_fd_pr__pfet_01v8_lvt l=0.6 w=1.4 as=0.406
+ ad=0.406 ps=3.38 pd=3.38
X$147 VDD \$280 \$89 VDD sky130_fd_pr__pfet_01v8_lvt l=0.6 w=1.4 as=0.406
+ ad=0.406 ps=3.38 pd=3.38
X$148 VDD \$280 \$42 VDD sky130_fd_pr__pfet_01v8_lvt l=0.6 w=1.4 as=0.406
+ ad=0.406 ps=3.38 pd=3.38
X$149 VDD \$280 \$89 VDD sky130_fd_pr__pfet_01v8_lvt l=0.6 w=1.4 as=0.406
+ ad=0.406 ps=3.38 pd=3.38
X$150 VDD \$280 \$89 VDD sky130_fd_pr__pfet_01v8_lvt l=0.6 w=1.4 as=0.406
+ ad=0.406 ps=3.38 pd=3.38
X$151 VDD VDD \$338 VDD sky130_fd_pr__pfet_01v8 l=0.6 w=1.4 as=0.406 ad=0.406
+ ps=3.38 pd=3.38
X$152 VDD VDD \$338 VDD sky130_fd_pr__pfet_01v8 l=0.6 w=1.4 as=0.406 ad=0.406
+ ps=3.38 pd=3.38
X$153 VDD VDD \$280 VDD sky130_fd_pr__pfet_01v8 l=0.6 w=1.4 as=0.406 ad=0.406
+ ps=3.38 pd=3.38
X$154 VDD VDD \$280 VDD sky130_fd_pr__pfet_01v8 l=0.6 w=1.4 as=0.406 ad=0.406
+ ps=3.38 pd=3.38
X$155 VDD VDD \$649 VDD sky130_fd_pr__pfet_01v8 l=0.6 w=1.4 as=0.406 ad=0.406
+ ps=3.38 pd=3.38
X$156 VDD VDD \$649 VDD sky130_fd_pr__pfet_01v8 l=0.6 w=1.4 as=0.406 ad=0.406
+ ps=3.38 pd=3.38
X$157 VDD VDD cm VDD sky130_fd_pr__pfet_01v8 l=0.6 w=1.4 as=0.406 ad=0.406
+ ps=3.38 pd=3.38
X$158 VDD VDD cm VDD sky130_fd_pr__pfet_01v8 l=0.6 w=1.4 as=0.406 ad=0.406
+ ps=3.38 pd=3.38
X$159 \$643 \$643 \$643 VDD sky130_fd_pr__pfet_01v8 l=0.6 w=1.4 as=0.406
+ ad=0.406 ps=3.38 pd=3.38
X$160 \$643 \$643 \$643 VDD sky130_fd_pr__pfet_01v8 l=0.6 w=1.4 as=0.406
+ ad=0.406 ps=3.38 pd=3.38
X$161 \$644 \$644 \$644 VDD sky130_fd_pr__pfet_01v8 l=0.6 w=1.4 as=0.406
+ ad=0.406 ps=3.38 pd=3.38
X$162 \$644 \$644 \$644 VDD sky130_fd_pr__pfet_01v8 l=0.6 w=1.4 as=0.406
+ ad=0.406 ps=3.38 pd=3.38
X$163 VDD VDD \$89 VDD sky130_fd_pr__pfet_01v8 l=0.6 w=1.4 as=0.406 ad=0.406
+ ps=3.38 pd=3.38
X$164 VDD VDD \$89 VDD sky130_fd_pr__pfet_01v8 l=0.6 w=1.4 as=0.406 ad=0.406
+ ps=3.38 pd=3.38
X$165 VDD VDD \$42 VDD sky130_fd_pr__pfet_01v8 l=0.6 w=1.4 as=0.406 ad=0.406
+ ps=3.38 pd=3.38
X$166 VDD VDD \$42 VDD sky130_fd_pr__pfet_01v8 l=0.6 w=1.4 as=0.406 ad=0.406
+ ps=3.38 pd=3.38
X$167 \$42 \$42 \$42 VDD sky130_fd_pr__pfet_01v8 l=0.6 w=1.4 as=0.406 ad=0.406
+ ps=3.38 pd=3.38
X$168 \$42 \$42 \$42 VDD sky130_fd_pr__pfet_01v8 l=0.6 w=1.4 as=0.406 ad=0.406
+ ps=3.38 pd=3.38
X$169 \$89 \$89 \$89 VDD sky130_fd_pr__pfet_01v8 l=0.6 w=1.4 as=0.406 ad=0.406
+ ps=3.38 pd=3.38
X$170 \$89 \$89 \$89 VDD sky130_fd_pr__pfet_01v8 l=0.6 w=1.4 as=0.406 ad=0.406
+ ps=3.38 pd=3.38
X$171 VDD VDD op VDD sky130_fd_pr__pfet_01v8 l=0.6 w=1.4 as=0.406 ad=0.406
+ ps=3.38 pd=3.38
X$172 VDD VDD op VDD sky130_fd_pr__pfet_01v8 l=0.6 w=1.4 as=0.406 ad=0.406
+ ps=3.38 pd=3.38
X$173 VDD VDD op VDD sky130_fd_pr__pfet_01v8 l=0.6 w=1.4 as=0.406 ad=0.406
+ ps=3.38 pd=3.38
X$174 VDD VDD op VDD sky130_fd_pr__pfet_01v8 l=0.6 w=1.4 as=0.406 ad=0.406
+ ps=3.38 pd=3.38
X$175 VDD VDD on VDD sky130_fd_pr__pfet_01v8 l=0.6 w=1.4 as=0.406 ad=0.406
+ ps=3.38 pd=3.38
X$176 VDD VDD on VDD sky130_fd_pr__pfet_01v8 l=0.6 w=1.4 as=0.406 ad=0.406
+ ps=3.38 pd=3.38
X$177 VDD VDD on VDD sky130_fd_pr__pfet_01v8 l=0.6 w=1.4 as=0.406 ad=0.406
+ ps=3.38 pd=3.38
X$178 VDD VDD on VDD sky130_fd_pr__pfet_01v8 l=0.6 w=1.4 as=0.406 ad=0.406
+ ps=3.38 pd=3.38
X$179 \$61 in \$89 sky130_gnd sky130_fd_pr__nfet_01v8_lvt l=0.2 w=1.2 as=0.348
+ ad=0.348 ps=2.98 pd=2.98
X$180 \$61 in \$89 sky130_gnd sky130_fd_pr__nfet_01v8_lvt l=0.2 w=1.2 as=0.348
+ ad=0.348 ps=2.98 pd=2.98
X$181 \$61 in \$89 sky130_gnd sky130_fd_pr__nfet_01v8_lvt l=0.2 w=1.2 as=0.348
+ ad=0.348 ps=2.98 pd=2.98
X$182 \$61 in \$89 sky130_gnd sky130_fd_pr__nfet_01v8_lvt l=0.2 w=1.2 as=0.348
+ ad=0.348 ps=2.98 pd=2.98
X$183 \$61 in \$89 sky130_gnd sky130_fd_pr__nfet_01v8_lvt l=0.2 w=1.2 as=0.348
+ ad=0.348 ps=2.98 pd=2.98
X$184 \$61 in \$89 sky130_gnd sky130_fd_pr__nfet_01v8_lvt l=0.2 w=1.2 as=0.348
+ ad=0.348 ps=2.98 pd=2.98
X$185 \$61 ip \$42 sky130_gnd sky130_fd_pr__nfet_01v8_lvt l=0.2 w=1.2 as=0.348
+ ad=0.348 ps=2.98 pd=2.98
X$186 \$61 ip \$42 sky130_gnd sky130_fd_pr__nfet_01v8_lvt l=0.2 w=1.2 as=0.348
+ ad=0.348 ps=2.98 pd=2.98
X$187 \$61 ip \$42 sky130_gnd sky130_fd_pr__nfet_01v8_lvt l=0.2 w=1.2 as=0.348
+ ad=0.348 ps=2.98 pd=2.98
X$188 \$61 ip \$42 sky130_gnd sky130_fd_pr__nfet_01v8_lvt l=0.2 w=1.2 as=0.348
+ ad=0.348 ps=2.98 pd=2.98
X$189 \$61 ip \$42 sky130_gnd sky130_fd_pr__nfet_01v8_lvt l=0.2 w=1.2 as=0.348
+ ad=0.348 ps=2.98 pd=2.98
X$190 \$61 ip \$42 sky130_gnd sky130_fd_pr__nfet_01v8_lvt l=0.2 w=1.2 as=0.348
+ ad=0.348 ps=2.98 pd=2.98
X$191 VSS VSS VSS sky130_gnd sky130_fd_pr__nfet_01v8_lvt l=0.2 w=1.2 as=0.348
+ ad=0.348 ps=2.98 pd=2.98
X$192 VSS VSS VSS sky130_gnd sky130_fd_pr__nfet_01v8_lvt l=0.2 w=1.2 as=0.348
+ ad=0.348 ps=2.98 pd=2.98
X$193 \$388 \$338 \$338 sky130_gnd sky130_fd_pr__nfet_01v8 l=0.6 w=1.4 as=0.406
+ ad=0.406 ps=3.38 pd=3.38
X$194 \$388 \$338 \$338 sky130_gnd sky130_fd_pr__nfet_01v8 l=0.6 w=1.4 as=0.406
+ ad=0.406 ps=3.38 pd=3.38
X$195 \$388 \$338 \$338 sky130_gnd sky130_fd_pr__nfet_01v8 l=0.6 w=1.4 as=0.406
+ ad=0.406 ps=3.38 pd=3.38
X$196 \$388 \$338 \$338 sky130_gnd sky130_fd_pr__nfet_01v8 l=0.6 w=1.4 as=0.406
+ ad=0.406 ps=3.38 pd=3.38
X$197 \$388 \$338 \$338 sky130_gnd sky130_fd_pr__nfet_01v8 l=0.6 w=1.4 as=0.406
+ ad=0.406 ps=3.38 pd=3.38
X$198 \$388 \$338 \$338 sky130_gnd sky130_fd_pr__nfet_01v8 l=0.6 w=1.4 as=0.406
+ ad=0.406 ps=3.38 pd=3.38
X$199 \$388 \$338 \$338 sky130_gnd sky130_fd_pr__nfet_01v8 l=0.6 w=1.4 as=0.406
+ ad=0.406 ps=3.38 pd=3.38
X$200 \$388 \$338 \$338 sky130_gnd sky130_fd_pr__nfet_01v8 l=0.6 w=1.4 as=0.406
+ ad=0.406 ps=3.38 pd=3.38
X$201 \$388 \$338 \$338 sky130_gnd sky130_fd_pr__nfet_01v8 l=0.6 w=1.4 as=0.406
+ ad=0.406 ps=3.38 pd=3.38
X$202 \$388 \$338 \$338 sky130_gnd sky130_fd_pr__nfet_01v8 l=0.6 w=1.4 as=0.406
+ ad=0.406 ps=3.38 pd=3.38
X$203 \$388 \$338 \$338 sky130_gnd sky130_fd_pr__nfet_01v8 l=0.6 w=1.4 as=0.406
+ ad=0.406 ps=3.38 pd=3.38
X$204 \$388 \$338 \$338 sky130_gnd sky130_fd_pr__nfet_01v8 l=0.6 w=1.4 as=0.406
+ ad=0.406 ps=3.38 pd=3.38
X$205 \$388 \$338 \$338 sky130_gnd sky130_fd_pr__nfet_01v8 l=0.6 w=1.4 as=0.406
+ ad=0.406 ps=3.38 pd=3.38
X$206 \$388 \$338 \$338 sky130_gnd sky130_fd_pr__nfet_01v8 l=0.6 w=1.4 as=0.406
+ ad=0.406 ps=3.38 pd=3.38
X$207 \$388 \$338 \$338 sky130_gnd sky130_fd_pr__nfet_01v8 l=0.6 w=1.4 as=0.406
+ ad=0.406 ps=3.38 pd=3.38
X$208 \$388 \$338 \$338 sky130_gnd sky130_fd_pr__nfet_01v8 l=0.6 w=1.4 as=0.406
+ ad=0.406 ps=3.38 pd=3.38
X$209 \$388 \$338 \$338 sky130_gnd sky130_fd_pr__nfet_01v8 l=0.6 w=1.4 as=0.406
+ ad=0.406 ps=3.38 pd=3.38
X$210 \$388 \$338 \$338 sky130_gnd sky130_fd_pr__nfet_01v8 l=0.6 w=1.4 as=0.406
+ ad=0.406 ps=3.38 pd=3.38
X$211 \$388 \$338 \$338 sky130_gnd sky130_fd_pr__nfet_01v8 l=0.6 w=1.4 as=0.406
+ ad=0.406 ps=3.38 pd=3.38
X$212 \$388 \$338 \$338 sky130_gnd sky130_fd_pr__nfet_01v8 l=0.6 w=1.4 as=0.406
+ ad=0.406 ps=3.38 pd=3.38
X$213 \$388 \$338 \$338 sky130_gnd sky130_fd_pr__nfet_01v8 l=0.6 w=1.4 as=0.406
+ ad=0.406 ps=3.38 pd=3.38
X$214 \$388 \$338 \$338 sky130_gnd sky130_fd_pr__nfet_01v8 l=0.6 w=1.4 as=0.406
+ ad=0.406 ps=3.38 pd=3.38
X$215 \$388 \$338 \$338 sky130_gnd sky130_fd_pr__nfet_01v8 l=0.6 w=1.4 as=0.406
+ ad=0.406 ps=3.38 pd=3.38
X$216 \$388 \$338 \$338 sky130_gnd sky130_fd_pr__nfet_01v8 l=0.6 w=1.4 as=0.406
+ ad=0.406 ps=3.38 pd=3.38
X$217 \$388 \$338 \$338 sky130_gnd sky130_fd_pr__nfet_01v8 l=0.6 w=1.4 as=0.406
+ ad=0.406 ps=3.38 pd=3.38
X$218 \$388 \$338 \$338 sky130_gnd sky130_fd_pr__nfet_01v8 l=0.6 w=1.4 as=0.406
+ ad=0.406 ps=3.38 pd=3.38
X$219 \$388 \$338 \$338 sky130_gnd sky130_fd_pr__nfet_01v8 l=0.6 w=1.4 as=0.406
+ ad=0.406 ps=3.38 pd=3.38
X$220 \$388 \$338 \$338 sky130_gnd sky130_fd_pr__nfet_01v8 l=0.6 w=1.4 as=0.406
+ ad=0.406 ps=3.38 pd=3.38
X$221 \$388 \$338 \$338 sky130_gnd sky130_fd_pr__nfet_01v8 l=0.6 w=1.4 as=0.406
+ ad=0.406 ps=3.38 pd=3.38
X$222 \$388 \$338 \$338 sky130_gnd sky130_fd_pr__nfet_01v8 l=0.6 w=1.4 as=0.406
+ ad=0.406 ps=3.38 pd=3.38
X$223 \$388 \$338 \$338 sky130_gnd sky130_fd_pr__nfet_01v8 l=0.6 w=1.4 as=0.406
+ ad=0.406 ps=3.38 pd=3.38
X$224 \$388 \$338 \$338 sky130_gnd sky130_fd_pr__nfet_01v8 l=0.6 w=1.4 as=0.406
+ ad=0.406 ps=3.38 pd=3.38
X$225 \$388 \$338 \$338 sky130_gnd sky130_fd_pr__nfet_01v8 l=0.6 w=1.4 as=0.406
+ ad=0.406 ps=3.38 pd=3.38
X$226 \$388 \$338 \$338 sky130_gnd sky130_fd_pr__nfet_01v8 l=0.6 w=1.4 as=0.406
+ ad=0.406 ps=3.38 pd=3.38
X$227 \$388 \$338 \$338 sky130_gnd sky130_fd_pr__nfet_01v8 l=0.6 w=1.4 as=0.406
+ ad=0.406 ps=3.38 pd=3.38
X$228 \$388 \$338 \$338 sky130_gnd sky130_fd_pr__nfet_01v8 l=0.6 w=1.4 as=0.406
+ ad=0.406 ps=3.38 pd=3.38
X$229 \$388 \$338 \$338 sky130_gnd sky130_fd_pr__nfet_01v8 l=0.6 w=1.4 as=0.406
+ ad=0.406 ps=3.38 pd=3.38
X$230 \$388 \$338 \$338 sky130_gnd sky130_fd_pr__nfet_01v8 l=0.6 w=1.4 as=0.406
+ ad=0.406 ps=3.38 pd=3.38
X$231 \$388 \$338 \$338 sky130_gnd sky130_fd_pr__nfet_01v8 l=0.6 w=1.4 as=0.406
+ ad=0.406 ps=3.38 pd=3.38
X$232 \$388 \$338 \$338 sky130_gnd sky130_fd_pr__nfet_01v8 l=0.6 w=1.4 as=0.406
+ ad=0.406 ps=3.38 pd=3.38
X$233 \$388 \$338 \$338 sky130_gnd sky130_fd_pr__nfet_01v8 l=0.6 w=1.4 as=0.406
+ ad=0.406 ps=3.38 pd=3.38
X$234 \$388 \$338 \$338 sky130_gnd sky130_fd_pr__nfet_01v8 l=0.6 w=1.4 as=0.406
+ ad=0.406 ps=3.38 pd=3.38
X$235 \$388 \$338 \$338 sky130_gnd sky130_fd_pr__nfet_01v8 l=0.6 w=1.4 as=0.406
+ ad=0.406 ps=3.38 pd=3.38
X$236 \$388 \$338 \$338 sky130_gnd sky130_fd_pr__nfet_01v8 l=0.6 w=1.4 as=0.406
+ ad=0.406 ps=3.38 pd=3.38
X$237 \$388 \$338 \$338 sky130_gnd sky130_fd_pr__nfet_01v8 l=0.6 w=1.4 as=0.406
+ ad=0.406 ps=3.38 pd=3.38
X$238 \$388 \$338 \$338 sky130_gnd sky130_fd_pr__nfet_01v8 l=0.6 w=1.4 as=0.406
+ ad=0.406 ps=3.38 pd=3.38
X$239 \$388 \$338 \$338 sky130_gnd sky130_fd_pr__nfet_01v8 l=0.6 w=1.4 as=0.406
+ ad=0.406 ps=3.38 pd=3.38
X$240 \$388 \$338 \$338 sky130_gnd sky130_fd_pr__nfet_01v8 l=0.6 w=1.4 as=0.406
+ ad=0.406 ps=3.38 pd=3.38
X$241 \$388 \$338 \$338 sky130_gnd sky130_fd_pr__nfet_01v8 l=0.6 w=1.4 as=0.406
+ ad=0.406 ps=3.38 pd=3.38
X$242 \$388 \$338 \$338 sky130_gnd sky130_fd_pr__nfet_01v8 l=0.6 w=1.4 as=0.406
+ ad=0.406 ps=3.38 pd=3.38
X$243 VSS IBIAS \$213 sky130_gnd sky130_fd_pr__nfet_01v8 l=0.6 w=1.4 as=0.406
+ ad=0.406 ps=3.38 pd=3.38
X$244 VSS IBIAS \$213 sky130_gnd sky130_fd_pr__nfet_01v8 l=0.6 w=1.4 as=0.406
+ ad=0.406 ps=3.38 pd=3.38
X$245 VSS IBIAS \$213 sky130_gnd sky130_fd_pr__nfet_01v8 l=0.6 w=1.4 as=0.406
+ ad=0.406 ps=3.38 pd=3.38
X$246 VSS IBIAS \$213 sky130_gnd sky130_fd_pr__nfet_01v8 l=0.6 w=1.4 as=0.406
+ ad=0.406 ps=3.38 pd=3.38
X$247 VSS IBIAS \$213 sky130_gnd sky130_fd_pr__nfet_01v8 l=0.6 w=1.4 as=0.406
+ ad=0.406 ps=3.38 pd=3.38
X$248 VSS IBIAS \$213 sky130_gnd sky130_fd_pr__nfet_01v8 l=0.6 w=1.4 as=0.406
+ ad=0.406 ps=3.38 pd=3.38
X$249 VSS IBIAS \$213 sky130_gnd sky130_fd_pr__nfet_01v8 l=0.6 w=1.4 as=0.406
+ ad=0.406 ps=3.38 pd=3.38
X$250 VSS IBIAS \$213 sky130_gnd sky130_fd_pr__nfet_01v8 l=0.6 w=1.4 as=0.406
+ ad=0.406 ps=3.38 pd=3.38
X$251 VSS IBIAS \$213 sky130_gnd sky130_fd_pr__nfet_01v8 l=0.6 w=1.4 as=0.406
+ ad=0.406 ps=3.38 pd=3.38
X$252 VSS IBIAS \$213 sky130_gnd sky130_fd_pr__nfet_01v8 l=0.6 w=1.4 as=0.406
+ ad=0.406 ps=3.38 pd=3.38
X$253 VSS IBIAS \$213 sky130_gnd sky130_fd_pr__nfet_01v8 l=0.6 w=1.4 as=0.406
+ ad=0.406 ps=3.38 pd=3.38
X$254 VSS IBIAS \$213 sky130_gnd sky130_fd_pr__nfet_01v8 l=0.6 w=1.4 as=0.406
+ ad=0.406 ps=3.38 pd=3.38
X$255 VSS IBIAS \$213 sky130_gnd sky130_fd_pr__nfet_01v8 l=0.6 w=1.4 as=0.406
+ ad=0.406 ps=3.38 pd=3.38
X$256 VSS IBIAS \$213 sky130_gnd sky130_fd_pr__nfet_01v8 l=0.6 w=1.4 as=0.406
+ ad=0.406 ps=3.38 pd=3.38
X$257 VSS IBIAS \$213 sky130_gnd sky130_fd_pr__nfet_01v8 l=0.6 w=1.4 as=0.406
+ ad=0.406 ps=3.38 pd=3.38
X$258 VSS IBIAS \$213 sky130_gnd sky130_fd_pr__nfet_01v8 l=0.6 w=1.4 as=0.406
+ ad=0.406 ps=3.38 pd=3.38
X$259 VSS IBIAS \$213 sky130_gnd sky130_fd_pr__nfet_01v8 l=0.6 w=1.4 as=0.406
+ ad=0.406 ps=3.38 pd=3.38
X$260 VSS IBIAS \$213 sky130_gnd sky130_fd_pr__nfet_01v8 l=0.6 w=1.4 as=0.406
+ ad=0.406 ps=3.38 pd=3.38
X$261 VSS VSS VSS sky130_gnd sky130_fd_pr__nfet_01v8 l=0.6 w=1.4 as=0.406
+ ad=0.406 ps=3.38 pd=3.38
X$262 VSS IBIAS IBIAS sky130_gnd sky130_fd_pr__nfet_01v8 l=0.6 w=1.4 as=0.406
+ ad=0.406 ps=3.38 pd=3.38
X$263 VSS IBIAS IBIAS sky130_gnd sky130_fd_pr__nfet_01v8 l=0.6 w=1.4 as=0.406
+ ad=0.406 ps=3.38 pd=3.38
X$264 VSS IBIAS IBIAS sky130_gnd sky130_fd_pr__nfet_01v8 l=0.6 w=1.4 as=0.406
+ ad=0.406 ps=3.38 pd=3.38
X$265 VSS IBIAS IBIAS sky130_gnd sky130_fd_pr__nfet_01v8 l=0.6 w=1.4 as=0.406
+ ad=0.406 ps=3.38 pd=3.38
X$266 VSS VSS VSS sky130_gnd sky130_fd_pr__nfet_01v8 l=0.6 w=1.4 as=0.406
+ ad=0.406 ps=3.38 pd=3.38
X$267 VSS IBIAS IBIAS sky130_gnd sky130_fd_pr__nfet_01v8 l=0.6 w=1.4 as=0.406
+ ad=0.406 ps=3.38 pd=3.38
X$268 VSS IBIAS IBIAS sky130_gnd sky130_fd_pr__nfet_01v8 l=0.6 w=1.4 as=0.406
+ ad=0.406 ps=3.38 pd=3.38
X$269 VSS IBIAS IBIAS sky130_gnd sky130_fd_pr__nfet_01v8 l=0.6 w=1.4 as=0.406
+ ad=0.406 ps=3.38 pd=3.38
X$270 VSS IBIAS IBIAS sky130_gnd sky130_fd_pr__nfet_01v8 l=0.6 w=1.4 as=0.406
+ ad=0.406 ps=3.38 pd=3.38
X$271 VSS IBIAS IBIAS sky130_gnd sky130_fd_pr__nfet_01v8 l=0.6 w=1.4 as=0.406
+ ad=0.406 ps=3.38 pd=3.38
X$272 VSS IBIAS IBIAS sky130_gnd sky130_fd_pr__nfet_01v8 l=0.6 w=1.4 as=0.406
+ ad=0.406 ps=3.38 pd=3.38
X$273 VSS IBIAS IBIAS sky130_gnd sky130_fd_pr__nfet_01v8 l=0.6 w=1.4 as=0.406
+ ad=0.406 ps=3.38 pd=3.38
X$274 VSS IBIAS IBIAS sky130_gnd sky130_fd_pr__nfet_01v8 l=0.6 w=1.4 as=0.406
+ ad=0.406 ps=3.38 pd=3.38
X$275 VSS IBIAS IBIAS sky130_gnd sky130_fd_pr__nfet_01v8 l=0.6 w=1.4 as=0.406
+ ad=0.406 ps=3.38 pd=3.38
X$276 VSS IBIAS IBIAS sky130_gnd sky130_fd_pr__nfet_01v8 l=0.6 w=1.4 as=0.406
+ ad=0.406 ps=3.38 pd=3.38
X$277 VSS IBIAS IBIAS sky130_gnd sky130_fd_pr__nfet_01v8 l=0.6 w=1.4 as=0.406
+ ad=0.406 ps=3.38 pd=3.38
X$278 VSS IBIAS IBIAS sky130_gnd sky130_fd_pr__nfet_01v8 l=0.6 w=1.4 as=0.406
+ ad=0.406 ps=3.38 pd=3.38
X$279 VSS IBIAS IBIAS sky130_gnd sky130_fd_pr__nfet_01v8 l=0.6 w=1.4 as=0.406
+ ad=0.406 ps=3.38 pd=3.38
X$280 VSS IBIAS IBIAS sky130_gnd sky130_fd_pr__nfet_01v8 l=0.6 w=1.4 as=0.406
+ ad=0.406 ps=3.38 pd=3.38
X$281 VSS bias_a \$342 sky130_gnd sky130_fd_pr__nfet_01v8 l=0.6 w=1.4 as=0.406
+ ad=0.406 ps=3.38 pd=3.38
X$282 VSS bias_a \$342 sky130_gnd sky130_fd_pr__nfet_01v8 l=0.6 w=1.4 as=0.406
+ ad=0.406 ps=3.38 pd=3.38
X$283 VSS bias_a \$342 sky130_gnd sky130_fd_pr__nfet_01v8 l=0.6 w=1.4 as=0.406
+ ad=0.406 ps=3.38 pd=3.38
X$284 VSS bias_a \$342 sky130_gnd sky130_fd_pr__nfet_01v8 l=0.6 w=1.4 as=0.406
+ ad=0.406 ps=3.38 pd=3.38
X$285 VSS bias_a \$342 sky130_gnd sky130_fd_pr__nfet_01v8 l=0.6 w=1.4 as=0.406
+ ad=0.406 ps=3.38 pd=3.38
X$286 VSS bias_a \$342 sky130_gnd sky130_fd_pr__nfet_01v8 l=0.6 w=1.4 as=0.406
+ ad=0.406 ps=3.38 pd=3.38
X$287 VSS bias_a \$342 sky130_gnd sky130_fd_pr__nfet_01v8 l=0.6 w=1.4 as=0.406
+ ad=0.406 ps=3.38 pd=3.38
X$288 VSS bias_a \$342 sky130_gnd sky130_fd_pr__nfet_01v8 l=0.6 w=1.4 as=0.406
+ ad=0.406 ps=3.38 pd=3.38
X$289 VSS bias_a \$342 sky130_gnd sky130_fd_pr__nfet_01v8 l=0.6 w=1.4 as=0.406
+ ad=0.406 ps=3.38 pd=3.38
X$290 VSS bias_a \$342 sky130_gnd sky130_fd_pr__nfet_01v8 l=0.6 w=1.4 as=0.406
+ ad=0.406 ps=3.38 pd=3.38
X$291 VSS bias_a \$342 sky130_gnd sky130_fd_pr__nfet_01v8 l=0.6 w=1.4 as=0.406
+ ad=0.406 ps=3.38 pd=3.38
X$292 VSS bias_a \$342 sky130_gnd sky130_fd_pr__nfet_01v8 l=0.6 w=1.4 as=0.406
+ ad=0.406 ps=3.38 pd=3.38
X$293 VSS bias_a \$342 sky130_gnd sky130_fd_pr__nfet_01v8 l=0.6 w=1.4 as=0.406
+ ad=0.406 ps=3.38 pd=3.38
X$294 VSS bias_a \$342 sky130_gnd sky130_fd_pr__nfet_01v8 l=0.6 w=1.4 as=0.406
+ ad=0.406 ps=3.38 pd=3.38
X$295 VSS bias_a \$342 sky130_gnd sky130_fd_pr__nfet_01v8 l=0.6 w=1.4 as=0.406
+ ad=0.406 ps=3.38 pd=3.38
X$296 VSS bias_a \$342 sky130_gnd sky130_fd_pr__nfet_01v8 l=0.6 w=1.4 as=0.406
+ ad=0.406 ps=3.38 pd=3.38
X$297 VSS bias_a \$342 sky130_gnd sky130_fd_pr__nfet_01v8 l=0.6 w=1.4 as=0.406
+ ad=0.406 ps=3.38 pd=3.38
X$298 VSS bias_a \$342 sky130_gnd sky130_fd_pr__nfet_01v8 l=0.6 w=1.4 as=0.406
+ ad=0.406 ps=3.38 pd=3.38
X$299 \$342 \$388 bias_a sky130_gnd sky130_fd_pr__nfet_01v8 l=0.6 w=1.4
+ as=0.406 ad=0.406 ps=3.38 pd=3.38
X$300 \$342 \$388 bias_a sky130_gnd sky130_fd_pr__nfet_01v8 l=0.6 w=1.4
+ as=0.406 ad=0.406 ps=3.38 pd=3.38
X$301 \$342 \$388 bias_a sky130_gnd sky130_fd_pr__nfet_01v8 l=0.6 w=1.4
+ as=0.406 ad=0.406 ps=3.38 pd=3.38
X$302 \$342 \$388 bias_a sky130_gnd sky130_fd_pr__nfet_01v8 l=0.6 w=1.4
+ as=0.406 ad=0.406 ps=3.38 pd=3.38
X$303 \$342 \$388 bias_a sky130_gnd sky130_fd_pr__nfet_01v8 l=0.6 w=1.4
+ as=0.406 ad=0.406 ps=3.38 pd=3.38
X$304 \$342 \$388 bias_a sky130_gnd sky130_fd_pr__nfet_01v8 l=0.6 w=1.4
+ as=0.406 ad=0.406 ps=3.38 pd=3.38
X$305 \$342 \$388 bias_a sky130_gnd sky130_fd_pr__nfet_01v8 l=0.6 w=1.4
+ as=0.406 ad=0.406 ps=3.38 pd=3.38
X$306 \$342 \$388 bias_a sky130_gnd sky130_fd_pr__nfet_01v8 l=0.6 w=1.4
+ as=0.406 ad=0.406 ps=3.38 pd=3.38
X$307 \$342 \$388 bias_a sky130_gnd sky130_fd_pr__nfet_01v8 l=0.6 w=1.4
+ as=0.406 ad=0.406 ps=3.38 pd=3.38
X$308 \$342 \$388 bias_a sky130_gnd sky130_fd_pr__nfet_01v8 l=0.6 w=1.4
+ as=0.406 ad=0.406 ps=3.38 pd=3.38
X$309 \$342 \$388 bias_a sky130_gnd sky130_fd_pr__nfet_01v8 l=0.6 w=1.4
+ as=0.406 ad=0.406 ps=3.38 pd=3.38
X$310 \$342 \$388 bias_a sky130_gnd sky130_fd_pr__nfet_01v8 l=0.6 w=1.4
+ as=0.406 ad=0.406 ps=3.38 pd=3.38
X$311 \$342 \$388 bias_a sky130_gnd sky130_fd_pr__nfet_01v8 l=0.6 w=1.4
+ as=0.406 ad=0.406 ps=3.38 pd=3.38
X$312 \$342 \$388 bias_a sky130_gnd sky130_fd_pr__nfet_01v8 l=0.6 w=1.4
+ as=0.406 ad=0.406 ps=3.38 pd=3.38
X$313 \$342 \$388 bias_a sky130_gnd sky130_fd_pr__nfet_01v8 l=0.6 w=1.4
+ as=0.406 ad=0.406 ps=3.38 pd=3.38
X$314 \$342 \$388 bias_a sky130_gnd sky130_fd_pr__nfet_01v8 l=0.6 w=1.4
+ as=0.406 ad=0.406 ps=3.38 pd=3.38
X$315 \$342 \$388 bias_a sky130_gnd sky130_fd_pr__nfet_01v8 l=0.6 w=1.4
+ as=0.406 ad=0.406 ps=3.38 pd=3.38
X$316 \$342 \$388 bias_a sky130_gnd sky130_fd_pr__nfet_01v8 l=0.6 w=1.4
+ as=0.406 ad=0.406 ps=3.38 pd=3.38
X$317 \$501 cm \$46.x1_net1 sky130_gnd sky130_fd_pr__nfet_01v8 l=0.6 w=1.4
+ as=0.406 ad=0.406 ps=3.38 pd=3.38
X$318 VSS VSS VSS sky130_gnd sky130_fd_pr__nfet_01v8 l=0.6 w=1.4 as=0.406
+ ad=0.406 ps=3.38 pd=3.38
X$319 VSS VSS VSS sky130_gnd sky130_fd_pr__nfet_01v8 l=0.6 w=1.4 as=0.406
+ ad=0.406 ps=3.38 pd=3.38
X$320 \$46.x1_net1 cm cm sky130_gnd sky130_fd_pr__nfet_01v8 l=0.6 w=1.4
+ as=0.406 ad=0.406 ps=3.38 pd=3.38
X$321 \$499 cm \$45.x1_net13 sky130_gnd sky130_fd_pr__nfet_01v8 l=0.6 w=1.4
+ as=0.406 ad=0.406 ps=3.38 pd=3.38
X$322 VSS VSS VSS sky130_gnd sky130_fd_pr__nfet_01v8 l=0.6 w=1.4 as=0.406
+ ad=0.406 ps=3.38 pd=3.38
X$323 VSS VSS VSS sky130_gnd sky130_fd_pr__nfet_01v8 l=0.6 w=1.4 as=0.406
+ ad=0.406 ps=3.38 pd=3.38
X$324 \$45.x1_net13 cm cm sky130_gnd sky130_fd_pr__nfet_01v8 l=0.6 w=1.4
+ as=0.406 ad=0.406 ps=3.38 pd=3.38
X$325 VSS VSS VSS sky130_gnd sky130_fd_pr__nfet_01v8 l=0.6 w=1.4 as=0.406
+ ad=0.406 ps=3.38 pd=3.38
X$326 VSS VSS VSS sky130_gnd sky130_fd_pr__nfet_01v8 l=0.6 w=1.4 as=0.406
+ ad=0.406 ps=3.38 pd=3.38
X$327 VSS cm \$38.x1_net3 sky130_gnd sky130_fd_pr__nfet_01v8 l=0.6 w=1.4
+ as=0.406 ad=0.406 ps=3.38 pd=3.38
X$328 \$38.x1_net3 cm \$501 sky130_gnd sky130_fd_pr__nfet_01v8 l=0.6 w=1.4
+ as=0.406 ad=0.406 ps=3.38 pd=3.38
X$329 VSS VSS VSS sky130_gnd sky130_fd_pr__nfet_01v8 l=0.6 w=1.4 as=0.406
+ ad=0.406 ps=3.38 pd=3.38
X$330 VSS VSS VSS sky130_gnd sky130_fd_pr__nfet_01v8 l=0.6 w=1.4 as=0.406
+ ad=0.406 ps=3.38 pd=3.38
X$331 VSS cm \$37.x1_net15 sky130_gnd sky130_fd_pr__nfet_01v8 l=0.6 w=1.4
+ as=0.406 ad=0.406 ps=3.38 pd=3.38
X$332 \$37.x1_net15 cm \$499 sky130_gnd sky130_fd_pr__nfet_01v8 l=0.6 w=1.4
+ as=0.406 ad=0.406 ps=3.38 pd=3.38
X$333 \$386 cm \$41.x1_net10 sky130_gnd sky130_fd_pr__nfet_01v8 l=0.6 w=1.4
+ as=0.406 ad=0.406 ps=3.38 pd=3.38
X$334 VSS VSS VSS sky130_gnd sky130_fd_pr__nfet_01v8 l=0.6 w=1.4 as=0.406
+ ad=0.406 ps=3.38 pd=3.38
X$335 VSS VSS VSS sky130_gnd sky130_fd_pr__nfet_01v8 l=0.6 w=1.4 as=0.406
+ ad=0.406 ps=3.38 pd=3.38
X$336 \$41.x1_net10 cm cm sky130_gnd sky130_fd_pr__nfet_01v8 l=0.6 w=1.4
+ as=0.406 ad=0.406 ps=3.38 pd=3.38
X$337 \$385 cm \$40.x1_net7 sky130_gnd sky130_fd_pr__nfet_01v8 l=0.6 w=1.4
+ as=0.406 ad=0.406 ps=3.38 pd=3.38
X$338 VSS VSS VSS sky130_gnd sky130_fd_pr__nfet_01v8 l=0.6 w=1.4 as=0.406
+ ad=0.406 ps=3.38 pd=3.38
X$339 VSS VSS VSS sky130_gnd sky130_fd_pr__nfet_01v8 l=0.6 w=1.4 as=0.406
+ ad=0.406 ps=3.38 pd=3.38
X$340 \$40.x1_net7 cm cm sky130_gnd sky130_fd_pr__nfet_01v8 l=0.6 w=1.4
+ as=0.406 ad=0.406 ps=3.38 pd=3.38
X$341 \$383 cm \$39.x1_net4 sky130_gnd sky130_fd_pr__nfet_01v8 l=0.6 w=1.4
+ as=0.406 ad=0.406 ps=3.38 pd=3.38
X$342 VSS VSS VSS sky130_gnd sky130_fd_pr__nfet_01v8 l=0.6 w=1.4 as=0.406
+ ad=0.406 ps=3.38 pd=3.38
X$343 VSS VSS VSS sky130_gnd sky130_fd_pr__nfet_01v8 l=0.6 w=1.4 as=0.406
+ ad=0.406 ps=3.38 pd=3.38
X$344 \$39.x1_net4 cm cm sky130_gnd sky130_fd_pr__nfet_01v8 l=0.6 w=1.4
+ as=0.406 ad=0.406 ps=3.38 pd=3.38
X$345 VSS VSS VSS sky130_gnd sky130_fd_pr__nfet_01v8 l=0.6 w=1.4 as=0.406
+ ad=0.406 ps=3.38 pd=3.38
X$346 VSS VSS VSS sky130_gnd sky130_fd_pr__nfet_01v8 l=0.6 w=1.4 as=0.406
+ ad=0.406 ps=3.38 pd=3.38
X$347 VSS cm \$36.x1_net12 sky130_gnd sky130_fd_pr__nfet_01v8 l=0.6 w=1.4
+ as=0.406 ad=0.406 ps=3.38 pd=3.38
X$348 \$36.x1_net12 cm \$386 sky130_gnd sky130_fd_pr__nfet_01v8 l=0.6 w=1.4
+ as=0.406 ad=0.406 ps=3.38 pd=3.38
X$349 VSS VSS VSS sky130_gnd sky130_fd_pr__nfet_01v8 l=0.6 w=1.4 as=0.406
+ ad=0.406 ps=3.38 pd=3.38
X$350 VSS VSS VSS sky130_gnd sky130_fd_pr__nfet_01v8 l=0.6 w=1.4 as=0.406
+ ad=0.406 ps=3.38 pd=3.38
X$351 VSS cm \$25.x1_net9 sky130_gnd sky130_fd_pr__nfet_01v8 l=0.6 w=1.4
+ as=0.406 ad=0.406 ps=3.38 pd=3.38
X$352 \$25.x1_net9 cm \$385 sky130_gnd sky130_fd_pr__nfet_01v8 l=0.6 w=1.4
+ as=0.406 ad=0.406 ps=3.38 pd=3.38
X$353 VSS VSS VSS sky130_gnd sky130_fd_pr__nfet_01v8 l=0.6 w=1.4 as=0.406
+ ad=0.406 ps=3.38 pd=3.38
X$354 VSS VSS VSS sky130_gnd sky130_fd_pr__nfet_01v8 l=0.6 w=1.4 as=0.406
+ ad=0.406 ps=3.38 pd=3.38
X$355 VSS cm \$22.x1_net6 sky130_gnd sky130_fd_pr__nfet_01v8 l=0.6 w=1.4
+ as=0.406 ad=0.406 ps=3.38 pd=3.38
X$356 \$22.x1_net6 cm \$383 sky130_gnd sky130_fd_pr__nfet_01v8 l=0.6 w=1.4
+ as=0.406 ad=0.406 ps=3.38 pd=3.38
X$357 \$148 \$388 on sky130_gnd sky130_fd_pr__nfet_01v8 l=0.6 w=1.4 as=0.406
+ ad=0.406 ps=3.38 pd=3.38
X$358 \$148 \$388 on sky130_gnd sky130_fd_pr__nfet_01v8 l=0.6 w=1.4 as=0.406
+ ad=0.406 ps=3.38 pd=3.38
X$359 \$148 \$388 on sky130_gnd sky130_fd_pr__nfet_01v8 l=0.6 w=1.4 as=0.406
+ ad=0.406 ps=3.38 pd=3.38
X$360 \$148 \$388 on sky130_gnd sky130_fd_pr__nfet_01v8 l=0.6 w=1.4 as=0.406
+ ad=0.406 ps=3.38 pd=3.38
X$361 \$148 \$388 on sky130_gnd sky130_fd_pr__nfet_01v8 l=0.6 w=1.4 as=0.406
+ ad=0.406 ps=3.38 pd=3.38
X$362 \$148 \$388 on sky130_gnd sky130_fd_pr__nfet_01v8 l=0.6 w=1.4 as=0.406
+ ad=0.406 ps=3.38 pd=3.38
X$363 \$148 \$388 on sky130_gnd sky130_fd_pr__nfet_01v8 l=0.6 w=1.4 as=0.406
+ ad=0.406 ps=3.38 pd=3.38
X$364 \$148 \$388 on sky130_gnd sky130_fd_pr__nfet_01v8 l=0.6 w=1.4 as=0.406
+ ad=0.406 ps=3.38 pd=3.38
X$365 \$148 \$388 on sky130_gnd sky130_fd_pr__nfet_01v8 l=0.6 w=1.4 as=0.406
+ ad=0.406 ps=3.38 pd=3.38
X$366 \$148 \$388 on sky130_gnd sky130_fd_pr__nfet_01v8 l=0.6 w=1.4 as=0.406
+ ad=0.406 ps=3.38 pd=3.38
X$367 \$148 \$388 on sky130_gnd sky130_fd_pr__nfet_01v8 l=0.6 w=1.4 as=0.406
+ ad=0.406 ps=3.38 pd=3.38
X$368 \$148 \$388 on sky130_gnd sky130_fd_pr__nfet_01v8 l=0.6 w=1.4 as=0.406
+ ad=0.406 ps=3.38 pd=3.38
X$369 \$148 \$388 on sky130_gnd sky130_fd_pr__nfet_01v8 l=0.6 w=1.4 as=0.406
+ ad=0.406 ps=3.38 pd=3.38
X$370 \$148 \$388 on sky130_gnd sky130_fd_pr__nfet_01v8 l=0.6 w=1.4 as=0.406
+ ad=0.406 ps=3.38 pd=3.38
X$371 \$148 \$388 on sky130_gnd sky130_fd_pr__nfet_01v8 l=0.6 w=1.4 as=0.406
+ ad=0.406 ps=3.38 pd=3.38
X$372 \$148 \$388 on sky130_gnd sky130_fd_pr__nfet_01v8 l=0.6 w=1.4 as=0.406
+ ad=0.406 ps=3.38 pd=3.38
X$373 \$148 \$388 on sky130_gnd sky130_fd_pr__nfet_01v8 l=0.6 w=1.4 as=0.406
+ ad=0.406 ps=3.38 pd=3.38
X$374 \$148 \$388 on sky130_gnd sky130_fd_pr__nfet_01v8 l=0.6 w=1.4 as=0.406
+ ad=0.406 ps=3.38 pd=3.38
X$375 \$148 \$388 on sky130_gnd sky130_fd_pr__nfet_01v8 l=0.6 w=1.4 as=0.406
+ ad=0.406 ps=3.38 pd=3.38
X$376 \$148 \$388 on sky130_gnd sky130_fd_pr__nfet_01v8 l=0.6 w=1.4 as=0.406
+ ad=0.406 ps=3.38 pd=3.38
X$377 \$148 \$388 on sky130_gnd sky130_fd_pr__nfet_01v8 l=0.6 w=1.4 as=0.406
+ ad=0.406 ps=3.38 pd=3.38
X$378 \$148 \$388 on sky130_gnd sky130_fd_pr__nfet_01v8 l=0.6 w=1.4 as=0.406
+ ad=0.406 ps=3.38 pd=3.38
X$379 \$148 \$388 on sky130_gnd sky130_fd_pr__nfet_01v8 l=0.6 w=1.4 as=0.406
+ ad=0.406 ps=3.38 pd=3.38
X$380 \$148 \$388 on sky130_gnd sky130_fd_pr__nfet_01v8 l=0.6 w=1.4 as=0.406
+ ad=0.406 ps=3.38 pd=3.38
X$381 \$148 \$388 on sky130_gnd sky130_fd_pr__nfet_01v8 l=0.6 w=1.4 as=0.406
+ ad=0.406 ps=3.38 pd=3.38
X$382 \$148 \$388 on sky130_gnd sky130_fd_pr__nfet_01v8 l=0.6 w=1.4 as=0.406
+ ad=0.406 ps=3.38 pd=3.38
X$383 \$148 \$388 on sky130_gnd sky130_fd_pr__nfet_01v8 l=0.6 w=1.4 as=0.406
+ ad=0.406 ps=3.38 pd=3.38
X$384 \$148 \$388 on sky130_gnd sky130_fd_pr__nfet_01v8 l=0.6 w=1.4 as=0.406
+ ad=0.406 ps=3.38 pd=3.38
X$385 \$148 \$388 on sky130_gnd sky130_fd_pr__nfet_01v8 l=0.6 w=1.4 as=0.406
+ ad=0.406 ps=3.38 pd=3.38
X$386 \$148 \$388 on sky130_gnd sky130_fd_pr__nfet_01v8 l=0.6 w=1.4 as=0.406
+ ad=0.406 ps=3.38 pd=3.38
X$387 \$148 \$388 on sky130_gnd sky130_fd_pr__nfet_01v8 l=0.6 w=1.4 as=0.406
+ ad=0.406 ps=3.38 pd=3.38
X$388 \$148 \$388 on sky130_gnd sky130_fd_pr__nfet_01v8 l=0.6 w=1.4 as=0.406
+ ad=0.406 ps=3.38 pd=3.38
X$389 \$148 \$388 on sky130_gnd sky130_fd_pr__nfet_01v8 l=0.6 w=1.4 as=0.406
+ ad=0.406 ps=3.38 pd=3.38
X$390 \$148 \$388 on sky130_gnd sky130_fd_pr__nfet_01v8 l=0.6 w=1.4 as=0.406
+ ad=0.406 ps=3.38 pd=3.38
X$391 \$148 \$388 on sky130_gnd sky130_fd_pr__nfet_01v8 l=0.6 w=1.4 as=0.406
+ ad=0.406 ps=3.38 pd=3.38
X$392 \$148 \$388 on sky130_gnd sky130_fd_pr__nfet_01v8 l=0.6 w=1.4 as=0.406
+ ad=0.406 ps=3.38 pd=3.38
X$393 \$149 \$388 op sky130_gnd sky130_fd_pr__nfet_01v8 l=0.6 w=1.4 as=0.406
+ ad=0.406 ps=3.38 pd=3.38
X$394 \$149 \$388 op sky130_gnd sky130_fd_pr__nfet_01v8 l=0.6 w=1.4 as=0.406
+ ad=0.406 ps=3.38 pd=3.38
X$395 \$149 \$388 op sky130_gnd sky130_fd_pr__nfet_01v8 l=0.6 w=1.4 as=0.406
+ ad=0.406 ps=3.38 pd=3.38
X$396 \$149 \$388 op sky130_gnd sky130_fd_pr__nfet_01v8 l=0.6 w=1.4 as=0.406
+ ad=0.406 ps=3.38 pd=3.38
X$397 \$149 \$388 op sky130_gnd sky130_fd_pr__nfet_01v8 l=0.6 w=1.4 as=0.406
+ ad=0.406 ps=3.38 pd=3.38
X$398 \$149 \$388 op sky130_gnd sky130_fd_pr__nfet_01v8 l=0.6 w=1.4 as=0.406
+ ad=0.406 ps=3.38 pd=3.38
X$399 \$149 \$388 op sky130_gnd sky130_fd_pr__nfet_01v8 l=0.6 w=1.4 as=0.406
+ ad=0.406 ps=3.38 pd=3.38
X$400 \$149 \$388 op sky130_gnd sky130_fd_pr__nfet_01v8 l=0.6 w=1.4 as=0.406
+ ad=0.406 ps=3.38 pd=3.38
X$401 \$149 \$388 op sky130_gnd sky130_fd_pr__nfet_01v8 l=0.6 w=1.4 as=0.406
+ ad=0.406 ps=3.38 pd=3.38
X$402 \$149 \$388 op sky130_gnd sky130_fd_pr__nfet_01v8 l=0.6 w=1.4 as=0.406
+ ad=0.406 ps=3.38 pd=3.38
X$403 \$149 \$388 op sky130_gnd sky130_fd_pr__nfet_01v8 l=0.6 w=1.4 as=0.406
+ ad=0.406 ps=3.38 pd=3.38
X$404 \$149 \$388 op sky130_gnd sky130_fd_pr__nfet_01v8 l=0.6 w=1.4 as=0.406
+ ad=0.406 ps=3.38 pd=3.38
X$405 \$149 \$388 op sky130_gnd sky130_fd_pr__nfet_01v8 l=0.6 w=1.4 as=0.406
+ ad=0.406 ps=3.38 pd=3.38
X$406 \$149 \$388 op sky130_gnd sky130_fd_pr__nfet_01v8 l=0.6 w=1.4 as=0.406
+ ad=0.406 ps=3.38 pd=3.38
X$407 \$149 \$388 op sky130_gnd sky130_fd_pr__nfet_01v8 l=0.6 w=1.4 as=0.406
+ ad=0.406 ps=3.38 pd=3.38
X$408 \$149 \$388 op sky130_gnd sky130_fd_pr__nfet_01v8 l=0.6 w=1.4 as=0.406
+ ad=0.406 ps=3.38 pd=3.38
X$409 \$149 \$388 op sky130_gnd sky130_fd_pr__nfet_01v8 l=0.6 w=1.4 as=0.406
+ ad=0.406 ps=3.38 pd=3.38
X$410 \$149 \$388 op sky130_gnd sky130_fd_pr__nfet_01v8 l=0.6 w=1.4 as=0.406
+ ad=0.406 ps=3.38 pd=3.38
X$411 \$149 \$388 op sky130_gnd sky130_fd_pr__nfet_01v8 l=0.6 w=1.4 as=0.406
+ ad=0.406 ps=3.38 pd=3.38
X$412 \$149 \$388 op sky130_gnd sky130_fd_pr__nfet_01v8 l=0.6 w=1.4 as=0.406
+ ad=0.406 ps=3.38 pd=3.38
X$413 \$149 \$388 op sky130_gnd sky130_fd_pr__nfet_01v8 l=0.6 w=1.4 as=0.406
+ ad=0.406 ps=3.38 pd=3.38
X$414 \$149 \$388 op sky130_gnd sky130_fd_pr__nfet_01v8 l=0.6 w=1.4 as=0.406
+ ad=0.406 ps=3.38 pd=3.38
X$415 \$149 \$388 op sky130_gnd sky130_fd_pr__nfet_01v8 l=0.6 w=1.4 as=0.406
+ ad=0.406 ps=3.38 pd=3.38
X$416 \$149 \$388 op sky130_gnd sky130_fd_pr__nfet_01v8 l=0.6 w=1.4 as=0.406
+ ad=0.406 ps=3.38 pd=3.38
X$417 \$149 \$388 op sky130_gnd sky130_fd_pr__nfet_01v8 l=0.6 w=1.4 as=0.406
+ ad=0.406 ps=3.38 pd=3.38
X$418 \$149 \$388 op sky130_gnd sky130_fd_pr__nfet_01v8 l=0.6 w=1.4 as=0.406
+ ad=0.406 ps=3.38 pd=3.38
X$419 \$149 \$388 op sky130_gnd sky130_fd_pr__nfet_01v8 l=0.6 w=1.4 as=0.406
+ ad=0.406 ps=3.38 pd=3.38
X$420 \$149 \$388 op sky130_gnd sky130_fd_pr__nfet_01v8 l=0.6 w=1.4 as=0.406
+ ad=0.406 ps=3.38 pd=3.38
X$421 \$149 \$388 op sky130_gnd sky130_fd_pr__nfet_01v8 l=0.6 w=1.4 as=0.406
+ ad=0.406 ps=3.38 pd=3.38
X$422 \$149 \$388 op sky130_gnd sky130_fd_pr__nfet_01v8 l=0.6 w=1.4 as=0.406
+ ad=0.406 ps=3.38 pd=3.38
X$423 \$149 \$388 op sky130_gnd sky130_fd_pr__nfet_01v8 l=0.6 w=1.4 as=0.406
+ ad=0.406 ps=3.38 pd=3.38
X$424 \$149 \$388 op sky130_gnd sky130_fd_pr__nfet_01v8 l=0.6 w=1.4 as=0.406
+ ad=0.406 ps=3.38 pd=3.38
X$425 \$149 \$388 op sky130_gnd sky130_fd_pr__nfet_01v8 l=0.6 w=1.4 as=0.406
+ ad=0.406 ps=3.38 pd=3.38
X$426 \$149 \$388 op sky130_gnd sky130_fd_pr__nfet_01v8 l=0.6 w=1.4 as=0.406
+ ad=0.406 ps=3.38 pd=3.38
X$427 \$149 \$388 op sky130_gnd sky130_fd_pr__nfet_01v8 l=0.6 w=1.4 as=0.406
+ ad=0.406 ps=3.38 pd=3.38
X$428 \$149 \$388 op sky130_gnd sky130_fd_pr__nfet_01v8 l=0.6 w=1.4 as=0.406
+ ad=0.406 ps=3.38 pd=3.38
X$429 VSS VSS VSS sky130_gnd sky130_fd_pr__nfet_01v8 l=0.6 w=1.4 as=0.406
+ ad=0.406 ps=3.38 pd=3.38
X$430 VSS VSS VSS sky130_gnd sky130_fd_pr__nfet_01v8 l=0.6 w=1.4 as=0.406
+ ad=0.406 ps=3.38 pd=3.38
X$431 VSS bias_a \$149 sky130_gnd sky130_fd_pr__nfet_01v8 l=0.6 w=1.4 as=0.406
+ ad=0.406 ps=3.38 pd=3.38
X$432 VSS bias_a \$148 sky130_gnd sky130_fd_pr__nfet_01v8 l=0.6 w=1.4 as=0.406
+ ad=0.406 ps=3.38 pd=3.38
X$433 VSS bias_a \$149 sky130_gnd sky130_fd_pr__nfet_01v8 l=0.6 w=1.4 as=0.406
+ ad=0.406 ps=3.38 pd=3.38
X$434 VSS bias_a \$148 sky130_gnd sky130_fd_pr__nfet_01v8 l=0.6 w=1.4 as=0.406
+ ad=0.406 ps=3.38 pd=3.38
X$435 VSS bias_a \$149 sky130_gnd sky130_fd_pr__nfet_01v8 l=0.6 w=1.4 as=0.406
+ ad=0.406 ps=3.38 pd=3.38
X$436 VSS bias_a \$148 sky130_gnd sky130_fd_pr__nfet_01v8 l=0.6 w=1.4 as=0.406
+ ad=0.406 ps=3.38 pd=3.38
X$437 VSS bias_a \$149 sky130_gnd sky130_fd_pr__nfet_01v8 l=0.6 w=1.4 as=0.406
+ ad=0.406 ps=3.38 pd=3.38
X$438 VSS bias_a \$148 sky130_gnd sky130_fd_pr__nfet_01v8 l=0.6 w=1.4 as=0.406
+ ad=0.406 ps=3.38 pd=3.38
X$439 VSS VSS VSS sky130_gnd sky130_fd_pr__nfet_01v8 l=0.6 w=1.4 as=0.406
+ ad=0.406 ps=3.38 pd=3.38
X$440 VSS bias_a \$148 sky130_gnd sky130_fd_pr__nfet_01v8 l=0.6 w=1.4 as=0.406
+ ad=0.406 ps=3.38 pd=3.38
X$441 VSS bias_a \$149 sky130_gnd sky130_fd_pr__nfet_01v8 l=0.6 w=1.4 as=0.406
+ ad=0.406 ps=3.38 pd=3.38
X$442 VSS bias_a \$148 sky130_gnd sky130_fd_pr__nfet_01v8 l=0.6 w=1.4 as=0.406
+ ad=0.406 ps=3.38 pd=3.38
X$443 VSS bias_a \$149 sky130_gnd sky130_fd_pr__nfet_01v8 l=0.6 w=1.4 as=0.406
+ ad=0.406 ps=3.38 pd=3.38
X$444 VSS bias_a \$148 sky130_gnd sky130_fd_pr__nfet_01v8 l=0.6 w=1.4 as=0.406
+ ad=0.406 ps=3.38 pd=3.38
X$445 VSS bias_a \$149 sky130_gnd sky130_fd_pr__nfet_01v8 l=0.6 w=1.4 as=0.406
+ ad=0.406 ps=3.38 pd=3.38
X$446 VSS bias_a \$148 sky130_gnd sky130_fd_pr__nfet_01v8 l=0.6 w=1.4 as=0.406
+ ad=0.406 ps=3.38 pd=3.38
X$447 VSS bias_a \$149 sky130_gnd sky130_fd_pr__nfet_01v8 l=0.6 w=1.4 as=0.406
+ ad=0.406 ps=3.38 pd=3.38
X$448 VSS bias_a \$149 sky130_gnd sky130_fd_pr__nfet_01v8 l=0.6 w=1.4 as=0.406
+ ad=0.406 ps=3.38 pd=3.38
X$449 VSS bias_a \$148 sky130_gnd sky130_fd_pr__nfet_01v8 l=0.6 w=1.4 as=0.406
+ ad=0.406 ps=3.38 pd=3.38
X$450 VSS bias_a \$149 sky130_gnd sky130_fd_pr__nfet_01v8 l=0.6 w=1.4 as=0.406
+ ad=0.406 ps=3.38 pd=3.38
X$451 VSS bias_a \$148 sky130_gnd sky130_fd_pr__nfet_01v8 l=0.6 w=1.4 as=0.406
+ ad=0.406 ps=3.38 pd=3.38
X$452 VSS bias_a \$149 sky130_gnd sky130_fd_pr__nfet_01v8 l=0.6 w=1.4 as=0.406
+ ad=0.406 ps=3.38 pd=3.38
X$453 VSS bias_a \$148 sky130_gnd sky130_fd_pr__nfet_01v8 l=0.6 w=1.4 as=0.406
+ ad=0.406 ps=3.38 pd=3.38
X$454 VSS bias_a \$149 sky130_gnd sky130_fd_pr__nfet_01v8 l=0.6 w=1.4 as=0.406
+ ad=0.406 ps=3.38 pd=3.38
X$455 VSS bias_a \$148 sky130_gnd sky130_fd_pr__nfet_01v8 l=0.6 w=1.4 as=0.406
+ ad=0.406 ps=3.38 pd=3.38
X$456 VSS bias_a \$149 sky130_gnd sky130_fd_pr__nfet_01v8 l=0.6 w=1.4 as=0.406
+ ad=0.406 ps=3.38 pd=3.38
X$457 VSS bias_a \$148 sky130_gnd sky130_fd_pr__nfet_01v8 l=0.6 w=1.4 as=0.406
+ ad=0.406 ps=3.38 pd=3.38
X$458 VSS bias_a \$149 sky130_gnd sky130_fd_pr__nfet_01v8 l=0.6 w=1.4 as=0.406
+ ad=0.406 ps=3.38 pd=3.38
X$459 VSS bias_a \$148 sky130_gnd sky130_fd_pr__nfet_01v8 l=0.6 w=1.4 as=0.406
+ ad=0.406 ps=3.38 pd=3.38
X$460 VSS bias_a \$149 sky130_gnd sky130_fd_pr__nfet_01v8 l=0.6 w=1.4 as=0.406
+ ad=0.406 ps=3.38 pd=3.38
X$461 VSS bias_a \$148 sky130_gnd sky130_fd_pr__nfet_01v8 l=0.6 w=1.4 as=0.406
+ ad=0.406 ps=3.38 pd=3.38
X$462 VSS bias_a \$149 sky130_gnd sky130_fd_pr__nfet_01v8 l=0.6 w=1.4 as=0.406
+ ad=0.406 ps=3.38 pd=3.38
X$463 VSS bias_a \$148 sky130_gnd sky130_fd_pr__nfet_01v8 l=0.6 w=1.4 as=0.406
+ ad=0.406 ps=3.38 pd=3.38
X$464 VSS bias_a \$149 sky130_gnd sky130_fd_pr__nfet_01v8 l=0.6 w=1.4 as=0.406
+ ad=0.406 ps=3.38 pd=3.38
X$465 VSS bias_a \$148 sky130_gnd sky130_fd_pr__nfet_01v8 l=0.6 w=1.4 as=0.406
+ ad=0.406 ps=3.38 pd=3.38
X$466 VSS bias_a \$149 sky130_gnd sky130_fd_pr__nfet_01v8 l=0.6 w=1.4 as=0.406
+ ad=0.406 ps=3.38 pd=3.38
X$467 VSS bias_a \$148 sky130_gnd sky130_fd_pr__nfet_01v8 l=0.6 w=1.4 as=0.406
+ ad=0.406 ps=3.38 pd=3.38
X$468 VSS bias_a \$148 sky130_gnd sky130_fd_pr__nfet_01v8 l=0.6 w=1.4 as=0.406
+ ad=0.406 ps=3.38 pd=3.38
X$469 VSS bias_a \$149 sky130_gnd sky130_fd_pr__nfet_01v8 l=0.6 w=1.4 as=0.406
+ ad=0.406 ps=3.38 pd=3.38
X$470 VSS bias_a \$148 sky130_gnd sky130_fd_pr__nfet_01v8 l=0.6 w=1.4 as=0.406
+ ad=0.406 ps=3.38 pd=3.38
X$471 VSS bias_a \$149 sky130_gnd sky130_fd_pr__nfet_01v8 l=0.6 w=1.4 as=0.406
+ ad=0.406 ps=3.38 pd=3.38
X$472 VSS bias_a \$148 sky130_gnd sky130_fd_pr__nfet_01v8 l=0.6 w=1.4 as=0.406
+ ad=0.406 ps=3.38 pd=3.38
X$473 VSS bias_a \$149 sky130_gnd sky130_fd_pr__nfet_01v8 l=0.6 w=1.4 as=0.406
+ ad=0.406 ps=3.38 pd=3.38
X$474 VSS bias_a \$148 sky130_gnd sky130_fd_pr__nfet_01v8 l=0.6 w=1.4 as=0.406
+ ad=0.406 ps=3.38 pd=3.38
X$475 VSS bias_a \$149 sky130_gnd sky130_fd_pr__nfet_01v8 l=0.6 w=1.4 as=0.406
+ ad=0.406 ps=3.38 pd=3.38
X$476 VSS bias_a \$148 sky130_gnd sky130_fd_pr__nfet_01v8 l=0.6 w=1.4 as=0.406
+ ad=0.406 ps=3.38 pd=3.38
X$477 VSS bias_a \$149 sky130_gnd sky130_fd_pr__nfet_01v8 l=0.6 w=1.4 as=0.406
+ ad=0.406 ps=3.38 pd=3.38
X$478 VSS bias_a \$148 sky130_gnd sky130_fd_pr__nfet_01v8 l=0.6 w=1.4 as=0.406
+ ad=0.406 ps=3.38 pd=3.38
X$479 VSS bias_a \$149 sky130_gnd sky130_fd_pr__nfet_01v8 l=0.6 w=1.4 as=0.406
+ ad=0.406 ps=3.38 pd=3.38
X$480 VSS bias_a \$148 sky130_gnd sky130_fd_pr__nfet_01v8 l=0.6 w=1.4 as=0.406
+ ad=0.406 ps=3.38 pd=3.38
X$481 VSS bias_a \$149 sky130_gnd sky130_fd_pr__nfet_01v8 l=0.6 w=1.4 as=0.406
+ ad=0.406 ps=3.38 pd=3.38
X$482 VSS bias_a \$148 sky130_gnd sky130_fd_pr__nfet_01v8 l=0.6 w=1.4 as=0.406
+ ad=0.406 ps=3.38 pd=3.38
X$483 VSS bias_a \$149 sky130_gnd sky130_fd_pr__nfet_01v8 l=0.6 w=1.4 as=0.406
+ ad=0.406 ps=3.38 pd=3.38
X$484 VSS VSS VSS sky130_gnd sky130_fd_pr__nfet_01v8 l=0.6 w=1.4 as=0.406
+ ad=0.406 ps=3.38 pd=3.38
X$485 VSS bias_a \$148 sky130_gnd sky130_fd_pr__nfet_01v8 l=0.6 w=1.4 as=0.406
+ ad=0.406 ps=3.38 pd=3.38
X$486 VSS bias_a \$149 sky130_gnd sky130_fd_pr__nfet_01v8 l=0.6 w=1.4 as=0.406
+ ad=0.406 ps=3.38 pd=3.38
X$487 VSS bias_a \$148 sky130_gnd sky130_fd_pr__nfet_01v8 l=0.6 w=1.4 as=0.406
+ ad=0.406 ps=3.38 pd=3.38
X$488 VSS bias_a \$149 sky130_gnd sky130_fd_pr__nfet_01v8 l=0.6 w=1.4 as=0.406
+ ad=0.406 ps=3.38 pd=3.38
X$489 VSS bias_a \$148 sky130_gnd sky130_fd_pr__nfet_01v8 l=0.6 w=1.4 as=0.406
+ ad=0.406 ps=3.38 pd=3.38
X$490 VSS bias_a \$149 sky130_gnd sky130_fd_pr__nfet_01v8 l=0.6 w=1.4 as=0.406
+ ad=0.406 ps=3.38 pd=3.38
X$491 VSS bias_a \$148 sky130_gnd sky130_fd_pr__nfet_01v8 l=0.6 w=1.4 as=0.406
+ ad=0.406 ps=3.38 pd=3.38
X$492 VSS bias_a \$149 sky130_gnd sky130_fd_pr__nfet_01v8 l=0.6 w=1.4 as=0.406
+ ad=0.406 ps=3.38 pd=3.38
X$493 VSS bias_a \$148 sky130_gnd sky130_fd_pr__nfet_01v8 l=0.6 w=1.4 as=0.406
+ ad=0.406 ps=3.38 pd=3.38
X$494 VSS bias_a \$149 sky130_gnd sky130_fd_pr__nfet_01v8 l=0.6 w=1.4 as=0.406
+ ad=0.406 ps=3.38 pd=3.38
X$495 VSS bias_a \$148 sky130_gnd sky130_fd_pr__nfet_01v8 l=0.6 w=1.4 as=0.406
+ ad=0.406 ps=3.38 pd=3.38
X$496 VSS bias_a \$149 sky130_gnd sky130_fd_pr__nfet_01v8 l=0.6 w=1.4 as=0.406
+ ad=0.406 ps=3.38 pd=3.38
X$497 VSS bias_a \$148 sky130_gnd sky130_fd_pr__nfet_01v8 l=0.6 w=1.4 as=0.406
+ ad=0.406 ps=3.38 pd=3.38
X$498 VSS bias_a \$149 sky130_gnd sky130_fd_pr__nfet_01v8 l=0.6 w=1.4 as=0.406
+ ad=0.406 ps=3.38 pd=3.38
X$499 VSS bias_a \$148 sky130_gnd sky130_fd_pr__nfet_01v8 l=0.6 w=1.4 as=0.406
+ ad=0.406 ps=3.38 pd=3.38
X$500 VSS bias_a \$149 sky130_gnd sky130_fd_pr__nfet_01v8 l=0.6 w=1.4 as=0.406
+ ad=0.406 ps=3.38 pd=3.38
X$501 VSS bias_a \$148 sky130_gnd sky130_fd_pr__nfet_01v8 l=0.6 w=1.4 as=0.406
+ ad=0.406 ps=3.38 pd=3.38
X$502 VSS bias_a \$149 sky130_gnd sky130_fd_pr__nfet_01v8 l=0.6 w=1.4 as=0.406
+ ad=0.406 ps=3.38 pd=3.38
X$503 VSS bias_a \$148 sky130_gnd sky130_fd_pr__nfet_01v8 l=0.6 w=1.4 as=0.406
+ ad=0.406 ps=3.38 pd=3.38
X$504 VSS bias_a \$149 sky130_gnd sky130_fd_pr__nfet_01v8 l=0.6 w=1.4 as=0.406
+ ad=0.406 ps=3.38 pd=3.38
X$505 VSS bias_a \$61 sky130_gnd sky130_fd_pr__nfet_01v8 l=0.6 w=1.4 as=0.406
+ ad=0.406 ps=3.38 pd=3.38
X$506 VSS bias_a \$61 sky130_gnd sky130_fd_pr__nfet_01v8 l=0.6 w=1.4 as=0.406
+ ad=0.406 ps=3.38 pd=3.38
X$507 VSS bias_a \$61 sky130_gnd sky130_fd_pr__nfet_01v8 l=0.6 w=1.4 as=0.406
+ ad=0.406 ps=3.38 pd=3.38
X$508 VSS bias_a \$61 sky130_gnd sky130_fd_pr__nfet_01v8 l=0.6 w=1.4 as=0.406
+ ad=0.406 ps=3.38 pd=3.38
X$509 VSS bias_a \$61 sky130_gnd sky130_fd_pr__nfet_01v8 l=0.6 w=1.4 as=0.406
+ ad=0.406 ps=3.38 pd=3.38
X$510 VSS bias_a \$61 sky130_gnd sky130_fd_pr__nfet_01v8 l=0.6 w=1.4 as=0.406
+ ad=0.406 ps=3.38 pd=3.38
X$511 VSS bias_a \$61 sky130_gnd sky130_fd_pr__nfet_01v8 l=0.6 w=1.4 as=0.406
+ ad=0.406 ps=3.38 pd=3.38
X$512 VSS bias_a \$61 sky130_gnd sky130_fd_pr__nfet_01v8 l=0.6 w=1.4 as=0.406
+ ad=0.406 ps=3.38 pd=3.38
X$513 VSS bias_a \$61 sky130_gnd sky130_fd_pr__nfet_01v8 l=0.6 w=1.4 as=0.406
+ ad=0.406 ps=3.38 pd=3.38
X$514 VSS bias_a \$61 sky130_gnd sky130_fd_pr__nfet_01v8 l=0.6 w=1.4 as=0.406
+ ad=0.406 ps=3.38 pd=3.38
X$515 VSS bias_a \$61 sky130_gnd sky130_fd_pr__nfet_01v8 l=0.6 w=1.4 as=0.406
+ ad=0.406 ps=3.38 pd=3.38
X$516 VSS bias_a \$61 sky130_gnd sky130_fd_pr__nfet_01v8 l=0.6 w=1.4 as=0.406
+ ad=0.406 ps=3.38 pd=3.38
X$517 VSS bias_a \$61 sky130_gnd sky130_fd_pr__nfet_01v8 l=0.6 w=1.4 as=0.406
+ ad=0.406 ps=3.38 pd=3.38
X$518 VSS bias_a \$61 sky130_gnd sky130_fd_pr__nfet_01v8 l=0.6 w=1.4 as=0.406
+ ad=0.406 ps=3.38 pd=3.38
X$519 VSS bias_a \$61 sky130_gnd sky130_fd_pr__nfet_01v8 l=0.6 w=1.4 as=0.406
+ ad=0.406 ps=3.38 pd=3.38
X$520 VSS bias_a \$61 sky130_gnd sky130_fd_pr__nfet_01v8 l=0.6 w=1.4 as=0.406
+ ad=0.406 ps=3.38 pd=3.38
X$521 VSS bias_a \$61 sky130_gnd sky130_fd_pr__nfet_01v8 l=0.6 w=1.4 as=0.406
+ ad=0.406 ps=3.38 pd=3.38
X$522 VSS bias_a \$61 sky130_gnd sky130_fd_pr__nfet_01v8 l=0.6 w=1.4 as=0.406
+ ad=0.406 ps=3.38 pd=3.38
X$523 VSS bias_a \$61 sky130_gnd sky130_fd_pr__nfet_01v8 l=0.6 w=1.4 as=0.406
+ ad=0.406 ps=3.38 pd=3.38
X$524 VSS bias_a \$61 sky130_gnd sky130_fd_pr__nfet_01v8 l=0.6 w=1.4 as=0.406
+ ad=0.406 ps=3.38 pd=3.38
X$525 VSS bias_a \$61 sky130_gnd sky130_fd_pr__nfet_01v8 l=0.6 w=1.4 as=0.406
+ ad=0.406 ps=3.38 pd=3.38
X$526 VSS bias_a \$61 sky130_gnd sky130_fd_pr__nfet_01v8 l=0.6 w=1.4 as=0.406
+ ad=0.406 ps=3.38 pd=3.38
X$527 VSS bias_a \$61 sky130_gnd sky130_fd_pr__nfet_01v8 l=0.6 w=1.4 as=0.406
+ ad=0.406 ps=3.38 pd=3.38
X$528 VSS bias_a \$61 sky130_gnd sky130_fd_pr__nfet_01v8 l=0.6 w=1.4 as=0.406
+ ad=0.406 ps=3.38 pd=3.38
X$529 VSS bias_a \$61 sky130_gnd sky130_fd_pr__nfet_01v8 l=0.6 w=1.4 as=0.406
+ ad=0.406 ps=3.38 pd=3.38
X$530 VSS bias_a \$61 sky130_gnd sky130_fd_pr__nfet_01v8 l=0.6 w=1.4 as=0.406
+ ad=0.406 ps=3.38 pd=3.38
X$531 VSS bias_a \$61 sky130_gnd sky130_fd_pr__nfet_01v8 l=0.6 w=1.4 as=0.406
+ ad=0.406 ps=3.38 pd=3.38
X$532 VSS bias_a \$61 sky130_gnd sky130_fd_pr__nfet_01v8 l=0.6 w=1.4 as=0.406
+ ad=0.406 ps=3.38 pd=3.38
X$533 VSS bias_a \$61 sky130_gnd sky130_fd_pr__nfet_01v8 l=0.6 w=1.4 as=0.406
+ ad=0.406 ps=3.38 pd=3.38
X$534 VSS bias_a \$61 sky130_gnd sky130_fd_pr__nfet_01v8 l=0.6 w=1.4 as=0.406
+ ad=0.406 ps=3.38 pd=3.38
X$535 VSS bias_a \$61 sky130_gnd sky130_fd_pr__nfet_01v8 l=0.6 w=1.4 as=0.406
+ ad=0.406 ps=3.38 pd=3.38
X$536 VSS bias_a \$61 sky130_gnd sky130_fd_pr__nfet_01v8 l=0.6 w=1.4 as=0.406
+ ad=0.406 ps=3.38 pd=3.38
X$537 VSS bias_a \$61 sky130_gnd sky130_fd_pr__nfet_01v8 l=0.6 w=1.4 as=0.406
+ ad=0.406 ps=3.38 pd=3.38
X$538 VSS bias_a \$61 sky130_gnd sky130_fd_pr__nfet_01v8 l=0.6 w=1.4 as=0.406
+ ad=0.406 ps=3.38 pd=3.38
X$539 VSS bias_a \$61 sky130_gnd sky130_fd_pr__nfet_01v8 l=0.6 w=1.4 as=0.406
+ ad=0.406 ps=3.38 pd=3.38
X$540 VSS bias_a \$61 sky130_gnd sky130_fd_pr__nfet_01v8 l=0.6 w=1.4 as=0.406
+ ad=0.406 ps=3.38 pd=3.38
X$541 VSS bias_a \$61 sky130_gnd sky130_fd_pr__nfet_01v8 l=0.6 w=1.4 as=0.406
+ ad=0.406 ps=3.38 pd=3.38
X$542 VSS bias_a \$61 sky130_gnd sky130_fd_pr__nfet_01v8 l=0.6 w=1.4 as=0.406
+ ad=0.406 ps=3.38 pd=3.38
X$543 VSS bias_a \$61 sky130_gnd sky130_fd_pr__nfet_01v8 l=0.6 w=1.4 as=0.406
+ ad=0.406 ps=3.38 pd=3.38
X$544 VSS bias_a \$61 sky130_gnd sky130_fd_pr__nfet_01v8 l=0.6 w=1.4 as=0.406
+ ad=0.406 ps=3.38 pd=3.38
X$545 VSS bias_a \$61 sky130_gnd sky130_fd_pr__nfet_01v8 l=0.6 w=1.4 as=0.406
+ ad=0.406 ps=3.38 pd=3.38
X$546 VSS bias_a \$61 sky130_gnd sky130_fd_pr__nfet_01v8 l=0.6 w=1.4 as=0.406
+ ad=0.406 ps=3.38 pd=3.38
X$547 VSS bias_a \$61 sky130_gnd sky130_fd_pr__nfet_01v8 l=0.6 w=1.4 as=0.406
+ ad=0.406 ps=3.38 pd=3.38
X$548 VSS bias_a \$61 sky130_gnd sky130_fd_pr__nfet_01v8 l=0.6 w=1.4 as=0.406
+ ad=0.406 ps=3.38 pd=3.38
X$549 VSS bias_a \$61 sky130_gnd sky130_fd_pr__nfet_01v8 l=0.6 w=1.4 as=0.406
+ ad=0.406 ps=3.38 pd=3.38
X$550 VSS bias_a \$61 sky130_gnd sky130_fd_pr__nfet_01v8 l=0.6 w=1.4 as=0.406
+ ad=0.406 ps=3.38 pd=3.38
X$551 VSS bias_a \$61 sky130_gnd sky130_fd_pr__nfet_01v8 l=0.6 w=1.4 as=0.406
+ ad=0.406 ps=3.38 pd=3.38
X$552 VSS bias_a \$61 sky130_gnd sky130_fd_pr__nfet_01v8 l=0.6 w=1.4 as=0.406
+ ad=0.406 ps=3.38 pd=3.38
X$553 VSS bias_a \$61 sky130_gnd sky130_fd_pr__nfet_01v8 l=0.6 w=1.4 as=0.406
+ ad=0.406 ps=3.38 pd=3.38
X$554 VSS bias_a \$61 sky130_gnd sky130_fd_pr__nfet_01v8 l=0.6 w=1.4 as=0.406
+ ad=0.406 ps=3.38 pd=3.38
X$555 VSS bias_a \$61 sky130_gnd sky130_fd_pr__nfet_01v8 l=0.6 w=1.4 as=0.406
+ ad=0.406 ps=3.38 pd=3.38
X$556 VSS bias_a \$61 sky130_gnd sky130_fd_pr__nfet_01v8 l=0.6 w=1.4 as=0.406
+ ad=0.406 ps=3.38 pd=3.38
X$557 VSS bias_a \$61 sky130_gnd sky130_fd_pr__nfet_01v8 l=0.6 w=1.4 as=0.406
+ ad=0.406 ps=3.38 pd=3.38
X$558 VSS bias_a \$61 sky130_gnd sky130_fd_pr__nfet_01v8 l=0.6 w=1.4 as=0.406
+ ad=0.406 ps=3.38 pd=3.38
X$559 VSS bias_a \$61 sky130_gnd sky130_fd_pr__nfet_01v8 l=0.6 w=1.4 as=0.406
+ ad=0.406 ps=3.38 pd=3.38
X$560 VSS bias_a \$61 sky130_gnd sky130_fd_pr__nfet_01v8 l=0.6 w=1.4 as=0.406
+ ad=0.406 ps=3.38 pd=3.38
X$561 VSS bias_a \$61 sky130_gnd sky130_fd_pr__nfet_01v8 l=0.6 w=1.4 as=0.406
+ ad=0.406 ps=3.38 pd=3.38
X$562 VSS bias_a \$61 sky130_gnd sky130_fd_pr__nfet_01v8 l=0.6 w=1.4 as=0.406
+ ad=0.406 ps=3.38 pd=3.38
X$563 VSS bias_a \$61 sky130_gnd sky130_fd_pr__nfet_01v8 l=0.6 w=1.4 as=0.406
+ ad=0.406 ps=3.38 pd=3.38
X$564 VSS bias_a \$61 sky130_gnd sky130_fd_pr__nfet_01v8 l=0.6 w=1.4 as=0.406
+ ad=0.406 ps=3.38 pd=3.38
X$565 VSS bias_a \$61 sky130_gnd sky130_fd_pr__nfet_01v8 l=0.6 w=1.4 as=0.406
+ ad=0.406 ps=3.38 pd=3.38
X$566 VSS bias_a \$61 sky130_gnd sky130_fd_pr__nfet_01v8 l=0.6 w=1.4 as=0.406
+ ad=0.406 ps=3.38 pd=3.38
X$567 VSS bias_a \$61 sky130_gnd sky130_fd_pr__nfet_01v8 l=0.6 w=1.4 as=0.406
+ ad=0.406 ps=3.38 pd=3.38
X$568 VSS bias_a \$61 sky130_gnd sky130_fd_pr__nfet_01v8 l=0.6 w=1.4 as=0.406
+ ad=0.406 ps=3.38 pd=3.38
X$569 VSS bias_a \$61 sky130_gnd sky130_fd_pr__nfet_01v8 l=0.6 w=1.4 as=0.406
+ ad=0.406 ps=3.38 pd=3.38
X$570 VSS bias_a \$61 sky130_gnd sky130_fd_pr__nfet_01v8 l=0.6 w=1.4 as=0.406
+ ad=0.406 ps=3.38 pd=3.38
X$571 VSS bias_a \$61 sky130_gnd sky130_fd_pr__nfet_01v8 l=0.6 w=1.4 as=0.406
+ ad=0.406 ps=3.38 pd=3.38
X$572 VSS bias_a \$61 sky130_gnd sky130_fd_pr__nfet_01v8 l=0.6 w=1.4 as=0.406
+ ad=0.406 ps=3.38 pd=3.38
X$573 VSS bias_a \$61 sky130_gnd sky130_fd_pr__nfet_01v8 l=0.6 w=1.4 as=0.406
+ ad=0.406 ps=3.38 pd=3.38
X$574 VSS bias_a \$61 sky130_gnd sky130_fd_pr__nfet_01v8 l=0.6 w=1.4 as=0.406
+ ad=0.406 ps=3.38 pd=3.38
X$575 VSS bias_a \$61 sky130_gnd sky130_fd_pr__nfet_01v8 l=0.6 w=1.4 as=0.406
+ ad=0.406 ps=3.38 pd=3.38
X$576 VSS bias_a \$61 sky130_gnd sky130_fd_pr__nfet_01v8 l=0.6 w=1.4 as=0.406
+ ad=0.406 ps=3.38 pd=3.38
X$577 VSS bias_a \$61 sky130_gnd sky130_fd_pr__nfet_01v8 l=0.6 w=1.4 as=0.406
+ ad=0.406 ps=3.38 pd=3.38
X$578 VSS bias_a \$61 sky130_gnd sky130_fd_pr__nfet_01v8 l=0.6 w=1.4 as=0.406
+ ad=0.406 ps=3.38 pd=3.38
X$579 VSS bias_a \$61 sky130_gnd sky130_fd_pr__nfet_01v8 l=0.6 w=1.4 as=0.406
+ ad=0.406 ps=3.38 pd=3.38
X$580 VSS bias_a \$61 sky130_gnd sky130_fd_pr__nfet_01v8 l=0.6 w=1.4 as=0.406
+ ad=0.406 ps=3.38 pd=3.38
X$581 VSS bias_a \$61 sky130_gnd sky130_fd_pr__nfet_01v8 l=0.6 w=1.4 as=0.406
+ ad=0.406 ps=3.38 pd=3.38
X$582 VSS bias_a \$61 sky130_gnd sky130_fd_pr__nfet_01v8 l=0.6 w=1.4 as=0.406
+ ad=0.406 ps=3.38 pd=3.38
X$583 VSS bias_a \$61 sky130_gnd sky130_fd_pr__nfet_01v8 l=0.6 w=1.4 as=0.406
+ ad=0.406 ps=3.38 pd=3.38
X$584 VSS bias_a \$61 sky130_gnd sky130_fd_pr__nfet_01v8 l=0.6 w=1.4 as=0.406
+ ad=0.406 ps=3.38 pd=3.38
X$585 VSS bias_a \$61 sky130_gnd sky130_fd_pr__nfet_01v8 l=0.6 w=1.4 as=0.406
+ ad=0.406 ps=3.38 pd=3.38
X$586 VSS bias_a \$61 sky130_gnd sky130_fd_pr__nfet_01v8 l=0.6 w=1.4 as=0.406
+ ad=0.406 ps=3.38 pd=3.38
X$587 VSS bias_a \$61 sky130_gnd sky130_fd_pr__nfet_01v8 l=0.6 w=1.4 as=0.406
+ ad=0.406 ps=3.38 pd=3.38
X$588 VSS bias_a \$61 sky130_gnd sky130_fd_pr__nfet_01v8 l=0.6 w=1.4 as=0.406
+ ad=0.406 ps=3.38 pd=3.38
X$589 VSS bias_a \$61 sky130_gnd sky130_fd_pr__nfet_01v8 l=0.6 w=1.4 as=0.406
+ ad=0.406 ps=3.38 pd=3.38
X$590 VSS bias_a \$61 sky130_gnd sky130_fd_pr__nfet_01v8 l=0.6 w=1.4 as=0.406
+ ad=0.406 ps=3.38 pd=3.38
X$591 VSS bias_a \$61 sky130_gnd sky130_fd_pr__nfet_01v8 l=0.6 w=1.4 as=0.406
+ ad=0.406 ps=3.38 pd=3.38
X$592 VSS bias_a \$61 sky130_gnd sky130_fd_pr__nfet_01v8 l=0.6 w=1.4 as=0.406
+ ad=0.406 ps=3.38 pd=3.38
X$593 VSS bias_a \$61 sky130_gnd sky130_fd_pr__nfet_01v8 l=0.6 w=1.4 as=0.406
+ ad=0.406 ps=3.38 pd=3.38
X$594 VSS bias_a \$61 sky130_gnd sky130_fd_pr__nfet_01v8 l=0.6 w=1.4 as=0.406
+ ad=0.406 ps=3.38 pd=3.38
X$595 VSS bias_a \$61 sky130_gnd sky130_fd_pr__nfet_01v8 l=0.6 w=1.4 as=0.406
+ ad=0.406 ps=3.38 pd=3.38
X$596 VSS bias_a \$61 sky130_gnd sky130_fd_pr__nfet_01v8 l=0.6 w=1.4 as=0.406
+ ad=0.406 ps=3.38 pd=3.38
X$597 VSS bias_a \$61 sky130_gnd sky130_fd_pr__nfet_01v8 l=0.6 w=1.4 as=0.406
+ ad=0.406 ps=3.38 pd=3.38
X$598 VSS bias_a \$61 sky130_gnd sky130_fd_pr__nfet_01v8 l=0.6 w=1.4 as=0.406
+ ad=0.406 ps=3.38 pd=3.38
X$599 VSS bias_a \$61 sky130_gnd sky130_fd_pr__nfet_01v8 l=0.6 w=1.4 as=0.406
+ ad=0.406 ps=3.38 pd=3.38
X$600 VSS bias_a \$61 sky130_gnd sky130_fd_pr__nfet_01v8 l=0.6 w=1.4 as=0.406
+ ad=0.406 ps=3.38 pd=3.38
X$601 VSS cmc \$61 sky130_gnd sky130_fd_pr__nfet_01v8 l=0.6 w=1.4 as=0.406
+ ad=0.406 ps=3.38 pd=3.38
X$602 VSS cmc \$61 sky130_gnd sky130_fd_pr__nfet_01v8 l=0.6 w=1.4 as=0.406
+ ad=0.406 ps=3.38 pd=3.38
X$603 VSS cmc \$61 sky130_gnd sky130_fd_pr__nfet_01v8 l=0.6 w=1.4 as=0.406
+ ad=0.406 ps=3.38 pd=3.38
X$604 VSS cmc \$61 sky130_gnd sky130_fd_pr__nfet_01v8 l=0.6 w=1.4 as=0.406
+ ad=0.406 ps=3.38 pd=3.38
X$605 VSS cmc \$61 sky130_gnd sky130_fd_pr__nfet_01v8 l=0.6 w=1.4 as=0.406
+ ad=0.406 ps=3.38 pd=3.38
X$606 VSS cmc \$61 sky130_gnd sky130_fd_pr__nfet_01v8 l=0.6 w=1.4 as=0.406
+ ad=0.406 ps=3.38 pd=3.38
X$607 VSS cmc \$61 sky130_gnd sky130_fd_pr__nfet_01v8 l=0.6 w=1.4 as=0.406
+ ad=0.406 ps=3.38 pd=3.38
X$608 VSS cmc \$61 sky130_gnd sky130_fd_pr__nfet_01v8 l=0.6 w=1.4 as=0.406
+ ad=0.406 ps=3.38 pd=3.38
X$609 VSS cmc \$61 sky130_gnd sky130_fd_pr__nfet_01v8 l=0.6 w=1.4 as=0.406
+ ad=0.406 ps=3.38 pd=3.38
X$610 VSS cmc \$61 sky130_gnd sky130_fd_pr__nfet_01v8 l=0.6 w=1.4 as=0.406
+ ad=0.406 ps=3.38 pd=3.38
X$611 VSS cmc \$61 sky130_gnd sky130_fd_pr__nfet_01v8 l=0.6 w=1.4 as=0.406
+ ad=0.406 ps=3.38 pd=3.38
X$612 VSS cmc \$61 sky130_gnd sky130_fd_pr__nfet_01v8 l=0.6 w=1.4 as=0.406
+ ad=0.406 ps=3.38 pd=3.38
X$613 VSS cmc \$61 sky130_gnd sky130_fd_pr__nfet_01v8 l=0.6 w=1.4 as=0.406
+ ad=0.406 ps=3.38 pd=3.38
X$614 VSS cmc \$61 sky130_gnd sky130_fd_pr__nfet_01v8 l=0.6 w=1.4 as=0.406
+ ad=0.406 ps=3.38 pd=3.38
X$615 VSS cmc \$61 sky130_gnd sky130_fd_pr__nfet_01v8 l=0.6 w=1.4 as=0.406
+ ad=0.406 ps=3.38 pd=3.38
X$616 VSS cmc \$61 sky130_gnd sky130_fd_pr__nfet_01v8 l=0.6 w=1.4 as=0.406
+ ad=0.406 ps=3.38 pd=3.38
X$617 VSS cmc \$61 sky130_gnd sky130_fd_pr__nfet_01v8 l=0.6 w=1.4 as=0.406
+ ad=0.406 ps=3.38 pd=3.38
X$618 VSS cmc \$61 sky130_gnd sky130_fd_pr__nfet_01v8 l=0.6 w=1.4 as=0.406
+ ad=0.406 ps=3.38 pd=3.38
X$619 VSS cmc \$61 sky130_gnd sky130_fd_pr__nfet_01v8 l=0.6 w=1.4 as=0.406
+ ad=0.406 ps=3.38 pd=3.38
X$620 VSS cmc \$61 sky130_gnd sky130_fd_pr__nfet_01v8 l=0.6 w=1.4 as=0.406
+ ad=0.406 ps=3.38 pd=3.38
X$621 VSS cmc \$61 sky130_gnd sky130_fd_pr__nfet_01v8 l=0.6 w=1.4 as=0.406
+ ad=0.406 ps=3.38 pd=3.38
X$622 VSS cmc \$61 sky130_gnd sky130_fd_pr__nfet_01v8 l=0.6 w=1.4 as=0.406
+ ad=0.406 ps=3.38 pd=3.38
X$623 VSS cmc \$61 sky130_gnd sky130_fd_pr__nfet_01v8 l=0.6 w=1.4 as=0.406
+ ad=0.406 ps=3.38 pd=3.38
X$624 VSS cmc \$61 sky130_gnd sky130_fd_pr__nfet_01v8 l=0.6 w=1.4 as=0.406
+ ad=0.406 ps=3.38 pd=3.38
X$625 VSS cmc \$61 sky130_gnd sky130_fd_pr__nfet_01v8 l=0.6 w=1.4 as=0.406
+ ad=0.406 ps=3.38 pd=3.38
X$626 VSS cmc \$61 sky130_gnd sky130_fd_pr__nfet_01v8 l=0.6 w=1.4 as=0.406
+ ad=0.406 ps=3.38 pd=3.38
X$627 VSS cmc \$61 sky130_gnd sky130_fd_pr__nfet_01v8 l=0.6 w=1.4 as=0.406
+ ad=0.406 ps=3.38 pd=3.38
X$628 VSS cmc \$61 sky130_gnd sky130_fd_pr__nfet_01v8 l=0.6 w=1.4 as=0.406
+ ad=0.406 ps=3.38 pd=3.38
X$629 VSS cmc \$61 sky130_gnd sky130_fd_pr__nfet_01v8 l=0.6 w=1.4 as=0.406
+ ad=0.406 ps=3.38 pd=3.38
X$630 VSS cmc \$61 sky130_gnd sky130_fd_pr__nfet_01v8 l=0.6 w=1.4 as=0.406
+ ad=0.406 ps=3.38 pd=3.38
X$631 VSS cmc \$61 sky130_gnd sky130_fd_pr__nfet_01v8 l=0.6 w=1.4 as=0.406
+ ad=0.406 ps=3.38 pd=3.38
X$632 VSS cmc \$61 sky130_gnd sky130_fd_pr__nfet_01v8 l=0.6 w=1.4 as=0.406
+ ad=0.406 ps=3.38 pd=3.38
X$633 VSS cmc \$61 sky130_gnd sky130_fd_pr__nfet_01v8 l=0.6 w=1.4 as=0.406
+ ad=0.406 ps=3.38 pd=3.38
X$634 VSS cmc \$61 sky130_gnd sky130_fd_pr__nfet_01v8 l=0.6 w=1.4 as=0.406
+ ad=0.406 ps=3.38 pd=3.38
X$635 VSS cmc \$61 sky130_gnd sky130_fd_pr__nfet_01v8 l=0.6 w=1.4 as=0.406
+ ad=0.406 ps=3.38 pd=3.38
X$636 VSS cmc \$61 sky130_gnd sky130_fd_pr__nfet_01v8 l=0.6 w=1.4 as=0.406
+ ad=0.406 ps=3.38 pd=3.38
X$637 VSS cmc \$61 sky130_gnd sky130_fd_pr__nfet_01v8 l=0.6 w=1.4 as=0.406
+ ad=0.406 ps=3.38 pd=3.38
X$638 VSS cmc \$61 sky130_gnd sky130_fd_pr__nfet_01v8 l=0.6 w=1.4 as=0.406
+ ad=0.406 ps=3.38 pd=3.38
X$639 VSS cmc \$61 sky130_gnd sky130_fd_pr__nfet_01v8 l=0.6 w=1.4 as=0.406
+ ad=0.406 ps=3.38 pd=3.38
X$640 VSS cmc \$61 sky130_gnd sky130_fd_pr__nfet_01v8 l=0.6 w=1.4 as=0.406
+ ad=0.406 ps=3.38 pd=3.38
X$641 VSS cmc \$61 sky130_gnd sky130_fd_pr__nfet_01v8 l=0.6 w=1.4 as=0.406
+ ad=0.406 ps=3.38 pd=3.38
X$642 VSS cmc \$61 sky130_gnd sky130_fd_pr__nfet_01v8 l=0.6 w=1.4 as=0.406
+ ad=0.406 ps=3.38 pd=3.38
X$643 VSS cmc \$61 sky130_gnd sky130_fd_pr__nfet_01v8 l=0.6 w=1.4 as=0.406
+ ad=0.406 ps=3.38 pd=3.38
X$644 VSS cmc \$61 sky130_gnd sky130_fd_pr__nfet_01v8 l=0.6 w=1.4 as=0.406
+ ad=0.406 ps=3.38 pd=3.38
X$645 VSS cmc \$61 sky130_gnd sky130_fd_pr__nfet_01v8 l=0.6 w=1.4 as=0.406
+ ad=0.406 ps=3.38 pd=3.38
X$646 VSS cmc \$61 sky130_gnd sky130_fd_pr__nfet_01v8 l=0.6 w=1.4 as=0.406
+ ad=0.406 ps=3.38 pd=3.38
X$647 VSS cmc \$61 sky130_gnd sky130_fd_pr__nfet_01v8 l=0.6 w=1.4 as=0.406
+ ad=0.406 ps=3.38 pd=3.38
X$648 VSS cmc \$61 sky130_gnd sky130_fd_pr__nfet_01v8 l=0.6 w=1.4 as=0.406
+ ad=0.406 ps=3.38 pd=3.38
X$649 VSS cmc \$61 sky130_gnd sky130_fd_pr__nfet_01v8 l=0.6 w=1.4 as=0.406
+ ad=0.406 ps=3.38 pd=3.38
X$650 VSS cmc \$61 sky130_gnd sky130_fd_pr__nfet_01v8 l=0.6 w=1.4 as=0.406
+ ad=0.406 ps=3.38 pd=3.38
X$651 VSS cmc \$61 sky130_gnd sky130_fd_pr__nfet_01v8 l=0.6 w=1.4 as=0.406
+ ad=0.406 ps=3.38 pd=3.38
X$652 VSS cmc \$61 sky130_gnd sky130_fd_pr__nfet_01v8 l=0.6 w=1.4 as=0.406
+ ad=0.406 ps=3.38 pd=3.38
X$653 VSS cmc \$61 sky130_gnd sky130_fd_pr__nfet_01v8 l=0.6 w=1.4 as=0.406
+ ad=0.406 ps=3.38 pd=3.38
X$654 VSS cmc \$61 sky130_gnd sky130_fd_pr__nfet_01v8 l=0.6 w=1.4 as=0.406
+ ad=0.406 ps=3.38 pd=3.38
X$655 VSS cmc \$61 sky130_gnd sky130_fd_pr__nfet_01v8 l=0.6 w=1.4 as=0.406
+ ad=0.406 ps=3.38 pd=3.38
X$656 VSS cmc \$61 sky130_gnd sky130_fd_pr__nfet_01v8 l=0.6 w=1.4 as=0.406
+ ad=0.406 ps=3.38 pd=3.38
X$657 VSS cmc \$61 sky130_gnd sky130_fd_pr__nfet_01v8 l=0.6 w=1.4 as=0.406
+ ad=0.406 ps=3.38 pd=3.38
X$658 VSS cmc \$61 sky130_gnd sky130_fd_pr__nfet_01v8 l=0.6 w=1.4 as=0.406
+ ad=0.406 ps=3.38 pd=3.38
X$659 VSS cmc \$61 sky130_gnd sky130_fd_pr__nfet_01v8 l=0.6 w=1.4 as=0.406
+ ad=0.406 ps=3.38 pd=3.38
X$660 VSS cmc \$61 sky130_gnd sky130_fd_pr__nfet_01v8 l=0.6 w=1.4 as=0.406
+ ad=0.406 ps=3.38 pd=3.38
X$661 VSS cmc \$61 sky130_gnd sky130_fd_pr__nfet_01v8 l=0.6 w=1.4 as=0.406
+ ad=0.406 ps=3.38 pd=3.38
X$662 VSS cmc \$61 sky130_gnd sky130_fd_pr__nfet_01v8 l=0.6 w=1.4 as=0.406
+ ad=0.406 ps=3.38 pd=3.38
X$663 VSS cmc \$61 sky130_gnd sky130_fd_pr__nfet_01v8 l=0.6 w=1.4 as=0.406
+ ad=0.406 ps=3.38 pd=3.38
X$664 VSS cmc \$61 sky130_gnd sky130_fd_pr__nfet_01v8 l=0.6 w=1.4 as=0.406
+ ad=0.406 ps=3.38 pd=3.38
X$665 VSS cmc \$61 sky130_gnd sky130_fd_pr__nfet_01v8 l=0.6 w=1.4 as=0.406
+ ad=0.406 ps=3.38 pd=3.38
X$666 VSS cmc \$61 sky130_gnd sky130_fd_pr__nfet_01v8 l=0.6 w=1.4 as=0.406
+ ad=0.406 ps=3.38 pd=3.38
X$667 VSS cmc \$61 sky130_gnd sky130_fd_pr__nfet_01v8 l=0.6 w=1.4 as=0.406
+ ad=0.406 ps=3.38 pd=3.38
X$668 VSS cmc \$61 sky130_gnd sky130_fd_pr__nfet_01v8 l=0.6 w=1.4 as=0.406
+ ad=0.406 ps=3.38 pd=3.38
X$669 VSS cmc \$61 sky130_gnd sky130_fd_pr__nfet_01v8 l=0.6 w=1.4 as=0.406
+ ad=0.406 ps=3.38 pd=3.38
X$670 VSS cmc \$61 sky130_gnd sky130_fd_pr__nfet_01v8 l=0.6 w=1.4 as=0.406
+ ad=0.406 ps=3.38 pd=3.38
X$671 VSS cmc \$61 sky130_gnd sky130_fd_pr__nfet_01v8 l=0.6 w=1.4 as=0.406
+ ad=0.406 ps=3.38 pd=3.38
X$672 VSS cmc \$61 sky130_gnd sky130_fd_pr__nfet_01v8 l=0.6 w=1.4 as=0.406
+ ad=0.406 ps=3.38 pd=3.38
X$673 VSS cmc \$61 sky130_gnd sky130_fd_pr__nfet_01v8 l=0.6 w=1.4 as=0.406
+ ad=0.406 ps=3.38 pd=3.38
X$674 VSS cmc \$61 sky130_gnd sky130_fd_pr__nfet_01v8 l=0.6 w=1.4 as=0.406
+ ad=0.406 ps=3.38 pd=3.38
X$675 VSS cmc \$61 sky130_gnd sky130_fd_pr__nfet_01v8 l=0.6 w=1.4 as=0.406
+ ad=0.406 ps=3.38 pd=3.38
X$676 VSS cmc \$61 sky130_gnd sky130_fd_pr__nfet_01v8 l=0.6 w=1.4 as=0.406
+ ad=0.406 ps=3.38 pd=3.38
X$677 VSS cmc \$61 sky130_gnd sky130_fd_pr__nfet_01v8 l=0.6 w=1.4 as=0.406
+ ad=0.406 ps=3.38 pd=3.38
X$678 VSS cmc \$61 sky130_gnd sky130_fd_pr__nfet_01v8 l=0.6 w=1.4 as=0.406
+ ad=0.406 ps=3.38 pd=3.38
X$679 VSS cmc \$61 sky130_gnd sky130_fd_pr__nfet_01v8 l=0.6 w=1.4 as=0.406
+ ad=0.406 ps=3.38 pd=3.38
X$680 VSS cmc \$61 sky130_gnd sky130_fd_pr__nfet_01v8 l=0.6 w=1.4 as=0.406
+ ad=0.406 ps=3.38 pd=3.38
X$681 VSS cmc \$61 sky130_gnd sky130_fd_pr__nfet_01v8 l=0.6 w=1.4 as=0.406
+ ad=0.406 ps=3.38 pd=3.38
X$682 VSS cmc \$61 sky130_gnd sky130_fd_pr__nfet_01v8 l=0.6 w=1.4 as=0.406
+ ad=0.406 ps=3.38 pd=3.38
X$683 VSS cmc \$61 sky130_gnd sky130_fd_pr__nfet_01v8 l=0.6 w=1.4 as=0.406
+ ad=0.406 ps=3.38 pd=3.38
X$684 VSS cmc \$61 sky130_gnd sky130_fd_pr__nfet_01v8 l=0.6 w=1.4 as=0.406
+ ad=0.406 ps=3.38 pd=3.38
X$685 VSS cmc \$61 sky130_gnd sky130_fd_pr__nfet_01v8 l=0.6 w=1.4 as=0.406
+ ad=0.406 ps=3.38 pd=3.38
X$686 VSS cmc \$61 sky130_gnd sky130_fd_pr__nfet_01v8 l=0.6 w=1.4 as=0.406
+ ad=0.406 ps=3.38 pd=3.38
X$687 VSS cmc \$61 sky130_gnd sky130_fd_pr__nfet_01v8 l=0.6 w=1.4 as=0.406
+ ad=0.406 ps=3.38 pd=3.38
X$688 VSS cmc \$61 sky130_gnd sky130_fd_pr__nfet_01v8 l=0.6 w=1.4 as=0.406
+ ad=0.406 ps=3.38 pd=3.38
X$689 VSS cmc \$61 sky130_gnd sky130_fd_pr__nfet_01v8 l=0.6 w=1.4 as=0.406
+ ad=0.406 ps=3.38 pd=3.38
X$690 VSS cmc \$61 sky130_gnd sky130_fd_pr__nfet_01v8 l=0.6 w=1.4 as=0.406
+ ad=0.406 ps=3.38 pd=3.38
X$691 VSS cmc \$61 sky130_gnd sky130_fd_pr__nfet_01v8 l=0.6 w=1.4 as=0.406
+ ad=0.406 ps=3.38 pd=3.38
X$692 VSS cmc \$61 sky130_gnd sky130_fd_pr__nfet_01v8 l=0.6 w=1.4 as=0.406
+ ad=0.406 ps=3.38 pd=3.38
X$693 VSS cmc \$61 sky130_gnd sky130_fd_pr__nfet_01v8 l=0.6 w=1.4 as=0.406
+ ad=0.406 ps=3.38 pd=3.38
X$694 VSS cmc \$61 sky130_gnd sky130_fd_pr__nfet_01v8 l=0.6 w=1.4 as=0.406
+ ad=0.406 ps=3.38 pd=3.38
X$695 VSS cmc \$61 sky130_gnd sky130_fd_pr__nfet_01v8 l=0.6 w=1.4 as=0.406
+ ad=0.406 ps=3.38 pd=3.38
X$696 VSS cmc \$61 sky130_gnd sky130_fd_pr__nfet_01v8 l=0.6 w=1.4 as=0.406
+ ad=0.406 ps=3.38 pd=3.38
X$697 bias_a \$338 \$388 sky130_gnd sky130_fd_pr__nfet_01v8 l=0.6 w=1.4
+ as=0.406 ad=0.406 ps=3.38 pd=3.38
X$698 bias_a \$338 \$388 sky130_gnd sky130_fd_pr__nfet_01v8 l=0.6 w=1.4
+ as=0.406 ad=0.406 ps=3.38 pd=3.38
X$699 \$338 \$338 \$338 sky130_gnd sky130_fd_pr__nfet_01v8 l=0.6 w=1.4 as=0.406
+ ad=0.406 ps=3.38 pd=3.38
X$700 \$338 \$338 \$338 sky130_gnd sky130_fd_pr__nfet_01v8 l=0.6 w=1.4 as=0.406
+ ad=0.406 ps=3.38 pd=3.38
X$701 IBIAS IBIAS IBIAS sky130_gnd sky130_fd_pr__nfet_01v8 l=0.6 w=1.4 as=0.406
+ ad=0.406 ps=3.38 pd=3.38
X$702 IBIAS IBIAS IBIAS sky130_gnd sky130_fd_pr__nfet_01v8 l=0.6 w=1.4 as=0.406
+ ad=0.406 ps=3.38 pd=3.38
X$703 \$213 \$213 \$213 sky130_gnd sky130_fd_pr__nfet_01v8 l=0.6 w=1.4 as=0.406
+ ad=0.406 ps=3.38 pd=3.38
X$704 \$213 \$213 \$213 sky130_gnd sky130_fd_pr__nfet_01v8 l=0.6 w=1.4 as=0.406
+ ad=0.406 ps=3.38 pd=3.38
X$705 VSS VSS on sky130_gnd sky130_fd_pr__nfet_01v8 l=0.6 w=1.4 as=0.406
+ ad=0.406 ps=3.38 pd=3.38
X$706 VSS VSS on sky130_gnd sky130_fd_pr__nfet_01v8 l=0.6 w=1.4 as=0.406
+ ad=0.406 ps=3.38 pd=3.38
X$707 VSS VSS \$61 sky130_gnd sky130_fd_pr__nfet_01v8 l=0.6 w=1.4 as=0.406
+ ad=0.406 ps=3.38 pd=3.38
X$708 VSS VSS \$61 sky130_gnd sky130_fd_pr__nfet_01v8 l=0.6 w=1.4 as=0.406
+ ad=0.406 ps=3.38 pd=3.38
X$709 VSS VSS op sky130_gnd sky130_fd_pr__nfet_01v8 l=0.6 w=1.4 as=0.406
+ ad=0.406 ps=3.38 pd=3.38
X$710 VSS VSS op sky130_gnd sky130_fd_pr__nfet_01v8 l=0.6 w=1.4 as=0.406
+ ad=0.406 ps=3.38 pd=3.38
X$711 op op op sky130_gnd sky130_fd_pr__nfet_01v8 l=0.6 w=1.4 as=0.406 ad=0.406
+ ps=3.38 pd=3.38
X$712 op op op sky130_gnd sky130_fd_pr__nfet_01v8 l=0.6 w=1.4 as=0.406 ad=0.406
+ ps=3.38 pd=3.38
X$713 on on on sky130_gnd sky130_fd_pr__nfet_01v8 l=0.6 w=1.4 as=0.406 ad=0.406
+ ps=3.38 pd=3.38
X$714 on on on sky130_gnd sky130_fd_pr__nfet_01v8 l=0.6 w=1.4 as=0.406 ad=0.406
+ ps=3.38 pd=3.38
X$715 \$89 \$89 \$89 sky130_gnd sky130_fd_pr__nfet_01v8_lvt l=0.2 w=1.2
+ as=0.348 ad=0.348 ps=2.98 pd=2.98
X$716 \$89 \$89 \$89 sky130_gnd sky130_fd_pr__nfet_01v8_lvt l=0.2 w=1.2
+ as=0.348 ad=0.348 ps=2.98 pd=2.98
X$717 \$42 \$42 \$42 sky130_gnd sky130_fd_pr__nfet_01v8_lvt l=0.2 w=1.2
+ as=0.348 ad=0.348 ps=2.98 pd=2.98
X$718 \$42 \$42 \$42 sky130_gnd sky130_fd_pr__nfet_01v8_lvt l=0.2 w=1.2
+ as=0.348 ad=0.348 ps=2.98 pd=2.98
X$719 VDD VDD VDD VDD sky130_fd_pr__pfet_01v8 l=0.6 w=1.4 as=0.406 ad=0.406
+ ps=3.38 pd=3.38
X$720 \$89 \$213 op VDD sky130_fd_pr__pfet_01v8 l=0.6 w=1.4 as=0.406 ad=0.406
+ ps=3.38 pd=3.38
X$721 \$42 \$213 on VDD sky130_fd_pr__pfet_01v8 l=0.6 w=1.4 as=0.406 ad=0.406
+ ps=3.38 pd=3.38
X$722 \$89 \$213 op VDD sky130_fd_pr__pfet_01v8 l=0.6 w=1.4 as=0.406 ad=0.406
+ ps=3.38 pd=3.38
X$723 \$42 \$213 on VDD sky130_fd_pr__pfet_01v8 l=0.6 w=1.4 as=0.406 ad=0.406
+ ps=3.38 pd=3.38
X$724 \$89 \$213 op VDD sky130_fd_pr__pfet_01v8 l=0.6 w=1.4 as=0.406 ad=0.406
+ ps=3.38 pd=3.38
X$725 \$42 \$213 on VDD sky130_fd_pr__pfet_01v8 l=0.6 w=1.4 as=0.406 ad=0.406
+ ps=3.38 pd=3.38
X$726 \$89 \$213 op VDD sky130_fd_pr__pfet_01v8 l=0.6 w=1.4 as=0.406 ad=0.406
+ ps=3.38 pd=3.38
X$727 \$42 \$213 on VDD sky130_fd_pr__pfet_01v8 l=0.6 w=1.4 as=0.406 ad=0.406
+ ps=3.38 pd=3.38
X$728 \$89 \$213 op VDD sky130_fd_pr__pfet_01v8 l=0.6 w=1.4 as=0.406 ad=0.406
+ ps=3.38 pd=3.38
X$729 \$89 \$213 op VDD sky130_fd_pr__pfet_01v8 l=0.6 w=1.4 as=0.406 ad=0.406
+ ps=3.38 pd=3.38
X$730 \$42 \$213 on VDD sky130_fd_pr__pfet_01v8 l=0.6 w=1.4 as=0.406 ad=0.406
+ ps=3.38 pd=3.38
X$731 \$89 \$213 op VDD sky130_fd_pr__pfet_01v8 l=0.6 w=1.4 as=0.406 ad=0.406
+ ps=3.38 pd=3.38
X$732 \$42 \$213 on VDD sky130_fd_pr__pfet_01v8 l=0.6 w=1.4 as=0.406 ad=0.406
+ ps=3.38 pd=3.38
X$733 \$89 \$213 op VDD sky130_fd_pr__pfet_01v8 l=0.6 w=1.4 as=0.406 ad=0.406
+ ps=3.38 pd=3.38
X$734 \$42 \$213 on VDD sky130_fd_pr__pfet_01v8 l=0.6 w=1.4 as=0.406 ad=0.406
+ ps=3.38 pd=3.38
X$735 \$89 \$213 op VDD sky130_fd_pr__pfet_01v8 l=0.6 w=1.4 as=0.406 ad=0.406
+ ps=3.38 pd=3.38
X$736 \$42 \$213 on VDD sky130_fd_pr__pfet_01v8 l=0.6 w=1.4 as=0.406 ad=0.406
+ ps=3.38 pd=3.38
X$737 \$89 \$213 op VDD sky130_fd_pr__pfet_01v8 l=0.6 w=1.4 as=0.406 ad=0.406
+ ps=3.38 pd=3.38
X$738 \$42 \$213 on VDD sky130_fd_pr__pfet_01v8 l=0.6 w=1.4 as=0.406 ad=0.406
+ ps=3.38 pd=3.38
X$739 \$42 \$213 on VDD sky130_fd_pr__pfet_01v8 l=0.6 w=1.4 as=0.406 ad=0.406
+ ps=3.38 pd=3.38
X$740 VDD VDD VDD VDD sky130_fd_pr__pfet_01v8 l=0.6 w=1.4 as=0.406 ad=0.406
+ ps=3.38 pd=3.38
X$741 \$89 \$213 op VDD sky130_fd_pr__pfet_01v8 l=0.6 w=1.4 as=0.406 ad=0.406
+ ps=3.38 pd=3.38
X$742 \$42 \$213 on VDD sky130_fd_pr__pfet_01v8 l=0.6 w=1.4 as=0.406 ad=0.406
+ ps=3.38 pd=3.38
X$743 \$89 \$213 op VDD sky130_fd_pr__pfet_01v8 l=0.6 w=1.4 as=0.406 ad=0.406
+ ps=3.38 pd=3.38
X$744 \$42 \$213 on VDD sky130_fd_pr__pfet_01v8 l=0.6 w=1.4 as=0.406 ad=0.406
+ ps=3.38 pd=3.38
X$745 \$89 \$213 op VDD sky130_fd_pr__pfet_01v8 l=0.6 w=1.4 as=0.406 ad=0.406
+ ps=3.38 pd=3.38
X$746 \$42 \$213 on VDD sky130_fd_pr__pfet_01v8 l=0.6 w=1.4 as=0.406 ad=0.406
+ ps=3.38 pd=3.38
X$747 \$89 \$213 op VDD sky130_fd_pr__pfet_01v8 l=0.6 w=1.4 as=0.406 ad=0.406
+ ps=3.38 pd=3.38
X$748 \$42 \$213 on VDD sky130_fd_pr__pfet_01v8 l=0.6 w=1.4 as=0.406 ad=0.406
+ ps=3.38 pd=3.38
X$749 \$42 \$213 on VDD sky130_fd_pr__pfet_01v8 l=0.6 w=1.4 as=0.406 ad=0.406
+ ps=3.38 pd=3.38
X$750 \$42 \$213 on VDD sky130_fd_pr__pfet_01v8 l=0.6 w=1.4 as=0.406 ad=0.406
+ ps=3.38 pd=3.38
X$751 \$89 \$213 op VDD sky130_fd_pr__pfet_01v8 l=0.6 w=1.4 as=0.406 ad=0.406
+ ps=3.38 pd=3.38
X$752 \$42 \$213 on VDD sky130_fd_pr__pfet_01v8 l=0.6 w=1.4 as=0.406 ad=0.406
+ ps=3.38 pd=3.38
X$753 \$89 \$213 op VDD sky130_fd_pr__pfet_01v8 l=0.6 w=1.4 as=0.406 ad=0.406
+ ps=3.38 pd=3.38
X$754 \$42 \$213 on VDD sky130_fd_pr__pfet_01v8 l=0.6 w=1.4 as=0.406 ad=0.406
+ ps=3.38 pd=3.38
X$755 \$89 \$213 op VDD sky130_fd_pr__pfet_01v8 l=0.6 w=1.4 as=0.406 ad=0.406
+ ps=3.38 pd=3.38
X$756 \$42 \$213 on VDD sky130_fd_pr__pfet_01v8 l=0.6 w=1.4 as=0.406 ad=0.406
+ ps=3.38 pd=3.38
X$757 \$89 \$213 op VDD sky130_fd_pr__pfet_01v8 l=0.6 w=1.4 as=0.406 ad=0.406
+ ps=3.38 pd=3.38
X$758 \$42 \$213 on VDD sky130_fd_pr__pfet_01v8 l=0.6 w=1.4 as=0.406 ad=0.406
+ ps=3.38 pd=3.38
X$759 \$89 \$213 op VDD sky130_fd_pr__pfet_01v8 l=0.6 w=1.4 as=0.406 ad=0.406
+ ps=3.38 pd=3.38
X$760 \$89 \$213 op VDD sky130_fd_pr__pfet_01v8 l=0.6 w=1.4 as=0.406 ad=0.406
+ ps=3.38 pd=3.38
X$761 \$649 \$213 cm VDD sky130_fd_pr__pfet_01v8 l=0.6 w=1.4 as=0.406 ad=0.406
+ ps=3.38 pd=3.38
X$762 \$649 \$213 cm VDD sky130_fd_pr__pfet_01v8 l=0.6 w=1.4 as=0.406 ad=0.406
+ ps=3.38 pd=3.38
X$763 \$649 \$213 cm VDD sky130_fd_pr__pfet_01v8 l=0.6 w=1.4 as=0.406 ad=0.406
+ ps=3.38 pd=3.38
X$764 \$649 \$213 cm VDD sky130_fd_pr__pfet_01v8 l=0.6 w=1.4 as=0.406 ad=0.406
+ ps=3.38 pd=3.38
X$765 \$649 \$213 cm VDD sky130_fd_pr__pfet_01v8 l=0.6 w=1.4 as=0.406 ad=0.406
+ ps=3.38 pd=3.38
X$766 \$649 \$213 cm VDD sky130_fd_pr__pfet_01v8 l=0.6 w=1.4 as=0.406 ad=0.406
+ ps=3.38 pd=3.38
X$767 \$643 \$213 \$338 VDD sky130_fd_pr__pfet_01v8 l=0.6 w=1.4 as=0.406
+ ad=0.406 ps=3.38 pd=3.38
X$768 \$644 \$213 \$280 VDD sky130_fd_pr__pfet_01v8 l=0.6 w=1.4 as=0.406
+ ad=0.406 ps=3.38 pd=3.38
X$769 \$643 \$213 \$338 VDD sky130_fd_pr__pfet_01v8 l=0.6 w=1.4 as=0.406
+ ad=0.406 ps=3.38 pd=3.38
X$770 \$644 \$213 \$280 VDD sky130_fd_pr__pfet_01v8 l=0.6 w=1.4 as=0.406
+ ad=0.406 ps=3.38 pd=3.38
X$771 \$643 \$213 \$338 VDD sky130_fd_pr__pfet_01v8 l=0.6 w=1.4 as=0.406
+ ad=0.406 ps=3.38 pd=3.38
X$772 \$644 \$213 \$280 VDD sky130_fd_pr__pfet_01v8 l=0.6 w=1.4 as=0.406
+ ad=0.406 ps=3.38 pd=3.38
X$773 VDD VDD VDD VDD sky130_fd_pr__pfet_01v8 l=0.6 w=1.4 as=0.406 ad=0.406
+ ps=3.38 pd=3.38
X$774 VDD VDD VDD VDD sky130_fd_pr__pfet_01v8 l=0.6 w=1.4 as=0.406 ad=0.406
+ ps=3.38 pd=3.38
X$775 \$644 \$213 \$280 VDD sky130_fd_pr__pfet_01v8 l=0.6 w=1.4 as=0.406
+ ad=0.406 ps=3.38 pd=3.38
X$776 \$643 \$213 \$338 VDD sky130_fd_pr__pfet_01v8 l=0.6 w=1.4 as=0.406
+ ad=0.406 ps=3.38 pd=3.38
X$777 \$644 \$213 \$280 VDD sky130_fd_pr__pfet_01v8 l=0.6 w=1.4 as=0.406
+ ad=0.406 ps=3.38 pd=3.38
X$778 \$643 \$213 \$338 VDD sky130_fd_pr__pfet_01v8 l=0.6 w=1.4 as=0.406
+ ad=0.406 ps=3.38 pd=3.38
X$779 \$644 \$213 \$280 VDD sky130_fd_pr__pfet_01v8 l=0.6 w=1.4 as=0.406
+ ad=0.406 ps=3.38 pd=3.38
X$780 \$643 \$213 \$338 VDD sky130_fd_pr__pfet_01v8 l=0.6 w=1.4 as=0.406
+ ad=0.406 ps=3.38 pd=3.38
X$781 VDD VDD VDD VDD sky130_fd_pr__pfet_01v8 l=0.6 w=1.4 as=0.406 ad=0.406
+ ps=3.38 pd=3.38
X$782 VDD VDD VDD VDD sky130_fd_pr__pfet_01v8 l=0.6 w=1.4 as=0.406 ad=0.406
+ ps=3.38 pd=3.38
X$783 VDD VDD VDD VDD sky130_fd_pr__pfet_01v8 l=0.6 w=1.4 as=0.406 ad=0.406
+ ps=3.38 pd=3.38
X$784 VDD VDD VDD VDD sky130_fd_pr__pfet_01v8 l=0.6 w=1.4 as=0.406 ad=0.406
+ ps=3.38 pd=3.38
X$785 VDD VDD VDD VDD sky130_fd_pr__pfet_01v8 l=0.6 w=1.4 as=0.406 ad=0.406
+ ps=3.38 pd=3.38
X$786 VDD VDD VDD VDD sky130_fd_pr__pfet_01v8 l=0.6 w=1.4 as=0.406 ad=0.406
+ ps=3.38 pd=3.38
X$787 \$649 \$649 \$649 VDD sky130_fd_pr__pfet_01v8_lvt l=0.6 w=1.4 as=0.406
+ ad=0.406 ps=3.38 pd=3.38
X$788 \$649 \$649 \$649 VDD sky130_fd_pr__pfet_01v8_lvt l=0.6 w=1.4 as=0.406
+ ad=0.406 ps=3.38 pd=3.38
X$789 \$643 \$643 \$643 VDD sky130_fd_pr__pfet_01v8_lvt l=0.6 w=1.4 as=0.406
+ ad=0.406 ps=3.38 pd=3.38
X$790 \$643 \$643 \$643 VDD sky130_fd_pr__pfet_01v8_lvt l=0.6 w=1.4 as=0.406
+ ad=0.406 ps=3.38 pd=3.38
X$791 \$644 \$644 \$644 VDD sky130_fd_pr__pfet_01v8_lvt l=0.6 w=1.4 as=0.406
+ ad=0.406 ps=3.38 pd=3.38
X$792 \$644 \$644 \$644 VDD sky130_fd_pr__pfet_01v8_lvt l=0.6 w=1.4 as=0.406
+ ad=0.406 ps=3.38 pd=3.38
X$793 VDD VDD VDD VDD sky130_fd_pr__pfet_01v8_lvt l=0.6 w=1.4 as=0.406 ad=0.406
+ ps=3.38 pd=3.38
X$794 VDD VDD VDD VDD sky130_fd_pr__pfet_01v8_lvt l=0.6 w=1.4 as=0.406 ad=0.406
+ ps=3.38 pd=3.38
X$795 VDD VDD VDD VDD sky130_fd_pr__pfet_01v8_lvt l=0.6 w=1.4 as=0.406 ad=0.406
+ ps=3.38 pd=3.38
X$796 VDD VDD VDD VDD sky130_fd_pr__pfet_01v8_lvt l=0.6 w=1.4 as=0.406 ad=0.406
+ ps=3.38 pd=3.38
X$797 VDD VDD VDD VDD sky130_fd_pr__pfet_01v8_lvt l=0.6 w=1.4 as=0.406 ad=0.406
+ ps=3.38 pd=3.38
X$798 VDD VDD VDD VDD sky130_fd_pr__pfet_01v8_lvt l=0.6 w=1.4 as=0.406 ad=0.406
+ ps=3.38 pd=3.38
X$799 VDD VDD VDD VDD sky130_fd_pr__pfet_01v8_lvt l=0.6 w=1.4 as=0.406 ad=0.406
+ ps=3.38 pd=3.38
X$800 VDD VDD VDD VDD sky130_fd_pr__pfet_01v8_lvt l=0.6 w=1.4 as=0.406 ad=0.406
+ ps=3.38 pd=3.38
X$801 bias_a bias_a bias_a sky130_gnd sky130_fd_pr__nfet_01v8 l=0.6 w=1.4
+ as=0.406 ad=0.406 ps=3.38 pd=3.38
X$802 bias_a bias_a bias_a sky130_gnd sky130_fd_pr__nfet_01v8 l=0.6 w=1.4
+ as=0.406 ad=0.406 ps=3.38 pd=3.38
X$803 bias_a bias_a bias_a sky130_gnd sky130_fd_pr__nfet_01v8 l=0.6 w=1.4
+ as=0.406 ad=0.406 ps=3.38 pd=3.38
X$804 bias_a bias_a bias_a sky130_gnd sky130_fd_pr__nfet_01v8 l=0.6 w=1.4
+ as=0.406 ad=0.406 ps=3.38 pd=3.38
X$805 VSS VSS \$342 sky130_gnd sky130_fd_pr__nfet_01v8 l=0.6 w=1.4 as=0.406
+ ad=0.406 ps=3.38 pd=3.38
X$806 VSS VSS \$342 sky130_gnd sky130_fd_pr__nfet_01v8 l=0.6 w=1.4 as=0.406
+ ad=0.406 ps=3.38 pd=3.38
X$807 VSS VSS \$342 sky130_gnd sky130_fd_pr__nfet_01v8 l=0.6 w=1.4 as=0.406
+ ad=0.406 ps=3.38 pd=3.38
X$808 VSS VSS \$342 sky130_gnd sky130_fd_pr__nfet_01v8 l=0.6 w=1.4 as=0.406
+ ad=0.406 ps=3.38 pd=3.38
X$809 VSS VSS \$342 sky130_gnd sky130_fd_pr__nfet_01v8 l=0.6 w=1.4 as=0.406
+ ad=0.406 ps=3.38 pd=3.38
X$810 VSS VSS \$342 sky130_gnd sky130_fd_pr__nfet_01v8 l=0.6 w=1.4 as=0.406
+ ad=0.406 ps=3.38 pd=3.38
X$811 \$342 \$342 \$342 sky130_gnd sky130_fd_pr__nfet_01v8 l=0.6 w=1.4 as=0.406
+ ad=0.406 ps=3.38 pd=3.38
X$812 \$342 \$342 \$342 sky130_gnd sky130_fd_pr__nfet_01v8 l=0.6 w=1.4 as=0.406
+ ad=0.406 ps=3.38 pd=3.38
X$813 \$342 \$342 \$342 sky130_gnd sky130_fd_pr__nfet_01v8 l=0.6 w=1.4 as=0.406
+ ad=0.406 ps=3.38 pd=3.38
X$814 \$342 \$342 \$342 sky130_gnd sky130_fd_pr__nfet_01v8 l=0.6 w=1.4 as=0.406
+ ad=0.406 ps=3.38 pd=3.38
X$815 \$342 \$342 \$342 sky130_gnd sky130_fd_pr__nfet_01v8 l=0.6 w=1.4 as=0.406
+ ad=0.406 ps=3.38 pd=3.38
X$816 \$342 \$342 \$342 sky130_gnd sky130_fd_pr__nfet_01v8 l=0.6 w=1.4 as=0.406
+ ad=0.406 ps=3.38 pd=3.38
X$817 \$61 \$61 \$61 sky130_gnd sky130_fd_pr__nfet_01v8 l=0.6 w=1.4 as=0.406
+ ad=0.406 ps=3.38 pd=3.38
X$818 \$61 \$61 \$61 sky130_gnd sky130_fd_pr__nfet_01v8 l=0.6 w=1.4 as=0.406
+ ad=0.406 ps=3.38 pd=3.38
X$819 \$61 \$61 \$61 sky130_gnd sky130_fd_pr__nfet_01v8 l=0.6 w=1.4 as=0.406
+ ad=0.406 ps=3.38 pd=3.38
X$820 \$61 \$61 \$61 sky130_gnd sky130_fd_pr__nfet_01v8 l=0.6 w=1.4 as=0.406
+ ad=0.406 ps=3.38 pd=3.38
X$821 \$61 \$61 \$61 sky130_gnd sky130_fd_pr__nfet_01v8 l=0.6 w=1.4 as=0.406
+ ad=0.406 ps=3.38 pd=3.38
X$822 \$61 \$61 \$61 sky130_gnd sky130_fd_pr__nfet_01v8 l=0.6 w=1.4 as=0.406
+ ad=0.406 ps=3.38 pd=3.38
X$823 VSS VSS \$149 sky130_gnd sky130_fd_pr__nfet_01v8 l=0.6 w=1.4 as=0.406
+ ad=0.406 ps=3.38 pd=3.38
X$824 VSS VSS \$149 sky130_gnd sky130_fd_pr__nfet_01v8 l=0.6 w=1.4 as=0.406
+ ad=0.406 ps=3.38 pd=3.38
X$825 VSS VSS \$149 sky130_gnd sky130_fd_pr__nfet_01v8 l=0.6 w=1.4 as=0.406
+ ad=0.406 ps=3.38 pd=3.38
X$826 VSS VSS \$149 sky130_gnd sky130_fd_pr__nfet_01v8 l=0.6 w=1.4 as=0.406
+ ad=0.406 ps=3.38 pd=3.38
X$827 VSS VSS \$149 sky130_gnd sky130_fd_pr__nfet_01v8 l=0.6 w=1.4 as=0.406
+ ad=0.406 ps=3.38 pd=3.38
X$828 VSS VSS \$149 sky130_gnd sky130_fd_pr__nfet_01v8 l=0.6 w=1.4 as=0.406
+ ad=0.406 ps=3.38 pd=3.38
X$829 cm cm cm sky130_gnd sky130_fd_pr__nfet_01v8 l=0.6 w=1.4 as=0.406 ad=0.406
+ ps=3.38 pd=3.38
X$830 cm cm cm sky130_gnd sky130_fd_pr__nfet_01v8 l=0.6 w=1.4 as=0.406 ad=0.406
+ ps=3.38 pd=3.38
X$831 cm cm cm sky130_gnd sky130_fd_pr__nfet_01v8 l=0.6 w=1.4 as=0.406 ad=0.406
+ ps=3.38 pd=3.38
X$832 cm cm cm sky130_gnd sky130_fd_pr__nfet_01v8 l=0.6 w=1.4 as=0.406 ad=0.406
+ ps=3.38 pd=3.38
X$833 cm cm cm sky130_gnd sky130_fd_pr__nfet_01v8 l=0.6 w=1.4 as=0.406 ad=0.406
+ ps=3.38 pd=3.38
X$834 cm cm cm sky130_gnd sky130_fd_pr__nfet_01v8 l=0.6 w=1.4 as=0.406 ad=0.406
+ ps=3.38 pd=3.38
X$835 cm cm cm sky130_gnd sky130_fd_pr__nfet_01v8 l=0.6 w=1.4 as=0.406 ad=0.406
+ ps=3.38 pd=3.38
X$836 cm cm cm sky130_gnd sky130_fd_pr__nfet_01v8 l=0.6 w=1.4 as=0.406 ad=0.406
+ ps=3.38 pd=3.38
X$837 \$388 \$388 \$388 sky130_gnd sky130_fd_pr__nfet_01v8 l=0.6 w=1.4 as=0.406
+ ad=0.406 ps=3.38 pd=3.38
X$838 \$388 \$388 \$388 sky130_gnd sky130_fd_pr__nfet_01v8 l=0.6 w=1.4 as=0.406
+ ad=0.406 ps=3.38 pd=3.38
X$839 \$388 \$388 \$388 sky130_gnd sky130_fd_pr__nfet_01v8 l=0.6 w=1.4 as=0.406
+ ad=0.406 ps=3.38 pd=3.38
X$840 \$388 \$388 \$388 sky130_gnd sky130_fd_pr__nfet_01v8 l=0.6 w=1.4 as=0.406
+ ad=0.406 ps=3.38 pd=3.38
X$841 \$388 \$388 \$388 sky130_gnd sky130_fd_pr__nfet_01v8 l=0.6 w=1.4 as=0.406
+ ad=0.406 ps=3.38 pd=3.38
X$842 \$388 \$388 \$388 sky130_gnd sky130_fd_pr__nfet_01v8 l=0.6 w=1.4 as=0.406
+ ad=0.406 ps=3.38 pd=3.38
X$843 \$388 \$388 \$388 sky130_gnd sky130_fd_pr__nfet_01v8 l=0.6 w=1.4 as=0.406
+ ad=0.406 ps=3.38 pd=3.38
X$844 \$388 \$388 \$388 sky130_gnd sky130_fd_pr__nfet_01v8 l=0.6 w=1.4 as=0.406
+ ad=0.406 ps=3.38 pd=3.38
X$845 VSS VSS \$148 sky130_gnd sky130_fd_pr__nfet_01v8 l=0.6 w=1.4 as=0.406
+ ad=0.406 ps=3.38 pd=3.38
X$846 VSS VSS \$148 sky130_gnd sky130_fd_pr__nfet_01v8 l=0.6 w=1.4 as=0.406
+ ad=0.406 ps=3.38 pd=3.38
X$847 VSS VSS \$148 sky130_gnd sky130_fd_pr__nfet_01v8 l=0.6 w=1.4 as=0.406
+ ad=0.406 ps=3.38 pd=3.38
X$848 VSS VSS \$148 sky130_gnd sky130_fd_pr__nfet_01v8 l=0.6 w=1.4 as=0.406
+ ad=0.406 ps=3.38 pd=3.38
X$849 VSS VSS \$148 sky130_gnd sky130_fd_pr__nfet_01v8 l=0.6 w=1.4 as=0.406
+ ad=0.406 ps=3.38 pd=3.38
X$850 VSS VSS \$148 sky130_gnd sky130_fd_pr__nfet_01v8 l=0.6 w=1.4 as=0.406
+ ad=0.406 ps=3.38 pd=3.38
X$851 VSS VSS \$148 sky130_gnd sky130_fd_pr__nfet_01v8 l=0.6 w=1.4 as=0.406
+ ad=0.406 ps=3.38 pd=3.38
X$852 VSS VSS \$148 sky130_gnd sky130_fd_pr__nfet_01v8 l=0.6 w=1.4 as=0.406
+ ad=0.406 ps=3.38 pd=3.38
X$853 VSS VSS VSS sky130_gnd sky130_fd_pr__nfet_01v8 l=0.6 w=1.4 as=0.406
+ ad=0.406 ps=3.38 pd=3.38
X$854 VSS VSS VSS sky130_gnd sky130_fd_pr__nfet_01v8 l=0.6 w=1.4 as=0.406
+ ad=0.406 ps=3.38 pd=3.38
X$855 VSS VSS VSS sky130_gnd sky130_fd_pr__nfet_01v8 l=0.6 w=1.4 as=0.406
+ ad=0.406 ps=3.38 pd=3.38
X$856 VSS VSS VSS sky130_gnd sky130_fd_pr__nfet_01v8 l=0.6 w=1.4 as=0.406
+ ad=0.406 ps=3.38 pd=3.38
X$857 VSS VSS VSS sky130_gnd sky130_fd_pr__nfet_01v8 l=0.6 w=1.4 as=0.406
+ ad=0.406 ps=3.38 pd=3.38
X$858 VSS VSS VSS sky130_gnd sky130_fd_pr__nfet_01v8 l=0.6 w=1.4 as=0.406
+ ad=0.406 ps=3.38 pd=3.38
X$859 VSS VSS VSS sky130_gnd sky130_fd_pr__nfet_01v8 l=0.6 w=1.4 as=0.406
+ ad=0.406 ps=3.38 pd=3.38
X$860 VSS VSS VSS sky130_gnd sky130_fd_pr__nfet_01v8 l=0.6 w=1.4 as=0.406
+ ad=0.406 ps=3.38 pd=3.38
X$861 VSS VSS VSS sky130_gnd sky130_fd_pr__nfet_01v8 l=0.6 w=1.4 as=0.406
+ ad=0.406 ps=3.38 pd=3.38
X$862 VSS VSS VSS sky130_gnd sky130_fd_pr__nfet_01v8 l=0.6 w=1.4 as=0.406
+ ad=0.406 ps=3.38 pd=3.38
X$863 VSS VSS VSS sky130_gnd sky130_fd_pr__nfet_01v8 l=0.6 w=1.4 as=0.406
+ ad=0.406 ps=3.38 pd=3.38
X$864 VSS VSS VSS sky130_gnd sky130_fd_pr__nfet_01v8 l=0.6 w=1.4 as=0.406
+ ad=0.406 ps=3.38 pd=3.38
X$865 VSS VSS VSS sky130_gnd sky130_fd_pr__nfet_01v8 l=0.6 w=1.4 as=0.406
+ ad=0.406 ps=3.38 pd=3.38
X$866 VSS VSS VSS sky130_gnd sky130_fd_pr__nfet_01v8 l=0.6 w=1.4 as=0.406
+ ad=0.406 ps=3.38 pd=3.38
X$867 VSS VSS VSS sky130_gnd sky130_fd_pr__nfet_01v8 l=0.6 w=1.4 as=0.406
+ ad=0.406 ps=3.38 pd=3.38
X$868 VSS VSS VSS sky130_gnd sky130_fd_pr__nfet_01v8 l=0.6 w=1.4 as=0.406
+ ad=0.406 ps=3.38 pd=3.38
X$869 VSS VSS VSS sky130_gnd sky130_fd_pr__nfet_01v8 l=0.6 w=1.4 as=0.406
+ ad=0.406 ps=3.38 pd=3.38
X$870 VSS VSS VSS sky130_gnd sky130_fd_pr__nfet_01v8 l=0.6 w=1.4 as=0.406
+ ad=0.406 ps=3.38 pd=3.38
X$871 VSS VSS VSS sky130_gnd sky130_fd_pr__nfet_01v8 l=0.6 w=1.4 as=0.406
+ ad=0.406 ps=3.38 pd=3.38
X$872 VSS VSS VSS sky130_gnd sky130_fd_pr__nfet_01v8 l=0.6 w=1.4 as=0.406
+ ad=0.406 ps=3.38 pd=3.38
X$873 VSS VSS VSS sky130_gnd sky130_fd_pr__nfet_01v8 l=0.6 w=1.4 as=0.406
+ ad=0.406 ps=3.38 pd=3.38
X$874 VSS VSS VSS sky130_gnd sky130_fd_pr__nfet_01v8 l=0.6 w=1.4 as=0.406
+ ad=0.406 ps=3.38 pd=3.38
X$875 VSS VSS VSS sky130_gnd sky130_fd_pr__nfet_01v8 l=0.6 w=1.4 as=0.406
+ ad=0.406 ps=3.38 pd=3.38
Cext_1 \$148 \$149 11.7223f
Cext_2 \$148 \$388 3.37258f
Cext_3 \$148 \$42 194.905a
Cext_4 \$148 \$89 373.168a
Cext_5 \$148 bias_a 4.3625f
Cext_6 \$148 on 13.2551f
Cext_7 \$148 op 12.8397f
Cext_8 \$148 VDD 346.83a
Cext_9 \$148 VSS 23.2736f
Cext_10 \$148 sky130_gnd 19.0901f
Cext_11 \$149 \$388 3.32399f
Cext_12 \$149 \$42 173.578a
Cext_13 \$149 \$61 4.77207a
Cext_14 \$149 \$89 454.893a
Cext_15 \$149 bias_a 3.79605f
Cext_16 \$149 in 2.19056a
Cext_17 \$149 ip 2.19056a
Cext_18 \$149 on 5.48724f
Cext_19 \$149 op 15.3199f
Cext_20 \$149 VDD 241.522a
Cext_21 \$149 VSS 16.7879f
Cext_22 \$149 sky130_gnd 31.7754f
Cext_23 \$213 \$22.x1_net6 1.08901a
Cext_24 \$213 \$280 30.5947f
Cext_25 \$213 \$338 2.09392f
Cext_26 \$213 \$36.x1_net12 0.107143a
Cext_27 \$213 \$383 360.255a
Cext_28 \$213 \$386 68.7014a
Cext_29 \$213 \$388 1.54173f
Cext_30 \$213 \$39.x1_net4 33.8268a
Cext_31 \$213 \$42 2.3936f
Cext_32 \$213 \$499 5.96595a
Cext_33 \$213 \$643 727.425a
Cext_34 \$213 \$644 647.86a
Cext_35 \$213 \$649 791.108a
Cext_36 \$213 \$89 2.2888f
Cext_37 \$213 bias_a 461.235a
Cext_38 \$213 cm 3.75903f
Cext_39 \$213 IBIAS 7.16202f
Cext_40 \$213 on 2.03044f
Cext_41 \$213 op 2.60673f
Cext_42 \$213 VDD 41.4188f
Cext_43 \$213 VSS 10.6008f
Cext_44 \$213 sky130_gnd 39.6333f
Cext_45 \$22.x1_net6 \$383 126.957a
Cext_46 \$22.x1_net6 cm 206.68a
Cext_47 \$22.x1_net6 VSS 555.524a
Cext_48 \$22.x1_net6 sky130_gnd 374.193a
Cext_49 \$25.x1_net9 \$338 1.29111a
Cext_50 \$25.x1_net9 \$385 127.167a
Cext_51 \$25.x1_net9 cm 206.665a
Cext_52 \$25.x1_net9 IBIAS 15.1227a
Cext_53 \$25.x1_net9 VSS 534.108a
Cext_54 \$25.x1_net9 sky130_gnd 376.161a
Cext_55 \$280 \$338 1.115f
Cext_56 \$280 \$342 288.44a
Cext_57 \$280 \$388 403.631a
Cext_58 \$280 \$42 2.52248f
Cext_59 \$280 \$643 1.29585f
Cext_60 \$280 \$644 3.21531f
Cext_61 \$280 \$649 1.47734f
Cext_62 \$280 \$89 3.25136f
Cext_63 \$280 bias_a 382.501a
Cext_64 \$280 cm 1.01983f
Cext_65 \$280 IBIAS 252.622a
Cext_66 \$280 op 187.688a
Cext_67 \$280 VDD 61.0643f
Cext_68 \$280 VSS 2.46664f
Cext_69 \$280 sky130_gnd 54.899f
Cext_70 \$338 \$36.x1_net12 113.048a
Cext_71 \$338 \$385 42.4824a
Cext_72 \$338 \$386 473.218a
Cext_73 \$338 \$388 25.3449f
Cext_74 \$338 \$40.x1_net7 0.917552a
Cext_75 \$338 \$42 1.62933a
Cext_76 \$338 \$643 3.01771f
Cext_77 \$338 \$644 2.50667f
Cext_78 \$338 \$649 257.87a
Cext_79 \$338 \$89 43.284a
Cext_80 \$338 bias_a 235.895a
Cext_81 \$338 cm 1.78871f
Cext_82 \$338 IBIAS 393.654a
Cext_83 \$338 VDD 5.70292f
Cext_84 \$338 VSS 3.35371f
Cext_85 \$338 sky130_gnd 45.851f
Cext_86 \$342 \$388 2.21103f
Cext_87 \$342 \$42 2.52192a
Cext_88 \$342 \$89 97.0015a
Cext_89 \$342 bias_a 9.24861f
Cext_90 \$342 cm 224.793a
Cext_91 \$342 VDD 126.922a
Cext_92 \$342 VSS 11.268f
Cext_93 \$342 sky130_gnd 15.7036f
Cext_94 \$36.x1_net12 \$386 126.974a
Cext_95 \$36.x1_net12 cm 197.71a
Cext_96 \$36.x1_net12 VSS 516.335a
Cext_97 \$36.x1_net12 sky130_gnd 345.781a
Cext_98 \$37.x1_net15 \$499 130.928a
Cext_99 \$37.x1_net15 cm 308.34a
Cext_100 \$37.x1_net15 VSS 537.88a
Cext_101 \$37.x1_net15 sky130_gnd 373.393a
Cext_102 \$38.x1_net3 \$501 126.989a
Cext_103 \$38.x1_net3 cm 206.733a
Cext_104 \$38.x1_net3 VSS 544.987a
Cext_105 \$38.x1_net3 sky130_gnd 372.884a
Cext_106 \$383 \$385 12.0408a
Cext_107 \$383 \$39.x1_net4 255.595a
Cext_108 \$383 cm 1.28168f
Cext_109 \$383 IBIAS 6.92829a
Cext_110 \$383 VSS 1.52964f
Cext_111 \$383 sky130_gnd 1.99488f
Cext_112 \$385 \$386 8.84237a
Cext_113 \$385 \$40.x1_net7 255.961a
Cext_114 \$385 cm 1.043f
Cext_115 \$385 IBIAS 340.625a
Cext_116 \$385 VSS 1.70104f
Cext_117 \$385 sky130_gnd 1.77193f
Cext_118 \$386 \$41.x1_net10 255.961a
Cext_119 \$386 bias_a 4.68511a
Cext_120 \$386 cm 1.00589f
Cext_121 \$386 IBIAS 367.659a
Cext_122 \$386 VSS 1.67093f
Cext_123 \$386 sky130_gnd 1.42174f
Cext_124 \$388 \$42 424.321a
Cext_125 \$388 \$499 4.76389a
Cext_126 \$388 \$643 1.60883a
Cext_127 \$388 \$644 1.5142a
Cext_128 \$388 \$649 0.488959a
Cext_129 \$388 \$89 727.074a
Cext_130 \$388 bias_a 4.20779f
Cext_131 \$388 cm 564.173a
Cext_132 \$388 IBIAS 398.22a
Cext_133 \$388 on 3.8283f
Cext_134 \$388 op 3.58717f
Cext_135 \$388 VDD 2.81907f
Cext_136 \$388 VSS 16.9478f
Cext_137 \$388 sky130_gnd 67.6707f
Cext_138 \$39.x1_net4 cm 335.152a
Cext_139 \$39.x1_net4 VSS 383.992a
Cext_140 \$39.x1_net4 sky130_gnd 370.681a
Cext_141 \$40.x1_net7 cm 335.048a
Cext_142 \$40.x1_net7 VSS 284.509a
Cext_143 \$40.x1_net7 sky130_gnd 375.44a
Cext_144 \$41.x1_net10 cm 333.977a
Cext_145 \$41.x1_net10 IBIAS 0.323299a
Cext_146 \$41.x1_net10 VSS 282.837a
Cext_147 \$41.x1_net10 sky130_gnd 376.237a
Cext_148 \$42 \$61 3.75323f
Cext_149 \$42 \$89 11.0993f
Cext_150 \$42 bias_a 474.091a
Cext_151 \$42 in 73.4466a
Cext_152 \$42 ip 434.519a
Cext_153 \$42 on 8.01867f
Cext_154 \$42 op 7.73796f
Cext_155 \$42 VDD 28.4886f
Cext_156 \$42 VSS 4.46894f
Cext_157 \$42 sky130_gnd 12.0184f
Cext_158 \$45.x1_net13 \$499 256.359a
Cext_159 \$45.x1_net13 cm 344.548a
Cext_160 \$45.x1_net13 VSS 275.258a
Cext_161 \$45.x1_net13 sky130_gnd 376.845a
Cext_162 \$46.x1_net1 \$501 261.553a
Cext_163 \$46.x1_net1 cm 334.934a
Cext_164 \$46.x1_net1 VSS 276.218a
Cext_165 \$46.x1_net1 sky130_gnd 375.547a
Cext_166 \$499 \$501 10.7567a
Cext_167 \$499 bias_a 33.0208a
Cext_168 \$499 cm 1.49633f
Cext_169 \$499 IBIAS 15.138a
Cext_170 \$499 VSS 1.54748f
Cext_171 \$499 sky130_gnd 2.0862f
Cext_172 \$501 cm 1.44503f
Cext_173 \$501 VSS 1.70965f
Cext_174 \$501 sky130_gnd 2.03393f
Cext_175 \$61 \$89 3.8454f
Cext_176 \$61 bias_a 13.1733f
Cext_177 \$61 cmc 11.9125f
Cext_178 \$61 in 397.676a
Cext_179 \$61 ip 400.766a
Cext_180 \$61 on 602.718a
Cext_181 \$61 op 1.98268f
Cext_182 \$61 VDD 508.231a
Cext_183 \$61 VSS 72.5085f
Cext_184 \$61 sky130_gnd 46.2875f
Cext_185 \$643 \$644 3.85755f
Cext_186 \$643 \$649 758.643a
Cext_187 \$643 cm 258.346a
Cext_188 \$643 VDD 12.4798f
Cext_189 \$643 VSS 6.88896a
Cext_190 \$643 sky130_gnd 4.99386f
Cext_191 \$644 \$649 396.458a
Cext_192 \$644 cm 2.47123a
Cext_193 \$644 VDD 12.0828f
Cext_194 \$644 VSS 6.33096a
Cext_195 \$644 sky130_gnd 3.21883f
Cext_196 \$649 cm 2.50878f
Cext_197 \$649 VDD 10.305f
Cext_198 \$649 VSS 2.93839a
Cext_199 \$649 sky130_gnd 2.59609f
Cext_200 \$89 bias_a 580.05a
Cext_201 \$89 cm 1.47965a
Cext_202 \$89 in 427.925a
Cext_203 \$89 ip 60.3283a
Cext_204 \$89 on 3.14041f
Cext_205 \$89 op 9.27577f
Cext_206 \$89 VDD 29.025f
Cext_207 \$89 VSS 2.66276f
Cext_208 \$89 sky130_gnd 16.0786f
Cext_209 bias_a cm 124.937a
Cext_210 bias_a cmc 77.0908a
Cext_211 bias_a in 200.855a
Cext_212 bias_a ip 3.39674a
Cext_213 bias_a on 689.24a
Cext_214 bias_a op 685.258a
Cext_215 cmc on 202.991f
Cext_216 cmc op 202.158f
Cext_217 IBIAS bias_a 0.207576a
Cext_218 IBIAS cm 1.49024f
Cext_219 IBIAS VDD 315.935a
Cext_220 IBIAS VSS 21.4554f
Cext_221 IBIAS sky130_gnd 27.0617f
Cext_222 in ip 2.07845f
Cext_223 on op 3.79592f
Cext_224 VDD bias_a 2.1715f
Cext_225 VDD cm 3.76284f
Cext_226 VDD cmc 1.52057f
Cext_227 VDD in 0.100793a
Cext_228 VDD ip 0.100793a
Cext_229 VDD on 14.0054f
Cext_230 VDD op 10.5795f
Cext_231 VDD VSS 4.10133f
Cext_232 VDD sky130_gnd 62.1375f
Cext_233 VSS bias_a 42.3281f
Cext_234 VSS cm 18.9957f
Cext_235 VSS cmc 15.7759f
Cext_236 VSS in 691.342a
Cext_237 VSS ip 1.73038f
Cext_238 VSS on 13.9393f
Cext_239 VSS op 7.62785f
Cext_240 VSS sky130_gnd 406.712f
Cext_241 sky130_gnd bias_a 105.964f
Cext_242 sky130_gnd cm 34.411f
Cext_243 sky130_gnd cmc 62.2934f
Cext_244 sky130_gnd in 3.3672f
Cext_245 sky130_gnd ip 2.38121f
Cext_246 sky130_gnd on 22.4126f
Cext_247 sky130_gnd op 24.1322f
.ENDS iadc_ota_routed
