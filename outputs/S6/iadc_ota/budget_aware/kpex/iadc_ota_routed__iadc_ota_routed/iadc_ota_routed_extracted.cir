* Extracted by KLayout with SKY130 LVS runset on : 04/11/2026 20:57

.SUBCKT iadc_ota_routed \$22.x1_net6 \$25.x1_net9 \$36.x1_net12 \$37.x1_net15
+ \$38.x1_net3 \$39.x1_net4 \$40.x1_net7 \$41.x1_net10 \$45.x1_net13
+ \$46.x1_net1 IBIAS VDD VSS bias_a cm cmc in ip on op sky130_gnd
C$1 cmc on sky130_fd_pr__model__cap_mim C=4.608e-14 A=23.04 P=19.2
C$2 cmc on sky130_fd_pr__model__cap_mim C=4.608e-14 A=23.04 P=19.2
C$3 cmc on sky130_fd_pr__model__cap_mim C=4.608e-14 A=23.04 P=19.2
C$4 cmc on sky130_fd_pr__model__cap_mim C=4.608e-14 A=23.04 P=19.2
C$5 cmc op sky130_fd_pr__model__cap_mim C=4.608e-14 A=23.04 P=19.2
C$6 cmc op sky130_fd_pr__model__cap_mim C=4.608e-14 A=23.04 P=19.2
C$7 cmc op sky130_fd_pr__model__cap_mim C=4.608e-14 A=23.04 P=19.2
C$8 cmc op sky130_fd_pr__model__cap_mim C=4.608e-14 A=23.04 P=19.2
M$9 \$280 \$280 \$213 sky130_gnd sky130_fd_pr__nfet_01v8_lvt L=0.6 W=1.4
+ AS=0.406 AD=0.406 PS=3.38 PD=3.38
M$10 \$280 \$280 \$213 sky130_gnd sky130_fd_pr__nfet_01v8_lvt L=0.6 W=1.4
+ AS=0.406 AD=0.406 PS=3.38 PD=3.38
M$11 \$280 \$280 \$213 sky130_gnd sky130_fd_pr__nfet_01v8_lvt L=0.6 W=1.4
+ AS=0.406 AD=0.406 PS=3.38 PD=3.38
M$12 \$280 \$280 \$213 sky130_gnd sky130_fd_pr__nfet_01v8_lvt L=0.6 W=1.4
+ AS=0.406 AD=0.406 PS=3.38 PD=3.38
M$13 \$280 \$280 \$213 sky130_gnd sky130_fd_pr__nfet_01v8_lvt L=0.6 W=1.4
+ AS=0.406 AD=0.406 PS=3.38 PD=3.38
M$14 \$280 \$280 \$213 sky130_gnd sky130_fd_pr__nfet_01v8_lvt L=0.6 W=1.4
+ AS=0.406 AD=0.406 PS=3.38 PD=3.38
M$15 \$280 \$280 \$213 sky130_gnd sky130_fd_pr__nfet_01v8_lvt L=0.6 W=1.4
+ AS=0.406 AD=0.406 PS=3.38 PD=3.38
M$16 \$280 \$280 \$213 sky130_gnd sky130_fd_pr__nfet_01v8_lvt L=0.6 W=1.4
+ AS=0.406 AD=0.406 PS=3.38 PD=3.38
M$17 \$280 \$280 \$213 sky130_gnd sky130_fd_pr__nfet_01v8_lvt L=0.6 W=1.4
+ AS=0.406 AD=0.406 PS=3.38 PD=3.38
M$18 \$280 \$280 \$213 sky130_gnd sky130_fd_pr__nfet_01v8_lvt L=0.6 W=1.4
+ AS=0.406 AD=0.406 PS=3.38 PD=3.38
M$19 \$280 \$280 \$213 sky130_gnd sky130_fd_pr__nfet_01v8_lvt L=0.6 W=1.4
+ AS=0.406 AD=0.406 PS=3.38 PD=3.38
M$20 \$280 \$280 \$213 sky130_gnd sky130_fd_pr__nfet_01v8_lvt L=0.6 W=1.4
+ AS=0.406 AD=0.406 PS=3.38 PD=3.38
M$21 \$280 \$280 \$213 sky130_gnd sky130_fd_pr__nfet_01v8_lvt L=0.6 W=1.4
+ AS=0.406 AD=0.406 PS=3.38 PD=3.38
M$22 \$280 \$280 \$213 sky130_gnd sky130_fd_pr__nfet_01v8_lvt L=0.6 W=1.4
+ AS=0.406 AD=0.406 PS=3.38 PD=3.38
M$23 \$280 \$280 \$213 sky130_gnd sky130_fd_pr__nfet_01v8_lvt L=0.6 W=1.4
+ AS=0.406 AD=0.406 PS=3.38 PD=3.38
M$24 \$280 \$280 \$213 sky130_gnd sky130_fd_pr__nfet_01v8_lvt L=0.6 W=1.4
+ AS=0.406 AD=0.406 PS=3.38 PD=3.38
M$25 \$280 \$280 \$213 sky130_gnd sky130_fd_pr__nfet_01v8_lvt L=0.6 W=1.4
+ AS=0.406 AD=0.406 PS=3.38 PD=3.38
M$26 \$280 \$280 \$213 sky130_gnd sky130_fd_pr__nfet_01v8_lvt L=0.6 W=1.4
+ AS=0.406 AD=0.406 PS=3.38 PD=3.38
M$27 \$280 \$280 \$213 sky130_gnd sky130_fd_pr__nfet_01v8_lvt L=0.6 W=1.4
+ AS=0.406 AD=0.406 PS=3.38 PD=3.38
M$28 \$280 \$280 \$213 sky130_gnd sky130_fd_pr__nfet_01v8_lvt L=0.6 W=1.4
+ AS=0.406 AD=0.406 PS=3.38 PD=3.38
M$29 \$280 \$280 \$213 sky130_gnd sky130_fd_pr__nfet_01v8_lvt L=0.6 W=1.4
+ AS=0.406 AD=0.406 PS=3.38 PD=3.38
M$30 \$280 \$280 \$213 sky130_gnd sky130_fd_pr__nfet_01v8_lvt L=0.6 W=1.4
+ AS=0.406 AD=0.406 PS=3.38 PD=3.38
M$31 \$280 \$280 \$213 sky130_gnd sky130_fd_pr__nfet_01v8_lvt L=0.6 W=1.4
+ AS=0.406 AD=0.406 PS=3.38 PD=3.38
M$32 \$280 \$280 \$213 sky130_gnd sky130_fd_pr__nfet_01v8_lvt L=0.6 W=1.4
+ AS=0.406 AD=0.406 PS=3.38 PD=3.38
M$33 \$280 \$280 \$213 sky130_gnd sky130_fd_pr__nfet_01v8_lvt L=0.6 W=1.4
+ AS=0.406 AD=0.406 PS=3.38 PD=3.38
M$34 \$280 \$280 \$213 sky130_gnd sky130_fd_pr__nfet_01v8_lvt L=0.6 W=1.4
+ AS=0.406 AD=0.406 PS=3.38 PD=3.38
M$35 \$280 \$280 \$213 sky130_gnd sky130_fd_pr__nfet_01v8_lvt L=0.6 W=1.4
+ AS=0.406 AD=0.406 PS=3.38 PD=3.38
M$36 \$280 \$280 \$213 sky130_gnd sky130_fd_pr__nfet_01v8_lvt L=0.6 W=1.4
+ AS=0.406 AD=0.406 PS=3.38 PD=3.38
M$37 \$280 \$280 \$213 sky130_gnd sky130_fd_pr__nfet_01v8_lvt L=0.6 W=1.4
+ AS=0.406 AD=0.406 PS=3.38 PD=3.38
M$38 \$280 \$280 \$213 sky130_gnd sky130_fd_pr__nfet_01v8_lvt L=0.6 W=1.4
+ AS=0.406 AD=0.406 PS=3.38 PD=3.38
M$39 \$280 \$280 \$213 sky130_gnd sky130_fd_pr__nfet_01v8_lvt L=0.6 W=1.4
+ AS=0.406 AD=0.406 PS=3.38 PD=3.38
M$40 \$280 \$280 \$213 sky130_gnd sky130_fd_pr__nfet_01v8_lvt L=0.6 W=1.4
+ AS=0.406 AD=0.406 PS=3.38 PD=3.38
M$41 \$280 \$280 \$213 sky130_gnd sky130_fd_pr__nfet_01v8_lvt L=0.6 W=1.4
+ AS=0.406 AD=0.406 PS=3.38 PD=3.38
M$42 \$280 \$280 \$213 sky130_gnd sky130_fd_pr__nfet_01v8_lvt L=0.6 W=1.4
+ AS=0.406 AD=0.406 PS=3.38 PD=3.38
M$43 \$280 \$280 \$213 sky130_gnd sky130_fd_pr__nfet_01v8_lvt L=0.6 W=1.4
+ AS=0.406 AD=0.406 PS=3.38 PD=3.38
M$44 \$280 \$280 \$213 sky130_gnd sky130_fd_pr__nfet_01v8_lvt L=0.6 W=1.4
+ AS=0.406 AD=0.406 PS=3.38 PD=3.38
M$45 \$280 \$280 \$213 sky130_gnd sky130_fd_pr__nfet_01v8_lvt L=0.6 W=1.4
+ AS=0.406 AD=0.406 PS=3.38 PD=3.38
M$46 \$280 \$280 \$213 sky130_gnd sky130_fd_pr__nfet_01v8_lvt L=0.6 W=1.4
+ AS=0.406 AD=0.406 PS=3.38 PD=3.38
M$47 \$280 \$280 \$213 sky130_gnd sky130_fd_pr__nfet_01v8_lvt L=0.6 W=1.4
+ AS=0.406 AD=0.406 PS=3.38 PD=3.38
M$48 \$280 \$280 \$213 sky130_gnd sky130_fd_pr__nfet_01v8_lvt L=0.6 W=1.4
+ AS=0.406 AD=0.406 PS=3.38 PD=3.38
M$49 \$280 \$280 \$213 sky130_gnd sky130_fd_pr__nfet_01v8_lvt L=0.6 W=1.4
+ AS=0.406 AD=0.406 PS=3.38 PD=3.38
M$50 \$280 \$280 \$213 sky130_gnd sky130_fd_pr__nfet_01v8_lvt L=0.6 W=1.4
+ AS=0.406 AD=0.406 PS=3.38 PD=3.38
M$51 \$280 \$280 \$213 sky130_gnd sky130_fd_pr__nfet_01v8_lvt L=0.6 W=1.4
+ AS=0.406 AD=0.406 PS=3.38 PD=3.38
M$52 \$280 \$280 \$213 sky130_gnd sky130_fd_pr__nfet_01v8_lvt L=0.6 W=1.4
+ AS=0.406 AD=0.406 PS=3.38 PD=3.38
M$53 \$280 \$280 \$213 sky130_gnd sky130_fd_pr__nfet_01v8_lvt L=0.6 W=1.4
+ AS=0.406 AD=0.406 PS=3.38 PD=3.38
M$54 \$280 \$280 \$213 sky130_gnd sky130_fd_pr__nfet_01v8_lvt L=0.6 W=1.4
+ AS=0.406 AD=0.406 PS=3.38 PD=3.38
M$55 \$280 \$280 \$213 sky130_gnd sky130_fd_pr__nfet_01v8_lvt L=0.6 W=1.4
+ AS=0.406 AD=0.406 PS=3.38 PD=3.38
M$56 \$280 \$280 \$213 sky130_gnd sky130_fd_pr__nfet_01v8_lvt L=0.6 W=1.4
+ AS=0.406 AD=0.406 PS=3.38 PD=3.38
M$57 \$280 \$280 \$213 sky130_gnd sky130_fd_pr__nfet_01v8_lvt L=0.6 W=1.4
+ AS=0.406 AD=0.406 PS=3.38 PD=3.38
M$58 \$280 \$280 \$213 sky130_gnd sky130_fd_pr__nfet_01v8_lvt L=0.6 W=1.4
+ AS=0.406 AD=0.406 PS=3.38 PD=3.38
M$59 \$280 \$280 \$213 sky130_gnd sky130_fd_pr__nfet_01v8_lvt L=0.6 W=1.4
+ AS=0.406 AD=0.406 PS=3.38 PD=3.38
M$60 \$280 \$280 \$213 sky130_gnd sky130_fd_pr__nfet_01v8_lvt L=0.6 W=1.4
+ AS=0.406 AD=0.406 PS=3.38 PD=3.38
M$61 \$280 \$280 \$213 sky130_gnd sky130_fd_pr__nfet_01v8_lvt L=0.6 W=1.4
+ AS=0.406 AD=0.406 PS=3.38 PD=3.38
M$62 \$280 \$280 \$213 sky130_gnd sky130_fd_pr__nfet_01v8_lvt L=0.6 W=1.4
+ AS=0.406 AD=0.406 PS=3.38 PD=3.38
M$63 \$280 \$280 \$213 sky130_gnd sky130_fd_pr__nfet_01v8_lvt L=0.6 W=1.4
+ AS=0.406 AD=0.406 PS=3.38 PD=3.38
M$64 \$280 \$280 \$213 sky130_gnd sky130_fd_pr__nfet_01v8_lvt L=0.6 W=1.4
+ AS=0.406 AD=0.406 PS=3.38 PD=3.38
M$65 \$280 \$280 \$280 sky130_gnd sky130_fd_pr__nfet_01v8_lvt L=0.6 W=1.4
+ AS=0.406 AD=0.406 PS=3.38 PD=3.38
M$66 \$280 \$280 \$280 sky130_gnd sky130_fd_pr__nfet_01v8_lvt L=0.6 W=1.4
+ AS=0.406 AD=0.406 PS=3.38 PD=3.38
M$67 \$280 \$280 \$280 sky130_gnd sky130_fd_pr__nfet_01v8_lvt L=0.6 W=1.4
+ AS=0.406 AD=0.406 PS=3.38 PD=3.38
M$68 \$280 \$280 \$280 sky130_gnd sky130_fd_pr__nfet_01v8_lvt L=0.6 W=1.4
+ AS=0.406 AD=0.406 PS=3.38 PD=3.38
M$69 \$280 \$280 \$280 sky130_gnd sky130_fd_pr__nfet_01v8_lvt L=0.6 W=1.4
+ AS=0.406 AD=0.406 PS=3.38 PD=3.38
M$70 \$280 \$280 \$280 sky130_gnd sky130_fd_pr__nfet_01v8_lvt L=0.6 W=1.4
+ AS=0.406 AD=0.406 PS=3.38 PD=3.38
M$71 \$280 \$280 \$280 sky130_gnd sky130_fd_pr__nfet_01v8_lvt L=0.6 W=1.4
+ AS=0.406 AD=0.406 PS=3.38 PD=3.38
M$72 \$280 \$280 \$280 sky130_gnd sky130_fd_pr__nfet_01v8_lvt L=0.6 W=1.4
+ AS=0.406 AD=0.406 PS=3.38 PD=3.38
M$73 \$213 \$213 \$213 sky130_gnd sky130_fd_pr__nfet_01v8_lvt L=0.6 W=1.4
+ AS=0.406 AD=0.406 PS=3.38 PD=3.38
M$74 \$213 \$213 \$213 sky130_gnd sky130_fd_pr__nfet_01v8_lvt L=0.6 W=1.4
+ AS=0.406 AD=0.406 PS=3.38 PD=3.38
M$75 \$213 \$213 \$213 sky130_gnd sky130_fd_pr__nfet_01v8_lvt L=0.6 W=1.4
+ AS=0.406 AD=0.406 PS=3.38 PD=3.38
M$76 \$213 \$213 \$213 sky130_gnd sky130_fd_pr__nfet_01v8_lvt L=0.6 W=1.4
+ AS=0.406 AD=0.406 PS=3.38 PD=3.38
M$77 \$213 \$213 \$213 sky130_gnd sky130_fd_pr__nfet_01v8_lvt L=0.6 W=1.4
+ AS=0.406 AD=0.406 PS=3.38 PD=3.38
M$78 \$213 \$213 \$213 sky130_gnd sky130_fd_pr__nfet_01v8_lvt L=0.6 W=1.4
+ AS=0.406 AD=0.406 PS=3.38 PD=3.38
M$79 \$213 \$213 \$213 sky130_gnd sky130_fd_pr__nfet_01v8_lvt L=0.6 W=1.4
+ AS=0.406 AD=0.406 PS=3.38 PD=3.38
M$80 \$213 \$213 \$213 sky130_gnd sky130_fd_pr__nfet_01v8_lvt L=0.6 W=1.4
+ AS=0.406 AD=0.406 PS=3.38 PD=3.38
M$81 \$649 \$280 VDD VDD sky130_fd_pr__pfet_01v8_lvt L=0.6 W=1.4 AS=0.406
+ AD=0.406 PS=3.38 PD=3.38
M$82 \$649 \$280 VDD VDD sky130_fd_pr__pfet_01v8_lvt L=0.6 W=1.4 AS=0.406
+ AD=0.406 PS=3.38 PD=3.38
M$83 \$649 \$280 VDD VDD sky130_fd_pr__pfet_01v8_lvt L=0.6 W=1.4 AS=0.406
+ AD=0.406 PS=3.38 PD=3.38
M$84 \$649 \$280 VDD VDD sky130_fd_pr__pfet_01v8_lvt L=0.6 W=1.4 AS=0.406
+ AD=0.406 PS=3.38 PD=3.38
M$85 \$649 \$280 VDD VDD sky130_fd_pr__pfet_01v8_lvt L=0.6 W=1.4 AS=0.406
+ AD=0.406 PS=3.38 PD=3.38
M$86 \$649 \$280 VDD VDD sky130_fd_pr__pfet_01v8_lvt L=0.6 W=1.4 AS=0.406
+ AD=0.406 PS=3.38 PD=3.38
M$87 \$643 \$280 VDD VDD sky130_fd_pr__pfet_01v8_lvt L=0.6 W=1.4 AS=0.406
+ AD=0.406 PS=3.38 PD=3.38
M$88 \$644 \$280 VDD VDD sky130_fd_pr__pfet_01v8_lvt L=0.6 W=1.4 AS=0.406
+ AD=0.406 PS=3.38 PD=3.38
M$89 \$643 \$280 VDD VDD sky130_fd_pr__pfet_01v8_lvt L=0.6 W=1.4 AS=0.406
+ AD=0.406 PS=3.38 PD=3.38
M$90 \$644 \$280 VDD VDD sky130_fd_pr__pfet_01v8_lvt L=0.6 W=1.4 AS=0.406
+ AD=0.406 PS=3.38 PD=3.38
M$91 \$643 \$280 VDD VDD sky130_fd_pr__pfet_01v8_lvt L=0.6 W=1.4 AS=0.406
+ AD=0.406 PS=3.38 PD=3.38
M$92 \$644 \$280 VDD VDD sky130_fd_pr__pfet_01v8_lvt L=0.6 W=1.4 AS=0.406
+ AD=0.406 PS=3.38 PD=3.38
M$93 VDD VDD VDD VDD sky130_fd_pr__pfet_01v8_lvt L=0.6 W=1.4 AS=0.406 AD=0.406
+ PS=3.38 PD=3.38
M$94 VDD VDD VDD VDD sky130_fd_pr__pfet_01v8_lvt L=0.6 W=1.4 AS=0.406 AD=0.406
+ PS=3.38 PD=3.38
M$95 \$644 \$280 VDD VDD sky130_fd_pr__pfet_01v8_lvt L=0.6 W=1.4 AS=0.406
+ AD=0.406 PS=3.38 PD=3.38
M$96 \$643 \$280 VDD VDD sky130_fd_pr__pfet_01v8_lvt L=0.6 W=1.4 AS=0.406
+ AD=0.406 PS=3.38 PD=3.38
M$97 \$644 \$280 VDD VDD sky130_fd_pr__pfet_01v8_lvt L=0.6 W=1.4 AS=0.406
+ AD=0.406 PS=3.38 PD=3.38
M$98 \$643 \$280 VDD VDD sky130_fd_pr__pfet_01v8_lvt L=0.6 W=1.4 AS=0.406
+ AD=0.406 PS=3.38 PD=3.38
M$99 \$644 \$280 VDD VDD sky130_fd_pr__pfet_01v8_lvt L=0.6 W=1.4 AS=0.406
+ AD=0.406 PS=3.38 PD=3.38
M$100 \$643 \$280 VDD VDD sky130_fd_pr__pfet_01v8_lvt L=0.6 W=1.4 AS=0.406
+ AD=0.406 PS=3.38 PD=3.38
M$101 VDD VDD VDD VDD sky130_fd_pr__pfet_01v8_lvt L=0.6 W=1.4 AS=0.406 AD=0.406
+ PS=3.38 PD=3.38
M$102 \$89 \$280 VDD VDD sky130_fd_pr__pfet_01v8_lvt L=0.6 W=1.4 AS=0.406
+ AD=0.406 PS=3.38 PD=3.38
M$103 \$42 \$280 VDD VDD sky130_fd_pr__pfet_01v8_lvt L=0.6 W=1.4 AS=0.406
+ AD=0.406 PS=3.38 PD=3.38
M$104 \$89 \$280 VDD VDD sky130_fd_pr__pfet_01v8_lvt L=0.6 W=1.4 AS=0.406
+ AD=0.406 PS=3.38 PD=3.38
M$105 \$42 \$280 VDD VDD sky130_fd_pr__pfet_01v8_lvt L=0.6 W=1.4 AS=0.406
+ AD=0.406 PS=3.38 PD=3.38
M$106 \$89 \$280 VDD VDD sky130_fd_pr__pfet_01v8_lvt L=0.6 W=1.4 AS=0.406
+ AD=0.406 PS=3.38 PD=3.38
M$107 \$42 \$280 VDD VDD sky130_fd_pr__pfet_01v8_lvt L=0.6 W=1.4 AS=0.406
+ AD=0.406 PS=3.38 PD=3.38
M$108 \$89 \$280 VDD VDD sky130_fd_pr__pfet_01v8_lvt L=0.6 W=1.4 AS=0.406
+ AD=0.406 PS=3.38 PD=3.38
M$109 \$42 \$280 VDD VDD sky130_fd_pr__pfet_01v8_lvt L=0.6 W=1.4 AS=0.406
+ AD=0.406 PS=3.38 PD=3.38
M$110 \$89 \$280 VDD VDD sky130_fd_pr__pfet_01v8_lvt L=0.6 W=1.4 AS=0.406
+ AD=0.406 PS=3.38 PD=3.38
M$111 \$42 \$280 VDD VDD sky130_fd_pr__pfet_01v8_lvt L=0.6 W=1.4 AS=0.406
+ AD=0.406 PS=3.38 PD=3.38
M$112 \$89 \$280 VDD VDD sky130_fd_pr__pfet_01v8_lvt L=0.6 W=1.4 AS=0.406
+ AD=0.406 PS=3.38 PD=3.38
M$113 \$89 \$280 VDD VDD sky130_fd_pr__pfet_01v8_lvt L=0.6 W=1.4 AS=0.406
+ AD=0.406 PS=3.38 PD=3.38
M$114 \$42 \$280 VDD VDD sky130_fd_pr__pfet_01v8_lvt L=0.6 W=1.4 AS=0.406
+ AD=0.406 PS=3.38 PD=3.38
M$115 \$89 \$280 VDD VDD sky130_fd_pr__pfet_01v8_lvt L=0.6 W=1.4 AS=0.406
+ AD=0.406 PS=3.38 PD=3.38
M$116 \$42 \$280 VDD VDD sky130_fd_pr__pfet_01v8_lvt L=0.6 W=1.4 AS=0.406
+ AD=0.406 PS=3.38 PD=3.38
M$117 \$89 \$280 VDD VDD sky130_fd_pr__pfet_01v8_lvt L=0.6 W=1.4 AS=0.406
+ AD=0.406 PS=3.38 PD=3.38
M$118 \$42 \$280 VDD VDD sky130_fd_pr__pfet_01v8_lvt L=0.6 W=1.4 AS=0.406
+ AD=0.406 PS=3.38 PD=3.38
M$119 \$89 \$280 VDD VDD sky130_fd_pr__pfet_01v8_lvt L=0.6 W=1.4 AS=0.406
+ AD=0.406 PS=3.38 PD=3.38
M$120 \$42 \$280 VDD VDD sky130_fd_pr__pfet_01v8_lvt L=0.6 W=1.4 AS=0.406
+ AD=0.406 PS=3.38 PD=3.38
M$121 \$89 \$280 VDD VDD sky130_fd_pr__pfet_01v8_lvt L=0.6 W=1.4 AS=0.406
+ AD=0.406 PS=3.38 PD=3.38
M$122 \$42 \$280 VDD VDD sky130_fd_pr__pfet_01v8_lvt L=0.6 W=1.4 AS=0.406
+ AD=0.406 PS=3.38 PD=3.38
M$123 \$89 \$280 VDD VDD sky130_fd_pr__pfet_01v8_lvt L=0.6 W=1.4 AS=0.406
+ AD=0.406 PS=3.38 PD=3.38
M$124 \$42 \$280 VDD VDD sky130_fd_pr__pfet_01v8_lvt L=0.6 W=1.4 AS=0.406
+ AD=0.406 PS=3.38 PD=3.38
M$125 \$42 \$280 VDD VDD sky130_fd_pr__pfet_01v8_lvt L=0.6 W=1.4 AS=0.406
+ AD=0.406 PS=3.38 PD=3.38
M$126 VDD VDD VDD VDD sky130_fd_pr__pfet_01v8_lvt L=0.6 W=1.4 AS=0.406 AD=0.406
+ PS=3.38 PD=3.38
M$127 \$89 \$280 VDD VDD sky130_fd_pr__pfet_01v8_lvt L=0.6 W=1.4 AS=0.406
+ AD=0.406 PS=3.38 PD=3.38
M$128 \$42 \$280 VDD VDD sky130_fd_pr__pfet_01v8_lvt L=0.6 W=1.4 AS=0.406
+ AD=0.406 PS=3.38 PD=3.38
M$129 \$89 \$280 VDD VDD sky130_fd_pr__pfet_01v8_lvt L=0.6 W=1.4 AS=0.406
+ AD=0.406 PS=3.38 PD=3.38
M$130 \$42 \$280 VDD VDD sky130_fd_pr__pfet_01v8_lvt L=0.6 W=1.4 AS=0.406
+ AD=0.406 PS=3.38 PD=3.38
M$131 \$89 \$280 VDD VDD sky130_fd_pr__pfet_01v8_lvt L=0.6 W=1.4 AS=0.406
+ AD=0.406 PS=3.38 PD=3.38
M$132 \$42 \$280 VDD VDD sky130_fd_pr__pfet_01v8_lvt L=0.6 W=1.4 AS=0.406
+ AD=0.406 PS=3.38 PD=3.38
M$133 \$89 \$280 VDD VDD sky130_fd_pr__pfet_01v8_lvt L=0.6 W=1.4 AS=0.406
+ AD=0.406 PS=3.38 PD=3.38
M$134 \$42 \$280 VDD VDD sky130_fd_pr__pfet_01v8_lvt L=0.6 W=1.4 AS=0.406
+ AD=0.406 PS=3.38 PD=3.38
M$135 \$89 \$280 VDD VDD sky130_fd_pr__pfet_01v8_lvt L=0.6 W=1.4 AS=0.406
+ AD=0.406 PS=3.38 PD=3.38
M$136 \$42 \$280 VDD VDD sky130_fd_pr__pfet_01v8_lvt L=0.6 W=1.4 AS=0.406
+ AD=0.406 PS=3.38 PD=3.38
M$137 \$42 \$280 VDD VDD sky130_fd_pr__pfet_01v8_lvt L=0.6 W=1.4 AS=0.406
+ AD=0.406 PS=3.38 PD=3.38
M$138 \$42 \$280 VDD VDD sky130_fd_pr__pfet_01v8_lvt L=0.6 W=1.4 AS=0.406
+ AD=0.406 PS=3.38 PD=3.38
M$139 \$89 \$280 VDD VDD sky130_fd_pr__pfet_01v8_lvt L=0.6 W=1.4 AS=0.406
+ AD=0.406 PS=3.38 PD=3.38
M$140 \$42 \$280 VDD VDD sky130_fd_pr__pfet_01v8_lvt L=0.6 W=1.4 AS=0.406
+ AD=0.406 PS=3.38 PD=3.38
M$141 \$89 \$280 VDD VDD sky130_fd_pr__pfet_01v8_lvt L=0.6 W=1.4 AS=0.406
+ AD=0.406 PS=3.38 PD=3.38
M$142 \$42 \$280 VDD VDD sky130_fd_pr__pfet_01v8_lvt L=0.6 W=1.4 AS=0.406
+ AD=0.406 PS=3.38 PD=3.38
M$143 \$89 \$280 VDD VDD sky130_fd_pr__pfet_01v8_lvt L=0.6 W=1.4 AS=0.406
+ AD=0.406 PS=3.38 PD=3.38
M$144 \$42 \$280 VDD VDD sky130_fd_pr__pfet_01v8_lvt L=0.6 W=1.4 AS=0.406
+ AD=0.406 PS=3.38 PD=3.38
M$145 \$89 \$280 VDD VDD sky130_fd_pr__pfet_01v8_lvt L=0.6 W=1.4 AS=0.406
+ AD=0.406 PS=3.38 PD=3.38
M$146 \$42 \$280 VDD VDD sky130_fd_pr__pfet_01v8_lvt L=0.6 W=1.4 AS=0.406
+ AD=0.406 PS=3.38 PD=3.38
M$147 \$89 \$280 VDD VDD sky130_fd_pr__pfet_01v8_lvt L=0.6 W=1.4 AS=0.406
+ AD=0.406 PS=3.38 PD=3.38
M$148 \$42 \$280 VDD VDD sky130_fd_pr__pfet_01v8_lvt L=0.6 W=1.4 AS=0.406
+ AD=0.406 PS=3.38 PD=3.38
M$149 \$89 \$280 VDD VDD sky130_fd_pr__pfet_01v8_lvt L=0.6 W=1.4 AS=0.406
+ AD=0.406 PS=3.38 PD=3.38
M$150 \$89 \$280 VDD VDD sky130_fd_pr__pfet_01v8_lvt L=0.6 W=1.4 AS=0.406
+ AD=0.406 PS=3.38 PD=3.38
M$151 \$338 VDD VDD VDD sky130_fd_pr__pfet_01v8 L=0.6 W=1.4 AS=0.406 AD=0.406
+ PS=3.38 PD=3.38
M$152 \$338 VDD VDD VDD sky130_fd_pr__pfet_01v8 L=0.6 W=1.4 AS=0.406 AD=0.406
+ PS=3.38 PD=3.38
M$153 \$280 VDD VDD VDD sky130_fd_pr__pfet_01v8 L=0.6 W=1.4 AS=0.406 AD=0.406
+ PS=3.38 PD=3.38
M$154 \$280 VDD VDD VDD sky130_fd_pr__pfet_01v8 L=0.6 W=1.4 AS=0.406 AD=0.406
+ PS=3.38 PD=3.38
M$155 \$649 VDD VDD VDD sky130_fd_pr__pfet_01v8 L=0.6 W=1.4 AS=0.406 AD=0.406
+ PS=3.38 PD=3.38
M$156 \$649 VDD VDD VDD sky130_fd_pr__pfet_01v8 L=0.6 W=1.4 AS=0.406 AD=0.406
+ PS=3.38 PD=3.38
M$157 cm VDD VDD VDD sky130_fd_pr__pfet_01v8 L=0.6 W=1.4 AS=0.406 AD=0.406
+ PS=3.38 PD=3.38
M$158 cm VDD VDD VDD sky130_fd_pr__pfet_01v8 L=0.6 W=1.4 AS=0.406 AD=0.406
+ PS=3.38 PD=3.38
M$159 \$643 \$643 \$643 VDD sky130_fd_pr__pfet_01v8 L=0.6 W=1.4 AS=0.406
+ AD=0.406 PS=3.38 PD=3.38
M$160 \$643 \$643 \$643 VDD sky130_fd_pr__pfet_01v8 L=0.6 W=1.4 AS=0.406
+ AD=0.406 PS=3.38 PD=3.38
M$161 \$644 \$644 \$644 VDD sky130_fd_pr__pfet_01v8 L=0.6 W=1.4 AS=0.406
+ AD=0.406 PS=3.38 PD=3.38
M$162 \$644 \$644 \$644 VDD sky130_fd_pr__pfet_01v8 L=0.6 W=1.4 AS=0.406
+ AD=0.406 PS=3.38 PD=3.38
M$163 \$89 VDD VDD VDD sky130_fd_pr__pfet_01v8 L=0.6 W=1.4 AS=0.406 AD=0.406
+ PS=3.38 PD=3.38
M$164 \$89 VDD VDD VDD sky130_fd_pr__pfet_01v8 L=0.6 W=1.4 AS=0.406 AD=0.406
+ PS=3.38 PD=3.38
M$165 \$42 VDD VDD VDD sky130_fd_pr__pfet_01v8 L=0.6 W=1.4 AS=0.406 AD=0.406
+ PS=3.38 PD=3.38
M$166 \$42 VDD VDD VDD sky130_fd_pr__pfet_01v8 L=0.6 W=1.4 AS=0.406 AD=0.406
+ PS=3.38 PD=3.38
M$167 \$42 \$42 \$42 VDD sky130_fd_pr__pfet_01v8 L=0.6 W=1.4 AS=0.406 AD=0.406
+ PS=3.38 PD=3.38
M$168 \$42 \$42 \$42 VDD sky130_fd_pr__pfet_01v8 L=0.6 W=1.4 AS=0.406 AD=0.406
+ PS=3.38 PD=3.38
M$169 \$89 \$89 \$89 VDD sky130_fd_pr__pfet_01v8 L=0.6 W=1.4 AS=0.406 AD=0.406
+ PS=3.38 PD=3.38
M$170 \$89 \$89 \$89 VDD sky130_fd_pr__pfet_01v8 L=0.6 W=1.4 AS=0.406 AD=0.406
+ PS=3.38 PD=3.38
M$171 op VDD VDD VDD sky130_fd_pr__pfet_01v8 L=0.6 W=1.4 AS=0.406 AD=0.406
+ PS=3.38 PD=3.38
M$172 op VDD VDD VDD sky130_fd_pr__pfet_01v8 L=0.6 W=1.4 AS=0.406 AD=0.406
+ PS=3.38 PD=3.38
M$173 op VDD VDD VDD sky130_fd_pr__pfet_01v8 L=0.6 W=1.4 AS=0.406 AD=0.406
+ PS=3.38 PD=3.38
M$174 op VDD VDD VDD sky130_fd_pr__pfet_01v8 L=0.6 W=1.4 AS=0.406 AD=0.406
+ PS=3.38 PD=3.38
M$175 on VDD VDD VDD sky130_fd_pr__pfet_01v8 L=0.6 W=1.4 AS=0.406 AD=0.406
+ PS=3.38 PD=3.38
M$176 on VDD VDD VDD sky130_fd_pr__pfet_01v8 L=0.6 W=1.4 AS=0.406 AD=0.406
+ PS=3.38 PD=3.38
M$177 on VDD VDD VDD sky130_fd_pr__pfet_01v8 L=0.6 W=1.4 AS=0.406 AD=0.406
+ PS=3.38 PD=3.38
M$178 on VDD VDD VDD sky130_fd_pr__pfet_01v8 L=0.6 W=1.4 AS=0.406 AD=0.406
+ PS=3.38 PD=3.38
M$179 \$89 in \$61 sky130_gnd sky130_fd_pr__nfet_01v8_lvt L=0.2 W=1.2 AS=0.348
+ AD=0.348 PS=2.98 PD=2.98
M$180 \$89 in \$61 sky130_gnd sky130_fd_pr__nfet_01v8_lvt L=0.2 W=1.2 AS=0.348
+ AD=0.348 PS=2.98 PD=2.98
M$181 \$89 in \$61 sky130_gnd sky130_fd_pr__nfet_01v8_lvt L=0.2 W=1.2 AS=0.348
+ AD=0.348 PS=2.98 PD=2.98
M$182 \$89 in \$61 sky130_gnd sky130_fd_pr__nfet_01v8_lvt L=0.2 W=1.2 AS=0.348
+ AD=0.348 PS=2.98 PD=2.98
M$183 \$89 in \$61 sky130_gnd sky130_fd_pr__nfet_01v8_lvt L=0.2 W=1.2 AS=0.348
+ AD=0.348 PS=2.98 PD=2.98
M$184 \$89 in \$61 sky130_gnd sky130_fd_pr__nfet_01v8_lvt L=0.2 W=1.2 AS=0.348
+ AD=0.348 PS=2.98 PD=2.98
M$185 \$42 ip \$61 sky130_gnd sky130_fd_pr__nfet_01v8_lvt L=0.2 W=1.2 AS=0.348
+ AD=0.348 PS=2.98 PD=2.98
M$186 \$42 ip \$61 sky130_gnd sky130_fd_pr__nfet_01v8_lvt L=0.2 W=1.2 AS=0.348
+ AD=0.348 PS=2.98 PD=2.98
M$187 \$42 ip \$61 sky130_gnd sky130_fd_pr__nfet_01v8_lvt L=0.2 W=1.2 AS=0.348
+ AD=0.348 PS=2.98 PD=2.98
M$188 \$42 ip \$61 sky130_gnd sky130_fd_pr__nfet_01v8_lvt L=0.2 W=1.2 AS=0.348
+ AD=0.348 PS=2.98 PD=2.98
M$189 \$42 ip \$61 sky130_gnd sky130_fd_pr__nfet_01v8_lvt L=0.2 W=1.2 AS=0.348
+ AD=0.348 PS=2.98 PD=2.98
M$190 \$42 ip \$61 sky130_gnd sky130_fd_pr__nfet_01v8_lvt L=0.2 W=1.2 AS=0.348
+ AD=0.348 PS=2.98 PD=2.98
M$191 VSS VSS VSS sky130_gnd sky130_fd_pr__nfet_01v8_lvt L=0.2 W=1.2 AS=0.348
+ AD=0.348 PS=2.98 PD=2.98
M$192 VSS VSS VSS sky130_gnd sky130_fd_pr__nfet_01v8_lvt L=0.2 W=1.2 AS=0.348
+ AD=0.348 PS=2.98 PD=2.98
M$193 \$338 \$338 \$388 sky130_gnd sky130_fd_pr__nfet_01v8 L=0.6 W=1.4 AS=0.406
+ AD=0.406 PS=3.38 PD=3.38
M$194 \$338 \$338 \$388 sky130_gnd sky130_fd_pr__nfet_01v8 L=0.6 W=1.4 AS=0.406
+ AD=0.406 PS=3.38 PD=3.38
M$195 \$338 \$338 \$388 sky130_gnd sky130_fd_pr__nfet_01v8 L=0.6 W=1.4 AS=0.406
+ AD=0.406 PS=3.38 PD=3.38
M$196 \$338 \$338 \$388 sky130_gnd sky130_fd_pr__nfet_01v8 L=0.6 W=1.4 AS=0.406
+ AD=0.406 PS=3.38 PD=3.38
M$197 \$338 \$338 \$388 sky130_gnd sky130_fd_pr__nfet_01v8 L=0.6 W=1.4 AS=0.406
+ AD=0.406 PS=3.38 PD=3.38
M$198 \$338 \$338 \$388 sky130_gnd sky130_fd_pr__nfet_01v8 L=0.6 W=1.4 AS=0.406
+ AD=0.406 PS=3.38 PD=3.38
M$199 \$338 \$338 \$388 sky130_gnd sky130_fd_pr__nfet_01v8 L=0.6 W=1.4 AS=0.406
+ AD=0.406 PS=3.38 PD=3.38
M$200 \$338 \$338 \$388 sky130_gnd sky130_fd_pr__nfet_01v8 L=0.6 W=1.4 AS=0.406
+ AD=0.406 PS=3.38 PD=3.38
M$201 \$338 \$338 \$388 sky130_gnd sky130_fd_pr__nfet_01v8 L=0.6 W=1.4 AS=0.406
+ AD=0.406 PS=3.38 PD=3.38
M$202 \$338 \$338 \$388 sky130_gnd sky130_fd_pr__nfet_01v8 L=0.6 W=1.4 AS=0.406
+ AD=0.406 PS=3.38 PD=3.38
M$203 \$338 \$338 \$388 sky130_gnd sky130_fd_pr__nfet_01v8 L=0.6 W=1.4 AS=0.406
+ AD=0.406 PS=3.38 PD=3.38
M$204 \$338 \$338 \$388 sky130_gnd sky130_fd_pr__nfet_01v8 L=0.6 W=1.4 AS=0.406
+ AD=0.406 PS=3.38 PD=3.38
M$205 \$338 \$338 \$388 sky130_gnd sky130_fd_pr__nfet_01v8 L=0.6 W=1.4 AS=0.406
+ AD=0.406 PS=3.38 PD=3.38
M$206 \$338 \$338 \$388 sky130_gnd sky130_fd_pr__nfet_01v8 L=0.6 W=1.4 AS=0.406
+ AD=0.406 PS=3.38 PD=3.38
M$207 \$338 \$338 \$388 sky130_gnd sky130_fd_pr__nfet_01v8 L=0.6 W=1.4 AS=0.406
+ AD=0.406 PS=3.38 PD=3.38
M$208 \$338 \$338 \$388 sky130_gnd sky130_fd_pr__nfet_01v8 L=0.6 W=1.4 AS=0.406
+ AD=0.406 PS=3.38 PD=3.38
M$209 \$338 \$338 \$388 sky130_gnd sky130_fd_pr__nfet_01v8 L=0.6 W=1.4 AS=0.406
+ AD=0.406 PS=3.38 PD=3.38
M$210 \$338 \$338 \$388 sky130_gnd sky130_fd_pr__nfet_01v8 L=0.6 W=1.4 AS=0.406
+ AD=0.406 PS=3.38 PD=3.38
M$211 \$338 \$338 \$388 sky130_gnd sky130_fd_pr__nfet_01v8 L=0.6 W=1.4 AS=0.406
+ AD=0.406 PS=3.38 PD=3.38
M$212 \$338 \$338 \$388 sky130_gnd sky130_fd_pr__nfet_01v8 L=0.6 W=1.4 AS=0.406
+ AD=0.406 PS=3.38 PD=3.38
M$213 \$338 \$338 \$388 sky130_gnd sky130_fd_pr__nfet_01v8 L=0.6 W=1.4 AS=0.406
+ AD=0.406 PS=3.38 PD=3.38
M$214 \$338 \$338 \$388 sky130_gnd sky130_fd_pr__nfet_01v8 L=0.6 W=1.4 AS=0.406
+ AD=0.406 PS=3.38 PD=3.38
M$215 \$338 \$338 \$388 sky130_gnd sky130_fd_pr__nfet_01v8 L=0.6 W=1.4 AS=0.406
+ AD=0.406 PS=3.38 PD=3.38
M$216 \$338 \$338 \$388 sky130_gnd sky130_fd_pr__nfet_01v8 L=0.6 W=1.4 AS=0.406
+ AD=0.406 PS=3.38 PD=3.38
M$217 \$338 \$338 \$388 sky130_gnd sky130_fd_pr__nfet_01v8 L=0.6 W=1.4 AS=0.406
+ AD=0.406 PS=3.38 PD=3.38
M$218 \$338 \$338 \$388 sky130_gnd sky130_fd_pr__nfet_01v8 L=0.6 W=1.4 AS=0.406
+ AD=0.406 PS=3.38 PD=3.38
M$219 \$338 \$338 \$388 sky130_gnd sky130_fd_pr__nfet_01v8 L=0.6 W=1.4 AS=0.406
+ AD=0.406 PS=3.38 PD=3.38
M$220 \$338 \$338 \$388 sky130_gnd sky130_fd_pr__nfet_01v8 L=0.6 W=1.4 AS=0.406
+ AD=0.406 PS=3.38 PD=3.38
M$221 \$338 \$338 \$388 sky130_gnd sky130_fd_pr__nfet_01v8 L=0.6 W=1.4 AS=0.406
+ AD=0.406 PS=3.38 PD=3.38
M$222 \$338 \$338 \$388 sky130_gnd sky130_fd_pr__nfet_01v8 L=0.6 W=1.4 AS=0.406
+ AD=0.406 PS=3.38 PD=3.38
M$223 \$338 \$338 \$388 sky130_gnd sky130_fd_pr__nfet_01v8 L=0.6 W=1.4 AS=0.406
+ AD=0.406 PS=3.38 PD=3.38
M$224 \$338 \$338 \$388 sky130_gnd sky130_fd_pr__nfet_01v8 L=0.6 W=1.4 AS=0.406
+ AD=0.406 PS=3.38 PD=3.38
M$225 \$338 \$338 \$388 sky130_gnd sky130_fd_pr__nfet_01v8 L=0.6 W=1.4 AS=0.406
+ AD=0.406 PS=3.38 PD=3.38
M$226 \$338 \$338 \$388 sky130_gnd sky130_fd_pr__nfet_01v8 L=0.6 W=1.4 AS=0.406
+ AD=0.406 PS=3.38 PD=3.38
M$227 \$338 \$338 \$388 sky130_gnd sky130_fd_pr__nfet_01v8 L=0.6 W=1.4 AS=0.406
+ AD=0.406 PS=3.38 PD=3.38
M$228 \$338 \$338 \$388 sky130_gnd sky130_fd_pr__nfet_01v8 L=0.6 W=1.4 AS=0.406
+ AD=0.406 PS=3.38 PD=3.38
M$229 \$338 \$338 \$388 sky130_gnd sky130_fd_pr__nfet_01v8 L=0.6 W=1.4 AS=0.406
+ AD=0.406 PS=3.38 PD=3.38
M$230 \$338 \$338 \$388 sky130_gnd sky130_fd_pr__nfet_01v8 L=0.6 W=1.4 AS=0.406
+ AD=0.406 PS=3.38 PD=3.38
M$231 \$338 \$338 \$388 sky130_gnd sky130_fd_pr__nfet_01v8 L=0.6 W=1.4 AS=0.406
+ AD=0.406 PS=3.38 PD=3.38
M$232 \$338 \$338 \$388 sky130_gnd sky130_fd_pr__nfet_01v8 L=0.6 W=1.4 AS=0.406
+ AD=0.406 PS=3.38 PD=3.38
M$233 \$338 \$338 \$388 sky130_gnd sky130_fd_pr__nfet_01v8 L=0.6 W=1.4 AS=0.406
+ AD=0.406 PS=3.38 PD=3.38
M$234 \$338 \$338 \$388 sky130_gnd sky130_fd_pr__nfet_01v8 L=0.6 W=1.4 AS=0.406
+ AD=0.406 PS=3.38 PD=3.38
M$235 \$338 \$338 \$388 sky130_gnd sky130_fd_pr__nfet_01v8 L=0.6 W=1.4 AS=0.406
+ AD=0.406 PS=3.38 PD=3.38
M$236 \$338 \$338 \$388 sky130_gnd sky130_fd_pr__nfet_01v8 L=0.6 W=1.4 AS=0.406
+ AD=0.406 PS=3.38 PD=3.38
M$237 \$338 \$338 \$388 sky130_gnd sky130_fd_pr__nfet_01v8 L=0.6 W=1.4 AS=0.406
+ AD=0.406 PS=3.38 PD=3.38
M$238 \$338 \$338 \$388 sky130_gnd sky130_fd_pr__nfet_01v8 L=0.6 W=1.4 AS=0.406
+ AD=0.406 PS=3.38 PD=3.38
M$239 \$338 \$338 \$388 sky130_gnd sky130_fd_pr__nfet_01v8 L=0.6 W=1.4 AS=0.406
+ AD=0.406 PS=3.38 PD=3.38
M$240 \$338 \$338 \$388 sky130_gnd sky130_fd_pr__nfet_01v8 L=0.6 W=1.4 AS=0.406
+ AD=0.406 PS=3.38 PD=3.38
M$241 \$338 \$338 \$388 sky130_gnd sky130_fd_pr__nfet_01v8 L=0.6 W=1.4 AS=0.406
+ AD=0.406 PS=3.38 PD=3.38
M$242 \$338 \$338 \$388 sky130_gnd sky130_fd_pr__nfet_01v8 L=0.6 W=1.4 AS=0.406
+ AD=0.406 PS=3.38 PD=3.38
M$243 \$213 IBIAS VSS sky130_gnd sky130_fd_pr__nfet_01v8 L=0.6 W=1.4 AS=0.406
+ AD=0.406 PS=3.38 PD=3.38
M$244 \$213 IBIAS VSS sky130_gnd sky130_fd_pr__nfet_01v8 L=0.6 W=1.4 AS=0.406
+ AD=0.406 PS=3.38 PD=3.38
M$245 \$213 IBIAS VSS sky130_gnd sky130_fd_pr__nfet_01v8 L=0.6 W=1.4 AS=0.406
+ AD=0.406 PS=3.38 PD=3.38
M$246 \$213 IBIAS VSS sky130_gnd sky130_fd_pr__nfet_01v8 L=0.6 W=1.4 AS=0.406
+ AD=0.406 PS=3.38 PD=3.38
M$247 \$213 IBIAS VSS sky130_gnd sky130_fd_pr__nfet_01v8 L=0.6 W=1.4 AS=0.406
+ AD=0.406 PS=3.38 PD=3.38
M$248 \$213 IBIAS VSS sky130_gnd sky130_fd_pr__nfet_01v8 L=0.6 W=1.4 AS=0.406
+ AD=0.406 PS=3.38 PD=3.38
M$249 \$213 IBIAS VSS sky130_gnd sky130_fd_pr__nfet_01v8 L=0.6 W=1.4 AS=0.406
+ AD=0.406 PS=3.38 PD=3.38
M$250 \$213 IBIAS VSS sky130_gnd sky130_fd_pr__nfet_01v8 L=0.6 W=1.4 AS=0.406
+ AD=0.406 PS=3.38 PD=3.38
M$251 \$213 IBIAS VSS sky130_gnd sky130_fd_pr__nfet_01v8 L=0.6 W=1.4 AS=0.406
+ AD=0.406 PS=3.38 PD=3.38
M$252 \$213 IBIAS VSS sky130_gnd sky130_fd_pr__nfet_01v8 L=0.6 W=1.4 AS=0.406
+ AD=0.406 PS=3.38 PD=3.38
M$253 \$213 IBIAS VSS sky130_gnd sky130_fd_pr__nfet_01v8 L=0.6 W=1.4 AS=0.406
+ AD=0.406 PS=3.38 PD=3.38
M$254 \$213 IBIAS VSS sky130_gnd sky130_fd_pr__nfet_01v8 L=0.6 W=1.4 AS=0.406
+ AD=0.406 PS=3.38 PD=3.38
M$255 \$213 IBIAS VSS sky130_gnd sky130_fd_pr__nfet_01v8 L=0.6 W=1.4 AS=0.406
+ AD=0.406 PS=3.38 PD=3.38
M$256 \$213 IBIAS VSS sky130_gnd sky130_fd_pr__nfet_01v8 L=0.6 W=1.4 AS=0.406
+ AD=0.406 PS=3.38 PD=3.38
M$257 \$213 IBIAS VSS sky130_gnd sky130_fd_pr__nfet_01v8 L=0.6 W=1.4 AS=0.406
+ AD=0.406 PS=3.38 PD=3.38
M$258 \$213 IBIAS VSS sky130_gnd sky130_fd_pr__nfet_01v8 L=0.6 W=1.4 AS=0.406
+ AD=0.406 PS=3.38 PD=3.38
M$259 \$213 IBIAS VSS sky130_gnd sky130_fd_pr__nfet_01v8 L=0.6 W=1.4 AS=0.406
+ AD=0.406 PS=3.38 PD=3.38
M$260 \$213 IBIAS VSS sky130_gnd sky130_fd_pr__nfet_01v8 L=0.6 W=1.4 AS=0.406
+ AD=0.406 PS=3.38 PD=3.38
M$261 VSS VSS VSS sky130_gnd sky130_fd_pr__nfet_01v8 L=0.6 W=1.4 AS=0.406
+ AD=0.406 PS=3.38 PD=3.38
M$262 IBIAS IBIAS VSS sky130_gnd sky130_fd_pr__nfet_01v8 L=0.6 W=1.4 AS=0.406
+ AD=0.406 PS=3.38 PD=3.38
M$263 IBIAS IBIAS VSS sky130_gnd sky130_fd_pr__nfet_01v8 L=0.6 W=1.4 AS=0.406
+ AD=0.406 PS=3.38 PD=3.38
M$264 IBIAS IBIAS VSS sky130_gnd sky130_fd_pr__nfet_01v8 L=0.6 W=1.4 AS=0.406
+ AD=0.406 PS=3.38 PD=3.38
M$265 IBIAS IBIAS VSS sky130_gnd sky130_fd_pr__nfet_01v8 L=0.6 W=1.4 AS=0.406
+ AD=0.406 PS=3.38 PD=3.38
M$266 VSS VSS VSS sky130_gnd sky130_fd_pr__nfet_01v8 L=0.6 W=1.4 AS=0.406
+ AD=0.406 PS=3.38 PD=3.38
M$267 IBIAS IBIAS VSS sky130_gnd sky130_fd_pr__nfet_01v8 L=0.6 W=1.4 AS=0.406
+ AD=0.406 PS=3.38 PD=3.38
M$268 IBIAS IBIAS VSS sky130_gnd sky130_fd_pr__nfet_01v8 L=0.6 W=1.4 AS=0.406
+ AD=0.406 PS=3.38 PD=3.38
M$269 IBIAS IBIAS VSS sky130_gnd sky130_fd_pr__nfet_01v8 L=0.6 W=1.4 AS=0.406
+ AD=0.406 PS=3.38 PD=3.38
M$270 IBIAS IBIAS VSS sky130_gnd sky130_fd_pr__nfet_01v8 L=0.6 W=1.4 AS=0.406
+ AD=0.406 PS=3.38 PD=3.38
M$271 IBIAS IBIAS VSS sky130_gnd sky130_fd_pr__nfet_01v8 L=0.6 W=1.4 AS=0.406
+ AD=0.406 PS=3.38 PD=3.38
M$272 IBIAS IBIAS VSS sky130_gnd sky130_fd_pr__nfet_01v8 L=0.6 W=1.4 AS=0.406
+ AD=0.406 PS=3.38 PD=3.38
M$273 IBIAS IBIAS VSS sky130_gnd sky130_fd_pr__nfet_01v8 L=0.6 W=1.4 AS=0.406
+ AD=0.406 PS=3.38 PD=3.38
M$274 IBIAS IBIAS VSS sky130_gnd sky130_fd_pr__nfet_01v8 L=0.6 W=1.4 AS=0.406
+ AD=0.406 PS=3.38 PD=3.38
M$275 IBIAS IBIAS VSS sky130_gnd sky130_fd_pr__nfet_01v8 L=0.6 W=1.4 AS=0.406
+ AD=0.406 PS=3.38 PD=3.38
M$276 IBIAS IBIAS VSS sky130_gnd sky130_fd_pr__nfet_01v8 L=0.6 W=1.4 AS=0.406
+ AD=0.406 PS=3.38 PD=3.38
M$277 IBIAS IBIAS VSS sky130_gnd sky130_fd_pr__nfet_01v8 L=0.6 W=1.4 AS=0.406
+ AD=0.406 PS=3.38 PD=3.38
M$278 IBIAS IBIAS VSS sky130_gnd sky130_fd_pr__nfet_01v8 L=0.6 W=1.4 AS=0.406
+ AD=0.406 PS=3.38 PD=3.38
M$279 IBIAS IBIAS VSS sky130_gnd sky130_fd_pr__nfet_01v8 L=0.6 W=1.4 AS=0.406
+ AD=0.406 PS=3.38 PD=3.38
M$280 IBIAS IBIAS VSS sky130_gnd sky130_fd_pr__nfet_01v8 L=0.6 W=1.4 AS=0.406
+ AD=0.406 PS=3.38 PD=3.38
M$281 \$342 bias_a VSS sky130_gnd sky130_fd_pr__nfet_01v8 L=0.6 W=1.4 AS=0.406
+ AD=0.406 PS=3.38 PD=3.38
M$282 \$342 bias_a VSS sky130_gnd sky130_fd_pr__nfet_01v8 L=0.6 W=1.4 AS=0.406
+ AD=0.406 PS=3.38 PD=3.38
M$283 \$342 bias_a VSS sky130_gnd sky130_fd_pr__nfet_01v8 L=0.6 W=1.4 AS=0.406
+ AD=0.406 PS=3.38 PD=3.38
M$284 \$342 bias_a VSS sky130_gnd sky130_fd_pr__nfet_01v8 L=0.6 W=1.4 AS=0.406
+ AD=0.406 PS=3.38 PD=3.38
M$285 \$342 bias_a VSS sky130_gnd sky130_fd_pr__nfet_01v8 L=0.6 W=1.4 AS=0.406
+ AD=0.406 PS=3.38 PD=3.38
M$286 \$342 bias_a VSS sky130_gnd sky130_fd_pr__nfet_01v8 L=0.6 W=1.4 AS=0.406
+ AD=0.406 PS=3.38 PD=3.38
M$287 \$342 bias_a VSS sky130_gnd sky130_fd_pr__nfet_01v8 L=0.6 W=1.4 AS=0.406
+ AD=0.406 PS=3.38 PD=3.38
M$288 \$342 bias_a VSS sky130_gnd sky130_fd_pr__nfet_01v8 L=0.6 W=1.4 AS=0.406
+ AD=0.406 PS=3.38 PD=3.38
M$289 \$342 bias_a VSS sky130_gnd sky130_fd_pr__nfet_01v8 L=0.6 W=1.4 AS=0.406
+ AD=0.406 PS=3.38 PD=3.38
M$290 \$342 bias_a VSS sky130_gnd sky130_fd_pr__nfet_01v8 L=0.6 W=1.4 AS=0.406
+ AD=0.406 PS=3.38 PD=3.38
M$291 \$342 bias_a VSS sky130_gnd sky130_fd_pr__nfet_01v8 L=0.6 W=1.4 AS=0.406
+ AD=0.406 PS=3.38 PD=3.38
M$292 \$342 bias_a VSS sky130_gnd sky130_fd_pr__nfet_01v8 L=0.6 W=1.4 AS=0.406
+ AD=0.406 PS=3.38 PD=3.38
M$293 \$342 bias_a VSS sky130_gnd sky130_fd_pr__nfet_01v8 L=0.6 W=1.4 AS=0.406
+ AD=0.406 PS=3.38 PD=3.38
M$294 \$342 bias_a VSS sky130_gnd sky130_fd_pr__nfet_01v8 L=0.6 W=1.4 AS=0.406
+ AD=0.406 PS=3.38 PD=3.38
M$295 \$342 bias_a VSS sky130_gnd sky130_fd_pr__nfet_01v8 L=0.6 W=1.4 AS=0.406
+ AD=0.406 PS=3.38 PD=3.38
M$296 \$342 bias_a VSS sky130_gnd sky130_fd_pr__nfet_01v8 L=0.6 W=1.4 AS=0.406
+ AD=0.406 PS=3.38 PD=3.38
M$297 \$342 bias_a VSS sky130_gnd sky130_fd_pr__nfet_01v8 L=0.6 W=1.4 AS=0.406
+ AD=0.406 PS=3.38 PD=3.38
M$298 \$342 bias_a VSS sky130_gnd sky130_fd_pr__nfet_01v8 L=0.6 W=1.4 AS=0.406
+ AD=0.406 PS=3.38 PD=3.38
M$299 bias_a \$388 \$342 sky130_gnd sky130_fd_pr__nfet_01v8 L=0.6 W=1.4
+ AS=0.406 AD=0.406 PS=3.38 PD=3.38
M$300 bias_a \$388 \$342 sky130_gnd sky130_fd_pr__nfet_01v8 L=0.6 W=1.4
+ AS=0.406 AD=0.406 PS=3.38 PD=3.38
M$301 bias_a \$388 \$342 sky130_gnd sky130_fd_pr__nfet_01v8 L=0.6 W=1.4
+ AS=0.406 AD=0.406 PS=3.38 PD=3.38
M$302 bias_a \$388 \$342 sky130_gnd sky130_fd_pr__nfet_01v8 L=0.6 W=1.4
+ AS=0.406 AD=0.406 PS=3.38 PD=3.38
M$303 bias_a \$388 \$342 sky130_gnd sky130_fd_pr__nfet_01v8 L=0.6 W=1.4
+ AS=0.406 AD=0.406 PS=3.38 PD=3.38
M$304 bias_a \$388 \$342 sky130_gnd sky130_fd_pr__nfet_01v8 L=0.6 W=1.4
+ AS=0.406 AD=0.406 PS=3.38 PD=3.38
M$305 bias_a \$388 \$342 sky130_gnd sky130_fd_pr__nfet_01v8 L=0.6 W=1.4
+ AS=0.406 AD=0.406 PS=3.38 PD=3.38
M$306 bias_a \$388 \$342 sky130_gnd sky130_fd_pr__nfet_01v8 L=0.6 W=1.4
+ AS=0.406 AD=0.406 PS=3.38 PD=3.38
M$307 bias_a \$388 \$342 sky130_gnd sky130_fd_pr__nfet_01v8 L=0.6 W=1.4
+ AS=0.406 AD=0.406 PS=3.38 PD=3.38
M$308 bias_a \$388 \$342 sky130_gnd sky130_fd_pr__nfet_01v8 L=0.6 W=1.4
+ AS=0.406 AD=0.406 PS=3.38 PD=3.38
M$309 bias_a \$388 \$342 sky130_gnd sky130_fd_pr__nfet_01v8 L=0.6 W=1.4
+ AS=0.406 AD=0.406 PS=3.38 PD=3.38
M$310 bias_a \$388 \$342 sky130_gnd sky130_fd_pr__nfet_01v8 L=0.6 W=1.4
+ AS=0.406 AD=0.406 PS=3.38 PD=3.38
M$311 bias_a \$388 \$342 sky130_gnd sky130_fd_pr__nfet_01v8 L=0.6 W=1.4
+ AS=0.406 AD=0.406 PS=3.38 PD=3.38
M$312 bias_a \$388 \$342 sky130_gnd sky130_fd_pr__nfet_01v8 L=0.6 W=1.4
+ AS=0.406 AD=0.406 PS=3.38 PD=3.38
M$313 bias_a \$388 \$342 sky130_gnd sky130_fd_pr__nfet_01v8 L=0.6 W=1.4
+ AS=0.406 AD=0.406 PS=3.38 PD=3.38
M$314 bias_a \$388 \$342 sky130_gnd sky130_fd_pr__nfet_01v8 L=0.6 W=1.4
+ AS=0.406 AD=0.406 PS=3.38 PD=3.38
M$315 bias_a \$388 \$342 sky130_gnd sky130_fd_pr__nfet_01v8 L=0.6 W=1.4
+ AS=0.406 AD=0.406 PS=3.38 PD=3.38
M$316 bias_a \$388 \$342 sky130_gnd sky130_fd_pr__nfet_01v8 L=0.6 W=1.4
+ AS=0.406 AD=0.406 PS=3.38 PD=3.38
M$317 \$46.x1_net1 cm \$501 sky130_gnd sky130_fd_pr__nfet_01v8 L=0.6 W=1.4
+ AS=0.406 AD=0.406 PS=3.38 PD=3.38
M$318 VSS VSS VSS sky130_gnd sky130_fd_pr__nfet_01v8 L=0.6 W=1.4 AS=0.406
+ AD=0.406 PS=3.38 PD=3.38
M$319 VSS VSS VSS sky130_gnd sky130_fd_pr__nfet_01v8 L=0.6 W=1.4 AS=0.406
+ AD=0.406 PS=3.38 PD=3.38
M$320 cm cm \$46.x1_net1 sky130_gnd sky130_fd_pr__nfet_01v8 L=0.6 W=1.4
+ AS=0.406 AD=0.406 PS=3.38 PD=3.38
M$321 \$45.x1_net13 cm \$499 sky130_gnd sky130_fd_pr__nfet_01v8 L=0.6 W=1.4
+ AS=0.406 AD=0.406 PS=3.38 PD=3.38
M$322 VSS VSS VSS sky130_gnd sky130_fd_pr__nfet_01v8 L=0.6 W=1.4 AS=0.406
+ AD=0.406 PS=3.38 PD=3.38
M$323 VSS VSS VSS sky130_gnd sky130_fd_pr__nfet_01v8 L=0.6 W=1.4 AS=0.406
+ AD=0.406 PS=3.38 PD=3.38
M$324 cm cm \$45.x1_net13 sky130_gnd sky130_fd_pr__nfet_01v8 L=0.6 W=1.4
+ AS=0.406 AD=0.406 PS=3.38 PD=3.38
M$325 VSS VSS VSS sky130_gnd sky130_fd_pr__nfet_01v8 L=0.6 W=1.4 AS=0.406
+ AD=0.406 PS=3.38 PD=3.38
M$326 VSS VSS VSS sky130_gnd sky130_fd_pr__nfet_01v8 L=0.6 W=1.4 AS=0.406
+ AD=0.406 PS=3.38 PD=3.38
M$327 \$38.x1_net3 cm VSS sky130_gnd sky130_fd_pr__nfet_01v8 L=0.6 W=1.4
+ AS=0.406 AD=0.406 PS=3.38 PD=3.38
M$328 \$501 cm \$38.x1_net3 sky130_gnd sky130_fd_pr__nfet_01v8 L=0.6 W=1.4
+ AS=0.406 AD=0.406 PS=3.38 PD=3.38
M$329 VSS VSS VSS sky130_gnd sky130_fd_pr__nfet_01v8 L=0.6 W=1.4 AS=0.406
+ AD=0.406 PS=3.38 PD=3.38
M$330 VSS VSS VSS sky130_gnd sky130_fd_pr__nfet_01v8 L=0.6 W=1.4 AS=0.406
+ AD=0.406 PS=3.38 PD=3.38
M$331 \$37.x1_net15 cm VSS sky130_gnd sky130_fd_pr__nfet_01v8 L=0.6 W=1.4
+ AS=0.406 AD=0.406 PS=3.38 PD=3.38
M$332 \$499 cm \$37.x1_net15 sky130_gnd sky130_fd_pr__nfet_01v8 L=0.6 W=1.4
+ AS=0.406 AD=0.406 PS=3.38 PD=3.38
M$333 \$41.x1_net10 cm \$386 sky130_gnd sky130_fd_pr__nfet_01v8 L=0.6 W=1.4
+ AS=0.406 AD=0.406 PS=3.38 PD=3.38
M$334 VSS VSS VSS sky130_gnd sky130_fd_pr__nfet_01v8 L=0.6 W=1.4 AS=0.406
+ AD=0.406 PS=3.38 PD=3.38
M$335 VSS VSS VSS sky130_gnd sky130_fd_pr__nfet_01v8 L=0.6 W=1.4 AS=0.406
+ AD=0.406 PS=3.38 PD=3.38
M$336 cm cm \$41.x1_net10 sky130_gnd sky130_fd_pr__nfet_01v8 L=0.6 W=1.4
+ AS=0.406 AD=0.406 PS=3.38 PD=3.38
M$337 \$40.x1_net7 cm \$385 sky130_gnd sky130_fd_pr__nfet_01v8 L=0.6 W=1.4
+ AS=0.406 AD=0.406 PS=3.38 PD=3.38
M$338 VSS VSS VSS sky130_gnd sky130_fd_pr__nfet_01v8 L=0.6 W=1.4 AS=0.406
+ AD=0.406 PS=3.38 PD=3.38
M$339 VSS VSS VSS sky130_gnd sky130_fd_pr__nfet_01v8 L=0.6 W=1.4 AS=0.406
+ AD=0.406 PS=3.38 PD=3.38
M$340 cm cm \$40.x1_net7 sky130_gnd sky130_fd_pr__nfet_01v8 L=0.6 W=1.4
+ AS=0.406 AD=0.406 PS=3.38 PD=3.38
M$341 \$39.x1_net4 cm \$383 sky130_gnd sky130_fd_pr__nfet_01v8 L=0.6 W=1.4
+ AS=0.406 AD=0.406 PS=3.38 PD=3.38
M$342 VSS VSS VSS sky130_gnd sky130_fd_pr__nfet_01v8 L=0.6 W=1.4 AS=0.406
+ AD=0.406 PS=3.38 PD=3.38
M$343 VSS VSS VSS sky130_gnd sky130_fd_pr__nfet_01v8 L=0.6 W=1.4 AS=0.406
+ AD=0.406 PS=3.38 PD=3.38
M$344 cm cm \$39.x1_net4 sky130_gnd sky130_fd_pr__nfet_01v8 L=0.6 W=1.4
+ AS=0.406 AD=0.406 PS=3.38 PD=3.38
M$345 VSS VSS VSS sky130_gnd sky130_fd_pr__nfet_01v8 L=0.6 W=1.4 AS=0.406
+ AD=0.406 PS=3.38 PD=3.38
M$346 VSS VSS VSS sky130_gnd sky130_fd_pr__nfet_01v8 L=0.6 W=1.4 AS=0.406
+ AD=0.406 PS=3.38 PD=3.38
M$347 \$36.x1_net12 cm VSS sky130_gnd sky130_fd_pr__nfet_01v8 L=0.6 W=1.4
+ AS=0.406 AD=0.406 PS=3.38 PD=3.38
M$348 \$386 cm \$36.x1_net12 sky130_gnd sky130_fd_pr__nfet_01v8 L=0.6 W=1.4
+ AS=0.406 AD=0.406 PS=3.38 PD=3.38
M$349 VSS VSS VSS sky130_gnd sky130_fd_pr__nfet_01v8 L=0.6 W=1.4 AS=0.406
+ AD=0.406 PS=3.38 PD=3.38
M$350 VSS VSS VSS sky130_gnd sky130_fd_pr__nfet_01v8 L=0.6 W=1.4 AS=0.406
+ AD=0.406 PS=3.38 PD=3.38
M$351 \$25.x1_net9 cm VSS sky130_gnd sky130_fd_pr__nfet_01v8 L=0.6 W=1.4
+ AS=0.406 AD=0.406 PS=3.38 PD=3.38
M$352 \$385 cm \$25.x1_net9 sky130_gnd sky130_fd_pr__nfet_01v8 L=0.6 W=1.4
+ AS=0.406 AD=0.406 PS=3.38 PD=3.38
M$353 VSS VSS VSS sky130_gnd sky130_fd_pr__nfet_01v8 L=0.6 W=1.4 AS=0.406
+ AD=0.406 PS=3.38 PD=3.38
M$354 VSS VSS VSS sky130_gnd sky130_fd_pr__nfet_01v8 L=0.6 W=1.4 AS=0.406
+ AD=0.406 PS=3.38 PD=3.38
M$355 \$22.x1_net6 cm VSS sky130_gnd sky130_fd_pr__nfet_01v8 L=0.6 W=1.4
+ AS=0.406 AD=0.406 PS=3.38 PD=3.38
M$356 \$383 cm \$22.x1_net6 sky130_gnd sky130_fd_pr__nfet_01v8 L=0.6 W=1.4
+ AS=0.406 AD=0.406 PS=3.38 PD=3.38
M$357 on \$388 \$148 sky130_gnd sky130_fd_pr__nfet_01v8 L=0.6 W=1.4 AS=0.406
+ AD=0.406 PS=3.38 PD=3.38
M$358 on \$388 \$148 sky130_gnd sky130_fd_pr__nfet_01v8 L=0.6 W=1.4 AS=0.406
+ AD=0.406 PS=3.38 PD=3.38
M$359 on \$388 \$148 sky130_gnd sky130_fd_pr__nfet_01v8 L=0.6 W=1.4 AS=0.406
+ AD=0.406 PS=3.38 PD=3.38
M$360 on \$388 \$148 sky130_gnd sky130_fd_pr__nfet_01v8 L=0.6 W=1.4 AS=0.406
+ AD=0.406 PS=3.38 PD=3.38
M$361 on \$388 \$148 sky130_gnd sky130_fd_pr__nfet_01v8 L=0.6 W=1.4 AS=0.406
+ AD=0.406 PS=3.38 PD=3.38
M$362 on \$388 \$148 sky130_gnd sky130_fd_pr__nfet_01v8 L=0.6 W=1.4 AS=0.406
+ AD=0.406 PS=3.38 PD=3.38
M$363 on \$388 \$148 sky130_gnd sky130_fd_pr__nfet_01v8 L=0.6 W=1.4 AS=0.406
+ AD=0.406 PS=3.38 PD=3.38
M$364 on \$388 \$148 sky130_gnd sky130_fd_pr__nfet_01v8 L=0.6 W=1.4 AS=0.406
+ AD=0.406 PS=3.38 PD=3.38
M$365 on \$388 \$148 sky130_gnd sky130_fd_pr__nfet_01v8 L=0.6 W=1.4 AS=0.406
+ AD=0.406 PS=3.38 PD=3.38
M$366 on \$388 \$148 sky130_gnd sky130_fd_pr__nfet_01v8 L=0.6 W=1.4 AS=0.406
+ AD=0.406 PS=3.38 PD=3.38
M$367 on \$388 \$148 sky130_gnd sky130_fd_pr__nfet_01v8 L=0.6 W=1.4 AS=0.406
+ AD=0.406 PS=3.38 PD=3.38
M$368 on \$388 \$148 sky130_gnd sky130_fd_pr__nfet_01v8 L=0.6 W=1.4 AS=0.406
+ AD=0.406 PS=3.38 PD=3.38
M$369 on \$388 \$148 sky130_gnd sky130_fd_pr__nfet_01v8 L=0.6 W=1.4 AS=0.406
+ AD=0.406 PS=3.38 PD=3.38
M$370 on \$388 \$148 sky130_gnd sky130_fd_pr__nfet_01v8 L=0.6 W=1.4 AS=0.406
+ AD=0.406 PS=3.38 PD=3.38
M$371 on \$388 \$148 sky130_gnd sky130_fd_pr__nfet_01v8 L=0.6 W=1.4 AS=0.406
+ AD=0.406 PS=3.38 PD=3.38
M$372 on \$388 \$148 sky130_gnd sky130_fd_pr__nfet_01v8 L=0.6 W=1.4 AS=0.406
+ AD=0.406 PS=3.38 PD=3.38
M$373 on \$388 \$148 sky130_gnd sky130_fd_pr__nfet_01v8 L=0.6 W=1.4 AS=0.406
+ AD=0.406 PS=3.38 PD=3.38
M$374 on \$388 \$148 sky130_gnd sky130_fd_pr__nfet_01v8 L=0.6 W=1.4 AS=0.406
+ AD=0.406 PS=3.38 PD=3.38
M$375 on \$388 \$148 sky130_gnd sky130_fd_pr__nfet_01v8 L=0.6 W=1.4 AS=0.406
+ AD=0.406 PS=3.38 PD=3.38
M$376 on \$388 \$148 sky130_gnd sky130_fd_pr__nfet_01v8 L=0.6 W=1.4 AS=0.406
+ AD=0.406 PS=3.38 PD=3.38
M$377 on \$388 \$148 sky130_gnd sky130_fd_pr__nfet_01v8 L=0.6 W=1.4 AS=0.406
+ AD=0.406 PS=3.38 PD=3.38
M$378 on \$388 \$148 sky130_gnd sky130_fd_pr__nfet_01v8 L=0.6 W=1.4 AS=0.406
+ AD=0.406 PS=3.38 PD=3.38
M$379 on \$388 \$148 sky130_gnd sky130_fd_pr__nfet_01v8 L=0.6 W=1.4 AS=0.406
+ AD=0.406 PS=3.38 PD=3.38
M$380 on \$388 \$148 sky130_gnd sky130_fd_pr__nfet_01v8 L=0.6 W=1.4 AS=0.406
+ AD=0.406 PS=3.38 PD=3.38
M$381 on \$388 \$148 sky130_gnd sky130_fd_pr__nfet_01v8 L=0.6 W=1.4 AS=0.406
+ AD=0.406 PS=3.38 PD=3.38
M$382 on \$388 \$148 sky130_gnd sky130_fd_pr__nfet_01v8 L=0.6 W=1.4 AS=0.406
+ AD=0.406 PS=3.38 PD=3.38
M$383 on \$388 \$148 sky130_gnd sky130_fd_pr__nfet_01v8 L=0.6 W=1.4 AS=0.406
+ AD=0.406 PS=3.38 PD=3.38
M$384 on \$388 \$148 sky130_gnd sky130_fd_pr__nfet_01v8 L=0.6 W=1.4 AS=0.406
+ AD=0.406 PS=3.38 PD=3.38
M$385 on \$388 \$148 sky130_gnd sky130_fd_pr__nfet_01v8 L=0.6 W=1.4 AS=0.406
+ AD=0.406 PS=3.38 PD=3.38
M$386 on \$388 \$148 sky130_gnd sky130_fd_pr__nfet_01v8 L=0.6 W=1.4 AS=0.406
+ AD=0.406 PS=3.38 PD=3.38
M$387 on \$388 \$148 sky130_gnd sky130_fd_pr__nfet_01v8 L=0.6 W=1.4 AS=0.406
+ AD=0.406 PS=3.38 PD=3.38
M$388 on \$388 \$148 sky130_gnd sky130_fd_pr__nfet_01v8 L=0.6 W=1.4 AS=0.406
+ AD=0.406 PS=3.38 PD=3.38
M$389 on \$388 \$148 sky130_gnd sky130_fd_pr__nfet_01v8 L=0.6 W=1.4 AS=0.406
+ AD=0.406 PS=3.38 PD=3.38
M$390 on \$388 \$148 sky130_gnd sky130_fd_pr__nfet_01v8 L=0.6 W=1.4 AS=0.406
+ AD=0.406 PS=3.38 PD=3.38
M$391 on \$388 \$148 sky130_gnd sky130_fd_pr__nfet_01v8 L=0.6 W=1.4 AS=0.406
+ AD=0.406 PS=3.38 PD=3.38
M$392 on \$388 \$148 sky130_gnd sky130_fd_pr__nfet_01v8 L=0.6 W=1.4 AS=0.406
+ AD=0.406 PS=3.38 PD=3.38
M$393 op \$388 \$149 sky130_gnd sky130_fd_pr__nfet_01v8 L=0.6 W=1.4 AS=0.406
+ AD=0.406 PS=3.38 PD=3.38
M$394 op \$388 \$149 sky130_gnd sky130_fd_pr__nfet_01v8 L=0.6 W=1.4 AS=0.406
+ AD=0.406 PS=3.38 PD=3.38
M$395 op \$388 \$149 sky130_gnd sky130_fd_pr__nfet_01v8 L=0.6 W=1.4 AS=0.406
+ AD=0.406 PS=3.38 PD=3.38
M$396 op \$388 \$149 sky130_gnd sky130_fd_pr__nfet_01v8 L=0.6 W=1.4 AS=0.406
+ AD=0.406 PS=3.38 PD=3.38
M$397 op \$388 \$149 sky130_gnd sky130_fd_pr__nfet_01v8 L=0.6 W=1.4 AS=0.406
+ AD=0.406 PS=3.38 PD=3.38
M$398 op \$388 \$149 sky130_gnd sky130_fd_pr__nfet_01v8 L=0.6 W=1.4 AS=0.406
+ AD=0.406 PS=3.38 PD=3.38
M$399 op \$388 \$149 sky130_gnd sky130_fd_pr__nfet_01v8 L=0.6 W=1.4 AS=0.406
+ AD=0.406 PS=3.38 PD=3.38
M$400 op \$388 \$149 sky130_gnd sky130_fd_pr__nfet_01v8 L=0.6 W=1.4 AS=0.406
+ AD=0.406 PS=3.38 PD=3.38
M$401 op \$388 \$149 sky130_gnd sky130_fd_pr__nfet_01v8 L=0.6 W=1.4 AS=0.406
+ AD=0.406 PS=3.38 PD=3.38
M$402 op \$388 \$149 sky130_gnd sky130_fd_pr__nfet_01v8 L=0.6 W=1.4 AS=0.406
+ AD=0.406 PS=3.38 PD=3.38
M$403 op \$388 \$149 sky130_gnd sky130_fd_pr__nfet_01v8 L=0.6 W=1.4 AS=0.406
+ AD=0.406 PS=3.38 PD=3.38
M$404 op \$388 \$149 sky130_gnd sky130_fd_pr__nfet_01v8 L=0.6 W=1.4 AS=0.406
+ AD=0.406 PS=3.38 PD=3.38
M$405 op \$388 \$149 sky130_gnd sky130_fd_pr__nfet_01v8 L=0.6 W=1.4 AS=0.406
+ AD=0.406 PS=3.38 PD=3.38
M$406 op \$388 \$149 sky130_gnd sky130_fd_pr__nfet_01v8 L=0.6 W=1.4 AS=0.406
+ AD=0.406 PS=3.38 PD=3.38
M$407 op \$388 \$149 sky130_gnd sky130_fd_pr__nfet_01v8 L=0.6 W=1.4 AS=0.406
+ AD=0.406 PS=3.38 PD=3.38
M$408 op \$388 \$149 sky130_gnd sky130_fd_pr__nfet_01v8 L=0.6 W=1.4 AS=0.406
+ AD=0.406 PS=3.38 PD=3.38
M$409 op \$388 \$149 sky130_gnd sky130_fd_pr__nfet_01v8 L=0.6 W=1.4 AS=0.406
+ AD=0.406 PS=3.38 PD=3.38
M$410 op \$388 \$149 sky130_gnd sky130_fd_pr__nfet_01v8 L=0.6 W=1.4 AS=0.406
+ AD=0.406 PS=3.38 PD=3.38
M$411 op \$388 \$149 sky130_gnd sky130_fd_pr__nfet_01v8 L=0.6 W=1.4 AS=0.406
+ AD=0.406 PS=3.38 PD=3.38
M$412 op \$388 \$149 sky130_gnd sky130_fd_pr__nfet_01v8 L=0.6 W=1.4 AS=0.406
+ AD=0.406 PS=3.38 PD=3.38
M$413 op \$388 \$149 sky130_gnd sky130_fd_pr__nfet_01v8 L=0.6 W=1.4 AS=0.406
+ AD=0.406 PS=3.38 PD=3.38
M$414 op \$388 \$149 sky130_gnd sky130_fd_pr__nfet_01v8 L=0.6 W=1.4 AS=0.406
+ AD=0.406 PS=3.38 PD=3.38
M$415 op \$388 \$149 sky130_gnd sky130_fd_pr__nfet_01v8 L=0.6 W=1.4 AS=0.406
+ AD=0.406 PS=3.38 PD=3.38
M$416 op \$388 \$149 sky130_gnd sky130_fd_pr__nfet_01v8 L=0.6 W=1.4 AS=0.406
+ AD=0.406 PS=3.38 PD=3.38
M$417 op \$388 \$149 sky130_gnd sky130_fd_pr__nfet_01v8 L=0.6 W=1.4 AS=0.406
+ AD=0.406 PS=3.38 PD=3.38
M$418 op \$388 \$149 sky130_gnd sky130_fd_pr__nfet_01v8 L=0.6 W=1.4 AS=0.406
+ AD=0.406 PS=3.38 PD=3.38
M$419 op \$388 \$149 sky130_gnd sky130_fd_pr__nfet_01v8 L=0.6 W=1.4 AS=0.406
+ AD=0.406 PS=3.38 PD=3.38
M$420 op \$388 \$149 sky130_gnd sky130_fd_pr__nfet_01v8 L=0.6 W=1.4 AS=0.406
+ AD=0.406 PS=3.38 PD=3.38
M$421 op \$388 \$149 sky130_gnd sky130_fd_pr__nfet_01v8 L=0.6 W=1.4 AS=0.406
+ AD=0.406 PS=3.38 PD=3.38
M$422 op \$388 \$149 sky130_gnd sky130_fd_pr__nfet_01v8 L=0.6 W=1.4 AS=0.406
+ AD=0.406 PS=3.38 PD=3.38
M$423 op \$388 \$149 sky130_gnd sky130_fd_pr__nfet_01v8 L=0.6 W=1.4 AS=0.406
+ AD=0.406 PS=3.38 PD=3.38
M$424 op \$388 \$149 sky130_gnd sky130_fd_pr__nfet_01v8 L=0.6 W=1.4 AS=0.406
+ AD=0.406 PS=3.38 PD=3.38
M$425 op \$388 \$149 sky130_gnd sky130_fd_pr__nfet_01v8 L=0.6 W=1.4 AS=0.406
+ AD=0.406 PS=3.38 PD=3.38
M$426 op \$388 \$149 sky130_gnd sky130_fd_pr__nfet_01v8 L=0.6 W=1.4 AS=0.406
+ AD=0.406 PS=3.38 PD=3.38
M$427 op \$388 \$149 sky130_gnd sky130_fd_pr__nfet_01v8 L=0.6 W=1.4 AS=0.406
+ AD=0.406 PS=3.38 PD=3.38
M$428 op \$388 \$149 sky130_gnd sky130_fd_pr__nfet_01v8 L=0.6 W=1.4 AS=0.406
+ AD=0.406 PS=3.38 PD=3.38
M$429 VSS VSS VSS sky130_gnd sky130_fd_pr__nfet_01v8 L=0.6 W=1.4 AS=0.406
+ AD=0.406 PS=3.38 PD=3.38
M$430 VSS VSS VSS sky130_gnd sky130_fd_pr__nfet_01v8 L=0.6 W=1.4 AS=0.406
+ AD=0.406 PS=3.38 PD=3.38
M$431 \$149 bias_a VSS sky130_gnd sky130_fd_pr__nfet_01v8 L=0.6 W=1.4 AS=0.406
+ AD=0.406 PS=3.38 PD=3.38
M$432 \$148 bias_a VSS sky130_gnd sky130_fd_pr__nfet_01v8 L=0.6 W=1.4 AS=0.406
+ AD=0.406 PS=3.38 PD=3.38
M$433 \$149 bias_a VSS sky130_gnd sky130_fd_pr__nfet_01v8 L=0.6 W=1.4 AS=0.406
+ AD=0.406 PS=3.38 PD=3.38
M$434 \$148 bias_a VSS sky130_gnd sky130_fd_pr__nfet_01v8 L=0.6 W=1.4 AS=0.406
+ AD=0.406 PS=3.38 PD=3.38
M$435 \$149 bias_a VSS sky130_gnd sky130_fd_pr__nfet_01v8 L=0.6 W=1.4 AS=0.406
+ AD=0.406 PS=3.38 PD=3.38
M$436 \$148 bias_a VSS sky130_gnd sky130_fd_pr__nfet_01v8 L=0.6 W=1.4 AS=0.406
+ AD=0.406 PS=3.38 PD=3.38
M$437 \$149 bias_a VSS sky130_gnd sky130_fd_pr__nfet_01v8 L=0.6 W=1.4 AS=0.406
+ AD=0.406 PS=3.38 PD=3.38
M$438 \$148 bias_a VSS sky130_gnd sky130_fd_pr__nfet_01v8 L=0.6 W=1.4 AS=0.406
+ AD=0.406 PS=3.38 PD=3.38
M$439 VSS VSS VSS sky130_gnd sky130_fd_pr__nfet_01v8 L=0.6 W=1.4 AS=0.406
+ AD=0.406 PS=3.38 PD=3.38
M$440 \$148 bias_a VSS sky130_gnd sky130_fd_pr__nfet_01v8 L=0.6 W=1.4 AS=0.406
+ AD=0.406 PS=3.38 PD=3.38
M$441 \$149 bias_a VSS sky130_gnd sky130_fd_pr__nfet_01v8 L=0.6 W=1.4 AS=0.406
+ AD=0.406 PS=3.38 PD=3.38
M$442 \$148 bias_a VSS sky130_gnd sky130_fd_pr__nfet_01v8 L=0.6 W=1.4 AS=0.406
+ AD=0.406 PS=3.38 PD=3.38
M$443 \$149 bias_a VSS sky130_gnd sky130_fd_pr__nfet_01v8 L=0.6 W=1.4 AS=0.406
+ AD=0.406 PS=3.38 PD=3.38
M$444 \$148 bias_a VSS sky130_gnd sky130_fd_pr__nfet_01v8 L=0.6 W=1.4 AS=0.406
+ AD=0.406 PS=3.38 PD=3.38
M$445 \$149 bias_a VSS sky130_gnd sky130_fd_pr__nfet_01v8 L=0.6 W=1.4 AS=0.406
+ AD=0.406 PS=3.38 PD=3.38
M$446 \$148 bias_a VSS sky130_gnd sky130_fd_pr__nfet_01v8 L=0.6 W=1.4 AS=0.406
+ AD=0.406 PS=3.38 PD=3.38
M$447 \$149 bias_a VSS sky130_gnd sky130_fd_pr__nfet_01v8 L=0.6 W=1.4 AS=0.406
+ AD=0.406 PS=3.38 PD=3.38
M$448 \$149 bias_a VSS sky130_gnd sky130_fd_pr__nfet_01v8 L=0.6 W=1.4 AS=0.406
+ AD=0.406 PS=3.38 PD=3.38
M$449 \$148 bias_a VSS sky130_gnd sky130_fd_pr__nfet_01v8 L=0.6 W=1.4 AS=0.406
+ AD=0.406 PS=3.38 PD=3.38
M$450 \$149 bias_a VSS sky130_gnd sky130_fd_pr__nfet_01v8 L=0.6 W=1.4 AS=0.406
+ AD=0.406 PS=3.38 PD=3.38
M$451 \$148 bias_a VSS sky130_gnd sky130_fd_pr__nfet_01v8 L=0.6 W=1.4 AS=0.406
+ AD=0.406 PS=3.38 PD=3.38
M$452 \$149 bias_a VSS sky130_gnd sky130_fd_pr__nfet_01v8 L=0.6 W=1.4 AS=0.406
+ AD=0.406 PS=3.38 PD=3.38
M$453 \$148 bias_a VSS sky130_gnd sky130_fd_pr__nfet_01v8 L=0.6 W=1.4 AS=0.406
+ AD=0.406 PS=3.38 PD=3.38
M$454 \$149 bias_a VSS sky130_gnd sky130_fd_pr__nfet_01v8 L=0.6 W=1.4 AS=0.406
+ AD=0.406 PS=3.38 PD=3.38
M$455 \$148 bias_a VSS sky130_gnd sky130_fd_pr__nfet_01v8 L=0.6 W=1.4 AS=0.406
+ AD=0.406 PS=3.38 PD=3.38
M$456 \$149 bias_a VSS sky130_gnd sky130_fd_pr__nfet_01v8 L=0.6 W=1.4 AS=0.406
+ AD=0.406 PS=3.38 PD=3.38
M$457 \$148 bias_a VSS sky130_gnd sky130_fd_pr__nfet_01v8 L=0.6 W=1.4 AS=0.406
+ AD=0.406 PS=3.38 PD=3.38
M$458 \$149 bias_a VSS sky130_gnd sky130_fd_pr__nfet_01v8 L=0.6 W=1.4 AS=0.406
+ AD=0.406 PS=3.38 PD=3.38
M$459 \$148 bias_a VSS sky130_gnd sky130_fd_pr__nfet_01v8 L=0.6 W=1.4 AS=0.406
+ AD=0.406 PS=3.38 PD=3.38
M$460 \$149 bias_a VSS sky130_gnd sky130_fd_pr__nfet_01v8 L=0.6 W=1.4 AS=0.406
+ AD=0.406 PS=3.38 PD=3.38
M$461 \$148 bias_a VSS sky130_gnd sky130_fd_pr__nfet_01v8 L=0.6 W=1.4 AS=0.406
+ AD=0.406 PS=3.38 PD=3.38
M$462 \$149 bias_a VSS sky130_gnd sky130_fd_pr__nfet_01v8 L=0.6 W=1.4 AS=0.406
+ AD=0.406 PS=3.38 PD=3.38
M$463 \$148 bias_a VSS sky130_gnd sky130_fd_pr__nfet_01v8 L=0.6 W=1.4 AS=0.406
+ AD=0.406 PS=3.38 PD=3.38
M$464 \$149 bias_a VSS sky130_gnd sky130_fd_pr__nfet_01v8 L=0.6 W=1.4 AS=0.406
+ AD=0.406 PS=3.38 PD=3.38
M$465 \$148 bias_a VSS sky130_gnd sky130_fd_pr__nfet_01v8 L=0.6 W=1.4 AS=0.406
+ AD=0.406 PS=3.38 PD=3.38
M$466 \$149 bias_a VSS sky130_gnd sky130_fd_pr__nfet_01v8 L=0.6 W=1.4 AS=0.406
+ AD=0.406 PS=3.38 PD=3.38
M$467 \$148 bias_a VSS sky130_gnd sky130_fd_pr__nfet_01v8 L=0.6 W=1.4 AS=0.406
+ AD=0.406 PS=3.38 PD=3.38
M$468 \$148 bias_a VSS sky130_gnd sky130_fd_pr__nfet_01v8 L=0.6 W=1.4 AS=0.406
+ AD=0.406 PS=3.38 PD=3.38
M$469 \$149 bias_a VSS sky130_gnd sky130_fd_pr__nfet_01v8 L=0.6 W=1.4 AS=0.406
+ AD=0.406 PS=3.38 PD=3.38
M$470 \$148 bias_a VSS sky130_gnd sky130_fd_pr__nfet_01v8 L=0.6 W=1.4 AS=0.406
+ AD=0.406 PS=3.38 PD=3.38
M$471 \$149 bias_a VSS sky130_gnd sky130_fd_pr__nfet_01v8 L=0.6 W=1.4 AS=0.406
+ AD=0.406 PS=3.38 PD=3.38
M$472 \$148 bias_a VSS sky130_gnd sky130_fd_pr__nfet_01v8 L=0.6 W=1.4 AS=0.406
+ AD=0.406 PS=3.38 PD=3.38
M$473 \$149 bias_a VSS sky130_gnd sky130_fd_pr__nfet_01v8 L=0.6 W=1.4 AS=0.406
+ AD=0.406 PS=3.38 PD=3.38
M$474 \$148 bias_a VSS sky130_gnd sky130_fd_pr__nfet_01v8 L=0.6 W=1.4 AS=0.406
+ AD=0.406 PS=3.38 PD=3.38
M$475 \$149 bias_a VSS sky130_gnd sky130_fd_pr__nfet_01v8 L=0.6 W=1.4 AS=0.406
+ AD=0.406 PS=3.38 PD=3.38
M$476 \$148 bias_a VSS sky130_gnd sky130_fd_pr__nfet_01v8 L=0.6 W=1.4 AS=0.406
+ AD=0.406 PS=3.38 PD=3.38
M$477 \$149 bias_a VSS sky130_gnd sky130_fd_pr__nfet_01v8 L=0.6 W=1.4 AS=0.406
+ AD=0.406 PS=3.38 PD=3.38
M$478 \$148 bias_a VSS sky130_gnd sky130_fd_pr__nfet_01v8 L=0.6 W=1.4 AS=0.406
+ AD=0.406 PS=3.38 PD=3.38
M$479 \$149 bias_a VSS sky130_gnd sky130_fd_pr__nfet_01v8 L=0.6 W=1.4 AS=0.406
+ AD=0.406 PS=3.38 PD=3.38
M$480 \$148 bias_a VSS sky130_gnd sky130_fd_pr__nfet_01v8 L=0.6 W=1.4 AS=0.406
+ AD=0.406 PS=3.38 PD=3.38
M$481 \$149 bias_a VSS sky130_gnd sky130_fd_pr__nfet_01v8 L=0.6 W=1.4 AS=0.406
+ AD=0.406 PS=3.38 PD=3.38
M$482 \$148 bias_a VSS sky130_gnd sky130_fd_pr__nfet_01v8 L=0.6 W=1.4 AS=0.406
+ AD=0.406 PS=3.38 PD=3.38
M$483 \$149 bias_a VSS sky130_gnd sky130_fd_pr__nfet_01v8 L=0.6 W=1.4 AS=0.406
+ AD=0.406 PS=3.38 PD=3.38
M$484 VSS VSS VSS sky130_gnd sky130_fd_pr__nfet_01v8 L=0.6 W=1.4 AS=0.406
+ AD=0.406 PS=3.38 PD=3.38
M$485 \$148 bias_a VSS sky130_gnd sky130_fd_pr__nfet_01v8 L=0.6 W=1.4 AS=0.406
+ AD=0.406 PS=3.38 PD=3.38
M$486 \$149 bias_a VSS sky130_gnd sky130_fd_pr__nfet_01v8 L=0.6 W=1.4 AS=0.406
+ AD=0.406 PS=3.38 PD=3.38
M$487 \$148 bias_a VSS sky130_gnd sky130_fd_pr__nfet_01v8 L=0.6 W=1.4 AS=0.406
+ AD=0.406 PS=3.38 PD=3.38
M$488 \$149 bias_a VSS sky130_gnd sky130_fd_pr__nfet_01v8 L=0.6 W=1.4 AS=0.406
+ AD=0.406 PS=3.38 PD=3.38
M$489 \$148 bias_a VSS sky130_gnd sky130_fd_pr__nfet_01v8 L=0.6 W=1.4 AS=0.406
+ AD=0.406 PS=3.38 PD=3.38
M$490 \$149 bias_a VSS sky130_gnd sky130_fd_pr__nfet_01v8 L=0.6 W=1.4 AS=0.406
+ AD=0.406 PS=3.38 PD=3.38
M$491 \$148 bias_a VSS sky130_gnd sky130_fd_pr__nfet_01v8 L=0.6 W=1.4 AS=0.406
+ AD=0.406 PS=3.38 PD=3.38
M$492 \$149 bias_a VSS sky130_gnd sky130_fd_pr__nfet_01v8 L=0.6 W=1.4 AS=0.406
+ AD=0.406 PS=3.38 PD=3.38
M$493 \$148 bias_a VSS sky130_gnd sky130_fd_pr__nfet_01v8 L=0.6 W=1.4 AS=0.406
+ AD=0.406 PS=3.38 PD=3.38
M$494 \$149 bias_a VSS sky130_gnd sky130_fd_pr__nfet_01v8 L=0.6 W=1.4 AS=0.406
+ AD=0.406 PS=3.38 PD=3.38
M$495 \$148 bias_a VSS sky130_gnd sky130_fd_pr__nfet_01v8 L=0.6 W=1.4 AS=0.406
+ AD=0.406 PS=3.38 PD=3.38
M$496 \$149 bias_a VSS sky130_gnd sky130_fd_pr__nfet_01v8 L=0.6 W=1.4 AS=0.406
+ AD=0.406 PS=3.38 PD=3.38
M$497 \$148 bias_a VSS sky130_gnd sky130_fd_pr__nfet_01v8 L=0.6 W=1.4 AS=0.406
+ AD=0.406 PS=3.38 PD=3.38
M$498 \$149 bias_a VSS sky130_gnd sky130_fd_pr__nfet_01v8 L=0.6 W=1.4 AS=0.406
+ AD=0.406 PS=3.38 PD=3.38
M$499 \$148 bias_a VSS sky130_gnd sky130_fd_pr__nfet_01v8 L=0.6 W=1.4 AS=0.406
+ AD=0.406 PS=3.38 PD=3.38
M$500 \$149 bias_a VSS sky130_gnd sky130_fd_pr__nfet_01v8 L=0.6 W=1.4 AS=0.406
+ AD=0.406 PS=3.38 PD=3.38
M$501 \$148 bias_a VSS sky130_gnd sky130_fd_pr__nfet_01v8 L=0.6 W=1.4 AS=0.406
+ AD=0.406 PS=3.38 PD=3.38
M$502 \$149 bias_a VSS sky130_gnd sky130_fd_pr__nfet_01v8 L=0.6 W=1.4 AS=0.406
+ AD=0.406 PS=3.38 PD=3.38
M$503 \$148 bias_a VSS sky130_gnd sky130_fd_pr__nfet_01v8 L=0.6 W=1.4 AS=0.406
+ AD=0.406 PS=3.38 PD=3.38
M$504 \$149 bias_a VSS sky130_gnd sky130_fd_pr__nfet_01v8 L=0.6 W=1.4 AS=0.406
+ AD=0.406 PS=3.38 PD=3.38
M$505 \$61 bias_a VSS sky130_gnd sky130_fd_pr__nfet_01v8 L=0.6 W=1.4 AS=0.406
+ AD=0.406 PS=3.38 PD=3.38
M$506 \$61 bias_a VSS sky130_gnd sky130_fd_pr__nfet_01v8 L=0.6 W=1.4 AS=0.406
+ AD=0.406 PS=3.38 PD=3.38
M$507 \$61 bias_a VSS sky130_gnd sky130_fd_pr__nfet_01v8 L=0.6 W=1.4 AS=0.406
+ AD=0.406 PS=3.38 PD=3.38
M$508 \$61 bias_a VSS sky130_gnd sky130_fd_pr__nfet_01v8 L=0.6 W=1.4 AS=0.406
+ AD=0.406 PS=3.38 PD=3.38
M$509 \$61 bias_a VSS sky130_gnd sky130_fd_pr__nfet_01v8 L=0.6 W=1.4 AS=0.406
+ AD=0.406 PS=3.38 PD=3.38
M$510 \$61 bias_a VSS sky130_gnd sky130_fd_pr__nfet_01v8 L=0.6 W=1.4 AS=0.406
+ AD=0.406 PS=3.38 PD=3.38
M$511 \$61 bias_a VSS sky130_gnd sky130_fd_pr__nfet_01v8 L=0.6 W=1.4 AS=0.406
+ AD=0.406 PS=3.38 PD=3.38
M$512 \$61 bias_a VSS sky130_gnd sky130_fd_pr__nfet_01v8 L=0.6 W=1.4 AS=0.406
+ AD=0.406 PS=3.38 PD=3.38
M$513 \$61 bias_a VSS sky130_gnd sky130_fd_pr__nfet_01v8 L=0.6 W=1.4 AS=0.406
+ AD=0.406 PS=3.38 PD=3.38
M$514 \$61 bias_a VSS sky130_gnd sky130_fd_pr__nfet_01v8 L=0.6 W=1.4 AS=0.406
+ AD=0.406 PS=3.38 PD=3.38
M$515 \$61 bias_a VSS sky130_gnd sky130_fd_pr__nfet_01v8 L=0.6 W=1.4 AS=0.406
+ AD=0.406 PS=3.38 PD=3.38
M$516 \$61 bias_a VSS sky130_gnd sky130_fd_pr__nfet_01v8 L=0.6 W=1.4 AS=0.406
+ AD=0.406 PS=3.38 PD=3.38
M$517 \$61 bias_a VSS sky130_gnd sky130_fd_pr__nfet_01v8 L=0.6 W=1.4 AS=0.406
+ AD=0.406 PS=3.38 PD=3.38
M$518 \$61 bias_a VSS sky130_gnd sky130_fd_pr__nfet_01v8 L=0.6 W=1.4 AS=0.406
+ AD=0.406 PS=3.38 PD=3.38
M$519 \$61 bias_a VSS sky130_gnd sky130_fd_pr__nfet_01v8 L=0.6 W=1.4 AS=0.406
+ AD=0.406 PS=3.38 PD=3.38
M$520 \$61 bias_a VSS sky130_gnd sky130_fd_pr__nfet_01v8 L=0.6 W=1.4 AS=0.406
+ AD=0.406 PS=3.38 PD=3.38
M$521 \$61 bias_a VSS sky130_gnd sky130_fd_pr__nfet_01v8 L=0.6 W=1.4 AS=0.406
+ AD=0.406 PS=3.38 PD=3.38
M$522 \$61 bias_a VSS sky130_gnd sky130_fd_pr__nfet_01v8 L=0.6 W=1.4 AS=0.406
+ AD=0.406 PS=3.38 PD=3.38
M$523 \$61 bias_a VSS sky130_gnd sky130_fd_pr__nfet_01v8 L=0.6 W=1.4 AS=0.406
+ AD=0.406 PS=3.38 PD=3.38
M$524 \$61 bias_a VSS sky130_gnd sky130_fd_pr__nfet_01v8 L=0.6 W=1.4 AS=0.406
+ AD=0.406 PS=3.38 PD=3.38
M$525 \$61 bias_a VSS sky130_gnd sky130_fd_pr__nfet_01v8 L=0.6 W=1.4 AS=0.406
+ AD=0.406 PS=3.38 PD=3.38
M$526 \$61 bias_a VSS sky130_gnd sky130_fd_pr__nfet_01v8 L=0.6 W=1.4 AS=0.406
+ AD=0.406 PS=3.38 PD=3.38
M$527 \$61 bias_a VSS sky130_gnd sky130_fd_pr__nfet_01v8 L=0.6 W=1.4 AS=0.406
+ AD=0.406 PS=3.38 PD=3.38
M$528 \$61 bias_a VSS sky130_gnd sky130_fd_pr__nfet_01v8 L=0.6 W=1.4 AS=0.406
+ AD=0.406 PS=3.38 PD=3.38
M$529 \$61 bias_a VSS sky130_gnd sky130_fd_pr__nfet_01v8 L=0.6 W=1.4 AS=0.406
+ AD=0.406 PS=3.38 PD=3.38
M$530 \$61 bias_a VSS sky130_gnd sky130_fd_pr__nfet_01v8 L=0.6 W=1.4 AS=0.406
+ AD=0.406 PS=3.38 PD=3.38
M$531 \$61 bias_a VSS sky130_gnd sky130_fd_pr__nfet_01v8 L=0.6 W=1.4 AS=0.406
+ AD=0.406 PS=3.38 PD=3.38
M$532 \$61 bias_a VSS sky130_gnd sky130_fd_pr__nfet_01v8 L=0.6 W=1.4 AS=0.406
+ AD=0.406 PS=3.38 PD=3.38
M$533 \$61 bias_a VSS sky130_gnd sky130_fd_pr__nfet_01v8 L=0.6 W=1.4 AS=0.406
+ AD=0.406 PS=3.38 PD=3.38
M$534 \$61 bias_a VSS sky130_gnd sky130_fd_pr__nfet_01v8 L=0.6 W=1.4 AS=0.406
+ AD=0.406 PS=3.38 PD=3.38
M$535 \$61 bias_a VSS sky130_gnd sky130_fd_pr__nfet_01v8 L=0.6 W=1.4 AS=0.406
+ AD=0.406 PS=3.38 PD=3.38
M$536 \$61 bias_a VSS sky130_gnd sky130_fd_pr__nfet_01v8 L=0.6 W=1.4 AS=0.406
+ AD=0.406 PS=3.38 PD=3.38
M$537 \$61 bias_a VSS sky130_gnd sky130_fd_pr__nfet_01v8 L=0.6 W=1.4 AS=0.406
+ AD=0.406 PS=3.38 PD=3.38
M$538 \$61 bias_a VSS sky130_gnd sky130_fd_pr__nfet_01v8 L=0.6 W=1.4 AS=0.406
+ AD=0.406 PS=3.38 PD=3.38
M$539 \$61 bias_a VSS sky130_gnd sky130_fd_pr__nfet_01v8 L=0.6 W=1.4 AS=0.406
+ AD=0.406 PS=3.38 PD=3.38
M$540 \$61 bias_a VSS sky130_gnd sky130_fd_pr__nfet_01v8 L=0.6 W=1.4 AS=0.406
+ AD=0.406 PS=3.38 PD=3.38
M$541 \$61 bias_a VSS sky130_gnd sky130_fd_pr__nfet_01v8 L=0.6 W=1.4 AS=0.406
+ AD=0.406 PS=3.38 PD=3.38
M$542 \$61 bias_a VSS sky130_gnd sky130_fd_pr__nfet_01v8 L=0.6 W=1.4 AS=0.406
+ AD=0.406 PS=3.38 PD=3.38
M$543 \$61 bias_a VSS sky130_gnd sky130_fd_pr__nfet_01v8 L=0.6 W=1.4 AS=0.406
+ AD=0.406 PS=3.38 PD=3.38
M$544 \$61 bias_a VSS sky130_gnd sky130_fd_pr__nfet_01v8 L=0.6 W=1.4 AS=0.406
+ AD=0.406 PS=3.38 PD=3.38
M$545 \$61 bias_a VSS sky130_gnd sky130_fd_pr__nfet_01v8 L=0.6 W=1.4 AS=0.406
+ AD=0.406 PS=3.38 PD=3.38
M$546 \$61 bias_a VSS sky130_gnd sky130_fd_pr__nfet_01v8 L=0.6 W=1.4 AS=0.406
+ AD=0.406 PS=3.38 PD=3.38
M$547 \$61 bias_a VSS sky130_gnd sky130_fd_pr__nfet_01v8 L=0.6 W=1.4 AS=0.406
+ AD=0.406 PS=3.38 PD=3.38
M$548 \$61 bias_a VSS sky130_gnd sky130_fd_pr__nfet_01v8 L=0.6 W=1.4 AS=0.406
+ AD=0.406 PS=3.38 PD=3.38
M$549 \$61 bias_a VSS sky130_gnd sky130_fd_pr__nfet_01v8 L=0.6 W=1.4 AS=0.406
+ AD=0.406 PS=3.38 PD=3.38
M$550 \$61 bias_a VSS sky130_gnd sky130_fd_pr__nfet_01v8 L=0.6 W=1.4 AS=0.406
+ AD=0.406 PS=3.38 PD=3.38
M$551 \$61 bias_a VSS sky130_gnd sky130_fd_pr__nfet_01v8 L=0.6 W=1.4 AS=0.406
+ AD=0.406 PS=3.38 PD=3.38
M$552 \$61 bias_a VSS sky130_gnd sky130_fd_pr__nfet_01v8 L=0.6 W=1.4 AS=0.406
+ AD=0.406 PS=3.38 PD=3.38
M$553 \$61 bias_a VSS sky130_gnd sky130_fd_pr__nfet_01v8 L=0.6 W=1.4 AS=0.406
+ AD=0.406 PS=3.38 PD=3.38
M$554 \$61 bias_a VSS sky130_gnd sky130_fd_pr__nfet_01v8 L=0.6 W=1.4 AS=0.406
+ AD=0.406 PS=3.38 PD=3.38
M$555 \$61 bias_a VSS sky130_gnd sky130_fd_pr__nfet_01v8 L=0.6 W=1.4 AS=0.406
+ AD=0.406 PS=3.38 PD=3.38
M$556 \$61 bias_a VSS sky130_gnd sky130_fd_pr__nfet_01v8 L=0.6 W=1.4 AS=0.406
+ AD=0.406 PS=3.38 PD=3.38
M$557 \$61 bias_a VSS sky130_gnd sky130_fd_pr__nfet_01v8 L=0.6 W=1.4 AS=0.406
+ AD=0.406 PS=3.38 PD=3.38
M$558 \$61 bias_a VSS sky130_gnd sky130_fd_pr__nfet_01v8 L=0.6 W=1.4 AS=0.406
+ AD=0.406 PS=3.38 PD=3.38
M$559 \$61 bias_a VSS sky130_gnd sky130_fd_pr__nfet_01v8 L=0.6 W=1.4 AS=0.406
+ AD=0.406 PS=3.38 PD=3.38
M$560 \$61 bias_a VSS sky130_gnd sky130_fd_pr__nfet_01v8 L=0.6 W=1.4 AS=0.406
+ AD=0.406 PS=3.38 PD=3.38
M$561 \$61 bias_a VSS sky130_gnd sky130_fd_pr__nfet_01v8 L=0.6 W=1.4 AS=0.406
+ AD=0.406 PS=3.38 PD=3.38
M$562 \$61 bias_a VSS sky130_gnd sky130_fd_pr__nfet_01v8 L=0.6 W=1.4 AS=0.406
+ AD=0.406 PS=3.38 PD=3.38
M$563 \$61 bias_a VSS sky130_gnd sky130_fd_pr__nfet_01v8 L=0.6 W=1.4 AS=0.406
+ AD=0.406 PS=3.38 PD=3.38
M$564 \$61 bias_a VSS sky130_gnd sky130_fd_pr__nfet_01v8 L=0.6 W=1.4 AS=0.406
+ AD=0.406 PS=3.38 PD=3.38
M$565 \$61 bias_a VSS sky130_gnd sky130_fd_pr__nfet_01v8 L=0.6 W=1.4 AS=0.406
+ AD=0.406 PS=3.38 PD=3.38
M$566 \$61 bias_a VSS sky130_gnd sky130_fd_pr__nfet_01v8 L=0.6 W=1.4 AS=0.406
+ AD=0.406 PS=3.38 PD=3.38
M$567 \$61 bias_a VSS sky130_gnd sky130_fd_pr__nfet_01v8 L=0.6 W=1.4 AS=0.406
+ AD=0.406 PS=3.38 PD=3.38
M$568 \$61 bias_a VSS sky130_gnd sky130_fd_pr__nfet_01v8 L=0.6 W=1.4 AS=0.406
+ AD=0.406 PS=3.38 PD=3.38
M$569 \$61 bias_a VSS sky130_gnd sky130_fd_pr__nfet_01v8 L=0.6 W=1.4 AS=0.406
+ AD=0.406 PS=3.38 PD=3.38
M$570 \$61 bias_a VSS sky130_gnd sky130_fd_pr__nfet_01v8 L=0.6 W=1.4 AS=0.406
+ AD=0.406 PS=3.38 PD=3.38
M$571 \$61 bias_a VSS sky130_gnd sky130_fd_pr__nfet_01v8 L=0.6 W=1.4 AS=0.406
+ AD=0.406 PS=3.38 PD=3.38
M$572 \$61 bias_a VSS sky130_gnd sky130_fd_pr__nfet_01v8 L=0.6 W=1.4 AS=0.406
+ AD=0.406 PS=3.38 PD=3.38
M$573 \$61 bias_a VSS sky130_gnd sky130_fd_pr__nfet_01v8 L=0.6 W=1.4 AS=0.406
+ AD=0.406 PS=3.38 PD=3.38
M$574 \$61 bias_a VSS sky130_gnd sky130_fd_pr__nfet_01v8 L=0.6 W=1.4 AS=0.406
+ AD=0.406 PS=3.38 PD=3.38
M$575 \$61 bias_a VSS sky130_gnd sky130_fd_pr__nfet_01v8 L=0.6 W=1.4 AS=0.406
+ AD=0.406 PS=3.38 PD=3.38
M$576 \$61 bias_a VSS sky130_gnd sky130_fd_pr__nfet_01v8 L=0.6 W=1.4 AS=0.406
+ AD=0.406 PS=3.38 PD=3.38
M$577 \$61 bias_a VSS sky130_gnd sky130_fd_pr__nfet_01v8 L=0.6 W=1.4 AS=0.406
+ AD=0.406 PS=3.38 PD=3.38
M$578 \$61 bias_a VSS sky130_gnd sky130_fd_pr__nfet_01v8 L=0.6 W=1.4 AS=0.406
+ AD=0.406 PS=3.38 PD=3.38
M$579 \$61 bias_a VSS sky130_gnd sky130_fd_pr__nfet_01v8 L=0.6 W=1.4 AS=0.406
+ AD=0.406 PS=3.38 PD=3.38
M$580 \$61 bias_a VSS sky130_gnd sky130_fd_pr__nfet_01v8 L=0.6 W=1.4 AS=0.406
+ AD=0.406 PS=3.38 PD=3.38
M$581 \$61 bias_a VSS sky130_gnd sky130_fd_pr__nfet_01v8 L=0.6 W=1.4 AS=0.406
+ AD=0.406 PS=3.38 PD=3.38
M$582 \$61 bias_a VSS sky130_gnd sky130_fd_pr__nfet_01v8 L=0.6 W=1.4 AS=0.406
+ AD=0.406 PS=3.38 PD=3.38
M$583 \$61 bias_a VSS sky130_gnd sky130_fd_pr__nfet_01v8 L=0.6 W=1.4 AS=0.406
+ AD=0.406 PS=3.38 PD=3.38
M$584 \$61 bias_a VSS sky130_gnd sky130_fd_pr__nfet_01v8 L=0.6 W=1.4 AS=0.406
+ AD=0.406 PS=3.38 PD=3.38
M$585 \$61 bias_a VSS sky130_gnd sky130_fd_pr__nfet_01v8 L=0.6 W=1.4 AS=0.406
+ AD=0.406 PS=3.38 PD=3.38
M$586 \$61 bias_a VSS sky130_gnd sky130_fd_pr__nfet_01v8 L=0.6 W=1.4 AS=0.406
+ AD=0.406 PS=3.38 PD=3.38
M$587 \$61 bias_a VSS sky130_gnd sky130_fd_pr__nfet_01v8 L=0.6 W=1.4 AS=0.406
+ AD=0.406 PS=3.38 PD=3.38
M$588 \$61 bias_a VSS sky130_gnd sky130_fd_pr__nfet_01v8 L=0.6 W=1.4 AS=0.406
+ AD=0.406 PS=3.38 PD=3.38
M$589 \$61 bias_a VSS sky130_gnd sky130_fd_pr__nfet_01v8 L=0.6 W=1.4 AS=0.406
+ AD=0.406 PS=3.38 PD=3.38
M$590 \$61 bias_a VSS sky130_gnd sky130_fd_pr__nfet_01v8 L=0.6 W=1.4 AS=0.406
+ AD=0.406 PS=3.38 PD=3.38
M$591 \$61 bias_a VSS sky130_gnd sky130_fd_pr__nfet_01v8 L=0.6 W=1.4 AS=0.406
+ AD=0.406 PS=3.38 PD=3.38
M$592 \$61 bias_a VSS sky130_gnd sky130_fd_pr__nfet_01v8 L=0.6 W=1.4 AS=0.406
+ AD=0.406 PS=3.38 PD=3.38
M$593 \$61 bias_a VSS sky130_gnd sky130_fd_pr__nfet_01v8 L=0.6 W=1.4 AS=0.406
+ AD=0.406 PS=3.38 PD=3.38
M$594 \$61 bias_a VSS sky130_gnd sky130_fd_pr__nfet_01v8 L=0.6 W=1.4 AS=0.406
+ AD=0.406 PS=3.38 PD=3.38
M$595 \$61 bias_a VSS sky130_gnd sky130_fd_pr__nfet_01v8 L=0.6 W=1.4 AS=0.406
+ AD=0.406 PS=3.38 PD=3.38
M$596 \$61 bias_a VSS sky130_gnd sky130_fd_pr__nfet_01v8 L=0.6 W=1.4 AS=0.406
+ AD=0.406 PS=3.38 PD=3.38
M$597 \$61 bias_a VSS sky130_gnd sky130_fd_pr__nfet_01v8 L=0.6 W=1.4 AS=0.406
+ AD=0.406 PS=3.38 PD=3.38
M$598 \$61 bias_a VSS sky130_gnd sky130_fd_pr__nfet_01v8 L=0.6 W=1.4 AS=0.406
+ AD=0.406 PS=3.38 PD=3.38
M$599 \$61 bias_a VSS sky130_gnd sky130_fd_pr__nfet_01v8 L=0.6 W=1.4 AS=0.406
+ AD=0.406 PS=3.38 PD=3.38
M$600 \$61 bias_a VSS sky130_gnd sky130_fd_pr__nfet_01v8 L=0.6 W=1.4 AS=0.406
+ AD=0.406 PS=3.38 PD=3.38
M$601 \$61 cmc VSS sky130_gnd sky130_fd_pr__nfet_01v8 L=0.6 W=1.4 AS=0.406
+ AD=0.406 PS=3.38 PD=3.38
M$602 \$61 cmc VSS sky130_gnd sky130_fd_pr__nfet_01v8 L=0.6 W=1.4 AS=0.406
+ AD=0.406 PS=3.38 PD=3.38
M$603 \$61 cmc VSS sky130_gnd sky130_fd_pr__nfet_01v8 L=0.6 W=1.4 AS=0.406
+ AD=0.406 PS=3.38 PD=3.38
M$604 \$61 cmc VSS sky130_gnd sky130_fd_pr__nfet_01v8 L=0.6 W=1.4 AS=0.406
+ AD=0.406 PS=3.38 PD=3.38
M$605 \$61 cmc VSS sky130_gnd sky130_fd_pr__nfet_01v8 L=0.6 W=1.4 AS=0.406
+ AD=0.406 PS=3.38 PD=3.38
M$606 \$61 cmc VSS sky130_gnd sky130_fd_pr__nfet_01v8 L=0.6 W=1.4 AS=0.406
+ AD=0.406 PS=3.38 PD=3.38
M$607 \$61 cmc VSS sky130_gnd sky130_fd_pr__nfet_01v8 L=0.6 W=1.4 AS=0.406
+ AD=0.406 PS=3.38 PD=3.38
M$608 \$61 cmc VSS sky130_gnd sky130_fd_pr__nfet_01v8 L=0.6 W=1.4 AS=0.406
+ AD=0.406 PS=3.38 PD=3.38
M$609 \$61 cmc VSS sky130_gnd sky130_fd_pr__nfet_01v8 L=0.6 W=1.4 AS=0.406
+ AD=0.406 PS=3.38 PD=3.38
M$610 \$61 cmc VSS sky130_gnd sky130_fd_pr__nfet_01v8 L=0.6 W=1.4 AS=0.406
+ AD=0.406 PS=3.38 PD=3.38
M$611 \$61 cmc VSS sky130_gnd sky130_fd_pr__nfet_01v8 L=0.6 W=1.4 AS=0.406
+ AD=0.406 PS=3.38 PD=3.38
M$612 \$61 cmc VSS sky130_gnd sky130_fd_pr__nfet_01v8 L=0.6 W=1.4 AS=0.406
+ AD=0.406 PS=3.38 PD=3.38
M$613 \$61 cmc VSS sky130_gnd sky130_fd_pr__nfet_01v8 L=0.6 W=1.4 AS=0.406
+ AD=0.406 PS=3.38 PD=3.38
M$614 \$61 cmc VSS sky130_gnd sky130_fd_pr__nfet_01v8 L=0.6 W=1.4 AS=0.406
+ AD=0.406 PS=3.38 PD=3.38
M$615 \$61 cmc VSS sky130_gnd sky130_fd_pr__nfet_01v8 L=0.6 W=1.4 AS=0.406
+ AD=0.406 PS=3.38 PD=3.38
M$616 \$61 cmc VSS sky130_gnd sky130_fd_pr__nfet_01v8 L=0.6 W=1.4 AS=0.406
+ AD=0.406 PS=3.38 PD=3.38
M$617 \$61 cmc VSS sky130_gnd sky130_fd_pr__nfet_01v8 L=0.6 W=1.4 AS=0.406
+ AD=0.406 PS=3.38 PD=3.38
M$618 \$61 cmc VSS sky130_gnd sky130_fd_pr__nfet_01v8 L=0.6 W=1.4 AS=0.406
+ AD=0.406 PS=3.38 PD=3.38
M$619 \$61 cmc VSS sky130_gnd sky130_fd_pr__nfet_01v8 L=0.6 W=1.4 AS=0.406
+ AD=0.406 PS=3.38 PD=3.38
M$620 \$61 cmc VSS sky130_gnd sky130_fd_pr__nfet_01v8 L=0.6 W=1.4 AS=0.406
+ AD=0.406 PS=3.38 PD=3.38
M$621 \$61 cmc VSS sky130_gnd sky130_fd_pr__nfet_01v8 L=0.6 W=1.4 AS=0.406
+ AD=0.406 PS=3.38 PD=3.38
M$622 \$61 cmc VSS sky130_gnd sky130_fd_pr__nfet_01v8 L=0.6 W=1.4 AS=0.406
+ AD=0.406 PS=3.38 PD=3.38
M$623 \$61 cmc VSS sky130_gnd sky130_fd_pr__nfet_01v8 L=0.6 W=1.4 AS=0.406
+ AD=0.406 PS=3.38 PD=3.38
M$624 \$61 cmc VSS sky130_gnd sky130_fd_pr__nfet_01v8 L=0.6 W=1.4 AS=0.406
+ AD=0.406 PS=3.38 PD=3.38
M$625 \$61 cmc VSS sky130_gnd sky130_fd_pr__nfet_01v8 L=0.6 W=1.4 AS=0.406
+ AD=0.406 PS=3.38 PD=3.38
M$626 \$61 cmc VSS sky130_gnd sky130_fd_pr__nfet_01v8 L=0.6 W=1.4 AS=0.406
+ AD=0.406 PS=3.38 PD=3.38
M$627 \$61 cmc VSS sky130_gnd sky130_fd_pr__nfet_01v8 L=0.6 W=1.4 AS=0.406
+ AD=0.406 PS=3.38 PD=3.38
M$628 \$61 cmc VSS sky130_gnd sky130_fd_pr__nfet_01v8 L=0.6 W=1.4 AS=0.406
+ AD=0.406 PS=3.38 PD=3.38
M$629 \$61 cmc VSS sky130_gnd sky130_fd_pr__nfet_01v8 L=0.6 W=1.4 AS=0.406
+ AD=0.406 PS=3.38 PD=3.38
M$630 \$61 cmc VSS sky130_gnd sky130_fd_pr__nfet_01v8 L=0.6 W=1.4 AS=0.406
+ AD=0.406 PS=3.38 PD=3.38
M$631 \$61 cmc VSS sky130_gnd sky130_fd_pr__nfet_01v8 L=0.6 W=1.4 AS=0.406
+ AD=0.406 PS=3.38 PD=3.38
M$632 \$61 cmc VSS sky130_gnd sky130_fd_pr__nfet_01v8 L=0.6 W=1.4 AS=0.406
+ AD=0.406 PS=3.38 PD=3.38
M$633 \$61 cmc VSS sky130_gnd sky130_fd_pr__nfet_01v8 L=0.6 W=1.4 AS=0.406
+ AD=0.406 PS=3.38 PD=3.38
M$634 \$61 cmc VSS sky130_gnd sky130_fd_pr__nfet_01v8 L=0.6 W=1.4 AS=0.406
+ AD=0.406 PS=3.38 PD=3.38
M$635 \$61 cmc VSS sky130_gnd sky130_fd_pr__nfet_01v8 L=0.6 W=1.4 AS=0.406
+ AD=0.406 PS=3.38 PD=3.38
M$636 \$61 cmc VSS sky130_gnd sky130_fd_pr__nfet_01v8 L=0.6 W=1.4 AS=0.406
+ AD=0.406 PS=3.38 PD=3.38
M$637 \$61 cmc VSS sky130_gnd sky130_fd_pr__nfet_01v8 L=0.6 W=1.4 AS=0.406
+ AD=0.406 PS=3.38 PD=3.38
M$638 \$61 cmc VSS sky130_gnd sky130_fd_pr__nfet_01v8 L=0.6 W=1.4 AS=0.406
+ AD=0.406 PS=3.38 PD=3.38
M$639 \$61 cmc VSS sky130_gnd sky130_fd_pr__nfet_01v8 L=0.6 W=1.4 AS=0.406
+ AD=0.406 PS=3.38 PD=3.38
M$640 \$61 cmc VSS sky130_gnd sky130_fd_pr__nfet_01v8 L=0.6 W=1.4 AS=0.406
+ AD=0.406 PS=3.38 PD=3.38
M$641 \$61 cmc VSS sky130_gnd sky130_fd_pr__nfet_01v8 L=0.6 W=1.4 AS=0.406
+ AD=0.406 PS=3.38 PD=3.38
M$642 \$61 cmc VSS sky130_gnd sky130_fd_pr__nfet_01v8 L=0.6 W=1.4 AS=0.406
+ AD=0.406 PS=3.38 PD=3.38
M$643 \$61 cmc VSS sky130_gnd sky130_fd_pr__nfet_01v8 L=0.6 W=1.4 AS=0.406
+ AD=0.406 PS=3.38 PD=3.38
M$644 \$61 cmc VSS sky130_gnd sky130_fd_pr__nfet_01v8 L=0.6 W=1.4 AS=0.406
+ AD=0.406 PS=3.38 PD=3.38
M$645 \$61 cmc VSS sky130_gnd sky130_fd_pr__nfet_01v8 L=0.6 W=1.4 AS=0.406
+ AD=0.406 PS=3.38 PD=3.38
M$646 \$61 cmc VSS sky130_gnd sky130_fd_pr__nfet_01v8 L=0.6 W=1.4 AS=0.406
+ AD=0.406 PS=3.38 PD=3.38
M$647 \$61 cmc VSS sky130_gnd sky130_fd_pr__nfet_01v8 L=0.6 W=1.4 AS=0.406
+ AD=0.406 PS=3.38 PD=3.38
M$648 \$61 cmc VSS sky130_gnd sky130_fd_pr__nfet_01v8 L=0.6 W=1.4 AS=0.406
+ AD=0.406 PS=3.38 PD=3.38
M$649 \$61 cmc VSS sky130_gnd sky130_fd_pr__nfet_01v8 L=0.6 W=1.4 AS=0.406
+ AD=0.406 PS=3.38 PD=3.38
M$650 \$61 cmc VSS sky130_gnd sky130_fd_pr__nfet_01v8 L=0.6 W=1.4 AS=0.406
+ AD=0.406 PS=3.38 PD=3.38
M$651 \$61 cmc VSS sky130_gnd sky130_fd_pr__nfet_01v8 L=0.6 W=1.4 AS=0.406
+ AD=0.406 PS=3.38 PD=3.38
M$652 \$61 cmc VSS sky130_gnd sky130_fd_pr__nfet_01v8 L=0.6 W=1.4 AS=0.406
+ AD=0.406 PS=3.38 PD=3.38
M$653 \$61 cmc VSS sky130_gnd sky130_fd_pr__nfet_01v8 L=0.6 W=1.4 AS=0.406
+ AD=0.406 PS=3.38 PD=3.38
M$654 \$61 cmc VSS sky130_gnd sky130_fd_pr__nfet_01v8 L=0.6 W=1.4 AS=0.406
+ AD=0.406 PS=3.38 PD=3.38
M$655 \$61 cmc VSS sky130_gnd sky130_fd_pr__nfet_01v8 L=0.6 W=1.4 AS=0.406
+ AD=0.406 PS=3.38 PD=3.38
M$656 \$61 cmc VSS sky130_gnd sky130_fd_pr__nfet_01v8 L=0.6 W=1.4 AS=0.406
+ AD=0.406 PS=3.38 PD=3.38
M$657 \$61 cmc VSS sky130_gnd sky130_fd_pr__nfet_01v8 L=0.6 W=1.4 AS=0.406
+ AD=0.406 PS=3.38 PD=3.38
M$658 \$61 cmc VSS sky130_gnd sky130_fd_pr__nfet_01v8 L=0.6 W=1.4 AS=0.406
+ AD=0.406 PS=3.38 PD=3.38
M$659 \$61 cmc VSS sky130_gnd sky130_fd_pr__nfet_01v8 L=0.6 W=1.4 AS=0.406
+ AD=0.406 PS=3.38 PD=3.38
M$660 \$61 cmc VSS sky130_gnd sky130_fd_pr__nfet_01v8 L=0.6 W=1.4 AS=0.406
+ AD=0.406 PS=3.38 PD=3.38
M$661 \$61 cmc VSS sky130_gnd sky130_fd_pr__nfet_01v8 L=0.6 W=1.4 AS=0.406
+ AD=0.406 PS=3.38 PD=3.38
M$662 \$61 cmc VSS sky130_gnd sky130_fd_pr__nfet_01v8 L=0.6 W=1.4 AS=0.406
+ AD=0.406 PS=3.38 PD=3.38
M$663 \$61 cmc VSS sky130_gnd sky130_fd_pr__nfet_01v8 L=0.6 W=1.4 AS=0.406
+ AD=0.406 PS=3.38 PD=3.38
M$664 \$61 cmc VSS sky130_gnd sky130_fd_pr__nfet_01v8 L=0.6 W=1.4 AS=0.406
+ AD=0.406 PS=3.38 PD=3.38
M$665 \$61 cmc VSS sky130_gnd sky130_fd_pr__nfet_01v8 L=0.6 W=1.4 AS=0.406
+ AD=0.406 PS=3.38 PD=3.38
M$666 \$61 cmc VSS sky130_gnd sky130_fd_pr__nfet_01v8 L=0.6 W=1.4 AS=0.406
+ AD=0.406 PS=3.38 PD=3.38
M$667 \$61 cmc VSS sky130_gnd sky130_fd_pr__nfet_01v8 L=0.6 W=1.4 AS=0.406
+ AD=0.406 PS=3.38 PD=3.38
M$668 \$61 cmc VSS sky130_gnd sky130_fd_pr__nfet_01v8 L=0.6 W=1.4 AS=0.406
+ AD=0.406 PS=3.38 PD=3.38
M$669 \$61 cmc VSS sky130_gnd sky130_fd_pr__nfet_01v8 L=0.6 W=1.4 AS=0.406
+ AD=0.406 PS=3.38 PD=3.38
M$670 \$61 cmc VSS sky130_gnd sky130_fd_pr__nfet_01v8 L=0.6 W=1.4 AS=0.406
+ AD=0.406 PS=3.38 PD=3.38
M$671 \$61 cmc VSS sky130_gnd sky130_fd_pr__nfet_01v8 L=0.6 W=1.4 AS=0.406
+ AD=0.406 PS=3.38 PD=3.38
M$672 \$61 cmc VSS sky130_gnd sky130_fd_pr__nfet_01v8 L=0.6 W=1.4 AS=0.406
+ AD=0.406 PS=3.38 PD=3.38
M$673 \$61 cmc VSS sky130_gnd sky130_fd_pr__nfet_01v8 L=0.6 W=1.4 AS=0.406
+ AD=0.406 PS=3.38 PD=3.38
M$674 \$61 cmc VSS sky130_gnd sky130_fd_pr__nfet_01v8 L=0.6 W=1.4 AS=0.406
+ AD=0.406 PS=3.38 PD=3.38
M$675 \$61 cmc VSS sky130_gnd sky130_fd_pr__nfet_01v8 L=0.6 W=1.4 AS=0.406
+ AD=0.406 PS=3.38 PD=3.38
M$676 \$61 cmc VSS sky130_gnd sky130_fd_pr__nfet_01v8 L=0.6 W=1.4 AS=0.406
+ AD=0.406 PS=3.38 PD=3.38
M$677 \$61 cmc VSS sky130_gnd sky130_fd_pr__nfet_01v8 L=0.6 W=1.4 AS=0.406
+ AD=0.406 PS=3.38 PD=3.38
M$678 \$61 cmc VSS sky130_gnd sky130_fd_pr__nfet_01v8 L=0.6 W=1.4 AS=0.406
+ AD=0.406 PS=3.38 PD=3.38
M$679 \$61 cmc VSS sky130_gnd sky130_fd_pr__nfet_01v8 L=0.6 W=1.4 AS=0.406
+ AD=0.406 PS=3.38 PD=3.38
M$680 \$61 cmc VSS sky130_gnd sky130_fd_pr__nfet_01v8 L=0.6 W=1.4 AS=0.406
+ AD=0.406 PS=3.38 PD=3.38
M$681 \$61 cmc VSS sky130_gnd sky130_fd_pr__nfet_01v8 L=0.6 W=1.4 AS=0.406
+ AD=0.406 PS=3.38 PD=3.38
M$682 \$61 cmc VSS sky130_gnd sky130_fd_pr__nfet_01v8 L=0.6 W=1.4 AS=0.406
+ AD=0.406 PS=3.38 PD=3.38
M$683 \$61 cmc VSS sky130_gnd sky130_fd_pr__nfet_01v8 L=0.6 W=1.4 AS=0.406
+ AD=0.406 PS=3.38 PD=3.38
M$684 \$61 cmc VSS sky130_gnd sky130_fd_pr__nfet_01v8 L=0.6 W=1.4 AS=0.406
+ AD=0.406 PS=3.38 PD=3.38
M$685 \$61 cmc VSS sky130_gnd sky130_fd_pr__nfet_01v8 L=0.6 W=1.4 AS=0.406
+ AD=0.406 PS=3.38 PD=3.38
M$686 \$61 cmc VSS sky130_gnd sky130_fd_pr__nfet_01v8 L=0.6 W=1.4 AS=0.406
+ AD=0.406 PS=3.38 PD=3.38
M$687 \$61 cmc VSS sky130_gnd sky130_fd_pr__nfet_01v8 L=0.6 W=1.4 AS=0.406
+ AD=0.406 PS=3.38 PD=3.38
M$688 \$61 cmc VSS sky130_gnd sky130_fd_pr__nfet_01v8 L=0.6 W=1.4 AS=0.406
+ AD=0.406 PS=3.38 PD=3.38
M$689 \$61 cmc VSS sky130_gnd sky130_fd_pr__nfet_01v8 L=0.6 W=1.4 AS=0.406
+ AD=0.406 PS=3.38 PD=3.38
M$690 \$61 cmc VSS sky130_gnd sky130_fd_pr__nfet_01v8 L=0.6 W=1.4 AS=0.406
+ AD=0.406 PS=3.38 PD=3.38
M$691 \$61 cmc VSS sky130_gnd sky130_fd_pr__nfet_01v8 L=0.6 W=1.4 AS=0.406
+ AD=0.406 PS=3.38 PD=3.38
M$692 \$61 cmc VSS sky130_gnd sky130_fd_pr__nfet_01v8 L=0.6 W=1.4 AS=0.406
+ AD=0.406 PS=3.38 PD=3.38
M$693 \$61 cmc VSS sky130_gnd sky130_fd_pr__nfet_01v8 L=0.6 W=1.4 AS=0.406
+ AD=0.406 PS=3.38 PD=3.38
M$694 \$61 cmc VSS sky130_gnd sky130_fd_pr__nfet_01v8 L=0.6 W=1.4 AS=0.406
+ AD=0.406 PS=3.38 PD=3.38
M$695 \$61 cmc VSS sky130_gnd sky130_fd_pr__nfet_01v8 L=0.6 W=1.4 AS=0.406
+ AD=0.406 PS=3.38 PD=3.38
M$696 \$61 cmc VSS sky130_gnd sky130_fd_pr__nfet_01v8 L=0.6 W=1.4 AS=0.406
+ AD=0.406 PS=3.38 PD=3.38
M$697 \$388 \$338 bias_a sky130_gnd sky130_fd_pr__nfet_01v8 L=0.6 W=1.4
+ AS=0.406 AD=0.406 PS=3.38 PD=3.38
M$698 \$388 \$338 bias_a sky130_gnd sky130_fd_pr__nfet_01v8 L=0.6 W=1.4
+ AS=0.406 AD=0.406 PS=3.38 PD=3.38
M$699 \$338 \$338 \$338 sky130_gnd sky130_fd_pr__nfet_01v8 L=0.6 W=1.4 AS=0.406
+ AD=0.406 PS=3.38 PD=3.38
M$700 \$338 \$338 \$338 sky130_gnd sky130_fd_pr__nfet_01v8 L=0.6 W=1.4 AS=0.406
+ AD=0.406 PS=3.38 PD=3.38
M$701 IBIAS IBIAS IBIAS sky130_gnd sky130_fd_pr__nfet_01v8 L=0.6 W=1.4 AS=0.406
+ AD=0.406 PS=3.38 PD=3.38
M$702 IBIAS IBIAS IBIAS sky130_gnd sky130_fd_pr__nfet_01v8 L=0.6 W=1.4 AS=0.406
+ AD=0.406 PS=3.38 PD=3.38
M$703 \$213 \$213 \$213 sky130_gnd sky130_fd_pr__nfet_01v8 L=0.6 W=1.4 AS=0.406
+ AD=0.406 PS=3.38 PD=3.38
M$704 \$213 \$213 \$213 sky130_gnd sky130_fd_pr__nfet_01v8 L=0.6 W=1.4 AS=0.406
+ AD=0.406 PS=3.38 PD=3.38
M$705 on VSS VSS sky130_gnd sky130_fd_pr__nfet_01v8 L=0.6 W=1.4 AS=0.406
+ AD=0.406 PS=3.38 PD=3.38
M$706 on VSS VSS sky130_gnd sky130_fd_pr__nfet_01v8 L=0.6 W=1.4 AS=0.406
+ AD=0.406 PS=3.38 PD=3.38
M$707 \$61 VSS VSS sky130_gnd sky130_fd_pr__nfet_01v8 L=0.6 W=1.4 AS=0.406
+ AD=0.406 PS=3.38 PD=3.38
M$708 \$61 VSS VSS sky130_gnd sky130_fd_pr__nfet_01v8 L=0.6 W=1.4 AS=0.406
+ AD=0.406 PS=3.38 PD=3.38
M$709 op VSS VSS sky130_gnd sky130_fd_pr__nfet_01v8 L=0.6 W=1.4 AS=0.406
+ AD=0.406 PS=3.38 PD=3.38
M$710 op VSS VSS sky130_gnd sky130_fd_pr__nfet_01v8 L=0.6 W=1.4 AS=0.406
+ AD=0.406 PS=3.38 PD=3.38
M$711 op op op sky130_gnd sky130_fd_pr__nfet_01v8 L=0.6 W=1.4 AS=0.406 AD=0.406
+ PS=3.38 PD=3.38
M$712 op op op sky130_gnd sky130_fd_pr__nfet_01v8 L=0.6 W=1.4 AS=0.406 AD=0.406
+ PS=3.38 PD=3.38
M$713 on on on sky130_gnd sky130_fd_pr__nfet_01v8 L=0.6 W=1.4 AS=0.406 AD=0.406
+ PS=3.38 PD=3.38
M$714 on on on sky130_gnd sky130_fd_pr__nfet_01v8 L=0.6 W=1.4 AS=0.406 AD=0.406
+ PS=3.38 PD=3.38
M$715 \$89 \$89 \$89 sky130_gnd sky130_fd_pr__nfet_01v8_lvt L=0.2 W=1.2
+ AS=0.348 AD=0.348 PS=2.98 PD=2.98
M$716 \$89 \$89 \$89 sky130_gnd sky130_fd_pr__nfet_01v8_lvt L=0.2 W=1.2
+ AS=0.348 AD=0.348 PS=2.98 PD=2.98
M$717 \$42 \$42 \$42 sky130_gnd sky130_fd_pr__nfet_01v8_lvt L=0.2 W=1.2
+ AS=0.348 AD=0.348 PS=2.98 PD=2.98
M$718 \$42 \$42 \$42 sky130_gnd sky130_fd_pr__nfet_01v8_lvt L=0.2 W=1.2
+ AS=0.348 AD=0.348 PS=2.98 PD=2.98
M$719 VDD VDD VDD VDD sky130_fd_pr__pfet_01v8 L=0.6 W=1.4 AS=0.406 AD=0.406
+ PS=3.38 PD=3.38
M$720 op \$213 \$89 VDD sky130_fd_pr__pfet_01v8 L=0.6 W=1.4 AS=0.406 AD=0.406
+ PS=3.38 PD=3.38
M$721 on \$213 \$42 VDD sky130_fd_pr__pfet_01v8 L=0.6 W=1.4 AS=0.406 AD=0.406
+ PS=3.38 PD=3.38
M$722 op \$213 \$89 VDD sky130_fd_pr__pfet_01v8 L=0.6 W=1.4 AS=0.406 AD=0.406
+ PS=3.38 PD=3.38
M$723 on \$213 \$42 VDD sky130_fd_pr__pfet_01v8 L=0.6 W=1.4 AS=0.406 AD=0.406
+ PS=3.38 PD=3.38
M$724 op \$213 \$89 VDD sky130_fd_pr__pfet_01v8 L=0.6 W=1.4 AS=0.406 AD=0.406
+ PS=3.38 PD=3.38
M$725 on \$213 \$42 VDD sky130_fd_pr__pfet_01v8 L=0.6 W=1.4 AS=0.406 AD=0.406
+ PS=3.38 PD=3.38
M$726 op \$213 \$89 VDD sky130_fd_pr__pfet_01v8 L=0.6 W=1.4 AS=0.406 AD=0.406
+ PS=3.38 PD=3.38
M$727 on \$213 \$42 VDD sky130_fd_pr__pfet_01v8 L=0.6 W=1.4 AS=0.406 AD=0.406
+ PS=3.38 PD=3.38
M$728 op \$213 \$89 VDD sky130_fd_pr__pfet_01v8 L=0.6 W=1.4 AS=0.406 AD=0.406
+ PS=3.38 PD=3.38
M$729 op \$213 \$89 VDD sky130_fd_pr__pfet_01v8 L=0.6 W=1.4 AS=0.406 AD=0.406
+ PS=3.38 PD=3.38
M$730 on \$213 \$42 VDD sky130_fd_pr__pfet_01v8 L=0.6 W=1.4 AS=0.406 AD=0.406
+ PS=3.38 PD=3.38
M$731 op \$213 \$89 VDD sky130_fd_pr__pfet_01v8 L=0.6 W=1.4 AS=0.406 AD=0.406
+ PS=3.38 PD=3.38
M$732 on \$213 \$42 VDD sky130_fd_pr__pfet_01v8 L=0.6 W=1.4 AS=0.406 AD=0.406
+ PS=3.38 PD=3.38
M$733 op \$213 \$89 VDD sky130_fd_pr__pfet_01v8 L=0.6 W=1.4 AS=0.406 AD=0.406
+ PS=3.38 PD=3.38
M$734 on \$213 \$42 VDD sky130_fd_pr__pfet_01v8 L=0.6 W=1.4 AS=0.406 AD=0.406
+ PS=3.38 PD=3.38
M$735 op \$213 \$89 VDD sky130_fd_pr__pfet_01v8 L=0.6 W=1.4 AS=0.406 AD=0.406
+ PS=3.38 PD=3.38
M$736 on \$213 \$42 VDD sky130_fd_pr__pfet_01v8 L=0.6 W=1.4 AS=0.406 AD=0.406
+ PS=3.38 PD=3.38
M$737 op \$213 \$89 VDD sky130_fd_pr__pfet_01v8 L=0.6 W=1.4 AS=0.406 AD=0.406
+ PS=3.38 PD=3.38
M$738 on \$213 \$42 VDD sky130_fd_pr__pfet_01v8 L=0.6 W=1.4 AS=0.406 AD=0.406
+ PS=3.38 PD=3.38
M$739 on \$213 \$42 VDD sky130_fd_pr__pfet_01v8 L=0.6 W=1.4 AS=0.406 AD=0.406
+ PS=3.38 PD=3.38
M$740 VDD VDD VDD VDD sky130_fd_pr__pfet_01v8 L=0.6 W=1.4 AS=0.406 AD=0.406
+ PS=3.38 PD=3.38
M$741 op \$213 \$89 VDD sky130_fd_pr__pfet_01v8 L=0.6 W=1.4 AS=0.406 AD=0.406
+ PS=3.38 PD=3.38
M$742 on \$213 \$42 VDD sky130_fd_pr__pfet_01v8 L=0.6 W=1.4 AS=0.406 AD=0.406
+ PS=3.38 PD=3.38
M$743 op \$213 \$89 VDD sky130_fd_pr__pfet_01v8 L=0.6 W=1.4 AS=0.406 AD=0.406
+ PS=3.38 PD=3.38
M$744 on \$213 \$42 VDD sky130_fd_pr__pfet_01v8 L=0.6 W=1.4 AS=0.406 AD=0.406
+ PS=3.38 PD=3.38
M$745 op \$213 \$89 VDD sky130_fd_pr__pfet_01v8 L=0.6 W=1.4 AS=0.406 AD=0.406
+ PS=3.38 PD=3.38
M$746 on \$213 \$42 VDD sky130_fd_pr__pfet_01v8 L=0.6 W=1.4 AS=0.406 AD=0.406
+ PS=3.38 PD=3.38
M$747 op \$213 \$89 VDD sky130_fd_pr__pfet_01v8 L=0.6 W=1.4 AS=0.406 AD=0.406
+ PS=3.38 PD=3.38
M$748 on \$213 \$42 VDD sky130_fd_pr__pfet_01v8 L=0.6 W=1.4 AS=0.406 AD=0.406
+ PS=3.38 PD=3.38
M$749 on \$213 \$42 VDD sky130_fd_pr__pfet_01v8 L=0.6 W=1.4 AS=0.406 AD=0.406
+ PS=3.38 PD=3.38
M$750 on \$213 \$42 VDD sky130_fd_pr__pfet_01v8 L=0.6 W=1.4 AS=0.406 AD=0.406
+ PS=3.38 PD=3.38
M$751 op \$213 \$89 VDD sky130_fd_pr__pfet_01v8 L=0.6 W=1.4 AS=0.406 AD=0.406
+ PS=3.38 PD=3.38
M$752 on \$213 \$42 VDD sky130_fd_pr__pfet_01v8 L=0.6 W=1.4 AS=0.406 AD=0.406
+ PS=3.38 PD=3.38
M$753 op \$213 \$89 VDD sky130_fd_pr__pfet_01v8 L=0.6 W=1.4 AS=0.406 AD=0.406
+ PS=3.38 PD=3.38
M$754 on \$213 \$42 VDD sky130_fd_pr__pfet_01v8 L=0.6 W=1.4 AS=0.406 AD=0.406
+ PS=3.38 PD=3.38
M$755 op \$213 \$89 VDD sky130_fd_pr__pfet_01v8 L=0.6 W=1.4 AS=0.406 AD=0.406
+ PS=3.38 PD=3.38
M$756 on \$213 \$42 VDD sky130_fd_pr__pfet_01v8 L=0.6 W=1.4 AS=0.406 AD=0.406
+ PS=3.38 PD=3.38
M$757 op \$213 \$89 VDD sky130_fd_pr__pfet_01v8 L=0.6 W=1.4 AS=0.406 AD=0.406
+ PS=3.38 PD=3.38
M$758 on \$213 \$42 VDD sky130_fd_pr__pfet_01v8 L=0.6 W=1.4 AS=0.406 AD=0.406
+ PS=3.38 PD=3.38
M$759 op \$213 \$89 VDD sky130_fd_pr__pfet_01v8 L=0.6 W=1.4 AS=0.406 AD=0.406
+ PS=3.38 PD=3.38
M$760 op \$213 \$89 VDD sky130_fd_pr__pfet_01v8 L=0.6 W=1.4 AS=0.406 AD=0.406
+ PS=3.38 PD=3.38
M$761 cm \$213 \$649 VDD sky130_fd_pr__pfet_01v8 L=0.6 W=1.4 AS=0.406 AD=0.406
+ PS=3.38 PD=3.38
M$762 cm \$213 \$649 VDD sky130_fd_pr__pfet_01v8 L=0.6 W=1.4 AS=0.406 AD=0.406
+ PS=3.38 PD=3.38
M$763 cm \$213 \$649 VDD sky130_fd_pr__pfet_01v8 L=0.6 W=1.4 AS=0.406 AD=0.406
+ PS=3.38 PD=3.38
M$764 cm \$213 \$649 VDD sky130_fd_pr__pfet_01v8 L=0.6 W=1.4 AS=0.406 AD=0.406
+ PS=3.38 PD=3.38
M$765 cm \$213 \$649 VDD sky130_fd_pr__pfet_01v8 L=0.6 W=1.4 AS=0.406 AD=0.406
+ PS=3.38 PD=3.38
M$766 cm \$213 \$649 VDD sky130_fd_pr__pfet_01v8 L=0.6 W=1.4 AS=0.406 AD=0.406
+ PS=3.38 PD=3.38
M$767 \$338 \$213 \$643 VDD sky130_fd_pr__pfet_01v8 L=0.6 W=1.4 AS=0.406
+ AD=0.406 PS=3.38 PD=3.38
M$768 \$280 \$213 \$644 VDD sky130_fd_pr__pfet_01v8 L=0.6 W=1.4 AS=0.406
+ AD=0.406 PS=3.38 PD=3.38
M$769 \$338 \$213 \$643 VDD sky130_fd_pr__pfet_01v8 L=0.6 W=1.4 AS=0.406
+ AD=0.406 PS=3.38 PD=3.38
M$770 \$280 \$213 \$644 VDD sky130_fd_pr__pfet_01v8 L=0.6 W=1.4 AS=0.406
+ AD=0.406 PS=3.38 PD=3.38
M$771 \$338 \$213 \$643 VDD sky130_fd_pr__pfet_01v8 L=0.6 W=1.4 AS=0.406
+ AD=0.406 PS=3.38 PD=3.38
M$772 \$280 \$213 \$644 VDD sky130_fd_pr__pfet_01v8 L=0.6 W=1.4 AS=0.406
+ AD=0.406 PS=3.38 PD=3.38
M$773 VDD VDD VDD VDD sky130_fd_pr__pfet_01v8 L=0.6 W=1.4 AS=0.406 AD=0.406
+ PS=3.38 PD=3.38
M$774 VDD VDD VDD VDD sky130_fd_pr__pfet_01v8 L=0.6 W=1.4 AS=0.406 AD=0.406
+ PS=3.38 PD=3.38
M$775 \$280 \$213 \$644 VDD sky130_fd_pr__pfet_01v8 L=0.6 W=1.4 AS=0.406
+ AD=0.406 PS=3.38 PD=3.38
M$776 \$338 \$213 \$643 VDD sky130_fd_pr__pfet_01v8 L=0.6 W=1.4 AS=0.406
+ AD=0.406 PS=3.38 PD=3.38
M$777 \$280 \$213 \$644 VDD sky130_fd_pr__pfet_01v8 L=0.6 W=1.4 AS=0.406
+ AD=0.406 PS=3.38 PD=3.38
M$778 \$338 \$213 \$643 VDD sky130_fd_pr__pfet_01v8 L=0.6 W=1.4 AS=0.406
+ AD=0.406 PS=3.38 PD=3.38
M$779 \$280 \$213 \$644 VDD sky130_fd_pr__pfet_01v8 L=0.6 W=1.4 AS=0.406
+ AD=0.406 PS=3.38 PD=3.38
M$780 \$338 \$213 \$643 VDD sky130_fd_pr__pfet_01v8 L=0.6 W=1.4 AS=0.406
+ AD=0.406 PS=3.38 PD=3.38
M$781 VDD VDD VDD VDD sky130_fd_pr__pfet_01v8 L=0.6 W=1.4 AS=0.406 AD=0.406
+ PS=3.38 PD=3.38
M$782 VDD VDD VDD VDD sky130_fd_pr__pfet_01v8 L=0.6 W=1.4 AS=0.406 AD=0.406
+ PS=3.38 PD=3.38
M$783 VDD VDD VDD VDD sky130_fd_pr__pfet_01v8 L=0.6 W=1.4 AS=0.406 AD=0.406
+ PS=3.38 PD=3.38
M$784 VDD VDD VDD VDD sky130_fd_pr__pfet_01v8 L=0.6 W=1.4 AS=0.406 AD=0.406
+ PS=3.38 PD=3.38
M$785 VDD VDD VDD VDD sky130_fd_pr__pfet_01v8 L=0.6 W=1.4 AS=0.406 AD=0.406
+ PS=3.38 PD=3.38
M$786 VDD VDD VDD VDD sky130_fd_pr__pfet_01v8 L=0.6 W=1.4 AS=0.406 AD=0.406
+ PS=3.38 PD=3.38
M$787 \$649 \$649 \$649 VDD sky130_fd_pr__pfet_01v8_lvt L=0.6 W=1.4 AS=0.406
+ AD=0.406 PS=3.38 PD=3.38
M$788 \$649 \$649 \$649 VDD sky130_fd_pr__pfet_01v8_lvt L=0.6 W=1.4 AS=0.406
+ AD=0.406 PS=3.38 PD=3.38
M$789 \$643 \$643 \$643 VDD sky130_fd_pr__pfet_01v8_lvt L=0.6 W=1.4 AS=0.406
+ AD=0.406 PS=3.38 PD=3.38
M$790 \$643 \$643 \$643 VDD sky130_fd_pr__pfet_01v8_lvt L=0.6 W=1.4 AS=0.406
+ AD=0.406 PS=3.38 PD=3.38
M$791 \$644 \$644 \$644 VDD sky130_fd_pr__pfet_01v8_lvt L=0.6 W=1.4 AS=0.406
+ AD=0.406 PS=3.38 PD=3.38
M$792 \$644 \$644 \$644 VDD sky130_fd_pr__pfet_01v8_lvt L=0.6 W=1.4 AS=0.406
+ AD=0.406 PS=3.38 PD=3.38
M$793 VDD VDD VDD VDD sky130_fd_pr__pfet_01v8_lvt L=0.6 W=1.4 AS=0.406 AD=0.406
+ PS=3.38 PD=3.38
M$794 VDD VDD VDD VDD sky130_fd_pr__pfet_01v8_lvt L=0.6 W=1.4 AS=0.406 AD=0.406
+ PS=3.38 PD=3.38
M$795 VDD VDD VDD VDD sky130_fd_pr__pfet_01v8_lvt L=0.6 W=1.4 AS=0.406 AD=0.406
+ PS=3.38 PD=3.38
M$796 VDD VDD VDD VDD sky130_fd_pr__pfet_01v8_lvt L=0.6 W=1.4 AS=0.406 AD=0.406
+ PS=3.38 PD=3.38
M$797 VDD VDD VDD VDD sky130_fd_pr__pfet_01v8_lvt L=0.6 W=1.4 AS=0.406 AD=0.406
+ PS=3.38 PD=3.38
M$798 VDD VDD VDD VDD sky130_fd_pr__pfet_01v8_lvt L=0.6 W=1.4 AS=0.406 AD=0.406
+ PS=3.38 PD=3.38
M$799 VDD VDD VDD VDD sky130_fd_pr__pfet_01v8_lvt L=0.6 W=1.4 AS=0.406 AD=0.406
+ PS=3.38 PD=3.38
M$800 VDD VDD VDD VDD sky130_fd_pr__pfet_01v8_lvt L=0.6 W=1.4 AS=0.406 AD=0.406
+ PS=3.38 PD=3.38
M$801 bias_a bias_a bias_a sky130_gnd sky130_fd_pr__nfet_01v8 L=0.6 W=1.4
+ AS=0.406 AD=0.406 PS=3.38 PD=3.38
M$802 bias_a bias_a bias_a sky130_gnd sky130_fd_pr__nfet_01v8 L=0.6 W=1.4
+ AS=0.406 AD=0.406 PS=3.38 PD=3.38
M$803 bias_a bias_a bias_a sky130_gnd sky130_fd_pr__nfet_01v8 L=0.6 W=1.4
+ AS=0.406 AD=0.406 PS=3.38 PD=3.38
M$804 bias_a bias_a bias_a sky130_gnd sky130_fd_pr__nfet_01v8 L=0.6 W=1.4
+ AS=0.406 AD=0.406 PS=3.38 PD=3.38
M$805 \$342 VSS VSS sky130_gnd sky130_fd_pr__nfet_01v8 L=0.6 W=1.4 AS=0.406
+ AD=0.406 PS=3.38 PD=3.38
M$806 \$342 VSS VSS sky130_gnd sky130_fd_pr__nfet_01v8 L=0.6 W=1.4 AS=0.406
+ AD=0.406 PS=3.38 PD=3.38
M$807 \$342 VSS VSS sky130_gnd sky130_fd_pr__nfet_01v8 L=0.6 W=1.4 AS=0.406
+ AD=0.406 PS=3.38 PD=3.38
M$808 \$342 VSS VSS sky130_gnd sky130_fd_pr__nfet_01v8 L=0.6 W=1.4 AS=0.406
+ AD=0.406 PS=3.38 PD=3.38
M$809 \$342 VSS VSS sky130_gnd sky130_fd_pr__nfet_01v8 L=0.6 W=1.4 AS=0.406
+ AD=0.406 PS=3.38 PD=3.38
M$810 \$342 VSS VSS sky130_gnd sky130_fd_pr__nfet_01v8 L=0.6 W=1.4 AS=0.406
+ AD=0.406 PS=3.38 PD=3.38
M$811 \$342 \$342 \$342 sky130_gnd sky130_fd_pr__nfet_01v8 L=0.6 W=1.4 AS=0.406
+ AD=0.406 PS=3.38 PD=3.38
M$812 \$342 \$342 \$342 sky130_gnd sky130_fd_pr__nfet_01v8 L=0.6 W=1.4 AS=0.406
+ AD=0.406 PS=3.38 PD=3.38
M$813 \$342 \$342 \$342 sky130_gnd sky130_fd_pr__nfet_01v8 L=0.6 W=1.4 AS=0.406
+ AD=0.406 PS=3.38 PD=3.38
M$814 \$342 \$342 \$342 sky130_gnd sky130_fd_pr__nfet_01v8 L=0.6 W=1.4 AS=0.406
+ AD=0.406 PS=3.38 PD=3.38
M$815 \$342 \$342 \$342 sky130_gnd sky130_fd_pr__nfet_01v8 L=0.6 W=1.4 AS=0.406
+ AD=0.406 PS=3.38 PD=3.38
M$816 \$342 \$342 \$342 sky130_gnd sky130_fd_pr__nfet_01v8 L=0.6 W=1.4 AS=0.406
+ AD=0.406 PS=3.38 PD=3.38
M$817 \$61 \$61 \$61 sky130_gnd sky130_fd_pr__nfet_01v8 L=0.6 W=1.4 AS=0.406
+ AD=0.406 PS=3.38 PD=3.38
M$818 \$61 \$61 \$61 sky130_gnd sky130_fd_pr__nfet_01v8 L=0.6 W=1.4 AS=0.406
+ AD=0.406 PS=3.38 PD=3.38
M$819 \$61 \$61 \$61 sky130_gnd sky130_fd_pr__nfet_01v8 L=0.6 W=1.4 AS=0.406
+ AD=0.406 PS=3.38 PD=3.38
M$820 \$61 \$61 \$61 sky130_gnd sky130_fd_pr__nfet_01v8 L=0.6 W=1.4 AS=0.406
+ AD=0.406 PS=3.38 PD=3.38
M$821 \$61 \$61 \$61 sky130_gnd sky130_fd_pr__nfet_01v8 L=0.6 W=1.4 AS=0.406
+ AD=0.406 PS=3.38 PD=3.38
M$822 \$61 \$61 \$61 sky130_gnd sky130_fd_pr__nfet_01v8 L=0.6 W=1.4 AS=0.406
+ AD=0.406 PS=3.38 PD=3.38
M$823 \$149 VSS VSS sky130_gnd sky130_fd_pr__nfet_01v8 L=0.6 W=1.4 AS=0.406
+ AD=0.406 PS=3.38 PD=3.38
M$824 \$149 VSS VSS sky130_gnd sky130_fd_pr__nfet_01v8 L=0.6 W=1.4 AS=0.406
+ AD=0.406 PS=3.38 PD=3.38
M$825 \$149 VSS VSS sky130_gnd sky130_fd_pr__nfet_01v8 L=0.6 W=1.4 AS=0.406
+ AD=0.406 PS=3.38 PD=3.38
M$826 \$149 VSS VSS sky130_gnd sky130_fd_pr__nfet_01v8 L=0.6 W=1.4 AS=0.406
+ AD=0.406 PS=3.38 PD=3.38
M$827 \$149 VSS VSS sky130_gnd sky130_fd_pr__nfet_01v8 L=0.6 W=1.4 AS=0.406
+ AD=0.406 PS=3.38 PD=3.38
M$828 \$149 VSS VSS sky130_gnd sky130_fd_pr__nfet_01v8 L=0.6 W=1.4 AS=0.406
+ AD=0.406 PS=3.38 PD=3.38
M$829 cm cm cm sky130_gnd sky130_fd_pr__nfet_01v8 L=0.6 W=1.4 AS=0.406 AD=0.406
+ PS=3.38 PD=3.38
M$830 cm cm cm sky130_gnd sky130_fd_pr__nfet_01v8 L=0.6 W=1.4 AS=0.406 AD=0.406
+ PS=3.38 PD=3.38
M$831 cm cm cm sky130_gnd sky130_fd_pr__nfet_01v8 L=0.6 W=1.4 AS=0.406 AD=0.406
+ PS=3.38 PD=3.38
M$832 cm cm cm sky130_gnd sky130_fd_pr__nfet_01v8 L=0.6 W=1.4 AS=0.406 AD=0.406
+ PS=3.38 PD=3.38
M$833 cm cm cm sky130_gnd sky130_fd_pr__nfet_01v8 L=0.6 W=1.4 AS=0.406 AD=0.406
+ PS=3.38 PD=3.38
M$834 cm cm cm sky130_gnd sky130_fd_pr__nfet_01v8 L=0.6 W=1.4 AS=0.406 AD=0.406
+ PS=3.38 PD=3.38
M$835 cm cm cm sky130_gnd sky130_fd_pr__nfet_01v8 L=0.6 W=1.4 AS=0.406 AD=0.406
+ PS=3.38 PD=3.38
M$836 cm cm cm sky130_gnd sky130_fd_pr__nfet_01v8 L=0.6 W=1.4 AS=0.406 AD=0.406
+ PS=3.38 PD=3.38
M$837 \$388 \$388 \$388 sky130_gnd sky130_fd_pr__nfet_01v8 L=0.6 W=1.4 AS=0.406
+ AD=0.406 PS=3.38 PD=3.38
M$838 \$388 \$388 \$388 sky130_gnd sky130_fd_pr__nfet_01v8 L=0.6 W=1.4 AS=0.406
+ AD=0.406 PS=3.38 PD=3.38
M$839 \$388 \$388 \$388 sky130_gnd sky130_fd_pr__nfet_01v8 L=0.6 W=1.4 AS=0.406
+ AD=0.406 PS=3.38 PD=3.38
M$840 \$388 \$388 \$388 sky130_gnd sky130_fd_pr__nfet_01v8 L=0.6 W=1.4 AS=0.406
+ AD=0.406 PS=3.38 PD=3.38
M$841 \$388 \$388 \$388 sky130_gnd sky130_fd_pr__nfet_01v8 L=0.6 W=1.4 AS=0.406
+ AD=0.406 PS=3.38 PD=3.38
M$842 \$388 \$388 \$388 sky130_gnd sky130_fd_pr__nfet_01v8 L=0.6 W=1.4 AS=0.406
+ AD=0.406 PS=3.38 PD=3.38
M$843 \$388 \$388 \$388 sky130_gnd sky130_fd_pr__nfet_01v8 L=0.6 W=1.4 AS=0.406
+ AD=0.406 PS=3.38 PD=3.38
M$844 \$388 \$388 \$388 sky130_gnd sky130_fd_pr__nfet_01v8 L=0.6 W=1.4 AS=0.406
+ AD=0.406 PS=3.38 PD=3.38
M$845 \$148 VSS VSS sky130_gnd sky130_fd_pr__nfet_01v8 L=0.6 W=1.4 AS=0.406
+ AD=0.406 PS=3.38 PD=3.38
M$846 \$148 VSS VSS sky130_gnd sky130_fd_pr__nfet_01v8 L=0.6 W=1.4 AS=0.406
+ AD=0.406 PS=3.38 PD=3.38
M$847 \$148 VSS VSS sky130_gnd sky130_fd_pr__nfet_01v8 L=0.6 W=1.4 AS=0.406
+ AD=0.406 PS=3.38 PD=3.38
M$848 \$148 VSS VSS sky130_gnd sky130_fd_pr__nfet_01v8 L=0.6 W=1.4 AS=0.406
+ AD=0.406 PS=3.38 PD=3.38
M$849 \$148 VSS VSS sky130_gnd sky130_fd_pr__nfet_01v8 L=0.6 W=1.4 AS=0.406
+ AD=0.406 PS=3.38 PD=3.38
M$850 \$148 VSS VSS sky130_gnd sky130_fd_pr__nfet_01v8 L=0.6 W=1.4 AS=0.406
+ AD=0.406 PS=3.38 PD=3.38
M$851 \$148 VSS VSS sky130_gnd sky130_fd_pr__nfet_01v8 L=0.6 W=1.4 AS=0.406
+ AD=0.406 PS=3.38 PD=3.38
M$852 \$148 VSS VSS sky130_gnd sky130_fd_pr__nfet_01v8 L=0.6 W=1.4 AS=0.406
+ AD=0.406 PS=3.38 PD=3.38
M$853 VSS VSS VSS sky130_gnd sky130_fd_pr__nfet_01v8 L=0.6 W=1.4 AS=0.406
+ AD=0.406 PS=3.38 PD=3.38
M$854 VSS VSS VSS sky130_gnd sky130_fd_pr__nfet_01v8 L=0.6 W=1.4 AS=0.406
+ AD=0.406 PS=3.38 PD=3.38
M$855 VSS VSS VSS sky130_gnd sky130_fd_pr__nfet_01v8 L=0.6 W=1.4 AS=0.406
+ AD=0.406 PS=3.38 PD=3.38
M$856 VSS VSS VSS sky130_gnd sky130_fd_pr__nfet_01v8 L=0.6 W=1.4 AS=0.406
+ AD=0.406 PS=3.38 PD=3.38
M$857 VSS VSS VSS sky130_gnd sky130_fd_pr__nfet_01v8 L=0.6 W=1.4 AS=0.406
+ AD=0.406 PS=3.38 PD=3.38
M$858 VSS VSS VSS sky130_gnd sky130_fd_pr__nfet_01v8 L=0.6 W=1.4 AS=0.406
+ AD=0.406 PS=3.38 PD=3.38
M$859 VSS VSS VSS sky130_gnd sky130_fd_pr__nfet_01v8 L=0.6 W=1.4 AS=0.406
+ AD=0.406 PS=3.38 PD=3.38
M$860 VSS VSS VSS sky130_gnd sky130_fd_pr__nfet_01v8 L=0.6 W=1.4 AS=0.406
+ AD=0.406 PS=3.38 PD=3.38
M$861 VSS VSS VSS sky130_gnd sky130_fd_pr__nfet_01v8 L=0.6 W=1.4 AS=0.406
+ AD=0.406 PS=3.38 PD=3.38
M$862 VSS VSS VSS sky130_gnd sky130_fd_pr__nfet_01v8 L=0.6 W=1.4 AS=0.406
+ AD=0.406 PS=3.38 PD=3.38
M$863 VSS VSS VSS sky130_gnd sky130_fd_pr__nfet_01v8 L=0.6 W=1.4 AS=0.406
+ AD=0.406 PS=3.38 PD=3.38
M$864 VSS VSS VSS sky130_gnd sky130_fd_pr__nfet_01v8 L=0.6 W=1.4 AS=0.406
+ AD=0.406 PS=3.38 PD=3.38
M$865 VSS VSS VSS sky130_gnd sky130_fd_pr__nfet_01v8 L=0.6 W=1.4 AS=0.406
+ AD=0.406 PS=3.38 PD=3.38
M$866 VSS VSS VSS sky130_gnd sky130_fd_pr__nfet_01v8 L=0.6 W=1.4 AS=0.406
+ AD=0.406 PS=3.38 PD=3.38
M$867 VSS VSS VSS sky130_gnd sky130_fd_pr__nfet_01v8 L=0.6 W=1.4 AS=0.406
+ AD=0.406 PS=3.38 PD=3.38
M$868 VSS VSS VSS sky130_gnd sky130_fd_pr__nfet_01v8 L=0.6 W=1.4 AS=0.406
+ AD=0.406 PS=3.38 PD=3.38
M$869 VSS VSS VSS sky130_gnd sky130_fd_pr__nfet_01v8 L=0.6 W=1.4 AS=0.406
+ AD=0.406 PS=3.38 PD=3.38
M$870 VSS VSS VSS sky130_gnd sky130_fd_pr__nfet_01v8 L=0.6 W=1.4 AS=0.406
+ AD=0.406 PS=3.38 PD=3.38
M$871 VSS VSS VSS sky130_gnd sky130_fd_pr__nfet_01v8 L=0.6 W=1.4 AS=0.406
+ AD=0.406 PS=3.38 PD=3.38
M$872 VSS VSS VSS sky130_gnd sky130_fd_pr__nfet_01v8 L=0.6 W=1.4 AS=0.406
+ AD=0.406 PS=3.38 PD=3.38
M$873 VSS VSS VSS sky130_gnd sky130_fd_pr__nfet_01v8 L=0.6 W=1.4 AS=0.406
+ AD=0.406 PS=3.38 PD=3.38
M$874 VSS VSS VSS sky130_gnd sky130_fd_pr__nfet_01v8 L=0.6 W=1.4 AS=0.406
+ AD=0.406 PS=3.38 PD=3.38
M$875 VSS VSS VSS sky130_gnd sky130_fd_pr__nfet_01v8 L=0.6 W=1.4 AS=0.406
+ AD=0.406 PS=3.38 PD=3.38
.ENDS iadc_ota_routed
