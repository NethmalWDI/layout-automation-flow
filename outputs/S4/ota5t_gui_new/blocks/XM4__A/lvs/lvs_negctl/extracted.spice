* NGSPICE file created from XM4__A.ext - technology: sky130A

.subckt sky130_fd_pr__pfet_01v8_8HDVAE G D w_n194_n900# S
X0 S G D w_n194_n900# sky130_fd_pr__pfet_01v8 ad=2.32 pd=16.58 as=2.32 ps=16.58 w=8 l=1
.ends

.subckt pfet_01v8_W8_L1_m1__nf1_gboth_sdfull_ng S B G D
Xpfet_01v8_W8_L1_m1__nf1_gboth_sdfull_ng_pc G D B S sky130_fd_pr__pfet_01v8_8HDVAE
.ends

.subckt XM4__A net3 OUTP VDD VDD_body
Xpfet_01v8_W8_L1_m1__nf1_gboth_sdfull_ng_0 VDD VDD_body net3 OUTP pfet_01v8_W8_L1_m1__nf1_gboth_sdfull_ng
.ends
