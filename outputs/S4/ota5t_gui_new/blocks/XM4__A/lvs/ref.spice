.subckt XM4__A OUTP VDD net3 VDD_body
XXM4 OUTP net3 VDD VDD_body sky130_fd_pr__pfet_01v8 L=1 W=8 nf=1
.ends
