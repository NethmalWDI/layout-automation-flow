.subckt XM5__A VSS net1 net2 VSS_body
XXM5 net1 net2 VSS VSS_body sky130_fd_pr__nfet_01v8 L=1.1 W=24 nf=1
.ends
