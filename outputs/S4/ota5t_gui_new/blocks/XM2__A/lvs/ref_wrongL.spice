.subckt XM2__A INN OUTP net1 VSS_body
XXM2 OUTP INN net1 VSS_body sky130_fd_pr__nfet_01v8 L=0.6 W=24 nf=2
.ends
