* NGSPICE file created from XM2__A.ext - technology: sky130A

.subckt sky130_fd_pr__nfet_01v8_BXZS2L a_129_n1200# G D0 S1 VSUBS
X0 S1 G D0 VSUBS sky130_fd_pr__nfet_01v8 ad=1.74 pd=12.29 as=3.48 ps=24.58 w=12 l=0.5
X1 a_129_n1200# G S1 VSUBS sky130_fd_pr__nfet_01v8 ad=3.48 pd=24.58 as=1.74 ps=12.29 w=12 l=0.5
.ends

.subckt nfet_01v8_W24_L0p5_m1__nf2_gboth_sdfull_outS_ng B G S D
Xnfet_01v8_W24_L0p5_m1__nf2_gboth_sdfull_outS_ng_pc S G S D B sky130_fd_pr__nfet_01v8_BXZS2L
.ends

.subckt XM2__A net1 INN OUTP VSS_body
Xnfet_01v8_W24_L0p5_m1__nf2_gboth_sdfull_outS_ng_0 VSS_body INN net1 OUTP nfet_01v8_W24_L0p5_m1__nf2_gboth_sdfull_outS_ng
.ends
