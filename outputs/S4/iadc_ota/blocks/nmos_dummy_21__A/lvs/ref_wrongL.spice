.subckt nmos_dummy_21__A VSS on VSS_body
XXX2_M81 on VSS VSS VSS_body sky130_fd_pr__nfet_01v8 L=0.7 W=1.4 nf=1 m=2
.ends
