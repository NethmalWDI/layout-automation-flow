.subckt nmos_dummy_5__A bias_d VSS_body
XXX1_M34 bias_d bias_d bias_d VSS_body sky130_fd_pr__nfet_01v8 L=0.7 W=1.4 nf=1 m=8
.ends
