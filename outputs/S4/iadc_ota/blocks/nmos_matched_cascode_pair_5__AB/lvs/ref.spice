.subckt nmos_matched_cascode_pair_5__AB VSS cm x1_net5 x1_net6 VSS_body
XXX1_M70 x1_net5 cm x1_net6 VSS_body sky130_fd_pr__nfet_01v8 L=0.6 W=1.4 nf=1
XXX1_M71 x1_net6 cm VSS VSS_body sky130_fd_pr__nfet_01v8 L=0.6 W=1.4 nf=1
Xnmos_matched_cascode_pair_5_DUMMY0 VSS VSS VSS VSS_body sky130_fd_pr__nfet_01v8 L=0.6 W=1.4 nf=1
Xnmos_matched_cascode_pair_5_DUMMY1 VSS VSS VSS VSS_body sky130_fd_pr__nfet_01v8 L=0.6 W=1.4 nf=1
.ends
