.subckt pmos_dummy_9__A VDD x1_m2d VDD_body
XXX1_M58 x1_m2d VDD VDD VDD_body sky130_fd_pr__pfet_01v8 L=0.6 W=1.4 nf=1 m=2
.ends
