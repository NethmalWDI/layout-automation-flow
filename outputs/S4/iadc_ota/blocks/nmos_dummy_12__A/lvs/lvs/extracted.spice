* NGSPICE file created from nmos_dummy_12__A.ext - technology: sky130A

.subckt sky130_fd_pr__nfet_01v8_lvt_CWMMG4 G D S VSUBS
X0 S G D VSUBS sky130_fd_pr__nfet_01v8_lvt ad=0.348 pd=2.98 as=0.348 ps=2.98 w=1.2 l=0.2
.ends

.subckt nfet_01v8_lvt_W1p2_L0p2_m2__nf1_gtop_sdfull_ng B G D S
Xnfet_01v8_lvt_W1p2_L0p2_m2__nf1_gtop_sdfull_ng_pc G D S B sky130_fd_pr__nfet_01v8_lvt_CWMMG4
.ends

.subckt nmos_dummy_12__A x2_foldp VSS_body
Xnfet_01v8_lvt_W1p2_L0p2_m2__nf1_gtop_sdfull_ng_0 VSS_body x2_foldp x2_foldp x2_foldp
+ nfet_01v8_lvt_W1p2_L0p2_m2__nf1_gtop_sdfull_ng
Xnfet_01v8_lvt_W1p2_L0p2_m2__nf1_gtop_sdfull_ng_1 VSS_body x2_foldp x2_foldp x2_foldp
+ nfet_01v8_lvt_W1p2_L0p2_m2__nf1_gtop_sdfull_ng
.ends
