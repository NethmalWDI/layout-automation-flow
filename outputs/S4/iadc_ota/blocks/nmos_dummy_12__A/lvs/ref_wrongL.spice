.subckt nmos_dummy_12__A x2_foldp VSS_body
XXX2_M23 x2_foldp x2_foldp x2_foldp VSS_body sky130_fd_pr__nfet_01v8_lvt L=0.3 W=1.2 nf=1 m=2
.ends
