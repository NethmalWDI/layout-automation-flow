.subckt nmos_dummy_9__A VSS x1_m5d VSS_body
XXX1_M42 x1_m5d VSS VSS VSS_body sky130_fd_pr__nfet_01v8 L=0.6 W=1.4 nf=1 m=6
.ends
