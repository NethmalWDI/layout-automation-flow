.subckt nmos_differential_pair__ABBA VSS in ip x2_foldn x2_foldp x2_tail VSS_body
XXX2_M1 x2_foldp ip x2_tail VSS_body sky130_fd_pr__nfet_01v8_lvt L=0.2 W=1.2 nf=1 m=6
XXX2_M2 x2_foldn in x2_tail VSS_body sky130_fd_pr__nfet_01v8_lvt L=0.2 W=1.2 nf=1 m=6
Xnmos_differential_pair_DUMMY0 VSS VSS VSS VSS_body sky130_fd_pr__nfet_01v8_lvt L=0.2 W=1.2 nf=1
Xnmos_differential_pair_DUMMY1 VSS VSS VSS VSS_body sky130_fd_pr__nfet_01v8_lvt L=0.2 W=1.2 nf=1
.ends
