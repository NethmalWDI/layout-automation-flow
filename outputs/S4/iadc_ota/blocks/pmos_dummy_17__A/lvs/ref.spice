.subckt pmos_dummy_17__A x2_foldp VDD_body
XXX2_M83 x2_foldp x2_foldp x2_foldp VDD_body sky130_fd_pr__pfet_01v8 L=0.6 W=1.4 nf=1 m=2
.ends
