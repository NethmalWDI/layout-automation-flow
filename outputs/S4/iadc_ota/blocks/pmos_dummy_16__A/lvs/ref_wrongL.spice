.subckt pmos_dummy_16__A x2_foldn VDD_body
XXX2_M82 x2_foldn x2_foldn x2_foldn VDD_body sky130_fd_pr__pfet_01v8 L=0.7 W=1.4 nf=1 m=2
.ends
