.subckt pmos_dummy_4__A x1_m25d VDD_body
XXX1_M47 x1_m25d x1_m25d x1_m25d VDD_body sky130_fd_pr__pfet_01v8_lvt L=0.6 W=1.4 nf=1 m=2
.ends
