.subckt nmos_single__A bias_a bias_d x1_m2d VSS_body
XXX1_M3 bias_d x1_m2d bias_a VSS_body sky130_fd_pr__nfet_01v8 L=0.7 W=1.4 nf=1 m=2
.ends
