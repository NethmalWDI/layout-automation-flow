.subckt nmos_dummy_11__A i_bias VSS_body
XXX1_M8 i_bias i_bias i_bias VSS_body sky130_fd_pr__nfet_01v8 L=0.7 W=1.4 nf=1 m=2
.ends
