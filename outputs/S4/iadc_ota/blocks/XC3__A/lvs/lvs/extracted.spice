* NGSPICE file created from XC3__A.ext - technology: sky130A

.subckt sky130_fd_pr__cap_mim_m3_1_MX4MQY C1_3 C1_2 C1_1 C1_0 C2_3 C2_2 C2_1 C2_0
X0 C1_0 C2_0 sky130_fd_pr__cap_mim_m3_1 l=4.8 w=4.8
X1 C1_2 C2_2 sky130_fd_pr__cap_mim_m3_1 l=4.8 w=4.8
X2 C1_1 C2_1 sky130_fd_pr__cap_mim_m3_1 l=4.8 w=4.8
X3 C1_3 C2_3 sky130_fd_pr__cap_mim_m3_1 l=4.8 w=4.8
.ends

.subckt XC3_mim XC3_mim_pc/C2_3 XC3_mim_pc/C2_2 XC3_mim_pc/C2_1 XC3_mim_pc/C2_0 XC3_mim_pc/C1_3
+ XC3_mim_pc/C1_1 XC3_mim_pc/C1_2 XC3_mim_pc/C1_0
XXC3_mim_pc XC3_mim_pc/C1_3 XC3_mim_pc/C1_2 XC3_mim_pc/C1_1 XC3_mim_pc/C1_0 XC3_mim_pc/C2_3
+ XC3_mim_pc/C2_2 XC3_mim_pc/C2_1 XC3_mim_pc/C2_0 sky130_fd_pr__cap_mim_m3_1_MX4MQY
.ends

.subckt XC3__A op cmc
XXC3_mim_0 cmc cmc cmc cmc op op op op XC3_mim
.ends
