.subckt nmos_matched_cascode_pair_3__AB VSS cm x1_net2 x1_net3 VSS_body
XXX1_M50 x1_net2 cm x1_net3 VSS_body sky130_fd_pr__nfet_01v8 L=0.6 W=1.4 nf=1
XXX1_M63 x1_net3 cm VSS VSS_body sky130_fd_pr__nfet_01v8 L=0.6 W=1.4 nf=1
Xnmos_matched_cascode_pair_3_DUMMY0 VSS VSS VSS VSS_body sky130_fd_pr__nfet_01v8 L=0.6 W=1.4 nf=1
Xnmos_matched_cascode_pair_3_DUMMY1 VSS VSS VSS VSS_body sky130_fd_pr__nfet_01v8 L=0.6 W=1.4 nf=1
.ends
