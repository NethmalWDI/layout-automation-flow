.subckt pmos_dummy_10__A VDD cm VDD_body
XXX1_M59 cm VDD VDD VDD_body sky130_fd_pr__pfet_01v8 L=0.6 W=1.4 nf=1 m=2
.ends
