.subckt nmos_dummy_17__A on VSS_body
XXX2_M39 on on on VSS_body sky130_fd_pr__nfet_01v8 L=0.7 W=1.4 nf=1 m=2
.ends
