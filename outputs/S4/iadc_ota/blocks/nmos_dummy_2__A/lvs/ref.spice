.subckt nmos_dummy_2__A bias_c VSS_body
XXX1_M10 bias_c bias_c bias_c VSS_body sky130_fd_pr__nfet_01v8_lvt L=0.6 W=1.4 nf=1 m=8
.ends
