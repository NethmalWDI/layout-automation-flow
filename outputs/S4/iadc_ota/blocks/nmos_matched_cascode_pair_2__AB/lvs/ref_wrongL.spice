.subckt nmos_matched_cascode_pair_2__AB VSS cm x1_net1 x1_net2 VSS_body
XXX1_M33 cm cm x1_net1 VSS_body sky130_fd_pr__nfet_01v8 L=0.7 W=1.4 nf=1
XXX1_M49 x1_net1 cm x1_net2 VSS_body sky130_fd_pr__nfet_01v8 L=0.6 W=1.4 nf=1
Xnmos_matched_cascode_pair_2_DUMMY0 VSS VSS VSS VSS_body sky130_fd_pr__nfet_01v8 L=0.6 W=1.4 nf=1
Xnmos_matched_cascode_pair_2_DUMMY1 VSS VSS VSS VSS_body sky130_fd_pr__nfet_01v8 L=0.6 W=1.4 nf=1
.ends
