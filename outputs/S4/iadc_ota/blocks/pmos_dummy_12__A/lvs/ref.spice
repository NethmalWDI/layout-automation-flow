.subckt pmos_dummy_12__A VDD x2_foldn VDD_body
XXX2_M55 x2_foldn VDD VDD VDD_body sky130_fd_pr__pfet_01v8 L=0.6 W=1.4 nf=1 m=2
.ends
