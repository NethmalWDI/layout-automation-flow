.subckt nmos_dummy_8__A cm VSS_body
XXX1_M37 cm cm cm VSS_body sky130_fd_pr__nfet_01v8 L=0.7 W=1.4 nf=1 m=8
.ends
