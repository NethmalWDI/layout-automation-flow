.subckt nmos_matched_cascode_pair_8__AB VSS cm x1_net10 x1_net11 VSS_body
XXX1_M76 cm cm x1_net10 VSS_body sky130_fd_pr__nfet_01v8 L=0.7 W=1.4 nf=1
XXX1_M77 x1_net10 cm x1_net11 VSS_body sky130_fd_pr__nfet_01v8 L=0.6 W=1.4 nf=1
Xnmos_matched_cascode_pair_8_DUMMY0 VSS VSS VSS VSS_body sky130_fd_pr__nfet_01v8 L=0.6 W=1.4 nf=1
Xnmos_matched_cascode_pair_8_DUMMY1 VSS VSS VSS VSS_body sky130_fd_pr__nfet_01v8 L=0.6 W=1.4 nf=1
.ends
