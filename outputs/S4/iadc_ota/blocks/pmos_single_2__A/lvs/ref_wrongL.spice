.subckt pmos_single_2__A bias_c cm x1_m31d VDD_body
XXX1_M32 cm bias_c x1_m31d VDD_body sky130_fd_pr__pfet_01v8 L=0.7 W=1.4 nf=1 m=6
.ends
