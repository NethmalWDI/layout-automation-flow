.subckt nmos_dummy_6__A x1_m2d VSS_body
XXX1_M35 x1_m2d x1_m2d x1_m2d VSS_body sky130_fd_pr__nfet_01v8 L=0.6 W=1.4 nf=1 m=2
.ends
