.subckt pmos_dummy_7__A x1_m25d VDD_body
XXX1_M54 x1_m25d x1_m25d x1_m25d VDD_body sky130_fd_pr__pfet_01v8 L=0.7 W=1.4 nf=1 m=2
.ends
