.subckt nmos_matched_cascode_pair_6__AB VSS cm x1_net7 x1_net8 VSS_body
XXX1_M72 cm cm x1_net7 VSS_body sky130_fd_pr__nfet_01v8 L=0.6 W=1.4 nf=1
XXX1_M73 x1_net7 cm x1_net8 VSS_body sky130_fd_pr__nfet_01v8 L=0.6 W=1.4 nf=1
Xnmos_matched_cascode_pair_6_DUMMY0 VSS VSS VSS VSS_body sky130_fd_pr__nfet_01v8 L=0.6 W=1.4 nf=1
Xnmos_matched_cascode_pair_6_DUMMY1 VSS VSS VSS VSS_body sky130_fd_pr__nfet_01v8 L=0.6 W=1.4 nf=1
.ends
