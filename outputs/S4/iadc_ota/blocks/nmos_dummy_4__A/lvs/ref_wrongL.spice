.subckt nmos_dummy_4__A x1_m5d VSS_body
XXX1_M29 x1_m5d x1_m5d x1_m5d VSS_body sky130_fd_pr__nfet_01v8 L=0.7 W=1.4 nf=1 m=6
.ends
