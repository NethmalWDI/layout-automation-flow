* NGSPICE file created from nmos_differential_pair__ABAB.ext - technology: sky130A

.subckt sky130_fd_pr__nfet_01v8_lvt_A2K2V3 G D S VSUBS
X0 S G D VSUBS sky130_fd_pr__nfet_01v8_lvt ad=0.348 pd=2.98 as=0.348 ps=2.98 w=1.2 l=0.2
.ends

.subckt nfet_01v8_lvt_W1p2_L0p2_m6__nf1_gboth_sdfull_ng G B D S
Xnfet_01v8_lvt_W1p2_L0p2_m6__nf1_gboth_sdfull_ng_pc G D S B sky130_fd_pr__nfet_01v8_lvt_A2K2V3
.ends

.subckt nmos_differential_pair__ABAB VSS ip in x2_foldp x2_tail x2_foldn VSS_body
Xnfet_01v8_lvt_W1p2_L0p2_m6__nf1_gboth_sdfull_ng_10 in VSS_body x2_foldn x2_tail nfet_01v8_lvt_W1p2_L0p2_m6__nf1_gboth_sdfull_ng
Xnfet_01v8_lvt_W1p2_L0p2_m6__nf1_gboth_sdfull_ng_11 ip VSS_body x2_foldp x2_tail nfet_01v8_lvt_W1p2_L0p2_m6__nf1_gboth_sdfull_ng
Xnfet_01v8_lvt_W1p2_L0p2_m6__nf1_gboth_sdfull_ng_13 VSS VSS_body VSS VSS nfet_01v8_lvt_W1p2_L0p2_m6__nf1_gboth_sdfull_ng
Xnfet_01v8_lvt_W1p2_L0p2_m6__nf1_gboth_sdfull_ng_12 in VSS_body x2_foldn x2_tail nfet_01v8_lvt_W1p2_L0p2_m6__nf1_gboth_sdfull_ng
Xnfet_01v8_lvt_W1p2_L0p2_m6__nf1_gboth_sdfull_ng_0 VSS VSS_body VSS VSS nfet_01v8_lvt_W1p2_L0p2_m6__nf1_gboth_sdfull_ng
Xnfet_01v8_lvt_W1p2_L0p2_m6__nf1_gboth_sdfull_ng_1 ip VSS_body x2_foldp x2_tail nfet_01v8_lvt_W1p2_L0p2_m6__nf1_gboth_sdfull_ng
Xnfet_01v8_lvt_W1p2_L0p2_m6__nf1_gboth_sdfull_ng_2 in VSS_body x2_foldn x2_tail nfet_01v8_lvt_W1p2_L0p2_m6__nf1_gboth_sdfull_ng
Xnfet_01v8_lvt_W1p2_L0p2_m6__nf1_gboth_sdfull_ng_4 in VSS_body x2_foldn x2_tail nfet_01v8_lvt_W1p2_L0p2_m6__nf1_gboth_sdfull_ng
Xnfet_01v8_lvt_W1p2_L0p2_m6__nf1_gboth_sdfull_ng_3 ip VSS_body x2_foldp x2_tail nfet_01v8_lvt_W1p2_L0p2_m6__nf1_gboth_sdfull_ng
Xnfet_01v8_lvt_W1p2_L0p2_m6__nf1_gboth_sdfull_ng_5 ip VSS_body x2_foldp x2_tail nfet_01v8_lvt_W1p2_L0p2_m6__nf1_gboth_sdfull_ng
Xnfet_01v8_lvt_W1p2_L0p2_m6__nf1_gboth_sdfull_ng_6 in VSS_body x2_foldn x2_tail nfet_01v8_lvt_W1p2_L0p2_m6__nf1_gboth_sdfull_ng
Xnfet_01v8_lvt_W1p2_L0p2_m6__nf1_gboth_sdfull_ng_7 ip VSS_body x2_foldp x2_tail nfet_01v8_lvt_W1p2_L0p2_m6__nf1_gboth_sdfull_ng
Xnfet_01v8_lvt_W1p2_L0p2_m6__nf1_gboth_sdfull_ng_8 in VSS_body x2_foldn x2_tail nfet_01v8_lvt_W1p2_L0p2_m6__nf1_gboth_sdfull_ng
Xnfet_01v8_lvt_W1p2_L0p2_m6__nf1_gboth_sdfull_ng_9 ip VSS_body x2_foldp x2_tail nfet_01v8_lvt_W1p2_L0p2_m6__nf1_gboth_sdfull_ng
.ends
