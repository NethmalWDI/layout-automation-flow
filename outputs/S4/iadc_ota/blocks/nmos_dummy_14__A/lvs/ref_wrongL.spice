.subckt nmos_dummy_14__A x2_tail VSS_body
XXX2_M28 x2_tail x2_tail x2_tail VSS_body sky130_fd_pr__nfet_01v8 L=0.7 W=1.4 nf=1 m=6
.ends
