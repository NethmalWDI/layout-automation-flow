.subckt pmos_dummy_8__A VDD bias_b VDD_body
XXX1_M57 bias_b VDD VDD VDD_body sky130_fd_pr__pfet_01v8 L=0.6 W=1.4 nf=1 m=2
.ends
