.subckt pmos_single__A VDD bias_b x1_m31d VDD_body
XXX1_M31 x1_m31d bias_b VDD VDD_body sky130_fd_pr__pfet_01v8_lvt L=0.6 W=1.4 nf=1 m=6
.ends
