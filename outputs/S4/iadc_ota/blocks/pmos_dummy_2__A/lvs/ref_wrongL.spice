.subckt pmos_dummy_2__A VDD VDD_body
XXM45 VDD VDD VDD VDD_body sky130_fd_pr__pfet_01v8 L=0.7 W=1.4 nf=1 m=6
.ends
