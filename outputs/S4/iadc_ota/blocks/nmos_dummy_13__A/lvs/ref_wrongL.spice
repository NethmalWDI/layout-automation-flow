.subckt nmos_dummy_13__A x2_foldn VSS_body
XXX2_M24 x2_foldn x2_foldn x2_foldn VSS_body sky130_fd_pr__nfet_01v8_lvt L=0.3 W=1.2 nf=1 m=2
.ends
