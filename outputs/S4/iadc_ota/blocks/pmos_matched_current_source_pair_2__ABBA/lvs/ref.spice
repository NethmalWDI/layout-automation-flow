.subckt pmos_matched_current_source_pair_2__ABBA VDD bias_b x2_foldn x2_foldp VDD_body
XXX2_M11 x2_foldp bias_b VDD VDD_body sky130_fd_pr__pfet_01v8_lvt L=0.6 W=1.4 nf=1 m=24
XXX2_M12 x2_foldn bias_b VDD VDD_body sky130_fd_pr__pfet_01v8_lvt L=0.6 W=1.4 nf=1 m=24
Xpmos_matched_current_source_pair_2_DUMMY0 VDD VDD VDD VDD_body sky130_fd_pr__pfet_01v8_lvt L=0.6 W=1.4 nf=1
Xpmos_matched_current_source_pair_2_DUMMY1 VDD VDD VDD VDD_body sky130_fd_pr__pfet_01v8_lvt L=0.6 W=1.4 nf=1
.ends
