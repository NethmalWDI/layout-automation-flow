.subckt nmos_dummy_15__A VSS x2_tail VSS_body
XXX2_M30 x2_tail VSS VSS VSS_body sky130_fd_pr__nfet_01v8 L=0.7 W=1.4 nf=1 m=2
.ends
