* NGSPICE file created from pmos_matched_cascode_pair_2__ABAB.ext - technology: sky130A

.subckt sky130_fd_pr__pfet_01v8_RGDEC8 G D w_n154_n240# S
X0 S G D w_n154_n240# sky130_fd_pr__pfet_01v8 ad=0.406 pd=3.38 as=0.406 ps=3.38 w=1.4 l=0.6
.ends

.subckt pfet_01v8_W1p4_L0p6_m20__nf1_gboth_sdfull_ng B G D S
Xpfet_01v8_W1p4_L0p6_m20__nf1_gboth_sdfull_ng_pc G D B S sky130_fd_pr__pfet_01v8_RGDEC8
.ends

.subckt pmos_matched_cascode_pair_2__ABAB VDD bias_c on x2_foldp op x2_foldn VDD_body
Xpfet_01v8_W1p4_L0p6_m20__nf1_gboth_sdfull_ng_40 VDD_body bias_c op x2_foldn pfet_01v8_W1p4_L0p6_m20__nf1_gboth_sdfull_ng
Xpfet_01v8_W1p4_L0p6_m20__nf1_gboth_sdfull_ng_41 VDD_body VDD VDD VDD pfet_01v8_W1p4_L0p6_m20__nf1_gboth_sdfull_ng
Xpfet_01v8_W1p4_L0p6_m20__nf1_gboth_sdfull_ng_30 VDD_body bias_c op x2_foldn pfet_01v8_W1p4_L0p6_m20__nf1_gboth_sdfull_ng
Xpfet_01v8_W1p4_L0p6_m20__nf1_gboth_sdfull_ng_31 VDD_body bias_c on x2_foldp pfet_01v8_W1p4_L0p6_m20__nf1_gboth_sdfull_ng
Xpfet_01v8_W1p4_L0p6_m20__nf1_gboth_sdfull_ng_20 VDD_body bias_c op x2_foldn pfet_01v8_W1p4_L0p6_m20__nf1_gboth_sdfull_ng
Xpfet_01v8_W1p4_L0p6_m20__nf1_gboth_sdfull_ng_32 VDD_body bias_c op x2_foldn pfet_01v8_W1p4_L0p6_m20__nf1_gboth_sdfull_ng
Xpfet_01v8_W1p4_L0p6_m20__nf1_gboth_sdfull_ng_21 VDD_body bias_c on x2_foldp pfet_01v8_W1p4_L0p6_m20__nf1_gboth_sdfull_ng
Xpfet_01v8_W1p4_L0p6_m20__nf1_gboth_sdfull_ng_10 VDD_body bias_c op x2_foldn pfet_01v8_W1p4_L0p6_m20__nf1_gboth_sdfull_ng
Xpfet_01v8_W1p4_L0p6_m20__nf1_gboth_sdfull_ng_33 VDD_body bias_c on x2_foldp pfet_01v8_W1p4_L0p6_m20__nf1_gboth_sdfull_ng
Xpfet_01v8_W1p4_L0p6_m20__nf1_gboth_sdfull_ng_22 VDD_body bias_c op x2_foldn pfet_01v8_W1p4_L0p6_m20__nf1_gboth_sdfull_ng
Xpfet_01v8_W1p4_L0p6_m20__nf1_gboth_sdfull_ng_11 VDD_body bias_c on x2_foldp pfet_01v8_W1p4_L0p6_m20__nf1_gboth_sdfull_ng
Xpfet_01v8_W1p4_L0p6_m20__nf1_gboth_sdfull_ng_34 VDD_body bias_c op x2_foldn pfet_01v8_W1p4_L0p6_m20__nf1_gboth_sdfull_ng
Xpfet_01v8_W1p4_L0p6_m20__nf1_gboth_sdfull_ng_23 VDD_body bias_c on x2_foldp pfet_01v8_W1p4_L0p6_m20__nf1_gboth_sdfull_ng
Xpfet_01v8_W1p4_L0p6_m20__nf1_gboth_sdfull_ng_12 VDD_body bias_c op x2_foldn pfet_01v8_W1p4_L0p6_m20__nf1_gboth_sdfull_ng
Xpfet_01v8_W1p4_L0p6_m20__nf1_gboth_sdfull_ng_35 VDD_body bias_c on x2_foldp pfet_01v8_W1p4_L0p6_m20__nf1_gboth_sdfull_ng
Xpfet_01v8_W1p4_L0p6_m20__nf1_gboth_sdfull_ng_24 VDD_body bias_c op x2_foldn pfet_01v8_W1p4_L0p6_m20__nf1_gboth_sdfull_ng
Xpfet_01v8_W1p4_L0p6_m20__nf1_gboth_sdfull_ng_13 VDD_body bias_c on x2_foldp pfet_01v8_W1p4_L0p6_m20__nf1_gboth_sdfull_ng
Xpfet_01v8_W1p4_L0p6_m20__nf1_gboth_sdfull_ng_36 VDD_body bias_c op x2_foldn pfet_01v8_W1p4_L0p6_m20__nf1_gboth_sdfull_ng
Xpfet_01v8_W1p4_L0p6_m20__nf1_gboth_sdfull_ng_25 VDD_body bias_c on x2_foldp pfet_01v8_W1p4_L0p6_m20__nf1_gboth_sdfull_ng
Xpfet_01v8_W1p4_L0p6_m20__nf1_gboth_sdfull_ng_14 VDD_body bias_c op x2_foldn pfet_01v8_W1p4_L0p6_m20__nf1_gboth_sdfull_ng
Xpfet_01v8_W1p4_L0p6_m20__nf1_gboth_sdfull_ng_38 VDD_body bias_c op x2_foldn pfet_01v8_W1p4_L0p6_m20__nf1_gboth_sdfull_ng
Xpfet_01v8_W1p4_L0p6_m20__nf1_gboth_sdfull_ng_37 VDD_body bias_c on x2_foldp pfet_01v8_W1p4_L0p6_m20__nf1_gboth_sdfull_ng
Xpfet_01v8_W1p4_L0p6_m20__nf1_gboth_sdfull_ng_27 VDD_body bias_c on x2_foldp pfet_01v8_W1p4_L0p6_m20__nf1_gboth_sdfull_ng
Xpfet_01v8_W1p4_L0p6_m20__nf1_gboth_sdfull_ng_26 VDD_body bias_c op x2_foldn pfet_01v8_W1p4_L0p6_m20__nf1_gboth_sdfull_ng
Xpfet_01v8_W1p4_L0p6_m20__nf1_gboth_sdfull_ng_16 VDD_body bias_c op x2_foldn pfet_01v8_W1p4_L0p6_m20__nf1_gboth_sdfull_ng
Xpfet_01v8_W1p4_L0p6_m20__nf1_gboth_sdfull_ng_15 VDD_body bias_c on x2_foldp pfet_01v8_W1p4_L0p6_m20__nf1_gboth_sdfull_ng
Xpfet_01v8_W1p4_L0p6_m20__nf1_gboth_sdfull_ng_39 VDD_body bias_c on x2_foldp pfet_01v8_W1p4_L0p6_m20__nf1_gboth_sdfull_ng
Xpfet_01v8_W1p4_L0p6_m20__nf1_gboth_sdfull_ng_28 VDD_body bias_c op x2_foldn pfet_01v8_W1p4_L0p6_m20__nf1_gboth_sdfull_ng
Xpfet_01v8_W1p4_L0p6_m20__nf1_gboth_sdfull_ng_17 VDD_body bias_c on x2_foldp pfet_01v8_W1p4_L0p6_m20__nf1_gboth_sdfull_ng
Xpfet_01v8_W1p4_L0p6_m20__nf1_gboth_sdfull_ng_29 VDD_body bias_c on x2_foldp pfet_01v8_W1p4_L0p6_m20__nf1_gboth_sdfull_ng
Xpfet_01v8_W1p4_L0p6_m20__nf1_gboth_sdfull_ng_18 VDD_body bias_c op x2_foldn pfet_01v8_W1p4_L0p6_m20__nf1_gboth_sdfull_ng
Xpfet_01v8_W1p4_L0p6_m20__nf1_gboth_sdfull_ng_19 VDD_body bias_c on x2_foldp pfet_01v8_W1p4_L0p6_m20__nf1_gboth_sdfull_ng
Xpfet_01v8_W1p4_L0p6_m20__nf1_gboth_sdfull_ng_0 VDD_body VDD VDD VDD pfet_01v8_W1p4_L0p6_m20__nf1_gboth_sdfull_ng
Xpfet_01v8_W1p4_L0p6_m20__nf1_gboth_sdfull_ng_1 VDD_body bias_c on x2_foldp pfet_01v8_W1p4_L0p6_m20__nf1_gboth_sdfull_ng
Xpfet_01v8_W1p4_L0p6_m20__nf1_gboth_sdfull_ng_2 VDD_body bias_c op x2_foldn pfet_01v8_W1p4_L0p6_m20__nf1_gboth_sdfull_ng
Xpfet_01v8_W1p4_L0p6_m20__nf1_gboth_sdfull_ng_4 VDD_body bias_c op x2_foldn pfet_01v8_W1p4_L0p6_m20__nf1_gboth_sdfull_ng
Xpfet_01v8_W1p4_L0p6_m20__nf1_gboth_sdfull_ng_3 VDD_body bias_c on x2_foldp pfet_01v8_W1p4_L0p6_m20__nf1_gboth_sdfull_ng
Xpfet_01v8_W1p4_L0p6_m20__nf1_gboth_sdfull_ng_5 VDD_body bias_c on x2_foldp pfet_01v8_W1p4_L0p6_m20__nf1_gboth_sdfull_ng
Xpfet_01v8_W1p4_L0p6_m20__nf1_gboth_sdfull_ng_6 VDD_body bias_c op x2_foldn pfet_01v8_W1p4_L0p6_m20__nf1_gboth_sdfull_ng
Xpfet_01v8_W1p4_L0p6_m20__nf1_gboth_sdfull_ng_7 VDD_body bias_c on x2_foldp pfet_01v8_W1p4_L0p6_m20__nf1_gboth_sdfull_ng
Xpfet_01v8_W1p4_L0p6_m20__nf1_gboth_sdfull_ng_8 VDD_body bias_c op x2_foldn pfet_01v8_W1p4_L0p6_m20__nf1_gboth_sdfull_ng
Xpfet_01v8_W1p4_L0p6_m20__nf1_gboth_sdfull_ng_9 VDD_body bias_c on x2_foldp pfet_01v8_W1p4_L0p6_m20__nf1_gboth_sdfull_ng
.ends
