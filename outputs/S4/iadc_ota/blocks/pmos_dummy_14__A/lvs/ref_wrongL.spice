.subckt pmos_dummy_14__A VDD x2_foldp VDD_body
XXX2_M61 x2_foldp VDD VDD VDD_body sky130_fd_pr__pfet_01v8 L=0.7 W=1.4 nf=1 m=2
.ends
