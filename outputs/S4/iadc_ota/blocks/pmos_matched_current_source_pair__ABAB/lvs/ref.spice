.subckt pmos_matched_current_source_pair__ABAB VDD bias_b x1_m21d x1_m25d VDD_body
XXX1_M21 x1_m21d bias_b VDD VDD_body sky130_fd_pr__pfet_01v8_lvt L=0.6 W=1.4 nf=1 m=6
XXX1_M25 x1_m25d bias_b VDD VDD_body sky130_fd_pr__pfet_01v8_lvt L=0.6 W=1.4 nf=1 m=6
Xpmos_matched_current_source_pair_DUMMY0 VDD VDD VDD VDD_body sky130_fd_pr__pfet_01v8_lvt L=0.6 W=1.4 nf=1
Xpmos_matched_current_source_pair_DUMMY1 VDD VDD VDD VDD_body sky130_fd_pr__pfet_01v8_lvt L=0.6 W=1.4 nf=1
.ends
