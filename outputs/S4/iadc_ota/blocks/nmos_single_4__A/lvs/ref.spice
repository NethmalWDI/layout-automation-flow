.subckt nmos_single_4__A VSS bias_a x2_tail VSS_body
XXX2_M5 x2_tail bias_a VSS VSS_body sky130_fd_pr__nfet_01v8 L=0.6 W=1.4 nf=1 m=96
.ends
