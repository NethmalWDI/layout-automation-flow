.subckt nmos_current_mirror__ABBA VSS bias_c i_bias VSS_body
XXX1_M7 i_bias i_bias VSS VSS_body sky130_fd_pr__nfet_01v8 L=0.6 W=1.4 nf=1 m=18
XXX1_M6 bias_c i_bias VSS VSS_body sky130_fd_pr__nfet_01v8 L=0.6 W=1.4 nf=1 m=18
Xnmos_current_mirror_DUMMY0 VSS VSS VSS VSS_body sky130_fd_pr__nfet_01v8 L=0.6 W=1.4 nf=1
Xnmos_current_mirror_DUMMY1 VSS VSS VSS VSS_body sky130_fd_pr__nfet_01v8 L=0.6 W=1.4 nf=1
.ends
