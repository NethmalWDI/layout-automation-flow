* NGSPICE file created from nmos_current_mirror__ABBA.ext - technology: sky130A

.subckt sky130_fd_pr__nfet_01v8_KCM6UP G D S VSUBS
X0 S G D VSUBS sky130_fd_pr__nfet_01v8 ad=0.406 pd=3.38 as=0.406 ps=3.38 w=1.4 l=0.6
.ends

.subckt nfet_01v8_W1p4_L0p6_m18__nf1_gboth_sdfull_ng G B D S
Xnfet_01v8_W1p4_L0p6_m18__nf1_gboth_sdfull_ng_pc G D S B sky130_fd_pr__nfet_01v8_KCM6UP
.ends

.subckt nmos_current_mirror__ABBA VSS i_bias bias_c VSS_body
Xnfet_01v8_W1p4_L0p6_m18__nf1_gboth_sdfull_ng_30 i_bias VSS_body i_bias VSS nfet_01v8_W1p4_L0p6_m18__nf1_gboth_sdfull_ng
Xnfet_01v8_W1p4_L0p6_m18__nf1_gboth_sdfull_ng_31 i_bias VSS_body bias_c VSS nfet_01v8_W1p4_L0p6_m18__nf1_gboth_sdfull_ng
Xnfet_01v8_W1p4_L0p6_m18__nf1_gboth_sdfull_ng_20 i_bias VSS_body i_bias VSS nfet_01v8_W1p4_L0p6_m18__nf1_gboth_sdfull_ng
Xnfet_01v8_W1p4_L0p6_m18__nf1_gboth_sdfull_ng_0 VSS VSS_body VSS VSS nfet_01v8_W1p4_L0p6_m18__nf1_gboth_sdfull_ng
Xnfet_01v8_W1p4_L0p6_m18__nf1_gboth_sdfull_ng_33 i_bias VSS_body bias_c VSS nfet_01v8_W1p4_L0p6_m18__nf1_gboth_sdfull_ng
Xnfet_01v8_W1p4_L0p6_m18__nf1_gboth_sdfull_ng_32 i_bias VSS_body i_bias VSS nfet_01v8_W1p4_L0p6_m18__nf1_gboth_sdfull_ng
Xnfet_01v8_W1p4_L0p6_m18__nf1_gboth_sdfull_ng_22 i_bias VSS_body i_bias VSS nfet_01v8_W1p4_L0p6_m18__nf1_gboth_sdfull_ng
Xnfet_01v8_W1p4_L0p6_m18__nf1_gboth_sdfull_ng_21 i_bias VSS_body bias_c VSS nfet_01v8_W1p4_L0p6_m18__nf1_gboth_sdfull_ng
Xnfet_01v8_W1p4_L0p6_m18__nf1_gboth_sdfull_ng_11 i_bias VSS_body i_bias VSS nfet_01v8_W1p4_L0p6_m18__nf1_gboth_sdfull_ng
Xnfet_01v8_W1p4_L0p6_m18__nf1_gboth_sdfull_ng_10 i_bias VSS_body bias_c VSS nfet_01v8_W1p4_L0p6_m18__nf1_gboth_sdfull_ng
Xnfet_01v8_W1p4_L0p6_m18__nf1_gboth_sdfull_ng_2 i_bias VSS_body bias_c VSS nfet_01v8_W1p4_L0p6_m18__nf1_gboth_sdfull_ng
Xnfet_01v8_W1p4_L0p6_m18__nf1_gboth_sdfull_ng_1 i_bias VSS_body i_bias VSS nfet_01v8_W1p4_L0p6_m18__nf1_gboth_sdfull_ng
Xnfet_01v8_W1p4_L0p6_m18__nf1_gboth_sdfull_ng_34 i_bias VSS_body i_bias VSS nfet_01v8_W1p4_L0p6_m18__nf1_gboth_sdfull_ng
Xnfet_01v8_W1p4_L0p6_m18__nf1_gboth_sdfull_ng_23 i_bias VSS_body bias_c VSS nfet_01v8_W1p4_L0p6_m18__nf1_gboth_sdfull_ng
Xnfet_01v8_W1p4_L0p6_m18__nf1_gboth_sdfull_ng_12 i_bias VSS_body bias_c VSS nfet_01v8_W1p4_L0p6_m18__nf1_gboth_sdfull_ng
Xnfet_01v8_W1p4_L0p6_m18__nf1_gboth_sdfull_ng_3 i_bias VSS_body i_bias VSS nfet_01v8_W1p4_L0p6_m18__nf1_gboth_sdfull_ng
Xnfet_01v8_W1p4_L0p6_m18__nf1_gboth_sdfull_ng_35 i_bias VSS_body bias_c VSS nfet_01v8_W1p4_L0p6_m18__nf1_gboth_sdfull_ng
Xnfet_01v8_W1p4_L0p6_m18__nf1_gboth_sdfull_ng_24 i_bias VSS_body i_bias VSS nfet_01v8_W1p4_L0p6_m18__nf1_gboth_sdfull_ng
Xnfet_01v8_W1p4_L0p6_m18__nf1_gboth_sdfull_ng_13 i_bias VSS_body i_bias VSS nfet_01v8_W1p4_L0p6_m18__nf1_gboth_sdfull_ng
Xnfet_01v8_W1p4_L0p6_m18__nf1_gboth_sdfull_ng_4 i_bias VSS_body bias_c VSS nfet_01v8_W1p4_L0p6_m18__nf1_gboth_sdfull_ng
Xnfet_01v8_W1p4_L0p6_m18__nf1_gboth_sdfull_ng_36 i_bias VSS_body i_bias VSS nfet_01v8_W1p4_L0p6_m18__nf1_gboth_sdfull_ng
Xnfet_01v8_W1p4_L0p6_m18__nf1_gboth_sdfull_ng_25 i_bias VSS_body bias_c VSS nfet_01v8_W1p4_L0p6_m18__nf1_gboth_sdfull_ng
Xnfet_01v8_W1p4_L0p6_m18__nf1_gboth_sdfull_ng_14 i_bias VSS_body bias_c VSS nfet_01v8_W1p4_L0p6_m18__nf1_gboth_sdfull_ng
Xnfet_01v8_W1p4_L0p6_m18__nf1_gboth_sdfull_ng_5 i_bias VSS_body i_bias VSS nfet_01v8_W1p4_L0p6_m18__nf1_gboth_sdfull_ng
Xnfet_01v8_W1p4_L0p6_m18__nf1_gboth_sdfull_ng_37 VSS VSS_body VSS VSS nfet_01v8_W1p4_L0p6_m18__nf1_gboth_sdfull_ng
Xnfet_01v8_W1p4_L0p6_m18__nf1_gboth_sdfull_ng_26 i_bias VSS_body i_bias VSS nfet_01v8_W1p4_L0p6_m18__nf1_gboth_sdfull_ng
Xnfet_01v8_W1p4_L0p6_m18__nf1_gboth_sdfull_ng_15 i_bias VSS_body i_bias VSS nfet_01v8_W1p4_L0p6_m18__nf1_gboth_sdfull_ng
Xnfet_01v8_W1p4_L0p6_m18__nf1_gboth_sdfull_ng_6 i_bias VSS_body bias_c VSS nfet_01v8_W1p4_L0p6_m18__nf1_gboth_sdfull_ng
Xnfet_01v8_W1p4_L0p6_m18__nf1_gboth_sdfull_ng_27 i_bias VSS_body bias_c VSS nfet_01v8_W1p4_L0p6_m18__nf1_gboth_sdfull_ng
Xnfet_01v8_W1p4_L0p6_m18__nf1_gboth_sdfull_ng_16 i_bias VSS_body bias_c VSS nfet_01v8_W1p4_L0p6_m18__nf1_gboth_sdfull_ng
Xnfet_01v8_W1p4_L0p6_m18__nf1_gboth_sdfull_ng_7 i_bias VSS_body i_bias VSS nfet_01v8_W1p4_L0p6_m18__nf1_gboth_sdfull_ng
Xnfet_01v8_W1p4_L0p6_m18__nf1_gboth_sdfull_ng_28 i_bias VSS_body i_bias VSS nfet_01v8_W1p4_L0p6_m18__nf1_gboth_sdfull_ng
Xnfet_01v8_W1p4_L0p6_m18__nf1_gboth_sdfull_ng_17 i_bias VSS_body i_bias VSS nfet_01v8_W1p4_L0p6_m18__nf1_gboth_sdfull_ng
Xnfet_01v8_W1p4_L0p6_m18__nf1_gboth_sdfull_ng_8 i_bias VSS_body bias_c VSS nfet_01v8_W1p4_L0p6_m18__nf1_gboth_sdfull_ng
Xnfet_01v8_W1p4_L0p6_m18__nf1_gboth_sdfull_ng_29 i_bias VSS_body bias_c VSS nfet_01v8_W1p4_L0p6_m18__nf1_gboth_sdfull_ng
Xnfet_01v8_W1p4_L0p6_m18__nf1_gboth_sdfull_ng_19 i_bias VSS_body bias_c VSS nfet_01v8_W1p4_L0p6_m18__nf1_gboth_sdfull_ng
Xnfet_01v8_W1p4_L0p6_m18__nf1_gboth_sdfull_ng_18 i_bias VSS_body bias_c VSS nfet_01v8_W1p4_L0p6_m18__nf1_gboth_sdfull_ng
Xnfet_01v8_W1p4_L0p6_m18__nf1_gboth_sdfull_ng_9 i_bias VSS_body i_bias VSS nfet_01v8_W1p4_L0p6_m18__nf1_gboth_sdfull_ng
.ends
