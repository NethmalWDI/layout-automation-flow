.subckt nmos_dummy_19__A VSS x2_m3d VSS_body
XXX2_M41 x2_m3d VSS VSS VSS_body sky130_fd_pr__nfet_01v8 L=0.7 W=1.4 nf=1 m=8
.ends
