.subckt pmos_matched_cascode_pair__ABAB VDD bias_b bias_c x1_m21d x1_m25d x1_m2d VDD_body
XXX1_M22 bias_b bias_c x1_m21d VDD_body sky130_fd_pr__pfet_01v8 L=0.7 W=1.4 nf=1 m=6
XXX1_M26 x1_m2d bias_c x1_m25d VDD_body sky130_fd_pr__pfet_01v8 L=0.6 W=1.4 nf=1 m=6
Xpmos_matched_cascode_pair_DUMMY0 VDD VDD VDD VDD_body sky130_fd_pr__pfet_01v8 L=0.6 W=1.4 nf=1
Xpmos_matched_cascode_pair_DUMMY1 VDD VDD VDD VDD_body sky130_fd_pr__pfet_01v8 L=0.6 W=1.4 nf=1
.ends
