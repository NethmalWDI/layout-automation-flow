* NGSPICE file created from nmos_matched_current_source_pair__ABBA.ext - technology: sky130A

.subckt sky130_fd_pr__nfet_01v8_KCM6UP G D S VSUBS
X0 S G D VSUBS sky130_fd_pr__nfet_01v8 ad=0.406 pd=3.38 as=0.406 ps=3.38 w=1.4 l=0.6
.ends

.subckt nfet_01v8_W1p4_L0p6_m36__nf1_gboth_sdfull_ng B S G D
Xnfet_01v8_W1p4_L0p6_m36__nf1_gboth_sdfull_ng_pc G D S B sky130_fd_pr__nfet_01v8_KCM6UP
.ends

.subckt nmos_matched_current_source_pair__ABBA VSS bias_a x2_m3d x2_m4d VSS_body
Xnfet_01v8_W1p4_L0p6_m36__nf1_gboth_sdfull_ng_66 VSS_body VSS bias_a x2_m3d nfet_01v8_W1p4_L0p6_m36__nf1_gboth_sdfull_ng
Xnfet_01v8_W1p4_L0p6_m36__nf1_gboth_sdfull_ng_55 VSS_body VSS bias_a x2_m4d nfet_01v8_W1p4_L0p6_m36__nf1_gboth_sdfull_ng
Xnfet_01v8_W1p4_L0p6_m36__nf1_gboth_sdfull_ng_44 VSS_body VSS bias_a x2_m3d nfet_01v8_W1p4_L0p6_m36__nf1_gboth_sdfull_ng
Xnfet_01v8_W1p4_L0p6_m36__nf1_gboth_sdfull_ng_33 VSS_body VSS bias_a x2_m3d nfet_01v8_W1p4_L0p6_m36__nf1_gboth_sdfull_ng
Xnfet_01v8_W1p4_L0p6_m36__nf1_gboth_sdfull_ng_22 VSS_body VSS bias_a x2_m4d nfet_01v8_W1p4_L0p6_m36__nf1_gboth_sdfull_ng
Xnfet_01v8_W1p4_L0p6_m36__nf1_gboth_sdfull_ng_11 VSS_body VSS bias_a x2_m3d nfet_01v8_W1p4_L0p6_m36__nf1_gboth_sdfull_ng
Xnfet_01v8_W1p4_L0p6_m36__nf1_gboth_sdfull_ng_67 VSS_body VSS bias_a x2_m4d nfet_01v8_W1p4_L0p6_m36__nf1_gboth_sdfull_ng
Xnfet_01v8_W1p4_L0p6_m36__nf1_gboth_sdfull_ng_56 VSS_body VSS bias_a x2_m3d nfet_01v8_W1p4_L0p6_m36__nf1_gboth_sdfull_ng
Xnfet_01v8_W1p4_L0p6_m36__nf1_gboth_sdfull_ng_45 VSS_body VSS bias_a x2_m4d nfet_01v8_W1p4_L0p6_m36__nf1_gboth_sdfull_ng
Xnfet_01v8_W1p4_L0p6_m36__nf1_gboth_sdfull_ng_34 VSS_body VSS bias_a x2_m4d nfet_01v8_W1p4_L0p6_m36__nf1_gboth_sdfull_ng
Xnfet_01v8_W1p4_L0p6_m36__nf1_gboth_sdfull_ng_23 VSS_body VSS bias_a x2_m3d nfet_01v8_W1p4_L0p6_m36__nf1_gboth_sdfull_ng
Xnfet_01v8_W1p4_L0p6_m36__nf1_gboth_sdfull_ng_12 VSS_body VSS bias_a x2_m4d nfet_01v8_W1p4_L0p6_m36__nf1_gboth_sdfull_ng
Xnfet_01v8_W1p4_L0p6_m36__nf1_gboth_sdfull_ng_68 VSS_body VSS bias_a x2_m3d nfet_01v8_W1p4_L0p6_m36__nf1_gboth_sdfull_ng
Xnfet_01v8_W1p4_L0p6_m36__nf1_gboth_sdfull_ng_57 VSS_body VSS bias_a x2_m4d nfet_01v8_W1p4_L0p6_m36__nf1_gboth_sdfull_ng
Xnfet_01v8_W1p4_L0p6_m36__nf1_gboth_sdfull_ng_46 VSS_body VSS bias_a x2_m3d nfet_01v8_W1p4_L0p6_m36__nf1_gboth_sdfull_ng
Xnfet_01v8_W1p4_L0p6_m36__nf1_gboth_sdfull_ng_35 VSS_body VSS bias_a x2_m3d nfet_01v8_W1p4_L0p6_m36__nf1_gboth_sdfull_ng
Xnfet_01v8_W1p4_L0p6_m36__nf1_gboth_sdfull_ng_24 VSS_body VSS bias_a x2_m4d nfet_01v8_W1p4_L0p6_m36__nf1_gboth_sdfull_ng
Xnfet_01v8_W1p4_L0p6_m36__nf1_gboth_sdfull_ng_13 VSS_body VSS bias_a x2_m3d nfet_01v8_W1p4_L0p6_m36__nf1_gboth_sdfull_ng
Xnfet_01v8_W1p4_L0p6_m36__nf1_gboth_sdfull_ng_69 VSS_body VSS bias_a x2_m4d nfet_01v8_W1p4_L0p6_m36__nf1_gboth_sdfull_ng
Xnfet_01v8_W1p4_L0p6_m36__nf1_gboth_sdfull_ng_58 VSS_body VSS bias_a x2_m3d nfet_01v8_W1p4_L0p6_m36__nf1_gboth_sdfull_ng
Xnfet_01v8_W1p4_L0p6_m36__nf1_gboth_sdfull_ng_47 VSS_body VSS bias_a x2_m4d nfet_01v8_W1p4_L0p6_m36__nf1_gboth_sdfull_ng
Xnfet_01v8_W1p4_L0p6_m36__nf1_gboth_sdfull_ng_36 VSS_body VSS bias_a x2_m4d nfet_01v8_W1p4_L0p6_m36__nf1_gboth_sdfull_ng
Xnfet_01v8_W1p4_L0p6_m36__nf1_gboth_sdfull_ng_25 VSS_body VSS bias_a x2_m3d nfet_01v8_W1p4_L0p6_m36__nf1_gboth_sdfull_ng
Xnfet_01v8_W1p4_L0p6_m36__nf1_gboth_sdfull_ng_14 VSS_body VSS bias_a x2_m4d nfet_01v8_W1p4_L0p6_m36__nf1_gboth_sdfull_ng
Xnfet_01v8_W1p4_L0p6_m36__nf1_gboth_sdfull_ng_59 VSS_body VSS bias_a x2_m4d nfet_01v8_W1p4_L0p6_m36__nf1_gboth_sdfull_ng
Xnfet_01v8_W1p4_L0p6_m36__nf1_gboth_sdfull_ng_49 VSS_body VSS bias_a x2_m4d nfet_01v8_W1p4_L0p6_m36__nf1_gboth_sdfull_ng
Xnfet_01v8_W1p4_L0p6_m36__nf1_gboth_sdfull_ng_48 VSS_body VSS bias_a x2_m3d nfet_01v8_W1p4_L0p6_m36__nf1_gboth_sdfull_ng
Xnfet_01v8_W1p4_L0p6_m36__nf1_gboth_sdfull_ng_38 VSS_body VSS bias_a x2_m3d nfet_01v8_W1p4_L0p6_m36__nf1_gboth_sdfull_ng
Xnfet_01v8_W1p4_L0p6_m36__nf1_gboth_sdfull_ng_37 VSS_body VSS bias_a x2_m4d nfet_01v8_W1p4_L0p6_m36__nf1_gboth_sdfull_ng
Xnfet_01v8_W1p4_L0p6_m36__nf1_gboth_sdfull_ng_27 VSS_body VSS bias_a x2_m3d nfet_01v8_W1p4_L0p6_m36__nf1_gboth_sdfull_ng
Xnfet_01v8_W1p4_L0p6_m36__nf1_gboth_sdfull_ng_26 VSS_body VSS bias_a x2_m4d nfet_01v8_W1p4_L0p6_m36__nf1_gboth_sdfull_ng
Xnfet_01v8_W1p4_L0p6_m36__nf1_gboth_sdfull_ng_16 VSS_body VSS bias_a x2_m4d nfet_01v8_W1p4_L0p6_m36__nf1_gboth_sdfull_ng
Xnfet_01v8_W1p4_L0p6_m36__nf1_gboth_sdfull_ng_15 VSS_body VSS bias_a x2_m3d nfet_01v8_W1p4_L0p6_m36__nf1_gboth_sdfull_ng
Xnfet_01v8_W1p4_L0p6_m36__nf1_gboth_sdfull_ng_39 VSS_body VSS bias_a x2_m4d nfet_01v8_W1p4_L0p6_m36__nf1_gboth_sdfull_ng
Xnfet_01v8_W1p4_L0p6_m36__nf1_gboth_sdfull_ng_28 VSS_body VSS bias_a x2_m4d nfet_01v8_W1p4_L0p6_m36__nf1_gboth_sdfull_ng
Xnfet_01v8_W1p4_L0p6_m36__nf1_gboth_sdfull_ng_17 VSS_body VSS bias_a x2_m3d nfet_01v8_W1p4_L0p6_m36__nf1_gboth_sdfull_ng
Xnfet_01v8_W1p4_L0p6_m36__nf1_gboth_sdfull_ng_29 VSS_body VSS bias_a x2_m3d nfet_01v8_W1p4_L0p6_m36__nf1_gboth_sdfull_ng
Xnfet_01v8_W1p4_L0p6_m36__nf1_gboth_sdfull_ng_18 VSS_body VSS bias_a x2_m4d nfet_01v8_W1p4_L0p6_m36__nf1_gboth_sdfull_ng
Xnfet_01v8_W1p4_L0p6_m36__nf1_gboth_sdfull_ng_19 VSS_body VSS bias_a x2_m3d nfet_01v8_W1p4_L0p6_m36__nf1_gboth_sdfull_ng
Xnfet_01v8_W1p4_L0p6_m36__nf1_gboth_sdfull_ng_0 VSS_body VSS VSS VSS nfet_01v8_W1p4_L0p6_m36__nf1_gboth_sdfull_ng
Xnfet_01v8_W1p4_L0p6_m36__nf1_gboth_sdfull_ng_1 VSS_body VSS bias_a x2_m3d nfet_01v8_W1p4_L0p6_m36__nf1_gboth_sdfull_ng
Xnfet_01v8_W1p4_L0p6_m36__nf1_gboth_sdfull_ng_2 VSS_body VSS bias_a x2_m4d nfet_01v8_W1p4_L0p6_m36__nf1_gboth_sdfull_ng
Xnfet_01v8_W1p4_L0p6_m36__nf1_gboth_sdfull_ng_3 VSS_body VSS bias_a x2_m3d nfet_01v8_W1p4_L0p6_m36__nf1_gboth_sdfull_ng
Xnfet_01v8_W1p4_L0p6_m36__nf1_gboth_sdfull_ng_4 VSS_body VSS bias_a x2_m4d nfet_01v8_W1p4_L0p6_m36__nf1_gboth_sdfull_ng
Xnfet_01v8_W1p4_L0p6_m36__nf1_gboth_sdfull_ng_5 VSS_body VSS bias_a x2_m3d nfet_01v8_W1p4_L0p6_m36__nf1_gboth_sdfull_ng
Xnfet_01v8_W1p4_L0p6_m36__nf1_gboth_sdfull_ng_7 VSS_body VSS bias_a x2_m3d nfet_01v8_W1p4_L0p6_m36__nf1_gboth_sdfull_ng
Xnfet_01v8_W1p4_L0p6_m36__nf1_gboth_sdfull_ng_6 VSS_body VSS bias_a x2_m4d nfet_01v8_W1p4_L0p6_m36__nf1_gboth_sdfull_ng
Xnfet_01v8_W1p4_L0p6_m36__nf1_gboth_sdfull_ng_8 VSS_body VSS bias_a x2_m4d nfet_01v8_W1p4_L0p6_m36__nf1_gboth_sdfull_ng
Xnfet_01v8_W1p4_L0p6_m36__nf1_gboth_sdfull_ng_9 VSS_body VSS bias_a x2_m3d nfet_01v8_W1p4_L0p6_m36__nf1_gboth_sdfull_ng
Xnfet_01v8_W1p4_L0p6_m36__nf1_gboth_sdfull_ng_70 VSS_body VSS bias_a x2_m3d nfet_01v8_W1p4_L0p6_m36__nf1_gboth_sdfull_ng
Xnfet_01v8_W1p4_L0p6_m36__nf1_gboth_sdfull_ng_71 VSS_body VSS bias_a x2_m4d nfet_01v8_W1p4_L0p6_m36__nf1_gboth_sdfull_ng
Xnfet_01v8_W1p4_L0p6_m36__nf1_gboth_sdfull_ng_60 VSS_body VSS bias_a x2_m3d nfet_01v8_W1p4_L0p6_m36__nf1_gboth_sdfull_ng
Xnfet_01v8_W1p4_L0p6_m36__nf1_gboth_sdfull_ng_73 VSS_body VSS VSS VSS nfet_01v8_W1p4_L0p6_m36__nf1_gboth_sdfull_ng
Xnfet_01v8_W1p4_L0p6_m36__nf1_gboth_sdfull_ng_72 VSS_body VSS bias_a x2_m3d nfet_01v8_W1p4_L0p6_m36__nf1_gboth_sdfull_ng
Xnfet_01v8_W1p4_L0p6_m36__nf1_gboth_sdfull_ng_62 VSS_body VSS bias_a x2_m3d nfet_01v8_W1p4_L0p6_m36__nf1_gboth_sdfull_ng
Xnfet_01v8_W1p4_L0p6_m36__nf1_gboth_sdfull_ng_61 VSS_body VSS bias_a x2_m4d nfet_01v8_W1p4_L0p6_m36__nf1_gboth_sdfull_ng
Xnfet_01v8_W1p4_L0p6_m36__nf1_gboth_sdfull_ng_51 VSS_body VSS bias_a x2_m4d nfet_01v8_W1p4_L0p6_m36__nf1_gboth_sdfull_ng
Xnfet_01v8_W1p4_L0p6_m36__nf1_gboth_sdfull_ng_50 VSS_body VSS bias_a x2_m3d nfet_01v8_W1p4_L0p6_m36__nf1_gboth_sdfull_ng
Xnfet_01v8_W1p4_L0p6_m36__nf1_gboth_sdfull_ng_40 VSS_body VSS bias_a x2_m3d nfet_01v8_W1p4_L0p6_m36__nf1_gboth_sdfull_ng
Xnfet_01v8_W1p4_L0p6_m36__nf1_gboth_sdfull_ng_63 VSS_body VSS bias_a x2_m4d nfet_01v8_W1p4_L0p6_m36__nf1_gboth_sdfull_ng
Xnfet_01v8_W1p4_L0p6_m36__nf1_gboth_sdfull_ng_52 VSS_body VSS bias_a x2_m3d nfet_01v8_W1p4_L0p6_m36__nf1_gboth_sdfull_ng
Xnfet_01v8_W1p4_L0p6_m36__nf1_gboth_sdfull_ng_41 VSS_body VSS bias_a x2_m4d nfet_01v8_W1p4_L0p6_m36__nf1_gboth_sdfull_ng
Xnfet_01v8_W1p4_L0p6_m36__nf1_gboth_sdfull_ng_30 VSS_body VSS bias_a x2_m4d nfet_01v8_W1p4_L0p6_m36__nf1_gboth_sdfull_ng
Xnfet_01v8_W1p4_L0p6_m36__nf1_gboth_sdfull_ng_64 VSS_body VSS bias_a x2_m3d nfet_01v8_W1p4_L0p6_m36__nf1_gboth_sdfull_ng
Xnfet_01v8_W1p4_L0p6_m36__nf1_gboth_sdfull_ng_53 VSS_body VSS bias_a x2_m4d nfet_01v8_W1p4_L0p6_m36__nf1_gboth_sdfull_ng
Xnfet_01v8_W1p4_L0p6_m36__nf1_gboth_sdfull_ng_42 VSS_body VSS bias_a x2_m3d nfet_01v8_W1p4_L0p6_m36__nf1_gboth_sdfull_ng
Xnfet_01v8_W1p4_L0p6_m36__nf1_gboth_sdfull_ng_31 VSS_body VSS bias_a x2_m3d nfet_01v8_W1p4_L0p6_m36__nf1_gboth_sdfull_ng
Xnfet_01v8_W1p4_L0p6_m36__nf1_gboth_sdfull_ng_20 VSS_body VSS bias_a x2_m4d nfet_01v8_W1p4_L0p6_m36__nf1_gboth_sdfull_ng
Xnfet_01v8_W1p4_L0p6_m36__nf1_gboth_sdfull_ng_65 VSS_body VSS bias_a x2_m4d nfet_01v8_W1p4_L0p6_m36__nf1_gboth_sdfull_ng
Xnfet_01v8_W1p4_L0p6_m36__nf1_gboth_sdfull_ng_54 VSS_body VSS bias_a x2_m3d nfet_01v8_W1p4_L0p6_m36__nf1_gboth_sdfull_ng
Xnfet_01v8_W1p4_L0p6_m36__nf1_gboth_sdfull_ng_43 VSS_body VSS bias_a x2_m4d nfet_01v8_W1p4_L0p6_m36__nf1_gboth_sdfull_ng
Xnfet_01v8_W1p4_L0p6_m36__nf1_gboth_sdfull_ng_32 VSS_body VSS bias_a x2_m4d nfet_01v8_W1p4_L0p6_m36__nf1_gboth_sdfull_ng
Xnfet_01v8_W1p4_L0p6_m36__nf1_gboth_sdfull_ng_21 VSS_body VSS bias_a x2_m3d nfet_01v8_W1p4_L0p6_m36__nf1_gboth_sdfull_ng
Xnfet_01v8_W1p4_L0p6_m36__nf1_gboth_sdfull_ng_10 VSS_body VSS bias_a x2_m4d nfet_01v8_W1p4_L0p6_m36__nf1_gboth_sdfull_ng
.ends
