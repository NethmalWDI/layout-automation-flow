.subckt nmos_diode__A bias_b bias_c VSS_body
XXX1_M1 bias_b bias_b bias_c VSS_body sky130_fd_pr__nfet_01v8_lvt L=0.7 W=1.4 nf=1 m=56
.ends
