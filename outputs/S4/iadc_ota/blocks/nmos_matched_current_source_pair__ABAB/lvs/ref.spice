.subckt nmos_matched_current_source_pair__ABAB VSS bias_a x2_m3d x2_m4d VSS_body
XXX2_M3 x2_m3d bias_a VSS VSS_body sky130_fd_pr__nfet_01v8 L=0.6 W=1.4 nf=1 m=36
XXX2_M4 x2_m4d bias_a VSS VSS_body sky130_fd_pr__nfet_01v8 L=0.6 W=1.4 nf=1 m=36
Xnmos_matched_current_source_pair_DUMMY0 VSS VSS VSS VSS_body sky130_fd_pr__nfet_01v8 L=0.6 W=1.4 nf=1
Xnmos_matched_current_source_pair_DUMMY1 VSS VSS VSS VSS_body sky130_fd_pr__nfet_01v8 L=0.6 W=1.4 nf=1
.ends
