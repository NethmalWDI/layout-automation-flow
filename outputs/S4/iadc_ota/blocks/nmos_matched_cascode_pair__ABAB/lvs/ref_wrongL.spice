.subckt nmos_matched_cascode_pair__ABAB VSS bias_d on op x2_m3d x2_m4d VSS_body
XXX2_M3A on bias_d x2_m3d VSS_body sky130_fd_pr__nfet_01v8 L=0.7 W=1.4 nf=1 m=36
XXX2_M7 op bias_d x2_m4d VSS_body sky130_fd_pr__nfet_01v8 L=0.6 W=1.4 nf=1 m=36
Xnmos_matched_cascode_pair_DUMMY0 VSS VSS VSS VSS_body sky130_fd_pr__nfet_01v8 L=0.6 W=1.4 nf=1
Xnmos_matched_cascode_pair_DUMMY1 VSS VSS VSS VSS_body sky130_fd_pr__nfet_01v8 L=0.6 W=1.4 nf=1
.ends
