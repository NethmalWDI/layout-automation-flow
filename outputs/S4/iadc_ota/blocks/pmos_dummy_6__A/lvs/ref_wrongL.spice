.subckt pmos_dummy_6__A x1_m21d VDD_body
XXX1_M51 x1_m21d x1_m21d x1_m21d VDD_body sky130_fd_pr__pfet_01v8 L=0.7 W=1.4 nf=1 m=2
.ends
