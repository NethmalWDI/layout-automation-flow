.subckt nmos_single_5__A VSS cmc x2_tail VSS_body
XXX2_M6 x2_tail cmc VSS VSS_body sky130_fd_pr__nfet_01v8 L=0.7 W=1.4 nf=1 m=96
.ends
