* NGSPICE file created from nmos_single_5__A.ext - technology: sky130A

.subckt sky130_fd_pr__nfet_01v8_KCM6UP G D S VSUBS
X0 S G D VSUBS sky130_fd_pr__nfet_01v8 ad=0.406 pd=3.38 as=0.406 ps=3.38 w=1.4 l=0.6
.ends

.subckt nfet_01v8_W1p4_L0p6_m96__nf1_gboth_sdfull_ng D B S G
Xnfet_01v8_W1p4_L0p6_m96__nf1_gboth_sdfull_ng_pc G D S B sky130_fd_pr__nfet_01v8_KCM6UP
.ends

.subckt nmos_single_5__A cmc x2_tail VSS VSS_body
Xnfet_01v8_W1p4_L0p6_m96__nf1_gboth_sdfull_ng_91 x2_tail VSS_body VSS cmc nfet_01v8_W1p4_L0p6_m96__nf1_gboth_sdfull_ng
Xnfet_01v8_W1p4_L0p6_m96__nf1_gboth_sdfull_ng_80 x2_tail VSS_body VSS cmc nfet_01v8_W1p4_L0p6_m96__nf1_gboth_sdfull_ng
Xnfet_01v8_W1p4_L0p6_m96__nf1_gboth_sdfull_ng_1 x2_tail VSS_body VSS cmc nfet_01v8_W1p4_L0p6_m96__nf1_gboth_sdfull_ng
Xnfet_01v8_W1p4_L0p6_m96__nf1_gboth_sdfull_ng_0 x2_tail VSS_body VSS cmc nfet_01v8_W1p4_L0p6_m96__nf1_gboth_sdfull_ng
Xnfet_01v8_W1p4_L0p6_m96__nf1_gboth_sdfull_ng_92 x2_tail VSS_body VSS cmc nfet_01v8_W1p4_L0p6_m96__nf1_gboth_sdfull_ng
Xnfet_01v8_W1p4_L0p6_m96__nf1_gboth_sdfull_ng_81 x2_tail VSS_body VSS cmc nfet_01v8_W1p4_L0p6_m96__nf1_gboth_sdfull_ng
Xnfet_01v8_W1p4_L0p6_m96__nf1_gboth_sdfull_ng_70 x2_tail VSS_body VSS cmc nfet_01v8_W1p4_L0p6_m96__nf1_gboth_sdfull_ng
Xnfet_01v8_W1p4_L0p6_m96__nf1_gboth_sdfull_ng_2 x2_tail VSS_body VSS cmc nfet_01v8_W1p4_L0p6_m96__nf1_gboth_sdfull_ng
Xnfet_01v8_W1p4_L0p6_m96__nf1_gboth_sdfull_ng_94 x2_tail VSS_body VSS cmc nfet_01v8_W1p4_L0p6_m96__nf1_gboth_sdfull_ng
Xnfet_01v8_W1p4_L0p6_m96__nf1_gboth_sdfull_ng_93 x2_tail VSS_body VSS cmc nfet_01v8_W1p4_L0p6_m96__nf1_gboth_sdfull_ng
Xnfet_01v8_W1p4_L0p6_m96__nf1_gboth_sdfull_ng_83 x2_tail VSS_body VSS cmc nfet_01v8_W1p4_L0p6_m96__nf1_gboth_sdfull_ng
Xnfet_01v8_W1p4_L0p6_m96__nf1_gboth_sdfull_ng_82 x2_tail VSS_body VSS cmc nfet_01v8_W1p4_L0p6_m96__nf1_gboth_sdfull_ng
Xnfet_01v8_W1p4_L0p6_m96__nf1_gboth_sdfull_ng_72 x2_tail VSS_body VSS cmc nfet_01v8_W1p4_L0p6_m96__nf1_gboth_sdfull_ng
Xnfet_01v8_W1p4_L0p6_m96__nf1_gboth_sdfull_ng_71 x2_tail VSS_body VSS cmc nfet_01v8_W1p4_L0p6_m96__nf1_gboth_sdfull_ng
Xnfet_01v8_W1p4_L0p6_m96__nf1_gboth_sdfull_ng_61 x2_tail VSS_body VSS cmc nfet_01v8_W1p4_L0p6_m96__nf1_gboth_sdfull_ng
Xnfet_01v8_W1p4_L0p6_m96__nf1_gboth_sdfull_ng_60 x2_tail VSS_body VSS cmc nfet_01v8_W1p4_L0p6_m96__nf1_gboth_sdfull_ng
Xnfet_01v8_W1p4_L0p6_m96__nf1_gboth_sdfull_ng_50 x2_tail VSS_body VSS cmc nfet_01v8_W1p4_L0p6_m96__nf1_gboth_sdfull_ng
Xnfet_01v8_W1p4_L0p6_m96__nf1_gboth_sdfull_ng_3 x2_tail VSS_body VSS cmc nfet_01v8_W1p4_L0p6_m96__nf1_gboth_sdfull_ng
Xnfet_01v8_W1p4_L0p6_m96__nf1_gboth_sdfull_ng_95 x2_tail VSS_body VSS cmc nfet_01v8_W1p4_L0p6_m96__nf1_gboth_sdfull_ng
Xnfet_01v8_W1p4_L0p6_m96__nf1_gboth_sdfull_ng_84 x2_tail VSS_body VSS cmc nfet_01v8_W1p4_L0p6_m96__nf1_gboth_sdfull_ng
Xnfet_01v8_W1p4_L0p6_m96__nf1_gboth_sdfull_ng_73 x2_tail VSS_body VSS cmc nfet_01v8_W1p4_L0p6_m96__nf1_gboth_sdfull_ng
Xnfet_01v8_W1p4_L0p6_m96__nf1_gboth_sdfull_ng_62 x2_tail VSS_body VSS cmc nfet_01v8_W1p4_L0p6_m96__nf1_gboth_sdfull_ng
Xnfet_01v8_W1p4_L0p6_m96__nf1_gboth_sdfull_ng_51 x2_tail VSS_body VSS cmc nfet_01v8_W1p4_L0p6_m96__nf1_gboth_sdfull_ng
Xnfet_01v8_W1p4_L0p6_m96__nf1_gboth_sdfull_ng_40 x2_tail VSS_body VSS cmc nfet_01v8_W1p4_L0p6_m96__nf1_gboth_sdfull_ng
Xnfet_01v8_W1p4_L0p6_m96__nf1_gboth_sdfull_ng_4 x2_tail VSS_body VSS cmc nfet_01v8_W1p4_L0p6_m96__nf1_gboth_sdfull_ng
Xnfet_01v8_W1p4_L0p6_m96__nf1_gboth_sdfull_ng_85 x2_tail VSS_body VSS cmc nfet_01v8_W1p4_L0p6_m96__nf1_gboth_sdfull_ng
Xnfet_01v8_W1p4_L0p6_m96__nf1_gboth_sdfull_ng_74 x2_tail VSS_body VSS cmc nfet_01v8_W1p4_L0p6_m96__nf1_gboth_sdfull_ng
Xnfet_01v8_W1p4_L0p6_m96__nf1_gboth_sdfull_ng_63 x2_tail VSS_body VSS cmc nfet_01v8_W1p4_L0p6_m96__nf1_gboth_sdfull_ng
Xnfet_01v8_W1p4_L0p6_m96__nf1_gboth_sdfull_ng_52 x2_tail VSS_body VSS cmc nfet_01v8_W1p4_L0p6_m96__nf1_gboth_sdfull_ng
Xnfet_01v8_W1p4_L0p6_m96__nf1_gboth_sdfull_ng_41 x2_tail VSS_body VSS cmc nfet_01v8_W1p4_L0p6_m96__nf1_gboth_sdfull_ng
Xnfet_01v8_W1p4_L0p6_m96__nf1_gboth_sdfull_ng_30 x2_tail VSS_body VSS cmc nfet_01v8_W1p4_L0p6_m96__nf1_gboth_sdfull_ng
Xnfet_01v8_W1p4_L0p6_m96__nf1_gboth_sdfull_ng_5 x2_tail VSS_body VSS cmc nfet_01v8_W1p4_L0p6_m96__nf1_gboth_sdfull_ng
Xnfet_01v8_W1p4_L0p6_m96__nf1_gboth_sdfull_ng_86 x2_tail VSS_body VSS cmc nfet_01v8_W1p4_L0p6_m96__nf1_gboth_sdfull_ng
Xnfet_01v8_W1p4_L0p6_m96__nf1_gboth_sdfull_ng_75 x2_tail VSS_body VSS cmc nfet_01v8_W1p4_L0p6_m96__nf1_gboth_sdfull_ng
Xnfet_01v8_W1p4_L0p6_m96__nf1_gboth_sdfull_ng_64 x2_tail VSS_body VSS cmc nfet_01v8_W1p4_L0p6_m96__nf1_gboth_sdfull_ng
Xnfet_01v8_W1p4_L0p6_m96__nf1_gboth_sdfull_ng_53 x2_tail VSS_body VSS cmc nfet_01v8_W1p4_L0p6_m96__nf1_gboth_sdfull_ng
Xnfet_01v8_W1p4_L0p6_m96__nf1_gboth_sdfull_ng_42 x2_tail VSS_body VSS cmc nfet_01v8_W1p4_L0p6_m96__nf1_gboth_sdfull_ng
Xnfet_01v8_W1p4_L0p6_m96__nf1_gboth_sdfull_ng_31 x2_tail VSS_body VSS cmc nfet_01v8_W1p4_L0p6_m96__nf1_gboth_sdfull_ng
Xnfet_01v8_W1p4_L0p6_m96__nf1_gboth_sdfull_ng_20 x2_tail VSS_body VSS cmc nfet_01v8_W1p4_L0p6_m96__nf1_gboth_sdfull_ng
Xnfet_01v8_W1p4_L0p6_m96__nf1_gboth_sdfull_ng_6 x2_tail VSS_body VSS cmc nfet_01v8_W1p4_L0p6_m96__nf1_gboth_sdfull_ng
Xnfet_01v8_W1p4_L0p6_m96__nf1_gboth_sdfull_ng_87 x2_tail VSS_body VSS cmc nfet_01v8_W1p4_L0p6_m96__nf1_gboth_sdfull_ng
Xnfet_01v8_W1p4_L0p6_m96__nf1_gboth_sdfull_ng_76 x2_tail VSS_body VSS cmc nfet_01v8_W1p4_L0p6_m96__nf1_gboth_sdfull_ng
Xnfet_01v8_W1p4_L0p6_m96__nf1_gboth_sdfull_ng_65 x2_tail VSS_body VSS cmc nfet_01v8_W1p4_L0p6_m96__nf1_gboth_sdfull_ng
Xnfet_01v8_W1p4_L0p6_m96__nf1_gboth_sdfull_ng_54 x2_tail VSS_body VSS cmc nfet_01v8_W1p4_L0p6_m96__nf1_gboth_sdfull_ng
Xnfet_01v8_W1p4_L0p6_m96__nf1_gboth_sdfull_ng_43 x2_tail VSS_body VSS cmc nfet_01v8_W1p4_L0p6_m96__nf1_gboth_sdfull_ng
Xnfet_01v8_W1p4_L0p6_m96__nf1_gboth_sdfull_ng_32 x2_tail VSS_body VSS cmc nfet_01v8_W1p4_L0p6_m96__nf1_gboth_sdfull_ng
Xnfet_01v8_W1p4_L0p6_m96__nf1_gboth_sdfull_ng_21 x2_tail VSS_body VSS cmc nfet_01v8_W1p4_L0p6_m96__nf1_gboth_sdfull_ng
Xnfet_01v8_W1p4_L0p6_m96__nf1_gboth_sdfull_ng_10 x2_tail VSS_body VSS cmc nfet_01v8_W1p4_L0p6_m96__nf1_gboth_sdfull_ng
Xnfet_01v8_W1p4_L0p6_m96__nf1_gboth_sdfull_ng_7 x2_tail VSS_body VSS cmc nfet_01v8_W1p4_L0p6_m96__nf1_gboth_sdfull_ng
Xnfet_01v8_W1p4_L0p6_m96__nf1_gboth_sdfull_ng_88 x2_tail VSS_body VSS cmc nfet_01v8_W1p4_L0p6_m96__nf1_gboth_sdfull_ng
Xnfet_01v8_W1p4_L0p6_m96__nf1_gboth_sdfull_ng_77 x2_tail VSS_body VSS cmc nfet_01v8_W1p4_L0p6_m96__nf1_gboth_sdfull_ng
Xnfet_01v8_W1p4_L0p6_m96__nf1_gboth_sdfull_ng_66 x2_tail VSS_body VSS cmc nfet_01v8_W1p4_L0p6_m96__nf1_gboth_sdfull_ng
Xnfet_01v8_W1p4_L0p6_m96__nf1_gboth_sdfull_ng_55 x2_tail VSS_body VSS cmc nfet_01v8_W1p4_L0p6_m96__nf1_gboth_sdfull_ng
Xnfet_01v8_W1p4_L0p6_m96__nf1_gboth_sdfull_ng_44 x2_tail VSS_body VSS cmc nfet_01v8_W1p4_L0p6_m96__nf1_gboth_sdfull_ng
Xnfet_01v8_W1p4_L0p6_m96__nf1_gboth_sdfull_ng_33 x2_tail VSS_body VSS cmc nfet_01v8_W1p4_L0p6_m96__nf1_gboth_sdfull_ng
Xnfet_01v8_W1p4_L0p6_m96__nf1_gboth_sdfull_ng_22 x2_tail VSS_body VSS cmc nfet_01v8_W1p4_L0p6_m96__nf1_gboth_sdfull_ng
Xnfet_01v8_W1p4_L0p6_m96__nf1_gboth_sdfull_ng_11 x2_tail VSS_body VSS cmc nfet_01v8_W1p4_L0p6_m96__nf1_gboth_sdfull_ng
Xnfet_01v8_W1p4_L0p6_m96__nf1_gboth_sdfull_ng_8 x2_tail VSS_body VSS cmc nfet_01v8_W1p4_L0p6_m96__nf1_gboth_sdfull_ng
Xnfet_01v8_W1p4_L0p6_m96__nf1_gboth_sdfull_ng_89 x2_tail VSS_body VSS cmc nfet_01v8_W1p4_L0p6_m96__nf1_gboth_sdfull_ng
Xnfet_01v8_W1p4_L0p6_m96__nf1_gboth_sdfull_ng_78 x2_tail VSS_body VSS cmc nfet_01v8_W1p4_L0p6_m96__nf1_gboth_sdfull_ng
Xnfet_01v8_W1p4_L0p6_m96__nf1_gboth_sdfull_ng_67 x2_tail VSS_body VSS cmc nfet_01v8_W1p4_L0p6_m96__nf1_gboth_sdfull_ng
Xnfet_01v8_W1p4_L0p6_m96__nf1_gboth_sdfull_ng_56 x2_tail VSS_body VSS cmc nfet_01v8_W1p4_L0p6_m96__nf1_gboth_sdfull_ng
Xnfet_01v8_W1p4_L0p6_m96__nf1_gboth_sdfull_ng_45 x2_tail VSS_body VSS cmc nfet_01v8_W1p4_L0p6_m96__nf1_gboth_sdfull_ng
Xnfet_01v8_W1p4_L0p6_m96__nf1_gboth_sdfull_ng_34 x2_tail VSS_body VSS cmc nfet_01v8_W1p4_L0p6_m96__nf1_gboth_sdfull_ng
Xnfet_01v8_W1p4_L0p6_m96__nf1_gboth_sdfull_ng_23 x2_tail VSS_body VSS cmc nfet_01v8_W1p4_L0p6_m96__nf1_gboth_sdfull_ng
Xnfet_01v8_W1p4_L0p6_m96__nf1_gboth_sdfull_ng_12 x2_tail VSS_body VSS cmc nfet_01v8_W1p4_L0p6_m96__nf1_gboth_sdfull_ng
Xnfet_01v8_W1p4_L0p6_m96__nf1_gboth_sdfull_ng_9 x2_tail VSS_body VSS cmc nfet_01v8_W1p4_L0p6_m96__nf1_gboth_sdfull_ng
Xnfet_01v8_W1p4_L0p6_m96__nf1_gboth_sdfull_ng_79 x2_tail VSS_body VSS cmc nfet_01v8_W1p4_L0p6_m96__nf1_gboth_sdfull_ng
Xnfet_01v8_W1p4_L0p6_m96__nf1_gboth_sdfull_ng_68 x2_tail VSS_body VSS cmc nfet_01v8_W1p4_L0p6_m96__nf1_gboth_sdfull_ng
Xnfet_01v8_W1p4_L0p6_m96__nf1_gboth_sdfull_ng_57 x2_tail VSS_body VSS cmc nfet_01v8_W1p4_L0p6_m96__nf1_gboth_sdfull_ng
Xnfet_01v8_W1p4_L0p6_m96__nf1_gboth_sdfull_ng_46 x2_tail VSS_body VSS cmc nfet_01v8_W1p4_L0p6_m96__nf1_gboth_sdfull_ng
Xnfet_01v8_W1p4_L0p6_m96__nf1_gboth_sdfull_ng_35 x2_tail VSS_body VSS cmc nfet_01v8_W1p4_L0p6_m96__nf1_gboth_sdfull_ng
Xnfet_01v8_W1p4_L0p6_m96__nf1_gboth_sdfull_ng_24 x2_tail VSS_body VSS cmc nfet_01v8_W1p4_L0p6_m96__nf1_gboth_sdfull_ng
Xnfet_01v8_W1p4_L0p6_m96__nf1_gboth_sdfull_ng_13 x2_tail VSS_body VSS cmc nfet_01v8_W1p4_L0p6_m96__nf1_gboth_sdfull_ng
Xnfet_01v8_W1p4_L0p6_m96__nf1_gboth_sdfull_ng_69 x2_tail VSS_body VSS cmc nfet_01v8_W1p4_L0p6_m96__nf1_gboth_sdfull_ng
Xnfet_01v8_W1p4_L0p6_m96__nf1_gboth_sdfull_ng_59 x2_tail VSS_body VSS cmc nfet_01v8_W1p4_L0p6_m96__nf1_gboth_sdfull_ng
Xnfet_01v8_W1p4_L0p6_m96__nf1_gboth_sdfull_ng_58 x2_tail VSS_body VSS cmc nfet_01v8_W1p4_L0p6_m96__nf1_gboth_sdfull_ng
Xnfet_01v8_W1p4_L0p6_m96__nf1_gboth_sdfull_ng_48 x2_tail VSS_body VSS cmc nfet_01v8_W1p4_L0p6_m96__nf1_gboth_sdfull_ng
Xnfet_01v8_W1p4_L0p6_m96__nf1_gboth_sdfull_ng_47 x2_tail VSS_body VSS cmc nfet_01v8_W1p4_L0p6_m96__nf1_gboth_sdfull_ng
Xnfet_01v8_W1p4_L0p6_m96__nf1_gboth_sdfull_ng_37 x2_tail VSS_body VSS cmc nfet_01v8_W1p4_L0p6_m96__nf1_gboth_sdfull_ng
Xnfet_01v8_W1p4_L0p6_m96__nf1_gboth_sdfull_ng_36 x2_tail VSS_body VSS cmc nfet_01v8_W1p4_L0p6_m96__nf1_gboth_sdfull_ng
Xnfet_01v8_W1p4_L0p6_m96__nf1_gboth_sdfull_ng_26 x2_tail VSS_body VSS cmc nfet_01v8_W1p4_L0p6_m96__nf1_gboth_sdfull_ng
Xnfet_01v8_W1p4_L0p6_m96__nf1_gboth_sdfull_ng_25 x2_tail VSS_body VSS cmc nfet_01v8_W1p4_L0p6_m96__nf1_gboth_sdfull_ng
Xnfet_01v8_W1p4_L0p6_m96__nf1_gboth_sdfull_ng_15 x2_tail VSS_body VSS cmc nfet_01v8_W1p4_L0p6_m96__nf1_gboth_sdfull_ng
Xnfet_01v8_W1p4_L0p6_m96__nf1_gboth_sdfull_ng_14 x2_tail VSS_body VSS cmc nfet_01v8_W1p4_L0p6_m96__nf1_gboth_sdfull_ng
Xnfet_01v8_W1p4_L0p6_m96__nf1_gboth_sdfull_ng_49 x2_tail VSS_body VSS cmc nfet_01v8_W1p4_L0p6_m96__nf1_gboth_sdfull_ng
Xnfet_01v8_W1p4_L0p6_m96__nf1_gboth_sdfull_ng_38 x2_tail VSS_body VSS cmc nfet_01v8_W1p4_L0p6_m96__nf1_gboth_sdfull_ng
Xnfet_01v8_W1p4_L0p6_m96__nf1_gboth_sdfull_ng_27 x2_tail VSS_body VSS cmc nfet_01v8_W1p4_L0p6_m96__nf1_gboth_sdfull_ng
Xnfet_01v8_W1p4_L0p6_m96__nf1_gboth_sdfull_ng_16 x2_tail VSS_body VSS cmc nfet_01v8_W1p4_L0p6_m96__nf1_gboth_sdfull_ng
Xnfet_01v8_W1p4_L0p6_m96__nf1_gboth_sdfull_ng_39 x2_tail VSS_body VSS cmc nfet_01v8_W1p4_L0p6_m96__nf1_gboth_sdfull_ng
Xnfet_01v8_W1p4_L0p6_m96__nf1_gboth_sdfull_ng_28 x2_tail VSS_body VSS cmc nfet_01v8_W1p4_L0p6_m96__nf1_gboth_sdfull_ng
Xnfet_01v8_W1p4_L0p6_m96__nf1_gboth_sdfull_ng_17 x2_tail VSS_body VSS cmc nfet_01v8_W1p4_L0p6_m96__nf1_gboth_sdfull_ng
Xnfet_01v8_W1p4_L0p6_m96__nf1_gboth_sdfull_ng_29 x2_tail VSS_body VSS cmc nfet_01v8_W1p4_L0p6_m96__nf1_gboth_sdfull_ng
Xnfet_01v8_W1p4_L0p6_m96__nf1_gboth_sdfull_ng_18 x2_tail VSS_body VSS cmc nfet_01v8_W1p4_L0p6_m96__nf1_gboth_sdfull_ng
Xnfet_01v8_W1p4_L0p6_m96__nf1_gboth_sdfull_ng_19 x2_tail VSS_body VSS cmc nfet_01v8_W1p4_L0p6_m96__nf1_gboth_sdfull_ng
Xnfet_01v8_W1p4_L0p6_m96__nf1_gboth_sdfull_ng_90 x2_tail VSS_body VSS cmc nfet_01v8_W1p4_L0p6_m96__nf1_gboth_sdfull_ng
.ends
