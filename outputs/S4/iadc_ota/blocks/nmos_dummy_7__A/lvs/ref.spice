.subckt nmos_dummy_7__A bias_a VSS_body
XXX1_M36 bias_a bias_a bias_a VSS_body sky130_fd_pr__nfet_01v8 L=0.6 W=1.4 nf=1 m=4
.ends
