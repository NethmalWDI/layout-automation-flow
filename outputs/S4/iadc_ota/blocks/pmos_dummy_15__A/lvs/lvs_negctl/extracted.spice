* NGSPICE file created from pmos_dummy_15__A.ext - technology: sky130A

.subckt sky130_fd_pr__pfet_01v8_FGX5XW G D w_n154_n238# S
X0 S G D w_n154_n238# sky130_fd_pr__pfet_01v8 ad=0.406 pd=3.38 as=0.406 ps=3.38 w=1.4 l=0.6
.ends

.subckt pfet_01v8_W1p4_L0p6_m4__nf1_gtop_sdhalf_ng G D B S
Xpfet_01v8_W1p4_L0p6_m4__nf1_gtop_sdhalf_ng_pc G D B S sky130_fd_pr__pfet_01v8_FGX5XW
.ends

.subckt pmos_dummy_15__A VDD on VDD_body
Xpfet_01v8_W1p4_L0p6_m4__nf1_gtop_sdhalf_ng_0 VDD on VDD_body VDD pfet_01v8_W1p4_L0p6_m4__nf1_gtop_sdhalf_ng
Xpfet_01v8_W1p4_L0p6_m4__nf1_gtop_sdhalf_ng_1 VDD on VDD_body VDD pfet_01v8_W1p4_L0p6_m4__nf1_gtop_sdhalf_ng
Xpfet_01v8_W1p4_L0p6_m4__nf1_gtop_sdhalf_ng_2 VDD on VDD_body VDD pfet_01v8_W1p4_L0p6_m4__nf1_gtop_sdhalf_ng
Xpfet_01v8_W1p4_L0p6_m4__nf1_gtop_sdhalf_ng_3 VDD on VDD_body VDD pfet_01v8_W1p4_L0p6_m4__nf1_gtop_sdhalf_ng
.ends
