.subckt pmos_dummy_15__A VDD on VDD_body
XXX2_M62 on VDD VDD VDD_body sky130_fd_pr__pfet_01v8 L=0.7 W=1.4 nf=1 m=4
.ends
