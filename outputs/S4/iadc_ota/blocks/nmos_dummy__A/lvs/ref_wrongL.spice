.subckt nmos_dummy__A VSS VSS_body
XXM9 VSS VSS VSS VSS_body sky130_fd_pr__nfet_01v8 L=0.7 W=1.4 nf=1 m=23
.ends
