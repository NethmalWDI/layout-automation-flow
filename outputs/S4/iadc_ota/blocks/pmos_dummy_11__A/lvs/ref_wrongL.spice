.subckt pmos_dummy_11__A VDD x1_m31d VDD_body
XXX1_M60 x1_m31d VDD VDD VDD_body sky130_fd_pr__pfet_01v8 L=0.7 W=1.4 nf=1 m=2
.ends
