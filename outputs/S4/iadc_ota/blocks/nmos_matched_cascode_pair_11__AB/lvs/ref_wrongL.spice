.subckt nmos_matched_cascode_pair_11__AB VSS cm x1_net14 x1_net15 VSS_body
XXX1_M66 x1_net14 cm x1_net15 VSS_body sky130_fd_pr__nfet_01v8 L=0.7 W=1.4 nf=1
XXX1_M67 x1_net15 cm VSS VSS_body sky130_fd_pr__nfet_01v8 L=0.6 W=1.4 nf=1
Xnmos_matched_cascode_pair_11_DUMMY0 VSS VSS VSS VSS_body sky130_fd_pr__nfet_01v8 L=0.6 W=1.4 nf=1
Xnmos_matched_cascode_pair_11_DUMMY1 VSS VSS VSS VSS_body sky130_fd_pr__nfet_01v8 L=0.6 W=1.4 nf=1
.ends
