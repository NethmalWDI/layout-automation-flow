.subckt nmos_matched_cascode_pair_7__AB VSS cm x1_net8 x1_net9 VSS_body
XXX1_M74 x1_net8 cm x1_net9 VSS_body sky130_fd_pr__nfet_01v8 L=0.6 W=1.4 nf=1
XXX1_M75 x1_net9 cm VSS VSS_body sky130_fd_pr__nfet_01v8 L=0.6 W=1.4 nf=1
Xnmos_matched_cascode_pair_7_DUMMY0 VSS VSS VSS VSS_body sky130_fd_pr__nfet_01v8 L=0.6 W=1.4 nf=1
Xnmos_matched_cascode_pair_7_DUMMY1 VSS VSS VSS VSS_body sky130_fd_pr__nfet_01v8 L=0.6 W=1.4 nf=1
.ends
