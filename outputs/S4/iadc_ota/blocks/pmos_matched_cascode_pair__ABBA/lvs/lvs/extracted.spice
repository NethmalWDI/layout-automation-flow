* NGSPICE file created from pmos_matched_cascode_pair__ABBA.ext - technology: sky130A

.subckt sky130_fd_pr__pfet_01v8_RGDEC8 G D w_n154_n240# S
X0 S G D w_n154_n240# sky130_fd_pr__pfet_01v8 ad=0.406 pd=3.38 as=0.406 ps=3.38 w=1.4 l=0.6
.ends

.subckt pfet_01v8_W1p4_L0p6_m6__nf1_gboth_sdfull_ng S B G D
Xpfet_01v8_W1p4_L0p6_m6__nf1_gboth_sdfull_ng_pc G D B S sky130_fd_pr__pfet_01v8_RGDEC8
.ends

.subckt pmos_matched_cascode_pair__ABBA VDD bias_c bias_b x1_m21d x1_m2d x1_m25d VDD_body
Xpfet_01v8_W1p4_L0p6_m6__nf1_gboth_sdfull_ng_0 VDD VDD_body VDD VDD pfet_01v8_W1p4_L0p6_m6__nf1_gboth_sdfull_ng
Xpfet_01v8_W1p4_L0p6_m6__nf1_gboth_sdfull_ng_10 x1_m21d VDD_body bias_c bias_b pfet_01v8_W1p4_L0p6_m6__nf1_gboth_sdfull_ng
Xpfet_01v8_W1p4_L0p6_m6__nf1_gboth_sdfull_ng_1 x1_m21d VDD_body bias_c bias_b pfet_01v8_W1p4_L0p6_m6__nf1_gboth_sdfull_ng
Xpfet_01v8_W1p4_L0p6_m6__nf1_gboth_sdfull_ng_11 x1_m25d VDD_body bias_c x1_m2d pfet_01v8_W1p4_L0p6_m6__nf1_gboth_sdfull_ng
Xpfet_01v8_W1p4_L0p6_m6__nf1_gboth_sdfull_ng_2 x1_m25d VDD_body bias_c x1_m2d pfet_01v8_W1p4_L0p6_m6__nf1_gboth_sdfull_ng
Xpfet_01v8_W1p4_L0p6_m6__nf1_gboth_sdfull_ng_12 x1_m21d VDD_body bias_c bias_b pfet_01v8_W1p4_L0p6_m6__nf1_gboth_sdfull_ng
Xpfet_01v8_W1p4_L0p6_m6__nf1_gboth_sdfull_ng_3 x1_m21d VDD_body bias_c bias_b pfet_01v8_W1p4_L0p6_m6__nf1_gboth_sdfull_ng
Xpfet_01v8_W1p4_L0p6_m6__nf1_gboth_sdfull_ng_13 VDD VDD_body VDD VDD pfet_01v8_W1p4_L0p6_m6__nf1_gboth_sdfull_ng
Xpfet_01v8_W1p4_L0p6_m6__nf1_gboth_sdfull_ng_4 x1_m25d VDD_body bias_c x1_m2d pfet_01v8_W1p4_L0p6_m6__nf1_gboth_sdfull_ng
Xpfet_01v8_W1p4_L0p6_m6__nf1_gboth_sdfull_ng_6 x1_m25d VDD_body bias_c x1_m2d pfet_01v8_W1p4_L0p6_m6__nf1_gboth_sdfull_ng
Xpfet_01v8_W1p4_L0p6_m6__nf1_gboth_sdfull_ng_5 x1_m21d VDD_body bias_c bias_b pfet_01v8_W1p4_L0p6_m6__nf1_gboth_sdfull_ng
Xpfet_01v8_W1p4_L0p6_m6__nf1_gboth_sdfull_ng_7 x1_m25d VDD_body bias_c x1_m2d pfet_01v8_W1p4_L0p6_m6__nf1_gboth_sdfull_ng
Xpfet_01v8_W1p4_L0p6_m6__nf1_gboth_sdfull_ng_8 x1_m21d VDD_body bias_c bias_b pfet_01v8_W1p4_L0p6_m6__nf1_gboth_sdfull_ng
Xpfet_01v8_W1p4_L0p6_m6__nf1_gboth_sdfull_ng_9 x1_m25d VDD_body bias_c x1_m2d pfet_01v8_W1p4_L0p6_m6__nf1_gboth_sdfull_ng
.ends
