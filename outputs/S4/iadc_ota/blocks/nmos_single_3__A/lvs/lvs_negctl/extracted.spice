* NGSPICE file created from nmos_single_3__A.ext - technology: sky130A

.subckt sky130_fd_pr__nfet_01v8_KCM6UP G D S VSUBS
X0 S G D VSUBS sky130_fd_pr__nfet_01v8 ad=0.406 pd=3.38 as=0.406 ps=3.38 w=1.4 l=0.6
.ends

.subckt nfet_01v8_W1p4_L0p6_m18__nf1_gboth_sdfull_ng G B D S
Xnfet_01v8_W1p4_L0p6_m18__nf1_gboth_sdfull_ng_pc G D S B sky130_fd_pr__nfet_01v8_KCM6UP
.ends

.subckt nmos_single_3__A bias_a x1_m5d VSS VSS_body
Xnfet_01v8_W1p4_L0p6_m18__nf1_gboth_sdfull_ng_0 bias_a VSS_body x1_m5d VSS nfet_01v8_W1p4_L0p6_m18__nf1_gboth_sdfull_ng
Xnfet_01v8_W1p4_L0p6_m18__nf1_gboth_sdfull_ng_11 bias_a VSS_body x1_m5d VSS nfet_01v8_W1p4_L0p6_m18__nf1_gboth_sdfull_ng
Xnfet_01v8_W1p4_L0p6_m18__nf1_gboth_sdfull_ng_10 bias_a VSS_body x1_m5d VSS nfet_01v8_W1p4_L0p6_m18__nf1_gboth_sdfull_ng
Xnfet_01v8_W1p4_L0p6_m18__nf1_gboth_sdfull_ng_2 bias_a VSS_body x1_m5d VSS nfet_01v8_W1p4_L0p6_m18__nf1_gboth_sdfull_ng
Xnfet_01v8_W1p4_L0p6_m18__nf1_gboth_sdfull_ng_1 bias_a VSS_body x1_m5d VSS nfet_01v8_W1p4_L0p6_m18__nf1_gboth_sdfull_ng
Xnfet_01v8_W1p4_L0p6_m18__nf1_gboth_sdfull_ng_12 bias_a VSS_body x1_m5d VSS nfet_01v8_W1p4_L0p6_m18__nf1_gboth_sdfull_ng
Xnfet_01v8_W1p4_L0p6_m18__nf1_gboth_sdfull_ng_3 bias_a VSS_body x1_m5d VSS nfet_01v8_W1p4_L0p6_m18__nf1_gboth_sdfull_ng
Xnfet_01v8_W1p4_L0p6_m18__nf1_gboth_sdfull_ng_13 bias_a VSS_body x1_m5d VSS nfet_01v8_W1p4_L0p6_m18__nf1_gboth_sdfull_ng
Xnfet_01v8_W1p4_L0p6_m18__nf1_gboth_sdfull_ng_4 bias_a VSS_body x1_m5d VSS nfet_01v8_W1p4_L0p6_m18__nf1_gboth_sdfull_ng
Xnfet_01v8_W1p4_L0p6_m18__nf1_gboth_sdfull_ng_14 bias_a VSS_body x1_m5d VSS nfet_01v8_W1p4_L0p6_m18__nf1_gboth_sdfull_ng
Xnfet_01v8_W1p4_L0p6_m18__nf1_gboth_sdfull_ng_5 bias_a VSS_body x1_m5d VSS nfet_01v8_W1p4_L0p6_m18__nf1_gboth_sdfull_ng
Xnfet_01v8_W1p4_L0p6_m18__nf1_gboth_sdfull_ng_15 bias_a VSS_body x1_m5d VSS nfet_01v8_W1p4_L0p6_m18__nf1_gboth_sdfull_ng
Xnfet_01v8_W1p4_L0p6_m18__nf1_gboth_sdfull_ng_6 bias_a VSS_body x1_m5d VSS nfet_01v8_W1p4_L0p6_m18__nf1_gboth_sdfull_ng
Xnfet_01v8_W1p4_L0p6_m18__nf1_gboth_sdfull_ng_16 bias_a VSS_body x1_m5d VSS nfet_01v8_W1p4_L0p6_m18__nf1_gboth_sdfull_ng
Xnfet_01v8_W1p4_L0p6_m18__nf1_gboth_sdfull_ng_7 bias_a VSS_body x1_m5d VSS nfet_01v8_W1p4_L0p6_m18__nf1_gboth_sdfull_ng
Xnfet_01v8_W1p4_L0p6_m18__nf1_gboth_sdfull_ng_17 bias_a VSS_body x1_m5d VSS nfet_01v8_W1p4_L0p6_m18__nf1_gboth_sdfull_ng
Xnfet_01v8_W1p4_L0p6_m18__nf1_gboth_sdfull_ng_8 bias_a VSS_body x1_m5d VSS nfet_01v8_W1p4_L0p6_m18__nf1_gboth_sdfull_ng
Xnfet_01v8_W1p4_L0p6_m18__nf1_gboth_sdfull_ng_9 bias_a VSS_body x1_m5d VSS nfet_01v8_W1p4_L0p6_m18__nf1_gboth_sdfull_ng
.ends
