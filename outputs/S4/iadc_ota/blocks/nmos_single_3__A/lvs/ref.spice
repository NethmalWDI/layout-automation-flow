.subckt nmos_single_3__A VSS bias_a x1_m5d VSS_body
XXX1_M5 x1_m5d bias_a VSS VSS_body sky130_fd_pr__nfet_01v8 L=0.6 W=1.4 nf=1 m=18
.ends
