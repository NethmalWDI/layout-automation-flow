.subckt pmos_dummy__A VDD VDD_body
XXM43 VDD VDD VDD VDD_body sky130_fd_pr__pfet_01v8_lvt L=0.7 W=1.4 nf=1 m=8
.ends
