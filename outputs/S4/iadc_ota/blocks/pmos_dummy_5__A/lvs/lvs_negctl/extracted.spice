* NGSPICE file created from pmos_dummy_5__A.ext - technology: sky130A

.subckt sky130_fd_pr__pfet_01v8_lvt_L7GY3J G D w_n154_n238# S
X0 S G D w_n154_n238# sky130_fd_pr__pfet_01v8_lvt ad=0.406 pd=3.38 as=0.406 ps=3.38 w=1.4 l=0.6
.ends

.subckt pfet_01v8_lvt_W1p4_L0p6_m2__nf1_gtop_sdfull_ng B G D S
Xpfet_01v8_lvt_W1p4_L0p6_m2__nf1_gtop_sdfull_ng_pc G D B S sky130_fd_pr__pfet_01v8_lvt_L7GY3J
.ends

.subckt pmos_dummy_5__A x1_m31d VDD_body
Xpfet_01v8_lvt_W1p4_L0p6_m2__nf1_gtop_sdfull_ng_0 VDD_body x1_m31d x1_m31d x1_m31d
+ pfet_01v8_lvt_W1p4_L0p6_m2__nf1_gtop_sdfull_ng
Xpfet_01v8_lvt_W1p4_L0p6_m2__nf1_gtop_sdfull_ng_1 VDD_body x1_m31d x1_m31d x1_m31d
+ pfet_01v8_lvt_W1p4_L0p6_m2__nf1_gtop_sdfull_ng
.ends
