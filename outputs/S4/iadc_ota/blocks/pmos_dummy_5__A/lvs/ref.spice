.subckt pmos_dummy_5__A x1_m31d VDD_body
XXX1_M48 x1_m31d x1_m31d x1_m31d VDD_body sky130_fd_pr__pfet_01v8_lvt L=0.6 W=1.4 nf=1 m=2
.ends
