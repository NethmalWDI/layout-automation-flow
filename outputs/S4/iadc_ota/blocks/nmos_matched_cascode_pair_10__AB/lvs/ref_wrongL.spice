.subckt nmos_matched_cascode_pair_10__AB VSS cm x1_net13 x1_net14 VSS_body
XXX1_M64 cm cm x1_net13 VSS_body sky130_fd_pr__nfet_01v8 L=0.7 W=1.4 nf=1
XXX1_M65 x1_net13 cm x1_net14 VSS_body sky130_fd_pr__nfet_01v8 L=0.6 W=1.4 nf=1
Xnmos_matched_cascode_pair_10_DUMMY0 VSS VSS VSS VSS_body sky130_fd_pr__nfet_01v8 L=0.6 W=1.4 nf=1
Xnmos_matched_cascode_pair_10_DUMMY1 VSS VSS VSS VSS_body sky130_fd_pr__nfet_01v8 L=0.6 W=1.4 nf=1
.ends
