.subckt pmos_matched_cascode_pair_2__ABBA VDD bias_c on op x2_foldn x2_foldp VDD_body
XXX2_M1A on bias_c x2_foldp VDD_body sky130_fd_pr__pfet_01v8 L=0.6 W=1.4 nf=1 m=20
XXX2_M8 op bias_c x2_foldn VDD_body sky130_fd_pr__pfet_01v8 L=0.6 W=1.4 nf=1 m=20
Xpmos_matched_cascode_pair_2_DUMMY0 VDD VDD VDD VDD_body sky130_fd_pr__pfet_01v8 L=0.6 W=1.4 nf=1
Xpmos_matched_cascode_pair_2_DUMMY1 VDD VDD VDD VDD_body sky130_fd_pr__pfet_01v8 L=0.6 W=1.4 nf=1
.ends
