.subckt pmos_current_mirror_load__AB OUTP VDD net3 VDD_body
XXM3 net3 net3 VDD VDD_body sky130_fd_pr__pfet_01v8 L=1.1 W=8 nf=1
XXM4 OUTP net3 VDD VDD_body sky130_fd_pr__pfet_01v8 L=1 W=8 nf=1
.ends
