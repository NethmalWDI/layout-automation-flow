.subckt x1_single_m4__f3 VSS bias_a bias_d x1_m5d VSS_body
XXX1_M4 bias_a bias_d x1_m5d VSS_body sky130_fd_pr__nfet_01v8 L=0.6 W=1.4 nf=1 m=18
XXX1_M36 bias_a bias_a bias_a VSS_body sky130_fd_pr__nfet_01v8 L=0.6 W=1.4 nf=1 m=4
Xx1_single_m4_DUMMY0 VSS VSS VSS VSS_body sky130_fd_pr__nfet_01v8 L=0.6 W=1.4 nf=1
Xx1_single_m4_DUMMY1 VSS VSS VSS VSS_body sky130_fd_pr__nfet_01v8 L=0.6 W=1.4 nf=1
.ends
