* NGSPICE file created from x1_cc_cm__strings1.ext - technology: sky130A

.subckt sky130_fd_pr__nfet_01v8_KCM6UP G D S VSUBS
X0 S G D VSUBS sky130_fd_pr__nfet_01v8 ad=0.406 pd=3.38 as=0.406 ps=3.38 w=1.4 l=0.6
.ends

.subckt nfet_01v8_W1p4_L0p6_m1__nf1_gboth_sdfull_ng B G D S
Xnfet_01v8_W1p4_L0p6_m1__nf1_gboth_sdfull_ng_pc G D S B sky130_fd_pr__nfet_01v8_KCM6UP
.ends

.subckt sky130_fd_pr__nfet_01v8_RUA5M6 G D S VSUBS
X0 S G D VSUBS sky130_fd_pr__nfet_01v8 ad=0.406 pd=3.38 as=0.406 ps=3.38 w=1.4 l=0.6
.ends

.subckt nfet_01v8_W1p4_L0p6_m8__nf1_gtop_sdfull_ng B S G D
Xnfet_01v8_W1p4_L0p6_m8__nf1_gtop_sdfull_ng_pc G D S B sky130_fd_pr__nfet_01v8_RUA5M6
.ends

.subckt x1_cc_cm__strings1 cm x1_net1 x1_net2 x1_net3 VSS x1_net13 x1_net14 x1_net15
+ x1_net4 x1_net5 x1_net6 x1_net7 x1_net8 x1_net9 x1_net10 x1_net11 x1_net12 VSS_body
Xnfet_01v8_W1p4_L0p6_m1__nf1_gboth_sdfull_ng_0 VSS_body cm cm x1_net1 nfet_01v8_W1p4_L0p6_m1__nf1_gboth_sdfull_ng
Xnfet_01v8_W1p4_L0p6_m1__nf1_gboth_sdfull_ng_1 VSS_body cm x1_net1 x1_net2 nfet_01v8_W1p4_L0p6_m1__nf1_gboth_sdfull_ng
Xnfet_01v8_W1p4_L0p6_m1__nf1_gboth_sdfull_ng_2 VSS_body cm x1_net2 x1_net3 nfet_01v8_W1p4_L0p6_m1__nf1_gboth_sdfull_ng
Xnfet_01v8_W1p4_L0p6_m1__nf1_gboth_sdfull_ng_10 VSS_body cm x1_net5 x1_net6 nfet_01v8_W1p4_L0p6_m1__nf1_gboth_sdfull_ng
Xnfet_01v8_W1p4_L0p6_m1__nf1_gboth_sdfull_ng_3 VSS_body cm x1_net3 VSS nfet_01v8_W1p4_L0p6_m1__nf1_gboth_sdfull_ng
Xnfet_01v8_W1p4_L0p6_m1__nf1_gboth_sdfull_ng_11 VSS_body cm x1_net6 VSS nfet_01v8_W1p4_L0p6_m1__nf1_gboth_sdfull_ng
Xnfet_01v8_W1p4_L0p6_m1__nf1_gboth_sdfull_ng_4 VSS_body cm cm x1_net13 nfet_01v8_W1p4_L0p6_m1__nf1_gboth_sdfull_ng
Xnfet_01v8_W1p4_L0p6_m1__nf1_gboth_sdfull_ng_12 VSS_body cm cm x1_net7 nfet_01v8_W1p4_L0p6_m1__nf1_gboth_sdfull_ng
Xnfet_01v8_W1p4_L0p6_m1__nf1_gboth_sdfull_ng_5 VSS_body cm x1_net13 x1_net14 nfet_01v8_W1p4_L0p6_m1__nf1_gboth_sdfull_ng
Xnfet_01v8_W1p4_L0p6_m1__nf1_gboth_sdfull_ng_13 VSS_body cm x1_net7 x1_net8 nfet_01v8_W1p4_L0p6_m1__nf1_gboth_sdfull_ng
Xnfet_01v8_W1p4_L0p6_m1__nf1_gboth_sdfull_ng_6 VSS_body cm x1_net14 x1_net15 nfet_01v8_W1p4_L0p6_m1__nf1_gboth_sdfull_ng
Xnfet_01v8_W1p4_L0p6_m1__nf1_gboth_sdfull_ng_14 VSS_body cm x1_net8 x1_net9 nfet_01v8_W1p4_L0p6_m1__nf1_gboth_sdfull_ng
Xnfet_01v8_W1p4_L0p6_m1__nf1_gboth_sdfull_ng_7 VSS_body cm x1_net15 VSS nfet_01v8_W1p4_L0p6_m1__nf1_gboth_sdfull_ng
Xnfet_01v8_W1p4_L0p6_m1__nf1_gboth_sdfull_ng_15 VSS_body cm x1_net9 VSS nfet_01v8_W1p4_L0p6_m1__nf1_gboth_sdfull_ng
Xnfet_01v8_W1p4_L0p6_m1__nf1_gboth_sdfull_ng_9 VSS_body cm x1_net4 x1_net5 nfet_01v8_W1p4_L0p6_m1__nf1_gboth_sdfull_ng
Xnfet_01v8_W1p4_L0p6_m1__nf1_gboth_sdfull_ng_8 VSS_body cm cm x1_net4 nfet_01v8_W1p4_L0p6_m1__nf1_gboth_sdfull_ng
Xnfet_01v8_W1p4_L0p6_m1__nf1_gboth_sdfull_ng_17 VSS_body cm x1_net10 x1_net11 nfet_01v8_W1p4_L0p6_m1__nf1_gboth_sdfull_ng
Xnfet_01v8_W1p4_L0p6_m1__nf1_gboth_sdfull_ng_16 VSS_body cm cm x1_net10 nfet_01v8_W1p4_L0p6_m1__nf1_gboth_sdfull_ng
Xnfet_01v8_W1p4_L0p6_m1__nf1_gboth_sdfull_ng_18 VSS_body cm x1_net11 x1_net12 nfet_01v8_W1p4_L0p6_m1__nf1_gboth_sdfull_ng
Xnfet_01v8_W1p4_L0p6_m1__nf1_gboth_sdfull_ng_19 VSS_body cm x1_net12 VSS nfet_01v8_W1p4_L0p6_m1__nf1_gboth_sdfull_ng
Xnfet_01v8_W1p4_L0p6_m8__nf1_gtop_sdfull_ng_0 VSS_body cm cm cm nfet_01v8_W1p4_L0p6_m8__nf1_gtop_sdfull_ng
Xnfet_01v8_W1p4_L0p6_m8__nf1_gtop_sdfull_ng_1 VSS_body cm cm cm nfet_01v8_W1p4_L0p6_m8__nf1_gtop_sdfull_ng
Xnfet_01v8_W1p4_L0p6_m8__nf1_gtop_sdfull_ng_2 VSS_body cm cm cm nfet_01v8_W1p4_L0p6_m8__nf1_gtop_sdfull_ng
Xnfet_01v8_W1p4_L0p6_m8__nf1_gtop_sdfull_ng_3 VSS_body cm cm cm nfet_01v8_W1p4_L0p6_m8__nf1_gtop_sdfull_ng
Xnfet_01v8_W1p4_L0p6_m8__nf1_gtop_sdfull_ng_5 VSS_body cm cm cm nfet_01v8_W1p4_L0p6_m8__nf1_gtop_sdfull_ng
Xnfet_01v8_W1p4_L0p6_m8__nf1_gtop_sdfull_ng_4 VSS_body cm cm cm nfet_01v8_W1p4_L0p6_m8__nf1_gtop_sdfull_ng
Xnfet_01v8_W1p4_L0p6_m8__nf1_gtop_sdfull_ng_6 VSS_body cm cm cm nfet_01v8_W1p4_L0p6_m8__nf1_gtop_sdfull_ng
Xnfet_01v8_W1p4_L0p6_m8__nf1_gtop_sdfull_ng_7 VSS_body cm cm cm nfet_01v8_W1p4_L0p6_m8__nf1_gtop_sdfull_ng
.ends
