.subckt XC3__A op cmc
XC3 op cmc sky130_fd_pr__cap_mim_m3_1 W=4.8 L=4.8 m=4
.ends
