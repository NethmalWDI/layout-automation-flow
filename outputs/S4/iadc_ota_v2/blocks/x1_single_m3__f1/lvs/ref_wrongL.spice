.subckt x1_single_m3__f1 bias_a bias_d x1_m2d VSS_body
XXX1_M3 bias_d x1_m2d bias_a VSS_body sky130_fd_pr__nfet_01v8 L=0.7 W=1.4 nf=1 m=2
XXX1_M34 bias_d bias_d bias_d VSS_body sky130_fd_pr__nfet_01v8 L=0.6 W=1.4 nf=1 m=8
.ends
