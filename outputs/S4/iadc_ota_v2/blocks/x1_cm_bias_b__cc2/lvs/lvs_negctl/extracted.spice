* NGSPICE file created from x1_cm_bias_b__cc2.ext - technology: sky130A

.subckt sky130_fd_pr__pfet_01v8_lvt_PJ46JE G D w_n154_n240# S
X0 S G D w_n154_n240# sky130_fd_pr__pfet_01v8_lvt ad=0.406 pd=3.38 as=0.406 ps=3.38 w=1.4 l=0.6
.ends

.subckt pfet_01v8_lvt_W1p4_L0p6_m6__nf1_gboth_sdfull_ng G D S B
Xpfet_01v8_lvt_W1p4_L0p6_m6__nf1_gboth_sdfull_ng_pc G D B S sky130_fd_pr__pfet_01v8_lvt_PJ46JE
.ends

.subckt sky130_fd_pr__pfet_01v8_7A4LUF G D w_n154_n238# S
X0 S G D w_n154_n238# sky130_fd_pr__pfet_01v8 ad=0.406 pd=3.38 as=0.406 ps=3.38 w=1.4 l=0.6
.ends

.subckt pfet_01v8_W1p4_L0p6_m2__nf1_gtop_sdfull_ng S B G D
Xpfet_01v8_W1p4_L0p6_m2__nf1_gtop_sdfull_ng_pc G D B S sky130_fd_pr__pfet_01v8_7A4LUF
.ends

.subckt sky130_fd_pr__pfet_01v8_lvt_L7GY3J G D w_n154_n238# S
X0 S G D w_n154_n238# sky130_fd_pr__pfet_01v8_lvt ad=0.406 pd=3.38 as=0.406 ps=3.38 w=1.4 l=0.6
.ends

.subckt pfet_01v8_lvt_W1p4_L0p6_m2__nf1_gtop_sdfull_ng G D B S
Xpfet_01v8_lvt_W1p4_L0p6_m2__nf1_gtop_sdfull_ng_pc G D B S sky130_fd_pr__pfet_01v8_lvt_L7GY3J
.ends

.subckt x1_cm_bias_b__cc2 x1_m25d x1_m21d VDD bias_b x1_m31d VDD_body
Xpfet_01v8_lvt_W1p4_L0p6_m6__nf1_gboth_sdfull_ng_10 bias_b x1_m25d VDD VDD_body pfet_01v8_lvt_W1p4_L0p6_m6__nf1_gboth_sdfull_ng
Xpfet_01v8_lvt_W1p4_L0p6_m6__nf1_gboth_sdfull_ng_11 bias_b x1_m21d VDD VDD_body pfet_01v8_lvt_W1p4_L0p6_m6__nf1_gboth_sdfull_ng
Xpfet_01v8_lvt_W1p4_L0p6_m6__nf1_gboth_sdfull_ng_12 bias_b x1_m31d VDD VDD_body pfet_01v8_lvt_W1p4_L0p6_m6__nf1_gboth_sdfull_ng
Xpfet_01v8_lvt_W1p4_L0p6_m6__nf1_gboth_sdfull_ng_13 bias_b x1_m25d VDD VDD_body pfet_01v8_lvt_W1p4_L0p6_m6__nf1_gboth_sdfull_ng
Xpfet_01v8_lvt_W1p4_L0p6_m6__nf1_gboth_sdfull_ng_14 bias_b x1_m21d VDD VDD_body pfet_01v8_lvt_W1p4_L0p6_m6__nf1_gboth_sdfull_ng
Xpfet_01v8_lvt_W1p4_L0p6_m6__nf1_gboth_sdfull_ng_15 bias_b x1_m31d VDD VDD_body pfet_01v8_lvt_W1p4_L0p6_m6__nf1_gboth_sdfull_ng
Xpfet_01v8_lvt_W1p4_L0p6_m6__nf1_gboth_sdfull_ng_0 bias_b x1_m21d VDD VDD_body pfet_01v8_lvt_W1p4_L0p6_m6__nf1_gboth_sdfull_ng
Xpfet_01v8_lvt_W1p4_L0p6_m6__nf1_gboth_sdfull_ng_16 bias_b x1_m25d VDD VDD_body pfet_01v8_lvt_W1p4_L0p6_m6__nf1_gboth_sdfull_ng
Xpfet_01v8_lvt_W1p4_L0p6_m6__nf1_gboth_sdfull_ng_1 bias_b x1_m25d VDD VDD_body pfet_01v8_lvt_W1p4_L0p6_m6__nf1_gboth_sdfull_ng
Xpfet_01v8_lvt_W1p4_L0p6_m6__nf1_gboth_sdfull_ng_2 bias_b x1_m31d VDD VDD_body pfet_01v8_lvt_W1p4_L0p6_m6__nf1_gboth_sdfull_ng
Xpfet_01v8_lvt_W1p4_L0p6_m6__nf1_gboth_sdfull_ng_17 bias_b x1_m21d VDD VDD_body pfet_01v8_lvt_W1p4_L0p6_m6__nf1_gboth_sdfull_ng
Xpfet_01v8_lvt_W1p4_L0p6_m6__nf1_gboth_sdfull_ng_3 bias_b x1_m21d VDD VDD_body pfet_01v8_lvt_W1p4_L0p6_m6__nf1_gboth_sdfull_ng
Xpfet_01v8_lvt_W1p4_L0p6_m6__nf1_gboth_sdfull_ng_4 bias_b x1_m25d VDD VDD_body pfet_01v8_lvt_W1p4_L0p6_m6__nf1_gboth_sdfull_ng
Xpfet_01v8_lvt_W1p4_L0p6_m6__nf1_gboth_sdfull_ng_5 bias_b x1_m31d VDD VDD_body pfet_01v8_lvt_W1p4_L0p6_m6__nf1_gboth_sdfull_ng
Xpfet_01v8_lvt_W1p4_L0p6_m6__nf1_gboth_sdfull_ng_6 bias_b x1_m21d VDD VDD_body pfet_01v8_lvt_W1p4_L0p6_m6__nf1_gboth_sdfull_ng
Xpfet_01v8_lvt_W1p4_L0p6_m6__nf1_gboth_sdfull_ng_7 bias_b x1_m25d VDD VDD_body pfet_01v8_lvt_W1p4_L0p6_m6__nf1_gboth_sdfull_ng
Xpfet_01v8_lvt_W1p4_L0p6_m6__nf1_gboth_sdfull_ng_8 bias_b x1_m31d VDD VDD_body pfet_01v8_lvt_W1p4_L0p6_m6__nf1_gboth_sdfull_ng
Xpfet_01v8_W1p4_L0p6_m2__nf1_gtop_sdfull_ng_0 x1_m25d VDD_body x1_m25d x1_m25d pfet_01v8_W1p4_L0p6_m2__nf1_gtop_sdfull_ng
Xpfet_01v8_lvt_W1p4_L0p6_m6__nf1_gboth_sdfull_ng_9 bias_b x1_m31d VDD VDD_body pfet_01v8_lvt_W1p4_L0p6_m6__nf1_gboth_sdfull_ng
Xpfet_01v8_W1p4_L0p6_m2__nf1_gtop_sdfull_ng_1 x1_m25d VDD_body x1_m25d x1_m25d pfet_01v8_W1p4_L0p6_m2__nf1_gtop_sdfull_ng
Xpfet_01v8_W1p4_L0p6_m2__nf1_gtop_sdfull_ng_2 x1_m21d VDD_body x1_m21d x1_m21d pfet_01v8_W1p4_L0p6_m2__nf1_gtop_sdfull_ng
Xpfet_01v8_W1p4_L0p6_m2__nf1_gtop_sdfull_ng_4 x1_m21d VDD_body x1_m21d x1_m21d pfet_01v8_W1p4_L0p6_m2__nf1_gtop_sdfull_ng
Xpfet_01v8_W1p4_L0p6_m2__nf1_gtop_sdfull_ng_3 VDD VDD_body VDD x1_m31d pfet_01v8_W1p4_L0p6_m2__nf1_gtop_sdfull_ng
Xpfet_01v8_W1p4_L0p6_m2__nf1_gtop_sdfull_ng_5 VDD VDD_body VDD x1_m31d pfet_01v8_W1p4_L0p6_m2__nf1_gtop_sdfull_ng
Xpfet_01v8_lvt_W1p4_L0p6_m2__nf1_gtop_sdfull_ng_0 x1_m21d x1_m21d VDD_body x1_m21d
+ pfet_01v8_lvt_W1p4_L0p6_m2__nf1_gtop_sdfull_ng
Xpfet_01v8_lvt_W1p4_L0p6_m2__nf1_gtop_sdfull_ng_1 x1_m31d x1_m31d VDD_body x1_m31d
+ pfet_01v8_lvt_W1p4_L0p6_m2__nf1_gtop_sdfull_ng
Xpfet_01v8_lvt_W1p4_L0p6_m2__nf1_gtop_sdfull_ng_2 x1_m21d x1_m21d VDD_body x1_m21d
+ pfet_01v8_lvt_W1p4_L0p6_m2__nf1_gtop_sdfull_ng
Xpfet_01v8_lvt_W1p4_L0p6_m2__nf1_gtop_sdfull_ng_3 x1_m31d x1_m31d VDD_body x1_m31d
+ pfet_01v8_lvt_W1p4_L0p6_m2__nf1_gtop_sdfull_ng
Xpfet_01v8_lvt_W1p4_L0p6_m2__nf1_gtop_sdfull_ng_4 x1_m25d x1_m25d VDD_body x1_m25d
+ pfet_01v8_lvt_W1p4_L0p6_m2__nf1_gtop_sdfull_ng
Xpfet_01v8_lvt_W1p4_L0p6_m2__nf1_gtop_sdfull_ng_5 x1_m25d x1_m25d VDD_body x1_m25d
+ pfet_01v8_lvt_W1p4_L0p6_m2__nf1_gtop_sdfull_ng
.ends
