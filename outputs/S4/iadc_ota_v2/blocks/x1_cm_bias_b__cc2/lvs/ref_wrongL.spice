.subckt x1_cm_bias_b__cc2 VDD bias_b x1_m21d x1_m25d x1_m31d VDD_body
XXX1_M21 x1_m21d bias_b VDD VDD_body sky130_fd_pr__pfet_01v8_lvt L=0.7 W=1.4 nf=1 m=6
XXX1_M25 x1_m25d bias_b VDD VDD_body sky130_fd_pr__pfet_01v8_lvt L=0.6 W=1.4 nf=1 m=6
XXX1_M31 x1_m31d bias_b VDD VDD_body sky130_fd_pr__pfet_01v8_lvt L=0.6 W=1.4 nf=1 m=6
XXX1_M46 x1_m21d x1_m21d x1_m21d VDD_body sky130_fd_pr__pfet_01v8_lvt L=0.6 W=1.4 nf=1 m=2
XXX1_M47 x1_m25d x1_m25d x1_m25d VDD_body sky130_fd_pr__pfet_01v8_lvt L=0.6 W=1.4 nf=1 m=2
XXX1_M48 x1_m31d x1_m31d x1_m31d VDD_body sky130_fd_pr__pfet_01v8_lvt L=0.6 W=1.4 nf=1 m=2
XXX1_M51 x1_m21d x1_m21d x1_m21d VDD_body sky130_fd_pr__pfet_01v8 L=0.6 W=1.4 nf=1 m=2
XXX1_M54 x1_m25d x1_m25d x1_m25d VDD_body sky130_fd_pr__pfet_01v8 L=0.6 W=1.4 nf=1 m=2
XXX1_M60 x1_m31d VDD VDD VDD_body sky130_fd_pr__pfet_01v8 L=0.6 W=1.4 nf=1 m=2
.ends
