.subckt x1_diode_bias_b__f4 bias_b bias_c VSS_body
XXX1_M1 bias_b bias_b bias_c VSS_body sky130_fd_pr__nfet_01v8_lvt L=0.7 W=1.4 nf=1 m=56
XXX1_M27 bias_b bias_b bias_b VSS_body sky130_fd_pr__nfet_01v8_lvt L=0.6 W=1.4 nf=1 m=8
.ends
