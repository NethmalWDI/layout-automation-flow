.subckt XC4__A on cmc
XC4 on cmc sky130_fd_pr__cap_mim_m3_1 W=4.8 L=5.28 m=4
.ends
