* NGSPICE file created from x1_diode_m2d__f5.ext - technology: sky130A

.subckt sky130_fd_pr__nfet_01v8_KCM6UP G D S VSUBS
X0 S G D VSUBS sky130_fd_pr__nfet_01v8 ad=0.406 pd=3.38 as=0.406 ps=3.38 w=1.4 l=0.6
.ends

.subckt nfet_01v8_W1p4_L0p6_m50__nf1_gboth_sdfull_ng S B G D
Xnfet_01v8_W1p4_L0p6_m50__nf1_gboth_sdfull_ng_pc G D S B sky130_fd_pr__nfet_01v8_KCM6UP
.ends

.subckt nfet_01v8_W1p4_L0p6_m2__nf1_gboth_sdfull_ng B S G D
Xnfet_01v8_W1p4_L0p6_m2__nf1_gboth_sdfull_ng_pc G D S B sky130_fd_pr__nfet_01v8_KCM6UP
.ends

.subckt x1_diode_m2d__f5 VSS x1_m2d bias_d VSS_body
Xnfet_01v8_W1p4_L0p6_m50__nf1_gboth_sdfull_ng_56 bias_d VSS_body x1_m2d x1_m2d nfet_01v8_W1p4_L0p6_m50__nf1_gboth_sdfull_ng
Xnfet_01v8_W1p4_L0p6_m50__nf1_gboth_sdfull_ng_57 VSS VSS_body VSS VSS nfet_01v8_W1p4_L0p6_m50__nf1_gboth_sdfull_ng
Xnfet_01v8_W1p4_L0p6_m50__nf1_gboth_sdfull_ng_46 VSS VSS_body VSS VSS nfet_01v8_W1p4_L0p6_m50__nf1_gboth_sdfull_ng
Xnfet_01v8_W1p4_L0p6_m50__nf1_gboth_sdfull_ng_45 VSS VSS_body VSS VSS nfet_01v8_W1p4_L0p6_m50__nf1_gboth_sdfull_ng
Xnfet_01v8_W1p4_L0p6_m50__nf1_gboth_sdfull_ng_34 VSS VSS_body VSS VSS nfet_01v8_W1p4_L0p6_m50__nf1_gboth_sdfull_ng
Xnfet_01v8_W1p4_L0p6_m50__nf1_gboth_sdfull_ng_35 bias_d VSS_body x1_m2d x1_m2d nfet_01v8_W1p4_L0p6_m50__nf1_gboth_sdfull_ng
Xnfet_01v8_W1p4_L0p6_m50__nf1_gboth_sdfull_ng_24 bias_d VSS_body x1_m2d x1_m2d nfet_01v8_W1p4_L0p6_m50__nf1_gboth_sdfull_ng
Xnfet_01v8_W1p4_L0p6_m50__nf1_gboth_sdfull_ng_23 bias_d VSS_body x1_m2d x1_m2d nfet_01v8_W1p4_L0p6_m50__nf1_gboth_sdfull_ng
Xnfet_01v8_W1p4_L0p6_m50__nf1_gboth_sdfull_ng_12 bias_d VSS_body x1_m2d x1_m2d nfet_01v8_W1p4_L0p6_m50__nf1_gboth_sdfull_ng
Xnfet_01v8_W1p4_L0p6_m50__nf1_gboth_sdfull_ng_13 bias_d VSS_body x1_m2d x1_m2d nfet_01v8_W1p4_L0p6_m50__nf1_gboth_sdfull_ng
Xnfet_01v8_W1p4_L0p6_m50__nf1_gboth_sdfull_ng_47 bias_d VSS_body x1_m2d x1_m2d nfet_01v8_W1p4_L0p6_m50__nf1_gboth_sdfull_ng
Xnfet_01v8_W1p4_L0p6_m50__nf1_gboth_sdfull_ng_36 bias_d VSS_body x1_m2d x1_m2d nfet_01v8_W1p4_L0p6_m50__nf1_gboth_sdfull_ng
Xnfet_01v8_W1p4_L0p6_m50__nf1_gboth_sdfull_ng_25 bias_d VSS_body x1_m2d x1_m2d nfet_01v8_W1p4_L0p6_m50__nf1_gboth_sdfull_ng
Xnfet_01v8_W1p4_L0p6_m50__nf1_gboth_sdfull_ng_14 bias_d VSS_body x1_m2d x1_m2d nfet_01v8_W1p4_L0p6_m50__nf1_gboth_sdfull_ng
Xnfet_01v8_W1p4_L0p6_m50__nf1_gboth_sdfull_ng_48 bias_d VSS_body x1_m2d x1_m2d nfet_01v8_W1p4_L0p6_m50__nf1_gboth_sdfull_ng
Xnfet_01v8_W1p4_L0p6_m50__nf1_gboth_sdfull_ng_37 bias_d VSS_body x1_m2d x1_m2d nfet_01v8_W1p4_L0p6_m50__nf1_gboth_sdfull_ng
Xnfet_01v8_W1p4_L0p6_m50__nf1_gboth_sdfull_ng_26 bias_d VSS_body x1_m2d x1_m2d nfet_01v8_W1p4_L0p6_m50__nf1_gboth_sdfull_ng
Xnfet_01v8_W1p4_L0p6_m50__nf1_gboth_sdfull_ng_15 bias_d VSS_body x1_m2d x1_m2d nfet_01v8_W1p4_L0p6_m50__nf1_gboth_sdfull_ng
Xnfet_01v8_W1p4_L0p6_m50__nf1_gboth_sdfull_ng_49 bias_d VSS_body x1_m2d x1_m2d nfet_01v8_W1p4_L0p6_m50__nf1_gboth_sdfull_ng
Xnfet_01v8_W1p4_L0p6_m50__nf1_gboth_sdfull_ng_38 bias_d VSS_body x1_m2d x1_m2d nfet_01v8_W1p4_L0p6_m50__nf1_gboth_sdfull_ng
Xnfet_01v8_W1p4_L0p6_m50__nf1_gboth_sdfull_ng_27 bias_d VSS_body x1_m2d x1_m2d nfet_01v8_W1p4_L0p6_m50__nf1_gboth_sdfull_ng
Xnfet_01v8_W1p4_L0p6_m50__nf1_gboth_sdfull_ng_16 bias_d VSS_body x1_m2d x1_m2d nfet_01v8_W1p4_L0p6_m50__nf1_gboth_sdfull_ng
Xnfet_01v8_W1p4_L0p6_m50__nf1_gboth_sdfull_ng_39 bias_d VSS_body x1_m2d x1_m2d nfet_01v8_W1p4_L0p6_m50__nf1_gboth_sdfull_ng
Xnfet_01v8_W1p4_L0p6_m50__nf1_gboth_sdfull_ng_28 bias_d VSS_body x1_m2d x1_m2d nfet_01v8_W1p4_L0p6_m50__nf1_gboth_sdfull_ng
Xnfet_01v8_W1p4_L0p6_m50__nf1_gboth_sdfull_ng_17 bias_d VSS_body x1_m2d x1_m2d nfet_01v8_W1p4_L0p6_m50__nf1_gboth_sdfull_ng
Xnfet_01v8_W1p4_L0p6_m50__nf1_gboth_sdfull_ng_0 bias_d VSS_body x1_m2d x1_m2d nfet_01v8_W1p4_L0p6_m50__nf1_gboth_sdfull_ng
Xnfet_01v8_W1p4_L0p6_m50__nf1_gboth_sdfull_ng_29 bias_d VSS_body x1_m2d x1_m2d nfet_01v8_W1p4_L0p6_m50__nf1_gboth_sdfull_ng
Xnfet_01v8_W1p4_L0p6_m50__nf1_gboth_sdfull_ng_18 bias_d VSS_body x1_m2d x1_m2d nfet_01v8_W1p4_L0p6_m50__nf1_gboth_sdfull_ng
Xnfet_01v8_W1p4_L0p6_m50__nf1_gboth_sdfull_ng_1 bias_d VSS_body x1_m2d x1_m2d nfet_01v8_W1p4_L0p6_m50__nf1_gboth_sdfull_ng
Xnfet_01v8_W1p4_L0p6_m50__nf1_gboth_sdfull_ng_19 bias_d VSS_body x1_m2d x1_m2d nfet_01v8_W1p4_L0p6_m50__nf1_gboth_sdfull_ng
Xnfet_01v8_W1p4_L0p6_m50__nf1_gboth_sdfull_ng_2 bias_d VSS_body x1_m2d x1_m2d nfet_01v8_W1p4_L0p6_m50__nf1_gboth_sdfull_ng
Xnfet_01v8_W1p4_L0p6_m50__nf1_gboth_sdfull_ng_3 bias_d VSS_body x1_m2d x1_m2d nfet_01v8_W1p4_L0p6_m50__nf1_gboth_sdfull_ng
Xnfet_01v8_W1p4_L0p6_m50__nf1_gboth_sdfull_ng_5 bias_d VSS_body x1_m2d x1_m2d nfet_01v8_W1p4_L0p6_m50__nf1_gboth_sdfull_ng
Xnfet_01v8_W1p4_L0p6_m50__nf1_gboth_sdfull_ng_4 bias_d VSS_body x1_m2d x1_m2d nfet_01v8_W1p4_L0p6_m50__nf1_gboth_sdfull_ng
Xnfet_01v8_W1p4_L0p6_m50__nf1_gboth_sdfull_ng_6 bias_d VSS_body x1_m2d x1_m2d nfet_01v8_W1p4_L0p6_m50__nf1_gboth_sdfull_ng
Xnfet_01v8_W1p4_L0p6_m50__nf1_gboth_sdfull_ng_7 bias_d VSS_body x1_m2d x1_m2d nfet_01v8_W1p4_L0p6_m50__nf1_gboth_sdfull_ng
Xnfet_01v8_W1p4_L0p6_m50__nf1_gboth_sdfull_ng_8 bias_d VSS_body x1_m2d x1_m2d nfet_01v8_W1p4_L0p6_m50__nf1_gboth_sdfull_ng
Xnfet_01v8_W1p4_L0p6_m50__nf1_gboth_sdfull_ng_9 bias_d VSS_body x1_m2d x1_m2d nfet_01v8_W1p4_L0p6_m50__nf1_gboth_sdfull_ng
Xnfet_01v8_W1p4_L0p6_m2__nf1_gboth_sdfull_ng_0 VSS_body x1_m2d x1_m2d x1_m2d nfet_01v8_W1p4_L0p6_m2__nf1_gboth_sdfull_ng
Xnfet_01v8_W1p4_L0p6_m2__nf1_gboth_sdfull_ng_1 VSS_body x1_m2d x1_m2d x1_m2d nfet_01v8_W1p4_L0p6_m2__nf1_gboth_sdfull_ng
Xnfet_01v8_W1p4_L0p6_m50__nf1_gboth_sdfull_ng_50 bias_d VSS_body x1_m2d x1_m2d nfet_01v8_W1p4_L0p6_m50__nf1_gboth_sdfull_ng
Xnfet_01v8_W1p4_L0p6_m50__nf1_gboth_sdfull_ng_51 bias_d VSS_body x1_m2d x1_m2d nfet_01v8_W1p4_L0p6_m50__nf1_gboth_sdfull_ng
Xnfet_01v8_W1p4_L0p6_m50__nf1_gboth_sdfull_ng_40 bias_d VSS_body x1_m2d x1_m2d nfet_01v8_W1p4_L0p6_m50__nf1_gboth_sdfull_ng
Xnfet_01v8_W1p4_L0p6_m50__nf1_gboth_sdfull_ng_52 bias_d VSS_body x1_m2d x1_m2d nfet_01v8_W1p4_L0p6_m50__nf1_gboth_sdfull_ng
Xnfet_01v8_W1p4_L0p6_m50__nf1_gboth_sdfull_ng_41 bias_d VSS_body x1_m2d x1_m2d nfet_01v8_W1p4_L0p6_m50__nf1_gboth_sdfull_ng
Xnfet_01v8_W1p4_L0p6_m50__nf1_gboth_sdfull_ng_30 bias_d VSS_body x1_m2d x1_m2d nfet_01v8_W1p4_L0p6_m50__nf1_gboth_sdfull_ng
Xnfet_01v8_W1p4_L0p6_m50__nf1_gboth_sdfull_ng_53 bias_d VSS_body x1_m2d x1_m2d nfet_01v8_W1p4_L0p6_m50__nf1_gboth_sdfull_ng
Xnfet_01v8_W1p4_L0p6_m50__nf1_gboth_sdfull_ng_42 bias_d VSS_body x1_m2d x1_m2d nfet_01v8_W1p4_L0p6_m50__nf1_gboth_sdfull_ng
Xnfet_01v8_W1p4_L0p6_m50__nf1_gboth_sdfull_ng_31 bias_d VSS_body x1_m2d x1_m2d nfet_01v8_W1p4_L0p6_m50__nf1_gboth_sdfull_ng
Xnfet_01v8_W1p4_L0p6_m50__nf1_gboth_sdfull_ng_20 bias_d VSS_body x1_m2d x1_m2d nfet_01v8_W1p4_L0p6_m50__nf1_gboth_sdfull_ng
Xnfet_01v8_W1p4_L0p6_m50__nf1_gboth_sdfull_ng_54 bias_d VSS_body x1_m2d x1_m2d nfet_01v8_W1p4_L0p6_m50__nf1_gboth_sdfull_ng
Xnfet_01v8_W1p4_L0p6_m50__nf1_gboth_sdfull_ng_43 bias_d VSS_body x1_m2d x1_m2d nfet_01v8_W1p4_L0p6_m50__nf1_gboth_sdfull_ng
Xnfet_01v8_W1p4_L0p6_m50__nf1_gboth_sdfull_ng_32 bias_d VSS_body x1_m2d x1_m2d nfet_01v8_W1p4_L0p6_m50__nf1_gboth_sdfull_ng
Xnfet_01v8_W1p4_L0p6_m50__nf1_gboth_sdfull_ng_21 VSS VSS_body VSS VSS nfet_01v8_W1p4_L0p6_m50__nf1_gboth_sdfull_ng
Xnfet_01v8_W1p4_L0p6_m50__nf1_gboth_sdfull_ng_10 VSS VSS_body VSS VSS nfet_01v8_W1p4_L0p6_m50__nf1_gboth_sdfull_ng
Xnfet_01v8_W1p4_L0p6_m50__nf1_gboth_sdfull_ng_55 bias_d VSS_body x1_m2d x1_m2d nfet_01v8_W1p4_L0p6_m50__nf1_gboth_sdfull_ng
Xnfet_01v8_W1p4_L0p6_m50__nf1_gboth_sdfull_ng_44 bias_d VSS_body x1_m2d x1_m2d nfet_01v8_W1p4_L0p6_m50__nf1_gboth_sdfull_ng
Xnfet_01v8_W1p4_L0p6_m50__nf1_gboth_sdfull_ng_33 VSS VSS_body VSS VSS nfet_01v8_W1p4_L0p6_m50__nf1_gboth_sdfull_ng
Xnfet_01v8_W1p4_L0p6_m50__nf1_gboth_sdfull_ng_22 VSS VSS_body VSS VSS nfet_01v8_W1p4_L0p6_m50__nf1_gboth_sdfull_ng
Xnfet_01v8_W1p4_L0p6_m50__nf1_gboth_sdfull_ng_11 bias_d VSS_body x1_m2d x1_m2d nfet_01v8_W1p4_L0p6_m50__nf1_gboth_sdfull_ng
.ends
