.subckt x2_cm_casc__cc3 VSS bias_d on op x2_m3d x2_m4d VSS_body
XXX2_M3A on bias_d x2_m3d VSS_body sky130_fd_pr__nfet_01v8 L=0.6 W=1.4 nf=1 m=36
XXX2_M7 op bias_d x2_m4d VSS_body sky130_fd_pr__nfet_01v8 L=0.6 W=1.4 nf=1 m=36
XXX2_M38 op op op VSS_body sky130_fd_pr__nfet_01v8 L=0.6 W=1.4 nf=1 m=2
XXX2_M39 on on on VSS_body sky130_fd_pr__nfet_01v8 L=0.6 W=1.4 nf=1 m=2
XXX2_M80 op VSS VSS VSS_body sky130_fd_pr__nfet_01v8 L=0.6 W=1.4 nf=1 m=2
XXX2_M81 on VSS VSS VSS_body sky130_fd_pr__nfet_01v8 L=0.6 W=1.4 nf=1 m=2
Xx2_cm_casc_DUMMY0 VSS VSS VSS VSS_body sky130_fd_pr__nfet_01v8 L=0.6 W=1.4 nf=1
Xx2_cm_casc_DUMMY1 VSS VSS VSS VSS_body sky130_fd_pr__nfet_01v8 L=0.6 W=1.4 nf=1
Xx2_cm_casc_DUMMY2 VSS VSS VSS VSS_body sky130_fd_pr__nfet_01v8 L=0.6 W=1.4 nf=1
Xx2_cm_casc_DUMMY3 VSS VSS VSS VSS_body sky130_fd_pr__nfet_01v8 L=0.6 W=1.4 nf=1
.ends
