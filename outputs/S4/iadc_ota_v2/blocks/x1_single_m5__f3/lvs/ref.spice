.subckt x1_single_m5__f3 VSS bias_a x1_m5d VSS_body
XXX1_M5 x1_m5d bias_a VSS VSS_body sky130_fd_pr__nfet_01v8 L=0.6 W=1.4 nf=1 m=18
XXX1_M29 x1_m5d x1_m5d x1_m5d VSS_body sky130_fd_pr__nfet_01v8 L=0.6 W=1.4 nf=1 m=6
XXX1_M42 x1_m5d VSS VSS VSS_body sky130_fd_pr__nfet_01v8 L=0.6 W=1.4 nf=1 m=6
.ends
