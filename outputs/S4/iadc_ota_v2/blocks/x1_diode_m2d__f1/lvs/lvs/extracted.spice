* NGSPICE file created from x1_diode_m2d__f1.ext - technology: sky130A

.subckt sky130_fd_pr__nfet_01v8_KCM6UP G D S VSUBS
X0 S G D VSUBS sky130_fd_pr__nfet_01v8 ad=0.406 pd=3.38 as=0.406 ps=3.38 w=1.4 l=0.6
.ends

.subckt nfet_01v8_W1p4_L0p6_m50__nf1_gboth_sdfull_ng B G D S
Xnfet_01v8_W1p4_L0p6_m50__nf1_gboth_sdfull_ng_pc G D S B sky130_fd_pr__nfet_01v8_KCM6UP
.ends

.subckt nfet_01v8_W1p4_L0p6_m2__nf1_gboth_sdfull_ng B S G D
Xnfet_01v8_W1p4_L0p6_m2__nf1_gboth_sdfull_ng_pc G D S B sky130_fd_pr__nfet_01v8_KCM6UP
.ends

.subckt x1_diode_m2d__f1 x1_m2d bias_d VSS_body
Xnfet_01v8_W1p4_L0p6_m50__nf1_gboth_sdfull_ng_46 VSS_body x1_m2d x1_m2d bias_d nfet_01v8_W1p4_L0p6_m50__nf1_gboth_sdfull_ng
Xnfet_01v8_W1p4_L0p6_m50__nf1_gboth_sdfull_ng_45 VSS_body x1_m2d x1_m2d bias_d nfet_01v8_W1p4_L0p6_m50__nf1_gboth_sdfull_ng
Xnfet_01v8_W1p4_L0p6_m50__nf1_gboth_sdfull_ng_35 VSS_body x1_m2d x1_m2d bias_d nfet_01v8_W1p4_L0p6_m50__nf1_gboth_sdfull_ng
Xnfet_01v8_W1p4_L0p6_m50__nf1_gboth_sdfull_ng_34 VSS_body x1_m2d x1_m2d bias_d nfet_01v8_W1p4_L0p6_m50__nf1_gboth_sdfull_ng
Xnfet_01v8_W1p4_L0p6_m50__nf1_gboth_sdfull_ng_24 VSS_body x1_m2d x1_m2d bias_d nfet_01v8_W1p4_L0p6_m50__nf1_gboth_sdfull_ng
Xnfet_01v8_W1p4_L0p6_m50__nf1_gboth_sdfull_ng_23 VSS_body x1_m2d x1_m2d bias_d nfet_01v8_W1p4_L0p6_m50__nf1_gboth_sdfull_ng
Xnfet_01v8_W1p4_L0p6_m50__nf1_gboth_sdfull_ng_13 VSS_body x1_m2d x1_m2d bias_d nfet_01v8_W1p4_L0p6_m50__nf1_gboth_sdfull_ng
Xnfet_01v8_W1p4_L0p6_m50__nf1_gboth_sdfull_ng_12 VSS_body x1_m2d x1_m2d bias_d nfet_01v8_W1p4_L0p6_m50__nf1_gboth_sdfull_ng
Xnfet_01v8_W1p4_L0p6_m50__nf1_gboth_sdfull_ng_47 VSS_body x1_m2d x1_m2d bias_d nfet_01v8_W1p4_L0p6_m50__nf1_gboth_sdfull_ng
Xnfet_01v8_W1p4_L0p6_m50__nf1_gboth_sdfull_ng_36 VSS_body x1_m2d x1_m2d bias_d nfet_01v8_W1p4_L0p6_m50__nf1_gboth_sdfull_ng
Xnfet_01v8_W1p4_L0p6_m50__nf1_gboth_sdfull_ng_25 VSS_body x1_m2d x1_m2d bias_d nfet_01v8_W1p4_L0p6_m50__nf1_gboth_sdfull_ng
Xnfet_01v8_W1p4_L0p6_m50__nf1_gboth_sdfull_ng_14 VSS_body x1_m2d x1_m2d bias_d nfet_01v8_W1p4_L0p6_m50__nf1_gboth_sdfull_ng
Xnfet_01v8_W1p4_L0p6_m50__nf1_gboth_sdfull_ng_48 VSS_body x1_m2d x1_m2d bias_d nfet_01v8_W1p4_L0p6_m50__nf1_gboth_sdfull_ng
Xnfet_01v8_W1p4_L0p6_m50__nf1_gboth_sdfull_ng_37 VSS_body x1_m2d x1_m2d bias_d nfet_01v8_W1p4_L0p6_m50__nf1_gboth_sdfull_ng
Xnfet_01v8_W1p4_L0p6_m50__nf1_gboth_sdfull_ng_26 VSS_body x1_m2d x1_m2d bias_d nfet_01v8_W1p4_L0p6_m50__nf1_gboth_sdfull_ng
Xnfet_01v8_W1p4_L0p6_m50__nf1_gboth_sdfull_ng_15 VSS_body x1_m2d x1_m2d bias_d nfet_01v8_W1p4_L0p6_m50__nf1_gboth_sdfull_ng
Xnfet_01v8_W1p4_L0p6_m50__nf1_gboth_sdfull_ng_49 VSS_body x1_m2d x1_m2d bias_d nfet_01v8_W1p4_L0p6_m50__nf1_gboth_sdfull_ng
Xnfet_01v8_W1p4_L0p6_m50__nf1_gboth_sdfull_ng_38 VSS_body x1_m2d x1_m2d bias_d nfet_01v8_W1p4_L0p6_m50__nf1_gboth_sdfull_ng
Xnfet_01v8_W1p4_L0p6_m50__nf1_gboth_sdfull_ng_27 VSS_body x1_m2d x1_m2d bias_d nfet_01v8_W1p4_L0p6_m50__nf1_gboth_sdfull_ng
Xnfet_01v8_W1p4_L0p6_m50__nf1_gboth_sdfull_ng_16 VSS_body x1_m2d x1_m2d bias_d nfet_01v8_W1p4_L0p6_m50__nf1_gboth_sdfull_ng
Xnfet_01v8_W1p4_L0p6_m50__nf1_gboth_sdfull_ng_39 VSS_body x1_m2d x1_m2d bias_d nfet_01v8_W1p4_L0p6_m50__nf1_gboth_sdfull_ng
Xnfet_01v8_W1p4_L0p6_m50__nf1_gboth_sdfull_ng_28 VSS_body x1_m2d x1_m2d bias_d nfet_01v8_W1p4_L0p6_m50__nf1_gboth_sdfull_ng
Xnfet_01v8_W1p4_L0p6_m50__nf1_gboth_sdfull_ng_17 VSS_body x1_m2d x1_m2d bias_d nfet_01v8_W1p4_L0p6_m50__nf1_gboth_sdfull_ng
Xnfet_01v8_W1p4_L0p6_m50__nf1_gboth_sdfull_ng_0 VSS_body x1_m2d x1_m2d bias_d nfet_01v8_W1p4_L0p6_m50__nf1_gboth_sdfull_ng
Xnfet_01v8_W1p4_L0p6_m50__nf1_gboth_sdfull_ng_29 VSS_body x1_m2d x1_m2d bias_d nfet_01v8_W1p4_L0p6_m50__nf1_gboth_sdfull_ng
Xnfet_01v8_W1p4_L0p6_m50__nf1_gboth_sdfull_ng_18 VSS_body x1_m2d x1_m2d bias_d nfet_01v8_W1p4_L0p6_m50__nf1_gboth_sdfull_ng
Xnfet_01v8_W1p4_L0p6_m50__nf1_gboth_sdfull_ng_1 VSS_body x1_m2d x1_m2d bias_d nfet_01v8_W1p4_L0p6_m50__nf1_gboth_sdfull_ng
Xnfet_01v8_W1p4_L0p6_m50__nf1_gboth_sdfull_ng_19 VSS_body x1_m2d x1_m2d bias_d nfet_01v8_W1p4_L0p6_m50__nf1_gboth_sdfull_ng
Xnfet_01v8_W1p4_L0p6_m50__nf1_gboth_sdfull_ng_2 VSS_body x1_m2d x1_m2d bias_d nfet_01v8_W1p4_L0p6_m50__nf1_gboth_sdfull_ng
Xnfet_01v8_W1p4_L0p6_m50__nf1_gboth_sdfull_ng_3 VSS_body x1_m2d x1_m2d bias_d nfet_01v8_W1p4_L0p6_m50__nf1_gboth_sdfull_ng
Xnfet_01v8_W1p4_L0p6_m50__nf1_gboth_sdfull_ng_5 VSS_body x1_m2d x1_m2d bias_d nfet_01v8_W1p4_L0p6_m50__nf1_gboth_sdfull_ng
Xnfet_01v8_W1p4_L0p6_m50__nf1_gboth_sdfull_ng_4 VSS_body x1_m2d x1_m2d bias_d nfet_01v8_W1p4_L0p6_m50__nf1_gboth_sdfull_ng
Xnfet_01v8_W1p4_L0p6_m50__nf1_gboth_sdfull_ng_6 VSS_body x1_m2d x1_m2d bias_d nfet_01v8_W1p4_L0p6_m50__nf1_gboth_sdfull_ng
Xnfet_01v8_W1p4_L0p6_m50__nf1_gboth_sdfull_ng_7 VSS_body x1_m2d x1_m2d bias_d nfet_01v8_W1p4_L0p6_m50__nf1_gboth_sdfull_ng
Xnfet_01v8_W1p4_L0p6_m50__nf1_gboth_sdfull_ng_8 VSS_body x1_m2d x1_m2d bias_d nfet_01v8_W1p4_L0p6_m50__nf1_gboth_sdfull_ng
Xnfet_01v8_W1p4_L0p6_m50__nf1_gboth_sdfull_ng_9 VSS_body x1_m2d x1_m2d bias_d nfet_01v8_W1p4_L0p6_m50__nf1_gboth_sdfull_ng
Xnfet_01v8_W1p4_L0p6_m2__nf1_gboth_sdfull_ng_0 VSS_body x1_m2d x1_m2d x1_m2d nfet_01v8_W1p4_L0p6_m2__nf1_gboth_sdfull_ng
Xnfet_01v8_W1p4_L0p6_m2__nf1_gboth_sdfull_ng_1 VSS_body x1_m2d x1_m2d x1_m2d nfet_01v8_W1p4_L0p6_m2__nf1_gboth_sdfull_ng
Xnfet_01v8_W1p4_L0p6_m50__nf1_gboth_sdfull_ng_40 VSS_body x1_m2d x1_m2d bias_d nfet_01v8_W1p4_L0p6_m50__nf1_gboth_sdfull_ng
Xnfet_01v8_W1p4_L0p6_m50__nf1_gboth_sdfull_ng_41 VSS_body x1_m2d x1_m2d bias_d nfet_01v8_W1p4_L0p6_m50__nf1_gboth_sdfull_ng
Xnfet_01v8_W1p4_L0p6_m50__nf1_gboth_sdfull_ng_30 VSS_body x1_m2d x1_m2d bias_d nfet_01v8_W1p4_L0p6_m50__nf1_gboth_sdfull_ng
Xnfet_01v8_W1p4_L0p6_m50__nf1_gboth_sdfull_ng_42 VSS_body x1_m2d x1_m2d bias_d nfet_01v8_W1p4_L0p6_m50__nf1_gboth_sdfull_ng
Xnfet_01v8_W1p4_L0p6_m50__nf1_gboth_sdfull_ng_31 VSS_body x1_m2d x1_m2d bias_d nfet_01v8_W1p4_L0p6_m50__nf1_gboth_sdfull_ng
Xnfet_01v8_W1p4_L0p6_m50__nf1_gboth_sdfull_ng_20 VSS_body x1_m2d x1_m2d bias_d nfet_01v8_W1p4_L0p6_m50__nf1_gboth_sdfull_ng
Xnfet_01v8_W1p4_L0p6_m50__nf1_gboth_sdfull_ng_43 VSS_body x1_m2d x1_m2d bias_d nfet_01v8_W1p4_L0p6_m50__nf1_gboth_sdfull_ng
Xnfet_01v8_W1p4_L0p6_m50__nf1_gboth_sdfull_ng_32 VSS_body x1_m2d x1_m2d bias_d nfet_01v8_W1p4_L0p6_m50__nf1_gboth_sdfull_ng
Xnfet_01v8_W1p4_L0p6_m50__nf1_gboth_sdfull_ng_21 VSS_body x1_m2d x1_m2d bias_d nfet_01v8_W1p4_L0p6_m50__nf1_gboth_sdfull_ng
Xnfet_01v8_W1p4_L0p6_m50__nf1_gboth_sdfull_ng_10 VSS_body x1_m2d x1_m2d bias_d nfet_01v8_W1p4_L0p6_m50__nf1_gboth_sdfull_ng
Xnfet_01v8_W1p4_L0p6_m50__nf1_gboth_sdfull_ng_44 VSS_body x1_m2d x1_m2d bias_d nfet_01v8_W1p4_L0p6_m50__nf1_gboth_sdfull_ng
Xnfet_01v8_W1p4_L0p6_m50__nf1_gboth_sdfull_ng_33 VSS_body x1_m2d x1_m2d bias_d nfet_01v8_W1p4_L0p6_m50__nf1_gboth_sdfull_ng
Xnfet_01v8_W1p4_L0p6_m50__nf1_gboth_sdfull_ng_22 VSS_body x1_m2d x1_m2d bias_d nfet_01v8_W1p4_L0p6_m50__nf1_gboth_sdfull_ng
Xnfet_01v8_W1p4_L0p6_m50__nf1_gboth_sdfull_ng_11 VSS_body x1_m2d x1_m2d bias_d nfet_01v8_W1p4_L0p6_m50__nf1_gboth_sdfull_ng
.ends
