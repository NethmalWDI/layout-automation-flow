.subckt x1_cm_bias_c__cc2 VDD bias_b bias_c cm x1_m21d x1_m25d x1_m2d x1_m31d VDD_body
XXX1_M22 bias_b bias_c x1_m21d VDD_body sky130_fd_pr__pfet_01v8 L=0.6 W=1.4 nf=1 m=6
XXX1_M26 x1_m2d bias_c x1_m25d VDD_body sky130_fd_pr__pfet_01v8 L=0.6 W=1.4 nf=1 m=6
XXX1_M32 cm bias_c x1_m31d VDD_body sky130_fd_pr__pfet_01v8 L=0.6 W=1.4 nf=1 m=6
XXX1_M57 bias_b VDD VDD VDD_body sky130_fd_pr__pfet_01v8 L=0.6 W=1.4 nf=1 m=2
XXX1_M58 x1_m2d VDD VDD VDD_body sky130_fd_pr__pfet_01v8 L=0.6 W=1.4 nf=1 m=2
XXX1_M59 cm VDD VDD VDD_body sky130_fd_pr__pfet_01v8 L=0.6 W=1.4 nf=1 m=2
Xx1_cm_bias_c_DUMMY0 VDD VDD VDD VDD_body sky130_fd_pr__pfet_01v8 L=0.6 W=1.4 nf=1
Xx1_cm_bias_c_DUMMY1 VDD VDD VDD VDD_body sky130_fd_pr__pfet_01v8 L=0.6 W=1.4 nf=1
.ends
