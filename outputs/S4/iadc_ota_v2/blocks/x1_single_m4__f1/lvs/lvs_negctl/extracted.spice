* NGSPICE file created from x1_single_m4__f1.ext - technology: sky130A

.subckt sky130_fd_pr__nfet_01v8_KCM6UP G D S VSUBS
X0 S G D VSUBS sky130_fd_pr__nfet_01v8 ad=0.406 pd=3.38 as=0.406 ps=3.38 w=1.4 l=0.6
.ends

.subckt nfet_01v8_W1p4_L0p6_m18__nf1_gboth_sdfull_ng G B D S
Xnfet_01v8_W1p4_L0p6_m18__nf1_gboth_sdfull_ng_pc G D S B sky130_fd_pr__nfet_01v8_KCM6UP
.ends

.subckt sky130_fd_pr__nfet_01v8_RUA5M6 G D S VSUBS
X0 S G D VSUBS sky130_fd_pr__nfet_01v8 ad=0.406 pd=3.38 as=0.406 ps=3.38 w=1.4 l=0.6
.ends

.subckt nfet_01v8_W1p4_L0p6_m4__nf1_gtop_sdfull_ng B S G D
Xnfet_01v8_W1p4_L0p6_m4__nf1_gtop_sdfull_ng_pc G D S B sky130_fd_pr__nfet_01v8_RUA5M6
.ends

.subckt x1_single_m4__f1 bias_a bias_d x1_m5d VSS_body
Xnfet_01v8_W1p4_L0p6_m18__nf1_gboth_sdfull_ng_0 bias_d VSS_body bias_a x1_m5d nfet_01v8_W1p4_L0p6_m18__nf1_gboth_sdfull_ng
Xnfet_01v8_W1p4_L0p6_m18__nf1_gboth_sdfull_ng_11 bias_d VSS_body bias_a x1_m5d nfet_01v8_W1p4_L0p6_m18__nf1_gboth_sdfull_ng
Xnfet_01v8_W1p4_L0p6_m18__nf1_gboth_sdfull_ng_10 bias_d VSS_body bias_a x1_m5d nfet_01v8_W1p4_L0p6_m18__nf1_gboth_sdfull_ng
Xnfet_01v8_W1p4_L0p6_m18__nf1_gboth_sdfull_ng_2 bias_d VSS_body bias_a x1_m5d nfet_01v8_W1p4_L0p6_m18__nf1_gboth_sdfull_ng
Xnfet_01v8_W1p4_L0p6_m18__nf1_gboth_sdfull_ng_1 bias_d VSS_body bias_a x1_m5d nfet_01v8_W1p4_L0p6_m18__nf1_gboth_sdfull_ng
Xnfet_01v8_W1p4_L0p6_m18__nf1_gboth_sdfull_ng_12 bias_d VSS_body bias_a x1_m5d nfet_01v8_W1p4_L0p6_m18__nf1_gboth_sdfull_ng
Xnfet_01v8_W1p4_L0p6_m18__nf1_gboth_sdfull_ng_3 bias_d VSS_body bias_a x1_m5d nfet_01v8_W1p4_L0p6_m18__nf1_gboth_sdfull_ng
Xnfet_01v8_W1p4_L0p6_m18__nf1_gboth_sdfull_ng_13 bias_d VSS_body bias_a x1_m5d nfet_01v8_W1p4_L0p6_m18__nf1_gboth_sdfull_ng
Xnfet_01v8_W1p4_L0p6_m18__nf1_gboth_sdfull_ng_4 bias_d VSS_body bias_a x1_m5d nfet_01v8_W1p4_L0p6_m18__nf1_gboth_sdfull_ng
Xnfet_01v8_W1p4_L0p6_m18__nf1_gboth_sdfull_ng_14 bias_d VSS_body bias_a x1_m5d nfet_01v8_W1p4_L0p6_m18__nf1_gboth_sdfull_ng
Xnfet_01v8_W1p4_L0p6_m18__nf1_gboth_sdfull_ng_5 bias_d VSS_body bias_a x1_m5d nfet_01v8_W1p4_L0p6_m18__nf1_gboth_sdfull_ng
Xnfet_01v8_W1p4_L0p6_m18__nf1_gboth_sdfull_ng_15 bias_d VSS_body bias_a x1_m5d nfet_01v8_W1p4_L0p6_m18__nf1_gboth_sdfull_ng
Xnfet_01v8_W1p4_L0p6_m18__nf1_gboth_sdfull_ng_6 bias_d VSS_body bias_a x1_m5d nfet_01v8_W1p4_L0p6_m18__nf1_gboth_sdfull_ng
Xnfet_01v8_W1p4_L0p6_m18__nf1_gboth_sdfull_ng_16 bias_d VSS_body bias_a x1_m5d nfet_01v8_W1p4_L0p6_m18__nf1_gboth_sdfull_ng
Xnfet_01v8_W1p4_L0p6_m18__nf1_gboth_sdfull_ng_7 bias_d VSS_body bias_a x1_m5d nfet_01v8_W1p4_L0p6_m18__nf1_gboth_sdfull_ng
Xnfet_01v8_W1p4_L0p6_m18__nf1_gboth_sdfull_ng_17 bias_d VSS_body bias_a x1_m5d nfet_01v8_W1p4_L0p6_m18__nf1_gboth_sdfull_ng
Xnfet_01v8_W1p4_L0p6_m18__nf1_gboth_sdfull_ng_8 bias_d VSS_body bias_a x1_m5d nfet_01v8_W1p4_L0p6_m18__nf1_gboth_sdfull_ng
Xnfet_01v8_W1p4_L0p6_m18__nf1_gboth_sdfull_ng_9 bias_d VSS_body bias_a x1_m5d nfet_01v8_W1p4_L0p6_m18__nf1_gboth_sdfull_ng
Xnfet_01v8_W1p4_L0p6_m4__nf1_gtop_sdfull_ng_0 VSS_body bias_a bias_a bias_a nfet_01v8_W1p4_L0p6_m4__nf1_gtop_sdfull_ng
Xnfet_01v8_W1p4_L0p6_m4__nf1_gtop_sdfull_ng_2 VSS_body bias_a bias_a bias_a nfet_01v8_W1p4_L0p6_m4__nf1_gtop_sdfull_ng
Xnfet_01v8_W1p4_L0p6_m4__nf1_gtop_sdfull_ng_1 VSS_body bias_a bias_a bias_a nfet_01v8_W1p4_L0p6_m4__nf1_gtop_sdfull_ng
Xnfet_01v8_W1p4_L0p6_m4__nf1_gtop_sdfull_ng_3 VSS_body bias_a bias_a bias_a nfet_01v8_W1p4_L0p6_m4__nf1_gtop_sdfull_ng
.ends
