.subckt x2_cl_src__id4 VDD bias_b x2_foldn x2_foldp VDD_body
XXX2_M11 x2_foldp bias_b VDD VDD_body sky130_fd_pr__pfet_01v8_lvt L=0.7 W=1.4 nf=1 m=24
XXX2_M12 x2_foldn bias_b VDD VDD_body sky130_fd_pr__pfet_01v8_lvt L=0.6 W=1.4 nf=1 m=24
XXX2_M55 x2_foldn VDD VDD VDD_body sky130_fd_pr__pfet_01v8 L=0.6 W=1.4 nf=1 m=2
XXX2_M61 x2_foldp VDD VDD VDD_body sky130_fd_pr__pfet_01v8 L=0.6 W=1.4 nf=1 m=2
XXX2_M82 x2_foldn x2_foldn x2_foldn VDD_body sky130_fd_pr__pfet_01v8 L=0.6 W=1.4 nf=1 m=2
XXX2_M83 x2_foldp x2_foldp x2_foldp VDD_body sky130_fd_pr__pfet_01v8 L=0.6 W=1.4 nf=1 m=2
.ends
