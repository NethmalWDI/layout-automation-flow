.subckt pmos_dummy_2__f2 VDD VDD_body
XXM45 VDD VDD VDD VDD_body sky130_fd_pr__pfet_01v8 L=0.6 W=1.4 nf=1 m=6
Xpmos_dummy_2_DUMMY0 VDD VDD VDD VDD_body sky130_fd_pr__pfet_01v8 L=0.6 W=1.4 nf=1
Xpmos_dummy_2_DUMMY1 VDD VDD VDD VDD_body sky130_fd_pr__pfet_01v8 L=0.6 W=1.4 nf=1
Xpmos_dummy_2_DUMMY2 VDD VDD VDD VDD_body sky130_fd_pr__pfet_01v8 L=0.6 W=1.4 nf=1
Xpmos_dummy_2_DUMMY3 VDD VDD VDD VDD_body sky130_fd_pr__pfet_01v8 L=0.6 W=1.4 nf=1
.ends
