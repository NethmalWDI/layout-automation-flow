.subckt x1_cc_cm__strings5 VSS cm x1_net1 x1_net2 x1_net3 VSS_body
XXX1_M33 cm cm x1_net1 VSS_body sky130_fd_pr__nfet_01v8 L=0.7 W=1.4 nf=1
XXX1_M49 x1_net1 cm x1_net2 VSS_body sky130_fd_pr__nfet_01v8 L=0.6 W=1.4 nf=1
XXX1_M50 x1_net2 cm x1_net3 VSS_body sky130_fd_pr__nfet_01v8 L=0.6 W=1.4 nf=1
XXX1_M63 x1_net3 cm VSS VSS_body sky130_fd_pr__nfet_01v8 L=0.6 W=1.4 nf=1
XXX1_M64 cm cm x1_net13 VSS_body sky130_fd_pr__nfet_01v8 L=0.6 W=1.4 nf=1
XXX1_M65 x1_net13 cm x1_net14 VSS_body sky130_fd_pr__nfet_01v8 L=0.6 W=1.4 nf=1
XXX1_M66 x1_net14 cm x1_net15 VSS_body sky130_fd_pr__nfet_01v8 L=0.6 W=1.4 nf=1
XXX1_M67 x1_net15 cm VSS VSS_body sky130_fd_pr__nfet_01v8 L=0.6 W=1.4 nf=1
XXX1_M68 cm cm x1_net4 VSS_body sky130_fd_pr__nfet_01v8 L=0.6 W=1.4 nf=1
XXX1_M69 x1_net4 cm x1_net5 VSS_body sky130_fd_pr__nfet_01v8 L=0.6 W=1.4 nf=1
XXX1_M70 x1_net5 cm x1_net6 VSS_body sky130_fd_pr__nfet_01v8 L=0.6 W=1.4 nf=1
XXX1_M71 x1_net6 cm VSS VSS_body sky130_fd_pr__nfet_01v8 L=0.6 W=1.4 nf=1
XXX1_M72 cm cm x1_net7 VSS_body sky130_fd_pr__nfet_01v8 L=0.6 W=1.4 nf=1
XXX1_M73 x1_net7 cm x1_net8 VSS_body sky130_fd_pr__nfet_01v8 L=0.6 W=1.4 nf=1
XXX1_M74 x1_net8 cm x1_net9 VSS_body sky130_fd_pr__nfet_01v8 L=0.6 W=1.4 nf=1
XXX1_M75 x1_net9 cm VSS VSS_body sky130_fd_pr__nfet_01v8 L=0.6 W=1.4 nf=1
XXX1_M76 cm cm x1_net10 VSS_body sky130_fd_pr__nfet_01v8 L=0.6 W=1.4 nf=1
XXX1_M77 x1_net10 cm x1_net11 VSS_body sky130_fd_pr__nfet_01v8 L=0.6 W=1.4 nf=1
XXX1_M78 x1_net11 cm x1_net12 VSS_body sky130_fd_pr__nfet_01v8 L=0.6 W=1.4 nf=1
XXX1_M79 x1_net12 cm VSS VSS_body sky130_fd_pr__nfet_01v8 L=0.6 W=1.4 nf=1
XXX1_M37 cm cm cm VSS_body sky130_fd_pr__nfet_01v8 L=0.6 W=1.4 nf=1 m=8
Xx1_cc_cm_DUMMY0 VSS VSS VSS VSS_body sky130_fd_pr__nfet_01v8 L=0.6 W=1.4 nf=1
Xx1_cc_cm_DUMMY1 VSS VSS VSS VSS_body sky130_fd_pr__nfet_01v8 L=0.6 W=1.4 nf=1
.ends
