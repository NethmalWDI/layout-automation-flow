* NGSPICE file created from x1_cc_cm__strings5.ext - technology: sky130A

.subckt sky130_fd_pr__nfet_01v8_KCM6UP G D S VSUBS
X0 S G D VSUBS sky130_fd_pr__nfet_01v8 ad=0.406 pd=3.38 as=0.406 ps=3.38 w=1.4 l=0.6
.ends

.subckt nfet_01v8_W1p4_L0p6_m1__nf1_gboth_sdfull_ng S B G D
Xnfet_01v8_W1p4_L0p6_m1__nf1_gboth_sdfull_ng_pc G D S B sky130_fd_pr__nfet_01v8_KCM6UP
.ends

.subckt sky130_fd_pr__nfet_01v8_RUA5M6 G D S VSUBS
X0 S G D VSUBS sky130_fd_pr__nfet_01v8 ad=0.406 pd=3.38 as=0.406 ps=3.38 w=1.4 l=0.6
.ends

.subckt nfet_01v8_W1p4_L0p6_m8__nf1_gtop_sdfull_ng B S G D
Xnfet_01v8_W1p4_L0p6_m8__nf1_gtop_sdfull_ng_pc G D S B sky130_fd_pr__nfet_01v8_RUA5M6
.ends

.subckt x1_cc_cm__strings5 VSS cm x1_net1 x1_net2 x1_net3 VSS_body
Xnfet_01v8_W1p4_L0p6_m1__nf1_gboth_sdfull_ng_0 x1_net1 VSS_body cm cm nfet_01v8_W1p4_L0p6_m1__nf1_gboth_sdfull_ng
Xnfet_01v8_W1p4_L0p6_m1__nf1_gboth_sdfull_ng_1 x1_net2 VSS_body cm x1_net1 nfet_01v8_W1p4_L0p6_m1__nf1_gboth_sdfull_ng
Xnfet_01v8_W1p4_L0p6_m1__nf1_gboth_sdfull_ng_20 VSS VSS_body cm nfet_01v8_W1p4_L0p6_m1__nf1_gboth_sdfull_ng_20/D
+ nfet_01v8_W1p4_L0p6_m1__nf1_gboth_sdfull_ng
Xnfet_01v8_W1p4_L0p6_m1__nf1_gboth_sdfull_ng_2 x1_net3 VSS_body cm x1_net2 nfet_01v8_W1p4_L0p6_m1__nf1_gboth_sdfull_ng
Xnfet_01v8_W1p4_L0p6_m1__nf1_gboth_sdfull_ng_21 VSS VSS_body VSS VSS nfet_01v8_W1p4_L0p6_m1__nf1_gboth_sdfull_ng
Xnfet_01v8_W1p4_L0p6_m1__nf1_gboth_sdfull_ng_10 nfet_01v8_W1p4_L0p6_m1__nf1_gboth_sdfull_ng_11/D
+ VSS_body cm nfet_01v8_W1p4_L0p6_m1__nf1_gboth_sdfull_ng_9/S nfet_01v8_W1p4_L0p6_m1__nf1_gboth_sdfull_ng
Xnfet_01v8_W1p4_L0p6_m1__nf1_gboth_sdfull_ng_3 VSS VSS_body cm x1_net3 nfet_01v8_W1p4_L0p6_m1__nf1_gboth_sdfull_ng
Xnfet_01v8_W1p4_L0p6_m1__nf1_gboth_sdfull_ng_11 VSS VSS_body cm nfet_01v8_W1p4_L0p6_m1__nf1_gboth_sdfull_ng_11/D
+ nfet_01v8_W1p4_L0p6_m1__nf1_gboth_sdfull_ng
Xnfet_01v8_W1p4_L0p6_m1__nf1_gboth_sdfull_ng_4 nfet_01v8_W1p4_L0p6_m1__nf1_gboth_sdfull_ng_5/D
+ VSS_body cm cm nfet_01v8_W1p4_L0p6_m1__nf1_gboth_sdfull_ng
Xnfet_01v8_W1p4_L0p6_m1__nf1_gboth_sdfull_ng_12 nfet_01v8_W1p4_L0p6_m1__nf1_gboth_sdfull_ng_13/D
+ VSS_body cm cm nfet_01v8_W1p4_L0p6_m1__nf1_gboth_sdfull_ng
Xnfet_01v8_W1p4_L0p6_m1__nf1_gboth_sdfull_ng_5 nfet_01v8_W1p4_L0p6_m1__nf1_gboth_sdfull_ng_6/D
+ VSS_body cm nfet_01v8_W1p4_L0p6_m1__nf1_gboth_sdfull_ng_5/D nfet_01v8_W1p4_L0p6_m1__nf1_gboth_sdfull_ng
Xnfet_01v8_W1p4_L0p6_m1__nf1_gboth_sdfull_ng_13 nfet_01v8_W1p4_L0p6_m1__nf1_gboth_sdfull_ng_14/D
+ VSS_body cm nfet_01v8_W1p4_L0p6_m1__nf1_gboth_sdfull_ng_13/D nfet_01v8_W1p4_L0p6_m1__nf1_gboth_sdfull_ng
Xnfet_01v8_W1p4_L0p6_m1__nf1_gboth_sdfull_ng_6 nfet_01v8_W1p4_L0p6_m1__nf1_gboth_sdfull_ng_7/D
+ VSS_body cm nfet_01v8_W1p4_L0p6_m1__nf1_gboth_sdfull_ng_6/D nfet_01v8_W1p4_L0p6_m1__nf1_gboth_sdfull_ng
Xnfet_01v8_W1p4_L0p6_m1__nf1_gboth_sdfull_ng_14 nfet_01v8_W1p4_L0p6_m1__nf1_gboth_sdfull_ng_15/D
+ VSS_body cm nfet_01v8_W1p4_L0p6_m1__nf1_gboth_sdfull_ng_14/D nfet_01v8_W1p4_L0p6_m1__nf1_gboth_sdfull_ng
Xnfet_01v8_W1p4_L0p6_m1__nf1_gboth_sdfull_ng_7 VSS VSS_body cm nfet_01v8_W1p4_L0p6_m1__nf1_gboth_sdfull_ng_7/D
+ nfet_01v8_W1p4_L0p6_m1__nf1_gboth_sdfull_ng
Xnfet_01v8_W1p4_L0p6_m1__nf1_gboth_sdfull_ng_15 VSS VSS_body cm nfet_01v8_W1p4_L0p6_m1__nf1_gboth_sdfull_ng_15/D
+ nfet_01v8_W1p4_L0p6_m1__nf1_gboth_sdfull_ng
Xnfet_01v8_W1p4_L0p6_m1__nf1_gboth_sdfull_ng_8 nfet_01v8_W1p4_L0p6_m1__nf1_gboth_sdfull_ng_9/D
+ VSS_body cm cm nfet_01v8_W1p4_L0p6_m1__nf1_gboth_sdfull_ng
Xnfet_01v8_W1p4_L0p6_m1__nf1_gboth_sdfull_ng_9 nfet_01v8_W1p4_L0p6_m1__nf1_gboth_sdfull_ng_9/S
+ VSS_body cm nfet_01v8_W1p4_L0p6_m1__nf1_gboth_sdfull_ng_9/D nfet_01v8_W1p4_L0p6_m1__nf1_gboth_sdfull_ng
Xnfet_01v8_W1p4_L0p6_m1__nf1_gboth_sdfull_ng_16 VSS VSS_body VSS VSS nfet_01v8_W1p4_L0p6_m1__nf1_gboth_sdfull_ng
Xnfet_01v8_W1p4_L0p6_m1__nf1_gboth_sdfull_ng_17 nfet_01v8_W1p4_L0p6_m1__nf1_gboth_sdfull_ng_18/D
+ VSS_body cm cm nfet_01v8_W1p4_L0p6_m1__nf1_gboth_sdfull_ng
Xnfet_01v8_W1p4_L0p6_m1__nf1_gboth_sdfull_ng_18 nfet_01v8_W1p4_L0p6_m1__nf1_gboth_sdfull_ng_19/D
+ VSS_body cm nfet_01v8_W1p4_L0p6_m1__nf1_gboth_sdfull_ng_18/D nfet_01v8_W1p4_L0p6_m1__nf1_gboth_sdfull_ng
Xnfet_01v8_W1p4_L0p6_m1__nf1_gboth_sdfull_ng_19 nfet_01v8_W1p4_L0p6_m1__nf1_gboth_sdfull_ng_20/D
+ VSS_body cm nfet_01v8_W1p4_L0p6_m1__nf1_gboth_sdfull_ng_19/D nfet_01v8_W1p4_L0p6_m1__nf1_gboth_sdfull_ng
Xnfet_01v8_W1p4_L0p6_m8__nf1_gtop_sdfull_ng_0 VSS_body cm cm cm nfet_01v8_W1p4_L0p6_m8__nf1_gtop_sdfull_ng
Xnfet_01v8_W1p4_L0p6_m8__nf1_gtop_sdfull_ng_1 VSS_body cm cm cm nfet_01v8_W1p4_L0p6_m8__nf1_gtop_sdfull_ng
Xnfet_01v8_W1p4_L0p6_m8__nf1_gtop_sdfull_ng_2 VSS_body cm cm cm nfet_01v8_W1p4_L0p6_m8__nf1_gtop_sdfull_ng
Xnfet_01v8_W1p4_L0p6_m8__nf1_gtop_sdfull_ng_3 VSS_body cm cm cm nfet_01v8_W1p4_L0p6_m8__nf1_gtop_sdfull_ng
Xnfet_01v8_W1p4_L0p6_m8__nf1_gtop_sdfull_ng_5 VSS_body cm cm cm nfet_01v8_W1p4_L0p6_m8__nf1_gtop_sdfull_ng
Xnfet_01v8_W1p4_L0p6_m8__nf1_gtop_sdfull_ng_4 VSS_body cm cm cm nfet_01v8_W1p4_L0p6_m8__nf1_gtop_sdfull_ng
Xnfet_01v8_W1p4_L0p6_m8__nf1_gtop_sdfull_ng_6 VSS_body cm cm cm nfet_01v8_W1p4_L0p6_m8__nf1_gtop_sdfull_ng
Xnfet_01v8_W1p4_L0p6_m8__nf1_gtop_sdfull_ng_7 VSS_body cm cm cm nfet_01v8_W1p4_L0p6_m8__nf1_gtop_sdfull_ng
.ends
