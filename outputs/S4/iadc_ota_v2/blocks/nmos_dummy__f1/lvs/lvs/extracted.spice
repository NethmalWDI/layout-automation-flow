* NGSPICE file created from nmos_dummy__f1.ext - technology: sky130A

.subckt sky130_fd_pr__nfet_01v8_RUA5M6 G D S VSUBS
X0 S G D VSUBS sky130_fd_pr__nfet_01v8 ad=0.406 pd=3.38 as=0.406 ps=3.38 w=1.4 l=0.6
.ends

.subckt nfet_01v8_W1p4_L0p6_m23__nf1_gtop_sdfull_ng B G D S
Xnfet_01v8_W1p4_L0p6_m23__nf1_gtop_sdfull_ng_pc G D S B sky130_fd_pr__nfet_01v8_RUA5M6
.ends

.subckt nmos_dummy__f1 VSS VSS_body
Xnfet_01v8_W1p4_L0p6_m23__nf1_gtop_sdfull_ng_1 VSS_body VSS VSS VSS nfet_01v8_W1p4_L0p6_m23__nf1_gtop_sdfull_ng
Xnfet_01v8_W1p4_L0p6_m23__nf1_gtop_sdfull_ng_0 VSS_body VSS VSS VSS nfet_01v8_W1p4_L0p6_m23__nf1_gtop_sdfull_ng
Xnfet_01v8_W1p4_L0p6_m23__nf1_gtop_sdfull_ng_2 VSS_body VSS VSS VSS nfet_01v8_W1p4_L0p6_m23__nf1_gtop_sdfull_ng
Xnfet_01v8_W1p4_L0p6_m23__nf1_gtop_sdfull_ng_3 VSS_body VSS VSS VSS nfet_01v8_W1p4_L0p6_m23__nf1_gtop_sdfull_ng
Xnfet_01v8_W1p4_L0p6_m23__nf1_gtop_sdfull_ng_4 VSS_body VSS VSS VSS nfet_01v8_W1p4_L0p6_m23__nf1_gtop_sdfull_ng
Xnfet_01v8_W1p4_L0p6_m23__nf1_gtop_sdfull_ng_5 VSS_body VSS VSS VSS nfet_01v8_W1p4_L0p6_m23__nf1_gtop_sdfull_ng
Xnfet_01v8_W1p4_L0p6_m23__nf1_gtop_sdfull_ng_6 VSS_body VSS VSS VSS nfet_01v8_W1p4_L0p6_m23__nf1_gtop_sdfull_ng
Xnfet_01v8_W1p4_L0p6_m23__nf1_gtop_sdfull_ng_7 VSS_body VSS VSS VSS nfet_01v8_W1p4_L0p6_m23__nf1_gtop_sdfull_ng
Xnfet_01v8_W1p4_L0p6_m23__nf1_gtop_sdfull_ng_8 VSS_body VSS VSS VSS nfet_01v8_W1p4_L0p6_m23__nf1_gtop_sdfull_ng
Xnfet_01v8_W1p4_L0p6_m23__nf1_gtop_sdfull_ng_9 VSS_body VSS VSS VSS nfet_01v8_W1p4_L0p6_m23__nf1_gtop_sdfull_ng
Xnfet_01v8_W1p4_L0p6_m23__nf1_gtop_sdfull_ng_20 VSS_body VSS VSS VSS nfet_01v8_W1p4_L0p6_m23__nf1_gtop_sdfull_ng
Xnfet_01v8_W1p4_L0p6_m23__nf1_gtop_sdfull_ng_21 VSS_body VSS VSS VSS nfet_01v8_W1p4_L0p6_m23__nf1_gtop_sdfull_ng
Xnfet_01v8_W1p4_L0p6_m23__nf1_gtop_sdfull_ng_10 VSS_body VSS VSS VSS nfet_01v8_W1p4_L0p6_m23__nf1_gtop_sdfull_ng
Xnfet_01v8_W1p4_L0p6_m23__nf1_gtop_sdfull_ng_22 VSS_body VSS VSS VSS nfet_01v8_W1p4_L0p6_m23__nf1_gtop_sdfull_ng
Xnfet_01v8_W1p4_L0p6_m23__nf1_gtop_sdfull_ng_11 VSS_body VSS VSS VSS nfet_01v8_W1p4_L0p6_m23__nf1_gtop_sdfull_ng
Xnfet_01v8_W1p4_L0p6_m23__nf1_gtop_sdfull_ng_23 VSS_body VSS VSS VSS nfet_01v8_W1p4_L0p6_m23__nf1_gtop_sdfull_ng
Xnfet_01v8_W1p4_L0p6_m23__nf1_gtop_sdfull_ng_12 VSS_body VSS VSS VSS nfet_01v8_W1p4_L0p6_m23__nf1_gtop_sdfull_ng
Xnfet_01v8_W1p4_L0p6_m23__nf1_gtop_sdfull_ng_24 VSS_body VSS VSS VSS nfet_01v8_W1p4_L0p6_m23__nf1_gtop_sdfull_ng
Xnfet_01v8_W1p4_L0p6_m23__nf1_gtop_sdfull_ng_14 VSS_body VSS VSS VSS nfet_01v8_W1p4_L0p6_m23__nf1_gtop_sdfull_ng
Xnfet_01v8_W1p4_L0p6_m23__nf1_gtop_sdfull_ng_13 VSS_body VSS VSS VSS nfet_01v8_W1p4_L0p6_m23__nf1_gtop_sdfull_ng
Xnfet_01v8_W1p4_L0p6_m23__nf1_gtop_sdfull_ng_15 VSS_body VSS VSS VSS nfet_01v8_W1p4_L0p6_m23__nf1_gtop_sdfull_ng
Xnfet_01v8_W1p4_L0p6_m23__nf1_gtop_sdfull_ng_16 VSS_body VSS VSS VSS nfet_01v8_W1p4_L0p6_m23__nf1_gtop_sdfull_ng
Xnfet_01v8_W1p4_L0p6_m23__nf1_gtop_sdfull_ng_17 VSS_body VSS VSS VSS nfet_01v8_W1p4_L0p6_m23__nf1_gtop_sdfull_ng
Xnfet_01v8_W1p4_L0p6_m23__nf1_gtop_sdfull_ng_18 VSS_body VSS VSS VSS nfet_01v8_W1p4_L0p6_m23__nf1_gtop_sdfull_ng
Xnfet_01v8_W1p4_L0p6_m23__nf1_gtop_sdfull_ng_19 VSS_body VSS VSS VSS nfet_01v8_W1p4_L0p6_m23__nf1_gtop_sdfull_ng
.ends
