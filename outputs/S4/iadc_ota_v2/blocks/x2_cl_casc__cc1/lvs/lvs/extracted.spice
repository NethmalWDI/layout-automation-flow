* NGSPICE file created from x2_cl_casc__cc1.ext - technology: sky130A

.subckt sky130_fd_pr__pfet_01v8_RGDEC8 G D w_n154_n240# S
X0 S G D w_n154_n240# sky130_fd_pr__pfet_01v8 ad=0.406 pd=3.38 as=0.406 ps=3.38 w=1.4 l=0.6
.ends

.subckt pfet_01v8_W1p4_L0p6_m20__nf1_gboth_sdfull_ng S B G D
Xpfet_01v8_W1p4_L0p6_m20__nf1_gboth_sdfull_ng_pc G D B S sky130_fd_pr__pfet_01v8_RGDEC8
.ends

.subckt sky130_fd_pr__pfet_01v8_FGX5XW G D w_n154_n238# S
X0 S G D w_n154_n238# sky130_fd_pr__pfet_01v8 ad=0.406 pd=3.38 as=0.406 ps=3.38 w=1.4 l=0.6
.ends

.subckt pfet_01v8_W1p4_L0p6_m4__nf1_gtop_sdhalf_ng G D B S
Xpfet_01v8_W1p4_L0p6_m4__nf1_gtop_sdhalf_ng_pc G D B S sky130_fd_pr__pfet_01v8_FGX5XW
.ends

.subckt x2_cl_casc__cc1 VDD bias_c op on x2_foldp x2_foldn VDD_body
Xpfet_01v8_W1p4_L0p6_m20__nf1_gboth_sdfull_ng_30 x2_foldn VDD_body bias_c op pfet_01v8_W1p4_L0p6_m20__nf1_gboth_sdfull_ng
Xpfet_01v8_W1p4_L0p6_m20__nf1_gboth_sdfull_ng_31 x2_foldp VDD_body bias_c on pfet_01v8_W1p4_L0p6_m20__nf1_gboth_sdfull_ng
Xpfet_01v8_W1p4_L0p6_m20__nf1_gboth_sdfull_ng_20 x2_foldn VDD_body bias_c op pfet_01v8_W1p4_L0p6_m20__nf1_gboth_sdfull_ng
Xpfet_01v8_W1p4_L0p6_m20__nf1_gboth_sdfull_ng_32 x2_foldn VDD_body bias_c op pfet_01v8_W1p4_L0p6_m20__nf1_gboth_sdfull_ng
Xpfet_01v8_W1p4_L0p6_m20__nf1_gboth_sdfull_ng_21 x2_foldp VDD_body bias_c on pfet_01v8_W1p4_L0p6_m20__nf1_gboth_sdfull_ng
Xpfet_01v8_W1p4_L0p6_m20__nf1_gboth_sdfull_ng_10 x2_foldp VDD_body bias_c on pfet_01v8_W1p4_L0p6_m20__nf1_gboth_sdfull_ng
Xpfet_01v8_W1p4_L0p6_m20__nf1_gboth_sdfull_ng_33 x2_foldp VDD_body bias_c on pfet_01v8_W1p4_L0p6_m20__nf1_gboth_sdfull_ng
Xpfet_01v8_W1p4_L0p6_m20__nf1_gboth_sdfull_ng_22 x2_foldn VDD_body bias_c op pfet_01v8_W1p4_L0p6_m20__nf1_gboth_sdfull_ng
Xpfet_01v8_W1p4_L0p6_m20__nf1_gboth_sdfull_ng_11 x2_foldn VDD_body bias_c op pfet_01v8_W1p4_L0p6_m20__nf1_gboth_sdfull_ng
Xpfet_01v8_W1p4_L0p6_m20__nf1_gboth_sdfull_ng_34 x2_foldn VDD_body bias_c op pfet_01v8_W1p4_L0p6_m20__nf1_gboth_sdfull_ng
Xpfet_01v8_W1p4_L0p6_m20__nf1_gboth_sdfull_ng_23 x2_foldp VDD_body bias_c on pfet_01v8_W1p4_L0p6_m20__nf1_gboth_sdfull_ng
Xpfet_01v8_W1p4_L0p6_m20__nf1_gboth_sdfull_ng_12 x2_foldp VDD_body bias_c on pfet_01v8_W1p4_L0p6_m20__nf1_gboth_sdfull_ng
Xpfet_01v8_W1p4_L0p6_m20__nf1_gboth_sdfull_ng_35 x2_foldp VDD_body bias_c on pfet_01v8_W1p4_L0p6_m20__nf1_gboth_sdfull_ng
Xpfet_01v8_W1p4_L0p6_m20__nf1_gboth_sdfull_ng_24 x2_foldn VDD_body bias_c op pfet_01v8_W1p4_L0p6_m20__nf1_gboth_sdfull_ng
Xpfet_01v8_W1p4_L0p6_m20__nf1_gboth_sdfull_ng_13 x2_foldn VDD_body bias_c op pfet_01v8_W1p4_L0p6_m20__nf1_gboth_sdfull_ng
Xpfet_01v8_W1p4_L0p6_m20__nf1_gboth_sdfull_ng_36 x2_foldn VDD_body bias_c op pfet_01v8_W1p4_L0p6_m20__nf1_gboth_sdfull_ng
Xpfet_01v8_W1p4_L0p6_m20__nf1_gboth_sdfull_ng_25 x2_foldp VDD_body bias_c on pfet_01v8_W1p4_L0p6_m20__nf1_gboth_sdfull_ng
Xpfet_01v8_W1p4_L0p6_m20__nf1_gboth_sdfull_ng_14 x2_foldp VDD_body bias_c on pfet_01v8_W1p4_L0p6_m20__nf1_gboth_sdfull_ng
Xpfet_01v8_W1p4_L0p6_m20__nf1_gboth_sdfull_ng_38 x2_foldn VDD_body bias_c op pfet_01v8_W1p4_L0p6_m20__nf1_gboth_sdfull_ng
Xpfet_01v8_W1p4_L0p6_m20__nf1_gboth_sdfull_ng_37 x2_foldp VDD_body bias_c on pfet_01v8_W1p4_L0p6_m20__nf1_gboth_sdfull_ng
Xpfet_01v8_W1p4_L0p6_m20__nf1_gboth_sdfull_ng_27 x2_foldp VDD_body bias_c on pfet_01v8_W1p4_L0p6_m20__nf1_gboth_sdfull_ng
Xpfet_01v8_W1p4_L0p6_m20__nf1_gboth_sdfull_ng_26 x2_foldn VDD_body bias_c op pfet_01v8_W1p4_L0p6_m20__nf1_gboth_sdfull_ng
Xpfet_01v8_W1p4_L0p6_m20__nf1_gboth_sdfull_ng_16 x2_foldp VDD_body bias_c on pfet_01v8_W1p4_L0p6_m20__nf1_gboth_sdfull_ng
Xpfet_01v8_W1p4_L0p6_m20__nf1_gboth_sdfull_ng_15 x2_foldn VDD_body bias_c op pfet_01v8_W1p4_L0p6_m20__nf1_gboth_sdfull_ng
Xpfet_01v8_W1p4_L0p6_m20__nf1_gboth_sdfull_ng_39 x2_foldp VDD_body bias_c on pfet_01v8_W1p4_L0p6_m20__nf1_gboth_sdfull_ng
Xpfet_01v8_W1p4_L0p6_m20__nf1_gboth_sdfull_ng_28 x2_foldn VDD_body bias_c op pfet_01v8_W1p4_L0p6_m20__nf1_gboth_sdfull_ng
Xpfet_01v8_W1p4_L0p6_m20__nf1_gboth_sdfull_ng_17 x2_foldn VDD_body bias_c op pfet_01v8_W1p4_L0p6_m20__nf1_gboth_sdfull_ng
Xpfet_01v8_W1p4_L0p6_m20__nf1_gboth_sdfull_ng_29 x2_foldp VDD_body bias_c on pfet_01v8_W1p4_L0p6_m20__nf1_gboth_sdfull_ng
Xpfet_01v8_W1p4_L0p6_m20__nf1_gboth_sdfull_ng_18 x2_foldp VDD_body bias_c on pfet_01v8_W1p4_L0p6_m20__nf1_gboth_sdfull_ng
Xpfet_01v8_W1p4_L0p6_m20__nf1_gboth_sdfull_ng_19 x2_foldn VDD_body bias_c op pfet_01v8_W1p4_L0p6_m20__nf1_gboth_sdfull_ng
Xpfet_01v8_W1p4_L0p6_m20__nf1_gboth_sdfull_ng_0 x2_foldp VDD_body bias_c on pfet_01v8_W1p4_L0p6_m20__nf1_gboth_sdfull_ng
Xpfet_01v8_W1p4_L0p6_m20__nf1_gboth_sdfull_ng_1 x2_foldn VDD_body bias_c op pfet_01v8_W1p4_L0p6_m20__nf1_gboth_sdfull_ng
Xpfet_01v8_W1p4_L0p6_m20__nf1_gboth_sdfull_ng_2 x2_foldp VDD_body bias_c on pfet_01v8_W1p4_L0p6_m20__nf1_gboth_sdfull_ng
Xpfet_01v8_W1p4_L0p6_m20__nf1_gboth_sdfull_ng_4 x2_foldp VDD_body bias_c on pfet_01v8_W1p4_L0p6_m20__nf1_gboth_sdfull_ng
Xpfet_01v8_W1p4_L0p6_m20__nf1_gboth_sdfull_ng_3 x2_foldn VDD_body bias_c op pfet_01v8_W1p4_L0p6_m20__nf1_gboth_sdfull_ng
Xpfet_01v8_W1p4_L0p6_m20__nf1_gboth_sdfull_ng_5 x2_foldn VDD_body bias_c op pfet_01v8_W1p4_L0p6_m20__nf1_gboth_sdfull_ng
Xpfet_01v8_W1p4_L0p6_m4__nf1_gtop_sdhalf_ng_0 VDD op VDD_body VDD pfet_01v8_W1p4_L0p6_m4__nf1_gtop_sdhalf_ng
Xpfet_01v8_W1p4_L0p6_m20__nf1_gboth_sdfull_ng_6 x2_foldp VDD_body bias_c on pfet_01v8_W1p4_L0p6_m20__nf1_gboth_sdfull_ng
Xpfet_01v8_W1p4_L0p6_m4__nf1_gtop_sdhalf_ng_1 VDD op VDD_body VDD pfet_01v8_W1p4_L0p6_m4__nf1_gtop_sdhalf_ng
Xpfet_01v8_W1p4_L0p6_m20__nf1_gboth_sdfull_ng_7 x2_foldn VDD_body bias_c op pfet_01v8_W1p4_L0p6_m20__nf1_gboth_sdfull_ng
Xpfet_01v8_W1p4_L0p6_m4__nf1_gtop_sdhalf_ng_2 VDD on VDD_body VDD pfet_01v8_W1p4_L0p6_m4__nf1_gtop_sdhalf_ng
Xpfet_01v8_W1p4_L0p6_m20__nf1_gboth_sdfull_ng_8 x2_foldp VDD_body bias_c on pfet_01v8_W1p4_L0p6_m20__nf1_gboth_sdfull_ng
Xpfet_01v8_W1p4_L0p6_m4__nf1_gtop_sdhalf_ng_3 VDD on VDD_body VDD pfet_01v8_W1p4_L0p6_m4__nf1_gtop_sdhalf_ng
Xpfet_01v8_W1p4_L0p6_m4__nf1_gtop_sdhalf_ng_4 VDD op VDD_body VDD pfet_01v8_W1p4_L0p6_m4__nf1_gtop_sdhalf_ng
Xpfet_01v8_W1p4_L0p6_m20__nf1_gboth_sdfull_ng_9 x2_foldn VDD_body bias_c op pfet_01v8_W1p4_L0p6_m20__nf1_gboth_sdfull_ng
Xpfet_01v8_W1p4_L0p6_m4__nf1_gtop_sdhalf_ng_5 VDD op VDD_body VDD pfet_01v8_W1p4_L0p6_m4__nf1_gtop_sdhalf_ng
Xpfet_01v8_W1p4_L0p6_m4__nf1_gtop_sdhalf_ng_7 VDD on VDD_body VDD pfet_01v8_W1p4_L0p6_m4__nf1_gtop_sdhalf_ng
Xpfet_01v8_W1p4_L0p6_m4__nf1_gtop_sdhalf_ng_6 VDD on VDD_body VDD pfet_01v8_W1p4_L0p6_m4__nf1_gtop_sdhalf_ng
.ends
