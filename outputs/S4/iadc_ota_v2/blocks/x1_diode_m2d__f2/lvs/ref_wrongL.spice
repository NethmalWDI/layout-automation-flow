.subckt x1_diode_m2d__f2 VSS bias_d x1_m2d VSS_body
XXX1_M2 x1_m2d x1_m2d bias_d VSS_body sky130_fd_pr__nfet_01v8 L=0.7 W=1.4 nf=1 m=50
XXX1_M35 x1_m2d x1_m2d x1_m2d VSS_body sky130_fd_pr__nfet_01v8 L=0.6 W=1.4 nf=1 m=2
Xx1_diode_m2d_DUMMY0 VSS VSS VSS VSS_body sky130_fd_pr__nfet_01v8 L=0.6 W=1.4 nf=1
Xx1_diode_m2d_DUMMY1 VSS VSS VSS VSS_body sky130_fd_pr__nfet_01v8 L=0.6 W=1.4 nf=1
.ends
