.subckt x2_cm_tail__cc6 VSS bias_a cmc x2_m3d x2_m4d x2_tail VSS_body
XXX2_M6 x2_tail cmc VSS VSS_body sky130_fd_pr__nfet_01v8 L=0.6 W=1.4 nf=1 m=96
XXX2_M5 x2_tail bias_a VSS VSS_body sky130_fd_pr__nfet_01v8 L=0.6 W=1.4 nf=1 m=96
XXX2_M3 x2_m3d bias_a VSS VSS_body sky130_fd_pr__nfet_01v8 L=0.6 W=1.4 nf=1 m=36
XXX2_M4 x2_m4d bias_a VSS VSS_body sky130_fd_pr__nfet_01v8 L=0.6 W=1.4 nf=1 m=36
XXX2_M28 x2_tail x2_tail x2_tail VSS_body sky130_fd_pr__nfet_01v8 L=0.6 W=1.4 nf=1 m=6
XXX2_M30 x2_tail VSS VSS VSS_body sky130_fd_pr__nfet_01v8 L=0.6 W=1.4 nf=1 m=2
XXX2_M40 x2_m4d VSS VSS VSS_body sky130_fd_pr__nfet_01v8 L=0.6 W=1.4 nf=1 m=6
XXX2_M41 x2_m3d VSS VSS VSS_body sky130_fd_pr__nfet_01v8 L=0.6 W=1.4 nf=1 m=8
Xx2_cm_tail_DUMMY0 VSS VSS VSS VSS_body sky130_fd_pr__nfet_01v8 L=0.6 W=1.4 nf=1
Xx2_cm_tail_DUMMY1 VSS VSS VSS VSS_body sky130_fd_pr__nfet_01v8 L=0.6 W=1.4 nf=1
.ends
