.subckt x1_cm_iref__cc3 VSS bias_c i_bias VSS_body
XXX1_M7 i_bias i_bias VSS VSS_body sky130_fd_pr__nfet_01v8 L=0.6 W=1.4 nf=1 m=18
XXX1_M6 bias_c i_bias VSS VSS_body sky130_fd_pr__nfet_01v8 L=0.6 W=1.4 nf=1 m=18
XXX1_M10 bias_c bias_c bias_c VSS_body sky130_fd_pr__nfet_01v8_lvt L=0.6 W=1.4 nf=1 m=8
XXX1_M44 bias_c bias_c bias_c VSS_body sky130_fd_pr__nfet_01v8 L=0.6 W=1.4 nf=1 m=2
XXX1_M8 i_bias i_bias i_bias VSS_body sky130_fd_pr__nfet_01v8 L=0.6 W=1.4 nf=1 m=2
.ends
