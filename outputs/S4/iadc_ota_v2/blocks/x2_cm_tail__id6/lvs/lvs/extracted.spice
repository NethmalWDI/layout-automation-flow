* NGSPICE file created from x2_cm_tail__id6.ext - technology: sky130A

.subckt sky130_fd_pr__nfet_01v8_KCM6UP G D S VSUBS
X0 S G D VSUBS sky130_fd_pr__nfet_01v8 ad=0.406 pd=3.38 as=0.406 ps=3.38 w=1.4 l=0.6
.ends

.subckt nfet_01v8_W1p4_L0p6_m96__nf1_gboth_sdfull_ng D B S G
Xnfet_01v8_W1p4_L0p6_m96__nf1_gboth_sdfull_ng_pc G D S B sky130_fd_pr__nfet_01v8_KCM6UP
.ends

.subckt nfet_01v8_W1p4_L0p6_m36__nf1_gboth_sdfull_ng B S G D
Xnfet_01v8_W1p4_L0p6_m36__nf1_gboth_sdfull_ng_pc G D S B sky130_fd_pr__nfet_01v8_KCM6UP
.ends

.subckt sky130_fd_pr__nfet_01v8_RUA5M6 G D S VSUBS
X0 S G D VSUBS sky130_fd_pr__nfet_01v8 ad=0.406 pd=3.38 as=0.406 ps=3.38 w=1.4 l=0.6
.ends

.subckt nfet_01v8_W1p4_L0p6_m6__nf1_gtop_sdfull_ng B G D S
Xnfet_01v8_W1p4_L0p6_m6__nf1_gtop_sdfull_ng_pc G D S B sky130_fd_pr__nfet_01v8_RUA5M6
.ends

.subckt nfet_01v8_W1p4_L0p6_m2__nf1_gboth_sdfull_ng B S G D
Xnfet_01v8_W1p4_L0p6_m2__nf1_gboth_sdfull_ng_pc G D S B sky130_fd_pr__nfet_01v8_KCM6UP
.ends

.subckt nfet_01v8_W1p4_L0p6_m8__nf1_gtop_sdfull_ng B S G D
Xnfet_01v8_W1p4_L0p6_m8__nf1_gtop_sdfull_ng_pc G D S B sky130_fd_pr__nfet_01v8_RUA5M6
.ends

.subckt x2_cm_tail__id6 VSS bias_a cmc x2_tail x2_m4d x2_m3d VSS_body
Xnfet_01v8_W1p4_L0p6_m96__nf1_gboth_sdfull_ng_0 x2_tail VSS_body VSS cmc nfet_01v8_W1p4_L0p6_m96__nf1_gboth_sdfull_ng
Xnfet_01v8_W1p4_L0p6_m36__nf1_gboth_sdfull_ng_66 VSS_body VSS bias_a x2_m4d nfet_01v8_W1p4_L0p6_m36__nf1_gboth_sdfull_ng
Xnfet_01v8_W1p4_L0p6_m36__nf1_gboth_sdfull_ng_55 VSS_body VSS bias_a x2_m4d nfet_01v8_W1p4_L0p6_m36__nf1_gboth_sdfull_ng
Xnfet_01v8_W1p4_L0p6_m36__nf1_gboth_sdfull_ng_44 VSS_body VSS bias_a x2_m4d nfet_01v8_W1p4_L0p6_m36__nf1_gboth_sdfull_ng
Xnfet_01v8_W1p4_L0p6_m96__nf1_gboth_sdfull_ng_91 x2_tail VSS_body VSS bias_a nfet_01v8_W1p4_L0p6_m96__nf1_gboth_sdfull_ng
Xnfet_01v8_W1p4_L0p6_m96__nf1_gboth_sdfull_ng_80 x2_tail VSS_body VSS cmc nfet_01v8_W1p4_L0p6_m96__nf1_gboth_sdfull_ng
Xnfet_01v8_W1p4_L0p6_m36__nf1_gboth_sdfull_ng_33 VSS_body VSS bias_a x2_m4d nfet_01v8_W1p4_L0p6_m36__nf1_gboth_sdfull_ng
Xnfet_01v8_W1p4_L0p6_m36__nf1_gboth_sdfull_ng_11 VSS_body VSS bias_a x2_m4d nfet_01v8_W1p4_L0p6_m36__nf1_gboth_sdfull_ng
Xnfet_01v8_W1p4_L0p6_m36__nf1_gboth_sdfull_ng_22 VSS_body VSS bias_a x2_m4d nfet_01v8_W1p4_L0p6_m36__nf1_gboth_sdfull_ng
Xnfet_01v8_W1p4_L0p6_m96__nf1_gboth_sdfull_ng_179 x2_tail VSS_body VSS cmc nfet_01v8_W1p4_L0p6_m96__nf1_gboth_sdfull_ng
Xnfet_01v8_W1p4_L0p6_m96__nf1_gboth_sdfull_ng_168 x2_tail VSS_body VSS bias_a nfet_01v8_W1p4_L0p6_m96__nf1_gboth_sdfull_ng
Xnfet_01v8_W1p4_L0p6_m96__nf1_gboth_sdfull_ng_157 x2_tail VSS_body VSS bias_a nfet_01v8_W1p4_L0p6_m96__nf1_gboth_sdfull_ng
Xnfet_01v8_W1p4_L0p6_m96__nf1_gboth_sdfull_ng_146 x2_tail VSS_body VSS cmc nfet_01v8_W1p4_L0p6_m96__nf1_gboth_sdfull_ng
Xnfet_01v8_W1p4_L0p6_m96__nf1_gboth_sdfull_ng_135 x2_tail VSS_body VSS bias_a nfet_01v8_W1p4_L0p6_m96__nf1_gboth_sdfull_ng
Xnfet_01v8_W1p4_L0p6_m96__nf1_gboth_sdfull_ng_124 x2_tail VSS_body VSS bias_a nfet_01v8_W1p4_L0p6_m96__nf1_gboth_sdfull_ng
Xnfet_01v8_W1p4_L0p6_m96__nf1_gboth_sdfull_ng_113 x2_tail VSS_body VSS cmc nfet_01v8_W1p4_L0p6_m96__nf1_gboth_sdfull_ng
Xnfet_01v8_W1p4_L0p6_m96__nf1_gboth_sdfull_ng_102 x2_tail VSS_body VSS bias_a nfet_01v8_W1p4_L0p6_m96__nf1_gboth_sdfull_ng
Xnfet_01v8_W1p4_L0p6_m96__nf1_gboth_sdfull_ng_1 x2_tail VSS_body VSS bias_a nfet_01v8_W1p4_L0p6_m96__nf1_gboth_sdfull_ng
Xnfet_01v8_W1p4_L0p6_m96__nf1_gboth_sdfull_ng_92 x2_tail VSS_body VSS cmc nfet_01v8_W1p4_L0p6_m96__nf1_gboth_sdfull_ng
Xnfet_01v8_W1p4_L0p6_m96__nf1_gboth_sdfull_ng_81 x2_tail VSS_body VSS bias_a nfet_01v8_W1p4_L0p6_m96__nf1_gboth_sdfull_ng
Xnfet_01v8_W1p4_L0p6_m96__nf1_gboth_sdfull_ng_70 x2_tail VSS_body VSS cmc nfet_01v8_W1p4_L0p6_m96__nf1_gboth_sdfull_ng
Xnfet_01v8_W1p4_L0p6_m36__nf1_gboth_sdfull_ng_67 VSS_body VSS bias_a x2_m3d nfet_01v8_W1p4_L0p6_m36__nf1_gboth_sdfull_ng
Xnfet_01v8_W1p4_L0p6_m36__nf1_gboth_sdfull_ng_56 VSS_body VSS bias_a x2_m3d nfet_01v8_W1p4_L0p6_m36__nf1_gboth_sdfull_ng
Xnfet_01v8_W1p4_L0p6_m36__nf1_gboth_sdfull_ng_45 VSS_body VSS bias_a x2_m3d nfet_01v8_W1p4_L0p6_m36__nf1_gboth_sdfull_ng
Xnfet_01v8_W1p4_L0p6_m36__nf1_gboth_sdfull_ng_34 VSS_body VSS bias_a x2_m3d nfet_01v8_W1p4_L0p6_m36__nf1_gboth_sdfull_ng
Xnfet_01v8_W1p4_L0p6_m36__nf1_gboth_sdfull_ng_12 VSS_body VSS bias_a x2_m4d nfet_01v8_W1p4_L0p6_m36__nf1_gboth_sdfull_ng
Xnfet_01v8_W1p4_L0p6_m36__nf1_gboth_sdfull_ng_23 VSS_body VSS bias_a x2_m3d nfet_01v8_W1p4_L0p6_m36__nf1_gboth_sdfull_ng
Xnfet_01v8_W1p4_L0p6_m96__nf1_gboth_sdfull_ng_169 x2_tail VSS_body VSS cmc nfet_01v8_W1p4_L0p6_m96__nf1_gboth_sdfull_ng
Xnfet_01v8_W1p4_L0p6_m96__nf1_gboth_sdfull_ng_158 x2_tail VSS_body VSS cmc nfet_01v8_W1p4_L0p6_m96__nf1_gboth_sdfull_ng
Xnfet_01v8_W1p4_L0p6_m96__nf1_gboth_sdfull_ng_147 x2_tail VSS_body VSS bias_a nfet_01v8_W1p4_L0p6_m96__nf1_gboth_sdfull_ng
Xnfet_01v8_W1p4_L0p6_m96__nf1_gboth_sdfull_ng_136 x2_tail VSS_body VSS cmc nfet_01v8_W1p4_L0p6_m96__nf1_gboth_sdfull_ng
Xnfet_01v8_W1p4_L0p6_m96__nf1_gboth_sdfull_ng_125 x2_tail VSS_body VSS cmc nfet_01v8_W1p4_L0p6_m96__nf1_gboth_sdfull_ng
Xnfet_01v8_W1p4_L0p6_m96__nf1_gboth_sdfull_ng_114 x2_tail VSS_body VSS bias_a nfet_01v8_W1p4_L0p6_m96__nf1_gboth_sdfull_ng
Xnfet_01v8_W1p4_L0p6_m96__nf1_gboth_sdfull_ng_103 x2_tail VSS_body VSS cmc nfet_01v8_W1p4_L0p6_m96__nf1_gboth_sdfull_ng
Xnfet_01v8_W1p4_L0p6_m96__nf1_gboth_sdfull_ng_2 x2_tail VSS_body VSS cmc nfet_01v8_W1p4_L0p6_m96__nf1_gboth_sdfull_ng
Xnfet_01v8_W1p4_L0p6_m36__nf1_gboth_sdfull_ng_68 VSS_body VSS bias_a x2_m4d nfet_01v8_W1p4_L0p6_m36__nf1_gboth_sdfull_ng
Xnfet_01v8_W1p4_L0p6_m36__nf1_gboth_sdfull_ng_57 VSS_body VSS bias_a x2_m4d nfet_01v8_W1p4_L0p6_m36__nf1_gboth_sdfull_ng
Xnfet_01v8_W1p4_L0p6_m36__nf1_gboth_sdfull_ng_46 VSS_body VSS bias_a x2_m4d nfet_01v8_W1p4_L0p6_m36__nf1_gboth_sdfull_ng
Xnfet_01v8_W1p4_L0p6_m96__nf1_gboth_sdfull_ng_93 x2_tail VSS_body VSS bias_a nfet_01v8_W1p4_L0p6_m96__nf1_gboth_sdfull_ng
Xnfet_01v8_W1p4_L0p6_m96__nf1_gboth_sdfull_ng_82 x2_tail VSS_body VSS cmc nfet_01v8_W1p4_L0p6_m96__nf1_gboth_sdfull_ng
Xnfet_01v8_W1p4_L0p6_m36__nf1_gboth_sdfull_ng_35 VSS_body VSS bias_a x2_m4d nfet_01v8_W1p4_L0p6_m36__nf1_gboth_sdfull_ng
Xnfet_01v8_W1p4_L0p6_m96__nf1_gboth_sdfull_ng_71 x2_tail VSS_body VSS bias_a nfet_01v8_W1p4_L0p6_m96__nf1_gboth_sdfull_ng
Xnfet_01v8_W1p4_L0p6_m36__nf1_gboth_sdfull_ng_24 VSS_body VSS bias_a x2_m3d nfet_01v8_W1p4_L0p6_m36__nf1_gboth_sdfull_ng
Xnfet_01v8_W1p4_L0p6_m36__nf1_gboth_sdfull_ng_13 VSS_body VSS bias_a x2_m3d nfet_01v8_W1p4_L0p6_m36__nf1_gboth_sdfull_ng
Xnfet_01v8_W1p4_L0p6_m96__nf1_gboth_sdfull_ng_60 x2_tail VSS_body VSS bias_a nfet_01v8_W1p4_L0p6_m96__nf1_gboth_sdfull_ng
Xnfet_01v8_W1p4_L0p6_m96__nf1_gboth_sdfull_ng_159 x2_tail VSS_body VSS bias_a nfet_01v8_W1p4_L0p6_m96__nf1_gboth_sdfull_ng
Xnfet_01v8_W1p4_L0p6_m96__nf1_gboth_sdfull_ng_148 x2_tail VSS_body VSS cmc nfet_01v8_W1p4_L0p6_m96__nf1_gboth_sdfull_ng
Xnfet_01v8_W1p4_L0p6_m96__nf1_gboth_sdfull_ng_137 x2_tail VSS_body VSS bias_a nfet_01v8_W1p4_L0p6_m96__nf1_gboth_sdfull_ng
Xnfet_01v8_W1p4_L0p6_m96__nf1_gboth_sdfull_ng_126 x2_tail VSS_body VSS bias_a nfet_01v8_W1p4_L0p6_m96__nf1_gboth_sdfull_ng
Xnfet_01v8_W1p4_L0p6_m96__nf1_gboth_sdfull_ng_115 x2_tail VSS_body VSS cmc nfet_01v8_W1p4_L0p6_m96__nf1_gboth_sdfull_ng
Xnfet_01v8_W1p4_L0p6_m96__nf1_gboth_sdfull_ng_104 x2_tail VSS_body VSS bias_a nfet_01v8_W1p4_L0p6_m96__nf1_gboth_sdfull_ng
Xnfet_01v8_W1p4_L0p6_m96__nf1_gboth_sdfull_ng_3 x2_tail VSS_body VSS bias_a nfet_01v8_W1p4_L0p6_m96__nf1_gboth_sdfull_ng
Xnfet_01v8_W1p4_L0p6_m96__nf1_gboth_sdfull_ng_94 x2_tail VSS_body VSS cmc nfet_01v8_W1p4_L0p6_m96__nf1_gboth_sdfull_ng
Xnfet_01v8_W1p4_L0p6_m96__nf1_gboth_sdfull_ng_83 x2_tail VSS_body VSS bias_a nfet_01v8_W1p4_L0p6_m96__nf1_gboth_sdfull_ng
Xnfet_01v8_W1p4_L0p6_m96__nf1_gboth_sdfull_ng_72 x2_tail VSS_body VSS cmc nfet_01v8_W1p4_L0p6_m96__nf1_gboth_sdfull_ng
Xnfet_01v8_W1p4_L0p6_m96__nf1_gboth_sdfull_ng_50 x2_tail VSS_body VSS bias_a nfet_01v8_W1p4_L0p6_m96__nf1_gboth_sdfull_ng
Xnfet_01v8_W1p4_L0p6_m96__nf1_gboth_sdfull_ng_61 x2_tail VSS_body VSS cmc nfet_01v8_W1p4_L0p6_m96__nf1_gboth_sdfull_ng
Xnfet_01v8_W1p4_L0p6_m36__nf1_gboth_sdfull_ng_69 VSS_body VSS bias_a x2_m3d nfet_01v8_W1p4_L0p6_m36__nf1_gboth_sdfull_ng
Xnfet_01v8_W1p4_L0p6_m36__nf1_gboth_sdfull_ng_58 VSS_body VSS bias_a x2_m3d nfet_01v8_W1p4_L0p6_m36__nf1_gboth_sdfull_ng
Xnfet_01v8_W1p4_L0p6_m36__nf1_gboth_sdfull_ng_47 VSS_body VSS bias_a x2_m3d nfet_01v8_W1p4_L0p6_m36__nf1_gboth_sdfull_ng
Xnfet_01v8_W1p4_L0p6_m36__nf1_gboth_sdfull_ng_36 VSS_body VSS bias_a x2_m4d nfet_01v8_W1p4_L0p6_m36__nf1_gboth_sdfull_ng
Xnfet_01v8_W1p4_L0p6_m36__nf1_gboth_sdfull_ng_25 VSS_body VSS bias_a x2_m4d nfet_01v8_W1p4_L0p6_m36__nf1_gboth_sdfull_ng
Xnfet_01v8_W1p4_L0p6_m36__nf1_gboth_sdfull_ng_14 VSS_body VSS bias_a x2_m4d nfet_01v8_W1p4_L0p6_m36__nf1_gboth_sdfull_ng
Xnfet_01v8_W1p4_L0p6_m96__nf1_gboth_sdfull_ng_149 x2_tail VSS_body VSS bias_a nfet_01v8_W1p4_L0p6_m96__nf1_gboth_sdfull_ng
Xnfet_01v8_W1p4_L0p6_m96__nf1_gboth_sdfull_ng_138 x2_tail VSS_body VSS cmc nfet_01v8_W1p4_L0p6_m96__nf1_gboth_sdfull_ng
Xnfet_01v8_W1p4_L0p6_m96__nf1_gboth_sdfull_ng_127 x2_tail VSS_body VSS cmc nfet_01v8_W1p4_L0p6_m96__nf1_gboth_sdfull_ng
Xnfet_01v8_W1p4_L0p6_m96__nf1_gboth_sdfull_ng_116 x2_tail VSS_body VSS bias_a nfet_01v8_W1p4_L0p6_m96__nf1_gboth_sdfull_ng
Xnfet_01v8_W1p4_L0p6_m96__nf1_gboth_sdfull_ng_105 x2_tail VSS_body VSS cmc nfet_01v8_W1p4_L0p6_m96__nf1_gboth_sdfull_ng
Xnfet_01v8_W1p4_L0p6_m96__nf1_gboth_sdfull_ng_4 x2_tail VSS_body VSS cmc nfet_01v8_W1p4_L0p6_m96__nf1_gboth_sdfull_ng
Xnfet_01v8_W1p4_L0p6_m96__nf1_gboth_sdfull_ng_95 x2_tail VSS_body VSS bias_a nfet_01v8_W1p4_L0p6_m96__nf1_gboth_sdfull_ng
Xnfet_01v8_W1p4_L0p6_m96__nf1_gboth_sdfull_ng_84 x2_tail VSS_body VSS cmc nfet_01v8_W1p4_L0p6_m96__nf1_gboth_sdfull_ng
Xnfet_01v8_W1p4_L0p6_m96__nf1_gboth_sdfull_ng_73 x2_tail VSS_body VSS bias_a nfet_01v8_W1p4_L0p6_m96__nf1_gboth_sdfull_ng
Xnfet_01v8_W1p4_L0p6_m96__nf1_gboth_sdfull_ng_40 x2_tail VSS_body VSS bias_a nfet_01v8_W1p4_L0p6_m96__nf1_gboth_sdfull_ng
Xnfet_01v8_W1p4_L0p6_m96__nf1_gboth_sdfull_ng_51 x2_tail VSS_body VSS cmc nfet_01v8_W1p4_L0p6_m96__nf1_gboth_sdfull_ng
Xnfet_01v8_W1p4_L0p6_m96__nf1_gboth_sdfull_ng_62 x2_tail VSS_body VSS bias_a nfet_01v8_W1p4_L0p6_m96__nf1_gboth_sdfull_ng
Xnfet_01v8_W1p4_L0p6_m36__nf1_gboth_sdfull_ng_59 VSS_body VSS bias_a x2_m4d nfet_01v8_W1p4_L0p6_m36__nf1_gboth_sdfull_ng
Xnfet_01v8_W1p4_L0p6_m36__nf1_gboth_sdfull_ng_48 VSS_body VSS bias_a x2_m3d nfet_01v8_W1p4_L0p6_m36__nf1_gboth_sdfull_ng
Xnfet_01v8_W1p4_L0p6_m36__nf1_gboth_sdfull_ng_37 VSS_body VSS bias_a x2_m3d nfet_01v8_W1p4_L0p6_m36__nf1_gboth_sdfull_ng
Xnfet_01v8_W1p4_L0p6_m36__nf1_gboth_sdfull_ng_26 VSS_body VSS bias_a x2_m3d nfet_01v8_W1p4_L0p6_m36__nf1_gboth_sdfull_ng
Xnfet_01v8_W1p4_L0p6_m36__nf1_gboth_sdfull_ng_15 VSS_body VSS bias_a x2_m3d nfet_01v8_W1p4_L0p6_m36__nf1_gboth_sdfull_ng
Xnfet_01v8_W1p4_L0p6_m96__nf1_gboth_sdfull_ng_139 x2_tail VSS_body VSS bias_a nfet_01v8_W1p4_L0p6_m96__nf1_gboth_sdfull_ng
Xnfet_01v8_W1p4_L0p6_m96__nf1_gboth_sdfull_ng_128 x2_tail VSS_body VSS cmc nfet_01v8_W1p4_L0p6_m96__nf1_gboth_sdfull_ng
Xnfet_01v8_W1p4_L0p6_m96__nf1_gboth_sdfull_ng_117 x2_tail VSS_body VSS cmc nfet_01v8_W1p4_L0p6_m96__nf1_gboth_sdfull_ng
Xnfet_01v8_W1p4_L0p6_m96__nf1_gboth_sdfull_ng_106 x2_tail VSS_body VSS bias_a nfet_01v8_W1p4_L0p6_m96__nf1_gboth_sdfull_ng
Xnfet_01v8_W1p4_L0p6_m96__nf1_gboth_sdfull_ng_5 x2_tail VSS_body VSS bias_a nfet_01v8_W1p4_L0p6_m96__nf1_gboth_sdfull_ng
Xnfet_01v8_W1p4_L0p6_m36__nf1_gboth_sdfull_ng_49 VSS_body VSS bias_a x2_m4d nfet_01v8_W1p4_L0p6_m36__nf1_gboth_sdfull_ng
Xnfet_01v8_W1p4_L0p6_m36__nf1_gboth_sdfull_ng_38 VSS_body VSS bias_a x2_m4d nfet_01v8_W1p4_L0p6_m36__nf1_gboth_sdfull_ng
Xnfet_01v8_W1p4_L0p6_m96__nf1_gboth_sdfull_ng_96 x2_tail VSS_body VSS bias_a nfet_01v8_W1p4_L0p6_m96__nf1_gboth_sdfull_ng
Xnfet_01v8_W1p4_L0p6_m96__nf1_gboth_sdfull_ng_85 x2_tail VSS_body VSS bias_a nfet_01v8_W1p4_L0p6_m96__nf1_gboth_sdfull_ng
Xnfet_01v8_W1p4_L0p6_m96__nf1_gboth_sdfull_ng_74 x2_tail VSS_body VSS cmc nfet_01v8_W1p4_L0p6_m96__nf1_gboth_sdfull_ng
Xnfet_01v8_W1p4_L0p6_m36__nf1_gboth_sdfull_ng_27 VSS_body VSS bias_a x2_m4d nfet_01v8_W1p4_L0p6_m36__nf1_gboth_sdfull_ng
Xnfet_01v8_W1p4_L0p6_m6__nf1_gtop_sdfull_ng_0 VSS_body x2_tail x2_tail x2_tail nfet_01v8_W1p4_L0p6_m6__nf1_gtop_sdfull_ng
Xnfet_01v8_W1p4_L0p6_m96__nf1_gboth_sdfull_ng_30 x2_tail VSS_body VSS cmc nfet_01v8_W1p4_L0p6_m96__nf1_gboth_sdfull_ng
Xnfet_01v8_W1p4_L0p6_m96__nf1_gboth_sdfull_ng_41 x2_tail VSS_body VSS cmc nfet_01v8_W1p4_L0p6_m96__nf1_gboth_sdfull_ng
Xnfet_01v8_W1p4_L0p6_m96__nf1_gboth_sdfull_ng_52 x2_tail VSS_body VSS bias_a nfet_01v8_W1p4_L0p6_m96__nf1_gboth_sdfull_ng
Xnfet_01v8_W1p4_L0p6_m36__nf1_gboth_sdfull_ng_16 VSS_body VSS bias_a x2_m4d nfet_01v8_W1p4_L0p6_m36__nf1_gboth_sdfull_ng
Xnfet_01v8_W1p4_L0p6_m96__nf1_gboth_sdfull_ng_63 x2_tail VSS_body VSS cmc nfet_01v8_W1p4_L0p6_m96__nf1_gboth_sdfull_ng
Xnfet_01v8_W1p4_L0p6_m96__nf1_gboth_sdfull_ng_129 x2_tail VSS_body VSS bias_a nfet_01v8_W1p4_L0p6_m96__nf1_gboth_sdfull_ng
Xnfet_01v8_W1p4_L0p6_m96__nf1_gboth_sdfull_ng_118 x2_tail VSS_body VSS bias_a nfet_01v8_W1p4_L0p6_m96__nf1_gboth_sdfull_ng
Xnfet_01v8_W1p4_L0p6_m96__nf1_gboth_sdfull_ng_107 x2_tail VSS_body VSS cmc nfet_01v8_W1p4_L0p6_m96__nf1_gboth_sdfull_ng
Xnfet_01v8_W1p4_L0p6_m96__nf1_gboth_sdfull_ng_6 x2_tail VSS_body VSS cmc nfet_01v8_W1p4_L0p6_m96__nf1_gboth_sdfull_ng
Xnfet_01v8_W1p4_L0p6_m96__nf1_gboth_sdfull_ng_97 x2_tail VSS_body VSS cmc nfet_01v8_W1p4_L0p6_m96__nf1_gboth_sdfull_ng
Xnfet_01v8_W1p4_L0p6_m96__nf1_gboth_sdfull_ng_86 x2_tail VSS_body VSS cmc nfet_01v8_W1p4_L0p6_m96__nf1_gboth_sdfull_ng
Xnfet_01v8_W1p4_L0p6_m96__nf1_gboth_sdfull_ng_75 x2_tail VSS_body VSS bias_a nfet_01v8_W1p4_L0p6_m96__nf1_gboth_sdfull_ng
Xnfet_01v8_W1p4_L0p6_m96__nf1_gboth_sdfull_ng_64 x2_tail VSS_body VSS cmc nfet_01v8_W1p4_L0p6_m96__nf1_gboth_sdfull_ng
Xnfet_01v8_W1p4_L0p6_m6__nf1_gtop_sdfull_ng_1 VSS_body VSS x2_m4d VSS nfet_01v8_W1p4_L0p6_m6__nf1_gtop_sdfull_ng
Xnfet_01v8_W1p4_L0p6_m96__nf1_gboth_sdfull_ng_20 x2_tail VSS_body VSS cmc nfet_01v8_W1p4_L0p6_m96__nf1_gboth_sdfull_ng
Xnfet_01v8_W1p4_L0p6_m96__nf1_gboth_sdfull_ng_31 x2_tail VSS_body VSS bias_a nfet_01v8_W1p4_L0p6_m96__nf1_gboth_sdfull_ng
Xnfet_01v8_W1p4_L0p6_m96__nf1_gboth_sdfull_ng_42 x2_tail VSS_body VSS bias_a nfet_01v8_W1p4_L0p6_m96__nf1_gboth_sdfull_ng
Xnfet_01v8_W1p4_L0p6_m96__nf1_gboth_sdfull_ng_53 x2_tail VSS_body VSS cmc nfet_01v8_W1p4_L0p6_m96__nf1_gboth_sdfull_ng
Xnfet_01v8_W1p4_L0p6_m36__nf1_gboth_sdfull_ng_39 VSS_body VSS bias_a x2_m3d nfet_01v8_W1p4_L0p6_m36__nf1_gboth_sdfull_ng
Xnfet_01v8_W1p4_L0p6_m36__nf1_gboth_sdfull_ng_28 VSS_body VSS bias_a x2_m3d nfet_01v8_W1p4_L0p6_m36__nf1_gboth_sdfull_ng
Xnfet_01v8_W1p4_L0p6_m36__nf1_gboth_sdfull_ng_17 VSS_body VSS bias_a x2_m3d nfet_01v8_W1p4_L0p6_m36__nf1_gboth_sdfull_ng
Xnfet_01v8_W1p4_L0p6_m96__nf1_gboth_sdfull_ng_119 x2_tail VSS_body VSS cmc nfet_01v8_W1p4_L0p6_m96__nf1_gboth_sdfull_ng
Xnfet_01v8_W1p4_L0p6_m96__nf1_gboth_sdfull_ng_108 x2_tail VSS_body VSS bias_a nfet_01v8_W1p4_L0p6_m96__nf1_gboth_sdfull_ng
Xnfet_01v8_W1p4_L0p6_m96__nf1_gboth_sdfull_ng_7 x2_tail VSS_body VSS bias_a nfet_01v8_W1p4_L0p6_m96__nf1_gboth_sdfull_ng
Xnfet_01v8_W1p4_L0p6_m96__nf1_gboth_sdfull_ng_98 x2_tail VSS_body VSS bias_a nfet_01v8_W1p4_L0p6_m96__nf1_gboth_sdfull_ng
Xnfet_01v8_W1p4_L0p6_m96__nf1_gboth_sdfull_ng_87 x2_tail VSS_body VSS bias_a nfet_01v8_W1p4_L0p6_m96__nf1_gboth_sdfull_ng
Xnfet_01v8_W1p4_L0p6_m96__nf1_gboth_sdfull_ng_76 x2_tail VSS_body VSS cmc nfet_01v8_W1p4_L0p6_m96__nf1_gboth_sdfull_ng
Xnfet_01v8_W1p4_L0p6_m36__nf1_gboth_sdfull_ng_29 VSS_body VSS bias_a x2_m4d nfet_01v8_W1p4_L0p6_m36__nf1_gboth_sdfull_ng
Xnfet_01v8_W1p4_L0p6_m96__nf1_gboth_sdfull_ng_65 x2_tail VSS_body VSS bias_a nfet_01v8_W1p4_L0p6_m96__nf1_gboth_sdfull_ng
Xnfet_01v8_W1p4_L0p6_m96__nf1_gboth_sdfull_ng_10 x2_tail VSS_body VSS cmc nfet_01v8_W1p4_L0p6_m96__nf1_gboth_sdfull_ng
Xnfet_01v8_W1p4_L0p6_m96__nf1_gboth_sdfull_ng_21 x2_tail VSS_body VSS bias_a nfet_01v8_W1p4_L0p6_m96__nf1_gboth_sdfull_ng
Xnfet_01v8_W1p4_L0p6_m6__nf1_gtop_sdfull_ng_2 VSS_body x2_tail x2_tail x2_tail nfet_01v8_W1p4_L0p6_m6__nf1_gtop_sdfull_ng
Xnfet_01v8_W1p4_L0p6_m96__nf1_gboth_sdfull_ng_32 x2_tail VSS_body VSS bias_a nfet_01v8_W1p4_L0p6_m96__nf1_gboth_sdfull_ng
Xnfet_01v8_W1p4_L0p6_m96__nf1_gboth_sdfull_ng_43 x2_tail VSS_body VSS cmc nfet_01v8_W1p4_L0p6_m96__nf1_gboth_sdfull_ng
Xnfet_01v8_W1p4_L0p6_m96__nf1_gboth_sdfull_ng_54 x2_tail VSS_body VSS bias_a nfet_01v8_W1p4_L0p6_m96__nf1_gboth_sdfull_ng
Xnfet_01v8_W1p4_L0p6_m36__nf1_gboth_sdfull_ng_18 VSS_body VSS bias_a x2_m4d nfet_01v8_W1p4_L0p6_m36__nf1_gboth_sdfull_ng
Xnfet_01v8_W1p4_L0p6_m96__nf1_gboth_sdfull_ng_109 x2_tail VSS_body VSS cmc nfet_01v8_W1p4_L0p6_m96__nf1_gboth_sdfull_ng
Xnfet_01v8_W1p4_L0p6_m96__nf1_gboth_sdfull_ng_8 x2_tail VSS_body VSS cmc nfet_01v8_W1p4_L0p6_m96__nf1_gboth_sdfull_ng
Xnfet_01v8_W1p4_L0p6_m96__nf1_gboth_sdfull_ng_99 x2_tail VSS_body VSS cmc nfet_01v8_W1p4_L0p6_m96__nf1_gboth_sdfull_ng
Xnfet_01v8_W1p4_L0p6_m96__nf1_gboth_sdfull_ng_88 x2_tail VSS_body VSS cmc nfet_01v8_W1p4_L0p6_m96__nf1_gboth_sdfull_ng
Xnfet_01v8_W1p4_L0p6_m96__nf1_gboth_sdfull_ng_77 x2_tail VSS_body VSS bias_a nfet_01v8_W1p4_L0p6_m96__nf1_gboth_sdfull_ng
Xnfet_01v8_W1p4_L0p6_m96__nf1_gboth_sdfull_ng_66 x2_tail VSS_body VSS cmc nfet_01v8_W1p4_L0p6_m96__nf1_gboth_sdfull_ng
Xnfet_01v8_W1p4_L0p6_m96__nf1_gboth_sdfull_ng_11 x2_tail VSS_body VSS bias_a nfet_01v8_W1p4_L0p6_m96__nf1_gboth_sdfull_ng
Xnfet_01v8_W1p4_L0p6_m96__nf1_gboth_sdfull_ng_22 x2_tail VSS_body VSS cmc nfet_01v8_W1p4_L0p6_m96__nf1_gboth_sdfull_ng
Xnfet_01v8_W1p4_L0p6_m6__nf1_gtop_sdfull_ng_3 VSS_body VSS x2_m4d VSS nfet_01v8_W1p4_L0p6_m6__nf1_gtop_sdfull_ng
Xnfet_01v8_W1p4_L0p6_m96__nf1_gboth_sdfull_ng_33 x2_tail VSS_body VSS cmc nfet_01v8_W1p4_L0p6_m96__nf1_gboth_sdfull_ng
Xnfet_01v8_W1p4_L0p6_m96__nf1_gboth_sdfull_ng_44 x2_tail VSS_body VSS bias_a nfet_01v8_W1p4_L0p6_m96__nf1_gboth_sdfull_ng
Xnfet_01v8_W1p4_L0p6_m96__nf1_gboth_sdfull_ng_55 x2_tail VSS_body VSS cmc nfet_01v8_W1p4_L0p6_m96__nf1_gboth_sdfull_ng
Xnfet_01v8_W1p4_L0p6_m36__nf1_gboth_sdfull_ng_19 VSS_body VSS bias_a x2_m3d nfet_01v8_W1p4_L0p6_m36__nf1_gboth_sdfull_ng
Xnfet_01v8_W1p4_L0p6_m96__nf1_gboth_sdfull_ng_9 x2_tail VSS_body VSS bias_a nfet_01v8_W1p4_L0p6_m96__nf1_gboth_sdfull_ng
Xnfet_01v8_W1p4_L0p6_m96__nf1_gboth_sdfull_ng_89 x2_tail VSS_body VSS bias_a nfet_01v8_W1p4_L0p6_m96__nf1_gboth_sdfull_ng
Xnfet_01v8_W1p4_L0p6_m96__nf1_gboth_sdfull_ng_78 x2_tail VSS_body VSS cmc nfet_01v8_W1p4_L0p6_m96__nf1_gboth_sdfull_ng
Xnfet_01v8_W1p4_L0p6_m96__nf1_gboth_sdfull_ng_67 x2_tail VSS_body VSS bias_a nfet_01v8_W1p4_L0p6_m96__nf1_gboth_sdfull_ng
Xnfet_01v8_W1p4_L0p6_m96__nf1_gboth_sdfull_ng_12 x2_tail VSS_body VSS cmc nfet_01v8_W1p4_L0p6_m96__nf1_gboth_sdfull_ng
Xnfet_01v8_W1p4_L0p6_m96__nf1_gboth_sdfull_ng_23 x2_tail VSS_body VSS bias_a nfet_01v8_W1p4_L0p6_m96__nf1_gboth_sdfull_ng
Xnfet_01v8_W1p4_L0p6_m6__nf1_gtop_sdfull_ng_4 VSS_body x2_tail x2_tail x2_tail nfet_01v8_W1p4_L0p6_m6__nf1_gtop_sdfull_ng
Xnfet_01v8_W1p4_L0p6_m96__nf1_gboth_sdfull_ng_34 x2_tail VSS_body VSS bias_a nfet_01v8_W1p4_L0p6_m96__nf1_gboth_sdfull_ng
Xnfet_01v8_W1p4_L0p6_m96__nf1_gboth_sdfull_ng_45 x2_tail VSS_body VSS cmc nfet_01v8_W1p4_L0p6_m96__nf1_gboth_sdfull_ng
Xnfet_01v8_W1p4_L0p6_m96__nf1_gboth_sdfull_ng_56 x2_tail VSS_body VSS bias_a nfet_01v8_W1p4_L0p6_m96__nf1_gboth_sdfull_ng
Xnfet_01v8_W1p4_L0p6_m96__nf1_gboth_sdfull_ng_79 x2_tail VSS_body VSS bias_a nfet_01v8_W1p4_L0p6_m96__nf1_gboth_sdfull_ng
Xnfet_01v8_W1p4_L0p6_m96__nf1_gboth_sdfull_ng_68 x2_tail VSS_body VSS cmc nfet_01v8_W1p4_L0p6_m96__nf1_gboth_sdfull_ng
Xnfet_01v8_W1p4_L0p6_m96__nf1_gboth_sdfull_ng_13 x2_tail VSS_body VSS bias_a nfet_01v8_W1p4_L0p6_m96__nf1_gboth_sdfull_ng
Xnfet_01v8_W1p4_L0p6_m96__nf1_gboth_sdfull_ng_24 x2_tail VSS_body VSS cmc nfet_01v8_W1p4_L0p6_m96__nf1_gboth_sdfull_ng
Xnfet_01v8_W1p4_L0p6_m96__nf1_gboth_sdfull_ng_35 x2_tail VSS_body VSS cmc nfet_01v8_W1p4_L0p6_m96__nf1_gboth_sdfull_ng
Xnfet_01v8_W1p4_L0p6_m96__nf1_gboth_sdfull_ng_46 x2_tail VSS_body VSS bias_a nfet_01v8_W1p4_L0p6_m96__nf1_gboth_sdfull_ng
Xnfet_01v8_W1p4_L0p6_m96__nf1_gboth_sdfull_ng_57 x2_tail VSS_body VSS cmc nfet_01v8_W1p4_L0p6_m96__nf1_gboth_sdfull_ng
Xnfet_01v8_W1p4_L0p6_m6__nf1_gtop_sdfull_ng_5 VSS_body x2_tail x2_tail x2_tail nfet_01v8_W1p4_L0p6_m6__nf1_gtop_sdfull_ng
Xnfet_01v8_W1p4_L0p6_m96__nf1_gboth_sdfull_ng_69 x2_tail VSS_body VSS bias_a nfet_01v8_W1p4_L0p6_m96__nf1_gboth_sdfull_ng
Xnfet_01v8_W1p4_L0p6_m6__nf1_gtop_sdfull_ng_6 VSS_body x2_tail x2_tail x2_tail nfet_01v8_W1p4_L0p6_m6__nf1_gtop_sdfull_ng
Xnfet_01v8_W1p4_L0p6_m96__nf1_gboth_sdfull_ng_14 x2_tail VSS_body VSS cmc nfet_01v8_W1p4_L0p6_m96__nf1_gboth_sdfull_ng
Xnfet_01v8_W1p4_L0p6_m96__nf1_gboth_sdfull_ng_25 x2_tail VSS_body VSS bias_a nfet_01v8_W1p4_L0p6_m96__nf1_gboth_sdfull_ng
Xnfet_01v8_W1p4_L0p6_m96__nf1_gboth_sdfull_ng_36 x2_tail VSS_body VSS bias_a nfet_01v8_W1p4_L0p6_m96__nf1_gboth_sdfull_ng
Xnfet_01v8_W1p4_L0p6_m96__nf1_gboth_sdfull_ng_47 x2_tail VSS_body VSS cmc nfet_01v8_W1p4_L0p6_m96__nf1_gboth_sdfull_ng
Xnfet_01v8_W1p4_L0p6_m96__nf1_gboth_sdfull_ng_58 x2_tail VSS_body VSS bias_a nfet_01v8_W1p4_L0p6_m96__nf1_gboth_sdfull_ng
Xnfet_01v8_W1p4_L0p6_m96__nf1_gboth_sdfull_ng_15 x2_tail VSS_body VSS bias_a nfet_01v8_W1p4_L0p6_m96__nf1_gboth_sdfull_ng
Xnfet_01v8_W1p4_L0p6_m96__nf1_gboth_sdfull_ng_26 x2_tail VSS_body VSS cmc nfet_01v8_W1p4_L0p6_m96__nf1_gboth_sdfull_ng
Xnfet_01v8_W1p4_L0p6_m96__nf1_gboth_sdfull_ng_37 x2_tail VSS_body VSS cmc nfet_01v8_W1p4_L0p6_m96__nf1_gboth_sdfull_ng
Xnfet_01v8_W1p4_L0p6_m96__nf1_gboth_sdfull_ng_48 x2_tail VSS_body VSS bias_a nfet_01v8_W1p4_L0p6_m96__nf1_gboth_sdfull_ng
Xnfet_01v8_W1p4_L0p6_m96__nf1_gboth_sdfull_ng_59 x2_tail VSS_body VSS cmc nfet_01v8_W1p4_L0p6_m96__nf1_gboth_sdfull_ng
Xnfet_01v8_W1p4_L0p6_m6__nf1_gtop_sdfull_ng_7 VSS_body x2_tail x2_tail x2_tail nfet_01v8_W1p4_L0p6_m6__nf1_gtop_sdfull_ng
Xnfet_01v8_W1p4_L0p6_m6__nf1_gtop_sdfull_ng_8 VSS_body VSS x2_m4d VSS nfet_01v8_W1p4_L0p6_m6__nf1_gtop_sdfull_ng
Xnfet_01v8_W1p4_L0p6_m96__nf1_gboth_sdfull_ng_16 x2_tail VSS_body VSS cmc nfet_01v8_W1p4_L0p6_m96__nf1_gboth_sdfull_ng
Xnfet_01v8_W1p4_L0p6_m96__nf1_gboth_sdfull_ng_27 x2_tail VSS_body VSS bias_a nfet_01v8_W1p4_L0p6_m96__nf1_gboth_sdfull_ng
Xnfet_01v8_W1p4_L0p6_m96__nf1_gboth_sdfull_ng_38 x2_tail VSS_body VSS bias_a nfet_01v8_W1p4_L0p6_m96__nf1_gboth_sdfull_ng
Xnfet_01v8_W1p4_L0p6_m96__nf1_gboth_sdfull_ng_49 x2_tail VSS_body VSS cmc nfet_01v8_W1p4_L0p6_m96__nf1_gboth_sdfull_ng
Xnfet_01v8_W1p4_L0p6_m96__nf1_gboth_sdfull_ng_17 x2_tail VSS_body VSS bias_a nfet_01v8_W1p4_L0p6_m96__nf1_gboth_sdfull_ng
Xnfet_01v8_W1p4_L0p6_m96__nf1_gboth_sdfull_ng_28 x2_tail VSS_body VSS cmc nfet_01v8_W1p4_L0p6_m96__nf1_gboth_sdfull_ng
Xnfet_01v8_W1p4_L0p6_m96__nf1_gboth_sdfull_ng_39 x2_tail VSS_body VSS cmc nfet_01v8_W1p4_L0p6_m96__nf1_gboth_sdfull_ng
Xnfet_01v8_W1p4_L0p6_m6__nf1_gtop_sdfull_ng_9 VSS_body VSS x2_m4d VSS nfet_01v8_W1p4_L0p6_m6__nf1_gtop_sdfull_ng
Xnfet_01v8_W1p4_L0p6_m96__nf1_gboth_sdfull_ng_18 x2_tail VSS_body VSS cmc nfet_01v8_W1p4_L0p6_m96__nf1_gboth_sdfull_ng
Xnfet_01v8_W1p4_L0p6_m96__nf1_gboth_sdfull_ng_29 x2_tail VSS_body VSS bias_a nfet_01v8_W1p4_L0p6_m96__nf1_gboth_sdfull_ng
Xnfet_01v8_W1p4_L0p6_m96__nf1_gboth_sdfull_ng_19 x2_tail VSS_body VSS bias_a nfet_01v8_W1p4_L0p6_m96__nf1_gboth_sdfull_ng
Xnfet_01v8_W1p4_L0p6_m36__nf1_gboth_sdfull_ng_0 VSS_body VSS bias_a x2_m3d nfet_01v8_W1p4_L0p6_m36__nf1_gboth_sdfull_ng
Xnfet_01v8_W1p4_L0p6_m36__nf1_gboth_sdfull_ng_1 VSS_body VSS bias_a x2_m4d nfet_01v8_W1p4_L0p6_m36__nf1_gboth_sdfull_ng
Xnfet_01v8_W1p4_L0p6_m6__nf1_gtop_sdfull_ng_10 VSS_body VSS VSS VSS nfet_01v8_W1p4_L0p6_m6__nf1_gtop_sdfull_ng
Xnfet_01v8_W1p4_L0p6_m2__nf1_gboth_sdfull_ng_0 VSS_body VSS VSS x2_tail nfet_01v8_W1p4_L0p6_m2__nf1_gboth_sdfull_ng
Xnfet_01v8_W1p4_L0p6_m36__nf1_gboth_sdfull_ng_2 VSS_body VSS bias_a x2_m3d nfet_01v8_W1p4_L0p6_m36__nf1_gboth_sdfull_ng
Xnfet_01v8_W1p4_L0p6_m6__nf1_gtop_sdfull_ng_11 VSS_body VSS x2_m4d VSS nfet_01v8_W1p4_L0p6_m6__nf1_gtop_sdfull_ng
Xnfet_01v8_W1p4_L0p6_m2__nf1_gboth_sdfull_ng_1 VSS_body VSS VSS x2_tail nfet_01v8_W1p4_L0p6_m2__nf1_gboth_sdfull_ng
Xnfet_01v8_W1p4_L0p6_m36__nf1_gboth_sdfull_ng_3 VSS_body VSS bias_a x2_m4d nfet_01v8_W1p4_L0p6_m36__nf1_gboth_sdfull_ng
Xnfet_01v8_W1p4_L0p6_m6__nf1_gtop_sdfull_ng_12 VSS_body VSS x2_m4d VSS nfet_01v8_W1p4_L0p6_m6__nf1_gtop_sdfull_ng
Xnfet_01v8_W1p4_L0p6_m36__nf1_gboth_sdfull_ng_4 VSS_body VSS bias_a x2_m3d nfet_01v8_W1p4_L0p6_m36__nf1_gboth_sdfull_ng
Xnfet_01v8_W1p4_L0p6_m6__nf1_gtop_sdfull_ng_13 VSS_body VSS VSS VSS nfet_01v8_W1p4_L0p6_m6__nf1_gtop_sdfull_ng
Xnfet_01v8_W1p4_L0p6_m36__nf1_gboth_sdfull_ng_5 VSS_body VSS bias_a x2_m4d nfet_01v8_W1p4_L0p6_m36__nf1_gboth_sdfull_ng
Xnfet_01v8_W1p4_L0p6_m96__nf1_gboth_sdfull_ng_190 x2_tail VSS_body VSS bias_a nfet_01v8_W1p4_L0p6_m96__nf1_gboth_sdfull_ng
Xnfet_01v8_W1p4_L0p6_m36__nf1_gboth_sdfull_ng_6 VSS_body VSS bias_a x2_m3d nfet_01v8_W1p4_L0p6_m36__nf1_gboth_sdfull_ng
Xnfet_01v8_W1p4_L0p6_m96__nf1_gboth_sdfull_ng_191 x2_tail VSS_body VSS cmc nfet_01v8_W1p4_L0p6_m96__nf1_gboth_sdfull_ng
Xnfet_01v8_W1p4_L0p6_m96__nf1_gboth_sdfull_ng_180 x2_tail VSS_body VSS bias_a nfet_01v8_W1p4_L0p6_m96__nf1_gboth_sdfull_ng
Xnfet_01v8_W1p4_L0p6_m36__nf1_gboth_sdfull_ng_7 VSS_body VSS bias_a x2_m4d nfet_01v8_W1p4_L0p6_m36__nf1_gboth_sdfull_ng
Xnfet_01v8_W1p4_L0p6_m8__nf1_gtop_sdfull_ng_0 VSS_body VSS VSS x2_m3d nfet_01v8_W1p4_L0p6_m8__nf1_gtop_sdfull_ng
Xnfet_01v8_W1p4_L0p6_m96__nf1_gboth_sdfull_ng_181 x2_tail VSS_body VSS cmc nfet_01v8_W1p4_L0p6_m96__nf1_gboth_sdfull_ng
Xnfet_01v8_W1p4_L0p6_m96__nf1_gboth_sdfull_ng_170 x2_tail VSS_body VSS bias_a nfet_01v8_W1p4_L0p6_m96__nf1_gboth_sdfull_ng
Xnfet_01v8_W1p4_L0p6_m36__nf1_gboth_sdfull_ng_8 VSS_body VSS bias_a x2_m3d nfet_01v8_W1p4_L0p6_m36__nf1_gboth_sdfull_ng
Xnfet_01v8_W1p4_L0p6_m8__nf1_gtop_sdfull_ng_1 VSS_body VSS VSS x2_m3d nfet_01v8_W1p4_L0p6_m8__nf1_gtop_sdfull_ng
Xnfet_01v8_W1p4_L0p6_m96__nf1_gboth_sdfull_ng_182 x2_tail VSS_body VSS bias_a nfet_01v8_W1p4_L0p6_m96__nf1_gboth_sdfull_ng
Xnfet_01v8_W1p4_L0p6_m96__nf1_gboth_sdfull_ng_171 x2_tail VSS_body VSS cmc nfet_01v8_W1p4_L0p6_m96__nf1_gboth_sdfull_ng
Xnfet_01v8_W1p4_L0p6_m96__nf1_gboth_sdfull_ng_160 x2_tail VSS_body VSS bias_a nfet_01v8_W1p4_L0p6_m96__nf1_gboth_sdfull_ng
Xnfet_01v8_W1p4_L0p6_m36__nf1_gboth_sdfull_ng_9 VSS_body VSS bias_a x2_m4d nfet_01v8_W1p4_L0p6_m36__nf1_gboth_sdfull_ng
Xnfet_01v8_W1p4_L0p6_m36__nf1_gboth_sdfull_ng_70 VSS_body VSS bias_a x2_m4d nfet_01v8_W1p4_L0p6_m36__nf1_gboth_sdfull_ng
Xnfet_01v8_W1p4_L0p6_m8__nf1_gtop_sdfull_ng_2 VSS_body VSS VSS x2_m3d nfet_01v8_W1p4_L0p6_m8__nf1_gtop_sdfull_ng
Xnfet_01v8_W1p4_L0p6_m96__nf1_gboth_sdfull_ng_183 x2_tail VSS_body VSS cmc nfet_01v8_W1p4_L0p6_m96__nf1_gboth_sdfull_ng
Xnfet_01v8_W1p4_L0p6_m96__nf1_gboth_sdfull_ng_172 x2_tail VSS_body VSS bias_a nfet_01v8_W1p4_L0p6_m96__nf1_gboth_sdfull_ng
Xnfet_01v8_W1p4_L0p6_m96__nf1_gboth_sdfull_ng_161 x2_tail VSS_body VSS cmc nfet_01v8_W1p4_L0p6_m96__nf1_gboth_sdfull_ng
Xnfet_01v8_W1p4_L0p6_m96__nf1_gboth_sdfull_ng_150 x2_tail VSS_body VSS cmc nfet_01v8_W1p4_L0p6_m96__nf1_gboth_sdfull_ng
Xnfet_01v8_W1p4_L0p6_m36__nf1_gboth_sdfull_ng_71 VSS_body VSS bias_a x2_m3d nfet_01v8_W1p4_L0p6_m36__nf1_gboth_sdfull_ng
Xnfet_01v8_W1p4_L0p6_m36__nf1_gboth_sdfull_ng_60 VSS_body VSS bias_a x2_m4d nfet_01v8_W1p4_L0p6_m36__nf1_gboth_sdfull_ng
Xnfet_01v8_W1p4_L0p6_m8__nf1_gtop_sdfull_ng_3 VSS_body VSS VSS x2_m3d nfet_01v8_W1p4_L0p6_m8__nf1_gtop_sdfull_ng
Xnfet_01v8_W1p4_L0p6_m96__nf1_gboth_sdfull_ng_184 x2_tail VSS_body VSS bias_a nfet_01v8_W1p4_L0p6_m96__nf1_gboth_sdfull_ng
Xnfet_01v8_W1p4_L0p6_m96__nf1_gboth_sdfull_ng_173 x2_tail VSS_body VSS cmc nfet_01v8_W1p4_L0p6_m96__nf1_gboth_sdfull_ng
Xnfet_01v8_W1p4_L0p6_m96__nf1_gboth_sdfull_ng_162 x2_tail VSS_body VSS bias_a nfet_01v8_W1p4_L0p6_m96__nf1_gboth_sdfull_ng
Xnfet_01v8_W1p4_L0p6_m96__nf1_gboth_sdfull_ng_151 x2_tail VSS_body VSS bias_a nfet_01v8_W1p4_L0p6_m96__nf1_gboth_sdfull_ng
Xnfet_01v8_W1p4_L0p6_m96__nf1_gboth_sdfull_ng_140 x2_tail VSS_body VSS cmc nfet_01v8_W1p4_L0p6_m96__nf1_gboth_sdfull_ng
Xnfet_01v8_W1p4_L0p6_m36__nf1_gboth_sdfull_ng_61 VSS_body VSS bias_a x2_m3d nfet_01v8_W1p4_L0p6_m36__nf1_gboth_sdfull_ng
Xnfet_01v8_W1p4_L0p6_m36__nf1_gboth_sdfull_ng_50 VSS_body VSS bias_a x2_m3d nfet_01v8_W1p4_L0p6_m36__nf1_gboth_sdfull_ng
Xnfet_01v8_W1p4_L0p6_m8__nf1_gtop_sdfull_ng_4 VSS_body VSS VSS x2_m3d nfet_01v8_W1p4_L0p6_m8__nf1_gtop_sdfull_ng
Xnfet_01v8_W1p4_L0p6_m96__nf1_gboth_sdfull_ng_185 x2_tail VSS_body VSS cmc nfet_01v8_W1p4_L0p6_m96__nf1_gboth_sdfull_ng
Xnfet_01v8_W1p4_L0p6_m96__nf1_gboth_sdfull_ng_174 x2_tail VSS_body VSS bias_a nfet_01v8_W1p4_L0p6_m96__nf1_gboth_sdfull_ng
Xnfet_01v8_W1p4_L0p6_m96__nf1_gboth_sdfull_ng_163 x2_tail VSS_body VSS cmc nfet_01v8_W1p4_L0p6_m96__nf1_gboth_sdfull_ng
Xnfet_01v8_W1p4_L0p6_m96__nf1_gboth_sdfull_ng_152 x2_tail VSS_body VSS cmc nfet_01v8_W1p4_L0p6_m96__nf1_gboth_sdfull_ng
Xnfet_01v8_W1p4_L0p6_m96__nf1_gboth_sdfull_ng_141 x2_tail VSS_body VSS bias_a nfet_01v8_W1p4_L0p6_m96__nf1_gboth_sdfull_ng
Xnfet_01v8_W1p4_L0p6_m96__nf1_gboth_sdfull_ng_130 x2_tail VSS_body VSS cmc nfet_01v8_W1p4_L0p6_m96__nf1_gboth_sdfull_ng
Xnfet_01v8_W1p4_L0p6_m36__nf1_gboth_sdfull_ng_62 VSS_body VSS bias_a x2_m4d nfet_01v8_W1p4_L0p6_m36__nf1_gboth_sdfull_ng
Xnfet_01v8_W1p4_L0p6_m36__nf1_gboth_sdfull_ng_51 VSS_body VSS bias_a x2_m4d nfet_01v8_W1p4_L0p6_m36__nf1_gboth_sdfull_ng
Xnfet_01v8_W1p4_L0p6_m8__nf1_gtop_sdfull_ng_5 VSS_body VSS VSS x2_m3d nfet_01v8_W1p4_L0p6_m8__nf1_gtop_sdfull_ng
Xnfet_01v8_W1p4_L0p6_m36__nf1_gboth_sdfull_ng_40 VSS_body VSS bias_a x2_m4d nfet_01v8_W1p4_L0p6_m36__nf1_gboth_sdfull_ng
Xnfet_01v8_W1p4_L0p6_m96__nf1_gboth_sdfull_ng_186 x2_tail VSS_body VSS bias_a nfet_01v8_W1p4_L0p6_m96__nf1_gboth_sdfull_ng
Xnfet_01v8_W1p4_L0p6_m96__nf1_gboth_sdfull_ng_175 x2_tail VSS_body VSS cmc nfet_01v8_W1p4_L0p6_m96__nf1_gboth_sdfull_ng
Xnfet_01v8_W1p4_L0p6_m96__nf1_gboth_sdfull_ng_164 x2_tail VSS_body VSS bias_a nfet_01v8_W1p4_L0p6_m96__nf1_gboth_sdfull_ng
Xnfet_01v8_W1p4_L0p6_m96__nf1_gboth_sdfull_ng_153 x2_tail VSS_body VSS bias_a nfet_01v8_W1p4_L0p6_m96__nf1_gboth_sdfull_ng
Xnfet_01v8_W1p4_L0p6_m96__nf1_gboth_sdfull_ng_142 x2_tail VSS_body VSS cmc nfet_01v8_W1p4_L0p6_m96__nf1_gboth_sdfull_ng
Xnfet_01v8_W1p4_L0p6_m96__nf1_gboth_sdfull_ng_131 x2_tail VSS_body VSS bias_a nfet_01v8_W1p4_L0p6_m96__nf1_gboth_sdfull_ng
Xnfet_01v8_W1p4_L0p6_m96__nf1_gboth_sdfull_ng_120 x2_tail VSS_body VSS bias_a nfet_01v8_W1p4_L0p6_m96__nf1_gboth_sdfull_ng
Xnfet_01v8_W1p4_L0p6_m36__nf1_gboth_sdfull_ng_63 VSS_body VSS bias_a x2_m3d nfet_01v8_W1p4_L0p6_m36__nf1_gboth_sdfull_ng
Xnfet_01v8_W1p4_L0p6_m36__nf1_gboth_sdfull_ng_52 VSS_body VSS bias_a x2_m3d nfet_01v8_W1p4_L0p6_m36__nf1_gboth_sdfull_ng
Xnfet_01v8_W1p4_L0p6_m8__nf1_gtop_sdfull_ng_6 VSS_body VSS VSS x2_m3d nfet_01v8_W1p4_L0p6_m8__nf1_gtop_sdfull_ng
Xnfet_01v8_W1p4_L0p6_m36__nf1_gboth_sdfull_ng_41 VSS_body VSS bias_a x2_m3d nfet_01v8_W1p4_L0p6_m36__nf1_gboth_sdfull_ng
Xnfet_01v8_W1p4_L0p6_m36__nf1_gboth_sdfull_ng_30 VSS_body VSS bias_a x2_m3d nfet_01v8_W1p4_L0p6_m36__nf1_gboth_sdfull_ng
Xnfet_01v8_W1p4_L0p6_m96__nf1_gboth_sdfull_ng_187 x2_tail VSS_body VSS cmc nfet_01v8_W1p4_L0p6_m96__nf1_gboth_sdfull_ng
Xnfet_01v8_W1p4_L0p6_m96__nf1_gboth_sdfull_ng_176 x2_tail VSS_body VSS bias_a nfet_01v8_W1p4_L0p6_m96__nf1_gboth_sdfull_ng
Xnfet_01v8_W1p4_L0p6_m96__nf1_gboth_sdfull_ng_165 x2_tail VSS_body VSS cmc nfet_01v8_W1p4_L0p6_m96__nf1_gboth_sdfull_ng
Xnfet_01v8_W1p4_L0p6_m96__nf1_gboth_sdfull_ng_154 x2_tail VSS_body VSS cmc nfet_01v8_W1p4_L0p6_m96__nf1_gboth_sdfull_ng
Xnfet_01v8_W1p4_L0p6_m96__nf1_gboth_sdfull_ng_143 x2_tail VSS_body VSS bias_a nfet_01v8_W1p4_L0p6_m96__nf1_gboth_sdfull_ng
Xnfet_01v8_W1p4_L0p6_m96__nf1_gboth_sdfull_ng_132 x2_tail VSS_body VSS cmc nfet_01v8_W1p4_L0p6_m96__nf1_gboth_sdfull_ng
Xnfet_01v8_W1p4_L0p6_m96__nf1_gboth_sdfull_ng_121 x2_tail VSS_body VSS cmc nfet_01v8_W1p4_L0p6_m96__nf1_gboth_sdfull_ng
Xnfet_01v8_W1p4_L0p6_m96__nf1_gboth_sdfull_ng_110 x2_tail VSS_body VSS bias_a nfet_01v8_W1p4_L0p6_m96__nf1_gboth_sdfull_ng
Xnfet_01v8_W1p4_L0p6_m36__nf1_gboth_sdfull_ng_64 VSS_body VSS bias_a x2_m4d nfet_01v8_W1p4_L0p6_m36__nf1_gboth_sdfull_ng
Xnfet_01v8_W1p4_L0p6_m8__nf1_gtop_sdfull_ng_7 VSS_body VSS VSS x2_m3d nfet_01v8_W1p4_L0p6_m8__nf1_gtop_sdfull_ng
Xnfet_01v8_W1p4_L0p6_m36__nf1_gboth_sdfull_ng_53 VSS_body VSS bias_a x2_m4d nfet_01v8_W1p4_L0p6_m36__nf1_gboth_sdfull_ng
Xnfet_01v8_W1p4_L0p6_m36__nf1_gboth_sdfull_ng_42 VSS_body VSS bias_a x2_m4d nfet_01v8_W1p4_L0p6_m36__nf1_gboth_sdfull_ng
Xnfet_01v8_W1p4_L0p6_m36__nf1_gboth_sdfull_ng_31 VSS_body VSS bias_a x2_m4d nfet_01v8_W1p4_L0p6_m36__nf1_gboth_sdfull_ng
Xnfet_01v8_W1p4_L0p6_m36__nf1_gboth_sdfull_ng_20 VSS_body VSS bias_a x2_m4d nfet_01v8_W1p4_L0p6_m36__nf1_gboth_sdfull_ng
Xnfet_01v8_W1p4_L0p6_m96__nf1_gboth_sdfull_ng_188 x2_tail VSS_body VSS bias_a nfet_01v8_W1p4_L0p6_m96__nf1_gboth_sdfull_ng
Xnfet_01v8_W1p4_L0p6_m96__nf1_gboth_sdfull_ng_177 x2_tail VSS_body VSS cmc nfet_01v8_W1p4_L0p6_m96__nf1_gboth_sdfull_ng
Xnfet_01v8_W1p4_L0p6_m96__nf1_gboth_sdfull_ng_166 x2_tail VSS_body VSS bias_a nfet_01v8_W1p4_L0p6_m96__nf1_gboth_sdfull_ng
Xnfet_01v8_W1p4_L0p6_m96__nf1_gboth_sdfull_ng_155 x2_tail VSS_body VSS bias_a nfet_01v8_W1p4_L0p6_m96__nf1_gboth_sdfull_ng
Xnfet_01v8_W1p4_L0p6_m96__nf1_gboth_sdfull_ng_144 x2_tail VSS_body VSS cmc nfet_01v8_W1p4_L0p6_m96__nf1_gboth_sdfull_ng
Xnfet_01v8_W1p4_L0p6_m96__nf1_gboth_sdfull_ng_133 x2_tail VSS_body VSS bias_a nfet_01v8_W1p4_L0p6_m96__nf1_gboth_sdfull_ng
Xnfet_01v8_W1p4_L0p6_m96__nf1_gboth_sdfull_ng_122 x2_tail VSS_body VSS bias_a nfet_01v8_W1p4_L0p6_m96__nf1_gboth_sdfull_ng
Xnfet_01v8_W1p4_L0p6_m96__nf1_gboth_sdfull_ng_111 x2_tail VSS_body VSS cmc nfet_01v8_W1p4_L0p6_m96__nf1_gboth_sdfull_ng
Xnfet_01v8_W1p4_L0p6_m96__nf1_gboth_sdfull_ng_100 x2_tail VSS_body VSS bias_a nfet_01v8_W1p4_L0p6_m96__nf1_gboth_sdfull_ng
Xnfet_01v8_W1p4_L0p6_m96__nf1_gboth_sdfull_ng_90 x2_tail VSS_body VSS cmc nfet_01v8_W1p4_L0p6_m96__nf1_gboth_sdfull_ng
Xnfet_01v8_W1p4_L0p6_m36__nf1_gboth_sdfull_ng_65 VSS_body VSS bias_a x2_m3d nfet_01v8_W1p4_L0p6_m36__nf1_gboth_sdfull_ng
Xnfet_01v8_W1p4_L0p6_m36__nf1_gboth_sdfull_ng_54 VSS_body VSS bias_a x2_m3d nfet_01v8_W1p4_L0p6_m36__nf1_gboth_sdfull_ng
Xnfet_01v8_W1p4_L0p6_m36__nf1_gboth_sdfull_ng_43 VSS_body VSS bias_a x2_m3d nfet_01v8_W1p4_L0p6_m36__nf1_gboth_sdfull_ng
Xnfet_01v8_W1p4_L0p6_m36__nf1_gboth_sdfull_ng_32 VSS_body VSS bias_a x2_m3d nfet_01v8_W1p4_L0p6_m36__nf1_gboth_sdfull_ng
Xnfet_01v8_W1p4_L0p6_m36__nf1_gboth_sdfull_ng_10 VSS_body VSS bias_a x2_m3d nfet_01v8_W1p4_L0p6_m36__nf1_gboth_sdfull_ng
Xnfet_01v8_W1p4_L0p6_m36__nf1_gboth_sdfull_ng_21 VSS_body VSS bias_a x2_m3d nfet_01v8_W1p4_L0p6_m36__nf1_gboth_sdfull_ng
Xnfet_01v8_W1p4_L0p6_m96__nf1_gboth_sdfull_ng_189 x2_tail VSS_body VSS cmc nfet_01v8_W1p4_L0p6_m96__nf1_gboth_sdfull_ng
Xnfet_01v8_W1p4_L0p6_m96__nf1_gboth_sdfull_ng_178 x2_tail VSS_body VSS bias_a nfet_01v8_W1p4_L0p6_m96__nf1_gboth_sdfull_ng
Xnfet_01v8_W1p4_L0p6_m96__nf1_gboth_sdfull_ng_167 x2_tail VSS_body VSS cmc nfet_01v8_W1p4_L0p6_m96__nf1_gboth_sdfull_ng
Xnfet_01v8_W1p4_L0p6_m96__nf1_gboth_sdfull_ng_156 x2_tail VSS_body VSS cmc nfet_01v8_W1p4_L0p6_m96__nf1_gboth_sdfull_ng
Xnfet_01v8_W1p4_L0p6_m96__nf1_gboth_sdfull_ng_145 x2_tail VSS_body VSS bias_a nfet_01v8_W1p4_L0p6_m96__nf1_gboth_sdfull_ng
Xnfet_01v8_W1p4_L0p6_m96__nf1_gboth_sdfull_ng_134 x2_tail VSS_body VSS cmc nfet_01v8_W1p4_L0p6_m96__nf1_gboth_sdfull_ng
Xnfet_01v8_W1p4_L0p6_m96__nf1_gboth_sdfull_ng_123 x2_tail VSS_body VSS cmc nfet_01v8_W1p4_L0p6_m96__nf1_gboth_sdfull_ng
Xnfet_01v8_W1p4_L0p6_m96__nf1_gboth_sdfull_ng_112 x2_tail VSS_body VSS bias_a nfet_01v8_W1p4_L0p6_m96__nf1_gboth_sdfull_ng
Xnfet_01v8_W1p4_L0p6_m96__nf1_gboth_sdfull_ng_101 x2_tail VSS_body VSS cmc nfet_01v8_W1p4_L0p6_m96__nf1_gboth_sdfull_ng
.ends
