.subckt pmos_dummy__f4 VDD VDD_body
XXM43 VDD VDD VDD VDD_body sky130_fd_pr__pfet_01v8_lvt L=0.6 W=1.4 nf=1 m=8
Xpmos_dummy_DUMMY0 VDD VDD VDD VDD_body sky130_fd_pr__pfet_01v8_lvt L=0.6 W=1.4 nf=1
Xpmos_dummy_DUMMY1 VDD VDD VDD VDD_body sky130_fd_pr__pfet_01v8_lvt L=0.6 W=1.4 nf=1
Xpmos_dummy_DUMMY2 VDD VDD VDD VDD_body sky130_fd_pr__pfet_01v8_lvt L=0.6 W=1.4 nf=1
Xpmos_dummy_DUMMY3 VDD VDD VDD VDD_body sky130_fd_pr__pfet_01v8_lvt L=0.6 W=1.4 nf=1
Xpmos_dummy_DUMMY4 VDD VDD VDD VDD_body sky130_fd_pr__pfet_01v8_lvt L=0.6 W=1.4 nf=1
Xpmos_dummy_DUMMY5 VDD VDD VDD VDD_body sky130_fd_pr__pfet_01v8_lvt L=0.6 W=1.4 nf=1
Xpmos_dummy_DUMMY6 VDD VDD VDD VDD_body sky130_fd_pr__pfet_01v8_lvt L=0.6 W=1.4 nf=1
Xpmos_dummy_DUMMY7 VDD VDD VDD VDD_body sky130_fd_pr__pfet_01v8_lvt L=0.6 W=1.4 nf=1
.ends
