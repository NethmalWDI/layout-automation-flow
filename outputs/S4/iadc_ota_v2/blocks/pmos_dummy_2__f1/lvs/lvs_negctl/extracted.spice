* NGSPICE file created from pmos_dummy_2__f1.ext - technology: sky130A

.subckt sky130_fd_pr__pfet_01v8_RGDEC8 G D w_n154_n240# S
X0 S G D w_n154_n240# sky130_fd_pr__pfet_01v8 ad=0.406 pd=3.38 as=0.406 ps=3.38 w=1.4 l=0.6
.ends

.subckt pfet_01v8_W1p4_L0p6_m6__nf1_gboth_sdfull_ng S B G D
Xpfet_01v8_W1p4_L0p6_m6__nf1_gboth_sdfull_ng_pc G D B S sky130_fd_pr__pfet_01v8_RGDEC8
.ends

.subckt pmos_dummy_2__f1 VDD VDD_body
Xpfet_01v8_W1p4_L0p6_m6__nf1_gboth_sdfull_ng_0 VDD VDD_body VDD VDD pfet_01v8_W1p4_L0p6_m6__nf1_gboth_sdfull_ng
Xpfet_01v8_W1p4_L0p6_m6__nf1_gboth_sdfull_ng_1 VDD VDD_body VDD VDD pfet_01v8_W1p4_L0p6_m6__nf1_gboth_sdfull_ng
Xpfet_01v8_W1p4_L0p6_m6__nf1_gboth_sdfull_ng_2 VDD VDD_body VDD VDD pfet_01v8_W1p4_L0p6_m6__nf1_gboth_sdfull_ng
Xpfet_01v8_W1p4_L0p6_m6__nf1_gboth_sdfull_ng_3 VDD VDD_body VDD VDD pfet_01v8_W1p4_L0p6_m6__nf1_gboth_sdfull_ng
Xpfet_01v8_W1p4_L0p6_m6__nf1_gboth_sdfull_ng_4 VDD VDD_body VDD VDD pfet_01v8_W1p4_L0p6_m6__nf1_gboth_sdfull_ng
Xpfet_01v8_W1p4_L0p6_m6__nf1_gboth_sdfull_ng_6 VDD VDD_body VDD VDD pfet_01v8_W1p4_L0p6_m6__nf1_gboth_sdfull_ng
Xpfet_01v8_W1p4_L0p6_m6__nf1_gboth_sdfull_ng_5 VDD VDD_body VDD VDD pfet_01v8_W1p4_L0p6_m6__nf1_gboth_sdfull_ng
Xpfet_01v8_W1p4_L0p6_m6__nf1_gboth_sdfull_ng_7 VDD VDD_body VDD VDD pfet_01v8_W1p4_L0p6_m6__nf1_gboth_sdfull_ng
.ends
