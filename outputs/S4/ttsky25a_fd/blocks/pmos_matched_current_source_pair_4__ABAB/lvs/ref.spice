.subckt pmos_matched_current_source_pair_4__ABAB Vdd x1_Vout x1_Vtest2 x1_net1 Vdd_body
XXX1_M13 x1_Vtest2 x1_Vout Vdd Vdd_body sky130_fd_pr__pfet_01v8_lvt L=5 W=2 nf=2 m=4
XXX1_M14 x1_net1 x1_Vout Vdd Vdd_body sky130_fd_pr__pfet_01v8_lvt L=5 W=2 nf=2 m=4
Xpmos_matched_current_source_pair_4_DUMMY0 Vdd Vdd Vdd Vdd_body sky130_fd_pr__pfet_01v8_lvt L=5 W=2 nf=2
Xpmos_matched_current_source_pair_4_DUMMY1 Vdd Vdd Vdd Vdd_body sky130_fd_pr__pfet_01v8_lvt L=5 W=2 nf=2
.ends
