.subckt nmos_current_mirror_4__A Vss net4 Vss_body
XXX1_M46 net4 net4 Vss Vss_body sky130_fd_pr__nfet_01v8_lvt L=2 W=1 nf=1 m=2
.ends
