* NGSPICE file created from nmos_current_mirror_4__A.ext - technology: sky130A

.subckt sky130_fd_pr__nfet_01v8_lvt_SLTJA6 G D S VSUBS
X0 S G D VSUBS sky130_fd_pr__nfet_01v8_lvt ad=0.29 pd=2.58 as=0.29 ps=2.58 w=1 l=2
.ends

.subckt nfet_01v8_lvt_W1_L2_m2__nf1_gboth_sdfull_ng B S G D
Xnfet_01v8_lvt_W1_L2_m2__nf1_gboth_sdfull_ng_pc G D S B sky130_fd_pr__nfet_01v8_lvt_SLTJA6
.ends

.subckt nmos_current_mirror_4__A net4 Vss Vss_body
Xnfet_01v8_lvt_W1_L2_m2__nf1_gboth_sdfull_ng_0 Vss_body Vss net4 net4 nfet_01v8_lvt_W1_L2_m2__nf1_gboth_sdfull_ng
Xnfet_01v8_lvt_W1_L2_m2__nf1_gboth_sdfull_ng_1 Vss_body Vss net4 net4 nfet_01v8_lvt_W1_L2_m2__nf1_gboth_sdfull_ng
.ends
