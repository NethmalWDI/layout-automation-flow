.subckt pmos_current_mirror_2__row Vdd x2_Vbiasp x2_net1 Vdd_body
XXX2_M12 x2_Vbiasp x2_Vbiasp Vdd Vdd_body sky130_fd_pr__pfet_01v8_lvt L=1 W=6 nf=1 m=2
XXX2_M3 x2_net1 x2_Vbiasp Vdd Vdd_body sky130_fd_pr__pfet_01v8_lvt L=5 W=1 nf=1 m=2
Xpmos_current_mirror_2_DUMMY0 Vdd Vdd Vdd Vdd_body sky130_fd_pr__pfet_01v8_lvt L=1 W=6 nf=1
Xpmos_current_mirror_2_DUMMY1 Vdd Vdd Vdd Vdd_body sky130_fd_pr__pfet_01v8_lvt L=5 W=1 nf=1
.ends
