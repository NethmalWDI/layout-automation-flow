* NGSPICE file created from nmos_diode_2__A.ext - technology: sky130A

.subckt sky130_fd_pr__nfet_01v8_lvt_E98VH6 G D S VSUBS
X0 S G D VSUBS sky130_fd_pr__nfet_01v8_lvt ad=0.174 pd=1.78 as=0.174 ps=1.78 w=0.6 l=5
.ends

.subckt nfet_01v8_lvt_W0p6_L5_m2__nf1_gboth_sdfull_ng B G D S
Xnfet_01v8_lvt_W0p6_L5_m2__nf1_gboth_sdfull_ng_pc G D S B sky130_fd_pr__nfet_01v8_lvt_E98VH6
.ends

.subckt nmos_diode_2__A net5 Vss Vss_body
Xnfet_01v8_lvt_W0p6_L5_m2__nf1_gboth_sdfull_ng_1 Vss_body net5 net5 Vss nfet_01v8_lvt_W0p6_L5_m2__nf1_gboth_sdfull_ng
Xnfet_01v8_lvt_W0p6_L5_m2__nf1_gboth_sdfull_ng_0 Vss_body net5 net5 Vss nfet_01v8_lvt_W0p6_L5_m2__nf1_gboth_sdfull_ng
.ends
