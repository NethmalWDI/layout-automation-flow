.subckt nmos_diode_2__A Vss net5 Vss_body
XXX1_M47 net5 net5 Vss Vss_body sky130_fd_pr__nfet_01v8_lvt L=5 W=0.6 nf=1 m=2
.ends
