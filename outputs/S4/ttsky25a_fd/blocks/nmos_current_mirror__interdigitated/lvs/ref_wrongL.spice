.subckt nmos_current_mirror__interdigitated NBias PBias Vss net3 Vss_body
XXM33 NBias NBias Vss Vss_body sky130_fd_pr__nfet_01v8_lvt L=2.2 W=5 nf=1 m=2
XXM37 PBias NBias Vss Vss_body sky130_fd_pr__nfet_01v8_lvt L=2 W=5 nf=1 m=2
XXM41 net3 NBias Vss Vss_body sky130_fd_pr__nfet_01v8_lvt L=2 W=5 nf=1 m=2
Xnmos_current_mirror_DUMMY0 Vss Vss Vss Vss_body sky130_fd_pr__nfet_01v8_lvt L=2 W=5 nf=1
Xnmos_current_mirror_DUMMY1 Vss Vss Vss Vss_body sky130_fd_pr__nfet_01v8_lvt L=2 W=5 nf=1
.ends
