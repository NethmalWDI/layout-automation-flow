.subckt pmos_diode__A Vdd net3 Vdd_body
XXM42 net3 net3 Vdd Vdd_body sky130_fd_pr__pfet_01v8_lvt L=20 W=1 nf=1 m=2
.ends
