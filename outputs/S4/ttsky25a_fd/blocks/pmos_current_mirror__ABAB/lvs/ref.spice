.subckt pmos_current_mirror__ABAB PBias Vdd net2 Vdd_body
XXM39 net2 net2 Vdd Vdd_body sky130_fd_pr__pfet_01v8_lvt L=1 W=5 nf=1 m=2
XXM38 PBias net2 Vdd Vdd_body sky130_fd_pr__pfet_01v8_lvt L=1 W=5 nf=1 m=2
Xpmos_current_mirror_DUMMY0 Vdd Vdd Vdd Vdd_body sky130_fd_pr__pfet_01v8_lvt L=1 W=5 nf=1
Xpmos_current_mirror_DUMMY1 Vdd Vdd Vdd Vdd_body sky130_fd_pr__pfet_01v8_lvt L=1 W=5 nf=1
.ends
