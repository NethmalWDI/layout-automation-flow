.subckt nmos_single__A Vss net1 net2 Vss_body
XXM36 net2 net1 Vss Vss_body sky130_fd_pr__nfet_01v8_lvt L=2.2 W=5 nf=1 m=2
.ends
