* NGSPICE file created from pmos_single__A.ext - technology: sky130A

.subckt sky130_fd_pr__pfet_01v8_lvt_2HDQYB G w_n323_n200# D0 a_229_n100# S1
X0 S1 G D0 w_n323_n200# sky130_fd_pr__pfet_01v8_lvt ad=0.145 pd=1.29 as=0.29 ps=2.58 w=1 l=1
X1 a_229_n100# G S1 w_n323_n200# sky130_fd_pr__pfet_01v8_lvt ad=0.29 pd=2.58 as=0.145 ps=1.29 w=1 l=1
.ends

.subckt pfet_01v8_lvt_W2_L1_m9__nf2_gboth_sdfull_outS_ng G D S B
Xpfet_01v8_lvt_W2_L1_m9__nf2_gboth_sdfull_outS_ng_pc G B S S D sky130_fd_pr__pfet_01v8_lvt_2HDQYB
.ends

.subckt pmos_single__A Vdd Vop1 Vom Vdd_body
Xpfet_01v8_lvt_W2_L1_m9__nf2_gboth_sdfull_outS_ng_0 Vop1 Vom Vdd Vdd_body pfet_01v8_lvt_W2_L1_m9__nf2_gboth_sdfull_outS_ng
Xpfet_01v8_lvt_W2_L1_m9__nf2_gboth_sdfull_outS_ng_1 Vop1 Vom Vdd Vdd_body pfet_01v8_lvt_W2_L1_m9__nf2_gboth_sdfull_outS_ng
Xpfet_01v8_lvt_W2_L1_m9__nf2_gboth_sdfull_outS_ng_2 Vop1 Vom Vdd Vdd_body pfet_01v8_lvt_W2_L1_m9__nf2_gboth_sdfull_outS_ng
Xpfet_01v8_lvt_W2_L1_m9__nf2_gboth_sdfull_outS_ng_3 Vop1 Vom Vdd Vdd_body pfet_01v8_lvt_W2_L1_m9__nf2_gboth_sdfull_outS_ng
Xpfet_01v8_lvt_W2_L1_m9__nf2_gboth_sdfull_outS_ng_4 Vop1 Vom Vdd Vdd_body pfet_01v8_lvt_W2_L1_m9__nf2_gboth_sdfull_outS_ng
Xpfet_01v8_lvt_W2_L1_m9__nf2_gboth_sdfull_outS_ng_5 Vop1 Vom Vdd Vdd_body pfet_01v8_lvt_W2_L1_m9__nf2_gboth_sdfull_outS_ng
Xpfet_01v8_lvt_W2_L1_m9__nf2_gboth_sdfull_outS_ng_7 Vop1 Vom Vdd Vdd_body pfet_01v8_lvt_W2_L1_m9__nf2_gboth_sdfull_outS_ng
Xpfet_01v8_lvt_W2_L1_m9__nf2_gboth_sdfull_outS_ng_6 Vop1 Vom Vdd Vdd_body pfet_01v8_lvt_W2_L1_m9__nf2_gboth_sdfull_outS_ng
Xpfet_01v8_lvt_W2_L1_m9__nf2_gboth_sdfull_outS_ng_8 Vop1 Vom Vdd Vdd_body pfet_01v8_lvt_W2_L1_m9__nf2_gboth_sdfull_outS_ng
.ends
