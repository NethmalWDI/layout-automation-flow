.subckt pmos_single__A Vdd Vom Vop1 Vdd_body
XXX2_M4 Vom Vop1 Vdd Vdd_body sky130_fd_pr__pfet_01v8_lvt L=1.1 W=2 nf=2 m=9
.ends
