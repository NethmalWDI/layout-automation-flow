.subckt XC1__A Vop1 Vom
XC1 Vop1 Vom sky130_fd_pr__cap_mim_m3_1 W=10 L=10 m=5
.ends
