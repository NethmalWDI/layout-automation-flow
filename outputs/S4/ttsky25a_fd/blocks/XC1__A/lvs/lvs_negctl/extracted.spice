* NGSPICE file created from XC1__A.ext - technology: sky130A

.subckt sky130_fd_pr__cap_mim_m3_1_DHLNXX C1_4 C1_3 C1_2 C1_1 C1_0 C2_4 C2_3 C2_2
+ C2_1 C2_0
X0 C1_0 C2_0 sky130_fd_pr__cap_mim_m3_1 l=10 w=10
X1 C1_2 C2_2 sky130_fd_pr__cap_mim_m3_1 l=10 w=10
X2 C1_3 C2_3 sky130_fd_pr__cap_mim_m3_1 l=10 w=10
X3 C1_1 C2_1 sky130_fd_pr__cap_mim_m3_1 l=10 w=10
X4 C1_4 C2_4 sky130_fd_pr__cap_mim_m3_1 l=10 w=10
.ends

.subckt XC1_mim XC1_mim_pc/C2_4 XC1_mim_pc/C2_2 XC1_mim_pc/C2_3 XC1_mim_pc/C2_1 XC1_mim_pc/C2_0
+ XC1_mim_pc/C1_4 XC1_mim_pc/C1_3 XC1_mim_pc/C1_2 XC1_mim_pc/C1_1 XC1_mim_pc/C1_0
XXC1_mim_pc XC1_mim_pc/C1_4 XC1_mim_pc/C1_3 XC1_mim_pc/C1_2 XC1_mim_pc/C1_1 XC1_mim_pc/C1_0
+ XC1_mim_pc/C2_4 XC1_mim_pc/C2_3 XC1_mim_pc/C2_2 XC1_mim_pc/C2_1 XC1_mim_pc/C2_0
+ sky130_fd_pr__cap_mim_m3_1_DHLNXX
.ends

.subckt XC1__A Vop1 Vom
XXC1_mim_0 Vom Vom Vom Vom Vom Vop1 Vop1 Vop1 Vop1 Vop1 XC1_mim
.ends
