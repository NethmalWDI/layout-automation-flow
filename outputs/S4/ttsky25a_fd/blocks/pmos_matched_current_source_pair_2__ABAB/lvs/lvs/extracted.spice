* NGSPICE file created from pmos_matched_current_source_pair_2__ABAB.ext - technology: sky130A

.subckt sky130_fd_pr__pfet_01v8_lvt_7Q9QDH G D S w_n194_n598#
X0 S G D w_n194_n598# sky130_fd_pr__pfet_01v8_lvt ad=1.45 pd=10.58 as=1.45 ps=10.58 w=5 l=1
.ends

.subckt pfet_01v8_lvt_W5_L1_m2__nf1_gtop_sdfull_ng G D S B
Xpfet_01v8_lvt_W5_L1_m2__nf1_gtop_sdfull_ng_pc G D S B sky130_fd_pr__pfet_01v8_lvt_7Q9QDH
.ends

.subckt pmos_matched_current_source_pair_2__ABAB Vdd PBias net4 net5 Vdd_body
Xpfet_01v8_lvt_W5_L1_m2__nf1_gtop_sdfull_ng_0 Vdd Vdd Vdd Vdd_body pfet_01v8_lvt_W5_L1_m2__nf1_gtop_sdfull_ng
Xpfet_01v8_lvt_W5_L1_m2__nf1_gtop_sdfull_ng_1 PBias net4 Vdd Vdd_body pfet_01v8_lvt_W5_L1_m2__nf1_gtop_sdfull_ng
Xpfet_01v8_lvt_W5_L1_m2__nf1_gtop_sdfull_ng_2 PBias net5 Vdd Vdd_body pfet_01v8_lvt_W5_L1_m2__nf1_gtop_sdfull_ng
Xpfet_01v8_lvt_W5_L1_m2__nf1_gtop_sdfull_ng_4 PBias net5 Vdd Vdd_body pfet_01v8_lvt_W5_L1_m2__nf1_gtop_sdfull_ng
Xpfet_01v8_lvt_W5_L1_m2__nf1_gtop_sdfull_ng_3 PBias net4 Vdd Vdd_body pfet_01v8_lvt_W5_L1_m2__nf1_gtop_sdfull_ng
Xpfet_01v8_lvt_W5_L1_m2__nf1_gtop_sdfull_ng_5 Vdd Vdd Vdd Vdd_body pfet_01v8_lvt_W5_L1_m2__nf1_gtop_sdfull_ng
.ends
