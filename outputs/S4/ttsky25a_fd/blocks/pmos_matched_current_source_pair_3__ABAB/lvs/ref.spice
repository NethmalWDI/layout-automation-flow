.subckt pmos_matched_current_source_pair_3__ABAB PBias Vdd net6 net7 Vdd_body
XXM45 net6 PBias Vdd Vdd_body sky130_fd_pr__pfet_01v8_lvt L=1 W=5 nf=1 m=2
XXM54 net7 PBias Vdd Vdd_body sky130_fd_pr__pfet_01v8_lvt L=1 W=5 nf=1 m=2
Xpmos_matched_current_source_pair_3_DUMMY0 Vdd Vdd Vdd Vdd_body sky130_fd_pr__pfet_01v8_lvt L=1 W=5 nf=1
Xpmos_matched_current_source_pair_3_DUMMY1 Vdd Vdd Vdd Vdd_body sky130_fd_pr__pfet_01v8_lvt L=1 W=5 nf=1
.ends
