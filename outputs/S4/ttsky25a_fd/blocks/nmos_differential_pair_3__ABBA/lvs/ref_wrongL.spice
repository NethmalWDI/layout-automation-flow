.subckt nmos_differential_pair_3__ABBA Vop1 Vref Vss x1_Vout x1_net8 x1_net9 Vss_body
XXX1_M10 x1_Vout Vref x1_net8 Vss_body sky130_fd_pr__nfet_01v8_lvt L=22 W=5 nf=1 m=2
XXX1_M17 x1_net9 Vop1 x1_net8 Vss_body sky130_fd_pr__nfet_01v8_lvt L=20 W=5 nf=1 m=2
Xnmos_differential_pair_3_DUMMY0 Vss Vss Vss Vss_body sky130_fd_pr__nfet_01v8_lvt L=20 W=5 nf=1
Xnmos_differential_pair_3_DUMMY1 Vss Vss Vss Vss_body sky130_fd_pr__nfet_01v8_lvt L=20 W=5 nf=1
.ends
