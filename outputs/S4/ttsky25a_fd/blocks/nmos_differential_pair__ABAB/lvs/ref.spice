.subckt nmos_differential_pair__ABAB Vm Vp Vss x1_Vtest2 x1_net1 x1_net2 Vss_body
XXX1_M5 x1_Vtest2 Vm x1_net2 Vss_body sky130_fd_pr__nfet_01v8_lvt L=4 W=4 nf=1 m=2
XXX1_M6 x1_net1 Vp x1_net2 Vss_body sky130_fd_pr__nfet_01v8_lvt L=4 W=4 nf=1 m=2
Xnmos_differential_pair_DUMMY0 Vss Vss Vss Vss_body sky130_fd_pr__nfet_01v8_lvt L=4 W=4 nf=1
Xnmos_differential_pair_DUMMY1 Vss Vss Vss Vss_body sky130_fd_pr__nfet_01v8_lvt L=4 W=4 nf=1
.ends
