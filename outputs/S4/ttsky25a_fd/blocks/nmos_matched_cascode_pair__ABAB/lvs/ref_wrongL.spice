.subckt nmos_matched_cascode_pair__ABAB Vop1 Vss net5 x1_net2 x1_net3 x1_net5 Vss_body
XXX1_M19 x1_net2 net5 x1_net3 Vss_body sky130_fd_pr__nfet_01v8_lvt L=1.1 W=1 nf=1 m=2
XXX1_M4 Vop1 net5 x1_net5 Vss_body sky130_fd_pr__nfet_01v8_lvt L=1 W=1 nf=1 m=2
Xnmos_matched_cascode_pair_DUMMY0 Vss Vss Vss Vss_body sky130_fd_pr__nfet_01v8_lvt L=1 W=1 nf=1
Xnmos_matched_cascode_pair_DUMMY1 Vss Vss Vss Vss_body sky130_fd_pr__nfet_01v8_lvt L=1 W=1 nf=1
.ends
