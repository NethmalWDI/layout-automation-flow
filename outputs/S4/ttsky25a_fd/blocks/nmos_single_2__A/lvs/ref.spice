.subckt nmos_single_2__A NBias PBias net3 Vss_body
XXM40 PBias net3 NBias Vss_body sky130_fd_pr__nfet_01v8_lvt L=1 W=2 nf=1
.ends
