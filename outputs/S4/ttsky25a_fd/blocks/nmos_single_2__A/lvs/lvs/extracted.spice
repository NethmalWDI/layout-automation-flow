* NGSPICE file created from nmos_single_2__A.ext - technology: sky130A

.subckt sky130_fd_pr__nfet_01v8_lvt_U7GK5T G D S VSUBS
X0 S G D VSUBS sky130_fd_pr__nfet_01v8_lvt ad=0.58 pd=4.58 as=0.58 ps=4.58 w=2 l=1
.ends

.subckt nfet_01v8_lvt_W2_L1_m1__nf1_gtop_sdfull_ng B G D S
Xnfet_01v8_lvt_W2_L1_m1__nf1_gtop_sdfull_ng_pc G D S B sky130_fd_pr__nfet_01v8_lvt_U7GK5T
.ends

.subckt nmos_single_2__A net3 PBias NBias Vss_body
Xnfet_01v8_lvt_W2_L1_m1__nf1_gtop_sdfull_ng_0 Vss_body net3 PBias NBias nfet_01v8_lvt_W2_L1_m1__nf1_gtop_sdfull_ng
.ends
