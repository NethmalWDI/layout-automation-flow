* NGSPICE file created from mirror_XX1_M22_XX1_M15__ABBA.ext - technology: sky130A

.subckt sky130_fd_pr__nfet_01v8_lvt_YRHGMU G D S VSUBS
X0 S G D VSUBS sky130_fd_pr__nfet_01v8_lvt ad=0.29 pd=2.58 as=0.29 ps=2.58 w=1 l=20
.ends

.subckt nfet_01v8_lvt_W1_L20_m2__nf1_gboth_sdfull_ng S B G D
Xnfet_01v8_lvt_W1_L20_m2__nf1_gboth_sdfull_ng_pc G D S B sky130_fd_pr__nfet_01v8_lvt_YRHGMU
.ends

.subckt mirror_XX1_M22_XX1_M15__ABBA Vss net4 x1_net7 x1_net8 Vss_body
Xnfet_01v8_lvt_W1_L20_m2__nf1_gboth_sdfull_ng_0 Vss Vss_body Vss Vss nfet_01v8_lvt_W1_L20_m2__nf1_gboth_sdfull_ng
Xnfet_01v8_lvt_W1_L20_m2__nf1_gboth_sdfull_ng_1 Vss Vss_body net4 x1_net7 nfet_01v8_lvt_W1_L20_m2__nf1_gboth_sdfull_ng
Xnfet_01v8_lvt_W1_L20_m2__nf1_gboth_sdfull_ng_2 Vss Vss_body net4 x1_net8 nfet_01v8_lvt_W1_L20_m2__nf1_gboth_sdfull_ng
Xnfet_01v8_lvt_W1_L20_m2__nf1_gboth_sdfull_ng_3 Vss Vss_body net4 x1_net8 nfet_01v8_lvt_W1_L20_m2__nf1_gboth_sdfull_ng
Xnfet_01v8_lvt_W1_L20_m2__nf1_gboth_sdfull_ng_4 Vss Vss_body net4 x1_net7 nfet_01v8_lvt_W1_L20_m2__nf1_gboth_sdfull_ng
Xnfet_01v8_lvt_W1_L20_m2__nf1_gboth_sdfull_ng_5 Vss Vss_body Vss Vss nfet_01v8_lvt_W1_L20_m2__nf1_gboth_sdfull_ng
.ends
