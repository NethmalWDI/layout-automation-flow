.subckt mirror_XX1_M22_XX1_M15__ABBA Vss net4 x1_net7 x1_net8 Vss_body
XXX1_M22 x1_net7 net4 Vss Vss_body sky130_fd_pr__nfet_01v8_lvt L=20 W=1 nf=1 m=2
XXX1_M15 x1_net8 net4 Vss Vss_body sky130_fd_pr__nfet_01v8_lvt L=20 W=1 nf=1 m=2
Xmirror_XX1_M22_XX1_M15_DUMMY0 Vss Vss Vss Vss_body sky130_fd_pr__nfet_01v8_lvt L=20 W=1 nf=1
Xmirror_XX1_M22_XX1_M15_DUMMY1 Vss Vss Vss Vss_body sky130_fd_pr__nfet_01v8_lvt L=20 W=1 nf=1
.ends
