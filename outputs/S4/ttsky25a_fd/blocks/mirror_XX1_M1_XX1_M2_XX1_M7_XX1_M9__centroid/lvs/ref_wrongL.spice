.subckt mirror_XX1_M1_XX1_M2_XX1_M7_XX1_M9__centroid Vss net4 x1_net3 x1_net4 x1_net5 x1_net6 Vss_body
XXX1_M1 x1_net3 net4 Vss Vss_body sky130_fd_pr__nfet_01v8_lvt L=11 W=1 nf=1 m=2
XXX1_M2 x1_net4 net4 Vss Vss_body sky130_fd_pr__nfet_01v8_lvt L=10 W=1 nf=1 m=2
XXX1_M7 x1_net5 net4 Vss Vss_body sky130_fd_pr__nfet_01v8_lvt L=10 W=1 nf=1 m=2
XXX1_M9 x1_net6 net4 Vss Vss_body sky130_fd_pr__nfet_01v8_lvt L=10 W=1 nf=1 m=2
Xmirror_XX1_M1_XX1_M2_XX1_M7_XX1_M9_DUMMY0 Vss Vss Vss Vss_body sky130_fd_pr__nfet_01v8_lvt L=10 W=1 nf=1
Xmirror_XX1_M1_XX1_M2_XX1_M7_XX1_M9_DUMMY1 Vss Vss Vss Vss_body sky130_fd_pr__nfet_01v8_lvt L=10 W=1 nf=1
.ends
