* NGSPICE file created from mirror_XX1_M1_XX1_M2_XX1_M7_XX1_M9__centroid.ext - technology: sky130A

.subckt sky130_fd_pr__nfet_01v8_lvt_7VF3LY G D S VSUBS
X0 S G D VSUBS sky130_fd_pr__nfet_01v8_lvt ad=0.29 pd=2.58 as=0.29 ps=2.58 w=1 l=10
.ends

.subckt nfet_01v8_lvt_W1_L10_m2__nf1_gboth_sdfull_ng B G D S
Xnfet_01v8_lvt_W1_L10_m2__nf1_gboth_sdfull_ng_pc G D S B sky130_fd_pr__nfet_01v8_lvt_7VF3LY
.ends

.subckt mirror_XX1_M1_XX1_M2_XX1_M7_XX1_M9__centroid Vss net4 x1_net3 x1_net4 x1_net5
+ x1_net6 Vss_body
Xnfet_01v8_lvt_W1_L10_m2__nf1_gboth_sdfull_ng_0 Vss_body Vss Vss Vss nfet_01v8_lvt_W1_L10_m2__nf1_gboth_sdfull_ng
Xnfet_01v8_lvt_W1_L10_m2__nf1_gboth_sdfull_ng_1 Vss_body net4 x1_net3 Vss nfet_01v8_lvt_W1_L10_m2__nf1_gboth_sdfull_ng
Xnfet_01v8_lvt_W1_L10_m2__nf1_gboth_sdfull_ng_2 Vss_body net4 x1_net4 Vss nfet_01v8_lvt_W1_L10_m2__nf1_gboth_sdfull_ng
Xnfet_01v8_lvt_W1_L10_m2__nf1_gboth_sdfull_ng_3 Vss_body net4 x1_net5 Vss nfet_01v8_lvt_W1_L10_m2__nf1_gboth_sdfull_ng
Xnfet_01v8_lvt_W1_L10_m2__nf1_gboth_sdfull_ng_4 Vss_body net4 x1_net6 Vss nfet_01v8_lvt_W1_L10_m2__nf1_gboth_sdfull_ng
Xnfet_01v8_lvt_W1_L10_m2__nf1_gboth_sdfull_ng_5 Vss_body net4 x1_net6 Vss nfet_01v8_lvt_W1_L10_m2__nf1_gboth_sdfull_ng
Xnfet_01v8_lvt_W1_L10_m2__nf1_gboth_sdfull_ng_6 Vss_body net4 x1_net5 Vss nfet_01v8_lvt_W1_L10_m2__nf1_gboth_sdfull_ng
Xnfet_01v8_lvt_W1_L10_m2__nf1_gboth_sdfull_ng_8 Vss_body net4 x1_net3 Vss nfet_01v8_lvt_W1_L10_m2__nf1_gboth_sdfull_ng
Xnfet_01v8_lvt_W1_L10_m2__nf1_gboth_sdfull_ng_7 Vss_body net4 x1_net4 Vss nfet_01v8_lvt_W1_L10_m2__nf1_gboth_sdfull_ng
Xnfet_01v8_lvt_W1_L10_m2__nf1_gboth_sdfull_ng_9 Vss_body Vss Vss Vss nfet_01v8_lvt_W1_L10_m2__nf1_gboth_sdfull_ng
.ends
