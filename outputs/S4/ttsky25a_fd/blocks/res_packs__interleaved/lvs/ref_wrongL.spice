.subckt res_packs__interleaved Vom Vop Vss x2_Vcm x2_x1_net1 x2_x1_net10 x2_x1_net11 x2_x1_net12 x2_x1_net13 x2_x1_net14 x2_x1_net15 x2_x1_net16 x2_x1_net17 x2_x1_net18 x2_x1_net19 x2_x1_net2 x2_x1_net3 x2_x1_net4 x2_x1_net5 x2_x1_net6 x2_x1_net7 x2_x1_net8 x2_x1_net9 x2_x2_net1 x2_x2_net10 x2_x2_net11 x2_x2_net12 x2_x2_net13 x2_x2_net14 x2_x2_net15 x2_x2_net16 x2_x2_net17 x2_x2_net18 x2_x2_net19 x2_x2_net2 x2_x2_net3 x2_x2_net4 x2_x2_net5 x2_x2_net6 x2_x2_net7 x2_x2_net8 x2_x2_net9 Vss_body
Xres_packs_DUMMY0 Vss Vss sky130_fd_pr__res_generic_po W=0.5 L=44
XXX2_X1_R1 x2_x1_net4 Vop sky130_fd_pr__res_generic_po W=0.5 L=40
XXX2_X2_R1 x2_x2_net4 x2_Vcm sky130_fd_pr__res_generic_po W=0.5 L=40
XXX2_X2_R2 x2_x2_net4 x2_x2_net5 sky130_fd_pr__res_generic_po W=0.5 L=40
XXX2_X1_R2 x2_x1_net4 x2_x1_net5 sky130_fd_pr__res_generic_po W=0.5 L=40
XXX2_X1_R3 x2_x1_net6 x2_x1_net5 sky130_fd_pr__res_generic_po W=0.5 L=40
XXX2_X2_R3 x2_x2_net6 x2_x2_net5 sky130_fd_pr__res_generic_po W=0.5 L=40
XXX2_X2_R4 x2_x2_net6 x2_x2_net7 sky130_fd_pr__res_generic_po W=0.5 L=40
XXX2_X1_R4 x2_x1_net6 x2_x1_net7 sky130_fd_pr__res_generic_po W=0.5 L=40
XXX2_X1_R5 x2_x1_net1 x2_x1_net7 sky130_fd_pr__res_generic_po W=0.5 L=40
XXX2_X2_R5 x2_x2_net1 x2_x2_net7 sky130_fd_pr__res_generic_po W=0.5 L=40
XXX2_X2_R10 x2_x2_net1 x2_x2_net11 sky130_fd_pr__res_generic_po W=0.5 L=40
XXX2_X1_R10 x2_x1_net1 x2_x1_net11 sky130_fd_pr__res_generic_po W=0.5 L=40
XXX2_X1_R9 x2_x1_net10 x2_x1_net11 sky130_fd_pr__res_generic_po W=0.5 L=40
XXX2_X2_R9 x2_x2_net10 x2_x2_net11 sky130_fd_pr__res_generic_po W=0.5 L=40
XXX2_X2_R8 x2_x2_net10 x2_x2_net9 sky130_fd_pr__res_generic_po W=0.5 L=40
XXX2_X1_R8 x2_x1_net10 x2_x1_net9 sky130_fd_pr__res_generic_po W=0.5 L=40
XXX2_X1_R7 x2_x1_net8 x2_x1_net9 sky130_fd_pr__res_generic_po W=0.5 L=40
XXX2_X2_R7 x2_x2_net8 x2_x2_net9 sky130_fd_pr__res_generic_po W=0.5 L=40
XXX2_X2_R6 x2_x2_net8 x2_x2_net2 sky130_fd_pr__res_generic_po W=0.5 L=40
XXX2_X1_R6 x2_x1_net8 x2_x1_net2 sky130_fd_pr__res_generic_po W=0.5 L=40
XXX2_X1_R11 x2_x1_net12 x2_x1_net2 sky130_fd_pr__res_generic_po W=0.5 L=40
XXX2_X2_R11 x2_x2_net12 x2_x2_net2 sky130_fd_pr__res_generic_po W=0.5 L=40
XXX2_X2_R12 x2_x2_net12 x2_x2_net13 sky130_fd_pr__res_generic_po W=0.5 L=40
XXX2_X1_R12 x2_x1_net12 x2_x1_net13 sky130_fd_pr__res_generic_po W=0.5 L=40
XXX2_X1_R13 x2_x1_net14 x2_x1_net13 sky130_fd_pr__res_generic_po W=0.5 L=40
XXX2_X2_R13 x2_x2_net14 x2_x2_net13 sky130_fd_pr__res_generic_po W=0.5 L=40
XXX2_X2_R14 x2_x2_net14 x2_x2_net15 sky130_fd_pr__res_generic_po W=0.5 L=40
XXX2_X1_R14 x2_x1_net14 x2_x1_net15 sky130_fd_pr__res_generic_po W=0.5 L=40
XXX2_X1_R15 x2_x1_net3 x2_x1_net15 sky130_fd_pr__res_generic_po W=0.5 L=40
XXX2_X2_R15 x2_x2_net3 x2_x2_net15 sky130_fd_pr__res_generic_po W=0.5 L=40
XXX2_X2_R20 x2_x2_net3 x2_x2_net19 sky130_fd_pr__res_generic_po W=0.5 L=40
XXX2_X1_R20 x2_x1_net3 x2_x1_net19 sky130_fd_pr__res_generic_po W=0.5 L=40
XXX2_X1_R19 x2_x1_net18 x2_x1_net19 sky130_fd_pr__res_generic_po W=0.5 L=40
XXX2_X2_R19 x2_x2_net18 x2_x2_net19 sky130_fd_pr__res_generic_po W=0.5 L=40
XXX2_X2_R18 x2_x2_net18 x2_x2_net17 sky130_fd_pr__res_generic_po W=0.5 L=40
XXX2_X1_R18 x2_x1_net18 x2_x1_net17 sky130_fd_pr__res_generic_po W=0.5 L=40
XXX2_X1_R17 x2_x1_net16 x2_x1_net17 sky130_fd_pr__res_generic_po W=0.5 L=40
XXX2_X2_R17 x2_x2_net16 x2_x2_net17 sky130_fd_pr__res_generic_po W=0.5 L=40
XXX2_X2_R16 x2_x2_net16 Vom sky130_fd_pr__res_generic_po W=0.5 L=40
XXX2_X1_R16 x2_x1_net16 x2_Vcm sky130_fd_pr__res_generic_po W=0.5 L=40
Xres_packs_DUMMY1 Vss Vss sky130_fd_pr__res_generic_po W=0.5 L=40
.ends
