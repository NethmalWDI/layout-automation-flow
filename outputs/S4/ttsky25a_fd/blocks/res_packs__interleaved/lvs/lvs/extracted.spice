* NGSPICE file created from res_packs__interleaved.ext - technology: sky130A

.subckt sky130_fd_pr__res_generic_po_5GPU7X R2 R1
X0 R1 R2 sky130_fd_pr__res_generic_po w=0.5 l=40
.ends

.subckt res_generic_po_W0p5_L40 res_generic_po_W0p5_L40_pc/R2 res_generic_po_W0p5_L40_pc/R1
Xres_generic_po_W0p5_L40_pc res_generic_po_W0p5_L40_pc/R2 res_generic_po_W0p5_L40_pc/R1
+ sky130_fd_pr__res_generic_po_5GPU7X
.ends

.subckt res_packs__interleaved Vss x2_x1_net4 x2_x2_net4 x2_x1_net6 x2_x2_net6 x2_x1_net1
+ x2_x2_net1 x2_x1_net10 x2_x2_net10 x2_x1_net8 x2_x2_net8 x2_x1_net12 x2_x2_net12
+ x2_x1_net14 x2_x2_net14 x2_x1_net3 x2_x2_net3 x2_x1_net18 x2_x2_net18 x2_x1_net16
+ x2_x2_net16 Vop x2_Vcm x2_x2_net5 x2_x1_net5 x2_x2_net7 x2_x1_net7 x2_x2_net11 x2_x1_net11
+ x2_x2_net9 x2_x1_net9 x2_x2_net2 x2_x1_net2 x2_x2_net13 x2_x1_net13 x2_x2_net15
+ x2_x1_net15 x2_x2_net19 x2_x1_net19 x2_x2_net17 x2_x1_net17 Vom Vss_body
Xres_generic_po_W0p5_L40_6 x2_x2_net5 x2_x2_net6 res_generic_po_W0p5_L40
Xres_generic_po_W0p5_L40_7 x2_x2_net7 x2_x2_net6 res_generic_po_W0p5_L40
Xres_generic_po_W0p5_L40_9 x2_x1_net7 x2_x1_net1 res_generic_po_W0p5_L40
Xres_generic_po_W0p5_L40_8 x2_x1_net7 x2_x1_net6 res_generic_po_W0p5_L40
Xres_generic_po_W0p5_L40_40 x2_Vcm x2_x1_net16 res_generic_po_W0p5_L40
Xres_generic_po_W0p5_L40_41 Vss Vss res_generic_po_W0p5_L40
Xres_generic_po_W0p5_L40_30 x2_x2_net15 x2_x2_net3 res_generic_po_W0p5_L40
Xres_generic_po_W0p5_L40_31 x2_x2_net19 x2_x2_net3 res_generic_po_W0p5_L40
Xres_generic_po_W0p5_L40_20 x2_x1_net2 x2_x1_net8 res_generic_po_W0p5_L40
Xres_generic_po_W0p5_L40_32 x2_x1_net19 x2_x1_net3 res_generic_po_W0p5_L40
Xres_generic_po_W0p5_L40_21 x2_x1_net2 x2_x1_net12 res_generic_po_W0p5_L40
Xres_generic_po_W0p5_L40_10 x2_x2_net7 x2_x2_net1 res_generic_po_W0p5_L40
Xres_generic_po_W0p5_L40_33 x2_x1_net19 x2_x1_net18 res_generic_po_W0p5_L40
Xres_generic_po_W0p5_L40_22 x2_x2_net2 x2_x2_net12 res_generic_po_W0p5_L40
Xres_generic_po_W0p5_L40_11 x2_x2_net11 x2_x2_net1 res_generic_po_W0p5_L40
Xres_generic_po_W0p5_L40_34 x2_x2_net19 x2_x2_net18 res_generic_po_W0p5_L40
Xres_generic_po_W0p5_L40_23 x2_x2_net13 x2_x2_net12 res_generic_po_W0p5_L40
Xres_generic_po_W0p5_L40_12 x2_x1_net11 x2_x1_net1 res_generic_po_W0p5_L40
Xres_generic_po_W0p5_L40_35 x2_x2_net17 x2_x2_net18 res_generic_po_W0p5_L40
Xres_generic_po_W0p5_L40_24 x2_x1_net13 x2_x1_net12 res_generic_po_W0p5_L40
Xres_generic_po_W0p5_L40_13 x2_x1_net11 x2_x1_net10 res_generic_po_W0p5_L40
Xres_generic_po_W0p5_L40_36 x2_x1_net17 x2_x1_net18 res_generic_po_W0p5_L40
Xres_generic_po_W0p5_L40_25 x2_x1_net13 x2_x1_net14 res_generic_po_W0p5_L40
Xres_generic_po_W0p5_L40_14 x2_x2_net11 x2_x2_net10 res_generic_po_W0p5_L40
Xres_generic_po_W0p5_L40_38 x2_x2_net17 x2_x2_net16 res_generic_po_W0p5_L40
Xres_generic_po_W0p5_L40_37 x2_x1_net17 x2_x1_net16 res_generic_po_W0p5_L40
Xres_generic_po_W0p5_L40_27 x2_x2_net15 x2_x2_net14 res_generic_po_W0p5_L40
Xres_generic_po_W0p5_L40_26 x2_x2_net13 x2_x2_net14 res_generic_po_W0p5_L40
Xres_generic_po_W0p5_L40_16 x2_x1_net9 x2_x1_net10 res_generic_po_W0p5_L40
Xres_generic_po_W0p5_L40_15 x2_x2_net9 x2_x2_net10 res_generic_po_W0p5_L40
Xres_generic_po_W0p5_L40_39 Vom x2_x2_net16 res_generic_po_W0p5_L40
Xres_generic_po_W0p5_L40_28 x2_x1_net15 x2_x1_net14 res_generic_po_W0p5_L40
Xres_generic_po_W0p5_L40_17 x2_x1_net9 x2_x1_net8 res_generic_po_W0p5_L40
Xres_generic_po_W0p5_L40_29 x2_x1_net15 x2_x1_net3 res_generic_po_W0p5_L40
Xres_generic_po_W0p5_L40_18 x2_x2_net9 x2_x2_net8 res_generic_po_W0p5_L40
Xres_generic_po_W0p5_L40_19 x2_x2_net2 x2_x2_net8 res_generic_po_W0p5_L40
Xres_generic_po_W0p5_L40_0 Vss Vss res_generic_po_W0p5_L40
Xres_generic_po_W0p5_L40_1 Vop x2_x1_net4 res_generic_po_W0p5_L40
Xres_generic_po_W0p5_L40_2 x2_Vcm x2_x2_net4 res_generic_po_W0p5_L40
Xres_generic_po_W0p5_L40_3 x2_x2_net5 x2_x2_net4 res_generic_po_W0p5_L40
Xres_generic_po_W0p5_L40_4 x2_x1_net5 x2_x1_net4 res_generic_po_W0p5_L40
Xres_generic_po_W0p5_L40_5 x2_x1_net5 x2_x1_net6 res_generic_po_W0p5_L40
.ends
