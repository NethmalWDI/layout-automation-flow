.subckt pmos_differential_pair__ABBA Vdd Vref x2_Vcm x2_Vout x2_Vtest x2_net1 Vdd_body
XXX2_M7 x2_Vtest x2_Vcm x2_net1 Vdd_body sky130_fd_pr__pfet_01v8_lvt L=10 W=1 nf=1 m=2
XXX2_M8 x2_Vout Vref x2_net1 Vdd_body sky130_fd_pr__pfet_01v8_lvt L=10 W=1 nf=1 m=2
Xpmos_differential_pair_DUMMY0 Vdd Vdd Vdd Vdd_body sky130_fd_pr__pfet_01v8_lvt L=10 W=1 nf=1
Xpmos_differential_pair_DUMMY1 Vdd Vdd Vdd Vdd_body sky130_fd_pr__pfet_01v8_lvt L=10 W=1 nf=1
.ends
