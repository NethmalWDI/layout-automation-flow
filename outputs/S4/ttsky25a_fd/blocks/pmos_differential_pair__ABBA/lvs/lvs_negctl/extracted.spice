* NGSPICE file created from pmos_differential_pair__ABBA.ext - technology: sky130A

.subckt sky130_fd_pr__pfet_01v8_lvt_5FXXCR G D w_n1094_n200# S
X0 S G D w_n1094_n200# sky130_fd_pr__pfet_01v8_lvt ad=0.29 pd=2.58 as=0.29 ps=2.58 w=1 l=10
.ends

.subckt pfet_01v8_lvt_W1_L10_m2__nf1_gboth_sdfull_ng S G D B
Xpfet_01v8_lvt_W1_L10_m2__nf1_gboth_sdfull_ng_pc G D B S sky130_fd_pr__pfet_01v8_lvt_5FXXCR
.ends

.subckt pmos_differential_pair__ABBA Vdd x2_Vcm Vref x2_Vtest x2_net1 x2_Vout Vdd_body
Xpfet_01v8_lvt_W1_L10_m2__nf1_gboth_sdfull_ng_0 Vdd Vdd Vdd Vdd_body pfet_01v8_lvt_W1_L10_m2__nf1_gboth_sdfull_ng
Xpfet_01v8_lvt_W1_L10_m2__nf1_gboth_sdfull_ng_1 x2_net1 x2_Vcm x2_Vtest Vdd_body pfet_01v8_lvt_W1_L10_m2__nf1_gboth_sdfull_ng
Xpfet_01v8_lvt_W1_L10_m2__nf1_gboth_sdfull_ng_2 x2_net1 Vref x2_Vout Vdd_body pfet_01v8_lvt_W1_L10_m2__nf1_gboth_sdfull_ng
Xpfet_01v8_lvt_W1_L10_m2__nf1_gboth_sdfull_ng_3 x2_net1 Vref x2_Vout Vdd_body pfet_01v8_lvt_W1_L10_m2__nf1_gboth_sdfull_ng
Xpfet_01v8_lvt_W1_L10_m2__nf1_gboth_sdfull_ng_4 x2_net1 x2_Vcm x2_Vtest Vdd_body pfet_01v8_lvt_W1_L10_m2__nf1_gboth_sdfull_ng
Xpfet_01v8_lvt_W1_L10_m2__nf1_gboth_sdfull_ng_5 Vdd Vdd Vdd Vdd_body pfet_01v8_lvt_W1_L10_m2__nf1_gboth_sdfull_ng
.ends
