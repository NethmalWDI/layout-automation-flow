* NGSPICE file created from nmos_differential_pair_2__ABAB.ext - technology: sky130A

.subckt sky130_fd_pr__nfet_01v8_lvt_KUHQTA G D S VSUBS
X0 S G D VSUBS sky130_fd_pr__nfet_01v8_lvt ad=1.45 pd=10.58 as=1.45 ps=10.58 w=5 l=20
.ends

.subckt nfet_01v8_lvt_W5_L20_m2__nf1_gboth_sdfull_ng B S G D
Xnfet_01v8_lvt_W5_L20_m2__nf1_gboth_sdfull_ng_pc G D S B sky130_fd_pr__nfet_01v8_lvt_KUHQTA
.ends

.subckt nmos_differential_pair_2__ABAB Vss Vom1 Vref x1_net9 x1_net7 x1_Vout Vss_body
Xnfet_01v8_lvt_W5_L20_m2__nf1_gboth_sdfull_ng_0 Vss_body Vss Vss Vss nfet_01v8_lvt_W5_L20_m2__nf1_gboth_sdfull_ng
Xnfet_01v8_lvt_W5_L20_m2__nf1_gboth_sdfull_ng_1 Vss_body x1_net7 Vom1 x1_net9 nfet_01v8_lvt_W5_L20_m2__nf1_gboth_sdfull_ng
Xnfet_01v8_lvt_W5_L20_m2__nf1_gboth_sdfull_ng_3 Vss_body x1_net7 Vom1 x1_net9 nfet_01v8_lvt_W5_L20_m2__nf1_gboth_sdfull_ng
Xnfet_01v8_lvt_W5_L20_m2__nf1_gboth_sdfull_ng_2 Vss_body x1_net7 Vref x1_Vout nfet_01v8_lvt_W5_L20_m2__nf1_gboth_sdfull_ng
Xnfet_01v8_lvt_W5_L20_m2__nf1_gboth_sdfull_ng_4 Vss_body x1_net7 Vref x1_Vout nfet_01v8_lvt_W5_L20_m2__nf1_gboth_sdfull_ng
Xnfet_01v8_lvt_W5_L20_m2__nf1_gboth_sdfull_ng_5 Vss_body Vss Vss Vss nfet_01v8_lvt_W5_L20_m2__nf1_gboth_sdfull_ng
.ends
