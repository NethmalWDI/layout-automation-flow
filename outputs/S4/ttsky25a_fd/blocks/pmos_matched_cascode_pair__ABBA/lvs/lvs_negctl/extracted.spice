* NGSPICE file created from pmos_matched_cascode_pair__ABBA.ext - technology: sky130A

.subckt sky130_fd_pr__pfet_01v8_lvt_26VEAH G D0 w_n1123_n200# a_1029_n100# S1
X0 a_1029_n100# G S1 w_n1123_n200# sky130_fd_pr__pfet_01v8_lvt ad=0.29 pd=2.58 as=0.145 ps=1.29 w=1 l=5
X1 S1 G D0 w_n1123_n200# sky130_fd_pr__pfet_01v8_lvt ad=0.145 pd=1.29 as=0.29 ps=2.58 w=1 l=5
.ends

.subckt pfet_01v8_lvt_W2_L5_m2__nf2_gboth_sdfull_outS_ng B D G S
Xpfet_01v8_lvt_W2_L5_m2__nf2_gboth_sdfull_outS_ng_pc G S B S D sky130_fd_pr__pfet_01v8_lvt_26VEAH
.ends

.subckt pmos_matched_cascode_pair__ABBA Vdd x1_Vtest2 x1_Vbias x1_net1 Vop1 Vom1 Vdd_body
Xpfet_01v8_lvt_W2_L5_m2__nf2_gboth_sdfull_outS_ng_0 Vdd_body Vdd Vdd Vdd pfet_01v8_lvt_W2_L5_m2__nf2_gboth_sdfull_outS_ng
Xpfet_01v8_lvt_W2_L5_m2__nf2_gboth_sdfull_outS_ng_2 Vdd_body Vom1 x1_Vbias x1_net1
+ pfet_01v8_lvt_W2_L5_m2__nf2_gboth_sdfull_outS_ng
Xpfet_01v8_lvt_W2_L5_m2__nf2_gboth_sdfull_outS_ng_1 Vdd_body Vop1 x1_Vbias x1_Vtest2
+ pfet_01v8_lvt_W2_L5_m2__nf2_gboth_sdfull_outS_ng
Xpfet_01v8_lvt_W2_L5_m2__nf2_gboth_sdfull_outS_ng_3 Vdd_body Vom1 x1_Vbias x1_net1
+ pfet_01v8_lvt_W2_L5_m2__nf2_gboth_sdfull_outS_ng
Xpfet_01v8_lvt_W2_L5_m2__nf2_gboth_sdfull_outS_ng_4 Vdd_body Vop1 x1_Vbias x1_Vtest2
+ pfet_01v8_lvt_W2_L5_m2__nf2_gboth_sdfull_outS_ng
Xpfet_01v8_lvt_W2_L5_m2__nf2_gboth_sdfull_outS_ng_5 Vdd_body Vdd Vdd Vdd pfet_01v8_lvt_W2_L5_m2__nf2_gboth_sdfull_outS_ng
.ends
