.subckt pmos_matched_cascode_pair__ABBA Vdd Vom1 Vop1 x1_Vbias x1_Vtest2 x1_net1 Vdd_body
XXX1_M11 Vop1 x1_Vbias x1_Vtest2 Vdd_body sky130_fd_pr__pfet_01v8_lvt L=5.5 W=2 nf=2 m=2
XXX1_M12 Vom1 x1_Vbias x1_net1 Vdd_body sky130_fd_pr__pfet_01v8_lvt L=5 W=2 nf=2 m=2
Xpmos_matched_cascode_pair_DUMMY0 Vdd Vdd Vdd Vdd_body sky130_fd_pr__pfet_01v8_lvt L=5 W=2 nf=2
Xpmos_matched_cascode_pair_DUMMY1 Vdd Vdd Vdd Vdd_body sky130_fd_pr__pfet_01v8_lvt L=5 W=2 nf=2
.ends
