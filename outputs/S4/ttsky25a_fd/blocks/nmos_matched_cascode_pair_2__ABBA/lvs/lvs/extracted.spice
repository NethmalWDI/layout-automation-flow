* NGSPICE file created from nmos_matched_cascode_pair_2__ABBA.ext - technology: sky130A

.subckt sky130_fd_pr__nfet_01v8_lvt_YU23CF G D S VSUBS
X0 S G D VSUBS sky130_fd_pr__nfet_01v8_lvt ad=0.29 pd=2.58 as=0.29 ps=2.58 w=1 l=1
.ends

.subckt nfet_01v8_lvt_W1_L1_m2__nf1_gboth_sdfull_ng D B S G
Xnfet_01v8_lvt_W1_L1_m2__nf1_gboth_sdfull_ng_pc G D S B sky130_fd_pr__nfet_01v8_lvt_YU23CF
.ends

.subckt nmos_matched_cascode_pair_2__ABBA Vss net5 x1_net2 x1_net4 Vom1 x1_net6 Vss_body
Xnfet_01v8_lvt_W1_L1_m2__nf1_gboth_sdfull_ng_1 x1_net2 Vss_body x1_net4 net5 nfet_01v8_lvt_W1_L1_m2__nf1_gboth_sdfull_ng
Xnfet_01v8_lvt_W1_L1_m2__nf1_gboth_sdfull_ng_0 Vss Vss_body Vss Vss nfet_01v8_lvt_W1_L1_m2__nf1_gboth_sdfull_ng
Xnfet_01v8_lvt_W1_L1_m2__nf1_gboth_sdfull_ng_2 Vom1 Vss_body x1_net6 net5 nfet_01v8_lvt_W1_L1_m2__nf1_gboth_sdfull_ng
Xnfet_01v8_lvt_W1_L1_m2__nf1_gboth_sdfull_ng_3 Vom1 Vss_body x1_net6 net5 nfet_01v8_lvt_W1_L1_m2__nf1_gboth_sdfull_ng
Xnfet_01v8_lvt_W1_L1_m2__nf1_gboth_sdfull_ng_4 x1_net2 Vss_body x1_net4 net5 nfet_01v8_lvt_W1_L1_m2__nf1_gboth_sdfull_ng
Xnfet_01v8_lvt_W1_L1_m2__nf1_gboth_sdfull_ng_5 Vss Vss_body Vss Vss nfet_01v8_lvt_W1_L1_m2__nf1_gboth_sdfull_ng
.ends
