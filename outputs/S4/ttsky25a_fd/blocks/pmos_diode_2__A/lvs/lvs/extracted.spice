* NGSPICE file created from pmos_diode_2__A.ext - technology: sky130A

.subckt sky130_fd_pr__pfet_01v8_lvt_BJW7CL G D S w_n1094_n250#
X0 S G D w_n1094_n250# sky130_fd_pr__pfet_01v8_lvt ad=0.435 pd=3.58 as=0.435 ps=3.58 w=1.5 l=10
.ends

.subckt pfet_01v8_lvt_W1p5_L10_m2__nf1_gboth_sdfull_ng G D S B
Xpfet_01v8_lvt_W1p5_L10_m2__nf1_gboth_sdfull_ng_pc G D S B sky130_fd_pr__pfet_01v8_lvt_BJW7CL
.ends

.subckt pmos_diode_2__A x1_Vbias Vdd Vdd_body
Xpfet_01v8_lvt_W1p5_L10_m2__nf1_gboth_sdfull_ng_0 x1_Vbias x1_Vbias Vdd Vdd_body pfet_01v8_lvt_W1p5_L10_m2__nf1_gboth_sdfull_ng
Xpfet_01v8_lvt_W1p5_L10_m2__nf1_gboth_sdfull_ng_1 x1_Vbias x1_Vbias Vdd Vdd_body pfet_01v8_lvt_W1p5_L10_m2__nf1_gboth_sdfull_ng
.ends
