.subckt pmos_diode_2__A Vdd x1_Vbias Vdd_body
XXX1_M25 x1_Vbias x1_Vbias Vdd Vdd_body sky130_fd_pr__pfet_01v8_lvt L=11 W=1.5 nf=1 m=2
.ends
