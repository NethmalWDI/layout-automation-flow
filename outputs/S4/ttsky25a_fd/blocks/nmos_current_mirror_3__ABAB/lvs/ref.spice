.subckt nmos_current_mirror_3__ABAB Vss net7 x2_Vbiasp Vss_body
XXX2_M10 net7 net7 Vss Vss_body sky130_fd_pr__nfet_01v8_lvt L=1 W=0.6 nf=1 m=2
XXX2_M11 x2_Vbiasp net7 Vss Vss_body sky130_fd_pr__nfet_01v8_lvt L=1 W=0.6 nf=1 m=2
Xnmos_current_mirror_3_DUMMY0 Vss Vss Vss Vss_body sky130_fd_pr__nfet_01v8_lvt L=1 W=0.6 nf=1
Xnmos_current_mirror_3_DUMMY1 Vss Vss Vss Vss_body sky130_fd_pr__nfet_01v8_lvt L=1 W=0.6 nf=1
.ends
