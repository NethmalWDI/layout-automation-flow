.subckt pmos_current_mirror_load__ABBA Vdd x1_Vout x1_net9 Vdd_body
XXX1_M20 x1_net9 x1_net9 Vdd Vdd_body sky130_fd_pr__pfet_01v8_lvt L=10 W=1 nf=1 m=2
XXX1_M21 x1_Vout x1_net9 Vdd Vdd_body sky130_fd_pr__pfet_01v8_lvt L=10 W=1 nf=1 m=2
Xpmos_current_mirror_load_DUMMY0 Vdd Vdd Vdd Vdd_body sky130_fd_pr__pfet_01v8_lvt L=10 W=1 nf=1
Xpmos_current_mirror_load_DUMMY1 Vdd Vdd Vdd Vdd_body sky130_fd_pr__pfet_01v8_lvt L=10 W=1 nf=1
.ends
