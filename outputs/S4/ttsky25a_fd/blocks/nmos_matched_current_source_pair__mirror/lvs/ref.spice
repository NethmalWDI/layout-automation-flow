.subckt nmos_matched_current_source_pair__mirror Vom Vop Vss x2_Vout Vss_body
XXX2_M2 Vop x2_Vout Vss Vss_body sky130_fd_pr__nfet_01v8_lvt L=1 W=1 nf=1 m=9
XXX2_M1 Vom x2_Vout Vss Vss_body sky130_fd_pr__nfet_01v8_lvt L=1 W=1 nf=1 m=9
Xnmos_matched_current_source_pair_DUMMY0 Vss Vss Vss Vss_body sky130_fd_pr__nfet_01v8_lvt L=1 W=1 nf=1
Xnmos_matched_current_source_pair_DUMMY1 Vss Vss Vss Vss_body sky130_fd_pr__nfet_01v8_lvt L=1 W=1 nf=1
.ends
