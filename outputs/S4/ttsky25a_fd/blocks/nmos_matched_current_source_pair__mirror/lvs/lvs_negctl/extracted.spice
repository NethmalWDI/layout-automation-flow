* NGSPICE file created from nmos_matched_current_source_pair__mirror.ext - technology: sky130A

.subckt sky130_fd_pr__nfet_01v8_lvt_YU23CF G D S VSUBS
X0 S G D VSUBS sky130_fd_pr__nfet_01v8_lvt ad=0.29 pd=2.58 as=0.29 ps=2.58 w=1 l=1
.ends

.subckt nfet_01v8_lvt_W1_L1_m9__nf1_gboth_sdfull_ng G D B S
Xnfet_01v8_lvt_W1_L1_m9__nf1_gboth_sdfull_ng_pc G D S B sky130_fd_pr__nfet_01v8_lvt_YU23CF
.ends

.subckt nmos_matched_current_source_pair__mirror Vss x2_Vout Vop Vom Vss_body
Xnfet_01v8_lvt_W1_L1_m9__nf1_gboth_sdfull_ng_0 Vss Vss Vss_body Vss nfet_01v8_lvt_W1_L1_m9__nf1_gboth_sdfull_ng
Xnfet_01v8_lvt_W1_L1_m9__nf1_gboth_sdfull_ng_2 x2_Vout Vom Vss_body Vss nfet_01v8_lvt_W1_L1_m9__nf1_gboth_sdfull_ng
Xnfet_01v8_lvt_W1_L1_m9__nf1_gboth_sdfull_ng_1 x2_Vout Vop Vss_body Vss nfet_01v8_lvt_W1_L1_m9__nf1_gboth_sdfull_ng
Xnfet_01v8_lvt_W1_L1_m9__nf1_gboth_sdfull_ng_10 x2_Vout Vom Vss_body Vss nfet_01v8_lvt_W1_L1_m9__nf1_gboth_sdfull_ng
Xnfet_01v8_lvt_W1_L1_m9__nf1_gboth_sdfull_ng_3 x2_Vout Vop Vss_body Vss nfet_01v8_lvt_W1_L1_m9__nf1_gboth_sdfull_ng
Xnfet_01v8_lvt_W1_L1_m9__nf1_gboth_sdfull_ng_11 x2_Vout Vop Vss_body Vss nfet_01v8_lvt_W1_L1_m9__nf1_gboth_sdfull_ng
Xnfet_01v8_lvt_W1_L1_m9__nf1_gboth_sdfull_ng_4 x2_Vout Vom Vss_body Vss nfet_01v8_lvt_W1_L1_m9__nf1_gboth_sdfull_ng
Xnfet_01v8_lvt_W1_L1_m9__nf1_gboth_sdfull_ng_12 x2_Vout Vom Vss_body Vss nfet_01v8_lvt_W1_L1_m9__nf1_gboth_sdfull_ng
Xnfet_01v8_lvt_W1_L1_m9__nf1_gboth_sdfull_ng_5 x2_Vout Vop Vss_body Vss nfet_01v8_lvt_W1_L1_m9__nf1_gboth_sdfull_ng
Xnfet_01v8_lvt_W1_L1_m9__nf1_gboth_sdfull_ng_13 x2_Vout Vop Vss_body Vss nfet_01v8_lvt_W1_L1_m9__nf1_gboth_sdfull_ng
Xnfet_01v8_lvt_W1_L1_m9__nf1_gboth_sdfull_ng_6 x2_Vout Vom Vss_body Vss nfet_01v8_lvt_W1_L1_m9__nf1_gboth_sdfull_ng
Xnfet_01v8_lvt_W1_L1_m9__nf1_gboth_sdfull_ng_14 x2_Vout Vom Vss_body Vss nfet_01v8_lvt_W1_L1_m9__nf1_gboth_sdfull_ng
Xnfet_01v8_lvt_W1_L1_m9__nf1_gboth_sdfull_ng_7 x2_Vout Vop Vss_body Vss nfet_01v8_lvt_W1_L1_m9__nf1_gboth_sdfull_ng
Xnfet_01v8_lvt_W1_L1_m9__nf1_gboth_sdfull_ng_15 x2_Vout Vop Vss_body Vss nfet_01v8_lvt_W1_L1_m9__nf1_gboth_sdfull_ng
Xnfet_01v8_lvt_W1_L1_m9__nf1_gboth_sdfull_ng_8 x2_Vout Vom Vss_body Vss nfet_01v8_lvt_W1_L1_m9__nf1_gboth_sdfull_ng
Xnfet_01v8_lvt_W1_L1_m9__nf1_gboth_sdfull_ng_17 x2_Vout Vop Vss_body Vss nfet_01v8_lvt_W1_L1_m9__nf1_gboth_sdfull_ng
Xnfet_01v8_lvt_W1_L1_m9__nf1_gboth_sdfull_ng_16 x2_Vout Vom Vss_body Vss nfet_01v8_lvt_W1_L1_m9__nf1_gboth_sdfull_ng
Xnfet_01v8_lvt_W1_L1_m9__nf1_gboth_sdfull_ng_9 x2_Vout Vop Vss_body Vss nfet_01v8_lvt_W1_L1_m9__nf1_gboth_sdfull_ng
Xnfet_01v8_lvt_W1_L1_m9__nf1_gboth_sdfull_ng_18 x2_Vout Vom Vss_body Vss nfet_01v8_lvt_W1_L1_m9__nf1_gboth_sdfull_ng
Xnfet_01v8_lvt_W1_L1_m9__nf1_gboth_sdfull_ng_19 Vss Vss Vss_body Vss nfet_01v8_lvt_W1_L1_m9__nf1_gboth_sdfull_ng
.ends
