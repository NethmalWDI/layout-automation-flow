* NGSPICE file created from XC2__A.ext - technology: sky130A

.subckt sky130_fd_pr__cap_mim_m3_1_DHLNXX C1_4 C1_3 C1_2 C1_1 C1_0 C2_4 C2_3 C2_2
+ C2_1 C2_0
X0 C1_0 C2_0 sky130_fd_pr__cap_mim_m3_1 l=10 w=10
X1 C1_2 C2_2 sky130_fd_pr__cap_mim_m3_1 l=10 w=10
X2 C1_3 C2_3 sky130_fd_pr__cap_mim_m3_1 l=10 w=10
X3 C1_1 C2_1 sky130_fd_pr__cap_mim_m3_1 l=10 w=10
X4 C1_4 C2_4 sky130_fd_pr__cap_mim_m3_1 l=10 w=10
.ends

.subckt XC2_mim XC2_mim_pc/C2_4 XC2_mim_pc/C2_3 XC2_mim_pc/C2_2 XC2_mim_pc/C2_1 XC2_mim_pc/C2_0
+ XC2_mim_pc/C1_4 XC2_mim_pc/C1_3 XC2_mim_pc/C1_2 XC2_mim_pc/C1_1 XC2_mim_pc/C1_0
XXC2_mim_pc XC2_mim_pc/C1_4 XC2_mim_pc/C1_3 XC2_mim_pc/C1_2 XC2_mim_pc/C1_1 XC2_mim_pc/C1_0
+ XC2_mim_pc/C2_4 XC2_mim_pc/C2_3 XC2_mim_pc/C2_2 XC2_mim_pc/C2_1 XC2_mim_pc/C2_0
+ sky130_fd_pr__cap_mim_m3_1_DHLNXX
.ends

.subckt XC2__A Vom1 Vop
XXC2_mim_0 Vop Vop Vop Vop Vop Vom1 Vom1 Vom1 Vom1 Vom1 XC2_mim
.ends
