.subckt XC2__A Vom1 Vop
XC2 Vom1 Vop sky130_fd_pr__cap_mim_m3_1 W=10 L=11 m=5
.ends
