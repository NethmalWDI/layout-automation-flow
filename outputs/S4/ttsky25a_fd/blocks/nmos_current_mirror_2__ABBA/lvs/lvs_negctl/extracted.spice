* NGSPICE file created from nmos_current_mirror_2__ABBA.ext - technology: sky130A

.subckt sky130_fd_pr__nfet_01v8_lvt_MHCJX9 G D S VSUBS
X0 S G D VSUBS sky130_fd_pr__nfet_01v8_lvt ad=0.174 pd=1.78 as=0.174 ps=1.78 w=0.6 l=1
.ends

.subckt nfet_01v8_lvt_W0p6_L1_m2__nf1_gtop_sdfull_ng B G D S
Xnfet_01v8_lvt_W0p6_L1_m2__nf1_gtop_sdfull_ng_pc G D S B sky130_fd_pr__nfet_01v8_lvt_MHCJX9
.ends

.subckt nmos_current_mirror_2__ABBA Vss net6 x1_Vbias Vss_body
Xnfet_01v8_lvt_W0p6_L1_m2__nf1_gtop_sdfull_ng_1 Vss_body net6 net6 Vss nfet_01v8_lvt_W0p6_L1_m2__nf1_gtop_sdfull_ng
Xnfet_01v8_lvt_W0p6_L1_m2__nf1_gtop_sdfull_ng_0 Vss_body Vss Vss Vss nfet_01v8_lvt_W0p6_L1_m2__nf1_gtop_sdfull_ng
Xnfet_01v8_lvt_W0p6_L1_m2__nf1_gtop_sdfull_ng_2 Vss_body net6 x1_Vbias Vss nfet_01v8_lvt_W0p6_L1_m2__nf1_gtop_sdfull_ng
Xnfet_01v8_lvt_W0p6_L1_m2__nf1_gtop_sdfull_ng_3 Vss_body net6 x1_Vbias Vss nfet_01v8_lvt_W0p6_L1_m2__nf1_gtop_sdfull_ng
Xnfet_01v8_lvt_W0p6_L1_m2__nf1_gtop_sdfull_ng_4 Vss_body net6 net6 Vss nfet_01v8_lvt_W0p6_L1_m2__nf1_gtop_sdfull_ng
Xnfet_01v8_lvt_W0p6_L1_m2__nf1_gtop_sdfull_ng_5 Vss_body Vss Vss Vss nfet_01v8_lvt_W0p6_L1_m2__nf1_gtop_sdfull_ng
.ends
