.subckt nmos_diode__A Rgm net1 Vss_body
XXM35 net1 net1 Rgm Vss_body sky130_fd_pr__nfet_01v8_lvt L=1.1 W=10 nf=1 m=2
.ends
