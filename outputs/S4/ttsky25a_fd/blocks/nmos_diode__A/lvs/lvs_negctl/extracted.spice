* NGSPICE file created from nmos_diode__A.ext - technology: sky130A

.subckt sky130_fd_pr__nfet_01v8_lvt_788GJP G D S VSUBS
X0 S G D VSUBS sky130_fd_pr__nfet_01v8_lvt ad=2.9 pd=20.58 as=2.9 ps=20.58 w=10 l=1
.ends

.subckt nfet_01v8_lvt_W10_L1_m2__nf1_gtop_sdfull_ng B S G D
Xnfet_01v8_lvt_W10_L1_m2__nf1_gtop_sdfull_ng_pc G D S B sky130_fd_pr__nfet_01v8_lvt_788GJP
.ends

.subckt nmos_diode__A net1 Rgm Vss_body
Xnfet_01v8_lvt_W10_L1_m2__nf1_gtop_sdfull_ng_1 Vss_body Rgm net1 net1 nfet_01v8_lvt_W10_L1_m2__nf1_gtop_sdfull_ng
Xnfet_01v8_lvt_W10_L1_m2__nf1_gtop_sdfull_ng_0 Vss_body Rgm net1 net1 nfet_01v8_lvt_W10_L1_m2__nf1_gtop_sdfull_ng
.ends
