.subckt pmos_single_2__A Vdd Vom1 Vop Vdd_body
XXX2_M9 Vop Vom1 Vdd Vdd_body sky130_fd_pr__pfet_01v8_lvt L=1 W=2 nf=2 m=9
.ends
