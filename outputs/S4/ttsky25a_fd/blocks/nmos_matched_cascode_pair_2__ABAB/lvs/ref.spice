.subckt nmos_matched_cascode_pair_2__ABAB Vom1 Vss net5 x1_net2 x1_net4 x1_net6 Vss_body
XXX1_M3 x1_net2 net5 x1_net4 Vss_body sky130_fd_pr__nfet_01v8_lvt L=1 W=1 nf=1 m=2
XXX1_M8 Vom1 net5 x1_net6 Vss_body sky130_fd_pr__nfet_01v8_lvt L=1 W=1 nf=1 m=2
Xnmos_matched_cascode_pair_2_DUMMY0 Vss Vss Vss Vss_body sky130_fd_pr__nfet_01v8_lvt L=1 W=1 nf=1
Xnmos_matched_cascode_pair_2_DUMMY1 Vss Vss Vss Vss_body sky130_fd_pr__nfet_01v8_lvt L=1 W=1 nf=1
.ends
