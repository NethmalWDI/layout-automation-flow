.subckt pmos_matched_current_source_pair__ABBA NBias PBias Vdd net1 Vdd_body
XXM32 NBias PBias Vdd Vdd_body sky130_fd_pr__pfet_01v8_lvt L=1.1 W=5 nf=1 m=2
XXM34 net1 PBias Vdd Vdd_body sky130_fd_pr__pfet_01v8_lvt L=1 W=5 nf=1 m=2
Xpmos_matched_current_source_pair_DUMMY0 Vdd Vdd Vdd Vdd_body sky130_fd_pr__pfet_01v8_lvt L=1 W=5 nf=1
Xpmos_matched_current_source_pair_DUMMY1 Vdd Vdd Vdd Vdd_body sky130_fd_pr__pfet_01v8_lvt L=1 W=5 nf=1
.ends
