.subckt pmos_matched_current_source_pair_2__ABBA PBias Vdd net4 net5 Vdd_body
XXM43 net4 PBias Vdd Vdd_body sky130_fd_pr__pfet_01v8_lvt L=1.1 W=5 nf=1 m=2
XXM44 net5 PBias Vdd Vdd_body sky130_fd_pr__pfet_01v8_lvt L=1 W=5 nf=1 m=2
Xpmos_matched_current_source_pair_2_DUMMY0 Vdd Vdd Vdd Vdd_body sky130_fd_pr__pfet_01v8_lvt L=1 W=5 nf=1
Xpmos_matched_current_source_pair_2_DUMMY1 Vdd Vdd Vdd Vdd_body sky130_fd_pr__pfet_01v8_lvt L=1 W=5 nf=1
.ends
