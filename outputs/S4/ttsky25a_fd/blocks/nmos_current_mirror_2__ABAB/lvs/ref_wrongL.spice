.subckt nmos_current_mirror_2__ABAB Vss net6 x1_Vbias Vss_body
XXX1_M23 net6 net6 Vss Vss_body sky130_fd_pr__nfet_01v8_lvt L=1.1 W=0.6 nf=1 m=2
XXX1_M24 x1_Vbias net6 Vss Vss_body sky130_fd_pr__nfet_01v8_lvt L=1 W=0.6 nf=1 m=2
Xnmos_current_mirror_2_DUMMY0 Vss Vss Vss Vss_body sky130_fd_pr__nfet_01v8_lvt L=1 W=0.6 nf=1
Xnmos_current_mirror_2_DUMMY1 Vss Vss Vss Vss_body sky130_fd_pr__nfet_01v8_lvt L=1 W=0.6 nf=1
.ends
