* NGSPICE file created from nmos_current_mirror_load__ABBA.ext - technology: sky130A

.subckt sky130_fd_pr__nfet_01v8_lvt_8GTBD2 G D S VSUBS
X0 S G D VSUBS sky130_fd_pr__nfet_01v8_lvt ad=0.145 pd=1.58 as=0.145 ps=1.58 w=0.5 l=20
.ends

.subckt nfet_01v8_lvt_W0p5_L20_m2__nf1_gboth_sdfull_ng B S G D
Xnfet_01v8_lvt_W0p5_L20_m2__nf1_gboth_sdfull_ng_pc G D S B sky130_fd_pr__nfet_01v8_lvt_8GTBD2
.ends

.subckt nmos_current_mirror_load__ABBA Vss x2_Vtest x2_Vout Vss_body
Xnfet_01v8_lvt_W0p5_L20_m2__nf1_gboth_sdfull_ng_0 Vss_body Vss Vss Vss nfet_01v8_lvt_W0p5_L20_m2__nf1_gboth_sdfull_ng
Xnfet_01v8_lvt_W0p5_L20_m2__nf1_gboth_sdfull_ng_1 Vss_body Vss x2_Vtest x2_Vtest nfet_01v8_lvt_W0p5_L20_m2__nf1_gboth_sdfull_ng
Xnfet_01v8_lvt_W0p5_L20_m2__nf1_gboth_sdfull_ng_2 Vss_body Vss x2_Vtest x2_Vout nfet_01v8_lvt_W0p5_L20_m2__nf1_gboth_sdfull_ng
Xnfet_01v8_lvt_W0p5_L20_m2__nf1_gboth_sdfull_ng_3 Vss_body Vss x2_Vtest x2_Vout nfet_01v8_lvt_W0p5_L20_m2__nf1_gboth_sdfull_ng
Xnfet_01v8_lvt_W0p5_L20_m2__nf1_gboth_sdfull_ng_4 Vss_body Vss x2_Vtest x2_Vtest nfet_01v8_lvt_W0p5_L20_m2__nf1_gboth_sdfull_ng
Xnfet_01v8_lvt_W0p5_L20_m2__nf1_gboth_sdfull_ng_5 Vss_body Vss Vss Vss nfet_01v8_lvt_W0p5_L20_m2__nf1_gboth_sdfull_ng
.ends
