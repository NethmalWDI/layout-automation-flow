.subckt nmos_current_mirror_load__ABBA Vss x2_Vout x2_Vtest Vss_body
XXX2_M5 x2_Vtest x2_Vtest Vss Vss_body sky130_fd_pr__nfet_01v8_lvt L=22 W=0.5 nf=1 m=2
XXX2_M6 x2_Vout x2_Vtest Vss Vss_body sky130_fd_pr__nfet_01v8_lvt L=20 W=0.5 nf=1 m=2
Xnmos_current_mirror_load_DUMMY0 Vss Vss Vss Vss_body sky130_fd_pr__nfet_01v8_lvt L=20 W=0.5 nf=1
Xnmos_current_mirror_load_DUMMY1 Vss Vss Vss Vss_body sky130_fd_pr__nfet_01v8_lvt L=20 W=0.5 nf=1
.ends
