.subckt input_pair__ABAB FirstStageYout1 FirstStageYsourceTransconductance in1 in2 outFirstStage FirstStageYsourceTransconductance_body
XXNormalTransistorPmos7 FirstStageYout1 in1 FirstStageYsourceTransconductance FirstStageYsourceTransconductance_body sky130_fd_pr__pfet_01v8_lvt L=0.99 W=14.21 nf=2
XXNormalTransistorPmos6 outFirstStage in2 FirstStageYsourceTransconductance FirstStageYsourceTransconductance_body sky130_fd_pr__pfet_01v8_lvt L=0.89 W=14.21 nf=2
.ends
