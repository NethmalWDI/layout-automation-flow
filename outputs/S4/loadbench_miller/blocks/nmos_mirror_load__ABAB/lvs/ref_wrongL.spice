.subckt nmos_mirror_load__ABAB FirstStageYout1 outFirstStage sourceNmos sourceNmos_body
XXDiodeTransistorNmos1 FirstStageYout1 FirstStageYout1 sourceNmos sourceNmos_body sky130_fd_pr__nfet_01v8_lvt L=2.233 W=66.13 nf=8
XXNormalTransistorNmos4 outFirstStage FirstStageYout1 sourceNmos sourceNmos_body sky130_fd_pr__nfet_01v8_lvt L=2.03 W=66.13 nf=8
.ends
