* NGSPICE file created from nmos_mirror_load__ABBA.ext - technology: sky130A

.subckt sky130_fd_pr__nfet_01v8_lvt_A8LSYS G D2 D0 S3 S1 a_899_n827# VSUBS
X0 a_899_n827# G S3 VSUBS sky130_fd_pr__nfet_01v8_lvt ad=2.3983 pd=17.12 as=1.19915 ps=8.56 w=8.27 l=2.03
X1 S3 G D2 VSUBS sky130_fd_pr__nfet_01v8_lvt ad=1.19915 pd=8.56 as=1.19915 ps=8.56 w=8.27 l=2.03
X2 D2 G S1 VSUBS sky130_fd_pr__nfet_01v8_lvt ad=1.19915 pd=8.56 as=1.19915 ps=8.56 w=8.27 l=2.03
X3 S1 G D0 VSUBS sky130_fd_pr__nfet_01v8_lvt ad=1.19915 pd=8.56 as=2.3983 ps=17.12 w=8.27 l=2.03
.ends

.subckt nfet_01v8_lvt_W33p065_L2p03_m1__nf4_gboth_sdfull_outS_ng G B S D
Xnfet_01v8_lvt_W33p065_L2p03_m1__nf4_gboth_sdfull_outS_ng_pc G S S D D S B sky130_fd_pr__nfet_01v8_lvt_A8LSYS
.ends

.subckt nmos_mirror_load__ABBA sourceNmos FirstStageYout1 outFirstStage sourceNmos_body
Xnfet_01v8_lvt_W33p065_L2p03_m1__nf4_gboth_sdfull_outS_ng_0 FirstStageYout1 sourceNmos_body
+ sourceNmos FirstStageYout1 nfet_01v8_lvt_W33p065_L2p03_m1__nf4_gboth_sdfull_outS_ng
Xnfet_01v8_lvt_W33p065_L2p03_m1__nf4_gboth_sdfull_outS_ng_1 FirstStageYout1 sourceNmos_body
+ sourceNmos outFirstStage nfet_01v8_lvt_W33p065_L2p03_m1__nf4_gboth_sdfull_outS_ng
Xnfet_01v8_lvt_W33p065_L2p03_m1__nf4_gboth_sdfull_outS_ng_3 FirstStageYout1 sourceNmos_body
+ sourceNmos FirstStageYout1 nfet_01v8_lvt_W33p065_L2p03_m1__nf4_gboth_sdfull_outS_ng
Xnfet_01v8_lvt_W33p065_L2p03_m1__nf4_gboth_sdfull_outS_ng_2 FirstStageYout1 sourceNmos_body
+ sourceNmos outFirstStage nfet_01v8_lvt_W33p065_L2p03_m1__nf4_gboth_sdfull_outS_ng
.ends
