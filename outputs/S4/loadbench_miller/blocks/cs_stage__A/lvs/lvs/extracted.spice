* NGSPICE file created from cs_stage__A.ext - technology: sky130A

.subckt sky130_fd_pr__nfet_01v8_lvt_2FVR8Y a_1667_n1544# S27 D22 S17 D10 D20 S15 G
+ D30 S25 S13 S23 S11 S21 S31 D8 D6 D4 D2 D0 S9 S7 D18 D28 S5 D16 D26 S3 D14 D24 S19
+ S1 S29 D12 VSUBS
X0 D4 G S3 VSUBS sky130_fd_pr__nfet_01v8_lvt ad=2.19385 pd=15.42 as=2.19385 ps=15.42 w=15.13 l=0.24
X1 D6 G S5 VSUBS sky130_fd_pr__nfet_01v8_lvt ad=2.19385 pd=15.42 as=2.19385 ps=15.42 w=15.13 l=0.24
X2 D30 G S29 VSUBS sky130_fd_pr__nfet_01v8_lvt ad=2.19385 pd=15.42 as=2.19385 ps=15.42 w=15.13 l=0.24
X3 a_1667_n1544# G S31 VSUBS sky130_fd_pr__nfet_01v8_lvt ad=4.3877 pd=30.84 as=2.19385 ps=15.42 w=15.13 l=0.24
X4 D14 G S13 VSUBS sky130_fd_pr__nfet_01v8_lvt ad=2.19385 pd=15.42 as=2.19385 ps=15.42 w=15.13 l=0.24
X5 S25 G D24 VSUBS sky130_fd_pr__nfet_01v8_lvt ad=2.19385 pd=15.42 as=2.19385 ps=15.42 w=15.13 l=0.24
X6 D8 G S7 VSUBS sky130_fd_pr__nfet_01v8_lvt ad=2.19385 pd=15.42 as=2.19385 ps=15.42 w=15.13 l=0.24
X7 S23 G D22 VSUBS sky130_fd_pr__nfet_01v8_lvt ad=2.19385 pd=15.42 as=2.19385 ps=15.42 w=15.13 l=0.24
X8 D10 G S9 VSUBS sky130_fd_pr__nfet_01v8_lvt ad=2.19385 pd=15.42 as=2.19385 ps=15.42 w=15.13 l=0.24
X9 D12 G S11 VSUBS sky130_fd_pr__nfet_01v8_lvt ad=2.19385 pd=15.42 as=2.19385 ps=15.42 w=15.13 l=0.24
X10 S21 G D20 VSUBS sky130_fd_pr__nfet_01v8_lvt ad=2.19385 pd=15.42 as=2.19385 ps=15.42 w=15.13 l=0.24
X11 S19 G D18 VSUBS sky130_fd_pr__nfet_01v8_lvt ad=2.19385 pd=15.42 as=2.19385 ps=15.42 w=15.13 l=0.24
X12 S9 G D8 VSUBS sky130_fd_pr__nfet_01v8_lvt ad=2.19385 pd=15.42 as=2.19385 ps=15.42 w=15.13 l=0.24
X13 S11 G D10 VSUBS sky130_fd_pr__nfet_01v8_lvt ad=2.19385 pd=15.42 as=2.19385 ps=15.42 w=15.13 l=0.24
X14 D20 G S19 VSUBS sky130_fd_pr__nfet_01v8_lvt ad=2.19385 pd=15.42 as=2.19385 ps=15.42 w=15.13 l=0.24
X15 D22 G S21 VSUBS sky130_fd_pr__nfet_01v8_lvt ad=2.19385 pd=15.42 as=2.19385 ps=15.42 w=15.13 l=0.24
X16 D18 G S17 VSUBS sky130_fd_pr__nfet_01v8_lvt ad=2.19385 pd=15.42 as=2.19385 ps=15.42 w=15.13 l=0.24
X17 D16 G S15 VSUBS sky130_fd_pr__nfet_01v8_lvt ad=2.19385 pd=15.42 as=2.19385 ps=15.42 w=15.13 l=0.24
X18 D28 G S27 VSUBS sky130_fd_pr__nfet_01v8_lvt ad=2.19385 pd=15.42 as=2.19385 ps=15.42 w=15.13 l=0.24
X19 D2 G S1 VSUBS sky130_fd_pr__nfet_01v8_lvt ad=2.19385 pd=15.42 as=2.19385 ps=15.42 w=15.13 l=0.24
X20 S17 G D16 VSUBS sky130_fd_pr__nfet_01v8_lvt ad=2.19385 pd=15.42 as=2.19385 ps=15.42 w=15.13 l=0.24
X21 S1 G D0 VSUBS sky130_fd_pr__nfet_01v8_lvt ad=2.19385 pd=15.42 as=4.3877 ps=30.84 w=15.13 l=0.24
X22 S3 G D2 VSUBS sky130_fd_pr__nfet_01v8_lvt ad=2.19385 pd=15.42 as=2.19385 ps=15.42 w=15.13 l=0.24
X23 S27 G D26 VSUBS sky130_fd_pr__nfet_01v8_lvt ad=2.19385 pd=15.42 as=2.19385 ps=15.42 w=15.13 l=0.24
X24 S5 G D4 VSUBS sky130_fd_pr__nfet_01v8_lvt ad=2.19385 pd=15.42 as=2.19385 ps=15.42 w=15.13 l=0.24
X25 S31 G D30 VSUBS sky130_fd_pr__nfet_01v8_lvt ad=2.19385 pd=15.42 as=2.19385 ps=15.42 w=15.13 l=0.24
X26 S7 G D6 VSUBS sky130_fd_pr__nfet_01v8_lvt ad=2.19385 pd=15.42 as=2.19385 ps=15.42 w=15.13 l=0.24
X27 S13 G D12 VSUBS sky130_fd_pr__nfet_01v8_lvt ad=2.19385 pd=15.42 as=2.19385 ps=15.42 w=15.13 l=0.24
X28 D26 G S25 VSUBS sky130_fd_pr__nfet_01v8_lvt ad=2.19385 pd=15.42 as=2.19385 ps=15.42 w=15.13 l=0.24
X29 S29 G D28 VSUBS sky130_fd_pr__nfet_01v8_lvt ad=2.19385 pd=15.42 as=2.19385 ps=15.42 w=15.13 l=0.24
X30 S15 G D14 VSUBS sky130_fd_pr__nfet_01v8_lvt ad=2.19385 pd=15.42 as=2.19385 ps=15.42 w=15.13 l=0.24
X31 D24 G S23 VSUBS sky130_fd_pr__nfet_01v8_lvt ad=2.19385 pd=15.42 as=2.19385 ps=15.42 w=15.13 l=0.24
.ends

.subckt nfet_01v8_lvt_W484p2_L0p24_m1__nf32_gtop_sdhalf_outS_ng G B S D
Xnfet_01v8_lvt_W484p2_L0p24_m1__nf32_gtop_sdhalf_outS_ng_pc S D S D S S D G S D D
+ D D D D S S S S S D D S S D S S D S S D D D S B sky130_fd_pr__nfet_01v8_lvt_2FVR8Y
.ends

.subckt cs_stage__A sourceNmos outFirstStage out sourceNmos_body
Xnfet_01v8_lvt_W484p2_L0p24_m1__nf32_gtop_sdhalf_outS_ng_0 outFirstStage sourceNmos_body
+ sourceNmos out nfet_01v8_lvt_W484p2_L0p24_m1__nf32_gtop_sdhalf_outS_ng
.ends
