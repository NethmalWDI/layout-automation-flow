.subckt cs_stage__A out outFirstStage sourceNmos sourceNmos_body
XXNormalTransistorNmos3 out outFirstStage sourceNmos sourceNmos_body sky130_fd_pr__nfet_01v8_lvt L=0.24 W=484.2 nf=32
.ends
