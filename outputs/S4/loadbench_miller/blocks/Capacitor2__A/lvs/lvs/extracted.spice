* NGSPICE file created from Capacitor2__A.ext - technology: sky130A

.subckt sky130_fd_pr__cap_mim_m3_1_84GA9G C1 C2
X0 C1 C2 sky130_fd_pr__cap_mim_m3_1 l=15.66 w=15.66
.ends

.subckt Capacitor2_mim Capacitor2_mim_pc/C2 Capacitor2_mim_pc/C1
XCapacitor2_mim_pc Capacitor2_mim_pc/C1 Capacitor2_mim_pc/C2 sky130_fd_pr__cap_mim_m3_1_84GA9G
.ends

.subckt Capacitor2__A outFirstStage out
XCapacitor2_mim_0 out outFirstStage Capacitor2_mim
.ends
