.subckt Capacitor2__A outFirstStage out
XCapacitor2 outFirstStage out sky130_fd_pr__cap_mim_m3_1 W=15.66 L=17.226
.ends
