.subckt nmos_differential_pair__AB INN INP OUTP net1 net3 VSS_body
XXM1 net3 INP net1 VSS_body sky130_fd_pr__nfet_01v8 L=0.6 W=24 nf=2
XXM2 OUTP INN net1 VSS_body sky130_fd_pr__nfet_01v8 L=0.5 W=24 nf=2
.ends
