* loadbench_miller on diso_amp_OP
.lib $PDK_ROOT/sky130A/libs.tech/combined/sky130.lib.spice tt
.param VDD_V=1.8 VCM_V=0.9 CL_F=1p
.temp 27

**.subckt diso_amp_OP
x1 INP INN net1 VDD 0 OUT dut_amp
Vsup VDD 0 'VDD_V'
Vinp INP 0 dc 'VCM_V' ac 0
* DC unity feedback, AC open loop: a 1 GH choke from OUT to INN and a 1 F capacitor from INN to
* ground. At DC the amplifier is a follower, so OUT sits at VCM as in LOADBench's offset-corrected
* open-loop bench; from 1 Hz up INN is an AC ground and the loop is open (corner ~5 uHz).
Lfb OUT INN 1G
Cfb INN 0 1
Cload OUT 0 'CL_F'
* noconn #net1
.control
  save all
  op
  let isup    = abs(i(vsup))
  let isup_ua = isup * 1e6
  let power_uw = isup * v(VDD) * 1e6
  let vout_v  = v(OUT)
  echo MEAS isup_ua $&isup_ua
  echo MEAS power_uw $&power_uw
  echo MEAS vout_v $&vout_v
  write
  quit 0
.endc
**.ends

.subckt dut_amp INP INN OUTN VDD VSS OUTP
XDUT INN INP OUTP VSS VDD loadbench_miller
.ends

.subckt loadbench_miller in1 in2 out sourceNmos sourcePmos
XDiodeTransistorNmos1 FirstStageYout1 FirstStageYout1 sourceNmos sourceNmos sky130_fd_pr__nfet_01v8_lvt L=2.03 W=66.13 NF=1 AD=19.1777 AS=19.1777 PD=132.84 PS=132.84 NRD=0.0043853 NRS=0.0043853 SA=0 SB=0 SD=0 MULT=1
XDiodeTransistorPmos2 ibias ibias sourcePmos sourcePmos sky130_fd_pr__pfet_01v8_lvt L=0.74 W=37.3 NF=1 AD=10.817 AS=10.817 PD=75.18 PS=75.18 NRD=0.0077748 NRS=0.0077748 SA=0 SB=0 SD=0 MULT=1
XNormalTransistorNmos3 out outFirstStage sourceNmos sourceNmos sky130_fd_pr__nfet_01v8_lvt L=0.24 W=484.2 NF=1 AD=140.418 AS=140.418 PD=968.98 PS=968.98 NRD=0.000598926 NRS=0.000598926 SA=0 SB=0 SD=0 MULT=1
XNormalTransistorNmos4 outFirstStage FirstStageYout1 sourceNmos sourceNmos sky130_fd_pr__nfet_01v8_lvt L=2.03 W=66.13 NF=1 AD=19.1777 AS=19.1777 PD=132.84 PS=132.84 NRD=0.0043853 NRS=0.0043853 SA=0 SB=0 SD=0 MULT=1
XNormalTransistorPmos5 sourcePmos out ibias sourcePmos sourceNmos s3c_pfet_01v8_lvt_w887p03_l0p74_m1__nf32_gtop_sdhalf_outs
XNormalTransistorPmos6 outFirstStage in2 FirstStageYsourceTransconductance FirstStageYsourceTransconductance sky130_fd_pr__pfet_01v8_lvt L=0.89 W=14.21 NF=1 AD=4.1209 AS=4.1209 PD=29 PS=29 NRD=0.0204082 NRS=0.0204082 SA=0 SB=0 SD=0 MULT=1
XNormalTransistorPmos7 FirstStageYout1 in1 FirstStageYsourceTransconductance FirstStageYsourceTransconductance sky130_fd_pr__pfet_01v8_lvt L=0.89 W=14.21 NF=1 AD=4.1209 AS=4.1209 PD=29 PS=29 NRD=0.0204082 NRS=0.0204082 SA=0 SB=0 SD=0 MULT=1
XNormalTransistorPmos8 FirstStageYsourceTransconductance ibias sourcePmos sourcePmos sky130_fd_pr__pfet_01v8_lvt L=0.74 W=90.63 NF=1 AD=26.2827 AS=26.2827 PD=181.84 PS=181.84 NRD=0.00319982 NRS=0.00319982 SA=0 SB=0 SD=0 MULT=1
Ibias ibias sourceNmos 1e-05
Capacitor2 outFirstStage out 5e-13
.ends loadbench_miller
.subckt s3c_pfet_01v8_lvt_w887p03_l0p74_m1__nf32_gtop_sdhalf_outs S D G B SUB
X0 D G S B sky130_fd_pr__pfet_01v8_lvt ad=4.0194 pd=28.01 as=4.0194 ps=28.01 w=27.72 l=0.74
X1 D G S B sky130_fd_pr__pfet_01v8_lvt ad=4.0194 pd=28.01 as=4.0194 ps=28.01 w=27.72 l=0.74
X2 D G S B sky130_fd_pr__pfet_01v8_lvt ad=4.0194 pd=28.01 as=4.0194 ps=28.01 w=27.72 l=0.74
X3 D G S B sky130_fd_pr__pfet_01v8_lvt ad=4.0194 pd=28.01 as=4.0194 ps=28.01 w=27.72 l=0.74
X4 S G D B sky130_fd_pr__pfet_01v8_lvt ad=4.0194 pd=28.01 as=4.0194 ps=28.01 w=27.72 l=0.74
X5 S G D B sky130_fd_pr__pfet_01v8_lvt ad=4.0194 pd=28.01 as=4.0194 ps=28.01 w=27.72 l=0.74
X6 S G D B sky130_fd_pr__pfet_01v8_lvt ad=4.0194 pd=28.01 as=4.0194 ps=28.01 w=27.72 l=0.74
X7 D G S B sky130_fd_pr__pfet_01v8_lvt ad=4.0194 pd=28.01 as=4.0194 ps=28.01 w=27.72 l=0.74
X8 D G S B sky130_fd_pr__pfet_01v8_lvt ad=4.0194 pd=28.01 as=4.0194 ps=28.01 w=27.72 l=0.74
X9 S G D B sky130_fd_pr__pfet_01v8_lvt ad=4.0194 pd=28.01 as=4.0194 ps=28.01 w=27.72 l=0.74
X10 D G S B sky130_fd_pr__pfet_01v8_lvt ad=4.0194 pd=28.01 as=4.0194 ps=28.01 w=27.72 l=0.74
X11 S G D B sky130_fd_pr__pfet_01v8_lvt ad=4.0194 pd=28.01 as=4.0194 ps=28.01 w=27.72 l=0.74
X12 D G S B sky130_fd_pr__pfet_01v8_lvt ad=4.0194 pd=28.01 as=4.0194 ps=28.01 w=27.72 l=0.74
X13 D G S B sky130_fd_pr__pfet_01v8_lvt ad=4.0194 pd=28.01 as=4.0194 ps=28.01 w=27.72 l=0.74
X14 S G D B sky130_fd_pr__pfet_01v8_lvt ad=4.0194 pd=28.01 as=4.0194 ps=28.01 w=27.72 l=0.74
X15 D G S B sky130_fd_pr__pfet_01v8_lvt ad=4.0194 pd=28.01 as=4.0194 ps=28.01 w=27.72 l=0.74
X16 D G S B sky130_fd_pr__pfet_01v8_lvt ad=4.0194 pd=28.01 as=4.0194 ps=28.01 w=27.72 l=0.74
X17 D G S B sky130_fd_pr__pfet_01v8_lvt ad=4.0194 pd=28.01 as=4.0194 ps=28.01 w=27.72 l=0.74
X18 S G D B sky130_fd_pr__pfet_01v8_lvt ad=4.0194 pd=28.01 as=4.0194 ps=28.01 w=27.72 l=0.74
X19 S G D B sky130_fd_pr__pfet_01v8_lvt ad=4.0194 pd=28.01 as=4.0194 ps=28.01 w=27.72 l=0.74
X20 D G S B sky130_fd_pr__pfet_01v8_lvt ad=4.0194 pd=28.01 as=4.0194 ps=28.01 w=27.72 l=0.74
X21 S G D B sky130_fd_pr__pfet_01v8_lvt ad=4.0194 pd=28.01 as=4.0194 ps=28.01 w=27.72 l=0.74
X22 S G D B sky130_fd_pr__pfet_01v8_lvt ad=4.0194 pd=28.01 as=4.0194 ps=28.01 w=27.72 l=0.74
X23 S G D B sky130_fd_pr__pfet_01v8_lvt ad=4.0194 pd=28.01 as=4.0194 ps=28.01 w=27.72 l=0.74
X24 S G D B sky130_fd_pr__pfet_01v8_lvt ad=4.0194 pd=28.01 as=4.0194 ps=28.01 w=27.72 l=0.74
X25 D G S B sky130_fd_pr__pfet_01v8_lvt ad=4.0194 pd=28.01 as=4.0194 ps=28.01 w=27.72 l=0.74
X26 D G S B sky130_fd_pr__pfet_01v8_lvt ad=4.0194 pd=28.01 as=8.0388 ps=56.02 w=27.72 l=0.74
X27 S G D B sky130_fd_pr__pfet_01v8_lvt ad=4.0194 pd=28.01 as=4.0194 ps=28.01 w=27.72 l=0.74
X28 S G D B sky130_fd_pr__pfet_01v8_lvt ad=4.0194 pd=28.01 as=4.0194 ps=28.01 w=27.72 l=0.74
X29 D G S B sky130_fd_pr__pfet_01v8_lvt ad=4.0194 pd=28.01 as=4.0194 ps=28.01 w=27.72 l=0.74
X30 S G D B sky130_fd_pr__pfet_01v8_lvt ad=8.0388 pd=56.02 as=4.0194 ps=28.01 w=27.72 l=0.74
X31 S G D B sky130_fd_pr__pfet_01v8_lvt ad=4.0194 pd=28.01 as=4.0194 ps=28.01 w=27.72 l=0.74
C0 S D 18.71573f
C1 B D 5.25718f
C2 G D 22.647f
C3 B S 6.72678f
C4 G S 22.65764f
C5 G B 7.55814f
C6 D SUB 0.36203f
C7 S SUB 1.08468f
C8 G SUB 2.41114f
C9 B SUB 0.12589p
.ends
.end
