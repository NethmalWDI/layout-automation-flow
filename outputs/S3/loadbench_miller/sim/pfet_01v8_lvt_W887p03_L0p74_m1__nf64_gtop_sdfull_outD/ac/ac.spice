* loadbench_miller on diso_amp_AC
.lib $PDK_ROOT/sky130A/libs.tech/combined/sky130.lib.spice tt
.param VDD_V=1.8 VCM_V=0.9 CL_F=1p
.temp 27

**.subckt diso_amp_AC
x1 INP INN net1 VDD 0 OUT dut_amp
Vsup VDD 0 'VDD_V'
Vinp INP 0 dc 'VCM_V' ac 1
* DC unity feedback, AC open loop: a 1 GH choke from OUT to INN and a 1 F capacitor from INN to
* ground. At DC the amplifier is a follower, so OUT sits at VCM as in LOADBench's offset-corrected
* open-loop bench; from 1 Hz up INN is an AC ground and the loop is open (corner ~5 uHz).
Lfb OUT INN 1G
Cfb INN 0 1
Cload OUT 0 'CL_F'
* noconn #net1
.control
  save all
  ac dec 40 1 1G
  let gph_deg = 180/pi * cph(v(OUT))
  meas ac gain_db find vdb(OUT) at=1
  meas ac gbw_hz  when vdb(OUT)=0
  meas ac ph_dc   find gph_deg at=1
  meas ac ph_ugb  find gph_deg when vdb(OUT)=0
  let gbw_mhz = gbw_hz / 1e6
  let pm_deg  = 180 + (ph_ugb - ph_dc)
  echo MEAS gain_db $&gain_db
  echo MEAS gbw_mhz $&gbw_mhz
  echo MEAS pm_deg $&pm_deg
  write
  quit 0
.endc
**.ends

.subckt dut_amp INP INN OUTN VDD VSS OUTP
XDUT INN INP OUTP VSS VDD loadbench_miller
.ends

.subckt loadbench_miller in1 in2 out sourceNmos sourcePmos
XDiodeTransistorNmos1 FirstStageYout1 FirstStageYout1 sourceNmos sourceNmos sky130_fd_pr__nfet_01v8_lvt L=2.03 W=66.13 NF=1 AD=19.1777 AS=19.1777 PD=132.84 PS=132.84 NRD=0.0043853 NRS=0.0043853 SA=0 SB=0 SD=0 MULT=1
XDiodeTransistorPmos2 ibias ibias sourcePmos sourcePmos sky130_fd_pr__pfet_01v8_lvt L=0.74 W=37.3 NF=1 AD=10.817 AS=10.817 PD=75.18 PS=75.18 NRD=0.0077748 NRS=0.0077748 SA=0 SB=0 SD=0 MULT=1
XNormalTransistorNmos3 out outFirstStage sourceNmos sourceNmos sky130_fd_pr__nfet_01v8_lvt L=0.24 W=484.2 NF=1 AD=140.418 AS=140.418 PD=968.98 PS=968.98 NRD=0.000598926 NRS=0.000598926 SA=0 SB=0 SD=0 MULT=1
XNormalTransistorNmos4 outFirstStage FirstStageYout1 sourceNmos sourceNmos sky130_fd_pr__nfet_01v8_lvt L=2.03 W=66.13 NF=1 AD=19.1777 AS=19.1777 PD=132.84 PS=132.84 NRD=0.0043853 NRS=0.0043853 SA=0 SB=0 SD=0 MULT=1
XNormalTransistorPmos5 sourcePmos out ibias sourcePmos sourceNmos s3c_pfet_01v8_lvt_w887p03_l0p74_m1__nf64_gtop_sdfull_outd
XNormalTransistorPmos6 outFirstStage in2 FirstStageYsourceTransconductance FirstStageYsourceTransconductance sky130_fd_pr__pfet_01v8_lvt L=0.89 W=14.21 NF=1 AD=4.1209 AS=4.1209 PD=29 PS=29 NRD=0.0204082 NRS=0.0204082 SA=0 SB=0 SD=0 MULT=1
XNormalTransistorPmos7 FirstStageYout1 in1 FirstStageYsourceTransconductance FirstStageYsourceTransconductance sky130_fd_pr__pfet_01v8_lvt L=0.89 W=14.21 NF=1 AD=4.1209 AS=4.1209 PD=29 PS=29 NRD=0.0204082 NRS=0.0204082 SA=0 SB=0 SD=0 MULT=1
XNormalTransistorPmos8 FirstStageYsourceTransconductance ibias sourcePmos sourcePmos sky130_fd_pr__pfet_01v8_lvt L=0.74 W=90.63 NF=1 AD=26.2827 AS=26.2827 PD=181.84 PS=181.84 NRD=0.00319982 NRS=0.00319982 SA=0 SB=0 SD=0 MULT=1
Ibias ibias sourceNmos 1e-05
Capacitor2 outFirstStage out 5e-13
.ends loadbench_miller
.subckt s3c_pfet_01v8_lvt_w887p03_l0p74_m1__nf64_gtop_sdfull_outd S D G B SUB
X0 S G D B sky130_fd_pr__pfet_01v8_lvt ad=2.0097 pd=14.15 as=2.0097 ps=14.15 w=13.86 l=0.74
X1 D G S B sky130_fd_pr__pfet_01v8_lvt ad=2.0097 pd=14.15 as=2.0097 ps=14.15 w=13.86 l=0.74
X2 D G S B sky130_fd_pr__pfet_01v8_lvt ad=2.0097 pd=14.15 as=2.0097 ps=14.15 w=13.86 l=0.74
X3 D G S B sky130_fd_pr__pfet_01v8_lvt ad=2.0097 pd=14.15 as=2.0097 ps=14.15 w=13.86 l=0.74
X4 S G D B sky130_fd_pr__pfet_01v8_lvt ad=2.0097 pd=14.15 as=2.0097 ps=14.15 w=13.86 l=0.74
X5 D G S B sky130_fd_pr__pfet_01v8_lvt ad=2.0097 pd=14.15 as=2.0097 ps=14.15 w=13.86 l=0.74
X6 S G D B sky130_fd_pr__pfet_01v8_lvt ad=2.0097 pd=14.15 as=2.0097 ps=14.15 w=13.86 l=0.74
X7 D G S B sky130_fd_pr__pfet_01v8_lvt ad=2.0097 pd=14.15 as=2.0097 ps=14.15 w=13.86 l=0.74
X8 D G S B sky130_fd_pr__pfet_01v8_lvt ad=2.0097 pd=14.15 as=2.0097 ps=14.15 w=13.86 l=0.74
X9 D G S B sky130_fd_pr__pfet_01v8_lvt ad=2.0097 pd=14.15 as=2.0097 ps=14.15 w=13.86 l=0.74
X10 D G S B sky130_fd_pr__pfet_01v8_lvt ad=2.0097 pd=14.15 as=2.0097 ps=14.15 w=13.86 l=0.74
X11 S G D B sky130_fd_pr__pfet_01v8_lvt ad=2.0097 pd=14.15 as=2.0097 ps=14.15 w=13.86 l=0.74
X12 S G D B sky130_fd_pr__pfet_01v8_lvt ad=2.0097 pd=14.15 as=4.0194 ps=28.3 w=13.86 l=0.74
X13 S G D B sky130_fd_pr__pfet_01v8_lvt ad=2.0097 pd=14.15 as=2.0097 ps=14.15 w=13.86 l=0.74
X14 S G D B sky130_fd_pr__pfet_01v8_lvt ad=2.0097 pd=14.15 as=2.0097 ps=14.15 w=13.86 l=0.74
X15 D G S B sky130_fd_pr__pfet_01v8_lvt ad=2.0097 pd=14.15 as=2.0097 ps=14.15 w=13.86 l=0.74
X16 D G S B sky130_fd_pr__pfet_01v8_lvt ad=2.0097 pd=14.15 as=2.0097 ps=14.15 w=13.86 l=0.74
X17 S G D B sky130_fd_pr__pfet_01v8_lvt ad=2.0097 pd=14.15 as=2.0097 ps=14.15 w=13.86 l=0.74
X18 S G D B sky130_fd_pr__pfet_01v8_lvt ad=2.0097 pd=14.15 as=2.0097 ps=14.15 w=13.86 l=0.74
X19 D G S B sky130_fd_pr__pfet_01v8_lvt ad=2.0097 pd=14.15 as=2.0097 ps=14.15 w=13.86 l=0.74
X20 S G D B sky130_fd_pr__pfet_01v8_lvt ad=2.0097 pd=14.15 as=2.0097 ps=14.15 w=13.86 l=0.74
X21 S G D B sky130_fd_pr__pfet_01v8_lvt ad=2.0097 pd=14.15 as=2.0097 ps=14.15 w=13.86 l=0.74
X22 S G D B sky130_fd_pr__pfet_01v8_lvt ad=2.0097 pd=14.15 as=2.0097 ps=14.15 w=13.86 l=0.74
X23 D G S B sky130_fd_pr__pfet_01v8_lvt ad=2.0097 pd=14.15 as=2.0097 ps=14.15 w=13.86 l=0.74
X24 D G S B sky130_fd_pr__pfet_01v8_lvt ad=2.0097 pd=14.15 as=2.0097 ps=14.15 w=13.86 l=0.74
X25 D G S B sky130_fd_pr__pfet_01v8_lvt ad=2.0097 pd=14.15 as=2.0097 ps=14.15 w=13.86 l=0.74
X26 D G S B sky130_fd_pr__pfet_01v8_lvt ad=4.0194 pd=28.3 as=2.0097 ps=14.15 w=13.86 l=0.74
X27 S G D B sky130_fd_pr__pfet_01v8_lvt ad=2.0097 pd=14.15 as=2.0097 ps=14.15 w=13.86 l=0.74
X28 S G D B sky130_fd_pr__pfet_01v8_lvt ad=2.0097 pd=14.15 as=2.0097 ps=14.15 w=13.86 l=0.74
X29 S G D B sky130_fd_pr__pfet_01v8_lvt ad=2.0097 pd=14.15 as=2.0097 ps=14.15 w=13.86 l=0.74
X30 D G S B sky130_fd_pr__pfet_01v8_lvt ad=2.0097 pd=14.15 as=2.0097 ps=14.15 w=13.86 l=0.74
X31 D G S B sky130_fd_pr__pfet_01v8_lvt ad=2.0097 pd=14.15 as=2.0097 ps=14.15 w=13.86 l=0.74
X32 S G D B sky130_fd_pr__pfet_01v8_lvt ad=2.0097 pd=14.15 as=2.0097 ps=14.15 w=13.86 l=0.74
X33 D G S B sky130_fd_pr__pfet_01v8_lvt ad=2.0097 pd=14.15 as=2.0097 ps=14.15 w=13.86 l=0.74
X34 D G S B sky130_fd_pr__pfet_01v8_lvt ad=2.0097 pd=14.15 as=2.0097 ps=14.15 w=13.86 l=0.74
X35 D G S B sky130_fd_pr__pfet_01v8_lvt ad=2.0097 pd=14.15 as=2.0097 ps=14.15 w=13.86 l=0.74
X36 S G D B sky130_fd_pr__pfet_01v8_lvt ad=2.0097 pd=14.15 as=2.0097 ps=14.15 w=13.86 l=0.74
X37 S G D B sky130_fd_pr__pfet_01v8_lvt ad=2.0097 pd=14.15 as=2.0097 ps=14.15 w=13.86 l=0.74
X38 D G S B sky130_fd_pr__pfet_01v8_lvt ad=2.0097 pd=14.15 as=2.0097 ps=14.15 w=13.86 l=0.74
X39 S G D B sky130_fd_pr__pfet_01v8_lvt ad=2.0097 pd=14.15 as=2.0097 ps=14.15 w=13.86 l=0.74
X40 S G D B sky130_fd_pr__pfet_01v8_lvt ad=2.0097 pd=14.15 as=2.0097 ps=14.15 w=13.86 l=0.74
X41 S G D B sky130_fd_pr__pfet_01v8_lvt ad=2.0097 pd=14.15 as=2.0097 ps=14.15 w=13.86 l=0.74
X42 D G S B sky130_fd_pr__pfet_01v8_lvt ad=2.0097 pd=14.15 as=2.0097 ps=14.15 w=13.86 l=0.74
X43 S G D B sky130_fd_pr__pfet_01v8_lvt ad=2.0097 pd=14.15 as=2.0097 ps=14.15 w=13.86 l=0.74
X44 D G S B sky130_fd_pr__pfet_01v8_lvt ad=2.0097 pd=14.15 as=2.0097 ps=14.15 w=13.86 l=0.74
X45 D G S B sky130_fd_pr__pfet_01v8_lvt ad=2.0097 pd=14.15 as=2.0097 ps=14.15 w=13.86 l=0.74
X46 D G S B sky130_fd_pr__pfet_01v8_lvt ad=2.0097 pd=14.15 as=2.0097 ps=14.15 w=13.86 l=0.74
X47 D G S B sky130_fd_pr__pfet_01v8_lvt ad=2.0097 pd=14.15 as=2.0097 ps=14.15 w=13.86 l=0.74
X48 S G D B sky130_fd_pr__pfet_01v8_lvt ad=2.0097 pd=14.15 as=2.0097 ps=14.15 w=13.86 l=0.74
X49 S G D B sky130_fd_pr__pfet_01v8_lvt ad=2.0097 pd=14.15 as=2.0097 ps=14.15 w=13.86 l=0.74
X50 S G D B sky130_fd_pr__pfet_01v8_lvt ad=2.0097 pd=14.15 as=2.0097 ps=14.15 w=13.86 l=0.74
X51 D G S B sky130_fd_pr__pfet_01v8_lvt ad=2.0097 pd=14.15 as=2.0097 ps=14.15 w=13.86 l=0.74
X52 S G D B sky130_fd_pr__pfet_01v8_lvt ad=2.0097 pd=14.15 as=2.0097 ps=14.15 w=13.86 l=0.74
X53 S G D B sky130_fd_pr__pfet_01v8_lvt ad=2.0097 pd=14.15 as=2.0097 ps=14.15 w=13.86 l=0.74
X54 D G S B sky130_fd_pr__pfet_01v8_lvt ad=2.0097 pd=14.15 as=2.0097 ps=14.15 w=13.86 l=0.74
X55 S G D B sky130_fd_pr__pfet_01v8_lvt ad=2.0097 pd=14.15 as=2.0097 ps=14.15 w=13.86 l=0.74
X56 D G S B sky130_fd_pr__pfet_01v8_lvt ad=2.0097 pd=14.15 as=2.0097 ps=14.15 w=13.86 l=0.74
X57 D G S B sky130_fd_pr__pfet_01v8_lvt ad=2.0097 pd=14.15 as=2.0097 ps=14.15 w=13.86 l=0.74
X58 S G D B sky130_fd_pr__pfet_01v8_lvt ad=2.0097 pd=14.15 as=2.0097 ps=14.15 w=13.86 l=0.74
X59 S G D B sky130_fd_pr__pfet_01v8_lvt ad=2.0097 pd=14.15 as=2.0097 ps=14.15 w=13.86 l=0.74
X60 D G S B sky130_fd_pr__pfet_01v8_lvt ad=2.0097 pd=14.15 as=2.0097 ps=14.15 w=13.86 l=0.74
X61 S G D B sky130_fd_pr__pfet_01v8_lvt ad=2.0097 pd=14.15 as=2.0097 ps=14.15 w=13.86 l=0.74
X62 D G S B sky130_fd_pr__pfet_01v8_lvt ad=2.0097 pd=14.15 as=2.0097 ps=14.15 w=13.86 l=0.74
X63 S G D B sky130_fd_pr__pfet_01v8_lvt ad=2.0097 pd=14.15 as=2.0097 ps=14.15 w=13.86 l=0.74
C0 G B 14.10058f
C1 D B 11.80426f
C2 D G 43.78272f
C3 S B 10.27881f
C4 S G 45.52165f
C5 S D 36.66219f
C6 S SUB 2.01824f
C7 D SUB 2.97651f
C8 G SUB 4.78907f
C9 B SUB 0.13192p
.ends
.end
