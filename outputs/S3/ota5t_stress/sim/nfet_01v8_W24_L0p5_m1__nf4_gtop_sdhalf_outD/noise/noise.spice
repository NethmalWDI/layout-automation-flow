* example_ota_5t on diso_amp_NOISE
.lib $PDK_ROOT/sky130A/libs.tech/combined/sky130.lib.spice tt
.param VDD_V=1.8 VCM_V=0.9 CL_F=200f
.temp 27

** sch_path: /foss/designs/PROJECTS/llm-analog-sizing/testbenches/diso_amp_NOISE.sch
**.subckt diso_amp_NOISE
x1 INP INN net1 VDD 0 OUT dut_amp
Vsup VDD 0 'VDD_V'
Vinp INP 0 dc 'VCM_V' ac 1
Vinn INN 0 'VCM_V'
Cload OUT 0 'CL_F'
* noconn #net1
**** begin user architecture code

.control
  save all

  * sweep settings -- fspot must lie on the grid, which it does by construction
  let npd    = 20
  let fstart = 1
  let fstop  = 1e9
  let fspot  = 1e3

  noise v(OUT) Vinp dec 20 1 1e9

  * input-referred voltage noise density [nV/sqrt(Hz)] at fspot.
  * meas does not work on noise plots, so index the vector directly:
  * index = points-per-decade * log10(fspot / fstart).
  setplot noise1
  let idx = npd * log10(fspot/fstart)
  let vnoise_nv_rthz = inoise_spectrum[$&idx] * 1e9
  echo MEAS vnoise_nv_rthz $&vnoise_nv_rthz
  write
  set appendwrite

  * total input-referred noise integrated over the sweep [uVrms]
  setplot noise2
  let vnoise_rms_uv_rms = inoise_total * 1e6
  echo MEAS vnoise_rms_uv_rms $&vnoise_rms_uv_rms
  write

  quit 0
.endc

**** end user architecture code
**.ends

* expanding   symbol:  dut_amp.sym # of pins=6
** sym_path: /foss/designs/PROJECTS/llm-analog-sizing/testbenches/dut_amp.sym
** sch_path: /foss/designs/PROJECTS/llm-analog-sizing/testbenches/dut_amp.sch
.subckt dut_amp INP INN OUTN VDD VSS OUTP
XDUT VDD OUTP INP INN VSS example_ota_5t_sized
.ends

.subckt example_ota_5t_sized VDD OUTP INP INN VSS
XM3 net3 net3 VDD VDD sky130_fd_pr__pfet_01v8 L=1 W=8 NF=1 AD=2.32 AS=2.32 PD=16.58 PS=16.58 NRD=0.03625 NRS=0.03625 SA=0 SB=0 SD=0 MULT=1
XM4 OUTP net3 VDD VDD sky130_fd_pr__pfet_01v8 L=1 W=8 NF=1 AD=2.32 AS=2.32 PD=16.58 PS=16.58 NRD=0.03625 NRS=0.03625 SA=0 SB=0 SD=0 MULT=1
XM1 net1 net3 INP VSS s3c_nfet_01v8_w24_l0p5_m1__nf4_gtop_sdhalf_outd
XM2 net1 OUTP INN VSS s3c_nfet_01v8_w24_l0p5_m1__nf4_gtop_sdhalf_outd
XM5 net1 net2 VSS VSS sky130_fd_pr__nfet_01v8 L=1 W=24 NF=1 AD=6.96 AS=6.96 PD=48.58 PS=48.58 NRD=0.0120833333333333 NRS=0.0120833333333333 SA=0 SB=0 SD=0 MULT=1
V1 net2 VSS 0.75
.ends example_ota_5t_sized
.subckt s3c_nfet_01v8_w24_l0p5_m1__nf4_gtop_sdhalf_outd S D G B
X0 D G S B sky130_fd_pr__nfet_01v8 ad=0.87 pd=6.29 as=0.87 ps=6.29 w=6 l=0.5
X1 S G D B sky130_fd_pr__nfet_01v8 ad=0.87 pd=6.29 as=1.74 ps=12.58 w=6 l=0.5
X2 D G S B sky130_fd_pr__nfet_01v8 ad=1.74 pd=12.58 as=0.87 ps=6.29 w=6 l=0.5
X3 S G D B sky130_fd_pr__nfet_01v8 ad=0.87 pd=6.29 as=0.87 ps=6.29 w=6 l=0.5
C0 D S 0.87688f
C1 D G 0.57299f
C2 G S 0.58114f
C3 S B 0.13106f
C4 D B 0.66212f
C5 G B 0.97074f
.ends
.end
