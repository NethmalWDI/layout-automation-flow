* example_ota_5t on diso_amp_NOISE
.lib $PDK_ROOT/sky130A/libs.tech/combined/sky130.lib.spice tt
.param VDD_V=1.8 VCM_V=0.9 CL_F=200f
.temp 27

** sch_path: /foss/designs/PROJECTS/llm-analog-sizing/testbenches/diso_amp_NOISE.sch
**.subckt diso_amp_NOISE
x1 INP INN net1 VDD 0 OUT dut_amp
Vsup VDD 0 'VDD_V'
Vinp INP 0 dc 'VCM_V' ac 1
Vinn INN 0 'VCM_V'
Cload OUT 0 'CL_F'
* noconn #net1
**** begin user architecture code

.control
  save all

  * sweep settings -- fspot must lie on the grid, which it does by construction
  let npd    = 20
  let fstart = 1
  let fstop  = 1e9
  let fspot  = 1e3

  noise v(OUT) Vinp dec 20 1 1e9

  * input-referred voltage noise density [nV/sqrt(Hz)] at fspot.
  * meas does not work on noise plots, so index the vector directly:
  * index = points-per-decade * log10(fspot / fstart).
  setplot noise1
  let idx = npd * log10(fspot/fstart)
  let vnoise_nv_rthz = inoise_spectrum[$&idx] * 1e9
  echo MEAS vnoise_nv_rthz $&vnoise_nv_rthz
  write
  set appendwrite

  * total input-referred noise integrated over the sweep [uVrms]
  setplot noise2
  let vnoise_rms_uv_rms = inoise_total * 1e6
  echo MEAS vnoise_rms_uv_rms $&vnoise_rms_uv_rms
  write

  quit 0
.endc

**** end user architecture code
**.ends

* expanding   symbol:  dut_amp.sym # of pins=6
** sym_path: /foss/designs/PROJECTS/llm-analog-sizing/testbenches/dut_amp.sym
** sch_path: /foss/designs/PROJECTS/llm-analog-sizing/testbenches/dut_amp.sch
.subckt dut_amp INP INN OUTN VDD VSS OUTP
XDUT VDD OUTP INP INN VSS example_ota_5t_sized
.ends

.subckt example_ota_5t_sized VDD OUTP INP INN VSS
XM3 VDD net3 net3 VDD VSS s3c_pfet_01v8_w8_l1_m1__nf2_gtop_sdhalf_outd
XM4 VDD OUTP net3 VDD VSS s3c_pfet_01v8_w8_l1_m1__nf2_gtop_sdhalf_outd
XM1 net3 INP net1 VSS sky130_fd_pr__nfet_01v8 L=0.5 W=24 NF=1 AD=6.96 AS=6.96 PD=48.58 PS=48.58 NRD=0.0120833333333333 NRS=0.0120833333333333 SA=0 SB=0 SD=0 MULT=1
XM2 OUTP INN net1 VSS sky130_fd_pr__nfet_01v8 L=0.5 W=24 NF=1 AD=6.96 AS=6.96 PD=48.58 PS=48.58 NRD=0.0120833333333333 NRS=0.0120833333333333 SA=0 SB=0 SD=0 MULT=1
XM5 net1 net2 VSS VSS sky130_fd_pr__nfet_01v8 L=1 W=24 NF=1 AD=6.96 AS=6.96 PD=48.58 PS=48.58 NRD=0.0120833333333333 NRS=0.0120833333333333 SA=0 SB=0 SD=0 MULT=1
V1 net2 VSS 0.75
.ends example_ota_5t_sized
.subckt s3c_pfet_01v8_w8_l1_m1__nf2_gtop_sdhalf_outd S D G B SUB
X0 D G S B sky130_fd_pr__pfet_01v8 ad=1.16 pd=8.58 as=0.58 ps=4.29 w=4 l=1
X1 S G D B sky130_fd_pr__pfet_01v8 ad=0.58 pd=4.29 as=1.16 ps=8.58 w=4 l=1
C0 S D 0.31207f
C1 S G 0.33056f
C2 D B 0.35092f
C3 G B 0.67596f
C4 G D 0.3183f
C5 S B 0.10711f
C6 S SUB 0.07767f
C7 D SUB 0.2048f
C8 G SUB 0.22248f
C9 B SUB 3.48708f
.ends
.end
