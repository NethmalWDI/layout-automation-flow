* example_ota_5t on diso_amp_OP
.lib $PDK_ROOT/sky130A/libs.tech/combined/sky130.lib.spice tt
.param VDD_V=1.8 VCM_V=0.9 CL_F=1p
.temp 27

** sch_path: /foss/designs/PROJECTS/llm-analog-sizing/testbenches/diso_amp_OP.sch
**.subckt diso_amp_OP
x1 INP INN net1 VDD 0 OUT dut_amp
Vinp INP 0 'VCM_V'
Vinn INN 0 'VCM_V'
Cload OUT 0 'CL_F'
* noconn #net1
Vsup VDD 0 'VDD_V'
**** begin user architecture code

.control
  save all
  op

  * supply current [uA], supply power [uW], output operating point [V]
  let isup    = abs(i(vsup))
  let isup_ua = isup * 1e6
  let power_uw = isup * v(VDD) * 1e6
  let vout_v  = v(OUT)

  echo MEAS isup_ua $&isup_ua
  echo MEAS power_uw $&power_uw
  echo MEAS vout_v $&vout_v

  write
  quit 0
.endc

**** end user architecture code
**.ends

* expanding   symbol:  dut_amp.sym # of pins=6
** sym_path: /foss/designs/PROJECTS/llm-analog-sizing/testbenches/dut_amp.sym
** sch_path: /foss/designs/PROJECTS/llm-analog-sizing/testbenches/dut_amp.sch
.subckt dut_amp INP INN OUTN VDD VSS OUTP
XDUT VDD OUTP INP INN VSS example_ota_5t_sized
.ends

.subckt example_ota_5t_sized VDD OUTP INP INN VSS
XM3 s3_XM3_s s3_XM3_d s3_XM3_g VDD VSS s3c_pfet_01v8_w8_l1_m1__nf2_gtop_sdfull_outs
Rs3_XM3_d s3_XM3_d net3 59.1683
Rs3_XM3_g s3_XM3_g net3 72.4583
Rs3_XM3_s s3_XM3_s VDD 29.5841
XM4 s3_XM4_s s3_XM4_d s3_XM4_g VDD VSS s3c_pfet_01v8_w8_l1_m1__nf2_gtop_sdfull_outs
Rs3_XM4_d s3_XM4_d OUTP 59.1683
Rs3_XM4_g s3_XM4_g net3 72.4583
Rs3_XM4_s s3_XM4_s VDD 29.5841
XM1 s3_XM1_s s3_XM1_d s3_XM1_g VSS s3c_nfet_01v8_w24_l0p5_m1__nf2_gtop_sdfull_outs
Rs3_XM1_d s3_XM1_d net3 11.9906
Rs3_XM1_g s3_XM1_g INP 273.45
Rs3_XM1_s s3_XM1_s net1 5.9953
XM2 s3_XM2_s s3_XM2_d s3_XM2_g VSS s3c_nfet_01v8_w24_l0p5_m1__nf2_gtop_sdfull_outs
Rs3_XM2_d s3_XM2_d OUTP 11.9906
Rs3_XM2_g s3_XM2_g INN 273.45
Rs3_XM2_s s3_XM2_s net1 5.9953
XM5 s3_XM5_s s3_XM5_d s3_XM5_g VSS s3c_nfet_01v8_w24_l1_m1__nf4_gtop_sdhalf_outs
Rs3_XM5_d s3_XM5_d net1 13.4797
Rs3_XM5_g s3_XM5_g net2 44.2625
Rs3_XM5_s s3_XM5_s VSS 8.98647
V1 net2 VSS 0.75
.ends example_ota_5t_sized
.subckt s3c_pfet_01v8_w8_l1_m1__nf2_gtop_sdfull_outs S D G B SUB
X0 S G D B sky130_fd_pr__pfet_01v8 ad=1.16 pd=8.58 as=0.58 ps=4.29 w=4 l=1
X1 D G S B sky130_fd_pr__pfet_01v8 ad=0.58 pd=4.29 as=1.16 ps=8.58 w=4 l=1
C0 G S 0.60458f
C1 D B 0.14188f
C2 D S 0.40109f
C3 D G 0.53573f
C4 S B 0.54023f
C5 G B 0.61486f
C6 D SUB 0.09945f
C7 S SUB 0.31368f
C8 G SUB 0.22248f
C9 B SUB 3.5838f
.ends
.subckt s3c_nfet_01v8_w24_l0p5_m1__nf2_gtop_sdfull_outs S D G B
X0 S G D B sky130_fd_pr__nfet_01v8 ad=3.48 pd=24.58 as=1.74 ps=12.29 w=12 l=0.5
X1 D G S B sky130_fd_pr__nfet_01v8 ad=1.74 pd=12.29 as=3.48 ps=24.58 w=12 l=0.5
C0 D G 0.92615f
C1 S G 0.96993f
C2 S D 1.29958f
C3 D B 0.10524f
C4 S B 1.95283f
C5 G B 0.48785f
.ends
.subckt s3c_nfet_01v8_w24_l1_m1__nf4_gtop_sdhalf_outs S D G B
X0 S G D B sky130_fd_pr__nfet_01v8 ad=1.74 pd=12.58 as=0.87 ps=6.29 w=6 l=1
X1 D G S B sky130_fd_pr__nfet_01v8 ad=0.87 pd=6.29 as=0.87 ps=6.29 w=6 l=1
X2 S G D B sky130_fd_pr__nfet_01v8 ad=0.87 pd=6.29 as=0.87 ps=6.29 w=6 l=1
X3 D G S B sky130_fd_pr__nfet_01v8 ad=0.87 pd=6.29 as=1.74 ps=12.58 w=6 l=1
C0 S D 0.69084f
C1 S G 0.91533f
C2 G D 0.90041f
C3 D B 0.17375f
C4 S B 0.68664f
C5 G B 1.60246f
.ends
.end
