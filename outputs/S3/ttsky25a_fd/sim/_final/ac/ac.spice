* ttsky25a_fd on dido_amp_AC
.lib $PDK_ROOT/sky130A/libs.tech/combined/sky130.lib.spice tt
.param VDD_V=1.8 VCM_V=0.9 CL_F=529f
.temp 27

**.subckt dido_amp_AC
x1 INP INN OUTN VDD 0 OUTP dut_amp
Vsup VDD 0 'VDD_V'
* AC drive through 1 F couplers; DC set by unity feedback through 1 GH chokes (OUTP->INN, OUTN->INP)
Vacp ACP 0 dc 0 ac 0.5
Vacn ACN 0 dc 0 ac -0.5
Cinp ACP INP 1
Cinn ACN INN 1
Lfbp OUTP INN 1G
Lfbn OUTN INP 1G
Cloadp OUTP 0 'CL_F'
Cloadn OUTN 0 'CL_F'
.control
  save all
  ac dec 40 1 1G
  let hsig = v(OUTP) - v(OUTN)
  let hdb = db(hsig)
  let gph_deg = 180/pi * cph(hsig)
  meas ac gain_db find hdb at=1
  meas ac gbw_hz  when hdb=0
  meas ac ph_dc   find gph_deg at=1
  meas ac ph_ugb  find gph_deg when hdb=0
  let gbw_mhz = gbw_hz / 1e6
  let pm_deg  = 180 + (ph_ugb - ph_dc)
  echo MEAS gain_db $&gain_db
  echo MEAS gbw_mhz $&gbw_mhz
  echo MEAS pm_deg $&pm_deg
  write
  quit 0
.endc
**.ends

.subckt dut_amp INP INN OUTN VDD VSS OUTP
XDUT OUTP INN VDD VSS OUTN INP ttsky25a_fd
.ends

.subckt ttsky25a_fd Vop Vm Vdd Vss Vom Vp
XM32 s3_XM32_d s3_XM32_s s3_XM32_g Vdd Vss s3c_pfet_01v8_lvt_w5_l1_m2__nf1_gtop_sdfull m=2
Rs3_XM32_d s3_XM32_d NBias 21.6779
Rs3_XM32_g s3_XM32_g PBias 80.4917
Rs3_XM32_s s3_XM32_s Vdd 21.6779
XM33 s3_XM33_d s3_XM33_s s3_XM33_g Vss s3c_nfet_01v8_lvt_w5_l2_m2__nf1_gtop_sdfull m=2
Rs3_XM33_d s3_XM33_d NBias 7.39218
Rs3_XM33_g s3_XM33_g NBias 36.2133
Rs3_XM33_s s3_XM33_s Vss 7.39218
XM34 s3_XM34_d s3_XM34_s s3_XM34_g Vdd Vss s3c_pfet_01v8_lvt_w5_l1_m2__nf1_gtop_sdfull m=2
Rs3_XM34_d s3_XM34_d net1 21.6779
Rs3_XM34_g s3_XM34_g PBias 80.4917
Rs3_XM34_s s3_XM34_s Vdd 21.6779
XM35 s3_XM35_d s3_XM35_s s3_XM35_g Vss s3c_nfet_01v8_lvt_w10_l1_m2__nf1_gboth_sdfull m=2
Rs3_XM35_d s3_XM35_d net1 4.26767
Rs3_XM35_g s3_XM35_g net1 40.2458
Rs3_XM35_s s3_XM35_s Rgm 4.26767
XM36 s3_XM36_d s3_XM36_s s3_XM36_g Vss s3c_nfet_01v8_lvt_w5_l2_m2__nf1_gtop_sdfull m=2
Rs3_XM36_d s3_XM36_d net2 7.39218
Rs3_XM36_g s3_XM36_g net1 36.2133
Rs3_XM36_s s3_XM36_s Vss 7.39218
XM37 s3_XM37_d s3_XM37_s s3_XM37_g Vss s3c_nfet_01v8_lvt_w5_l2_m2__nf1_gtop_sdfull m=2
Rs3_XM37_d s3_XM37_d PBias 7.39218
Rs3_XM37_g s3_XM37_g NBias 36.2133
Rs3_XM37_s s3_XM37_s Vss 7.39218
XM38 s3_XM38_d s3_XM38_s s3_XM38_g Vdd Vss s3c_pfet_01v8_lvt_w5_l1_m2__nf1_gtop_sdfull m=2
Rs3_XM38_d s3_XM38_d PBias 21.6779
Rs3_XM38_g s3_XM38_g net2 80.4917
Rs3_XM38_s s3_XM38_s Vdd 21.6779
XM39 s3_XM39_d s3_XM39_s s3_XM39_g Vdd Vss s3c_pfet_01v8_lvt_w5_l1_m2__nf1_gtop_sdfull m=2
Rs3_XM39_d s3_XM39_d net2 21.6779
Rs3_XM39_g s3_XM39_g net2 80.4917
Rs3_XM39_s s3_XM39_s Vdd 21.6779
XM40 s3_XM40_d s3_XM40_s s3_XM40_g Vss s3c_nfet_01v8_lvt_w2_l1_m1__nf1_gtop_sdfull
Rs3_XM40_d s3_XM40_d PBias 33.0557
Rs3_XM40_g s3_XM40_g net3 112.783
Rs3_XM40_s s3_XM40_s NBias 33.0557
XM41 s3_XM41_d s3_XM41_s s3_XM41_g Vss s3c_nfet_01v8_lvt_w5_l2_m2__nf1_gtop_sdfull m=2
Rs3_XM41_d s3_XM41_d net3 7.39218
Rs3_XM41_g s3_XM41_g NBias 36.2133
Rs3_XM41_s s3_XM41_s Vss 7.39218
XM42 s3_XM42_d s3_XM42_s s3_XM42_g Vdd Vss s3c_pfet_01v8_lvt_w1_l20_m2__nf1_gtop_sdfull m=2
Rs3_XM42_d s3_XM42_d net3 99.9156
Rs3_XM42_g s3_XM42_g net3 1.79656
Rs3_XM42_s s3_XM42_s Vdd 99.9156
XM43 s3_XM43_d s3_XM43_s s3_XM43_g Vdd Vss s3c_pfet_01v8_lvt_w5_l1_m2__nf1_gtop_sdfull m=2
Rs3_XM43_d s3_XM43_d net4 21.6779
Rs3_XM43_g s3_XM43_g PBias 80.4917
Rs3_XM43_s s3_XM43_s Vdd 21.6779
XM44 s3_XM44_d s3_XM44_s s3_XM44_g Vdd Vss s3c_pfet_01v8_lvt_w5_l1_m2__nf1_gtop_sdfull m=2
Rs3_XM44_d s3_XM44_d net5 21.6779
Rs3_XM44_g s3_XM44_g PBias 80.4917
Rs3_XM44_s s3_XM44_s Vdd 21.6779
XM45 s3_XM45_d s3_XM45_s s3_XM45_g Vdd Vss s3c_pfet_01v8_lvt_w5_l1_m2__nf1_gtop_sdfull m=2
Rs3_XM45_d s3_XM45_d net6 21.6779
Rs3_XM45_g s3_XM45_g PBias 80.4917
Rs3_XM45_s s3_XM45_s Vdd 21.6779
XM54 s3_XM54_d s3_XM54_s s3_XM54_g Vdd Vss s3c_pfet_01v8_lvt_w5_l1_m2__nf1_gtop_sdfull m=2
Rs3_XM54_d s3_XM54_d net7 21.6779
Rs3_XM54_g s3_XM54_g PBias 80.4917
Rs3_XM54_s s3_XM54_s Vdd 21.6779
XX1_M5 s3_XX1_M5_d s3_XX1_M5_s s3_XX1_M5_g Vss s3c_nfet_01v8_lvt_w4_l4_m2__nf1_gboth_sdfull m=2
Rs3_XX1_M5_d s3_XX1_M5_d x1_Vtest2 9.19414
Rs3_XX1_M5_g s3_XX1_M5_g Vm 5.67424
Rs3_XX1_M5_s s3_XX1_M5_s x1_net2 9.19414
XX1_M6 s3_XX1_M6_d s3_XX1_M6_s s3_XX1_M6_g Vss s3c_nfet_01v8_lvt_w4_l4_m2__nf1_gboth_sdfull m=2
Rs3_XX1_M6_d s3_XX1_M6_d x1_net1 9.19414
Rs3_XX1_M6_g s3_XX1_M6_g Vp 5.67424
Rs3_XX1_M6_s s3_XX1_M6_s x1_net2 9.19414
XX1_M11 s3_XX1_M11_d s3_XX1_M11_s s3_XX1_M11_g Vdd Vss s3c_pfet_01v8_lvt_w2_l5_m2__nf1_gboth_sdfull m=2
Rs3_XX1_M11_d s3_XX1_M11_d Vop1 49.8612
Rs3_XX1_M11_g s3_XX1_M11_g x1_Vbias 3.69647
Rs3_XX1_M11_s s3_XX1_M11_s x1_Vtest2 49.8612
XX1_M12 s3_XX1_M12_d s3_XX1_M12_s s3_XX1_M12_g Vdd Vss s3c_pfet_01v8_lvt_w2_l5_m2__nf1_gboth_sdfull m=2
Rs3_XX1_M12_d s3_XX1_M12_d Vom1 49.8612
Rs3_XX1_M12_g s3_XX1_M12_g x1_Vbias 3.69647
Rs3_XX1_M12_s s3_XX1_M12_s x1_net1 49.8612
XX1_M13 s3_XX1_M13_d s3_XX1_M13_s s3_XX1_M13_g Vdd Vss s3c_pfet_01v8_lvt_w2_l5_m4__nf1_gboth_sdfull m=4
Rs3_XX1_M13_d s3_XX1_M13_d x1_Vtest2 24.9306
Rs3_XX1_M13_g s3_XX1_M13_g x1_Vout 1.84823
Rs3_XX1_M13_s s3_XX1_M13_s Vdd 24.9306
XX1_M14 s3_XX1_M14_d s3_XX1_M14_s s3_XX1_M14_g Vdd Vss s3c_pfet_01v8_lvt_w2_l5_m4__nf1_gboth_sdfull m=4
Rs3_XX1_M14_d s3_XX1_M14_d x1_net1 24.9306
Rs3_XX1_M14_g s3_XX1_M14_g x1_Vout 1.84823
Rs3_XX1_M14_s s3_XX1_M14_s Vdd 24.9306
XX1_M19 s3_XX1_M19_d s3_XX1_M19_s s3_XX1_M19_g Vss s3c_nfet_01v8_lvt_w1_l1_m2__nf1_gboth_sdfull m=2
Rs3_XX1_M19_d s3_XX1_M19_d x1_net2 33.2489
Rs3_XX1_M19_g s3_XX1_M19_g net5 22.1708
Rs3_XX1_M19_s s3_XX1_M19_s x1_net3 33.2489
XX1_M1 s3_XX1_M1_d s3_XX1_M1_s s3_XX1_M1_g Vss s3c_nfet_01v8_lvt_w1_l10_m2__nf1_gboth_sdfull m=2
Rs3_XX1_M1_d s3_XX1_M1_d x1_net3 33.2489
Rs3_XX1_M1_g s3_XX1_M1_g net4 1.59729
Rs3_XX1_M1_s s3_XX1_M1_s Vss 33.2489
XX1_M2 s3_XX1_M2_d s3_XX1_M2_s s3_XX1_M2_g Vss s3c_nfet_01v8_lvt_w1_l10_m2__nf1_gboth_sdfull m=2
Rs3_XX1_M2_d s3_XX1_M2_d x1_net4 33.2489
Rs3_XX1_M2_g s3_XX1_M2_g net4 1.59729
Rs3_XX1_M2_s s3_XX1_M2_s Vss 33.2489
XX1_M3 s3_XX1_M3_d s3_XX1_M3_s s3_XX1_M3_g Vss s3c_nfet_01v8_lvt_w1_l1_m2__nf1_gboth_sdfull m=2
Rs3_XX1_M3_d s3_XX1_M3_d x1_net2 33.2489
Rs3_XX1_M3_g s3_XX1_M3_g net5 22.1708
Rs3_XX1_M3_s s3_XX1_M3_s x1_net4 33.2489
XX1_M4 s3_XX1_M4_d s3_XX1_M4_s s3_XX1_M4_g Vss s3c_nfet_01v8_lvt_w1_l1_m2__nf1_gboth_sdfull m=2
Rs3_XX1_M4_d s3_XX1_M4_d Vop1 33.2489
Rs3_XX1_M4_g s3_XX1_M4_g net5 22.1708
Rs3_XX1_M4_s s3_XX1_M4_s x1_net5 33.2489
XX1_M7 s3_XX1_M7_d s3_XX1_M7_s s3_XX1_M7_g Vss s3c_nfet_01v8_lvt_w1_l10_m2__nf1_gboth_sdfull m=2
Rs3_XX1_M7_d s3_XX1_M7_d x1_net5 33.2489
Rs3_XX1_M7_g s3_XX1_M7_g net4 1.59729
Rs3_XX1_M7_s s3_XX1_M7_s Vss 33.2489
XX1_M8 s3_XX1_M8_d s3_XX1_M8_s s3_XX1_M8_g Vss s3c_nfet_01v8_lvt_w1_l1_m2__nf1_gboth_sdfull m=2
Rs3_XX1_M8_d s3_XX1_M8_d Vom1 33.2489
Rs3_XX1_M8_g s3_XX1_M8_g net5 22.1708
Rs3_XX1_M8_s s3_XX1_M8_s x1_net6 33.2489
XX1_M9 s3_XX1_M9_d s3_XX1_M9_s s3_XX1_M9_g Vss s3c_nfet_01v8_lvt_w1_l10_m2__nf1_gboth_sdfull m=2
Rs3_XX1_M9_d s3_XX1_M9_d x1_net6 33.2489
Rs3_XX1_M9_g s3_XX1_M9_g net4 1.59729
Rs3_XX1_M9_s s3_XX1_M9_s Vss 33.2489
XX1_M10 s3_XX1_M10_d s3_XX1_M10_s s3_XX1_M10_g Vss s3c_nfet_01v8_lvt_w5_l20_m2__nf1_gtop_sdfull m=2
Rs3_XX1_M10_d s3_XX1_M10_d x1_Vout 7.39218
Rs3_XX1_M10_g s3_XX1_M10_g Vref 3.40322
Rs3_XX1_M10_s s3_XX1_M10_s x1_net8 7.39218
XX1_M17 s3_XX1_M17_d s3_XX1_M17_s s3_XX1_M17_g Vss s3c_nfet_01v8_lvt_w5_l20_m2__nf1_gtop_sdfull m=2
Rs3_XX1_M17_d s3_XX1_M17_d x1_net9 7.39218
Rs3_XX1_M17_g s3_XX1_M17_g Vop1 3.40322
Rs3_XX1_M17_s s3_XX1_M17_s x1_net8 7.39218
XX1_M18 s3_XX1_M18_d s3_XX1_M18_s s3_XX1_M18_g Vss s3c_nfet_01v8_lvt_w5_l20_m2__nf1_gtop_sdfull m=2
Rs3_XX1_M18_d s3_XX1_M18_d x1_net9 7.39218
Rs3_XX1_M18_g s3_XX1_M18_g Vom1 3.40322
Rs3_XX1_M18_s s3_XX1_M18_s x1_net7 7.39218
XX1_M22 s3_XX1_M22_d s3_XX1_M22_s s3_XX1_M22_g Vss s3c_nfet_01v8_lvt_w1_l20_m2__nf1_gtop_sdfull m=2
Rs3_XX1_M22_d s3_XX1_M22_d x1_net7 33.2489
Rs3_XX1_M22_g s3_XX1_M22_g net4 1.79656
Rs3_XX1_M22_s s3_XX1_M22_s Vss 33.2489
XX1_M20 s3_XX1_M20_d s3_XX1_M20_s s3_XX1_M20_g Vdd Vss s3c_pfet_01v8_lvt_w1_l10_m2__nf1_gtop_sdfull m=2
Rs3_XX1_M20_d s3_XX1_M20_d x1_net9 99.9156
Rs3_XX1_M20_g s3_XX1_M20_g x1_net9 3.59625
Rs3_XX1_M20_s s3_XX1_M20_s Vdd 99.9156
XX1_M21 s3_XX1_M21_d s3_XX1_M21_s s3_XX1_M21_g Vdd Vss s3c_pfet_01v8_lvt_w1_l10_m2__nf1_gtop_sdfull m=2
Rs3_XX1_M21_d s3_XX1_M21_d x1_Vout 99.9156
Rs3_XX1_M21_g s3_XX1_M21_g x1_net9 3.59625
Rs3_XX1_M21_s s3_XX1_M21_s Vdd 99.9156
XX1_M15 s3_XX1_M15_d s3_XX1_M15_s s3_XX1_M15_g Vss s3c_nfet_01v8_lvt_w1_l20_m2__nf1_gtop_sdfull m=2
Rs3_XX1_M15_d s3_XX1_M15_d x1_net8 33.2489
Rs3_XX1_M15_g s3_XX1_M15_g net4 1.79656
Rs3_XX1_M15_s s3_XX1_M15_s Vss 33.2489
XX1_M16 s3_XX1_M16_d s3_XX1_M16_s s3_XX1_M16_g Vss s3c_nfet_01v8_lvt_w5_l20_m2__nf1_gtop_sdfull m=2
Rs3_XX1_M16_d s3_XX1_M16_d x1_Vout 7.39218
Rs3_XX1_M16_g s3_XX1_M16_g Vref 3.40322
Rs3_XX1_M16_s s3_XX1_M16_s x1_net7 7.39218
XX1_M46 s3_XX1_M46_d s3_XX1_M46_s s3_XX1_M46_g Vss s3c_nfet_01v8_lvt_w1_l2_m2__nf1_gboth_sdfull m=2
Rs3_XX1_M46_d s3_XX1_M46_d net4 33.2489
Rs3_XX1_M46_g s3_XX1_M46_g net4 9.06917
Rs3_XX1_M46_s s3_XX1_M46_s Vss 33.2489
XX1_M47 s3_XX1_M47_d s3_XX1_M47_s s3_XX1_M47_g Vss s3c_nfet_01v8_lvt_w0p6_l5_m2__nf1_gboth_sdfull m=2
Rs3_XX1_M47_d s3_XX1_M47_d net5 97.2043
Rs3_XX1_M47_g s3_XX1_M47_g net5 3.13413
Rs3_XX1_M47_s s3_XX1_M47_s Vss 97.2043
XX1_M23 s3_XX1_M23_d s3_XX1_M23_s s3_XX1_M23_g Vss s3c_nfet_01v8_lvt_w0p6_l1_m2__nf1_gtop_sdfull m=2
Rs3_XX1_M23_d s3_XX1_M23_d net6 97.2043
Rs3_XX1_M23_g s3_XX1_M23_g net6 45.145
Rs3_XX1_M23_s s3_XX1_M23_s Vss 97.2043
XX1_M24 s3_XX1_M24_d s3_XX1_M24_s s3_XX1_M24_g Vss s3c_nfet_01v8_lvt_w0p6_l1_m2__nf1_gtop_sdfull m=2
Rs3_XX1_M24_d s3_XX1_M24_d x1_Vbias 97.2043
Rs3_XX1_M24_g s3_XX1_M24_g net6 45.145
Rs3_XX1_M24_s s3_XX1_M24_s Vss 97.2043
XX1_M25 s3_XX1_M25_d s3_XX1_M25_s s3_XX1_M25_g Vdd Vss s3c_pfet_01v8_lvt_w1p5_l10_m2__nf1_gtop_sdfull m=2
Rs3_XX1_M25_d s3_XX1_M25_d x1_Vbias 74.4234
Rs3_XX1_M25_g s3_XX1_M25_g x1_Vbias 3.99791
Rs3_XX1_M25_s s3_XX1_M25_s Vdd 74.4234
XX2_M9 s3_XX2_M9_d s3_XX2_M9_s s3_XX2_M9_g Vdd Vss s3c_pfet_01v8_lvt_w2_l1_m9__nf1_gboth_sdfull m=9
Rs3_XX2_M9_d s3_XX2_M9_d Vop 11.0803
Rs3_XX2_M9_g s3_XX2_M9_g Vom1 5.37315
Rs3_XX2_M9_s s3_XX2_M9_s Vdd 11.0803
XX2_M4 s3_XX2_M4_d s3_XX2_M4_s s3_XX2_M4_g Vdd Vss s3c_pfet_01v8_lvt_w2_l1_m9__nf1_gboth_sdfull m=9
Rs3_XX2_M4_d s3_XX2_M4_d Vom 11.0803
Rs3_XX2_M4_g s3_XX2_M4_g Vop1 5.37315
Rs3_XX2_M4_s s3_XX2_M4_s Vdd 11.0803
XX2_M2 s3_XX2_M2_d s3_XX2_M2_s s3_XX2_M2_g Vss s3c_nfet_01v8_lvt_w1_l1_m9__nf1_gboth_sdfull m=9
Rs3_XX2_M2_d s3_XX2_M2_d Vop 7.38865
Rs3_XX2_M2_g s3_XX2_M2_g x2_Vout 4.92685
Rs3_XX2_M2_s s3_XX2_M2_s Vss 7.38865
XX2_M1 s3_XX2_M1_d s3_XX2_M1_s s3_XX2_M1_g Vss s3c_nfet_01v8_lvt_w1_l1_m9__nf1_gboth_sdfull m=9
Rs3_XX2_M1_d s3_XX2_M1_d Vom 7.38865
Rs3_XX2_M1_g s3_XX2_M1_g x2_Vout 4.92685
Rs3_XX2_M1_s s3_XX2_M1_s Vss 7.38865
XX2_M3 s3_XX2_M3_d s3_XX2_M3_s s3_XX2_M3_g Vdd Vss s3c_pfet_01v8_lvt_w1_l5_m2__nf1_gtop_sdfull m=2
Rs3_XX2_M3_d s3_XX2_M3_d x2_net1 99.9156
Rs3_XX2_M3_g s3_XX2_M3_g x2_Vbiasp 7.39293
Rs3_XX2_M3_s s3_XX2_M3_s Vdd 99.9156
XX2_M7 s3_XX2_M7_d s3_XX2_M7_s s3_XX2_M7_g Vdd Vss s3c_pfet_01v8_lvt_w1_l10_m2__nf1_gtop_sdfull m=2
Rs3_XX2_M7_d s3_XX2_M7_d x2_Vtest 99.9156
Rs3_XX2_M7_g s3_XX2_M7_g x2_Vcm 3.59625
Rs3_XX2_M7_s s3_XX2_M7_s x2_net1 99.9156
XX2_M8 s3_XX2_M8_d s3_XX2_M8_s s3_XX2_M8_g Vdd Vss s3c_pfet_01v8_lvt_w1_l10_m2__nf1_gtop_sdfull m=2
Rs3_XX2_M8_d s3_XX2_M8_d x2_Vout 99.9156
Rs3_XX2_M8_g s3_XX2_M8_g Vref 3.59625
Rs3_XX2_M8_s s3_XX2_M8_s x2_net1 99.9156
XX2_M5 s3_XX2_M5_d s3_XX2_M5_s s3_XX2_M5_g Vss s3c_nfet_01v8_lvt_w0p5_l20_m2__nf1_gtop_sdfull m=2
Rs3_XX2_M5_d s3_XX2_M5_d x2_Vtest 97.1953
Rs3_XX2_M5_g s3_XX2_M5_g x2_Vtest 1.59572
Rs3_XX2_M5_s s3_XX2_M5_s Vss 97.1953
XX2_M6 s3_XX2_M6_d s3_XX2_M6_s s3_XX2_M6_g Vss s3c_nfet_01v8_lvt_w0p5_l20_m2__nf1_gtop_sdfull m=2
Rs3_XX2_M6_d s3_XX2_M6_d x2_Vout 97.1953
Rs3_XX2_M6_g s3_XX2_M6_g x2_Vtest 1.59572
Rs3_XX2_M6_s s3_XX2_M6_s Vss 97.1953
XX2_M10 s3_XX2_M10_d s3_XX2_M10_s s3_XX2_M10_g Vss s3c_nfet_01v8_lvt_w0p6_l1_m2__nf1_gtop_sdfull m=2
Rs3_XX2_M10_d s3_XX2_M10_d net7 97.2043
Rs3_XX2_M10_g s3_XX2_M10_g net7 45.145
Rs3_XX2_M10_s s3_XX2_M10_s Vss 97.2043
XX2_M11 s3_XX2_M11_d s3_XX2_M11_s s3_XX2_M11_g Vss s3c_nfet_01v8_lvt_w0p6_l1_m2__nf1_gtop_sdfull m=2
Rs3_XX2_M11_d s3_XX2_M11_d x2_Vbiasp 97.2043
Rs3_XX2_M11_g s3_XX2_M11_g net7 45.145
Rs3_XX2_M11_s s3_XX2_M11_s Vss 97.2043
XX2_M12 s3_XX2_M12_d s3_XX2_M12_s s3_XX2_M12_g Vdd Vss s3c_pfet_01v8_lvt_w6_l1_m2__nf1_gtop_sdfull m=2
Rs3_XX2_M12_d s3_XX2_M12_d x2_Vbiasp 18.04
Rs3_XX2_M12_g s3_XX2_M12_g x2_Vbiasp 88.525
Rs3_XX2_M12_s s3_XX2_M12_s Vdd 18.04
Vref_ext Vref Vss 0.9
XC1 Vop1 Vom sky130_fd_pr__cap_mim_m3_1 W=10 L=10 MF=5 M=5
XC2 Vom1 Vop sky130_fd_pr__cap_mim_m3_1 W=10 L=10 MF=5 M=5
XX2_X1_R1 x2_x1_net4 Vop sky130_fd_pr__res_generic_po W=0.5 L=40
XX2_X1_R2 x2_x1_net5 x2_x1_net4 sky130_fd_pr__res_generic_po W=0.5 L=40
XX2_X1_R3 x2_x1_net6 x2_x1_net5 sky130_fd_pr__res_generic_po W=0.5 L=40
XX2_X1_R4 x2_x1_net7 x2_x1_net6 sky130_fd_pr__res_generic_po W=0.5 L=40
XX2_X1_R5 x2_x1_net1 x2_x1_net7 sky130_fd_pr__res_generic_po W=0.5 L=40
XX2_X1_R6 x2_x1_net8 x2_x1_net2 sky130_fd_pr__res_generic_po W=0.5 L=40
XX2_X1_R7 x2_x1_net9 x2_x1_net8 sky130_fd_pr__res_generic_po W=0.5 L=40
XX2_X1_R8 x2_x1_net10 x2_x1_net9 sky130_fd_pr__res_generic_po W=0.5 L=40
XX2_X1_R9 x2_x1_net11 x2_x1_net10 sky130_fd_pr__res_generic_po W=0.5 L=40
XX2_X1_R10 x2_x1_net1 x2_x1_net11 sky130_fd_pr__res_generic_po W=0.5 L=40
XX2_X1_R11 x2_x1_net12 x2_x1_net2 sky130_fd_pr__res_generic_po W=0.5 L=40
XX2_X1_R12 x2_x1_net13 x2_x1_net12 sky130_fd_pr__res_generic_po W=0.5 L=40
XX2_X1_R13 x2_x1_net14 x2_x1_net13 sky130_fd_pr__res_generic_po W=0.5 L=40
XX2_X1_R14 x2_x1_net15 x2_x1_net14 sky130_fd_pr__res_generic_po W=0.5 L=40
XX2_X1_R16 x2_x1_net16 x2_Vcm sky130_fd_pr__res_generic_po W=0.5 L=40
XX2_X1_R17 x2_x1_net17 x2_x1_net16 sky130_fd_pr__res_generic_po W=0.5 L=40
XX2_X1_R18 x2_x1_net18 x2_x1_net17 sky130_fd_pr__res_generic_po W=0.5 L=40
XX2_X1_R19 x2_x1_net19 x2_x1_net18 sky130_fd_pr__res_generic_po W=0.5 L=40
XX2_X1_R20 x2_x1_net3 x2_x1_net19 sky130_fd_pr__res_generic_po W=0.5 L=40
XX2_X1_R15 x2_x1_net3 x2_x1_net15 sky130_fd_pr__res_generic_po W=0.5 L=40
XX2_X2_R1 x2_x2_net4 x2_Vcm sky130_fd_pr__res_generic_po W=0.5 L=40
XX2_X2_R2 x2_x2_net5 x2_x2_net4 sky130_fd_pr__res_generic_po W=0.5 L=40
XX2_X2_R3 x2_x2_net6 x2_x2_net5 sky130_fd_pr__res_generic_po W=0.5 L=40
XX2_X2_R4 x2_x2_net7 x2_x2_net6 sky130_fd_pr__res_generic_po W=0.5 L=40
XX2_X2_R5 x2_x2_net1 x2_x2_net7 sky130_fd_pr__res_generic_po W=0.5 L=40
XX2_X2_R6 x2_x2_net8 x2_x2_net2 sky130_fd_pr__res_generic_po W=0.5 L=40
XX2_X2_R7 x2_x2_net9 x2_x2_net8 sky130_fd_pr__res_generic_po W=0.5 L=40
XX2_X2_R8 x2_x2_net10 x2_x2_net9 sky130_fd_pr__res_generic_po W=0.5 L=40
XX2_X2_R9 x2_x2_net11 x2_x2_net10 sky130_fd_pr__res_generic_po W=0.5 L=40
XX2_X2_R10 x2_x2_net1 x2_x2_net11 sky130_fd_pr__res_generic_po W=0.5 L=40
XX2_X2_R11 x2_x2_net12 x2_x2_net2 sky130_fd_pr__res_generic_po W=0.5 L=40
XX2_X2_R12 x2_x2_net13 x2_x2_net12 sky130_fd_pr__res_generic_po W=0.5 L=40
XX2_X2_R13 x2_x2_net14 x2_x2_net13 sky130_fd_pr__res_generic_po W=0.5 L=40
XX2_X2_R14 x2_x2_net15 x2_x2_net14 sky130_fd_pr__res_generic_po W=0.5 L=40
XX2_X2_R16 x2_x2_net16 Vom sky130_fd_pr__res_generic_po W=0.5 L=40
XX2_X2_R17 x2_x2_net17 x2_x2_net16 sky130_fd_pr__res_generic_po W=0.5 L=40
XX2_X2_R18 x2_x2_net18 x2_x2_net17 sky130_fd_pr__res_generic_po W=0.5 L=40
XX2_X2_R19 x2_x2_net19 x2_x2_net18 sky130_fd_pr__res_generic_po W=0.5 L=40
XX2_X2_R20 x2_x2_net3 x2_x2_net19 sky130_fd_pr__res_generic_po W=0.5 L=40
XX2_X2_R15 x2_x2_net3 x2_x2_net15 sky130_fd_pr__res_generic_po W=0.5 L=40
Rgm_ext Rgm Vss 12000
.ends ttsky25a_fd
.subckt s3c_pfet_01v8_lvt_w5_l1_m2__nf1_gtop_sdfull D S G B SUB
X0 S G D B sky130_fd_pr__pfet_01v8_lvt ad=1.45 pd=10.58 as=1.45 ps=10.58 w=5 l=1
C0 S D 0.14835f
C1 B D 0.32032f
C2 G S 0.27238f
C3 B G 0.31364f
C4 B S 0.32032f
C5 G D 0.27238f
C6 S SUB 0.14408f
C7 D SUB 0.14408f
C8 G SUB 0.11454f
C9 B SUB 3.04361f
.ends
.subckt s3c_nfet_01v8_lvt_w5_l2_m2__nf1_gtop_sdfull D S G B
X0 S G D B sky130_fd_pr__nfet_01v8_lvt ad=1.45 pd=10.58 as=1.45 ps=10.58 w=5 l=2
C0 D S 0.08154f
C1 S G 0.35567f
C2 D G 0.35567f
C3 S B 0.41135f
C4 D B 0.41135f
C5 G B 0.71194f
.ends
.subckt s3c_nfet_01v8_lvt_w10_l1_m2__nf1_gboth_sdfull D S G B
X0 S G D B sky130_fd_pr__nfet_01v8_lvt ad=2.9 pd=20.58 as=2.9 ps=20.58 w=10 l=1
C0 D S 0.2963f
C1 G S 0.54327f
C2 G D 0.54327f
C3 S B 0.78302f
C4 D B 0.78302f
C5 G B 0.5633f
.ends
.subckt s3c_nfet_01v8_lvt_w2_l1_m1__nf1_gtop_sdfull D S G B
X0 S G D B sky130_fd_pr__nfet_01v8_lvt ad=0.58 pd=4.58 as=0.58 ps=4.58 w=2 l=1
C0 D S 0.05958f
C1 S G 0.10986f
C2 D G 0.10986f
C3 S B 0.18744f
C4 D B 0.18744f
C5 G B 0.41337f
.ends
.subckt s3c_pfet_01v8_lvt_w1_l20_m2__nf1_gtop_sdfull D S G B SUB
X0 S G D B sky130_fd_pr__pfet_01v8_lvt ad=0.29 pd=2.58 as=0.29 ps=2.58 w=1 l=20
C0 B G 4.93691f
C1 S G 0.08977f
C2 S B 0.09984f
C3 D G 0.08977f
C4 D B 0.09984f
C5 S SUB 0.05403f
C6 D SUB 0.05403f
C7 G SUB 1.89198f
C8 B SUB 8.87363f
.ends
.subckt s3c_nfet_01v8_lvt_w4_l4_m2__nf1_gboth_sdfull D S G B
X0 S G D B sky130_fd_pr__nfet_01v8_lvt ad=1.16 pd=8.58 as=1.16 ps=8.58 w=4 l=4
C0 D G 0.32885f
C1 D S 0.03387f
C2 S G 0.32885f
C3 S B 0.33664f
C4 D B 0.33664f
C5 G B 1.65938f
.ends
.subckt s3c_pfet_01v8_lvt_w2_l5_m2__nf1_gboth_sdfull D S G B SUB
X0 S G D B sky130_fd_pr__pfet_01v8_lvt ad=0.58 pd=4.58 as=0.58 ps=4.58 w=2 l=5
C0 G S 0.1702f
C1 B G 1.72808f
C2 B S 0.17609f
C3 G D 0.1702f
C4 S D 0.01368f
C5 B D 0.17609f
C6 S SUB 0.06872f
C7 D SUB 0.06872f
C8 G SUB 0.55883f
C9 B SUB 4.22298f
.ends
.subckt s3c_pfet_01v8_lvt_w2_l5_m4__nf1_gboth_sdfull D S G B SUB
X0 S G D B sky130_fd_pr__pfet_01v8_lvt ad=0.58 pd=4.58 as=0.58 ps=4.58 w=2 l=5
C0 G D 0.1702f
C1 S D 0.01368f
C2 B D 0.17609f
C3 G S 0.1702f
C4 B G 1.72808f
C5 B S 0.17609f
C6 S SUB 0.06872f
C7 D SUB 0.06872f
C8 G SUB 0.55883f
C9 B SUB 4.22298f
.ends
.subckt s3c_nfet_01v8_lvt_w1_l1_m2__nf1_gboth_sdfull D S G B
X0 S G D B sky130_fd_pr__nfet_01v8_lvt ad=0.29 pd=2.58 as=0.29 ps=2.58 w=1 l=1
C0 D S 0.02999f
C1 S G 0.05568f
C2 D G 0.05568f
C3 S B 0.10929f
C4 D B 0.10929f
C5 G B 0.53975f
.ends
.subckt s3c_nfet_01v8_lvt_w1_l10_m2__nf1_gboth_sdfull D S G B
X0 S G D B sky130_fd_pr__nfet_01v8_lvt ad=0.29 pd=2.58 as=0.29 ps=2.58 w=1 l=10
C0 G S 0.08977f
C1 G D 0.08977f
C2 S B 0.12137f
C3 D B 0.12137f
C4 G B 3.87276f
.ends
.subckt s3c_nfet_01v8_lvt_w5_l20_m2__nf1_gtop_sdfull D S G B
X0 S G D B sky130_fd_pr__nfet_01v8_lvt ad=1.45 pd=10.58 as=1.45 ps=10.58 w=5 l=20
C0 S G 0.44075f
C1 D G 0.44075f
C2 S B 0.47447f
C3 D B 0.47447f
C4 G B 6.17702f
.ends
.subckt s3c_nfet_01v8_lvt_w1_l20_m2__nf1_gtop_sdfull D S G B
X0 S G D B sky130_fd_pr__nfet_01v8_lvt ad=0.29 pd=2.58 as=0.29 ps=2.58 w=1 l=20
C0 S G 0.08977f
C1 D G 0.08977f
C2 S B 0.12367f
C3 D B 0.12367f
C4 G B 6.47467f
.ends
.subckt s3c_pfet_01v8_lvt_w1_l10_m2__nf1_gtop_sdfull D S G B SUB
X0 S G D B sky130_fd_pr__pfet_01v8_lvt ad=0.29 pd=2.58 as=0.29 ps=2.58 w=1 l=10
C0 B G 2.51997f
C1 S G 0.08977f
C2 D G 0.08977f
C3 B S 0.09984f
C4 B D 0.09984f
C5 S SUB 0.05403f
C6 D SUB 0.05403f
C7 G SUB 0.96207f
C8 B SUB 4.9128f
.ends
.subckt s3c_nfet_01v8_lvt_w1_l2_m2__nf1_gboth_sdfull D S G B
X0 S G D B sky130_fd_pr__nfet_01v8_lvt ad=0.29 pd=2.58 as=0.29 ps=2.58 w=1 l=2
C0 D S 0.01649f
C1 S G 0.07256f
C2 D G 0.07256f
C3 S B 0.10922f
C4 D B 0.10922f
C5 G B 0.91292f
.ends
.subckt s3c_nfet_01v8_lvt_w0p6_l5_m2__nf1_gboth_sdfull D S G B
X0 S G D B sky130_fd_pr__nfet_01v8_lvt ad=0.174 pd=1.78 as=0.174 ps=1.78 w=0.6 l=5
C0 S G 0.05244f
C1 D G 0.05244f
C2 D S 0.00417f
C3 S B 0.07861f
C4 D B 0.07861f
C5 G B 2.02757f
.ends
.subckt s3c_nfet_01v8_lvt_w0p6_l1_m2__nf1_gtop_sdfull D S G B
X0 S G D B sky130_fd_pr__nfet_01v8_lvt ad=0.174 pd=1.78 as=0.174 ps=1.78 w=0.6 l=1
C0 D S 0.01816f
C1 S G 0.03401f
C2 D G 0.03401f
C3 S B 0.08046f
C4 D B 0.08046f
C5 G B 0.42438f
.ends
.subckt s3c_pfet_01v8_lvt_w1p5_l10_m2__nf1_gtop_sdfull D S G B SUB
X0 S G D B sky130_fd_pr__pfet_01v8_lvt ad=0.435 pd=3.58 as=0.435 ps=3.58 w=1.5 l=10
C0 B G 2.53895f
C1 S G 0.13364f
C2 D G 0.13364f
C3 B S 0.12121f
C4 B D 0.12121f
C5 S SUB 0.07353f
C6 D SUB 0.07353f
C7 G SUB 0.93351f
C8 B SUB 5.63195f
.ends
.subckt s3c_pfet_01v8_lvt_w2_l1_m9__nf1_gboth_sdfull D S G B SUB
X0 S G D B sky130_fd_pr__pfet_01v8_lvt ad=0.58 pd=4.58 as=0.58 ps=4.58 w=2 l=1
C0 G D 0.10986f
C1 S D 0.05958f
C2 B D 0.14797f
C3 G S 0.10986f
C4 B G 0.42288f
C5 B S 0.14797f
C6 S SUB 0.06594f
C7 D SUB 0.06594f
C8 G SUB 0.15704f
C9 B SUB 1.93927f
.ends
.subckt s3c_nfet_01v8_lvt_w1_l1_m9__nf1_gboth_sdfull D S G B
X0 S G D B sky130_fd_pr__nfet_01v8_lvt ad=0.29 pd=2.58 as=0.29 ps=2.58 w=1 l=1
C0 D S 0.02999f
C1 S G 0.05568f
C2 D G 0.05568f
C3 S B 0.10929f
C4 D B 0.10929f
C5 G B 0.53975f
.ends
.subckt s3c_pfet_01v8_lvt_w1_l5_m2__nf1_gtop_sdfull D S G B SUB
X0 S G D B sky130_fd_pr__pfet_01v8_lvt ad=0.29 pd=2.58 as=0.29 ps=2.58 w=1 l=5
C0 G S 0.08609f
C1 B G 1.30057f
C2 B S 0.09789f
C3 G D 0.08609f
C4 S D 0.00689f
C5 B D 0.09789f
C6 S SUB 0.04218f
C7 D SUB 0.04218f
C8 G SUB 0.49712f
C9 B SUB 2.92575f
.ends
.subckt s3c_nfet_01v8_lvt_w0p5_l20_m2__nf1_gtop_sdfull D S G B
X0 S G D B sky130_fd_pr__nfet_01v8_lvt ad=0.145 pd=1.58 as=0.145 ps=1.58 w=0.5 l=20
C0 D G 0.0459f
C1 S G 0.0459f
C2 S B 0.07843f
C3 D B 0.07843f
C4 G B 6.58813f
.ends
.subckt s3c_pfet_01v8_lvt_w6_l1_m2__nf1_gtop_sdfull D S G B SUB
X0 S G D B sky130_fd_pr__pfet_01v8_lvt ad=1.74 pd=12.58 as=1.74 ps=12.58 w=6 l=1
C0 B G 0.31387f
C1 S G 0.32656f
C2 D G 0.32656f
C3 B S 0.38514f
C4 B D 0.38514f
C5 D S 0.17794f
C6 S SUB 0.17171f
C7 D SUB 0.17171f
C8 G SUB 0.11371f
C9 B SUB 3.46988f
.ends
.end
