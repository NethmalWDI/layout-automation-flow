* NGSPICE file created from nfet_01v8_lvt_W10_L1_m2__nf8_gtop_sdfull_outD.ext - technology: sky130A

.subckt sky130_fd_pr__nfet_01v8_lvt_E5UCWF G B D6 D4 D2 D0 S7 S5 a_1003_n156# S3 S1
X0 D4 G S3 B sky130_fd_pr__nfet_01v8_lvt ad=0.18125 pd=1.54 as=0.18125 ps=1.54 w=1.25 l=1
X1 S5 G D4 B sky130_fd_pr__nfet_01v8_lvt ad=0.18125 pd=1.54 as=0.18125 ps=1.54 w=1.25 l=1
X2 D2 G S1 B sky130_fd_pr__nfet_01v8_lvt ad=0.18125 pd=1.54 as=0.18125 ps=1.54 w=1.25 l=1
X3 S1 G D0 B sky130_fd_pr__nfet_01v8_lvt ad=0.18125 pd=1.54 as=0.3625 ps=3.08 w=1.25 l=1
X4 S3 G D2 B sky130_fd_pr__nfet_01v8_lvt ad=0.18125 pd=1.54 as=0.18125 ps=1.54 w=1.25 l=1
X5 S7 G D6 B sky130_fd_pr__nfet_01v8_lvt ad=0.18125 pd=1.54 as=0.18125 ps=1.54 w=1.25 l=1
X6 a_1003_n156# G S7 B sky130_fd_pr__nfet_01v8_lvt ad=0.3625 pd=3.08 as=0.18125 ps=1.54 w=1.25 l=1
X7 D6 G S5 B sky130_fd_pr__nfet_01v8_lvt ad=0.18125 pd=1.54 as=0.18125 ps=1.54 w=1.25 l=1
.ends

.subckt nfet_01v8_lvt_W10_L1_m2__nf8_gtop_sdfull_outD S D G B
Xnfet_01v8_lvt_W10_L1_m2__nf8_gtop_sdfull_outD_pc G B D D D D S S D S S sky130_fd_pr__nfet_01v8_lvt_E5UCWF
.ends
