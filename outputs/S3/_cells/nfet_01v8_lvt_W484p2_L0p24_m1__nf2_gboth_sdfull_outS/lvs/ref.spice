.subckt nfet_01v8_lvt_W484p2_L0p24_m1__nf2_gboth_sdfull_outS D G S B
Xnfet_01v8_lvt_W484p2_L0p24_m1__nf2_gboth_sdfull_outS D G S B sky130_fd_pr__nfet_01v8_lvt L=0.24 W=484.2 nf=2
.ends
