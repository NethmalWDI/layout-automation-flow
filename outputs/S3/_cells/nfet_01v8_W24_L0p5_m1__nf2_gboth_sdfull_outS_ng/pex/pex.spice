* NGSPICE file created from nfet_01v8_W24_L0p5_m1__nf2_gboth_sdfull_outS_ng.ext - technology: sky130A

.subckt nfet_01v8_W24_L0p5_m1__nf2_gboth_sdfull_outS_ng S D G B
X0 D G S B sky130_fd_pr__nfet_01v8 ad=1.74 pd=12.29 as=3.48 ps=24.58 w=12 l=0.5
X1 S G D B sky130_fd_pr__nfet_01v8 ad=3.48 pd=24.58 as=1.74 ps=12.29 w=12 l=0.5
C0 S D 1.29958f
C1 G D 0.99362f
C2 G S 0.99645f
C3 D B 0.09221f
C4 S B 1.99937f
C5 G B 0.69199f
.ends
