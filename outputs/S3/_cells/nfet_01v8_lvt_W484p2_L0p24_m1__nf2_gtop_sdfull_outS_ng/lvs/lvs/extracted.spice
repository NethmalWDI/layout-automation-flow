* NGSPICE file created from nfet_01v8_lvt_W484p2_L0p24_m1__nf2_gtop_sdfull_outS_ng.ext - technology: sky130A

.subckt sky130_fd_pr__nfet_01v8_lvt_87EBZP G a_77_n24241# D0 S1 VSUBS
X0 a_77_n24241# G S1 VSUBS sky130_fd_pr__nfet_01v8_lvt ad=70.209 pd=484.78 as=35.1045 ps=242.39 w=242.10001 l=0.24
X1 S1 G D0 VSUBS sky130_fd_pr__nfet_01v8_lvt ad=35.1045 pd=242.39 as=70.209 ps=484.78 w=242.10001 l=0.24
.ends

.subckt nfet_01v8_lvt_W484p2_L0p24_m1__nf2_gtop_sdfull_outS_ng S D G B
Xnfet_01v8_lvt_W484p2_L0p24_m1__nf2_gtop_sdfull_outS_ng_pc G S S D B sky130_fd_pr__nfet_01v8_lvt_87EBZP
.ends
