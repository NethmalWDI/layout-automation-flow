* NGSPICE file created from nfet_01v8_lvt_W66p13_L2p03_m1__nf1_gtop_sdhalf.ext - technology: sky130A

.subckt sky130_fd_pr__nfet_01v8_lvt_WGCJY2 G D B S
X0 S G D B sky130_fd_pr__nfet_01v8_lvt ad=19.1777 pd=132.84 as=19.1777 ps=132.84 w=66.13 l=2.03
.ends

.subckt nfet_01v8_lvt_W66p13_L2p03_m1__nf1_gtop_sdhalf D S G B
Xnfet_01v8_lvt_W66p13_L2p03_m1__nf1_gtop_sdhalf_pc G D B S sky130_fd_pr__nfet_01v8_lvt_WGCJY2
.ends
