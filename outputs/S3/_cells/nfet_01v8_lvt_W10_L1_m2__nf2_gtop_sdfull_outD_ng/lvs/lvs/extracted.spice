* NGSPICE file created from nfet_01v8_lvt_W10_L1_m2__nf2_gtop_sdfull_outD_ng.ext - technology: sky130A

.subckt sky130_fd_pr__nfet_01v8_lvt_T3WZVG G a_229_n531# D0 S1 VSUBS
X0 S1 G D0 VSUBS sky130_fd_pr__nfet_01v8_lvt ad=0.725 pd=5.29 as=1.45 ps=10.58 w=5 l=1
X1 a_229_n531# G S1 VSUBS sky130_fd_pr__nfet_01v8_lvt ad=1.45 pd=10.58 as=0.725 ps=5.29 w=5 l=1
.ends

.subckt nfet_01v8_lvt_W10_L1_m2__nf2_gtop_sdfull_outD_ng S D G B
Xnfet_01v8_lvt_W10_L1_m2__nf2_gtop_sdfull_outD_ng_pc G D D S B sky130_fd_pr__nfet_01v8_lvt_T3WZVG
.ends
