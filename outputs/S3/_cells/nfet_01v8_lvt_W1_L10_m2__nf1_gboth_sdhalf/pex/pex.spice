* NGSPICE file created from nfet_01v8_lvt_W1_L10_m2__nf1_gboth_sdhalf.ext - technology: sky130A

.subckt nfet_01v8_lvt_W1_L10_m2__nf1_gboth_sdhalf D S G B
X0 S G D B sky130_fd_pr__nfet_01v8_lvt ad=0.29 pd=2.58 as=0.29 ps=2.58 w=1 l=10
C0 G S 0.05097f
C1 G D 0.05097f
C2 S B 0.08318f
C3 D B 0.08318f
C4 G B 3.89117f
.ends
