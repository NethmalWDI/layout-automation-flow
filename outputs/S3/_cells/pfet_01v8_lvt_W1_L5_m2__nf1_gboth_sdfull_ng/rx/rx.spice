* NGSPICE file created from pfet_01v8_lvt_W1_L5_m2__nf1_gboth_sdfull_ng.ext - technology: sky130A

X0 S G D B sky130_fd_pr__pfet_01v8_lvt ad=0.29 pd=2.58 as=0.29 ps=2.58 w=1 l=5
C0 B G 0.76808f
C1 B D 0.04137f
C2 G S 0.08609f
C3 S D 0.00689f
C4 G D 0.08609f
C5 B S 0.04137f
C6 S VSUBS 0.09993f
C7 D VSUBS 0.09993f
C8 G VSUBS 1.38828f
C9 B VSUBS 1.4256f
