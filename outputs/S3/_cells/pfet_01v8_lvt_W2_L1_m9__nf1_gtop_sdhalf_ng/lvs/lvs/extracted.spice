* NGSPICE file created from pfet_01v8_lvt_W2_L1_m9__nf1_gtop_sdhalf_ng.ext - technology: sky130A

.subckt sky130_fd_pr__pfet_01v8_lvt_77NRKJ G D S w_n194_n298#
X0 S G D w_n194_n298# sky130_fd_pr__pfet_01v8_lvt ad=0.58 pd=4.58 as=0.58 ps=4.58 w=2 l=1
.ends

.subckt pfet_01v8_lvt_W2_L1_m9__nf1_gtop_sdhalf_ng D S G B
Xpfet_01v8_lvt_W2_L1_m9__nf1_gtop_sdhalf_ng_pc G D S B sky130_fd_pr__pfet_01v8_lvt_77NRKJ
.ends
