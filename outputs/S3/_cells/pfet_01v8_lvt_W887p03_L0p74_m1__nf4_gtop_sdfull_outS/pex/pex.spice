* NGSPICE file created from pfet_01v8_lvt_W887p03_L0p74_m1__nf4_gtop_sdfull_outS.ext - technology: sky130A

.subckt pfet_01v8_lvt_W887p03_L0p74_m1__nf4_gtop_sdfull_outS S D G B
X0 S G D B sky130_fd_pr__pfet_01v8_lvt ad=32.1552 pd=222.05 as=32.1552 ps=222.05 w=221.75999 l=0.74
X1 S G D B sky130_fd_pr__pfet_01v8_lvt ad=64.3104 pd=444.10001 as=32.1552 ps=222.05 w=221.75999 l=0.74
X2 D G S B sky130_fd_pr__pfet_01v8_lvt ad=32.1552 pd=222.05 as=32.1552 ps=222.05 w=221.75999 l=0.74
X3 D G S B sky130_fd_pr__pfet_01v8_lvt ad=32.1552 pd=222.05 as=64.3104 ps=444.10001 w=221.75999 l=0.74
C0 B G 0.93564f
C1 D G 40.9551f
C2 G S 41.06379f
C3 D B 9.66603f
C4 B S 30.51749f
C5 D S 33.28658f
C6 S VSUBS 11.97876f
C7 G VSUBS 0.33047f
C8 B VSUBS 0.17182p
.ends
