* NGSPICE file created from nfet_01v8_lvt_W484p2_L0p24_m1__nf1_gboth_sdfull_ng.ext - technology: sky130A

X0 S nfet_01v8_lvt_W484p2_L0p24_m1__nf1_gboth_sdfull_ng_pc/G.t0 D B sky130_fd_pr__nfet_01v8_lvt ad=140.418 pd=968.97998 as=140.418 ps=968.97998 w=484.20001 l=0.24
C0 S G 9.46369f
C1 D G 9.46369f
C2 D S 34.7351f
R0 G nfet_01v8_lvt_W484p2_L0p24_m1__nf1_gboth_sdfull_ng_pc/G.t0 48829.3
R1 nfet_01v8_lvt_W484p2_L0p24_m1__nf1_gboth_sdfull_ng_pc/G.t0 G 48829.3
C3 G B 9.77073f
C4 S B 40.48745f
C5 D B 40.48745f
C6 nfet_01v8_lvt_W484p2_L0p24_m1__nf1_gboth_sdfull_ng_pc/G.t0 B 9.45823f ; **FLOATING
