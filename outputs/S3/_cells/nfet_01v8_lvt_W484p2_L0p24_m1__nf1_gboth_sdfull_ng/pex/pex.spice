* NGSPICE file created from nfet_01v8_lvt_W484p2_L0p24_m1__nf1_gboth_sdfull_ng.ext - technology: sky130A

.subckt nfet_01v8_lvt_W484p2_L0p24_m1__nf1_gboth_sdfull_ng D S G B
X0 S G D B sky130_fd_pr__nfet_01v8_lvt ad=140.418 pd=968.97998 as=140.418 ps=968.97998 w=484.20001 l=0.24
C0 D S 34.7351f
C1 G D 9.46369f
C2 G S 9.46369f
C3 G B 0.29681f
C4 S B 38.2068f
C5 D B 38.2068f
.ends
