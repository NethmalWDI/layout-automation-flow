* NGSPICE file created from pfet_01v8_lvt_W887p03_L0p74_m1__nf32_gtop_sdfull_outD.ext - technology: sky130A

.subckt pfet_01v8_lvt_W887p03_L0p74_m1__nf32_gtop_sdfull_outD S D G B
X0 S G D B sky130_fd_pr__pfet_01v8_lvt ad=4.0194 pd=28.01 as=4.0194 ps=28.01 w=27.72 l=0.74
X1 S G D B sky130_fd_pr__pfet_01v8_lvt ad=4.0194 pd=28.01 as=4.0194 ps=28.01 w=27.72 l=0.74
X2 S G D B sky130_fd_pr__pfet_01v8_lvt ad=4.0194 pd=28.01 as=4.0194 ps=28.01 w=27.72 l=0.74
X3 S G D B sky130_fd_pr__pfet_01v8_lvt ad=4.0194 pd=28.01 as=4.0194 ps=28.01 w=27.72 l=0.74
X4 D G S B sky130_fd_pr__pfet_01v8_lvt ad=4.0194 pd=28.01 as=4.0194 ps=28.01 w=27.72 l=0.74
X5 D G S B sky130_fd_pr__pfet_01v8_lvt ad=4.0194 pd=28.01 as=4.0194 ps=28.01 w=27.72 l=0.74
X6 D G S B sky130_fd_pr__pfet_01v8_lvt ad=4.0194 pd=28.01 as=4.0194 ps=28.01 w=27.72 l=0.74
X7 S G D B sky130_fd_pr__pfet_01v8_lvt ad=4.0194 pd=28.01 as=4.0194 ps=28.01 w=27.72 l=0.74
X8 S G D B sky130_fd_pr__pfet_01v8_lvt ad=4.0194 pd=28.01 as=4.0194 ps=28.01 w=27.72 l=0.74
X9 D G S B sky130_fd_pr__pfet_01v8_lvt ad=4.0194 pd=28.01 as=4.0194 ps=28.01 w=27.72 l=0.74
X10 S G D B sky130_fd_pr__pfet_01v8_lvt ad=4.0194 pd=28.01 as=4.0194 ps=28.01 w=27.72 l=0.74
X11 D G S B sky130_fd_pr__pfet_01v8_lvt ad=4.0194 pd=28.01 as=4.0194 ps=28.01 w=27.72 l=0.74
X12 S G D B sky130_fd_pr__pfet_01v8_lvt ad=4.0194 pd=28.01 as=4.0194 ps=28.01 w=27.72 l=0.74
X13 S G D B sky130_fd_pr__pfet_01v8_lvt ad=4.0194 pd=28.01 as=4.0194 ps=28.01 w=27.72 l=0.74
X14 D G S B sky130_fd_pr__pfet_01v8_lvt ad=4.0194 pd=28.01 as=4.0194 ps=28.01 w=27.72 l=0.74
X15 S G D B sky130_fd_pr__pfet_01v8_lvt ad=4.0194 pd=28.01 as=4.0194 ps=28.01 w=27.72 l=0.74
X16 S G D B sky130_fd_pr__pfet_01v8_lvt ad=4.0194 pd=28.01 as=4.0194 ps=28.01 w=27.72 l=0.74
X17 S G D B sky130_fd_pr__pfet_01v8_lvt ad=4.0194 pd=28.01 as=4.0194 ps=28.01 w=27.72 l=0.74
X18 D G S B sky130_fd_pr__pfet_01v8_lvt ad=4.0194 pd=28.01 as=4.0194 ps=28.01 w=27.72 l=0.74
X19 D G S B sky130_fd_pr__pfet_01v8_lvt ad=4.0194 pd=28.01 as=4.0194 ps=28.01 w=27.72 l=0.74
X20 S G D B sky130_fd_pr__pfet_01v8_lvt ad=4.0194 pd=28.01 as=4.0194 ps=28.01 w=27.72 l=0.74
X21 D G S B sky130_fd_pr__pfet_01v8_lvt ad=4.0194 pd=28.01 as=4.0194 ps=28.01 w=27.72 l=0.74
X22 D G S B sky130_fd_pr__pfet_01v8_lvt ad=4.0194 pd=28.01 as=4.0194 ps=28.01 w=27.72 l=0.74
X23 D G S B sky130_fd_pr__pfet_01v8_lvt ad=4.0194 pd=28.01 as=4.0194 ps=28.01 w=27.72 l=0.74
X24 D G S B sky130_fd_pr__pfet_01v8_lvt ad=4.0194 pd=28.01 as=4.0194 ps=28.01 w=27.72 l=0.74
X25 S G D B sky130_fd_pr__pfet_01v8_lvt ad=4.0194 pd=28.01 as=4.0194 ps=28.01 w=27.72 l=0.74
X26 S G D B sky130_fd_pr__pfet_01v8_lvt ad=4.0194 pd=28.01 as=8.0388 ps=56.02 w=27.72 l=0.74
X27 D G S B sky130_fd_pr__pfet_01v8_lvt ad=4.0194 pd=28.01 as=4.0194 ps=28.01 w=27.72 l=0.74
X28 D G S B sky130_fd_pr__pfet_01v8_lvt ad=4.0194 pd=28.01 as=4.0194 ps=28.01 w=27.72 l=0.74
X29 S G D B sky130_fd_pr__pfet_01v8_lvt ad=4.0194 pd=28.01 as=4.0194 ps=28.01 w=27.72 l=0.74
X30 D G S B sky130_fd_pr__pfet_01v8_lvt ad=8.0388 pd=56.02 as=4.0194 ps=28.01 w=27.72 l=0.74
X31 D G S B sky130_fd_pr__pfet_01v8_lvt ad=4.0194 pd=28.01 as=4.0194 ps=28.01 w=27.72 l=0.74
C0 G D 42.27475f
C1 G B 7.07983f
C2 D S 34.86456f
C3 B S 9.91183f
C4 G S 43.14419f
C5 B D 12.64208f
C6 S VSUBS 1.02433f
C7 D VSUBS 1.92989f
C8 G VSUBS 2.41114f
C9 B VSUBS 0.12673p
.ends
