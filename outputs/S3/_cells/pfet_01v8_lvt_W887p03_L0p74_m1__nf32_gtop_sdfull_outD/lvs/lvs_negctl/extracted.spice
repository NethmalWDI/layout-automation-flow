* NGSPICE file created from pfet_01v8_lvt_W887p03_L0p74_m1__nf32_gtop_sdfull_outD.ext - technology: sky130A

.subckt sky130_fd_pr__pfet_01v8_lvt_DLGRS6 S27 D22 S17 D10 D20 S15 G D30 S25 S13 S23
+ S11 B S21 S31 D8 D6 D4 D2 a_3267_n2808# D0 S9 S7 D18 D28 S5 D16 D26 S3 D14 D24 S19
+ S1 S29 D12
X0 S3 G D2 B sky130_fd_pr__pfet_01v8_lvt ad=4.0194 pd=28.01 as=4.0194 ps=28.01 w=27.72 l=0.74
X1 S9 G D8 B sky130_fd_pr__pfet_01v8_lvt ad=4.0194 pd=28.01 as=4.0194 ps=28.01 w=27.72 l=0.74
X2 S31 G D30 B sky130_fd_pr__pfet_01v8_lvt ad=4.0194 pd=28.01 as=4.0194 ps=28.01 w=27.72 l=0.74
X3 S13 G D12 B sky130_fd_pr__pfet_01v8_lvt ad=4.0194 pd=28.01 as=4.0194 ps=28.01 w=27.72 l=0.74
X4 D22 G S21 B sky130_fd_pr__pfet_01v8_lvt ad=4.0194 pd=28.01 as=4.0194 ps=28.01 w=27.72 l=0.74
X5 D28 G S27 B sky130_fd_pr__pfet_01v8_lvt ad=4.0194 pd=28.01 as=4.0194 ps=28.01 w=27.72 l=0.74
X6 D12 G S11 B sky130_fd_pr__pfet_01v8_lvt ad=4.0194 pd=28.01 as=4.0194 ps=28.01 w=27.72 l=0.74
X7 S11 G D10 B sky130_fd_pr__pfet_01v8_lvt ad=4.0194 pd=28.01 as=4.0194 ps=28.01 w=27.72 l=0.74
X8 S5 G D4 B sky130_fd_pr__pfet_01v8_lvt ad=4.0194 pd=28.01 as=4.0194 ps=28.01 w=27.72 l=0.74
X9 D4 G S3 B sky130_fd_pr__pfet_01v8_lvt ad=4.0194 pd=28.01 as=4.0194 ps=28.01 w=27.72 l=0.74
X10 S29 G D28 B sky130_fd_pr__pfet_01v8_lvt ad=4.0194 pd=28.01 as=4.0194 ps=28.01 w=27.72 l=0.74
X11 D30 G S29 B sky130_fd_pr__pfet_01v8_lvt ad=4.0194 pd=28.01 as=4.0194 ps=28.01 w=27.72 l=0.74
X12 S15 G D14 B sky130_fd_pr__pfet_01v8_lvt ad=4.0194 pd=28.01 as=4.0194 ps=28.01 w=27.72 l=0.74
X13 S21 G D20 B sky130_fd_pr__pfet_01v8_lvt ad=4.0194 pd=28.01 as=4.0194 ps=28.01 w=27.72 l=0.74
X14 D14 G S13 B sky130_fd_pr__pfet_01v8_lvt ad=4.0194 pd=28.01 as=4.0194 ps=28.01 w=27.72 l=0.74
X15 S17 G D16 B sky130_fd_pr__pfet_01v8_lvt ad=4.0194 pd=28.01 as=4.0194 ps=28.01 w=27.72 l=0.74
X16 S27 G D26 B sky130_fd_pr__pfet_01v8_lvt ad=4.0194 pd=28.01 as=4.0194 ps=28.01 w=27.72 l=0.74
X17 S7 G D6 B sky130_fd_pr__pfet_01v8_lvt ad=4.0194 pd=28.01 as=4.0194 ps=28.01 w=27.72 l=0.74
X18 D6 G S5 B sky130_fd_pr__pfet_01v8_lvt ad=4.0194 pd=28.01 as=4.0194 ps=28.01 w=27.72 l=0.74
X19 D26 G S25 B sky130_fd_pr__pfet_01v8_lvt ad=4.0194 pd=28.01 as=4.0194 ps=28.01 w=27.72 l=0.74
X20 S19 G D18 B sky130_fd_pr__pfet_01v8_lvt ad=4.0194 pd=28.01 as=4.0194 ps=28.01 w=27.72 l=0.74
X21 D16 G S15 B sky130_fd_pr__pfet_01v8_lvt ad=4.0194 pd=28.01 as=4.0194 ps=28.01 w=27.72 l=0.74
X22 D20 G S19 B sky130_fd_pr__pfet_01v8_lvt ad=4.0194 pd=28.01 as=4.0194 ps=28.01 w=27.72 l=0.74
X23 D2 G S1 B sky130_fd_pr__pfet_01v8_lvt ad=4.0194 pd=28.01 as=4.0194 ps=28.01 w=27.72 l=0.74
X24 D24 G S23 B sky130_fd_pr__pfet_01v8_lvt ad=4.0194 pd=28.01 as=4.0194 ps=28.01 w=27.72 l=0.74
X25 S25 G D24 B sky130_fd_pr__pfet_01v8_lvt ad=4.0194 pd=28.01 as=4.0194 ps=28.01 w=27.72 l=0.74
X26 S1 G D0 B sky130_fd_pr__pfet_01v8_lvt ad=4.0194 pd=28.01 as=8.0388 ps=56.02 w=27.72 l=0.74
X27 D18 G S17 B sky130_fd_pr__pfet_01v8_lvt ad=4.0194 pd=28.01 as=4.0194 ps=28.01 w=27.72 l=0.74
X28 D8 G S7 B sky130_fd_pr__pfet_01v8_lvt ad=4.0194 pd=28.01 as=4.0194 ps=28.01 w=27.72 l=0.74
X29 S23 G D22 B sky130_fd_pr__pfet_01v8_lvt ad=4.0194 pd=28.01 as=4.0194 ps=28.01 w=27.72 l=0.74
X30 a_3267_n2808# G S31 B sky130_fd_pr__pfet_01v8_lvt ad=8.0388 pd=56.02 as=4.0194 ps=28.01 w=27.72 l=0.74
X31 D10 G S9 B sky130_fd_pr__pfet_01v8_lvt ad=4.0194 pd=28.01 as=4.0194 ps=28.01 w=27.72 l=0.74
.ends

.subckt pfet_01v8_lvt_W887p03_L0p74_m1__nf32_gtop_sdfull_outD S D G B
Xpfet_01v8_lvt_W887p03_L0p74_m1__nf32_gtop_sdfull_outD_pc S D S D D S G D S S S S
+ B S S D D D D D D S S D D S D D S D D S S S D sky130_fd_pr__pfet_01v8_lvt_DLGRS6
.ends
