* NGSPICE file created from pfet_01v8_lvt_W6_L1_m2__nf1_gboth_sdfull_ng.ext - technology: sky130A

X0 pfet_01v8_lvt_W6_L1_m2__nf1_gboth_sdfull_ng_pc/S.t0 G pfet_01v8_lvt_W6_L1_m2__nf1_gboth_sdfull_ng_pc/D.t0 B sky130_fd_pr__pfet_01v8_lvt ad=1.74 pd=12.58 as=1.74 ps=12.58 w=6 l=1
C0 G B 0.19777f
C1 G S 0.32656f
C2 S B 0.12376f
C3 D G 0.32656f
C4 D B 0.12376f
C5 D S 0.17794f
R0 pfet_01v8_lvt_W6_L1_m2__nf1_gboth_sdfull_ng_pc/S.n0 S 74.559
R1 pfet_01v8_lvt_W6_L1_m2__nf1_gboth_sdfull_ng_pc/S.n1 pfet_01v8_lvt_W6_L1_m2__nf1_gboth_sdfull_ng_pc/S.n0 64.1817
R2 S pfet_01v8_lvt_W6_L1_m2__nf1_gboth_sdfull_ng_pc/S.n1 17.2465
R3 pfet_01v8_lvt_W6_L1_m2__nf1_gboth_sdfull_ng_pc/S.n0 pfet_01v8_lvt_W6_L1_m2__nf1_gboth_sdfull_ng_pc/S.t0 4.76133
R4 pfet_01v8_lvt_W6_L1_m2__nf1_gboth_sdfull_ng_pc/S.n1 S 4.03393
R5 pfet_01v8_lvt_W6_L1_m2__nf1_gboth_sdfull_ng_pc/D.n0 D 74.559
R6 pfet_01v8_lvt_W6_L1_m2__nf1_gboth_sdfull_ng_pc/D.n1 pfet_01v8_lvt_W6_L1_m2__nf1_gboth_sdfull_ng_pc/D.n0 64.1817
R7 D pfet_01v8_lvt_W6_L1_m2__nf1_gboth_sdfull_ng_pc/D.n1 17.2465
R8 pfet_01v8_lvt_W6_L1_m2__nf1_gboth_sdfull_ng_pc/D.n0 pfet_01v8_lvt_W6_L1_m2__nf1_gboth_sdfull_ng_pc/D.t0 4.76133
R9 pfet_01v8_lvt_W6_L1_m2__nf1_gboth_sdfull_ng_pc/D.n1 D 4.03393
C6 S VSUBS 0.79685f
C7 D VSUBS 0.79691f
C8 G VSUBS 0.36573f
C9 B VSUBS 1.6296f
C10 pfet_01v8_lvt_W6_L1_m2__nf1_gboth_sdfull_ng_pc/D.t0 VSUBS 0.0659f ; **FLOATING
C11 pfet_01v8_lvt_W6_L1_m2__nf1_gboth_sdfull_ng_pc/D.n0 VSUBS 0.20238f ; **FLOATING
C12 pfet_01v8_lvt_W6_L1_m2__nf1_gboth_sdfull_ng_pc/D.n1 VSUBS 0.0136f ; **FLOATING
C13 pfet_01v8_lvt_W6_L1_m2__nf1_gboth_sdfull_ng_pc/S.t0 VSUBS 0.0659f ; **FLOATING
C14 pfet_01v8_lvt_W6_L1_m2__nf1_gboth_sdfull_ng_pc/S.n0 VSUBS 0.20238f ; **FLOATING
C15 pfet_01v8_lvt_W6_L1_m2__nf1_gboth_sdfull_ng_pc/S.n1 VSUBS 0.0136f ; **FLOATING
