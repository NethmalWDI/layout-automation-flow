* NGSPICE file created from pfet_01v8_lvt_W6_L1_m2__nf1_gboth_sdfull_ng.ext - technology: sky130A

.subckt sky130_fd_pr__pfet_01v8_lvt_P6PHCF G D S w_n194_n700#
X0 S G D w_n194_n700# sky130_fd_pr__pfet_01v8_lvt ad=1.74 pd=12.58 as=1.74 ps=12.58 w=6 l=1
.ends

.subckt pfet_01v8_lvt_W6_L1_m2__nf1_gboth_sdfull_ng D S G B
Xpfet_01v8_lvt_W6_L1_m2__nf1_gboth_sdfull_ng_pc G D S B sky130_fd_pr__pfet_01v8_lvt_P6PHCF
.ends
