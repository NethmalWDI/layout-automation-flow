* NGSPICE file created from nfet_01v8_lvt_W10_L1_m2__nf1_gboth_sdhalf.ext - technology: sky130A

.subckt sky130_fd_pr__nfet_01v8_lvt_VYJ8PD G D B S
X0 S G D B sky130_fd_pr__nfet_01v8_lvt ad=2.9 pd=20.58 as=2.9 ps=20.58 w=10 l=1
.ends

.subckt nfet_01v8_lvt_W10_L1_m2__nf1_gboth_sdhalf D S G B
Xnfet_01v8_lvt_W10_L1_m2__nf1_gboth_sdhalf_pc G D B S sky130_fd_pr__nfet_01v8_lvt_VYJ8PD
.ends
