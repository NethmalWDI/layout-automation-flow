* NGSPICE file created from nfet_01v8_lvt_W0p5_L20_m2__nf1_gboth_sdfull_ng.ext - technology: sky130A

X0 S G D B sky130_fd_pr__nfet_01v8_lvt ad=0.145 pd=1.58 as=0.145 ps=1.58 w=0.5 l=20
C0 D G 0.0459f
C1 G S 0.0459f
C2 S B 0.08562f
C3 D B 0.08562f
C4 G B 7.718f
