* NGSPICE file created from nfet_01v8_lvt_W66p13_L2p03_m1__nf8_gboth_sdfull_outD.ext - technology: sky130A

.subckt sky130_fd_pr__nfet_01v8_lvt_7JNKSZ G B D6 D4 D2 D0 a_1827_n827# S7 S5 S3 S1
X0 S1 G D0 B sky130_fd_pr__nfet_01v8_lvt ad=1.19915 pd=8.56 as=2.3983 ps=17.12 w=8.27 l=2.03
X1 D2 G S1 B sky130_fd_pr__nfet_01v8_lvt ad=1.19915 pd=8.56 as=1.19915 ps=8.56 w=8.27 l=2.03
X2 S7 G D6 B sky130_fd_pr__nfet_01v8_lvt ad=1.19915 pd=8.56 as=1.19915 ps=8.56 w=8.27 l=2.03
X3 D6 G S5 B sky130_fd_pr__nfet_01v8_lvt ad=1.19915 pd=8.56 as=1.19915 ps=8.56 w=8.27 l=2.03
X4 a_1827_n827# G S7 B sky130_fd_pr__nfet_01v8_lvt ad=2.3983 pd=17.12 as=1.19915 ps=8.56 w=8.27 l=2.03
X5 S5 G D4 B sky130_fd_pr__nfet_01v8_lvt ad=1.19915 pd=8.56 as=1.19915 ps=8.56 w=8.27 l=2.03
X6 D4 G S3 B sky130_fd_pr__nfet_01v8_lvt ad=1.19915 pd=8.56 as=1.19915 ps=8.56 w=8.27 l=2.03
X7 S3 G D2 B sky130_fd_pr__nfet_01v8_lvt ad=1.19915 pd=8.56 as=1.19915 ps=8.56 w=8.27 l=2.03
.ends

.subckt nfet_01v8_lvt_W66p13_L2p03_m1__nf8_gboth_sdfull_outD S D G B
Xnfet_01v8_lvt_W66p13_L2p03_m1__nf8_gboth_sdfull_outD_pc G B D D D D D S S S S sky130_fd_pr__nfet_01v8_lvt_7JNKSZ
.ends
