* NGSPICE file created from nfet_01v8_lvt_W0p6_L5_m2__nf1_gboth_sdfull_ng.ext - technology: sky130A

.subckt nfet_01v8_lvt_W0p6_L5_m2__nf1_gboth_sdfull_ng D S G B
X0 S G D B sky130_fd_pr__nfet_01v8_lvt ad=0.174 pd=1.78 as=0.174 ps=1.78 w=0.6 l=5
C0 D G 0.05244f
C1 S D 0.00417f
C2 S G 0.05244f
C3 S B 0.08172f
C4 D B 0.08172f
C5 G B 1.9512f
.ends
