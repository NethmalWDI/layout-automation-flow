* NGSPICE file created from pfet_01v8_W8_L1_m1__nf8_gboth_sdfull_outS_ng.ext - technology: sky130A

.subckt pfet_01v8_W8_L1_m1__nf8_gboth_sdfull_outS_ng S D G B
X0 S G D B sky130_fd_pr__pfet_01v8 ad=0.29 pd=2.58 as=0.145 ps=1.29 w=1 l=1
X1 D G S B sky130_fd_pr__pfet_01v8 ad=0.145 pd=1.29 as=0.29 ps=2.58 w=1 l=1
X2 D G S B sky130_fd_pr__pfet_01v8 ad=0.145 pd=1.29 as=0.145 ps=1.29 w=1 l=1
X3 S G D B sky130_fd_pr__pfet_01v8 ad=0.145 pd=1.29 as=0.145 ps=1.29 w=1 l=1
X4 D G S B sky130_fd_pr__pfet_01v8 ad=0.145 pd=1.29 as=0.145 ps=1.29 w=1 l=1
X5 S G D B sky130_fd_pr__pfet_01v8 ad=0.145 pd=1.29 as=0.145 ps=1.29 w=1 l=1
X6 S G D B sky130_fd_pr__pfet_01v8 ad=0.145 pd=1.29 as=0.145 ps=1.29 w=1 l=1
X7 D G S B sky130_fd_pr__pfet_01v8 ad=0.145 pd=1.29 as=0.145 ps=1.29 w=1 l=1
C0 S D 1.12011f
C1 G B 1.39419f
C2 B S 0.1869f
C3 G S 1.05414f
C4 B D 0.16758f
C5 G D 1.04419f
C6 D VSUBS 0.35956f
C7 S VSUBS 0.53157f
C8 G VSUBS 2.54523f
C9 B VSUBS 2.6328f
.ends
