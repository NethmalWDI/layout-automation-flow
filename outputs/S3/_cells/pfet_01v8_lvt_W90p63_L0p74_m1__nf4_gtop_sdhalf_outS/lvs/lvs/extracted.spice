* NGSPICE file created from pfet_01v8_lvt_W90p63_L0p74_m1__nf4_gtop_sdhalf_outS.ext - technology: sky130A

.subckt sky130_fd_pr__pfet_01v8_lvt_VB43C5 G B a_383_n2302# D2 D0 S3 S1
X0 D2 G S1 B sky130_fd_pr__pfet_01v8_lvt ad=3.2857 pd=22.95 as=3.2857 ps=22.95 w=22.66 l=0.74
X1 a_383_n2302# G S3 B sky130_fd_pr__pfet_01v8_lvt ad=6.5714 pd=45.9 as=3.2857 ps=22.95 w=22.66 l=0.74
X2 S1 G D0 B sky130_fd_pr__pfet_01v8_lvt ad=3.2857 pd=22.95 as=6.5714 ps=45.9 w=22.66 l=0.74
X3 S3 G D2 B sky130_fd_pr__pfet_01v8_lvt ad=3.2857 pd=22.95 as=3.2857 ps=22.95 w=22.66 l=0.74
.ends

.subckt pfet_01v8_lvt_W90p63_L0p74_m1__nf4_gtop_sdhalf_outS S D G B
Xpfet_01v8_lvt_W90p63_L0p74_m1__nf4_gtop_sdhalf_outS_pc G B S S S D D sky130_fd_pr__pfet_01v8_lvt_VB43C5
.ends
