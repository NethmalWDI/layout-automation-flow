* NGSPICE file created from pfet_01v8_lvt_W90p63_L0p74_m1__nf8_gtop_sdfull_outS_ng.ext - technology: sky130A

.subckt pfet_01v8_lvt_W90p63_L0p74_m1__nf8_gtop_sdfull_outS_ng S D G B
X0 S G D B sky130_fd_pr__pfet_01v8_lvt ad=1.64285 pd=11.62 as=1.64285 ps=11.62 w=11.33 l=0.74
X1 D G S B sky130_fd_pr__pfet_01v8_lvt ad=1.64285 pd=11.62 as=1.64285 ps=11.62 w=11.33 l=0.74
X2 D G S B sky130_fd_pr__pfet_01v8_lvt ad=1.64285 pd=11.62 as=1.64285 ps=11.62 w=11.33 l=0.74
X3 S G D B sky130_fd_pr__pfet_01v8_lvt ad=3.2857 pd=23.24 as=1.64285 ps=11.62 w=11.33 l=0.74
X4 S G D B sky130_fd_pr__pfet_01v8_lvt ad=1.64285 pd=11.62 as=1.64285 ps=11.62 w=11.33 l=0.74
X5 S G D B sky130_fd_pr__pfet_01v8_lvt ad=1.64285 pd=11.62 as=1.64285 ps=11.62 w=11.33 l=0.74
X6 D G S B sky130_fd_pr__pfet_01v8_lvt ad=1.64285 pd=11.62 as=3.2857 ps=23.24 w=11.33 l=0.74
X7 D G S B sky130_fd_pr__pfet_01v8_lvt ad=1.64285 pd=11.62 as=1.64285 ps=11.62 w=11.33 l=0.74
C0 D S 3.85483f
C1 B G 0.8264f
C2 B D 1.04396f
C3 D G 4.54268f
C4 B S 1.19157f
C5 S G 4.76004f
C6 D VSUBS 0.3385f
C7 S VSUBS 1.94624f
C8 G VSUBS 1.344f
C9 B VSUBS 12.951f
.ends
