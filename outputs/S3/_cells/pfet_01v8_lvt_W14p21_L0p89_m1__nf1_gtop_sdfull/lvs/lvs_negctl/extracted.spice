* NGSPICE file created from pfet_01v8_lvt_W14p21_L0p89_m1__nf1_gtop_sdfull.ext - technology: sky130A

.subckt sky130_fd_pr__pfet_01v8_lvt_GL6QPL G D B S
X0 S G D B sky130_fd_pr__pfet_01v8_lvt ad=4.1209 pd=29 as=4.1209 ps=29 w=14.21 l=0.89
.ends

.subckt pfet_01v8_lvt_W14p21_L0p89_m1__nf1_gtop_sdfull D S G B
Xpfet_01v8_lvt_W14p21_L0p89_m1__nf1_gtop_sdfull_pc G D B S sky130_fd_pr__pfet_01v8_lvt_GL6QPL
.ends
