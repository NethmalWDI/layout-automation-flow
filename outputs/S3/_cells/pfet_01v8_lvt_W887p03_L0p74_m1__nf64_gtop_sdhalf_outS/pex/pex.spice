* NGSPICE file created from pfet_01v8_lvt_W887p03_L0p74_m1__nf64_gtop_sdhalf_outS.ext - technology: sky130A

.subckt pfet_01v8_lvt_W887p03_L0p74_m1__nf64_gtop_sdhalf_outS S D G B
X0 D G S B sky130_fd_pr__pfet_01v8_lvt ad=2.0097 pd=14.15 as=2.0097 ps=14.15 w=13.86 l=0.74
X1 S G D B sky130_fd_pr__pfet_01v8_lvt ad=2.0097 pd=14.15 as=2.0097 ps=14.15 w=13.86 l=0.74
X2 S G D B sky130_fd_pr__pfet_01v8_lvt ad=2.0097 pd=14.15 as=2.0097 ps=14.15 w=13.86 l=0.74
X3 S G D B sky130_fd_pr__pfet_01v8_lvt ad=2.0097 pd=14.15 as=2.0097 ps=14.15 w=13.86 l=0.74
X4 D G S B sky130_fd_pr__pfet_01v8_lvt ad=2.0097 pd=14.15 as=2.0097 ps=14.15 w=13.86 l=0.74
X5 S G D B sky130_fd_pr__pfet_01v8_lvt ad=2.0097 pd=14.15 as=2.0097 ps=14.15 w=13.86 l=0.74
X6 D G S B sky130_fd_pr__pfet_01v8_lvt ad=2.0097 pd=14.15 as=2.0097 ps=14.15 w=13.86 l=0.74
X7 S G D B sky130_fd_pr__pfet_01v8_lvt ad=2.0097 pd=14.15 as=2.0097 ps=14.15 w=13.86 l=0.74
X8 S G D B sky130_fd_pr__pfet_01v8_lvt ad=2.0097 pd=14.15 as=2.0097 ps=14.15 w=13.86 l=0.74
X9 S G D B sky130_fd_pr__pfet_01v8_lvt ad=2.0097 pd=14.15 as=2.0097 ps=14.15 w=13.86 l=0.74
X10 S G D B sky130_fd_pr__pfet_01v8_lvt ad=2.0097 pd=14.15 as=2.0097 ps=14.15 w=13.86 l=0.74
X11 D G S B sky130_fd_pr__pfet_01v8_lvt ad=2.0097 pd=14.15 as=2.0097 ps=14.15 w=13.86 l=0.74
X12 D G S B sky130_fd_pr__pfet_01v8_lvt ad=2.0097 pd=14.15 as=4.0194 ps=28.3 w=13.86 l=0.74
X13 D G S B sky130_fd_pr__pfet_01v8_lvt ad=2.0097 pd=14.15 as=2.0097 ps=14.15 w=13.86 l=0.74
X14 D G S B sky130_fd_pr__pfet_01v8_lvt ad=2.0097 pd=14.15 as=2.0097 ps=14.15 w=13.86 l=0.74
X15 S G D B sky130_fd_pr__pfet_01v8_lvt ad=2.0097 pd=14.15 as=2.0097 ps=14.15 w=13.86 l=0.74
X16 S G D B sky130_fd_pr__pfet_01v8_lvt ad=2.0097 pd=14.15 as=2.0097 ps=14.15 w=13.86 l=0.74
X17 D G S B sky130_fd_pr__pfet_01v8_lvt ad=2.0097 pd=14.15 as=2.0097 ps=14.15 w=13.86 l=0.74
X18 D G S B sky130_fd_pr__pfet_01v8_lvt ad=2.0097 pd=14.15 as=2.0097 ps=14.15 w=13.86 l=0.74
X19 S G D B sky130_fd_pr__pfet_01v8_lvt ad=2.0097 pd=14.15 as=2.0097 ps=14.15 w=13.86 l=0.74
X20 D G S B sky130_fd_pr__pfet_01v8_lvt ad=2.0097 pd=14.15 as=2.0097 ps=14.15 w=13.86 l=0.74
X21 D G S B sky130_fd_pr__pfet_01v8_lvt ad=2.0097 pd=14.15 as=2.0097 ps=14.15 w=13.86 l=0.74
X22 D G S B sky130_fd_pr__pfet_01v8_lvt ad=2.0097 pd=14.15 as=2.0097 ps=14.15 w=13.86 l=0.74
X23 S G D B sky130_fd_pr__pfet_01v8_lvt ad=2.0097 pd=14.15 as=2.0097 ps=14.15 w=13.86 l=0.74
X24 S G D B sky130_fd_pr__pfet_01v8_lvt ad=2.0097 pd=14.15 as=2.0097 ps=14.15 w=13.86 l=0.74
X25 S G D B sky130_fd_pr__pfet_01v8_lvt ad=2.0097 pd=14.15 as=2.0097 ps=14.15 w=13.86 l=0.74
X26 S G D B sky130_fd_pr__pfet_01v8_lvt ad=4.0194 pd=28.3 as=2.0097 ps=14.15 w=13.86 l=0.74
X27 D G S B sky130_fd_pr__pfet_01v8_lvt ad=2.0097 pd=14.15 as=2.0097 ps=14.15 w=13.86 l=0.74
X28 D G S B sky130_fd_pr__pfet_01v8_lvt ad=2.0097 pd=14.15 as=2.0097 ps=14.15 w=13.86 l=0.74
X29 D G S B sky130_fd_pr__pfet_01v8_lvt ad=2.0097 pd=14.15 as=2.0097 ps=14.15 w=13.86 l=0.74
X30 S G D B sky130_fd_pr__pfet_01v8_lvt ad=2.0097 pd=14.15 as=2.0097 ps=14.15 w=13.86 l=0.74
X31 S G D B sky130_fd_pr__pfet_01v8_lvt ad=2.0097 pd=14.15 as=2.0097 ps=14.15 w=13.86 l=0.74
X32 D G S B sky130_fd_pr__pfet_01v8_lvt ad=2.0097 pd=14.15 as=2.0097 ps=14.15 w=13.86 l=0.74
X33 S G D B sky130_fd_pr__pfet_01v8_lvt ad=2.0097 pd=14.15 as=2.0097 ps=14.15 w=13.86 l=0.74
X34 S G D B sky130_fd_pr__pfet_01v8_lvt ad=2.0097 pd=14.15 as=2.0097 ps=14.15 w=13.86 l=0.74
X35 S G D B sky130_fd_pr__pfet_01v8_lvt ad=2.0097 pd=14.15 as=2.0097 ps=14.15 w=13.86 l=0.74
X36 D G S B sky130_fd_pr__pfet_01v8_lvt ad=2.0097 pd=14.15 as=2.0097 ps=14.15 w=13.86 l=0.74
X37 D G S B sky130_fd_pr__pfet_01v8_lvt ad=2.0097 pd=14.15 as=2.0097 ps=14.15 w=13.86 l=0.74
X38 S G D B sky130_fd_pr__pfet_01v8_lvt ad=2.0097 pd=14.15 as=2.0097 ps=14.15 w=13.86 l=0.74
X39 D G S B sky130_fd_pr__pfet_01v8_lvt ad=2.0097 pd=14.15 as=2.0097 ps=14.15 w=13.86 l=0.74
X40 D G S B sky130_fd_pr__pfet_01v8_lvt ad=2.0097 pd=14.15 as=2.0097 ps=14.15 w=13.86 l=0.74
X41 D G S B sky130_fd_pr__pfet_01v8_lvt ad=2.0097 pd=14.15 as=2.0097 ps=14.15 w=13.86 l=0.74
X42 S G D B sky130_fd_pr__pfet_01v8_lvt ad=2.0097 pd=14.15 as=2.0097 ps=14.15 w=13.86 l=0.74
X43 D G S B sky130_fd_pr__pfet_01v8_lvt ad=2.0097 pd=14.15 as=2.0097 ps=14.15 w=13.86 l=0.74
X44 S G D B sky130_fd_pr__pfet_01v8_lvt ad=2.0097 pd=14.15 as=2.0097 ps=14.15 w=13.86 l=0.74
X45 S G D B sky130_fd_pr__pfet_01v8_lvt ad=2.0097 pd=14.15 as=2.0097 ps=14.15 w=13.86 l=0.74
X46 S G D B sky130_fd_pr__pfet_01v8_lvt ad=2.0097 pd=14.15 as=2.0097 ps=14.15 w=13.86 l=0.74
X47 S G D B sky130_fd_pr__pfet_01v8_lvt ad=2.0097 pd=14.15 as=2.0097 ps=14.15 w=13.86 l=0.74
X48 D G S B sky130_fd_pr__pfet_01v8_lvt ad=2.0097 pd=14.15 as=2.0097 ps=14.15 w=13.86 l=0.74
X49 D G S B sky130_fd_pr__pfet_01v8_lvt ad=2.0097 pd=14.15 as=2.0097 ps=14.15 w=13.86 l=0.74
X50 D G S B sky130_fd_pr__pfet_01v8_lvt ad=2.0097 pd=14.15 as=2.0097 ps=14.15 w=13.86 l=0.74
X51 S G D B sky130_fd_pr__pfet_01v8_lvt ad=2.0097 pd=14.15 as=2.0097 ps=14.15 w=13.86 l=0.74
X52 D G S B sky130_fd_pr__pfet_01v8_lvt ad=2.0097 pd=14.15 as=2.0097 ps=14.15 w=13.86 l=0.74
X53 D G S B sky130_fd_pr__pfet_01v8_lvt ad=2.0097 pd=14.15 as=2.0097 ps=14.15 w=13.86 l=0.74
X54 S G D B sky130_fd_pr__pfet_01v8_lvt ad=2.0097 pd=14.15 as=2.0097 ps=14.15 w=13.86 l=0.74
X55 D G S B sky130_fd_pr__pfet_01v8_lvt ad=2.0097 pd=14.15 as=2.0097 ps=14.15 w=13.86 l=0.74
X56 S G D B sky130_fd_pr__pfet_01v8_lvt ad=2.0097 pd=14.15 as=2.0097 ps=14.15 w=13.86 l=0.74
X57 S G D B sky130_fd_pr__pfet_01v8_lvt ad=2.0097 pd=14.15 as=2.0097 ps=14.15 w=13.86 l=0.74
X58 D G S B sky130_fd_pr__pfet_01v8_lvt ad=2.0097 pd=14.15 as=2.0097 ps=14.15 w=13.86 l=0.74
X59 D G S B sky130_fd_pr__pfet_01v8_lvt ad=2.0097 pd=14.15 as=2.0097 ps=14.15 w=13.86 l=0.74
X60 S G D B sky130_fd_pr__pfet_01v8_lvt ad=2.0097 pd=14.15 as=2.0097 ps=14.15 w=13.86 l=0.74
X61 D G S B sky130_fd_pr__pfet_01v8_lvt ad=2.0097 pd=14.15 as=2.0097 ps=14.15 w=13.86 l=0.74
X62 S G D B sky130_fd_pr__pfet_01v8_lvt ad=2.0097 pd=14.15 as=2.0097 ps=14.15 w=13.86 l=0.74
X63 D G S B sky130_fd_pr__pfet_01v8_lvt ad=2.0097 pd=14.15 as=2.0097 ps=14.15 w=13.86 l=0.74
C0 G B 14.34389f
C1 S B 5.95806f
C2 S G 24.57936f
C3 D B 5.23157f
C4 D G 24.51528f
C5 D S 20.9771f
C6 D VSUBS 0.56418f
C7 S VSUBS 0.86405f
C8 G VSUBS 4.78906f
C9 B VSUBS 0.1313p
.ends
