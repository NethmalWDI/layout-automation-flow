* NGSPICE file created from nfet_01v8_lvt_W0p5_L20_m2__nf1_gtop_sdhalf.ext - technology: sky130A

.subckt sky130_fd_pr__nfet_01v8_lvt_8HM5GC G D B S
X0 S G D B sky130_fd_pr__nfet_01v8_lvt ad=0.145 pd=1.58 as=0.145 ps=1.58 w=0.5 l=20
.ends

.subckt nfet_01v8_lvt_W0p5_L20_m2__nf1_gtop_sdhalf D S G B
Xnfet_01v8_lvt_W0p5_L20_m2__nf1_gtop_sdhalf_pc G D B S sky130_fd_pr__nfet_01v8_lvt_8HM5GC
.ends
