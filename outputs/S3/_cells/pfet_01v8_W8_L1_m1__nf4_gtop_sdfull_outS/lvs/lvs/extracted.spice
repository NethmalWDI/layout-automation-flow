* NGSPICE file created from pfet_01v8_W8_L1_m1__nf4_gtop_sdfull_outS.ext - technology: sky130A

.subckt sky130_fd_pr__pfet_01v8_7TXNAJ G B D2 D0 a_487_n236# S3 S1
X0 a_487_n236# G S3 B sky130_fd_pr__pfet_01v8 ad=0.58 pd=4.58 as=0.29 ps=2.29 w=2 l=1
X1 D2 G S1 B sky130_fd_pr__pfet_01v8 ad=0.29 pd=2.29 as=0.29 ps=2.29 w=2 l=1
X2 S3 G D2 B sky130_fd_pr__pfet_01v8 ad=0.29 pd=2.29 as=0.29 ps=2.29 w=2 l=1
X3 S1 G D0 B sky130_fd_pr__pfet_01v8 ad=0.29 pd=2.29 as=0.58 ps=4.58 w=2 l=1
.ends

.subckt pfet_01v8_W8_L1_m1__nf4_gtop_sdfull_outS S D G B
Xpfet_01v8_W8_L1_m1__nf4_gtop_sdfull_outS_pc G B S S S D D sky130_fd_pr__pfet_01v8_7TXNAJ
.ends
