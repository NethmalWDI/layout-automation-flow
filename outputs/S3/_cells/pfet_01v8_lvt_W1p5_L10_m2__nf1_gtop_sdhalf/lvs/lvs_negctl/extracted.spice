* NGSPICE file created from pfet_01v8_lvt_W1p5_L10_m2__nf1_gtop_sdhalf.ext - technology: sky130A

.subckt sky130_fd_pr__pfet_01v8_lvt_9A4BUQ G D B S
X0 S G D B sky130_fd_pr__pfet_01v8_lvt ad=0.435 pd=3.58 as=0.435 ps=3.58 w=1.5 l=10
.ends

.subckt pfet_01v8_lvt_W1p5_L10_m2__nf1_gtop_sdhalf D S G B
Xpfet_01v8_lvt_W1p5_L10_m2__nf1_gtop_sdhalf_pc G D B S sky130_fd_pr__pfet_01v8_lvt_9A4BUQ
.ends
