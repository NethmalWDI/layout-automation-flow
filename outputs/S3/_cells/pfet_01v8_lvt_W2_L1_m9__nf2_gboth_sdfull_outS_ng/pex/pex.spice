* NGSPICE file created from pfet_01v8_lvt_W2_L1_m9__nf2_gboth_sdfull_outS_ng.ext - technology: sky130A

.subckt pfet_01v8_lvt_W2_L1_m9__nf2_gboth_sdfull_outS_ng S D G B
X0 D G S B sky130_fd_pr__pfet_01v8_lvt ad=0.145 pd=1.29 as=0.29 ps=2.58 w=1 l=1
X1 S G D B sky130_fd_pr__pfet_01v8_lvt ad=0.29 pd=2.58 as=0.145 ps=1.29 w=1 l=1
C0 D G 0.26105f
C1 S B 0.06363f
C2 G B 0.36634f
C3 G S 0.26353f
C4 D B 0.04344f
C5 D S 0.30361f
C6 D VSUBS 0.11397f
C7 S VSUBS 0.28598f
C8 G VSUBS 0.71906f
C9 B VSUBS 0.7752f
.ends
