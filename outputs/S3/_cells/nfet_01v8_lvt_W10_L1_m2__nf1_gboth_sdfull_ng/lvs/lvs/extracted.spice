* NGSPICE file created from nfet_01v8_lvt_W10_L1_m2__nf1_gboth_sdfull_ng.ext - technology: sky130A

.subckt sky130_fd_pr__nfet_01v8_lvt_QC8V32 G D S VSUBS
X0 S G D VSUBS sky130_fd_pr__nfet_01v8_lvt ad=2.9 pd=20.58 as=2.9 ps=20.58 w=10 l=1
.ends

.subckt nfet_01v8_lvt_W10_L1_m2__nf1_gboth_sdfull_ng D S G B
Xnfet_01v8_lvt_W10_L1_m2__nf1_gboth_sdfull_ng_pc G D S B sky130_fd_pr__nfet_01v8_lvt_QC8V32
.ends
