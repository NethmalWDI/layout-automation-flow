* NGSPICE file created from pfet_01v8_lvt_W7p105_L0p89_m1__nf1_gboth_sdfull_ng.ext - technology: sky130A

.subckt sky130_fd_pr__pfet_01v8_lvt_NF2RB5 G D w_n183_n811# S
X0 S G D w_n183_n811# sky130_fd_pr__pfet_01v8_lvt ad=2.0619 pd=14.8 as=2.0619 ps=14.8 w=7.11 l=0.89
.ends

.subckt pfet_01v8_lvt_W7p105_L0p89_m1__nf1_gboth_sdfull_ng D S G B
Xpfet_01v8_lvt_W7p105_L0p89_m1__nf1_gboth_sdfull_ng_pc G D B S sky130_fd_pr__pfet_01v8_lvt_NF2RB5
.ends
