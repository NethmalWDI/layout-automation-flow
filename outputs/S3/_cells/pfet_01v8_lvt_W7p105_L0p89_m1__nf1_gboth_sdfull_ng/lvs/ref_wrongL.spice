.subckt pfet_01v8_lvt_W7p105_L0p89_m1__nf1_gboth_sdfull_ng D G S B
Xpfet_01v8_lvt_W7p105_L0p89_m1__nf1_gboth_sdfull_ng D G S B sky130_fd_pr__pfet_01v8_lvt L=0.99 W=7.105 nf=1
.ends
