* NGSPICE file created from pfet_01v8_lvt_W7p105_L0p89_m1__nf1_gboth_sdfull_ng.ext - technology: sky130A

.subckt pfet_01v8_lvt_W7p105_L0p89_m1__nf1_gboth_sdfull_ng D S G B
X0 S G D B sky130_fd_pr__pfet_01v8_lvt ad=2.0619 pd=14.8 as=2.0619 ps=14.8 w=7.11 l=0.89
C0 B S 0.14233f
C1 B D 0.14233f
C2 D S 0.23098f
C3 B G 0.18664f
C4 S G 0.36418f
C5 D G 0.36418f
C6 S VSUBS 0.52572f
C7 D VSUBS 0.52572f
C8 G VSUBS 0.33692f
C9 B VSUBS 1.78096f
.ends
