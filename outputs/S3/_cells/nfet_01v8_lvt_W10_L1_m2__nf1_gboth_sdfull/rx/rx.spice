* NGSPICE file created from nfet_01v8_lvt_W10_L1_m2__nf1_gboth_sdfull.ext - technology: sky130A

X0 S G D nfet_01v8_lvt_W10_L1_m2__nf1_gboth_sdfull_pc/B.t0 sky130_fd_pr__nfet_01v8_lvt ad=2.9 pd=20.58 as=2.9 ps=20.58 w=10 l=1
C0 S D 0.2963f
C1 S G 0.54327f
C2 D G 0.54327f
R0 nfet_01v8_lvt_W10_L1_m2__nf1_gboth_sdfull_pc/B.n182 nfet_01v8_lvt_W10_L1_m2__nf1_gboth_sdfull_pc/B.n181 1118.26
R1 nfet_01v8_lvt_W10_L1_m2__nf1_gboth_sdfull_pc/B.n179 nfet_01v8_lvt_W10_L1_m2__nf1_gboth_sdfull_pc/B.n8 1118.26
R2 nfet_01v8_lvt_W10_L1_m2__nf1_gboth_sdfull_pc/B.n80 nfet_01v8_lvt_W10_L1_m2__nf1_gboth_sdfull_pc/B.n68 1118.26
R3 nfet_01v8_lvt_W10_L1_m2__nf1_gboth_sdfull_pc/B.n76 nfet_01v8_lvt_W10_L1_m2__nf1_gboth_sdfull_pc/B.n66 1118.26
R4 nfet_01v8_lvt_W10_L1_m2__nf1_gboth_sdfull_pc/B.n180 nfet_01v8_lvt_W10_L1_m2__nf1_gboth_sdfull_pc/B.n3 792.308
R5 nfet_01v8_lvt_W10_L1_m2__nf1_gboth_sdfull_pc/B.n78 nfet_01v8_lvt_W10_L1_m2__nf1_gboth_sdfull_pc/B.n67 792.308
R6 nfet_01v8_lvt_W10_L1_m2__nf1_gboth_sdfull_pc/B.n81 nfet_01v8_lvt_W10_L1_m2__nf1_gboth_sdfull_pc/B.n80 585
R7 nfet_01v8_lvt_W10_L1_m2__nf1_gboth_sdfull_pc/B.n70 nfet_01v8_lvt_W10_L1_m2__nf1_gboth_sdfull_pc/B.n69 585
R8 nfet_01v8_lvt_W10_L1_m2__nf1_gboth_sdfull_pc/B.n78 nfet_01v8_lvt_W10_L1_m2__nf1_gboth_sdfull_pc/B.n71 585
R9 nfet_01v8_lvt_W10_L1_m2__nf1_gboth_sdfull_pc/B.n73 nfet_01v8_lvt_W10_L1_m2__nf1_gboth_sdfull_pc/B.n71 585
R10 nfet_01v8_lvt_W10_L1_m2__nf1_gboth_sdfull_pc/B.n74 nfet_01v8_lvt_W10_L1_m2__nf1_gboth_sdfull_pc/B.n72 585
R11 nfet_01v8_lvt_W10_L1_m2__nf1_gboth_sdfull_pc/B.n76 nfet_01v8_lvt_W10_L1_m2__nf1_gboth_sdfull_pc/B.n75 585
R12 nfet_01v8_lvt_W10_L1_m2__nf1_gboth_sdfull_pc/B.n67 nfet_01v8_lvt_W10_L1_m2__nf1_gboth_sdfull_pc/B.n66 585
R13 nfet_01v8_lvt_W10_L1_m2__nf1_gboth_sdfull_pc/B.n66 nfet_01v8_lvt_W10_L1_m2__nf1_gboth_sdfull_pc/B.n65 585
R14 nfet_01v8_lvt_W10_L1_m2__nf1_gboth_sdfull_pc/B.n86 nfet_01v8_lvt_W10_L1_m2__nf1_gboth_sdfull_pc/B.n85 585
R15 nfet_01v8_lvt_W10_L1_m2__nf1_gboth_sdfull_pc/B.n87 nfet_01v8_lvt_W10_L1_m2__nf1_gboth_sdfull_pc/B.n86 585
R16 nfet_01v8_lvt_W10_L1_m2__nf1_gboth_sdfull_pc/B.n64 nfet_01v8_lvt_W10_L1_m2__nf1_gboth_sdfull_pc/B.n63 585
R17 nfet_01v8_lvt_W10_L1_m2__nf1_gboth_sdfull_pc/B.n88 nfet_01v8_lvt_W10_L1_m2__nf1_gboth_sdfull_pc/B.n64 585
R18 nfet_01v8_lvt_W10_L1_m2__nf1_gboth_sdfull_pc/B.n91 nfet_01v8_lvt_W10_L1_m2__nf1_gboth_sdfull_pc/B.n90 585
R19 nfet_01v8_lvt_W10_L1_m2__nf1_gboth_sdfull_pc/B.n90 nfet_01v8_lvt_W10_L1_m2__nf1_gboth_sdfull_pc/B.n89 585
R20 nfet_01v8_lvt_W10_L1_m2__nf1_gboth_sdfull_pc/B.n59 nfet_01v8_lvt_W10_L1_m2__nf1_gboth_sdfull_pc/B.n58 585
R21 nfet_01v8_lvt_W10_L1_m2__nf1_gboth_sdfull_pc/B.n58 nfet_01v8_lvt_W10_L1_m2__nf1_gboth_sdfull_pc/B.n57 585
R22 nfet_01v8_lvt_W10_L1_m2__nf1_gboth_sdfull_pc/B.n98 nfet_01v8_lvt_W10_L1_m2__nf1_gboth_sdfull_pc/B.n97 585
R23 nfet_01v8_lvt_W10_L1_m2__nf1_gboth_sdfull_pc/B.n99 nfet_01v8_lvt_W10_L1_m2__nf1_gboth_sdfull_pc/B.n98 585
R24 nfet_01v8_lvt_W10_L1_m2__nf1_gboth_sdfull_pc/B.n56 nfet_01v8_lvt_W10_L1_m2__nf1_gboth_sdfull_pc/B.n55 585
R25 nfet_01v8_lvt_W10_L1_m2__nf1_gboth_sdfull_pc/B.n100 nfet_01v8_lvt_W10_L1_m2__nf1_gboth_sdfull_pc/B.n56 585
R26 nfet_01v8_lvt_W10_L1_m2__nf1_gboth_sdfull_pc/B.n103 nfet_01v8_lvt_W10_L1_m2__nf1_gboth_sdfull_pc/B.n102 585
R27 nfet_01v8_lvt_W10_L1_m2__nf1_gboth_sdfull_pc/B.n102 nfet_01v8_lvt_W10_L1_m2__nf1_gboth_sdfull_pc/B.n101 585
R28 nfet_01v8_lvt_W10_L1_m2__nf1_gboth_sdfull_pc/B.n51 nfet_01v8_lvt_W10_L1_m2__nf1_gboth_sdfull_pc/B.n50 585
R29 nfet_01v8_lvt_W10_L1_m2__nf1_gboth_sdfull_pc/B.n50 nfet_01v8_lvt_W10_L1_m2__nf1_gboth_sdfull_pc/B.n49 585
R30 nfet_01v8_lvt_W10_L1_m2__nf1_gboth_sdfull_pc/B.n110 nfet_01v8_lvt_W10_L1_m2__nf1_gboth_sdfull_pc/B.n109 585
R31 nfet_01v8_lvt_W10_L1_m2__nf1_gboth_sdfull_pc/B.n111 nfet_01v8_lvt_W10_L1_m2__nf1_gboth_sdfull_pc/B.n110 585
R32 nfet_01v8_lvt_W10_L1_m2__nf1_gboth_sdfull_pc/B.n48 nfet_01v8_lvt_W10_L1_m2__nf1_gboth_sdfull_pc/B.n47 585
R33 nfet_01v8_lvt_W10_L1_m2__nf1_gboth_sdfull_pc/B.n112 nfet_01v8_lvt_W10_L1_m2__nf1_gboth_sdfull_pc/B.n48 585
R34 nfet_01v8_lvt_W10_L1_m2__nf1_gboth_sdfull_pc/B.n115 nfet_01v8_lvt_W10_L1_m2__nf1_gboth_sdfull_pc/B.n114 585
R35 nfet_01v8_lvt_W10_L1_m2__nf1_gboth_sdfull_pc/B.n114 nfet_01v8_lvt_W10_L1_m2__nf1_gboth_sdfull_pc/B.n113 585
R36 nfet_01v8_lvt_W10_L1_m2__nf1_gboth_sdfull_pc/B.n43 nfet_01v8_lvt_W10_L1_m2__nf1_gboth_sdfull_pc/B.n42 585
R37 nfet_01v8_lvt_W10_L1_m2__nf1_gboth_sdfull_pc/B.n42 nfet_01v8_lvt_W10_L1_m2__nf1_gboth_sdfull_pc/B.n41 585
R38 nfet_01v8_lvt_W10_L1_m2__nf1_gboth_sdfull_pc/B.n122 nfet_01v8_lvt_W10_L1_m2__nf1_gboth_sdfull_pc/B.n121 585
R39 nfet_01v8_lvt_W10_L1_m2__nf1_gboth_sdfull_pc/B.n123 nfet_01v8_lvt_W10_L1_m2__nf1_gboth_sdfull_pc/B.n122 585
R40 nfet_01v8_lvt_W10_L1_m2__nf1_gboth_sdfull_pc/B.n40 nfet_01v8_lvt_W10_L1_m2__nf1_gboth_sdfull_pc/B.n39 585
R41 nfet_01v8_lvt_W10_L1_m2__nf1_gboth_sdfull_pc/B.n124 nfet_01v8_lvt_W10_L1_m2__nf1_gboth_sdfull_pc/B.n40 585
R42 nfet_01v8_lvt_W10_L1_m2__nf1_gboth_sdfull_pc/B.n127 nfet_01v8_lvt_W10_L1_m2__nf1_gboth_sdfull_pc/B.n126 585
R43 nfet_01v8_lvt_W10_L1_m2__nf1_gboth_sdfull_pc/B.n126 nfet_01v8_lvt_W10_L1_m2__nf1_gboth_sdfull_pc/B.n125 585
R44 nfet_01v8_lvt_W10_L1_m2__nf1_gboth_sdfull_pc/B.n35 nfet_01v8_lvt_W10_L1_m2__nf1_gboth_sdfull_pc/B.n34 585
R45 nfet_01v8_lvt_W10_L1_m2__nf1_gboth_sdfull_pc/B.n34 nfet_01v8_lvt_W10_L1_m2__nf1_gboth_sdfull_pc/B.n33 585
R46 nfet_01v8_lvt_W10_L1_m2__nf1_gboth_sdfull_pc/B.n134 nfet_01v8_lvt_W10_L1_m2__nf1_gboth_sdfull_pc/B.n133 585
R47 nfet_01v8_lvt_W10_L1_m2__nf1_gboth_sdfull_pc/B.n135 nfet_01v8_lvt_W10_L1_m2__nf1_gboth_sdfull_pc/B.n134 585
R48 nfet_01v8_lvt_W10_L1_m2__nf1_gboth_sdfull_pc/B.n32 nfet_01v8_lvt_W10_L1_m2__nf1_gboth_sdfull_pc/B.n31 585
R49 nfet_01v8_lvt_W10_L1_m2__nf1_gboth_sdfull_pc/B.n136 nfet_01v8_lvt_W10_L1_m2__nf1_gboth_sdfull_pc/B.n32 585
R50 nfet_01v8_lvt_W10_L1_m2__nf1_gboth_sdfull_pc/B.n139 nfet_01v8_lvt_W10_L1_m2__nf1_gboth_sdfull_pc/B.n138 585
R51 nfet_01v8_lvt_W10_L1_m2__nf1_gboth_sdfull_pc/B.n138 nfet_01v8_lvt_W10_L1_m2__nf1_gboth_sdfull_pc/B.n137 585
R52 nfet_01v8_lvt_W10_L1_m2__nf1_gboth_sdfull_pc/B.n27 nfet_01v8_lvt_W10_L1_m2__nf1_gboth_sdfull_pc/B.n26 585
R53 nfet_01v8_lvt_W10_L1_m2__nf1_gboth_sdfull_pc/B.n26 nfet_01v8_lvt_W10_L1_m2__nf1_gboth_sdfull_pc/B.n25 585
R54 nfet_01v8_lvt_W10_L1_m2__nf1_gboth_sdfull_pc/B.n146 nfet_01v8_lvt_W10_L1_m2__nf1_gboth_sdfull_pc/B.n145 585
R55 nfet_01v8_lvt_W10_L1_m2__nf1_gboth_sdfull_pc/B.n147 nfet_01v8_lvt_W10_L1_m2__nf1_gboth_sdfull_pc/B.n146 585
R56 nfet_01v8_lvt_W10_L1_m2__nf1_gboth_sdfull_pc/B.n24 nfet_01v8_lvt_W10_L1_m2__nf1_gboth_sdfull_pc/B.n23 585
R57 nfet_01v8_lvt_W10_L1_m2__nf1_gboth_sdfull_pc/B.n148 nfet_01v8_lvt_W10_L1_m2__nf1_gboth_sdfull_pc/B.n24 585
R58 nfet_01v8_lvt_W10_L1_m2__nf1_gboth_sdfull_pc/B.n151 nfet_01v8_lvt_W10_L1_m2__nf1_gboth_sdfull_pc/B.n150 585
R59 nfet_01v8_lvt_W10_L1_m2__nf1_gboth_sdfull_pc/B.n150 nfet_01v8_lvt_W10_L1_m2__nf1_gboth_sdfull_pc/B.n149 585
R60 nfet_01v8_lvt_W10_L1_m2__nf1_gboth_sdfull_pc/B.n19 nfet_01v8_lvt_W10_L1_m2__nf1_gboth_sdfull_pc/B.n18 585
R61 nfet_01v8_lvt_W10_L1_m2__nf1_gboth_sdfull_pc/B.n18 nfet_01v8_lvt_W10_L1_m2__nf1_gboth_sdfull_pc/B.n17 585
R62 nfet_01v8_lvt_W10_L1_m2__nf1_gboth_sdfull_pc/B.n158 nfet_01v8_lvt_W10_L1_m2__nf1_gboth_sdfull_pc/B.n157 585
R63 nfet_01v8_lvt_W10_L1_m2__nf1_gboth_sdfull_pc/B.n159 nfet_01v8_lvt_W10_L1_m2__nf1_gboth_sdfull_pc/B.n158 585
R64 nfet_01v8_lvt_W10_L1_m2__nf1_gboth_sdfull_pc/B.n16 nfet_01v8_lvt_W10_L1_m2__nf1_gboth_sdfull_pc/B.n15 585
R65 nfet_01v8_lvt_W10_L1_m2__nf1_gboth_sdfull_pc/B.n160 nfet_01v8_lvt_W10_L1_m2__nf1_gboth_sdfull_pc/B.n16 585
R66 nfet_01v8_lvt_W10_L1_m2__nf1_gboth_sdfull_pc/B.n163 nfet_01v8_lvt_W10_L1_m2__nf1_gboth_sdfull_pc/B.n162 585
R67 nfet_01v8_lvt_W10_L1_m2__nf1_gboth_sdfull_pc/B.n162 nfet_01v8_lvt_W10_L1_m2__nf1_gboth_sdfull_pc/B.n161 585
R68 nfet_01v8_lvt_W10_L1_m2__nf1_gboth_sdfull_pc/B.n11 nfet_01v8_lvt_W10_L1_m2__nf1_gboth_sdfull_pc/B.n10 585
R69 nfet_01v8_lvt_W10_L1_m2__nf1_gboth_sdfull_pc/B.n10 nfet_01v8_lvt_W10_L1_m2__nf1_gboth_sdfull_pc/B.n9 585
R70 nfet_01v8_lvt_W10_L1_m2__nf1_gboth_sdfull_pc/B.n171 nfet_01v8_lvt_W10_L1_m2__nf1_gboth_sdfull_pc/B.n170 585
R71 nfet_01v8_lvt_W10_L1_m2__nf1_gboth_sdfull_pc/B.n172 nfet_01v8_lvt_W10_L1_m2__nf1_gboth_sdfull_pc/B.n171 585
R72 nfet_01v8_lvt_W10_L1_m2__nf1_gboth_sdfull_pc/B.n7 nfet_01v8_lvt_W10_L1_m2__nf1_gboth_sdfull_pc/B.n6 585
R73 nfet_01v8_lvt_W10_L1_m2__nf1_gboth_sdfull_pc/B.n173 nfet_01v8_lvt_W10_L1_m2__nf1_gboth_sdfull_pc/B.n7 585
R74 nfet_01v8_lvt_W10_L1_m2__nf1_gboth_sdfull_pc/B.n180 nfet_01v8_lvt_W10_L1_m2__nf1_gboth_sdfull_pc/B.n179 585
R75 nfet_01v8_lvt_W10_L1_m2__nf1_gboth_sdfull_pc/B.n179 nfet_01v8_lvt_W10_L1_m2__nf1_gboth_sdfull_pc/B.n178 585
R76 nfet_01v8_lvt_W10_L1_m2__nf1_gboth_sdfull_pc/B.n8 nfet_01v8_lvt_W10_L1_m2__nf1_gboth_sdfull_pc/B.n3 585
R77 nfet_01v8_lvt_W10_L1_m2__nf1_gboth_sdfull_pc/B.n177 nfet_01v8_lvt_W10_L1_m2__nf1_gboth_sdfull_pc/B.n8 585
R78 nfet_01v8_lvt_W10_L1_m2__nf1_gboth_sdfull_pc/B.n176 nfet_01v8_lvt_W10_L1_m2__nf1_gboth_sdfull_pc/B.n175 585
R79 nfet_01v8_lvt_W10_L1_m2__nf1_gboth_sdfull_pc/B.n2 nfet_01v8_lvt_W10_L1_m2__nf1_gboth_sdfull_pc/B.n0 585
R80 nfet_01v8_lvt_W10_L1_m2__nf1_gboth_sdfull_pc/B.n185 nfet_01v8_lvt_W10_L1_m2__nf1_gboth_sdfull_pc/B.n184 585
R81 nfet_01v8_lvt_W10_L1_m2__nf1_gboth_sdfull_pc/B.n182 nfet_01v8_lvt_W10_L1_m2__nf1_gboth_sdfull_pc/B.n1 585
R82 nfet_01v8_lvt_W10_L1_m2__nf1_gboth_sdfull_pc/B.n181 nfet_01v8_lvt_W10_L1_m2__nf1_gboth_sdfull_pc/B.n180 585
R83 nfet_01v8_lvt_W10_L1_m2__nf1_gboth_sdfull_pc/B.n181 nfet_01v8_lvt_W10_L1_m2__nf1_gboth_sdfull_pc/B.n5 585
R84 nfet_01v8_lvt_W10_L1_m2__nf1_gboth_sdfull_pc/B.n6 nfet_01v8_lvt_W10_L1_m2__nf1_gboth_sdfull_pc/B.n4 585
R85 nfet_01v8_lvt_W10_L1_m2__nf1_gboth_sdfull_pc/B.n167 nfet_01v8_lvt_W10_L1_m2__nf1_gboth_sdfull_pc/B.n4 585
R86 nfet_01v8_lvt_W10_L1_m2__nf1_gboth_sdfull_pc/B.n170 nfet_01v8_lvt_W10_L1_m2__nf1_gboth_sdfull_pc/B.n169 585
R87 nfet_01v8_lvt_W10_L1_m2__nf1_gboth_sdfull_pc/B.n169 nfet_01v8_lvt_W10_L1_m2__nf1_gboth_sdfull_pc/B.n168 585
R88 nfet_01v8_lvt_W10_L1_m2__nf1_gboth_sdfull_pc/B.n12 nfet_01v8_lvt_W10_L1_m2__nf1_gboth_sdfull_pc/B.n11 585
R89 nfet_01v8_lvt_W10_L1_m2__nf1_gboth_sdfull_pc/B.n166 nfet_01v8_lvt_W10_L1_m2__nf1_gboth_sdfull_pc/B.n12 585
R90 nfet_01v8_lvt_W10_L1_m2__nf1_gboth_sdfull_pc/B.n164 nfet_01v8_lvt_W10_L1_m2__nf1_gboth_sdfull_pc/B.n163 585
R91 nfet_01v8_lvt_W10_L1_m2__nf1_gboth_sdfull_pc/B.n165 nfet_01v8_lvt_W10_L1_m2__nf1_gboth_sdfull_pc/B.n164 585
R92 nfet_01v8_lvt_W10_L1_m2__nf1_gboth_sdfull_pc/B.n15 nfet_01v8_lvt_W10_L1_m2__nf1_gboth_sdfull_pc/B.n14 585
R93 nfet_01v8_lvt_W10_L1_m2__nf1_gboth_sdfull_pc/B.n14 nfet_01v8_lvt_W10_L1_m2__nf1_gboth_sdfull_pc/B.n13 585
R94 nfet_01v8_lvt_W10_L1_m2__nf1_gboth_sdfull_pc/B.n157 nfet_01v8_lvt_W10_L1_m2__nf1_gboth_sdfull_pc/B.n156 585
R95 nfet_01v8_lvt_W10_L1_m2__nf1_gboth_sdfull_pc/B.n156 nfet_01v8_lvt_W10_L1_m2__nf1_gboth_sdfull_pc/B.n155 585
R96 nfet_01v8_lvt_W10_L1_m2__nf1_gboth_sdfull_pc/B.n20 nfet_01v8_lvt_W10_L1_m2__nf1_gboth_sdfull_pc/B.n19 585
R97 nfet_01v8_lvt_W10_L1_m2__nf1_gboth_sdfull_pc/B.n154 nfet_01v8_lvt_W10_L1_m2__nf1_gboth_sdfull_pc/B.n20 585
R98 nfet_01v8_lvt_W10_L1_m2__nf1_gboth_sdfull_pc/B.n152 nfet_01v8_lvt_W10_L1_m2__nf1_gboth_sdfull_pc/B.n151 585
R99 nfet_01v8_lvt_W10_L1_m2__nf1_gboth_sdfull_pc/B.n153 nfet_01v8_lvt_W10_L1_m2__nf1_gboth_sdfull_pc/B.n152 585
R100 nfet_01v8_lvt_W10_L1_m2__nf1_gboth_sdfull_pc/B.n23 nfet_01v8_lvt_W10_L1_m2__nf1_gboth_sdfull_pc/B.n22 585
R101 nfet_01v8_lvt_W10_L1_m2__nf1_gboth_sdfull_pc/B.n22 nfet_01v8_lvt_W10_L1_m2__nf1_gboth_sdfull_pc/B.n21 585
R102 nfet_01v8_lvt_W10_L1_m2__nf1_gboth_sdfull_pc/B.n145 nfet_01v8_lvt_W10_L1_m2__nf1_gboth_sdfull_pc/B.n144 585
R103 nfet_01v8_lvt_W10_L1_m2__nf1_gboth_sdfull_pc/B.n144 nfet_01v8_lvt_W10_L1_m2__nf1_gboth_sdfull_pc/B.n143 585
R104 nfet_01v8_lvt_W10_L1_m2__nf1_gboth_sdfull_pc/B.n28 nfet_01v8_lvt_W10_L1_m2__nf1_gboth_sdfull_pc/B.n27 585
R105 nfet_01v8_lvt_W10_L1_m2__nf1_gboth_sdfull_pc/B.n142 nfet_01v8_lvt_W10_L1_m2__nf1_gboth_sdfull_pc/B.n28 585
R106 nfet_01v8_lvt_W10_L1_m2__nf1_gboth_sdfull_pc/B.n140 nfet_01v8_lvt_W10_L1_m2__nf1_gboth_sdfull_pc/B.n139 585
R107 nfet_01v8_lvt_W10_L1_m2__nf1_gboth_sdfull_pc/B.n141 nfet_01v8_lvt_W10_L1_m2__nf1_gboth_sdfull_pc/B.n140 585
R108 nfet_01v8_lvt_W10_L1_m2__nf1_gboth_sdfull_pc/B.n31 nfet_01v8_lvt_W10_L1_m2__nf1_gboth_sdfull_pc/B.n30 585
R109 nfet_01v8_lvt_W10_L1_m2__nf1_gboth_sdfull_pc/B.n30 nfet_01v8_lvt_W10_L1_m2__nf1_gboth_sdfull_pc/B.n29 585
R110 nfet_01v8_lvt_W10_L1_m2__nf1_gboth_sdfull_pc/B.n133 nfet_01v8_lvt_W10_L1_m2__nf1_gboth_sdfull_pc/B.n132 585
R111 nfet_01v8_lvt_W10_L1_m2__nf1_gboth_sdfull_pc/B.n132 nfet_01v8_lvt_W10_L1_m2__nf1_gboth_sdfull_pc/B.n131 585
R112 nfet_01v8_lvt_W10_L1_m2__nf1_gboth_sdfull_pc/B.n36 nfet_01v8_lvt_W10_L1_m2__nf1_gboth_sdfull_pc/B.n35 585
R113 nfet_01v8_lvt_W10_L1_m2__nf1_gboth_sdfull_pc/B.n130 nfet_01v8_lvt_W10_L1_m2__nf1_gboth_sdfull_pc/B.n36 585
R114 nfet_01v8_lvt_W10_L1_m2__nf1_gboth_sdfull_pc/B.n128 nfet_01v8_lvt_W10_L1_m2__nf1_gboth_sdfull_pc/B.n127 585
R115 nfet_01v8_lvt_W10_L1_m2__nf1_gboth_sdfull_pc/B.n129 nfet_01v8_lvt_W10_L1_m2__nf1_gboth_sdfull_pc/B.n128 585
R116 nfet_01v8_lvt_W10_L1_m2__nf1_gboth_sdfull_pc/B.n39 nfet_01v8_lvt_W10_L1_m2__nf1_gboth_sdfull_pc/B.n38 585
R117 nfet_01v8_lvt_W10_L1_m2__nf1_gboth_sdfull_pc/B.n38 nfet_01v8_lvt_W10_L1_m2__nf1_gboth_sdfull_pc/B.n37 585
R118 nfet_01v8_lvt_W10_L1_m2__nf1_gboth_sdfull_pc/B.n121 nfet_01v8_lvt_W10_L1_m2__nf1_gboth_sdfull_pc/B.n120 585
R119 nfet_01v8_lvt_W10_L1_m2__nf1_gboth_sdfull_pc/B.n120 nfet_01v8_lvt_W10_L1_m2__nf1_gboth_sdfull_pc/B.n119 585
R120 nfet_01v8_lvt_W10_L1_m2__nf1_gboth_sdfull_pc/B.n44 nfet_01v8_lvt_W10_L1_m2__nf1_gboth_sdfull_pc/B.n43 585
R121 nfet_01v8_lvt_W10_L1_m2__nf1_gboth_sdfull_pc/B.n118 nfet_01v8_lvt_W10_L1_m2__nf1_gboth_sdfull_pc/B.n44 585
R122 nfet_01v8_lvt_W10_L1_m2__nf1_gboth_sdfull_pc/B.n116 nfet_01v8_lvt_W10_L1_m2__nf1_gboth_sdfull_pc/B.n115 585
R123 nfet_01v8_lvt_W10_L1_m2__nf1_gboth_sdfull_pc/B.n117 nfet_01v8_lvt_W10_L1_m2__nf1_gboth_sdfull_pc/B.n116 585
R124 nfet_01v8_lvt_W10_L1_m2__nf1_gboth_sdfull_pc/B.n47 nfet_01v8_lvt_W10_L1_m2__nf1_gboth_sdfull_pc/B.n46 585
R125 nfet_01v8_lvt_W10_L1_m2__nf1_gboth_sdfull_pc/B.n46 nfet_01v8_lvt_W10_L1_m2__nf1_gboth_sdfull_pc/B.n45 585
R126 nfet_01v8_lvt_W10_L1_m2__nf1_gboth_sdfull_pc/B.n109 nfet_01v8_lvt_W10_L1_m2__nf1_gboth_sdfull_pc/B.n108 585
R127 nfet_01v8_lvt_W10_L1_m2__nf1_gboth_sdfull_pc/B.n108 nfet_01v8_lvt_W10_L1_m2__nf1_gboth_sdfull_pc/B.n107 585
R128 nfet_01v8_lvt_W10_L1_m2__nf1_gboth_sdfull_pc/B.n52 nfet_01v8_lvt_W10_L1_m2__nf1_gboth_sdfull_pc/B.n51 585
R129 nfet_01v8_lvt_W10_L1_m2__nf1_gboth_sdfull_pc/B.n106 nfet_01v8_lvt_W10_L1_m2__nf1_gboth_sdfull_pc/B.n52 585
R130 nfet_01v8_lvt_W10_L1_m2__nf1_gboth_sdfull_pc/B.n104 nfet_01v8_lvt_W10_L1_m2__nf1_gboth_sdfull_pc/B.n103 585
R131 nfet_01v8_lvt_W10_L1_m2__nf1_gboth_sdfull_pc/B.n105 nfet_01v8_lvt_W10_L1_m2__nf1_gboth_sdfull_pc/B.n104 585
R132 nfet_01v8_lvt_W10_L1_m2__nf1_gboth_sdfull_pc/B.n55 nfet_01v8_lvt_W10_L1_m2__nf1_gboth_sdfull_pc/B.n54 585
R133 nfet_01v8_lvt_W10_L1_m2__nf1_gboth_sdfull_pc/B.n54 nfet_01v8_lvt_W10_L1_m2__nf1_gboth_sdfull_pc/B.n53 585
R134 nfet_01v8_lvt_W10_L1_m2__nf1_gboth_sdfull_pc/B.n97 nfet_01v8_lvt_W10_L1_m2__nf1_gboth_sdfull_pc/B.n96 585
R135 nfet_01v8_lvt_W10_L1_m2__nf1_gboth_sdfull_pc/B.n96 nfet_01v8_lvt_W10_L1_m2__nf1_gboth_sdfull_pc/B.n95 585
R136 nfet_01v8_lvt_W10_L1_m2__nf1_gboth_sdfull_pc/B.n60 nfet_01v8_lvt_W10_L1_m2__nf1_gboth_sdfull_pc/B.n59 585
R137 nfet_01v8_lvt_W10_L1_m2__nf1_gboth_sdfull_pc/B.n94 nfet_01v8_lvt_W10_L1_m2__nf1_gboth_sdfull_pc/B.n60 585
R138 nfet_01v8_lvt_W10_L1_m2__nf1_gboth_sdfull_pc/B.n92 nfet_01v8_lvt_W10_L1_m2__nf1_gboth_sdfull_pc/B.n91 585
R139 nfet_01v8_lvt_W10_L1_m2__nf1_gboth_sdfull_pc/B.n93 nfet_01v8_lvt_W10_L1_m2__nf1_gboth_sdfull_pc/B.n92 585
R140 nfet_01v8_lvt_W10_L1_m2__nf1_gboth_sdfull_pc/B.n63 nfet_01v8_lvt_W10_L1_m2__nf1_gboth_sdfull_pc/B.n62 585
R141 nfet_01v8_lvt_W10_L1_m2__nf1_gboth_sdfull_pc/B.n62 nfet_01v8_lvt_W10_L1_m2__nf1_gboth_sdfull_pc/B.n61 585
R142 nfet_01v8_lvt_W10_L1_m2__nf1_gboth_sdfull_pc/B.n85 nfet_01v8_lvt_W10_L1_m2__nf1_gboth_sdfull_pc/B.n84 585
R143 nfet_01v8_lvt_W10_L1_m2__nf1_gboth_sdfull_pc/B.n84 nfet_01v8_lvt_W10_L1_m2__nf1_gboth_sdfull_pc/B.n83 585
R144 nfet_01v8_lvt_W10_L1_m2__nf1_gboth_sdfull_pc/B.n68 nfet_01v8_lvt_W10_L1_m2__nf1_gboth_sdfull_pc/B.n67 585
R145 nfet_01v8_lvt_W10_L1_m2__nf1_gboth_sdfull_pc/B.n82 nfet_01v8_lvt_W10_L1_m2__nf1_gboth_sdfull_pc/B.n68 585
R146 nfet_01v8_lvt_W10_L1_m2__nf1_gboth_sdfull_pc/B.n180 nfet_01v8_lvt_W10_L1_m2__nf1_gboth_sdfull_pc/B.n6 523.077
R147 nfet_01v8_lvt_W10_L1_m2__nf1_gboth_sdfull_pc/B.n170 nfet_01v8_lvt_W10_L1_m2__nf1_gboth_sdfull_pc/B.n6 523.077
R148 nfet_01v8_lvt_W10_L1_m2__nf1_gboth_sdfull_pc/B.n170 nfet_01v8_lvt_W10_L1_m2__nf1_gboth_sdfull_pc/B.n11 523.077
R149 nfet_01v8_lvt_W10_L1_m2__nf1_gboth_sdfull_pc/B.n163 nfet_01v8_lvt_W10_L1_m2__nf1_gboth_sdfull_pc/B.n11 523.077
R150 nfet_01v8_lvt_W10_L1_m2__nf1_gboth_sdfull_pc/B.n163 nfet_01v8_lvt_W10_L1_m2__nf1_gboth_sdfull_pc/B.n15 523.077
R151 nfet_01v8_lvt_W10_L1_m2__nf1_gboth_sdfull_pc/B.n157 nfet_01v8_lvt_W10_L1_m2__nf1_gboth_sdfull_pc/B.n15 523.077
R152 nfet_01v8_lvt_W10_L1_m2__nf1_gboth_sdfull_pc/B.n157 nfet_01v8_lvt_W10_L1_m2__nf1_gboth_sdfull_pc/B.n19 523.077
R153 nfet_01v8_lvt_W10_L1_m2__nf1_gboth_sdfull_pc/B.n151 nfet_01v8_lvt_W10_L1_m2__nf1_gboth_sdfull_pc/B.n19 523.077
R154 nfet_01v8_lvt_W10_L1_m2__nf1_gboth_sdfull_pc/B.n151 nfet_01v8_lvt_W10_L1_m2__nf1_gboth_sdfull_pc/B.n23 523.077
R155 nfet_01v8_lvt_W10_L1_m2__nf1_gboth_sdfull_pc/B.n145 nfet_01v8_lvt_W10_L1_m2__nf1_gboth_sdfull_pc/B.n23 523.077
R156 nfet_01v8_lvt_W10_L1_m2__nf1_gboth_sdfull_pc/B.n145 nfet_01v8_lvt_W10_L1_m2__nf1_gboth_sdfull_pc/B.n27 523.077
R157 nfet_01v8_lvt_W10_L1_m2__nf1_gboth_sdfull_pc/B.n139 nfet_01v8_lvt_W10_L1_m2__nf1_gboth_sdfull_pc/B.n27 523.077
R158 nfet_01v8_lvt_W10_L1_m2__nf1_gboth_sdfull_pc/B.n139 nfet_01v8_lvt_W10_L1_m2__nf1_gboth_sdfull_pc/B.n31 523.077
R159 nfet_01v8_lvt_W10_L1_m2__nf1_gboth_sdfull_pc/B.n133 nfet_01v8_lvt_W10_L1_m2__nf1_gboth_sdfull_pc/B.n31 523.077
R160 nfet_01v8_lvt_W10_L1_m2__nf1_gboth_sdfull_pc/B.n133 nfet_01v8_lvt_W10_L1_m2__nf1_gboth_sdfull_pc/B.n35 523.077
R161 nfet_01v8_lvt_W10_L1_m2__nf1_gboth_sdfull_pc/B.n127 nfet_01v8_lvt_W10_L1_m2__nf1_gboth_sdfull_pc/B.n39 523.077
R162 nfet_01v8_lvt_W10_L1_m2__nf1_gboth_sdfull_pc/B.n121 nfet_01v8_lvt_W10_L1_m2__nf1_gboth_sdfull_pc/B.n39 523.077
R163 nfet_01v8_lvt_W10_L1_m2__nf1_gboth_sdfull_pc/B.n121 nfet_01v8_lvt_W10_L1_m2__nf1_gboth_sdfull_pc/B.n43 523.077
R164 nfet_01v8_lvt_W10_L1_m2__nf1_gboth_sdfull_pc/B.n115 nfet_01v8_lvt_W10_L1_m2__nf1_gboth_sdfull_pc/B.n43 523.077
R165 nfet_01v8_lvt_W10_L1_m2__nf1_gboth_sdfull_pc/B.n115 nfet_01v8_lvt_W10_L1_m2__nf1_gboth_sdfull_pc/B.n47 523.077
R166 nfet_01v8_lvt_W10_L1_m2__nf1_gboth_sdfull_pc/B.n109 nfet_01v8_lvt_W10_L1_m2__nf1_gboth_sdfull_pc/B.n47 523.077
R167 nfet_01v8_lvt_W10_L1_m2__nf1_gboth_sdfull_pc/B.n109 nfet_01v8_lvt_W10_L1_m2__nf1_gboth_sdfull_pc/B.n51 523.077
R168 nfet_01v8_lvt_W10_L1_m2__nf1_gboth_sdfull_pc/B.n103 nfet_01v8_lvt_W10_L1_m2__nf1_gboth_sdfull_pc/B.n51 523.077
R169 nfet_01v8_lvt_W10_L1_m2__nf1_gboth_sdfull_pc/B.n103 nfet_01v8_lvt_W10_L1_m2__nf1_gboth_sdfull_pc/B.n55 523.077
R170 nfet_01v8_lvt_W10_L1_m2__nf1_gboth_sdfull_pc/B.n97 nfet_01v8_lvt_W10_L1_m2__nf1_gboth_sdfull_pc/B.n55 523.077
R171 nfet_01v8_lvt_W10_L1_m2__nf1_gboth_sdfull_pc/B.n97 nfet_01v8_lvt_W10_L1_m2__nf1_gboth_sdfull_pc/B.n59 523.077
R172 nfet_01v8_lvt_W10_L1_m2__nf1_gboth_sdfull_pc/B.n91 nfet_01v8_lvt_W10_L1_m2__nf1_gboth_sdfull_pc/B.n59 523.077
R173 nfet_01v8_lvt_W10_L1_m2__nf1_gboth_sdfull_pc/B.n91 nfet_01v8_lvt_W10_L1_m2__nf1_gboth_sdfull_pc/B.n63 523.077
R174 nfet_01v8_lvt_W10_L1_m2__nf1_gboth_sdfull_pc/B.n85 nfet_01v8_lvt_W10_L1_m2__nf1_gboth_sdfull_pc/B.n63 523.077
R175 nfet_01v8_lvt_W10_L1_m2__nf1_gboth_sdfull_pc/B.n85 nfet_01v8_lvt_W10_L1_m2__nf1_gboth_sdfull_pc/B.n67 523.077
R176 nfet_01v8_lvt_W10_L1_m2__nf1_gboth_sdfull_pc/B.n181 nfet_01v8_lvt_W10_L1_m2__nf1_gboth_sdfull_pc/B.n4 394
R177 nfet_01v8_lvt_W10_L1_m2__nf1_gboth_sdfull_pc/B.n169 nfet_01v8_lvt_W10_L1_m2__nf1_gboth_sdfull_pc/B.n4 394
R178 nfet_01v8_lvt_W10_L1_m2__nf1_gboth_sdfull_pc/B.n169 nfet_01v8_lvt_W10_L1_m2__nf1_gboth_sdfull_pc/B.n12 394
R179 nfet_01v8_lvt_W10_L1_m2__nf1_gboth_sdfull_pc/B.n164 nfet_01v8_lvt_W10_L1_m2__nf1_gboth_sdfull_pc/B.n12 394
R180 nfet_01v8_lvt_W10_L1_m2__nf1_gboth_sdfull_pc/B.n164 nfet_01v8_lvt_W10_L1_m2__nf1_gboth_sdfull_pc/B.n14 394
R181 nfet_01v8_lvt_W10_L1_m2__nf1_gboth_sdfull_pc/B.n156 nfet_01v8_lvt_W10_L1_m2__nf1_gboth_sdfull_pc/B.n14 394
R182 nfet_01v8_lvt_W10_L1_m2__nf1_gboth_sdfull_pc/B.n156 nfet_01v8_lvt_W10_L1_m2__nf1_gboth_sdfull_pc/B.n20 394
R183 nfet_01v8_lvt_W10_L1_m2__nf1_gboth_sdfull_pc/B.n152 nfet_01v8_lvt_W10_L1_m2__nf1_gboth_sdfull_pc/B.n20 394
R184 nfet_01v8_lvt_W10_L1_m2__nf1_gboth_sdfull_pc/B.n152 nfet_01v8_lvt_W10_L1_m2__nf1_gboth_sdfull_pc/B.n22 394
R185 nfet_01v8_lvt_W10_L1_m2__nf1_gboth_sdfull_pc/B.n144 nfet_01v8_lvt_W10_L1_m2__nf1_gboth_sdfull_pc/B.n22 394
R186 nfet_01v8_lvt_W10_L1_m2__nf1_gboth_sdfull_pc/B.n144 nfet_01v8_lvt_W10_L1_m2__nf1_gboth_sdfull_pc/B.n28 394
R187 nfet_01v8_lvt_W10_L1_m2__nf1_gboth_sdfull_pc/B.n140 nfet_01v8_lvt_W10_L1_m2__nf1_gboth_sdfull_pc/B.n28 394
R188 nfet_01v8_lvt_W10_L1_m2__nf1_gboth_sdfull_pc/B.n140 nfet_01v8_lvt_W10_L1_m2__nf1_gboth_sdfull_pc/B.n30 394
R189 nfet_01v8_lvt_W10_L1_m2__nf1_gboth_sdfull_pc/B.n132 nfet_01v8_lvt_W10_L1_m2__nf1_gboth_sdfull_pc/B.n30 394
R190 nfet_01v8_lvt_W10_L1_m2__nf1_gboth_sdfull_pc/B.n132 nfet_01v8_lvt_W10_L1_m2__nf1_gboth_sdfull_pc/B.n36 394
R191 nfet_01v8_lvt_W10_L1_m2__nf1_gboth_sdfull_pc/B.n128 nfet_01v8_lvt_W10_L1_m2__nf1_gboth_sdfull_pc/B.n36 394
R192 nfet_01v8_lvt_W10_L1_m2__nf1_gboth_sdfull_pc/B.n128 nfet_01v8_lvt_W10_L1_m2__nf1_gboth_sdfull_pc/B.n38 394
R193 nfet_01v8_lvt_W10_L1_m2__nf1_gboth_sdfull_pc/B.n120 nfet_01v8_lvt_W10_L1_m2__nf1_gboth_sdfull_pc/B.n38 394
R194 nfet_01v8_lvt_W10_L1_m2__nf1_gboth_sdfull_pc/B.n120 nfet_01v8_lvt_W10_L1_m2__nf1_gboth_sdfull_pc/B.n44 394
R195 nfet_01v8_lvt_W10_L1_m2__nf1_gboth_sdfull_pc/B.n116 nfet_01v8_lvt_W10_L1_m2__nf1_gboth_sdfull_pc/B.n44 394
R196 nfet_01v8_lvt_W10_L1_m2__nf1_gboth_sdfull_pc/B.n116 nfet_01v8_lvt_W10_L1_m2__nf1_gboth_sdfull_pc/B.n46 394
R197 nfet_01v8_lvt_W10_L1_m2__nf1_gboth_sdfull_pc/B.n108 nfet_01v8_lvt_W10_L1_m2__nf1_gboth_sdfull_pc/B.n46 394
R198 nfet_01v8_lvt_W10_L1_m2__nf1_gboth_sdfull_pc/B.n108 nfet_01v8_lvt_W10_L1_m2__nf1_gboth_sdfull_pc/B.n52 394
R199 nfet_01v8_lvt_W10_L1_m2__nf1_gboth_sdfull_pc/B.n104 nfet_01v8_lvt_W10_L1_m2__nf1_gboth_sdfull_pc/B.n52 394
R200 nfet_01v8_lvt_W10_L1_m2__nf1_gboth_sdfull_pc/B.n104 nfet_01v8_lvt_W10_L1_m2__nf1_gboth_sdfull_pc/B.n54 394
R201 nfet_01v8_lvt_W10_L1_m2__nf1_gboth_sdfull_pc/B.n96 nfet_01v8_lvt_W10_L1_m2__nf1_gboth_sdfull_pc/B.n54 394
R202 nfet_01v8_lvt_W10_L1_m2__nf1_gboth_sdfull_pc/B.n96 nfet_01v8_lvt_W10_L1_m2__nf1_gboth_sdfull_pc/B.n60 394
R203 nfet_01v8_lvt_W10_L1_m2__nf1_gboth_sdfull_pc/B.n92 nfet_01v8_lvt_W10_L1_m2__nf1_gboth_sdfull_pc/B.n60 394
R204 nfet_01v8_lvt_W10_L1_m2__nf1_gboth_sdfull_pc/B.n92 nfet_01v8_lvt_W10_L1_m2__nf1_gboth_sdfull_pc/B.n62 394
R205 nfet_01v8_lvt_W10_L1_m2__nf1_gboth_sdfull_pc/B.n84 nfet_01v8_lvt_W10_L1_m2__nf1_gboth_sdfull_pc/B.n62 394
R206 nfet_01v8_lvt_W10_L1_m2__nf1_gboth_sdfull_pc/B.n84 nfet_01v8_lvt_W10_L1_m2__nf1_gboth_sdfull_pc/B.n68 394
R207 nfet_01v8_lvt_W10_L1_m2__nf1_gboth_sdfull_pc/B.n184 nfet_01v8_lvt_W10_L1_m2__nf1_gboth_sdfull_pc/B.n2 394
R208 nfet_01v8_lvt_W10_L1_m2__nf1_gboth_sdfull_pc/B.n175 nfet_01v8_lvt_W10_L1_m2__nf1_gboth_sdfull_pc/B.n8 394
R209 nfet_01v8_lvt_W10_L1_m2__nf1_gboth_sdfull_pc/B.n179 nfet_01v8_lvt_W10_L1_m2__nf1_gboth_sdfull_pc/B.n7 394
R210 nfet_01v8_lvt_W10_L1_m2__nf1_gboth_sdfull_pc/B.n171 nfet_01v8_lvt_W10_L1_m2__nf1_gboth_sdfull_pc/B.n7 394
R211 nfet_01v8_lvt_W10_L1_m2__nf1_gboth_sdfull_pc/B.n171 nfet_01v8_lvt_W10_L1_m2__nf1_gboth_sdfull_pc/B.n10 394
R212 nfet_01v8_lvt_W10_L1_m2__nf1_gboth_sdfull_pc/B.n162 nfet_01v8_lvt_W10_L1_m2__nf1_gboth_sdfull_pc/B.n10 394
R213 nfet_01v8_lvt_W10_L1_m2__nf1_gboth_sdfull_pc/B.n162 nfet_01v8_lvt_W10_L1_m2__nf1_gboth_sdfull_pc/B.n16 394
R214 nfet_01v8_lvt_W10_L1_m2__nf1_gboth_sdfull_pc/B.n158 nfet_01v8_lvt_W10_L1_m2__nf1_gboth_sdfull_pc/B.n16 394
R215 nfet_01v8_lvt_W10_L1_m2__nf1_gboth_sdfull_pc/B.n158 nfet_01v8_lvt_W10_L1_m2__nf1_gboth_sdfull_pc/B.n18 394
R216 nfet_01v8_lvt_W10_L1_m2__nf1_gboth_sdfull_pc/B.n150 nfet_01v8_lvt_W10_L1_m2__nf1_gboth_sdfull_pc/B.n18 394
R217 nfet_01v8_lvt_W10_L1_m2__nf1_gboth_sdfull_pc/B.n150 nfet_01v8_lvt_W10_L1_m2__nf1_gboth_sdfull_pc/B.n24 394
R218 nfet_01v8_lvt_W10_L1_m2__nf1_gboth_sdfull_pc/B.n146 nfet_01v8_lvt_W10_L1_m2__nf1_gboth_sdfull_pc/B.n24 394
R219 nfet_01v8_lvt_W10_L1_m2__nf1_gboth_sdfull_pc/B.n146 nfet_01v8_lvt_W10_L1_m2__nf1_gboth_sdfull_pc/B.n26 394
R220 nfet_01v8_lvt_W10_L1_m2__nf1_gboth_sdfull_pc/B.n138 nfet_01v8_lvt_W10_L1_m2__nf1_gboth_sdfull_pc/B.n26 394
R221 nfet_01v8_lvt_W10_L1_m2__nf1_gboth_sdfull_pc/B.n138 nfet_01v8_lvt_W10_L1_m2__nf1_gboth_sdfull_pc/B.n32 394
R222 nfet_01v8_lvt_W10_L1_m2__nf1_gboth_sdfull_pc/B.n134 nfet_01v8_lvt_W10_L1_m2__nf1_gboth_sdfull_pc/B.n32 394
R223 nfet_01v8_lvt_W10_L1_m2__nf1_gboth_sdfull_pc/B.n134 nfet_01v8_lvt_W10_L1_m2__nf1_gboth_sdfull_pc/B.n34 394
R224 nfet_01v8_lvt_W10_L1_m2__nf1_gboth_sdfull_pc/B.n126 nfet_01v8_lvt_W10_L1_m2__nf1_gboth_sdfull_pc/B.n34 394
R225 nfet_01v8_lvt_W10_L1_m2__nf1_gboth_sdfull_pc/B.n126 nfet_01v8_lvt_W10_L1_m2__nf1_gboth_sdfull_pc/B.n40 394
R226 nfet_01v8_lvt_W10_L1_m2__nf1_gboth_sdfull_pc/B.n122 nfet_01v8_lvt_W10_L1_m2__nf1_gboth_sdfull_pc/B.n40 394
R227 nfet_01v8_lvt_W10_L1_m2__nf1_gboth_sdfull_pc/B.n122 nfet_01v8_lvt_W10_L1_m2__nf1_gboth_sdfull_pc/B.n42 394
R228 nfet_01v8_lvt_W10_L1_m2__nf1_gboth_sdfull_pc/B.n114 nfet_01v8_lvt_W10_L1_m2__nf1_gboth_sdfull_pc/B.n42 394
R229 nfet_01v8_lvt_W10_L1_m2__nf1_gboth_sdfull_pc/B.n114 nfet_01v8_lvt_W10_L1_m2__nf1_gboth_sdfull_pc/B.n48 394
R230 nfet_01v8_lvt_W10_L1_m2__nf1_gboth_sdfull_pc/B.n110 nfet_01v8_lvt_W10_L1_m2__nf1_gboth_sdfull_pc/B.n48 394
R231 nfet_01v8_lvt_W10_L1_m2__nf1_gboth_sdfull_pc/B.n110 nfet_01v8_lvt_W10_L1_m2__nf1_gboth_sdfull_pc/B.n50 394
R232 nfet_01v8_lvt_W10_L1_m2__nf1_gboth_sdfull_pc/B.n102 nfet_01v8_lvt_W10_L1_m2__nf1_gboth_sdfull_pc/B.n50 394
R233 nfet_01v8_lvt_W10_L1_m2__nf1_gboth_sdfull_pc/B.n102 nfet_01v8_lvt_W10_L1_m2__nf1_gboth_sdfull_pc/B.n56 394
R234 nfet_01v8_lvt_W10_L1_m2__nf1_gboth_sdfull_pc/B.n98 nfet_01v8_lvt_W10_L1_m2__nf1_gboth_sdfull_pc/B.n56 394
R235 nfet_01v8_lvt_W10_L1_m2__nf1_gboth_sdfull_pc/B.n98 nfet_01v8_lvt_W10_L1_m2__nf1_gboth_sdfull_pc/B.n58 394
R236 nfet_01v8_lvt_W10_L1_m2__nf1_gboth_sdfull_pc/B.n90 nfet_01v8_lvt_W10_L1_m2__nf1_gboth_sdfull_pc/B.n58 394
R237 nfet_01v8_lvt_W10_L1_m2__nf1_gboth_sdfull_pc/B.n90 nfet_01v8_lvt_W10_L1_m2__nf1_gboth_sdfull_pc/B.n64 394
R238 nfet_01v8_lvt_W10_L1_m2__nf1_gboth_sdfull_pc/B.n86 nfet_01v8_lvt_W10_L1_m2__nf1_gboth_sdfull_pc/B.n64 394
R239 nfet_01v8_lvt_W10_L1_m2__nf1_gboth_sdfull_pc/B.n86 nfet_01v8_lvt_W10_L1_m2__nf1_gboth_sdfull_pc/B.n66 394
R240 nfet_01v8_lvt_W10_L1_m2__nf1_gboth_sdfull_pc/B.n71 nfet_01v8_lvt_W10_L1_m2__nf1_gboth_sdfull_pc/B.n70 394
R241 nfet_01v8_lvt_W10_L1_m2__nf1_gboth_sdfull_pc/B.n72 nfet_01v8_lvt_W10_L1_m2__nf1_gboth_sdfull_pc/B.n71 394
R242 nfet_01v8_lvt_W10_L1_m2__nf1_gboth_sdfull_pc/B.n3 B 330.769
R243 nfet_01v8_lvt_W10_L1_m2__nf1_gboth_sdfull_pc/B.t0 nfet_01v8_lvt_W10_L1_m2__nf1_gboth_sdfull_pc/B.n35 261.538
R244 nfet_01v8_lvt_W10_L1_m2__nf1_gboth_sdfull_pc/B.n127 nfet_01v8_lvt_W10_L1_m2__nf1_gboth_sdfull_pc/B.t0 261.538
R245 nfet_01v8_lvt_W10_L1_m2__nf1_gboth_sdfull_pc/B.n79 nfet_01v8_lvt_W10_L1_m2__nf1_gboth_sdfull_pc/B.n78 218.815
R246 nfet_01v8_lvt_W10_L1_m2__nf1_gboth_sdfull_pc/B.n78 nfet_01v8_lvt_W10_L1_m2__nf1_gboth_sdfull_pc/B.n77 218.815
R247 nfet_01v8_lvt_W10_L1_m2__nf1_gboth_sdfull_pc/B.n174 nfet_01v8_lvt_W10_L1_m2__nf1_gboth_sdfull_pc/B.n3 218.815
R248 nfet_01v8_lvt_W10_L1_m2__nf1_gboth_sdfull_pc/B.n183 nfet_01v8_lvt_W10_L1_m2__nf1_gboth_sdfull_pc/B.n3 218.815
R249 nfet_01v8_lvt_W10_L1_m2__nf1_gboth_sdfull_pc/B.n80 nfet_01v8_lvt_W10_L1_m2__nf1_gboth_sdfull_pc/B.n79 147.374
R250 nfet_01v8_lvt_W10_L1_m2__nf1_gboth_sdfull_pc/B.n77 nfet_01v8_lvt_W10_L1_m2__nf1_gboth_sdfull_pc/B.n72 147.374
R251 nfet_01v8_lvt_W10_L1_m2__nf1_gboth_sdfull_pc/B.n175 nfet_01v8_lvt_W10_L1_m2__nf1_gboth_sdfull_pc/B.n174 147.374
R252 nfet_01v8_lvt_W10_L1_m2__nf1_gboth_sdfull_pc/B.n184 nfet_01v8_lvt_W10_L1_m2__nf1_gboth_sdfull_pc/B.n183 147.374
R253 nfet_01v8_lvt_W10_L1_m2__nf1_gboth_sdfull_pc/B.n183 nfet_01v8_lvt_W10_L1_m2__nf1_gboth_sdfull_pc/B.n182 147.374
R254 nfet_01v8_lvt_W10_L1_m2__nf1_gboth_sdfull_pc/B.n174 nfet_01v8_lvt_W10_L1_m2__nf1_gboth_sdfull_pc/B.n2 147.374
R255 nfet_01v8_lvt_W10_L1_m2__nf1_gboth_sdfull_pc/B.n79 nfet_01v8_lvt_W10_L1_m2__nf1_gboth_sdfull_pc/B.n70 147.374
R256 nfet_01v8_lvt_W10_L1_m2__nf1_gboth_sdfull_pc/B.n77 nfet_01v8_lvt_W10_L1_m2__nf1_gboth_sdfull_pc/B.n76 147.374
R257 nfet_01v8_lvt_W10_L1_m2__nf1_gboth_sdfull_pc/B.n5 nfet_01v8_lvt_W10_L1_m2__nf1_gboth_sdfull_pc/B.n1 72.6593
R258 nfet_01v8_lvt_W10_L1_m2__nf1_gboth_sdfull_pc/B.n178 nfet_01v8_lvt_W10_L1_m2__nf1_gboth_sdfull_pc/B.n177 72.6593
R259 nfet_01v8_lvt_W10_L1_m2__nf1_gboth_sdfull_pc/B.n82 nfet_01v8_lvt_W10_L1_m2__nf1_gboth_sdfull_pc/B.n81 72.6593
R260 nfet_01v8_lvt_W10_L1_m2__nf1_gboth_sdfull_pc/B.n75 nfet_01v8_lvt_W10_L1_m2__nf1_gboth_sdfull_pc/B.n65 72.6593
R261 nfet_01v8_lvt_W10_L1_m2__nf1_gboth_sdfull_pc/B.n167 nfet_01v8_lvt_W10_L1_m2__nf1_gboth_sdfull_pc/B.n5 25.6005
R262 nfet_01v8_lvt_W10_L1_m2__nf1_gboth_sdfull_pc/B.n168 nfet_01v8_lvt_W10_L1_m2__nf1_gboth_sdfull_pc/B.n167 25.6005
R263 nfet_01v8_lvt_W10_L1_m2__nf1_gboth_sdfull_pc/B.n168 nfet_01v8_lvt_W10_L1_m2__nf1_gboth_sdfull_pc/B.n166 25.6005
R264 nfet_01v8_lvt_W10_L1_m2__nf1_gboth_sdfull_pc/B.n166 nfet_01v8_lvt_W10_L1_m2__nf1_gboth_sdfull_pc/B.n165 25.6005
R265 nfet_01v8_lvt_W10_L1_m2__nf1_gboth_sdfull_pc/B.n165 nfet_01v8_lvt_W10_L1_m2__nf1_gboth_sdfull_pc/B.n13 25.6005
R266 nfet_01v8_lvt_W10_L1_m2__nf1_gboth_sdfull_pc/B.n155 nfet_01v8_lvt_W10_L1_m2__nf1_gboth_sdfull_pc/B.n13 25.6005
R267 nfet_01v8_lvt_W10_L1_m2__nf1_gboth_sdfull_pc/B.n155 nfet_01v8_lvt_W10_L1_m2__nf1_gboth_sdfull_pc/B.n154 25.6005
R268 nfet_01v8_lvt_W10_L1_m2__nf1_gboth_sdfull_pc/B.n154 nfet_01v8_lvt_W10_L1_m2__nf1_gboth_sdfull_pc/B.n153 25.6005
R269 nfet_01v8_lvt_W10_L1_m2__nf1_gboth_sdfull_pc/B.n153 nfet_01v8_lvt_W10_L1_m2__nf1_gboth_sdfull_pc/B.n21 25.6005
R270 nfet_01v8_lvt_W10_L1_m2__nf1_gboth_sdfull_pc/B.n143 nfet_01v8_lvt_W10_L1_m2__nf1_gboth_sdfull_pc/B.n21 25.6005
R271 nfet_01v8_lvt_W10_L1_m2__nf1_gboth_sdfull_pc/B.n143 nfet_01v8_lvt_W10_L1_m2__nf1_gboth_sdfull_pc/B.n142 25.6005
R272 nfet_01v8_lvt_W10_L1_m2__nf1_gboth_sdfull_pc/B.n142 nfet_01v8_lvt_W10_L1_m2__nf1_gboth_sdfull_pc/B.n141 25.6005
R273 nfet_01v8_lvt_W10_L1_m2__nf1_gboth_sdfull_pc/B.n141 nfet_01v8_lvt_W10_L1_m2__nf1_gboth_sdfull_pc/B.n29 25.6005
R274 nfet_01v8_lvt_W10_L1_m2__nf1_gboth_sdfull_pc/B.n131 nfet_01v8_lvt_W10_L1_m2__nf1_gboth_sdfull_pc/B.n29 25.6005
R275 nfet_01v8_lvt_W10_L1_m2__nf1_gboth_sdfull_pc/B.n131 nfet_01v8_lvt_W10_L1_m2__nf1_gboth_sdfull_pc/B.n130 25.6005
R276 nfet_01v8_lvt_W10_L1_m2__nf1_gboth_sdfull_pc/B.n130 nfet_01v8_lvt_W10_L1_m2__nf1_gboth_sdfull_pc/B.n129 25.6005
R277 nfet_01v8_lvt_W10_L1_m2__nf1_gboth_sdfull_pc/B.n129 nfet_01v8_lvt_W10_L1_m2__nf1_gboth_sdfull_pc/B.n37 25.6005
R278 nfet_01v8_lvt_W10_L1_m2__nf1_gboth_sdfull_pc/B.n119 nfet_01v8_lvt_W10_L1_m2__nf1_gboth_sdfull_pc/B.n37 25.6005
R279 nfet_01v8_lvt_W10_L1_m2__nf1_gboth_sdfull_pc/B.n119 nfet_01v8_lvt_W10_L1_m2__nf1_gboth_sdfull_pc/B.n118 25.6005
R280 nfet_01v8_lvt_W10_L1_m2__nf1_gboth_sdfull_pc/B.n118 nfet_01v8_lvt_W10_L1_m2__nf1_gboth_sdfull_pc/B.n117 25.6005
R281 nfet_01v8_lvt_W10_L1_m2__nf1_gboth_sdfull_pc/B.n117 nfet_01v8_lvt_W10_L1_m2__nf1_gboth_sdfull_pc/B.n45 25.6005
R282 nfet_01v8_lvt_W10_L1_m2__nf1_gboth_sdfull_pc/B.n107 nfet_01v8_lvt_W10_L1_m2__nf1_gboth_sdfull_pc/B.n45 25.6005
R283 nfet_01v8_lvt_W10_L1_m2__nf1_gboth_sdfull_pc/B.n107 nfet_01v8_lvt_W10_L1_m2__nf1_gboth_sdfull_pc/B.n106 25.6005
R284 nfet_01v8_lvt_W10_L1_m2__nf1_gboth_sdfull_pc/B.n106 nfet_01v8_lvt_W10_L1_m2__nf1_gboth_sdfull_pc/B.n105 25.6005
R285 nfet_01v8_lvt_W10_L1_m2__nf1_gboth_sdfull_pc/B.n105 nfet_01v8_lvt_W10_L1_m2__nf1_gboth_sdfull_pc/B.n53 25.6005
R286 nfet_01v8_lvt_W10_L1_m2__nf1_gboth_sdfull_pc/B.n95 nfet_01v8_lvt_W10_L1_m2__nf1_gboth_sdfull_pc/B.n53 25.6005
R287 nfet_01v8_lvt_W10_L1_m2__nf1_gboth_sdfull_pc/B.n95 nfet_01v8_lvt_W10_L1_m2__nf1_gboth_sdfull_pc/B.n94 25.6005
R288 nfet_01v8_lvt_W10_L1_m2__nf1_gboth_sdfull_pc/B.n94 nfet_01v8_lvt_W10_L1_m2__nf1_gboth_sdfull_pc/B.n93 25.6005
R289 nfet_01v8_lvt_W10_L1_m2__nf1_gboth_sdfull_pc/B.n93 nfet_01v8_lvt_W10_L1_m2__nf1_gboth_sdfull_pc/B.n61 25.6005
R290 nfet_01v8_lvt_W10_L1_m2__nf1_gboth_sdfull_pc/B.n83 nfet_01v8_lvt_W10_L1_m2__nf1_gboth_sdfull_pc/B.n61 25.6005
R291 nfet_01v8_lvt_W10_L1_m2__nf1_gboth_sdfull_pc/B.n83 nfet_01v8_lvt_W10_L1_m2__nf1_gboth_sdfull_pc/B.n82 25.6005
R292 nfet_01v8_lvt_W10_L1_m2__nf1_gboth_sdfull_pc/B.n185 nfet_01v8_lvt_W10_L1_m2__nf1_gboth_sdfull_pc/B.n1 25.6005
R293 nfet_01v8_lvt_W10_L1_m2__nf1_gboth_sdfull_pc/B.n176 nfet_01v8_lvt_W10_L1_m2__nf1_gboth_sdfull_pc/B.n0 25.6005
R294 nfet_01v8_lvt_W10_L1_m2__nf1_gboth_sdfull_pc/B.n177 nfet_01v8_lvt_W10_L1_m2__nf1_gboth_sdfull_pc/B.n176 25.6005
R295 nfet_01v8_lvt_W10_L1_m2__nf1_gboth_sdfull_pc/B.n178 nfet_01v8_lvt_W10_L1_m2__nf1_gboth_sdfull_pc/B.n173 25.6005
R296 nfet_01v8_lvt_W10_L1_m2__nf1_gboth_sdfull_pc/B.n173 nfet_01v8_lvt_W10_L1_m2__nf1_gboth_sdfull_pc/B.n172 25.6005
R297 nfet_01v8_lvt_W10_L1_m2__nf1_gboth_sdfull_pc/B.n172 nfet_01v8_lvt_W10_L1_m2__nf1_gboth_sdfull_pc/B.n9 25.6005
R298 nfet_01v8_lvt_W10_L1_m2__nf1_gboth_sdfull_pc/B.n161 nfet_01v8_lvt_W10_L1_m2__nf1_gboth_sdfull_pc/B.n9 25.6005
R299 nfet_01v8_lvt_W10_L1_m2__nf1_gboth_sdfull_pc/B.n161 nfet_01v8_lvt_W10_L1_m2__nf1_gboth_sdfull_pc/B.n160 25.6005
R300 nfet_01v8_lvt_W10_L1_m2__nf1_gboth_sdfull_pc/B.n160 nfet_01v8_lvt_W10_L1_m2__nf1_gboth_sdfull_pc/B.n159 25.6005
R301 nfet_01v8_lvt_W10_L1_m2__nf1_gboth_sdfull_pc/B.n159 nfet_01v8_lvt_W10_L1_m2__nf1_gboth_sdfull_pc/B.n17 25.6005
R302 nfet_01v8_lvt_W10_L1_m2__nf1_gboth_sdfull_pc/B.n149 nfet_01v8_lvt_W10_L1_m2__nf1_gboth_sdfull_pc/B.n17 25.6005
R303 nfet_01v8_lvt_W10_L1_m2__nf1_gboth_sdfull_pc/B.n149 nfet_01v8_lvt_W10_L1_m2__nf1_gboth_sdfull_pc/B.n148 25.6005
R304 nfet_01v8_lvt_W10_L1_m2__nf1_gboth_sdfull_pc/B.n148 nfet_01v8_lvt_W10_L1_m2__nf1_gboth_sdfull_pc/B.n147 25.6005
R305 nfet_01v8_lvt_W10_L1_m2__nf1_gboth_sdfull_pc/B.n147 nfet_01v8_lvt_W10_L1_m2__nf1_gboth_sdfull_pc/B.n25 25.6005
R306 nfet_01v8_lvt_W10_L1_m2__nf1_gboth_sdfull_pc/B.n137 nfet_01v8_lvt_W10_L1_m2__nf1_gboth_sdfull_pc/B.n25 25.6005
R307 nfet_01v8_lvt_W10_L1_m2__nf1_gboth_sdfull_pc/B.n137 nfet_01v8_lvt_W10_L1_m2__nf1_gboth_sdfull_pc/B.n136 25.6005
R308 nfet_01v8_lvt_W10_L1_m2__nf1_gboth_sdfull_pc/B.n136 nfet_01v8_lvt_W10_L1_m2__nf1_gboth_sdfull_pc/B.n135 25.6005
R309 nfet_01v8_lvt_W10_L1_m2__nf1_gboth_sdfull_pc/B.n135 nfet_01v8_lvt_W10_L1_m2__nf1_gboth_sdfull_pc/B.n33 25.6005
R310 nfet_01v8_lvt_W10_L1_m2__nf1_gboth_sdfull_pc/B.n125 nfet_01v8_lvt_W10_L1_m2__nf1_gboth_sdfull_pc/B.n33 25.6005
R311 nfet_01v8_lvt_W10_L1_m2__nf1_gboth_sdfull_pc/B.n125 nfet_01v8_lvt_W10_L1_m2__nf1_gboth_sdfull_pc/B.n124 25.6005
R312 nfet_01v8_lvt_W10_L1_m2__nf1_gboth_sdfull_pc/B.n124 nfet_01v8_lvt_W10_L1_m2__nf1_gboth_sdfull_pc/B.n123 25.6005
R313 nfet_01v8_lvt_W10_L1_m2__nf1_gboth_sdfull_pc/B.n123 nfet_01v8_lvt_W10_L1_m2__nf1_gboth_sdfull_pc/B.n41 25.6005
R314 nfet_01v8_lvt_W10_L1_m2__nf1_gboth_sdfull_pc/B.n113 nfet_01v8_lvt_W10_L1_m2__nf1_gboth_sdfull_pc/B.n41 25.6005
R315 nfet_01v8_lvt_W10_L1_m2__nf1_gboth_sdfull_pc/B.n113 nfet_01v8_lvt_W10_L1_m2__nf1_gboth_sdfull_pc/B.n112 25.6005
R316 nfet_01v8_lvt_W10_L1_m2__nf1_gboth_sdfull_pc/B.n112 nfet_01v8_lvt_W10_L1_m2__nf1_gboth_sdfull_pc/B.n111 25.6005
R317 nfet_01v8_lvt_W10_L1_m2__nf1_gboth_sdfull_pc/B.n111 nfet_01v8_lvt_W10_L1_m2__nf1_gboth_sdfull_pc/B.n49 25.6005
R318 nfet_01v8_lvt_W10_L1_m2__nf1_gboth_sdfull_pc/B.n101 nfet_01v8_lvt_W10_L1_m2__nf1_gboth_sdfull_pc/B.n49 25.6005
R319 nfet_01v8_lvt_W10_L1_m2__nf1_gboth_sdfull_pc/B.n101 nfet_01v8_lvt_W10_L1_m2__nf1_gboth_sdfull_pc/B.n100 25.6005
R320 nfet_01v8_lvt_W10_L1_m2__nf1_gboth_sdfull_pc/B.n100 nfet_01v8_lvt_W10_L1_m2__nf1_gboth_sdfull_pc/B.n99 25.6005
R321 nfet_01v8_lvt_W10_L1_m2__nf1_gboth_sdfull_pc/B.n99 nfet_01v8_lvt_W10_L1_m2__nf1_gboth_sdfull_pc/B.n57 25.6005
R322 nfet_01v8_lvt_W10_L1_m2__nf1_gboth_sdfull_pc/B.n89 nfet_01v8_lvt_W10_L1_m2__nf1_gboth_sdfull_pc/B.n57 25.6005
R323 nfet_01v8_lvt_W10_L1_m2__nf1_gboth_sdfull_pc/B.n89 nfet_01v8_lvt_W10_L1_m2__nf1_gboth_sdfull_pc/B.n88 25.6005
R324 nfet_01v8_lvt_W10_L1_m2__nf1_gboth_sdfull_pc/B.n88 nfet_01v8_lvt_W10_L1_m2__nf1_gboth_sdfull_pc/B.n87 25.6005
R325 nfet_01v8_lvt_W10_L1_m2__nf1_gboth_sdfull_pc/B.n87 nfet_01v8_lvt_W10_L1_m2__nf1_gboth_sdfull_pc/B.n65 25.6005
R326 nfet_01v8_lvt_W10_L1_m2__nf1_gboth_sdfull_pc/B.n81 nfet_01v8_lvt_W10_L1_m2__nf1_gboth_sdfull_pc/B.n69 25.6005
R327 nfet_01v8_lvt_W10_L1_m2__nf1_gboth_sdfull_pc/B.n73 nfet_01v8_lvt_W10_L1_m2__nf1_gboth_sdfull_pc/B.n69 25.6005
R328 nfet_01v8_lvt_W10_L1_m2__nf1_gboth_sdfull_pc/B.n74 nfet_01v8_lvt_W10_L1_m2__nf1_gboth_sdfull_pc/B.n73 25.6005
R329 nfet_01v8_lvt_W10_L1_m2__nf1_gboth_sdfull_pc/B.n75 nfet_01v8_lvt_W10_L1_m2__nf1_gboth_sdfull_pc/B.n74 25.6005
R330 B nfet_01v8_lvt_W10_L1_m2__nf1_gboth_sdfull_pc/B.n185 19.2005
R331 B nfet_01v8_lvt_W10_L1_m2__nf1_gboth_sdfull_pc/B.n0 6.4005
R332 B.n184 B.n3 1118.26
R333 B.n176 B.n175 1118.26
R334 B.n81 B.n70 1118.26
R335 B.n83 B.n68 1118.26
R336 B.n185 B.n0 792.308
R337 B.n82 B.n69 792.308
R338 B.n185 B.n184 585
R339 B.n184 B.n183 585
R340 B.n182 B.n4 585
R341 B.n181 B.n180 585
R342 B.n179 B.n178 585
R343 B.n177 B.n176 585
R344 B.n175 B.n0 585
R345 B.n175 B.n6 585
R346 B.n174 B.n173 585
R347 B.n174 B.n8 585
R348 B.n9 B.n7 585
R349 B.n164 B.n7 585
R350 B.n167 B.n166 585
R351 B.n166 B.n165 585
R352 B.n14 B.n13 585
R353 B.n163 B.n14 585
R354 B.n161 B.n160 585
R355 B.n162 B.n161 585
R356 B.n17 B.n16 585
R357 B.n16 B.n15 585
R358 B.n154 B.n153 585
R359 B.n153 B.n152 585
R360 B.n22 B.n21 585
R361 B.n151 B.n22 585
R362 B.n149 B.n148 585
R363 B.n150 B.n149 585
R364 B.n25 B.n24 585
R365 B.n24 B.n23 585
R366 B.n142 B.n141 585
R367 B.n141 B.n140 585
R368 B.n30 B.n29 585
R369 B.n139 B.n30 585
R370 B.n137 B.n136 585
R371 B.n138 B.n137 585
R372 B.n33 B.n32 585
R373 B.n32 B.n31 585
R374 B.n130 B.n129 585
R375 B.n129 B.n128 585
R376 B.n38 B.n37 585
R377 B.n127 B.n38 585
R378 B.n125 B.n124 585
R379 B.n126 B.n125 585
R380 B.n41 B.n40 585
R381 B.n40 B.n39 585
R382 B.n118 B.n117 585
R383 B.n117 B.n116 585
R384 B.n46 B.n45 585
R385 B.n115 B.n46 585
R386 B.n113 B.n112 585
R387 B.n114 B.n113 585
R388 B.n49 B.n48 585
R389 B.n48 B.n47 585
R390 B.n106 B.n105 585
R391 B.n105 B.n104 585
R392 B.n54 B.n53 585
R393 B.n103 B.n54 585
R394 B.n101 B.n100 585
R395 B.n102 B.n101 585
R396 B.n57 B.n56 585
R397 B.n56 B.n55 585
R398 B.n94 B.n93 585
R399 B.n93 B.n92 585
R400 B.n62 B.n61 585
R401 B.n91 B.n62 585
R402 B.n89 B.n88 585
R403 B.n90 B.n89 585
R404 B.n65 B.n64 585
R405 B.n64 B.n63 585
R406 B.n82 B.n81 585
R407 B.n81 B.n80 585
R408 B.n70 B.n69 585
R409 B.n79 B.n70 585
R410 B.n78 B.n77 585
R411 B.n75 B.n71 585
R412 B.n74 B.n72 585
R413 B.n68 B.n67 585
R414 B.n83 B.n82 585
R415 B.n84 B.n83 585
R416 B.n66 B.n65 585
R417 B.n85 B.n66 585
R418 B.n88 B.n87 585
R419 B.n87 B.n86 585
R420 B.n61 B.n60 585
R421 B.n60 B.n59 585
R422 B.n95 B.n94 585
R423 B.n96 B.n95 585
R424 B.n58 B.n57 585
R425 B.n97 B.n58 585
R426 B.n100 B.n99 585
R427 B.n99 B.n98 585
R428 B.n53 B.n52 585
R429 B.n52 B.n51 585
R430 B.n107 B.n106 585
R431 B.n108 B.n107 585
R432 B.n50 B.n49 585
R433 B.n109 B.n50 585
R434 B.n112 B.n111 585
R435 B.n111 B.n110 585
R436 B.n45 B.n44 585
R437 B.n44 B.n43 585
R438 B.n119 B.n118 585
R439 B.n120 B.n119 585
R440 B.n42 B.n41 585
R441 B.n121 B.n42 585
R442 B.n124 B.n123 585
R443 B.n123 B.n122 585
R444 B.n37 B.n36 585
R445 B.n36 B.n35 585
R446 B.n131 B.n130 585
R447 B.n132 B.n131 585
R448 B.n34 B.n33 585
R449 B.n133 B.n34 585
R450 B.n136 B.n135 585
R451 B.n135 B.n134 585
R452 B.n29 B.n28 585
R453 B.n28 B.n27 585
R454 B.n143 B.n142 585
R455 B.n144 B.n143 585
R456 B.n26 B.n25 585
R457 B.n145 B.n26 585
R458 B.n148 B.n147 585
R459 B.n147 B.n146 585
R460 B.n21 B.n20 585
R461 B.n20 B.n19 585
R462 B.n155 B.n154 585
R463 B.n156 B.n155 585
R464 B.n18 B.n17 585
R465 B.n157 B.n18 585
R466 B.n160 B.n159 585
R467 B.n159 B.n158 585
R468 B.n13 B.n12 585
R469 B.n12 B.n11 585
R470 B.n168 B.n167 585
R471 B.n169 B.n168 585
R472 B.n10 B.n9 585
R473 B.n170 B.n10 585
R474 B.n173 B.n172 585
R475 B.n172 B.n171 585
R476 B.n3 B.n0 585
R477 B.n5 B.n3 585
R478 B.n173 B.n0 523.077
R479 B.n173 B.n9 523.077
R480 B.n167 B.n9 523.077
R481 B.n167 B.n13 523.077
R482 B.n160 B.n13 523.077
R483 B.n160 B.n17 523.077
R484 B.n154 B.n17 523.077
R485 B.n154 B.n21 523.077
R486 B.n148 B.n21 523.077
R487 B.n148 B.n25 523.077
R488 B.n142 B.n25 523.077
R489 B.n142 B.n29 523.077
R490 B.n136 B.n29 523.077
R491 B.n136 B.n33 523.077
R492 B.n130 B.n33 523.077
R493 B.n130 B.n37 523.077
R494 B.n124 B.n37 523.077
R495 B.n124 B.n41 523.077
R496 B.n118 B.n41 523.077
R497 B.n118 B.n45 523.077
R498 B.n112 B.n45 523.077
R499 B.n112 B.n49 523.077
R500 B.n106 B.n49 523.077
R501 B.n106 B.n53 523.077
R502 B.n100 B.n53 523.077
R503 B.n100 B.n57 523.077
R504 B.n94 B.n57 523.077
R505 B.n94 B.n61 523.077
R506 B.n88 B.n61 523.077
R507 B.n88 B.n65 523.077
R508 B.n82 B.n65 523.077
R509 B.n172 B.n3 394
R510 B.n172 B.n10 394
R511 B.n168 B.n10 394
R512 B.n168 B.n12 394
R513 B.n159 B.n12 394
R514 B.n159 B.n18 394
R515 B.n155 B.n18 394
R516 B.n155 B.n20 394
R517 B.n147 B.n20 394
R518 B.n147 B.n26 394
R519 B.n143 B.n26 394
R520 B.n143 B.n28 394
R521 B.n135 B.n28 394
R522 B.n135 B.n34 394
R523 B.n131 B.n34 394
R524 B.n131 B.n36 394
R525 B.n123 B.n36 394
R526 B.n123 B.n42 394
R527 B.n119 B.n42 394
R528 B.n119 B.n44 394
R529 B.n111 B.n44 394
R530 B.n111 B.n50 394
R531 B.n107 B.n50 394
R532 B.n107 B.n52 394
R533 B.n99 B.n52 394
R534 B.n99 B.n58 394
R535 B.n95 B.n58 394
R536 B.n95 B.n60 394
R537 B.n87 B.n60 394
R538 B.n87 B.n66 394
R539 B.n83 B.n66 394
R540 B.n180 B.n179 394
R541 B.n184 B.n4 394
R542 B.n175 B.n174 394
R543 B.n174 B.n7 394
R544 B.n166 B.n7 394
R545 B.n166 B.n14 394
R546 B.n161 B.n14 394
R547 B.n161 B.n16 394
R548 B.n153 B.n16 394
R549 B.n153 B.n22 394
R550 B.n149 B.n22 394
R551 B.n149 B.n24 394
R552 B.n141 B.n24 394
R553 B.n141 B.n30 394
R554 B.n137 B.n30 394
R555 B.n137 B.n32 394
R556 B.n129 B.n32 394
R557 B.n129 B.n38 394
R558 B.n125 B.n38 394
R559 B.n125 B.n40 394
R560 B.n117 B.n40 394
R561 B.n117 B.n46 394
R562 B.n113 B.n46 394
R563 B.n113 B.n48 394
R564 B.n105 B.n48 394
R565 B.n105 B.n54 394
R566 B.n101 B.n54 394
R567 B.n101 B.n56 394
R568 B.n93 B.n56 394
R569 B.n93 B.n62 394
R570 B.n89 B.n62 394
R571 B.n89 B.n64 394
R572 B.n81 B.n64 394
R573 B.n77 B.n70 394
R574 B.n75 B.n74 394
R575 B B.n185 330.769
R576 B.n185 B.n2 218.815
R577 B.n185 B.n1 218.815
R578 B.n76 B.n69 218.815
R579 B.n73 B.n69 218.815
R580 B.n4 B.n2 147.374
R581 B.n179 B.n1 147.374
R582 B.n77 B.n76 147.374
R583 B.n74 B.n73 147.374
R584 B.n176 B.n1 147.374
R585 B.n180 B.n2 147.374
R586 B.n76 B.n75 147.374
R587 B.n73 B.n68 147.374
R588 B.n177 B.n6 72.6593
R589 B.n80 B.n79 72.6593
R590 B.n183 B.n5 72.6593
R591 B.n84 B.n67 72.6593
R592 B.n178 B.n177 25.6005
R593 B.n182 B.n181 25.6005
R594 B.n183 B.n182 25.6005
R595 B.n8 B.n6 25.6005
R596 B.n164 B.n8 25.6005
R597 B.n165 B.n164 25.6005
R598 B.n165 B.n163 25.6005
R599 B.n163 B.n162 25.6005
R600 B.n162 B.n15 25.6005
R601 B.n152 B.n15 25.6005
R602 B.n152 B.n151 25.6005
R603 B.n151 B.n150 25.6005
R604 B.n150 B.n23 25.6005
R605 B.n140 B.n23 25.6005
R606 B.n140 B.n139 25.6005
R607 B.n139 B.n138 25.6005
R608 B.n138 B.n31 25.6005
R609 B.n128 B.n31 25.6005
R610 B.n128 B.n127 25.6005
R611 B.n127 B.n126 25.6005
R612 B.n126 B.n39 25.6005
R613 B.n116 B.n39 25.6005
R614 B.n116 B.n115 25.6005
R615 B.n115 B.n114 25.6005
R616 B.n114 B.n47 25.6005
R617 B.n104 B.n47 25.6005
R618 B.n104 B.n103 25.6005
R619 B.n103 B.n102 25.6005
R620 B.n102 B.n55 25.6005
R621 B.n92 B.n55 25.6005
R622 B.n92 B.n91 25.6005
R623 B.n91 B.n90 25.6005
R624 B.n90 B.n63 25.6005
R625 B.n80 B.n63 25.6005
R626 B.n79 B.n78 25.6005
R627 B.n78 B.n71 25.6005
R628 B.n72 B.n71 25.6005
R629 B.n72 B.n67 25.6005
R630 B.n171 B.n5 25.6005
R631 B.n171 B.n170 25.6005
R632 B.n170 B.n169 25.6005
R633 B.n169 B.n11 25.6005
R634 B.n158 B.n11 25.6005
R635 B.n158 B.n157 25.6005
R636 B.n157 B.n156 25.6005
R637 B.n156 B.n19 25.6005
R638 B.n146 B.n19 25.6005
R639 B.n146 B.n145 25.6005
R640 B.n145 B.n144 25.6005
R641 B.n144 B.n27 25.6005
R642 B.n134 B.n27 25.6005
R643 B.n134 B.n133 25.6005
R644 B.n133 B.n132 25.6005
R645 B.n132 B.n35 25.6005
R646 B.n122 B.n35 25.6005
R647 B.n122 B.n121 25.6005
R648 B.n121 B.n120 25.6005
R649 B.n120 B.n43 25.6005
R650 B.n110 B.n43 25.6005
R651 B.n110 B.n109 25.6005
R652 B.n109 B.n108 25.6005
R653 B.n108 B.n51 25.6005
R654 B.n98 B.n51 25.6005
R655 B.n98 B.n97 25.6005
R656 B.n97 B.n96 25.6005
R657 B.n96 B.n59 25.6005
R658 B.n86 B.n59 25.6005
R659 B.n86 B.n85 25.6005
R660 B.n85 B.n84 25.6005
R661 B.n178 B 19.2005
R662 B.n181 B 6.4005
R663 w_n43_n43.n182 w_n43_n43.n181 1118.26
R664 w_n43_n43.n179 w_n43_n43.n8 1118.26
R665 w_n43_n43.n80 w_n43_n43.n68 1118.26
R666 w_n43_n43.n73 w_n43_n43.n66 1118.26
R667 w_n43_n43.n180 w_n43_n43.n3 792.308
R668 w_n43_n43.n79 w_n43_n43.n67 792.308
R669 w_n43_n43.n80 w_n43_n43.n79 585
R670 w_n43_n43.n81 w_n43_n43.n80 585
R671 w_n43_n43.n70 w_n43_n43.n69 585
R672 w_n43_n43.n77 w_n43_n43.n76 585
R673 w_n43_n43.n75 w_n43_n43.n72 585
R674 w_n43_n43.n74 w_n43_n43.n73 585
R675 w_n43_n43.n67 w_n43_n43.n66 585
R676 w_n43_n43.n66 w_n43_n43.n65 585
R677 w_n43_n43.n86 w_n43_n43.n85 585
R678 w_n43_n43.n87 w_n43_n43.n86 585
R679 w_n43_n43.n64 w_n43_n43.n63 585
R680 w_n43_n43.n88 w_n43_n43.n64 585
R681 w_n43_n43.n91 w_n43_n43.n90 585
R682 w_n43_n43.n90 w_n43_n43.n89 585
R683 w_n43_n43.n59 w_n43_n43.n58 585
R684 w_n43_n43.n58 w_n43_n43.n57 585
R685 w_n43_n43.n98 w_n43_n43.n97 585
R686 w_n43_n43.n99 w_n43_n43.n98 585
R687 w_n43_n43.n56 w_n43_n43.n55 585
R688 w_n43_n43.n100 w_n43_n43.n56 585
R689 w_n43_n43.n103 w_n43_n43.n102 585
R690 w_n43_n43.n102 w_n43_n43.n101 585
R691 w_n43_n43.n51 w_n43_n43.n50 585
R692 w_n43_n43.n50 w_n43_n43.n49 585
R693 w_n43_n43.n110 w_n43_n43.n109 585
R694 w_n43_n43.n111 w_n43_n43.n110 585
R695 w_n43_n43.n48 w_n43_n43.n47 585
R696 w_n43_n43.n112 w_n43_n43.n48 585
R697 w_n43_n43.n115 w_n43_n43.n114 585
R698 w_n43_n43.n114 w_n43_n43.n113 585
R699 w_n43_n43.n43 w_n43_n43.n42 585
R700 w_n43_n43.n42 w_n43_n43.n41 585
R701 w_n43_n43.n122 w_n43_n43.n121 585
R702 w_n43_n43.n123 w_n43_n43.n122 585
R703 w_n43_n43.n40 w_n43_n43.n39 585
R704 w_n43_n43.n124 w_n43_n43.n40 585
R705 w_n43_n43.n127 w_n43_n43.n126 585
R706 w_n43_n43.n126 w_n43_n43.n125 585
R707 w_n43_n43.n35 w_n43_n43.n34 585
R708 w_n43_n43.n34 w_n43_n43.n33 585
R709 w_n43_n43.n134 w_n43_n43.n133 585
R710 w_n43_n43.n135 w_n43_n43.n134 585
R711 w_n43_n43.n32 w_n43_n43.n31 585
R712 w_n43_n43.n136 w_n43_n43.n32 585
R713 w_n43_n43.n139 w_n43_n43.n138 585
R714 w_n43_n43.n138 w_n43_n43.n137 585
R715 w_n43_n43.n27 w_n43_n43.n26 585
R716 w_n43_n43.n26 w_n43_n43.n25 585
R717 w_n43_n43.n146 w_n43_n43.n145 585
R718 w_n43_n43.n147 w_n43_n43.n146 585
R719 w_n43_n43.n24 w_n43_n43.n23 585
R720 w_n43_n43.n148 w_n43_n43.n24 585
R721 w_n43_n43.n151 w_n43_n43.n150 585
R722 w_n43_n43.n150 w_n43_n43.n149 585
R723 w_n43_n43.n19 w_n43_n43.n18 585
R724 w_n43_n43.n18 w_n43_n43.n17 585
R725 w_n43_n43.n158 w_n43_n43.n157 585
R726 w_n43_n43.n159 w_n43_n43.n158 585
R727 w_n43_n43.n16 w_n43_n43.n15 585
R728 w_n43_n43.n160 w_n43_n43.n16 585
R729 w_n43_n43.n163 w_n43_n43.n162 585
R730 w_n43_n43.n162 w_n43_n43.n161 585
R731 w_n43_n43.n11 w_n43_n43.n10 585
R732 w_n43_n43.n10 w_n43_n43.n9 585
R733 w_n43_n43.n171 w_n43_n43.n170 585
R734 w_n43_n43.n172 w_n43_n43.n171 585
R735 w_n43_n43.n7 w_n43_n43.n6 585
R736 w_n43_n43.n173 w_n43_n43.n7 585
R737 w_n43_n43.n180 w_n43_n43.n179 585
R738 w_n43_n43.n179 w_n43_n43.n178 585
R739 w_n43_n43.n8 w_n43_n43.n3 585
R740 w_n43_n43.n177 w_n43_n43.n8 585
R741 w_n43_n43.n176 w_n43_n43.n175 585
R742 w_n43_n43.n2 w_n43_n43.n0 585
R743 w_n43_n43.n185 w_n43_n43.n184 585
R744 w_n43_n43.n182 w_n43_n43.n1 585
R745 w_n43_n43.n181 w_n43_n43.n180 585
R746 w_n43_n43.n181 w_n43_n43.n5 585
R747 w_n43_n43.n6 w_n43_n43.n4 585
R748 w_n43_n43.n167 w_n43_n43.n4 585
R749 w_n43_n43.n170 w_n43_n43.n169 585
R750 w_n43_n43.n169 w_n43_n43.n168 585
R751 w_n43_n43.n12 w_n43_n43.n11 585
R752 w_n43_n43.n166 w_n43_n43.n12 585
R753 w_n43_n43.n164 w_n43_n43.n163 585
R754 w_n43_n43.n165 w_n43_n43.n164 585
R755 w_n43_n43.n15 w_n43_n43.n14 585
R756 w_n43_n43.n14 w_n43_n43.n13 585
R757 w_n43_n43.n157 w_n43_n43.n156 585
R758 w_n43_n43.n156 w_n43_n43.n155 585
R759 w_n43_n43.n20 w_n43_n43.n19 585
R760 w_n43_n43.n154 w_n43_n43.n20 585
R761 w_n43_n43.n152 w_n43_n43.n151 585
R762 w_n43_n43.n153 w_n43_n43.n152 585
R763 w_n43_n43.n23 w_n43_n43.n22 585
R764 w_n43_n43.n22 w_n43_n43.n21 585
R765 w_n43_n43.n145 w_n43_n43.n144 585
R766 w_n43_n43.n144 w_n43_n43.n143 585
R767 w_n43_n43.n28 w_n43_n43.n27 585
R768 w_n43_n43.n142 w_n43_n43.n28 585
R769 w_n43_n43.n140 w_n43_n43.n139 585
R770 w_n43_n43.n141 w_n43_n43.n140 585
R771 w_n43_n43.n31 w_n43_n43.n30 585
R772 w_n43_n43.n30 w_n43_n43.n29 585
R773 w_n43_n43.n133 w_n43_n43.n132 585
R774 w_n43_n43.n132 w_n43_n43.n131 585
R775 w_n43_n43.n36 w_n43_n43.n35 585
R776 w_n43_n43.n130 w_n43_n43.n36 585
R777 w_n43_n43.n128 w_n43_n43.n127 585
R778 w_n43_n43.n129 w_n43_n43.n128 585
R779 w_n43_n43.n39 w_n43_n43.n38 585
R780 w_n43_n43.n38 w_n43_n43.n37 585
R781 w_n43_n43.n121 w_n43_n43.n120 585
R782 w_n43_n43.n120 w_n43_n43.n119 585
R783 w_n43_n43.n44 w_n43_n43.n43 585
R784 w_n43_n43.n118 w_n43_n43.n44 585
R785 w_n43_n43.n116 w_n43_n43.n115 585
R786 w_n43_n43.n117 w_n43_n43.n116 585
R787 w_n43_n43.n47 w_n43_n43.n46 585
R788 w_n43_n43.n46 w_n43_n43.n45 585
R789 w_n43_n43.n109 w_n43_n43.n108 585
R790 w_n43_n43.n108 w_n43_n43.n107 585
R791 w_n43_n43.n52 w_n43_n43.n51 585
R792 w_n43_n43.n106 w_n43_n43.n52 585
R793 w_n43_n43.n104 w_n43_n43.n103 585
R794 w_n43_n43.n105 w_n43_n43.n104 585
R795 w_n43_n43.n55 w_n43_n43.n54 585
R796 w_n43_n43.n54 w_n43_n43.n53 585
R797 w_n43_n43.n97 w_n43_n43.n96 585
R798 w_n43_n43.n96 w_n43_n43.n95 585
R799 w_n43_n43.n60 w_n43_n43.n59 585
R800 w_n43_n43.n94 w_n43_n43.n60 585
R801 w_n43_n43.n92 w_n43_n43.n91 585
R802 w_n43_n43.n93 w_n43_n43.n92 585
R803 w_n43_n43.n63 w_n43_n43.n62 585
R804 w_n43_n43.n62 w_n43_n43.n61 585
R805 w_n43_n43.n85 w_n43_n43.n84 585
R806 w_n43_n43.n84 w_n43_n43.n83 585
R807 w_n43_n43.n68 w_n43_n43.n67 585
R808 w_n43_n43.n82 w_n43_n43.n68 585
R809 w_n43_n43.n180 w_n43_n43.n6 523.077
R810 w_n43_n43.n170 w_n43_n43.n6 523.077
R811 w_n43_n43.n170 w_n43_n43.n11 523.077
R812 w_n43_n43.n163 w_n43_n43.n11 523.077
R813 w_n43_n43.n163 w_n43_n43.n15 523.077
R814 w_n43_n43.n157 w_n43_n43.n15 523.077
R815 w_n43_n43.n157 w_n43_n43.n19 523.077
R816 w_n43_n43.n151 w_n43_n43.n19 523.077
R817 w_n43_n43.n151 w_n43_n43.n23 523.077
R818 w_n43_n43.n145 w_n43_n43.n23 523.077
R819 w_n43_n43.n145 w_n43_n43.n27 523.077
R820 w_n43_n43.n139 w_n43_n43.n27 523.077
R821 w_n43_n43.n139 w_n43_n43.n31 523.077
R822 w_n43_n43.n133 w_n43_n43.n31 523.077
R823 w_n43_n43.n133 w_n43_n43.n35 523.077
R824 w_n43_n43.n127 w_n43_n43.n35 523.077
R825 w_n43_n43.n127 w_n43_n43.n39 523.077
R826 w_n43_n43.n121 w_n43_n43.n39 523.077
R827 w_n43_n43.n121 w_n43_n43.n43 523.077
R828 w_n43_n43.n115 w_n43_n43.n43 523.077
R829 w_n43_n43.n115 w_n43_n43.n47 523.077
R830 w_n43_n43.n109 w_n43_n43.n47 523.077
R831 w_n43_n43.n109 w_n43_n43.n51 523.077
R832 w_n43_n43.n103 w_n43_n43.n51 523.077
R833 w_n43_n43.n103 w_n43_n43.n55 523.077
R834 w_n43_n43.n97 w_n43_n43.n55 523.077
R835 w_n43_n43.n97 w_n43_n43.n59 523.077
R836 w_n43_n43.n91 w_n43_n43.n59 523.077
R837 w_n43_n43.n91 w_n43_n43.n63 523.077
R838 w_n43_n43.n85 w_n43_n43.n63 523.077
R839 w_n43_n43.n85 w_n43_n43.n67 523.077
R840 w_n43_n43.n181 w_n43_n43.n4 394
R841 w_n43_n43.n169 w_n43_n43.n4 394
R842 w_n43_n43.n169 w_n43_n43.n12 394
R843 w_n43_n43.n164 w_n43_n43.n12 394
R844 w_n43_n43.n164 w_n43_n43.n14 394
R845 w_n43_n43.n156 w_n43_n43.n14 394
R846 w_n43_n43.n156 w_n43_n43.n20 394
R847 w_n43_n43.n152 w_n43_n43.n20 394
R848 w_n43_n43.n152 w_n43_n43.n22 394
R849 w_n43_n43.n144 w_n43_n43.n22 394
R850 w_n43_n43.n144 w_n43_n43.n28 394
R851 w_n43_n43.n140 w_n43_n43.n28 394
R852 w_n43_n43.n140 w_n43_n43.n30 394
R853 w_n43_n43.n132 w_n43_n43.n30 394
R854 w_n43_n43.n132 w_n43_n43.n36 394
R855 w_n43_n43.n128 w_n43_n43.n36 394
R856 w_n43_n43.n128 w_n43_n43.n38 394
R857 w_n43_n43.n120 w_n43_n43.n38 394
R858 w_n43_n43.n120 w_n43_n43.n44 394
R859 w_n43_n43.n116 w_n43_n43.n44 394
R860 w_n43_n43.n116 w_n43_n43.n46 394
R861 w_n43_n43.n108 w_n43_n43.n46 394
R862 w_n43_n43.n108 w_n43_n43.n52 394
R863 w_n43_n43.n104 w_n43_n43.n52 394
R864 w_n43_n43.n104 w_n43_n43.n54 394
R865 w_n43_n43.n96 w_n43_n43.n54 394
R866 w_n43_n43.n96 w_n43_n43.n60 394
R867 w_n43_n43.n92 w_n43_n43.n60 394
R868 w_n43_n43.n92 w_n43_n43.n62 394
R869 w_n43_n43.n84 w_n43_n43.n62 394
R870 w_n43_n43.n84 w_n43_n43.n68 394
R871 w_n43_n43.n184 w_n43_n43.n2 394
R872 w_n43_n43.n175 w_n43_n43.n8 394
R873 w_n43_n43.n179 w_n43_n43.n7 394
R874 w_n43_n43.n171 w_n43_n43.n7 394
R875 w_n43_n43.n171 w_n43_n43.n10 394
R876 w_n43_n43.n162 w_n43_n43.n10 394
R877 w_n43_n43.n162 w_n43_n43.n16 394
R878 w_n43_n43.n158 w_n43_n43.n16 394
R879 w_n43_n43.n158 w_n43_n43.n18 394
R880 w_n43_n43.n150 w_n43_n43.n18 394
R881 w_n43_n43.n150 w_n43_n43.n24 394
R882 w_n43_n43.n146 w_n43_n43.n24 394
R883 w_n43_n43.n146 w_n43_n43.n26 394
R884 w_n43_n43.n138 w_n43_n43.n26 394
R885 w_n43_n43.n138 w_n43_n43.n32 394
R886 w_n43_n43.n134 w_n43_n43.n32 394
R887 w_n43_n43.n134 w_n43_n43.n34 394
R888 w_n43_n43.n126 w_n43_n43.n34 394
R889 w_n43_n43.n126 w_n43_n43.n40 394
R890 w_n43_n43.n122 w_n43_n43.n40 394
R891 w_n43_n43.n122 w_n43_n43.n42 394
R892 w_n43_n43.n114 w_n43_n43.n42 394
R893 w_n43_n43.n114 w_n43_n43.n48 394
R894 w_n43_n43.n110 w_n43_n43.n48 394
R895 w_n43_n43.n110 w_n43_n43.n50 394
R896 w_n43_n43.n102 w_n43_n43.n50 394
R897 w_n43_n43.n102 w_n43_n43.n56 394
R898 w_n43_n43.n98 w_n43_n43.n56 394
R899 w_n43_n43.n98 w_n43_n43.n58 394
R900 w_n43_n43.n90 w_n43_n43.n58 394
R901 w_n43_n43.n90 w_n43_n43.n64 394
R902 w_n43_n43.n86 w_n43_n43.n64 394
R903 w_n43_n43.n86 w_n43_n43.n66 394
R904 w_n43_n43.n80 w_n43_n43.n70 394
R905 w_n43_n43.n77 w_n43_n43.n72 394
R906 w_n43_n43.n3 B 330.769
R907 w_n43_n43.n79 w_n43_n43.n78 218.815
R908 w_n43_n43.n79 w_n43_n43.n71 218.815
R909 w_n43_n43.n174 w_n43_n43.n3 218.815
R910 w_n43_n43.n183 w_n43_n43.n3 218.815
R911 w_n43_n43.n78 w_n43_n43.n70 147.374
R912 w_n43_n43.n72 w_n43_n43.n71 147.374
R913 w_n43_n43.n175 w_n43_n43.n174 147.374
R914 w_n43_n43.n184 w_n43_n43.n183 147.374
R915 w_n43_n43.n183 w_n43_n43.n182 147.374
R916 w_n43_n43.n174 w_n43_n43.n2 147.374
R917 w_n43_n43.n78 w_n43_n43.n77 147.374
R918 w_n43_n43.n73 w_n43_n43.n71 147.374
R919 w_n43_n43.n5 w_n43_n43.n1 72.6593
R920 w_n43_n43.n178 w_n43_n43.n177 72.6593
R921 w_n43_n43.n82 w_n43_n43.n81 72.6593
R922 w_n43_n43.n74 w_n43_n43.n65 72.6593
R923 w_n43_n43.n167 w_n43_n43.n5 25.6005
R924 w_n43_n43.n168 w_n43_n43.n167 25.6005
R925 w_n43_n43.n168 w_n43_n43.n166 25.6005
R926 w_n43_n43.n166 w_n43_n43.n165 25.6005
R927 w_n43_n43.n165 w_n43_n43.n13 25.6005
R928 w_n43_n43.n155 w_n43_n43.n13 25.6005
R929 w_n43_n43.n155 w_n43_n43.n154 25.6005
R930 w_n43_n43.n154 w_n43_n43.n153 25.6005
R931 w_n43_n43.n153 w_n43_n43.n21 25.6005
R932 w_n43_n43.n143 w_n43_n43.n21 25.6005
R933 w_n43_n43.n143 w_n43_n43.n142 25.6005
R934 w_n43_n43.n142 w_n43_n43.n141 25.6005
R935 w_n43_n43.n141 w_n43_n43.n29 25.6005
R936 w_n43_n43.n131 w_n43_n43.n29 25.6005
R937 w_n43_n43.n131 w_n43_n43.n130 25.6005
R938 w_n43_n43.n130 w_n43_n43.n129 25.6005
R939 w_n43_n43.n129 w_n43_n43.n37 25.6005
R940 w_n43_n43.n119 w_n43_n43.n37 25.6005
R941 w_n43_n43.n119 w_n43_n43.n118 25.6005
R942 w_n43_n43.n118 w_n43_n43.n117 25.6005
R943 w_n43_n43.n117 w_n43_n43.n45 25.6005
R944 w_n43_n43.n107 w_n43_n43.n45 25.6005
R945 w_n43_n43.n107 w_n43_n43.n106 25.6005
R946 w_n43_n43.n106 w_n43_n43.n105 25.6005
R947 w_n43_n43.n105 w_n43_n43.n53 25.6005
R948 w_n43_n43.n95 w_n43_n43.n53 25.6005
R949 w_n43_n43.n95 w_n43_n43.n94 25.6005
R950 w_n43_n43.n94 w_n43_n43.n93 25.6005
R951 w_n43_n43.n93 w_n43_n43.n61 25.6005
R952 w_n43_n43.n83 w_n43_n43.n61 25.6005
R953 w_n43_n43.n83 w_n43_n43.n82 25.6005
R954 w_n43_n43.n185 w_n43_n43.n1 25.6005
R955 w_n43_n43.n176 w_n43_n43.n0 25.6005
R956 w_n43_n43.n177 w_n43_n43.n176 25.6005
R957 w_n43_n43.n178 w_n43_n43.n173 25.6005
R958 w_n43_n43.n173 w_n43_n43.n172 25.6005
R959 w_n43_n43.n172 w_n43_n43.n9 25.6005
R960 w_n43_n43.n161 w_n43_n43.n9 25.6005
R961 w_n43_n43.n161 w_n43_n43.n160 25.6005
R962 w_n43_n43.n160 w_n43_n43.n159 25.6005
R963 w_n43_n43.n159 w_n43_n43.n17 25.6005
R964 w_n43_n43.n149 w_n43_n43.n17 25.6005
R965 w_n43_n43.n149 w_n43_n43.n148 25.6005
R966 w_n43_n43.n148 w_n43_n43.n147 25.6005
R967 w_n43_n43.n147 w_n43_n43.n25 25.6005
R968 w_n43_n43.n137 w_n43_n43.n25 25.6005
R969 w_n43_n43.n137 w_n43_n43.n136 25.6005
R970 w_n43_n43.n136 w_n43_n43.n135 25.6005
R971 w_n43_n43.n135 w_n43_n43.n33 25.6005
R972 w_n43_n43.n125 w_n43_n43.n33 25.6005
R973 w_n43_n43.n125 w_n43_n43.n124 25.6005
R974 w_n43_n43.n124 w_n43_n43.n123 25.6005
R975 w_n43_n43.n123 w_n43_n43.n41 25.6005
R976 w_n43_n43.n113 w_n43_n43.n41 25.6005
R977 w_n43_n43.n113 w_n43_n43.n112 25.6005
R978 w_n43_n43.n112 w_n43_n43.n111 25.6005
R979 w_n43_n43.n111 w_n43_n43.n49 25.6005
R980 w_n43_n43.n101 w_n43_n43.n49 25.6005
R981 w_n43_n43.n101 w_n43_n43.n100 25.6005
R982 w_n43_n43.n100 w_n43_n43.n99 25.6005
R983 w_n43_n43.n99 w_n43_n43.n57 25.6005
R984 w_n43_n43.n89 w_n43_n43.n57 25.6005
R985 w_n43_n43.n89 w_n43_n43.n88 25.6005
R986 w_n43_n43.n88 w_n43_n43.n87 25.6005
R987 w_n43_n43.n87 w_n43_n43.n65 25.6005
R988 w_n43_n43.n81 w_n43_n43.n69 25.6005
R989 w_n43_n43.n76 w_n43_n43.n69 25.6005
R990 w_n43_n43.n76 w_n43_n43.n75 25.6005
R991 w_n43_n43.n75 w_n43_n43.n74 25.6005
R992 B w_n43_n43.n185 19.2005
R993 B w_n43_n43.n0 6.4005
C3 S B 0.90582f
C4 D B 0.90582f
C5 G B 0.58902f
