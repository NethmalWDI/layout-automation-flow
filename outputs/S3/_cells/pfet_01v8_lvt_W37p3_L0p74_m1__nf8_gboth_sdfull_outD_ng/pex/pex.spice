* NGSPICE file created from pfet_01v8_lvt_W37p3_L0p74_m1__nf8_gboth_sdfull_outD_ng.ext - technology: sky130A

.subckt pfet_01v8_lvt_W37p3_L0p74_m1__nf8_gboth_sdfull_outD_ng S D G B
X0 D G S B sky130_fd_pr__pfet_01v8_lvt ad=0.6757 pd=4.95 as=0.6757 ps=4.95 w=4.66 l=0.74
X1 D G S B sky130_fd_pr__pfet_01v8_lvt ad=0.6757 pd=4.95 as=0.6757 ps=4.95 w=4.66 l=0.74
X2 S G D B sky130_fd_pr__pfet_01v8_lvt ad=0.6757 pd=4.95 as=0.6757 ps=4.95 w=4.66 l=0.74
X3 D G S B sky130_fd_pr__pfet_01v8_lvt ad=0.6757 pd=4.95 as=0.6757 ps=4.95 w=4.66 l=0.74
X4 S G D B sky130_fd_pr__pfet_01v8_lvt ad=0.6757 pd=4.95 as=1.3514 ps=9.9 w=4.66 l=0.74
X5 D G S B sky130_fd_pr__pfet_01v8_lvt ad=1.3514 pd=9.9 as=0.6757 ps=4.95 w=4.66 l=0.74
X6 S G D B sky130_fd_pr__pfet_01v8_lvt ad=0.6757 pd=4.95 as=0.6757 ps=4.95 w=4.66 l=0.74
X7 S G D B sky130_fd_pr__pfet_01v8_lvt ad=0.6757 pd=4.95 as=0.6757 ps=4.95 w=4.66 l=0.74
C0 B D 0.46826f
C1 G D 2.35851f
C2 B S 0.39924f
C3 G S 2.36857f
C4 D S 1.91141f
C5 G B 1.24138f
C6 S VSUBS 0.26105f
C7 D VSUBS 0.93636f
C8 G VSUBS 2.01391f
C9 B VSUBS 6.03809f
.ends
