* NGSPICE file created from pfet_01v8_lvt_W37p3_L0p74_m1__nf8_gboth_sdfull_outD_ng.ext - technology: sky130A

.subckt sky130_fd_pr__pfet_01v8_lvt_EQA6WV G a_795_n466# w_n889_n566# D6 D4 D2 D0
+ S7 S5 S3 S1
X0 D4 G S3 w_n889_n566# sky130_fd_pr__pfet_01v8_lvt ad=0.6757 pd=4.95 as=0.6757 ps=4.95 w=4.66 l=0.74
X1 D2 G S1 w_n889_n566# sky130_fd_pr__pfet_01v8_lvt ad=0.6757 pd=4.95 as=0.6757 ps=4.95 w=4.66 l=0.74
X2 S3 G D2 w_n889_n566# sky130_fd_pr__pfet_01v8_lvt ad=0.6757 pd=4.95 as=0.6757 ps=4.95 w=4.66 l=0.74
X3 D6 G S5 w_n889_n566# sky130_fd_pr__pfet_01v8_lvt ad=0.6757 pd=4.95 as=0.6757 ps=4.95 w=4.66 l=0.74
X4 S1 G D0 w_n889_n566# sky130_fd_pr__pfet_01v8_lvt ad=0.6757 pd=4.95 as=1.3514 ps=9.9 w=4.66 l=0.74
X5 a_795_n466# G S7 w_n889_n566# sky130_fd_pr__pfet_01v8_lvt ad=1.3514 pd=9.9 as=0.6757 ps=4.95 w=4.66 l=0.74
X6 S7 G D6 w_n889_n566# sky130_fd_pr__pfet_01v8_lvt ad=0.6757 pd=4.95 as=0.6757 ps=4.95 w=4.66 l=0.74
X7 S5 G D4 w_n889_n566# sky130_fd_pr__pfet_01v8_lvt ad=0.6757 pd=4.95 as=0.6757 ps=4.95 w=4.66 l=0.74
.ends

.subckt pfet_01v8_lvt_W37p3_L0p74_m1__nf8_gboth_sdfull_outD_ng S D G B
Xpfet_01v8_lvt_W37p3_L0p74_m1__nf8_gboth_sdfull_outD_ng_pc G D B D D D D S S S S sky130_fd_pr__pfet_01v8_lvt_EQA6WV
.ends
