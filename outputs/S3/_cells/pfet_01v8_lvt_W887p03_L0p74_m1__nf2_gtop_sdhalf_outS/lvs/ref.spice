.subckt pfet_01v8_lvt_W887p03_L0p74_m1__nf2_gtop_sdhalf_outS D G S B
Xpfet_01v8_lvt_W887p03_L0p74_m1__nf2_gtop_sdhalf_outS D G S B sky130_fd_pr__pfet_01v8_lvt L=0.74 W=887.03 nf=2
.ends
