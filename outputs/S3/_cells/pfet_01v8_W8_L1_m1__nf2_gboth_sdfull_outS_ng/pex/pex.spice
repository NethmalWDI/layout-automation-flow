* NGSPICE file created from pfet_01v8_W8_L1_m1__nf2_gboth_sdfull_outS_ng.ext - technology: sky130A

.subckt pfet_01v8_W8_L1_m1__nf2_gboth_sdfull_outS_ng S D G B
X0 D G S B sky130_fd_pr__pfet_01v8 ad=0.58 pd=4.29 as=1.16 ps=8.58 w=4 l=1
X1 S G D B sky130_fd_pr__pfet_01v8 ad=1.16 pd=8.58 as=0.58 ps=4.29 w=4 l=1
C0 G S 0.62945f
C1 D B 0.10219f
C2 D S 0.40109f
C3 D G 0.62694f
C4 S B 0.16075f
C5 G B 0.38205f
C6 D VSUBS 0.10666f
C7 S VSUBS 0.687f
C8 G VSUBS 0.72345f
C9 B VSUBS 1.938f
.ends
