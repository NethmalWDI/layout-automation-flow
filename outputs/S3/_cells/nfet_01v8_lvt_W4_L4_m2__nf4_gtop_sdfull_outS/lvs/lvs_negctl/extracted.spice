* NGSPICE file created from nfet_01v8_lvt_W4_L4_m2__nf4_gtop_sdfull_outS.ext - technology: sky130A

.subckt sky130_fd_pr__nfet_01v8_lvt_KW35PD G B D2 D0 S3 a_1687_n131# S1
X0 S3 G D2 B sky130_fd_pr__nfet_01v8_lvt ad=0.145 pd=1.29 as=0.145 ps=1.29 w=1 l=4
X1 a_1687_n131# G S3 B sky130_fd_pr__nfet_01v8_lvt ad=0.29 pd=2.58 as=0.145 ps=1.29 w=1 l=4
X2 S1 G D0 B sky130_fd_pr__nfet_01v8_lvt ad=0.145 pd=1.29 as=0.29 ps=2.58 w=1 l=4
X3 D2 G S1 B sky130_fd_pr__nfet_01v8_lvt ad=0.145 pd=1.29 as=0.145 ps=1.29 w=1 l=4
.ends

.subckt nfet_01v8_lvt_W4_L4_m2__nf4_gtop_sdfull_outS S D G B
Xnfet_01v8_lvt_W4_L4_m2__nf4_gtop_sdfull_outS_pc G B S S D S D sky130_fd_pr__nfet_01v8_lvt_KW35PD
.ends
