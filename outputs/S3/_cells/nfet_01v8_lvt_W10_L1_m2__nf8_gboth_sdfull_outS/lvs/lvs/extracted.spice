* NGSPICE file created from nfet_01v8_lvt_W10_L1_m2__nf8_gboth_sdfull_outS.ext - technology: sky130A

.subckt sky130_fd_pr__nfet_01v8_lvt_QXL9VH G B a_1003_n125# D6 D4 D2 D0 S7 S5 S3 S1
X0 D2 G S1 B sky130_fd_pr__nfet_01v8_lvt ad=0.18125 pd=1.54 as=0.18125 ps=1.54 w=1.25 l=1
X1 S3 G D2 B sky130_fd_pr__nfet_01v8_lvt ad=0.18125 pd=1.54 as=0.18125 ps=1.54 w=1.25 l=1
X2 S1 G D0 B sky130_fd_pr__nfet_01v8_lvt ad=0.18125 pd=1.54 as=0.3625 ps=3.08 w=1.25 l=1
X3 a_1003_n125# G S7 B sky130_fd_pr__nfet_01v8_lvt ad=0.3625 pd=3.08 as=0.18125 ps=1.54 w=1.25 l=1
X4 S7 G D6 B sky130_fd_pr__nfet_01v8_lvt ad=0.18125 pd=1.54 as=0.18125 ps=1.54 w=1.25 l=1
X5 D6 G S5 B sky130_fd_pr__nfet_01v8_lvt ad=0.18125 pd=1.54 as=0.18125 ps=1.54 w=1.25 l=1
X6 S5 G D4 B sky130_fd_pr__nfet_01v8_lvt ad=0.18125 pd=1.54 as=0.18125 ps=1.54 w=1.25 l=1
X7 D4 G S3 B sky130_fd_pr__nfet_01v8_lvt ad=0.18125 pd=1.54 as=0.18125 ps=1.54 w=1.25 l=1
.ends

.subckt nfet_01v8_lvt_W10_L1_m2__nf8_gboth_sdfull_outS S D G B
Xnfet_01v8_lvt_W10_L1_m2__nf8_gboth_sdfull_outS_pc G B S S S S S D D D D sky130_fd_pr__nfet_01v8_lvt_QXL9VH
.ends
