* NGSPICE file created from nfet_01v8_lvt_W10_L1_m2__nf8_gboth_sdfull_outS.ext - technology: sky130A

.subckt nfet_01v8_lvt_W10_L1_m2__nf8_gboth_sdfull_outS S D G B
X0 S G D B sky130_fd_pr__nfet_01v8_lvt ad=0.18125 pd=1.54 as=0.18125 ps=1.54 w=1.25 l=1
X1 D G S B sky130_fd_pr__nfet_01v8_lvt ad=0.18125 pd=1.54 as=0.18125 ps=1.54 w=1.25 l=1
X2 D G S B sky130_fd_pr__nfet_01v8_lvt ad=0.18125 pd=1.54 as=0.3625 ps=3.08 w=1.25 l=1
X3 S G D B sky130_fd_pr__nfet_01v8_lvt ad=0.3625 pd=3.08 as=0.18125 ps=1.54 w=1.25 l=1
X4 D G S B sky130_fd_pr__nfet_01v8_lvt ad=0.18125 pd=1.54 as=0.18125 ps=1.54 w=1.25 l=1
X5 S G D B sky130_fd_pr__nfet_01v8_lvt ad=0.18125 pd=1.54 as=0.18125 ps=1.54 w=1.25 l=1
X6 D G S B sky130_fd_pr__nfet_01v8_lvt ad=0.18125 pd=1.54 as=0.18125 ps=1.54 w=1.25 l=1
X7 S G D B sky130_fd_pr__nfet_01v8_lvt ad=0.18125 pd=1.54 as=0.18125 ps=1.54 w=1.25 l=1
C0 S G 1.22515f
C1 D G 1.21389f
C2 D S 1.06135f
C3 D B 0.39244f
C4 S B 0.61832f
C5 G B 3.8235f
.ends
