* NGSPICE file created from pfet_01v8_lvt_W887p03_L0p74_m1__nf1_gboth_sdfull.ext - technology: sky130A

.subckt pfet_01v8_lvt_W887p03_L0p74_m1__nf1_gboth_sdfull D S G B
X0 S G D B sky130_fd_pr__pfet_01v8_lvt ad=257.23871 pd=1.77464k as=257.23871 ps=1.77464k w=887.03003 l=0.74
C0 G D 40.7675f
C1 S B 51.2645f
C2 B D 51.2645f
C3 S D 33.0325f
C4 B G 0.35539f
C5 S G 40.7675f
C6 S VSUBS 23.6424f
C7 D VSUBS 23.6424f
C8 G VSUBS 0.14787f
C9 B VSUBS 0.35262p
.ends
