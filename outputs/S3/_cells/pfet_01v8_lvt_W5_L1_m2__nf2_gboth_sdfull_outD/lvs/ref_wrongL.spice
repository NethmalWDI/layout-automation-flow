.subckt pfet_01v8_lvt_W5_L1_m2__nf2_gboth_sdfull_outD D G S B
Xpfet_01v8_lvt_W5_L1_m2__nf2_gboth_sdfull_outD D G S B sky130_fd_pr__pfet_01v8_lvt L=1.1 W=5 nf=2
.ends
