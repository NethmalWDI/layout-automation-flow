* NGSPICE file created from nfet_01v8_lvt_W10_L1_m2__nf4_gtop_sdhalf_outS_ng.ext - technology: sky130A

.subckt nfet_01v8_lvt_W10_L1_m2__nf4_gtop_sdhalf_outS_ng S D G B
X0 D G S B sky130_fd_pr__nfet_01v8_lvt ad=0.3625 pd=2.79 as=0.3625 ps=2.79 w=2.5 l=1
X1 S G D B sky130_fd_pr__nfet_01v8_lvt ad=0.3625 pd=2.79 as=0.3625 ps=2.79 w=2.5 l=1
X2 D G S B sky130_fd_pr__nfet_01v8_lvt ad=0.3625 pd=2.79 as=0.725 ps=5.58 w=2.5 l=1
X3 S G D B sky130_fd_pr__nfet_01v8_lvt ad=0.725 pd=5.58 as=0.3625 ps=2.79 w=2.5 l=1
C0 G S 0.46953f
C1 D S 0.55363f
C2 D G 0.43201f
C3 D B 0.21069f
C4 S B 0.43579f
C5 G B 1.38919f
.ends
