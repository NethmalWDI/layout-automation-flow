* NGSPICE file created from pfet_01v8_lvt_W887p03_L0p74_m1__nf8_gboth_sdfull_outS_ng.ext - technology: sky130A

.subckt pfet_01v8_lvt_W887p03_L0p74_m1__nf8_gboth_sdfull_outS_ng S D G B
X0 D G S B sky130_fd_pr__pfet_01v8_lvt ad=16.0776 pd=111.17 as=16.0776 ps=111.17 w=110.88 l=0.74
X1 S G D B sky130_fd_pr__pfet_01v8_lvt ad=32.1552 pd=222.34 as=16.0776 ps=111.17 w=110.88 l=0.74
X2 D G S B sky130_fd_pr__pfet_01v8_lvt ad=16.0776 pd=111.17 as=16.0776 ps=111.17 w=110.88 l=0.74
X3 S G D B sky130_fd_pr__pfet_01v8_lvt ad=16.0776 pd=111.17 as=16.0776 ps=111.17 w=110.88 l=0.74
X4 D G S B sky130_fd_pr__pfet_01v8_lvt ad=16.0776 pd=111.17 as=32.1552 ps=222.34 w=110.88 l=0.74
X5 D G S B sky130_fd_pr__pfet_01v8_lvt ad=16.0776 pd=111.17 as=16.0776 ps=111.17 w=110.88 l=0.74
X6 S G D B sky130_fd_pr__pfet_01v8_lvt ad=16.0776 pd=111.17 as=16.0776 ps=111.17 w=110.88 l=0.74
X7 S G D B sky130_fd_pr__pfet_01v8_lvt ad=16.0776 pd=111.17 as=16.0776 ps=111.17 w=110.88 l=0.74
C0 D B 9.61903f
C1 S G 41.45795f
C2 S B 11.09601f
C3 S D 33.5115f
C4 G B 1.25407f
C5 G D 41.4479f
C6 S VSUBS 15.89824f
C7 G VSUBS 2.17068f
C8 B VSUBS 0.10359p
.ends
