* NGSPICE file created from nfet_01v8_lvt_W5_L20_m2__nf4_gboth_sdfull_outS.ext - technology: sky130A

.subckt sky130_fd_pr__nfet_01v8_lvt_EMGEN3 a_8087_n125# G B D2 D0 S3 S1
X0 S1 G D0 B sky130_fd_pr__nfet_01v8_lvt ad=0.18125 pd=1.54 as=0.3625 ps=3.08 w=1.25 l=20
X1 a_8087_n125# G S3 B sky130_fd_pr__nfet_01v8_lvt ad=0.3625 pd=3.08 as=0.18125 ps=1.54 w=1.25 l=20
X2 D2 G S1 B sky130_fd_pr__nfet_01v8_lvt ad=0.18125 pd=1.54 as=0.18125 ps=1.54 w=1.25 l=20
X3 S3 G D2 B sky130_fd_pr__nfet_01v8_lvt ad=0.18125 pd=1.54 as=0.18125 ps=1.54 w=1.25 l=20
.ends

.subckt nfet_01v8_lvt_W5_L20_m2__nf4_gboth_sdfull_outS S D G B
Xnfet_01v8_lvt_W5_L20_m2__nf4_gboth_sdfull_outS_pc S G B S S D D sky130_fd_pr__nfet_01v8_lvt_EMGEN3
.ends
