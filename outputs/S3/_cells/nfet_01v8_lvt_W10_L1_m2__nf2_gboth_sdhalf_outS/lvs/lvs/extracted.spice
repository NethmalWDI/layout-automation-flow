* NGSPICE file created from nfet_01v8_lvt_W10_L1_m2__nf2_gboth_sdhalf_outS.ext - technology: sky130A

.subckt sky130_fd_pr__nfet_01v8_lvt_W97P6K G B a_229_n500# D0 S1
X0 a_229_n500# G S1 B sky130_fd_pr__nfet_01v8_lvt ad=1.45 pd=10.58 as=0.725 ps=5.29 w=5 l=1
X1 S1 G D0 B sky130_fd_pr__nfet_01v8_lvt ad=0.725 pd=5.29 as=1.45 ps=10.58 w=5 l=1
.ends

.subckt nfet_01v8_lvt_W10_L1_m2__nf2_gboth_sdhalf_outS S D G B
Xnfet_01v8_lvt_W10_L1_m2__nf2_gboth_sdhalf_outS_pc G B S S D sky130_fd_pr__nfet_01v8_lvt_W97P6K
.ends
