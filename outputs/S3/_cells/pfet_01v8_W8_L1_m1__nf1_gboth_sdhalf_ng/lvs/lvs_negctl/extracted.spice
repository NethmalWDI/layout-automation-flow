* NGSPICE file created from pfet_01v8_W8_L1_m1__nf1_gboth_sdhalf_ng.ext - technology: sky130A

.subckt sky130_fd_pr__pfet_01v8_8RQ7R5 G D w_n194_n900# S
X0 S G D w_n194_n900# sky130_fd_pr__pfet_01v8 ad=2.32 pd=16.58 as=2.32 ps=16.58 w=8 l=1
.ends

.subckt pfet_01v8_W8_L1_m1__nf1_gboth_sdhalf_ng D S G B
Xpfet_01v8_W8_L1_m1__nf1_gboth_sdhalf_ng_pc G D B S sky130_fd_pr__pfet_01v8_8RQ7R5
.ends
