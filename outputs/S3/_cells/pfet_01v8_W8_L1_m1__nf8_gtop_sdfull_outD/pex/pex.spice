* NGSPICE file created from pfet_01v8_W8_L1_m1__nf8_gtop_sdfull_outD.ext - technology: sky130A

.subckt pfet_01v8_W8_L1_m1__nf8_gtop_sdfull_outD S D G B
X0 D G S B sky130_fd_pr__pfet_01v8 ad=0.145 pd=1.29 as=0.145 ps=1.29 w=1 l=1
X1 S G D B sky130_fd_pr__pfet_01v8 ad=0.145 pd=1.29 as=0.29 ps=2.58 w=1 l=1
X2 S G D B sky130_fd_pr__pfet_01v8 ad=0.145 pd=1.29 as=0.145 ps=1.29 w=1 l=1
X3 S G D B sky130_fd_pr__pfet_01v8 ad=0.145 pd=1.29 as=0.145 ps=1.29 w=1 l=1
X4 D G S B sky130_fd_pr__pfet_01v8 ad=0.29 pd=2.58 as=0.145 ps=1.29 w=1 l=1
X5 D G S B sky130_fd_pr__pfet_01v8 ad=0.145 pd=1.29 as=0.145 ps=1.29 w=1 l=1
X6 D G S B sky130_fd_pr__pfet_01v8 ad=0.145 pd=1.29 as=0.145 ps=1.29 w=1 l=1
X7 S G D B sky130_fd_pr__pfet_01v8 ad=0.145 pd=1.29 as=0.145 ps=1.29 w=1 l=1
C0 B D 0.42633f
C1 G D 0.6881f
C2 B S 0.29045f
C3 G S 0.92357f
C4 D S 1.12011f
C5 G B 2.28714f
C6 S VSUBS 0.31604f
C7 D VSUBS 0.41998f
C8 G VSUBS 0.86878f
C9 B VSUBS 4.95695f
.ends
