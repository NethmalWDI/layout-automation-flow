.subckt pfet_01v8_W1p4_L0p6_m6__nf1_gtop_sdhalf D G S B
Xpfet_01v8_W1p4_L0p6_m6__nf1_gtop_sdhalf D G S B sky130_fd_pr__pfet_01v8 L=0.6 W=1.4 nf=1
.ends
