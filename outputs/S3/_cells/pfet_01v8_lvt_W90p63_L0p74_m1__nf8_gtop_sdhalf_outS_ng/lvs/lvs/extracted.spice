* NGSPICE file created from pfet_01v8_lvt_W90p63_L0p74_m1__nf8_gtop_sdhalf_outS_ng.ext - technology: sky130A

.subckt sky130_fd_pr__pfet_01v8_lvt_6C4F3K G a_795_n1169# D6 D4 D2 w_n889_n1231# D0
+ S7 S5 S3 S1
X0 D2 G S1 w_n889_n1231# sky130_fd_pr__pfet_01v8_lvt ad=1.64285 pd=11.62 as=1.64285 ps=11.62 w=11.33 l=0.74
X1 S5 G D4 w_n889_n1231# sky130_fd_pr__pfet_01v8_lvt ad=1.64285 pd=11.62 as=1.64285 ps=11.62 w=11.33 l=0.74
X2 S7 G D6 w_n889_n1231# sky130_fd_pr__pfet_01v8_lvt ad=1.64285 pd=11.62 as=1.64285 ps=11.62 w=11.33 l=0.74
X3 a_795_n1169# G S7 w_n889_n1231# sky130_fd_pr__pfet_01v8_lvt ad=3.2857 pd=23.24 as=1.64285 ps=11.62 w=11.33 l=0.74
X4 D4 G S3 w_n889_n1231# sky130_fd_pr__pfet_01v8_lvt ad=1.64285 pd=11.62 as=1.64285 ps=11.62 w=11.33 l=0.74
X5 D6 G S5 w_n889_n1231# sky130_fd_pr__pfet_01v8_lvt ad=1.64285 pd=11.62 as=1.64285 ps=11.62 w=11.33 l=0.74
X6 S1 G D0 w_n889_n1231# sky130_fd_pr__pfet_01v8_lvt ad=1.64285 pd=11.62 as=3.2857 ps=23.24 w=11.33 l=0.74
X7 S3 G D2 w_n889_n1231# sky130_fd_pr__pfet_01v8_lvt ad=1.64285 pd=11.62 as=1.64285 ps=11.62 w=11.33 l=0.74
.ends

.subckt pfet_01v8_lvt_W90p63_L0p74_m1__nf8_gtop_sdhalf_outS_ng S D G B
Xpfet_01v8_lvt_W90p63_L0p74_m1__nf8_gtop_sdhalf_outS_ng_pc G S S S S B S D D D D sky130_fd_pr__pfet_01v8_lvt_6C4F3K
.ends
