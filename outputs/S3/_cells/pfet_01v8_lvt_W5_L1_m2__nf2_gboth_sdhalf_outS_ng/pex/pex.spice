* NGSPICE file created from pfet_01v8_lvt_W5_L1_m2__nf2_gboth_sdhalf_outS_ng.ext - technology: sky130A

.subckt pfet_01v8_lvt_W5_L1_m2__nf2_gboth_sdhalf_outS_ng S D G B
X0 D G S B sky130_fd_pr__pfet_01v8_lvt ad=0.3625 pd=2.79 as=0.725 ps=5.58 w=2.5 l=1
X1 S G D B sky130_fd_pr__pfet_01v8_lvt ad=0.725 pd=5.58 as=0.3625 ps=2.79 w=2.5 l=1
C0 G S 0.25476f
C1 D B 0.05409f
C2 D S 0.29305f
C3 D G 0.25418f
C4 S B 0.07724f
C5 G B 0.37777f
C6 D VSUBS 0.09984f
C7 S VSUBS 0.30696f
C8 G VSUBS 0.72095f
C9 B VSUBS 1.3566f
.ends
