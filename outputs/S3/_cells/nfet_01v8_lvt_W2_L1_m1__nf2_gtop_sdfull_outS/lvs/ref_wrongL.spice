.subckt nfet_01v8_lvt_W2_L1_m1__nf2_gtop_sdfull_outS D G S B
Xnfet_01v8_lvt_W2_L1_m1__nf2_gtop_sdfull_outS D G S B sky130_fd_pr__nfet_01v8_lvt L=1.1 W=2 nf=2
.ends
