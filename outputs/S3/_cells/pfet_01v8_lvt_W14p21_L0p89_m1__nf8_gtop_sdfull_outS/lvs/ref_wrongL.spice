.subckt pfet_01v8_lvt_W14p21_L0p89_m1__nf8_gtop_sdfull_outS D G S B
Xpfet_01v8_lvt_W14p21_L0p89_m1__nf8_gtop_sdfull_outS D G S B sky130_fd_pr__pfet_01v8_lvt L=0.99 W=14.21 nf=8
.ends
