* NGSPICE file created from nfet_01v8_lvt_W484p2_L0p24_m1__nf2_gtop_sdhalf_outD_ng.ext - technology: sky130A

.subckt nfet_01v8_lvt_W484p2_L0p24_m1__nf2_gtop_sdhalf_outD_ng S D G B
X0 D G S B sky130_fd_pr__nfet_01v8_lvt ad=70.209 pd=484.78 as=35.1045 ps=242.39 w=242.10001 l=0.24
X1 S G D B sky130_fd_pr__nfet_01v8_lvt ad=35.1045 pd=242.39 as=70.209 ps=484.78 w=242.10001 l=0.24
C0 D G 4.78719f
C1 S G 4.78719f
C2 S D 17.52275f
C3 S B 0.03516f
C4 D B 19.13123f
C5 G B 0.36834f
.ends
