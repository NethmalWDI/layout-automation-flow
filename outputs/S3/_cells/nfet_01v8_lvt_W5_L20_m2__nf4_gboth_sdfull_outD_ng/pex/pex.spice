* NGSPICE file created from nfet_01v8_lvt_W5_L20_m2__nf4_gboth_sdfull_outD_ng.ext - technology: sky130A

.subckt nfet_01v8_lvt_W5_L20_m2__nf4_gboth_sdfull_outD_ng S D G B
X0 S G D B sky130_fd_pr__nfet_01v8_lvt ad=0.18125 pd=1.54 as=0.3625 ps=3.08 w=1.25 l=20
X1 D G S B sky130_fd_pr__nfet_01v8_lvt ad=0.3625 pd=3.08 as=0.18125 ps=1.54 w=1.25 l=20
X2 D G S B sky130_fd_pr__nfet_01v8_lvt ad=0.18125 pd=1.54 as=0.18125 ps=1.54 w=1.25 l=20
X3 S G D B sky130_fd_pr__nfet_01v8_lvt ad=0.18125 pd=1.54 as=0.18125 ps=1.54 w=1.25 l=20
C0 D G 4.84689f
C1 S G 4.85252f
C2 S D 2.79052f
C3 S B 2.03144f
C4 D B 1.87999f
C5 G B 29.10955f
.ends
