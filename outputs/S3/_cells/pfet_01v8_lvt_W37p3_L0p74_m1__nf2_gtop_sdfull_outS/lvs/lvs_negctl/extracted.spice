* NGSPICE file created from pfet_01v8_lvt_W37p3_L0p74_m1__nf2_gtop_sdfull_outS.ext - technology: sky130A

.subckt sky130_fd_pr__pfet_01v8_lvt_R4MRQR G B a_177_n1901# D0 S1
X0 a_177_n1901# G S1 B sky130_fd_pr__pfet_01v8_lvt ad=5.4085 pd=37.88 as=2.70425 ps=18.94 w=18.65 l=0.74
X1 S1 G D0 B sky130_fd_pr__pfet_01v8_lvt ad=2.70425 pd=18.94 as=5.4085 ps=37.88 w=18.65 l=0.74
.ends

.subckt pfet_01v8_lvt_W37p3_L0p74_m1__nf2_gtop_sdfull_outS S D G B
Xpfet_01v8_lvt_W37p3_L0p74_m1__nf2_gtop_sdfull_outS_pc G B S S D sky130_fd_pr__pfet_01v8_lvt_R4MRQR
.ends
