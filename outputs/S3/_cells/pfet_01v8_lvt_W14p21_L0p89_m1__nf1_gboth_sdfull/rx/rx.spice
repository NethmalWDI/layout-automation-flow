* NGSPICE file created from pfet_01v8_lvt_W14p21_L0p89_m1__nf1_gboth_sdfull.ext - technology: sky130A

X0 S G D pfet_01v8_lvt_W14p21_L0p89_m1__nf1_gboth_sdfull_pc/B.t0 sky130_fd_pr__pfet_01v8_lvt ad=4.1209 pd=29 as=4.1209 ps=29 w=14.21 l=0.89
C0 D B 0.85665f
C1 G B 0.398f
C2 G D 0.72641f
C3 S B 0.85665f
C4 S D 0.4612f
C5 S G 0.72641f
R0 pfet_01v8_lvt_W14p21_L0p89_m1__nf1_gboth_sdfull_pc/B.n239 pfet_01v8_lvt_W14p21_L0p89_m1__nf1_gboth_sdfull_pc/B.n8 720
R1 pfet_01v8_lvt_W14p21_L0p89_m1__nf1_gboth_sdfull_pc/B.n242 pfet_01v8_lvt_W14p21_L0p89_m1__nf1_gboth_sdfull_pc/B.n241 720
R2 pfet_01v8_lvt_W14p21_L0p89_m1__nf1_gboth_sdfull_pc/B.n104 pfet_01v8_lvt_W14p21_L0p89_m1__nf1_gboth_sdfull_pc/B.n92 720
R3 pfet_01v8_lvt_W14p21_L0p89_m1__nf1_gboth_sdfull_pc/B.n100 pfet_01v8_lvt_W14p21_L0p89_m1__nf1_gboth_sdfull_pc/B.n90 720
R4 pfet_01v8_lvt_W14p21_L0p89_m1__nf1_gboth_sdfull_pc/B.n239 pfet_01v8_lvt_W14p21_L0p89_m1__nf1_gboth_sdfull_pc/B.n7 240
R5 pfet_01v8_lvt_W14p21_L0p89_m1__nf1_gboth_sdfull_pc/B.n231 pfet_01v8_lvt_W14p21_L0p89_m1__nf1_gboth_sdfull_pc/B.n7 240
R6 pfet_01v8_lvt_W14p21_L0p89_m1__nf1_gboth_sdfull_pc/B.n231 pfet_01v8_lvt_W14p21_L0p89_m1__nf1_gboth_sdfull_pc/B.n10 240
R7 pfet_01v8_lvt_W14p21_L0p89_m1__nf1_gboth_sdfull_pc/B.n222 pfet_01v8_lvt_W14p21_L0p89_m1__nf1_gboth_sdfull_pc/B.n10 240
R8 pfet_01v8_lvt_W14p21_L0p89_m1__nf1_gboth_sdfull_pc/B.n222 pfet_01v8_lvt_W14p21_L0p89_m1__nf1_gboth_sdfull_pc/B.n16 240
R9 pfet_01v8_lvt_W14p21_L0p89_m1__nf1_gboth_sdfull_pc/B.n218 pfet_01v8_lvt_W14p21_L0p89_m1__nf1_gboth_sdfull_pc/B.n16 240
R10 pfet_01v8_lvt_W14p21_L0p89_m1__nf1_gboth_sdfull_pc/B.n218 pfet_01v8_lvt_W14p21_L0p89_m1__nf1_gboth_sdfull_pc/B.n18 240
R11 pfet_01v8_lvt_W14p21_L0p89_m1__nf1_gboth_sdfull_pc/B.n210 pfet_01v8_lvt_W14p21_L0p89_m1__nf1_gboth_sdfull_pc/B.n18 240
R12 pfet_01v8_lvt_W14p21_L0p89_m1__nf1_gboth_sdfull_pc/B.n210 pfet_01v8_lvt_W14p21_L0p89_m1__nf1_gboth_sdfull_pc/B.n24 240
R13 pfet_01v8_lvt_W14p21_L0p89_m1__nf1_gboth_sdfull_pc/B.n206 pfet_01v8_lvt_W14p21_L0p89_m1__nf1_gboth_sdfull_pc/B.n24 240
R14 pfet_01v8_lvt_W14p21_L0p89_m1__nf1_gboth_sdfull_pc/B.n206 pfet_01v8_lvt_W14p21_L0p89_m1__nf1_gboth_sdfull_pc/B.n26 240
R15 pfet_01v8_lvt_W14p21_L0p89_m1__nf1_gboth_sdfull_pc/B.n198 pfet_01v8_lvt_W14p21_L0p89_m1__nf1_gboth_sdfull_pc/B.n26 240
R16 pfet_01v8_lvt_W14p21_L0p89_m1__nf1_gboth_sdfull_pc/B.n198 pfet_01v8_lvt_W14p21_L0p89_m1__nf1_gboth_sdfull_pc/B.n32 240
R17 pfet_01v8_lvt_W14p21_L0p89_m1__nf1_gboth_sdfull_pc/B.n194 pfet_01v8_lvt_W14p21_L0p89_m1__nf1_gboth_sdfull_pc/B.n32 240
R18 pfet_01v8_lvt_W14p21_L0p89_m1__nf1_gboth_sdfull_pc/B.n194 pfet_01v8_lvt_W14p21_L0p89_m1__nf1_gboth_sdfull_pc/B.n34 240
R19 pfet_01v8_lvt_W14p21_L0p89_m1__nf1_gboth_sdfull_pc/B.n186 pfet_01v8_lvt_W14p21_L0p89_m1__nf1_gboth_sdfull_pc/B.n34 240
R20 pfet_01v8_lvt_W14p21_L0p89_m1__nf1_gboth_sdfull_pc/B.n186 pfet_01v8_lvt_W14p21_L0p89_m1__nf1_gboth_sdfull_pc/B.n40 240
R21 pfet_01v8_lvt_W14p21_L0p89_m1__nf1_gboth_sdfull_pc/B.n182 pfet_01v8_lvt_W14p21_L0p89_m1__nf1_gboth_sdfull_pc/B.n40 240
R22 pfet_01v8_lvt_W14p21_L0p89_m1__nf1_gboth_sdfull_pc/B.n182 pfet_01v8_lvt_W14p21_L0p89_m1__nf1_gboth_sdfull_pc/B.n42 240
R23 pfet_01v8_lvt_W14p21_L0p89_m1__nf1_gboth_sdfull_pc/B.n174 pfet_01v8_lvt_W14p21_L0p89_m1__nf1_gboth_sdfull_pc/B.n42 240
R24 pfet_01v8_lvt_W14p21_L0p89_m1__nf1_gboth_sdfull_pc/B.n174 pfet_01v8_lvt_W14p21_L0p89_m1__nf1_gboth_sdfull_pc/B.n48 240
R25 pfet_01v8_lvt_W14p21_L0p89_m1__nf1_gboth_sdfull_pc/B.n170 pfet_01v8_lvt_W14p21_L0p89_m1__nf1_gboth_sdfull_pc/B.n48 240
R26 pfet_01v8_lvt_W14p21_L0p89_m1__nf1_gboth_sdfull_pc/B.n170 pfet_01v8_lvt_W14p21_L0p89_m1__nf1_gboth_sdfull_pc/B.n50 240
R27 pfet_01v8_lvt_W14p21_L0p89_m1__nf1_gboth_sdfull_pc/B.n162 pfet_01v8_lvt_W14p21_L0p89_m1__nf1_gboth_sdfull_pc/B.n50 240
R28 pfet_01v8_lvt_W14p21_L0p89_m1__nf1_gboth_sdfull_pc/B.n162 pfet_01v8_lvt_W14p21_L0p89_m1__nf1_gboth_sdfull_pc/B.n56 240
R29 pfet_01v8_lvt_W14p21_L0p89_m1__nf1_gboth_sdfull_pc/B.n158 pfet_01v8_lvt_W14p21_L0p89_m1__nf1_gboth_sdfull_pc/B.n56 240
R30 pfet_01v8_lvt_W14p21_L0p89_m1__nf1_gboth_sdfull_pc/B.n158 pfet_01v8_lvt_W14p21_L0p89_m1__nf1_gboth_sdfull_pc/B.n58 240
R31 pfet_01v8_lvt_W14p21_L0p89_m1__nf1_gboth_sdfull_pc/B.n150 pfet_01v8_lvt_W14p21_L0p89_m1__nf1_gboth_sdfull_pc/B.n58 240
R32 pfet_01v8_lvt_W14p21_L0p89_m1__nf1_gboth_sdfull_pc/B.n150 pfet_01v8_lvt_W14p21_L0p89_m1__nf1_gboth_sdfull_pc/B.n64 240
R33 pfet_01v8_lvt_W14p21_L0p89_m1__nf1_gboth_sdfull_pc/B.n146 pfet_01v8_lvt_W14p21_L0p89_m1__nf1_gboth_sdfull_pc/B.n64 240
R34 pfet_01v8_lvt_W14p21_L0p89_m1__nf1_gboth_sdfull_pc/B.n146 pfet_01v8_lvt_W14p21_L0p89_m1__nf1_gboth_sdfull_pc/B.n66 240
R35 pfet_01v8_lvt_W14p21_L0p89_m1__nf1_gboth_sdfull_pc/B.n138 pfet_01v8_lvt_W14p21_L0p89_m1__nf1_gboth_sdfull_pc/B.n66 240
R36 pfet_01v8_lvt_W14p21_L0p89_m1__nf1_gboth_sdfull_pc/B.n138 pfet_01v8_lvt_W14p21_L0p89_m1__nf1_gboth_sdfull_pc/B.n72 240
R37 pfet_01v8_lvt_W14p21_L0p89_m1__nf1_gboth_sdfull_pc/B.n134 pfet_01v8_lvt_W14p21_L0p89_m1__nf1_gboth_sdfull_pc/B.n72 240
R38 pfet_01v8_lvt_W14p21_L0p89_m1__nf1_gboth_sdfull_pc/B.n134 pfet_01v8_lvt_W14p21_L0p89_m1__nf1_gboth_sdfull_pc/B.n74 240
R39 pfet_01v8_lvt_W14p21_L0p89_m1__nf1_gboth_sdfull_pc/B.n126 pfet_01v8_lvt_W14p21_L0p89_m1__nf1_gboth_sdfull_pc/B.n74 240
R40 pfet_01v8_lvt_W14p21_L0p89_m1__nf1_gboth_sdfull_pc/B.n126 pfet_01v8_lvt_W14p21_L0p89_m1__nf1_gboth_sdfull_pc/B.n80 240
R41 pfet_01v8_lvt_W14p21_L0p89_m1__nf1_gboth_sdfull_pc/B.n122 pfet_01v8_lvt_W14p21_L0p89_m1__nf1_gboth_sdfull_pc/B.n80 240
R42 pfet_01v8_lvt_W14p21_L0p89_m1__nf1_gboth_sdfull_pc/B.n122 pfet_01v8_lvt_W14p21_L0p89_m1__nf1_gboth_sdfull_pc/B.n82 240
R43 pfet_01v8_lvt_W14p21_L0p89_m1__nf1_gboth_sdfull_pc/B.n114 pfet_01v8_lvt_W14p21_L0p89_m1__nf1_gboth_sdfull_pc/B.n82 240
R44 pfet_01v8_lvt_W14p21_L0p89_m1__nf1_gboth_sdfull_pc/B.n114 pfet_01v8_lvt_W14p21_L0p89_m1__nf1_gboth_sdfull_pc/B.n88 240
R45 pfet_01v8_lvt_W14p21_L0p89_m1__nf1_gboth_sdfull_pc/B.n110 pfet_01v8_lvt_W14p21_L0p89_m1__nf1_gboth_sdfull_pc/B.n88 240
R46 pfet_01v8_lvt_W14p21_L0p89_m1__nf1_gboth_sdfull_pc/B.n110 pfet_01v8_lvt_W14p21_L0p89_m1__nf1_gboth_sdfull_pc/B.n90 240
R47 pfet_01v8_lvt_W14p21_L0p89_m1__nf1_gboth_sdfull_pc/B.n244 pfet_01v8_lvt_W14p21_L0p89_m1__nf1_gboth_sdfull_pc/B.n2 240
R48 pfet_01v8_lvt_W14p21_L0p89_m1__nf1_gboth_sdfull_pc/B.n235 pfet_01v8_lvt_W14p21_L0p89_m1__nf1_gboth_sdfull_pc/B.n8 240
R49 pfet_01v8_lvt_W14p21_L0p89_m1__nf1_gboth_sdfull_pc/B.n241 pfet_01v8_lvt_W14p21_L0p89_m1__nf1_gboth_sdfull_pc/B.n4 240
R50 pfet_01v8_lvt_W14p21_L0p89_m1__nf1_gboth_sdfull_pc/B.n229 pfet_01v8_lvt_W14p21_L0p89_m1__nf1_gboth_sdfull_pc/B.n4 240
R51 pfet_01v8_lvt_W14p21_L0p89_m1__nf1_gboth_sdfull_pc/B.n229 pfet_01v8_lvt_W14p21_L0p89_m1__nf1_gboth_sdfull_pc/B.n12 240
R52 pfet_01v8_lvt_W14p21_L0p89_m1__nf1_gboth_sdfull_pc/B.n224 pfet_01v8_lvt_W14p21_L0p89_m1__nf1_gboth_sdfull_pc/B.n12 240
R53 pfet_01v8_lvt_W14p21_L0p89_m1__nf1_gboth_sdfull_pc/B.n224 pfet_01v8_lvt_W14p21_L0p89_m1__nf1_gboth_sdfull_pc/B.n14 240
R54 pfet_01v8_lvt_W14p21_L0p89_m1__nf1_gboth_sdfull_pc/B.n216 pfet_01v8_lvt_W14p21_L0p89_m1__nf1_gboth_sdfull_pc/B.n14 240
R55 pfet_01v8_lvt_W14p21_L0p89_m1__nf1_gboth_sdfull_pc/B.n216 pfet_01v8_lvt_W14p21_L0p89_m1__nf1_gboth_sdfull_pc/B.n20 240
R56 pfet_01v8_lvt_W14p21_L0p89_m1__nf1_gboth_sdfull_pc/B.n212 pfet_01v8_lvt_W14p21_L0p89_m1__nf1_gboth_sdfull_pc/B.n20 240
R57 pfet_01v8_lvt_W14p21_L0p89_m1__nf1_gboth_sdfull_pc/B.n212 pfet_01v8_lvt_W14p21_L0p89_m1__nf1_gboth_sdfull_pc/B.n22 240
R58 pfet_01v8_lvt_W14p21_L0p89_m1__nf1_gboth_sdfull_pc/B.n204 pfet_01v8_lvt_W14p21_L0p89_m1__nf1_gboth_sdfull_pc/B.n22 240
R59 pfet_01v8_lvt_W14p21_L0p89_m1__nf1_gboth_sdfull_pc/B.n204 pfet_01v8_lvt_W14p21_L0p89_m1__nf1_gboth_sdfull_pc/B.n28 240
R60 pfet_01v8_lvt_W14p21_L0p89_m1__nf1_gboth_sdfull_pc/B.n200 pfet_01v8_lvt_W14p21_L0p89_m1__nf1_gboth_sdfull_pc/B.n28 240
R61 pfet_01v8_lvt_W14p21_L0p89_m1__nf1_gboth_sdfull_pc/B.n200 pfet_01v8_lvt_W14p21_L0p89_m1__nf1_gboth_sdfull_pc/B.n30 240
R62 pfet_01v8_lvt_W14p21_L0p89_m1__nf1_gboth_sdfull_pc/B.n192 pfet_01v8_lvt_W14p21_L0p89_m1__nf1_gboth_sdfull_pc/B.n30 240
R63 pfet_01v8_lvt_W14p21_L0p89_m1__nf1_gboth_sdfull_pc/B.n192 pfet_01v8_lvt_W14p21_L0p89_m1__nf1_gboth_sdfull_pc/B.n36 240
R64 pfet_01v8_lvt_W14p21_L0p89_m1__nf1_gboth_sdfull_pc/B.n188 pfet_01v8_lvt_W14p21_L0p89_m1__nf1_gboth_sdfull_pc/B.n36 240
R65 pfet_01v8_lvt_W14p21_L0p89_m1__nf1_gboth_sdfull_pc/B.n188 pfet_01v8_lvt_W14p21_L0p89_m1__nf1_gboth_sdfull_pc/B.n38 240
R66 pfet_01v8_lvt_W14p21_L0p89_m1__nf1_gboth_sdfull_pc/B.n180 pfet_01v8_lvt_W14p21_L0p89_m1__nf1_gboth_sdfull_pc/B.n38 240
R67 pfet_01v8_lvt_W14p21_L0p89_m1__nf1_gboth_sdfull_pc/B.n180 pfet_01v8_lvt_W14p21_L0p89_m1__nf1_gboth_sdfull_pc/B.n44 240
R68 pfet_01v8_lvt_W14p21_L0p89_m1__nf1_gboth_sdfull_pc/B.n176 pfet_01v8_lvt_W14p21_L0p89_m1__nf1_gboth_sdfull_pc/B.n44 240
R69 pfet_01v8_lvt_W14p21_L0p89_m1__nf1_gboth_sdfull_pc/B.n176 pfet_01v8_lvt_W14p21_L0p89_m1__nf1_gboth_sdfull_pc/B.n46 240
R70 pfet_01v8_lvt_W14p21_L0p89_m1__nf1_gboth_sdfull_pc/B.n168 pfet_01v8_lvt_W14p21_L0p89_m1__nf1_gboth_sdfull_pc/B.n46 240
R71 pfet_01v8_lvt_W14p21_L0p89_m1__nf1_gboth_sdfull_pc/B.n168 pfet_01v8_lvt_W14p21_L0p89_m1__nf1_gboth_sdfull_pc/B.n52 240
R72 pfet_01v8_lvt_W14p21_L0p89_m1__nf1_gboth_sdfull_pc/B.n164 pfet_01v8_lvt_W14p21_L0p89_m1__nf1_gboth_sdfull_pc/B.n52 240
R73 pfet_01v8_lvt_W14p21_L0p89_m1__nf1_gboth_sdfull_pc/B.n164 pfet_01v8_lvt_W14p21_L0p89_m1__nf1_gboth_sdfull_pc/B.n54 240
R74 pfet_01v8_lvt_W14p21_L0p89_m1__nf1_gboth_sdfull_pc/B.n156 pfet_01v8_lvt_W14p21_L0p89_m1__nf1_gboth_sdfull_pc/B.n54 240
R75 pfet_01v8_lvt_W14p21_L0p89_m1__nf1_gboth_sdfull_pc/B.n156 pfet_01v8_lvt_W14p21_L0p89_m1__nf1_gboth_sdfull_pc/B.n60 240
R76 pfet_01v8_lvt_W14p21_L0p89_m1__nf1_gboth_sdfull_pc/B.n152 pfet_01v8_lvt_W14p21_L0p89_m1__nf1_gboth_sdfull_pc/B.n60 240
R77 pfet_01v8_lvt_W14p21_L0p89_m1__nf1_gboth_sdfull_pc/B.n152 pfet_01v8_lvt_W14p21_L0p89_m1__nf1_gboth_sdfull_pc/B.n62 240
R78 pfet_01v8_lvt_W14p21_L0p89_m1__nf1_gboth_sdfull_pc/B.n144 pfet_01v8_lvt_W14p21_L0p89_m1__nf1_gboth_sdfull_pc/B.n62 240
R79 pfet_01v8_lvt_W14p21_L0p89_m1__nf1_gboth_sdfull_pc/B.n144 pfet_01v8_lvt_W14p21_L0p89_m1__nf1_gboth_sdfull_pc/B.n68 240
R80 pfet_01v8_lvt_W14p21_L0p89_m1__nf1_gboth_sdfull_pc/B.n140 pfet_01v8_lvt_W14p21_L0p89_m1__nf1_gboth_sdfull_pc/B.n68 240
R81 pfet_01v8_lvt_W14p21_L0p89_m1__nf1_gboth_sdfull_pc/B.n140 pfet_01v8_lvt_W14p21_L0p89_m1__nf1_gboth_sdfull_pc/B.n70 240
R82 pfet_01v8_lvt_W14p21_L0p89_m1__nf1_gboth_sdfull_pc/B.n132 pfet_01v8_lvt_W14p21_L0p89_m1__nf1_gboth_sdfull_pc/B.n70 240
R83 pfet_01v8_lvt_W14p21_L0p89_m1__nf1_gboth_sdfull_pc/B.n132 pfet_01v8_lvt_W14p21_L0p89_m1__nf1_gboth_sdfull_pc/B.n76 240
R84 pfet_01v8_lvt_W14p21_L0p89_m1__nf1_gboth_sdfull_pc/B.n128 pfet_01v8_lvt_W14p21_L0p89_m1__nf1_gboth_sdfull_pc/B.n76 240
R85 pfet_01v8_lvt_W14p21_L0p89_m1__nf1_gboth_sdfull_pc/B.n128 pfet_01v8_lvt_W14p21_L0p89_m1__nf1_gboth_sdfull_pc/B.n78 240
R86 pfet_01v8_lvt_W14p21_L0p89_m1__nf1_gboth_sdfull_pc/B.n120 pfet_01v8_lvt_W14p21_L0p89_m1__nf1_gboth_sdfull_pc/B.n78 240
R87 pfet_01v8_lvt_W14p21_L0p89_m1__nf1_gboth_sdfull_pc/B.n120 pfet_01v8_lvt_W14p21_L0p89_m1__nf1_gboth_sdfull_pc/B.n84 240
R88 pfet_01v8_lvt_W14p21_L0p89_m1__nf1_gboth_sdfull_pc/B.n116 pfet_01v8_lvt_W14p21_L0p89_m1__nf1_gboth_sdfull_pc/B.n84 240
R89 pfet_01v8_lvt_W14p21_L0p89_m1__nf1_gboth_sdfull_pc/B.n116 pfet_01v8_lvt_W14p21_L0p89_m1__nf1_gboth_sdfull_pc/B.n86 240
R90 pfet_01v8_lvt_W14p21_L0p89_m1__nf1_gboth_sdfull_pc/B.n108 pfet_01v8_lvt_W14p21_L0p89_m1__nf1_gboth_sdfull_pc/B.n86 240
R91 pfet_01v8_lvt_W14p21_L0p89_m1__nf1_gboth_sdfull_pc/B.n108 pfet_01v8_lvt_W14p21_L0p89_m1__nf1_gboth_sdfull_pc/B.n92 240
R92 pfet_01v8_lvt_W14p21_L0p89_m1__nf1_gboth_sdfull_pc/B.n95 pfet_01v8_lvt_W14p21_L0p89_m1__nf1_gboth_sdfull_pc/B.n94 240
R93 pfet_01v8_lvt_W14p21_L0p89_m1__nf1_gboth_sdfull_pc/B.n96 pfet_01v8_lvt_W14p21_L0p89_m1__nf1_gboth_sdfull_pc/B.n95 240
R94 pfet_01v8_lvt_W14p21_L0p89_m1__nf1_gboth_sdfull_pc/B.n240 pfet_01v8_lvt_W14p21_L0p89_m1__nf1_gboth_sdfull_pc/B.n3 208.333
R95 pfet_01v8_lvt_W14p21_L0p89_m1__nf1_gboth_sdfull_pc/B.n102 pfet_01v8_lvt_W14p21_L0p89_m1__nf1_gboth_sdfull_pc/B.n91 208.333
R96 pfet_01v8_lvt_W14p21_L0p89_m1__nf1_gboth_sdfull_pc/B.n8 pfet_01v8_lvt_W14p21_L0p89_m1__nf1_gboth_sdfull_pc/B.n3 185
R97 pfet_01v8_lvt_W14p21_L0p89_m1__nf1_gboth_sdfull_pc/B.n237 pfet_01v8_lvt_W14p21_L0p89_m1__nf1_gboth_sdfull_pc/B.n8 185
R98 pfet_01v8_lvt_W14p21_L0p89_m1__nf1_gboth_sdfull_pc/B.n236 pfet_01v8_lvt_W14p21_L0p89_m1__nf1_gboth_sdfull_pc/B.n235 185
R99 pfet_01v8_lvt_W14p21_L0p89_m1__nf1_gboth_sdfull_pc/B.n2 pfet_01v8_lvt_W14p21_L0p89_m1__nf1_gboth_sdfull_pc/B.n0 185
R100 pfet_01v8_lvt_W14p21_L0p89_m1__nf1_gboth_sdfull_pc/B.n245 pfet_01v8_lvt_W14p21_L0p89_m1__nf1_gboth_sdfull_pc/B.n244 185
R101 pfet_01v8_lvt_W14p21_L0p89_m1__nf1_gboth_sdfull_pc/B.n242 pfet_01v8_lvt_W14p21_L0p89_m1__nf1_gboth_sdfull_pc/B.n1 185
R102 pfet_01v8_lvt_W14p21_L0p89_m1__nf1_gboth_sdfull_pc/B.n241 pfet_01v8_lvt_W14p21_L0p89_m1__nf1_gboth_sdfull_pc/B.n240 185
R103 pfet_01v8_lvt_W14p21_L0p89_m1__nf1_gboth_sdfull_pc/B.n241 pfet_01v8_lvt_W14p21_L0p89_m1__nf1_gboth_sdfull_pc/B.n5 185
R104 pfet_01v8_lvt_W14p21_L0p89_m1__nf1_gboth_sdfull_pc/B.n6 pfet_01v8_lvt_W14p21_L0p89_m1__nf1_gboth_sdfull_pc/B.n4 185
R105 pfet_01v8_lvt_W14p21_L0p89_m1__nf1_gboth_sdfull_pc/B.n227 pfet_01v8_lvt_W14p21_L0p89_m1__nf1_gboth_sdfull_pc/B.n4 185
R106 pfet_01v8_lvt_W14p21_L0p89_m1__nf1_gboth_sdfull_pc/B.n230 pfet_01v8_lvt_W14p21_L0p89_m1__nf1_gboth_sdfull_pc/B.n229 185
R107 pfet_01v8_lvt_W14p21_L0p89_m1__nf1_gboth_sdfull_pc/B.n229 pfet_01v8_lvt_W14p21_L0p89_m1__nf1_gboth_sdfull_pc/B.n228 185
R108 pfet_01v8_lvt_W14p21_L0p89_m1__nf1_gboth_sdfull_pc/B.n12 pfet_01v8_lvt_W14p21_L0p89_m1__nf1_gboth_sdfull_pc/B.n11 185
R109 pfet_01v8_lvt_W14p21_L0p89_m1__nf1_gboth_sdfull_pc/B.n226 pfet_01v8_lvt_W14p21_L0p89_m1__nf1_gboth_sdfull_pc/B.n12 185
R110 pfet_01v8_lvt_W14p21_L0p89_m1__nf1_gboth_sdfull_pc/B.n224 pfet_01v8_lvt_W14p21_L0p89_m1__nf1_gboth_sdfull_pc/B.n223 185
R111 pfet_01v8_lvt_W14p21_L0p89_m1__nf1_gboth_sdfull_pc/B.n225 pfet_01v8_lvt_W14p21_L0p89_m1__nf1_gboth_sdfull_pc/B.n224 185
R112 pfet_01v8_lvt_W14p21_L0p89_m1__nf1_gboth_sdfull_pc/B.n15 pfet_01v8_lvt_W14p21_L0p89_m1__nf1_gboth_sdfull_pc/B.n14 185
R113 pfet_01v8_lvt_W14p21_L0p89_m1__nf1_gboth_sdfull_pc/B.n14 pfet_01v8_lvt_W14p21_L0p89_m1__nf1_gboth_sdfull_pc/B.n13 185
R114 pfet_01v8_lvt_W14p21_L0p89_m1__nf1_gboth_sdfull_pc/B.n217 pfet_01v8_lvt_W14p21_L0p89_m1__nf1_gboth_sdfull_pc/B.n216 185
R115 pfet_01v8_lvt_W14p21_L0p89_m1__nf1_gboth_sdfull_pc/B.n216 pfet_01v8_lvt_W14p21_L0p89_m1__nf1_gboth_sdfull_pc/B.n215 185
R116 pfet_01v8_lvt_W14p21_L0p89_m1__nf1_gboth_sdfull_pc/B.n20 pfet_01v8_lvt_W14p21_L0p89_m1__nf1_gboth_sdfull_pc/B.n19 185
R117 pfet_01v8_lvt_W14p21_L0p89_m1__nf1_gboth_sdfull_pc/B.n214 pfet_01v8_lvt_W14p21_L0p89_m1__nf1_gboth_sdfull_pc/B.n20 185
R118 pfet_01v8_lvt_W14p21_L0p89_m1__nf1_gboth_sdfull_pc/B.n212 pfet_01v8_lvt_W14p21_L0p89_m1__nf1_gboth_sdfull_pc/B.n211 185
R119 pfet_01v8_lvt_W14p21_L0p89_m1__nf1_gboth_sdfull_pc/B.n213 pfet_01v8_lvt_W14p21_L0p89_m1__nf1_gboth_sdfull_pc/B.n212 185
R120 pfet_01v8_lvt_W14p21_L0p89_m1__nf1_gboth_sdfull_pc/B.n23 pfet_01v8_lvt_W14p21_L0p89_m1__nf1_gboth_sdfull_pc/B.n22 185
R121 pfet_01v8_lvt_W14p21_L0p89_m1__nf1_gboth_sdfull_pc/B.n22 pfet_01v8_lvt_W14p21_L0p89_m1__nf1_gboth_sdfull_pc/B.n21 185
R122 pfet_01v8_lvt_W14p21_L0p89_m1__nf1_gboth_sdfull_pc/B.n205 pfet_01v8_lvt_W14p21_L0p89_m1__nf1_gboth_sdfull_pc/B.n204 185
R123 pfet_01v8_lvt_W14p21_L0p89_m1__nf1_gboth_sdfull_pc/B.n204 pfet_01v8_lvt_W14p21_L0p89_m1__nf1_gboth_sdfull_pc/B.n203 185
R124 pfet_01v8_lvt_W14p21_L0p89_m1__nf1_gboth_sdfull_pc/B.n28 pfet_01v8_lvt_W14p21_L0p89_m1__nf1_gboth_sdfull_pc/B.n27 185
R125 pfet_01v8_lvt_W14p21_L0p89_m1__nf1_gboth_sdfull_pc/B.n202 pfet_01v8_lvt_W14p21_L0p89_m1__nf1_gboth_sdfull_pc/B.n28 185
R126 pfet_01v8_lvt_W14p21_L0p89_m1__nf1_gboth_sdfull_pc/B.n200 pfet_01v8_lvt_W14p21_L0p89_m1__nf1_gboth_sdfull_pc/B.n199 185
R127 pfet_01v8_lvt_W14p21_L0p89_m1__nf1_gboth_sdfull_pc/B.n201 pfet_01v8_lvt_W14p21_L0p89_m1__nf1_gboth_sdfull_pc/B.n200 185
R128 pfet_01v8_lvt_W14p21_L0p89_m1__nf1_gboth_sdfull_pc/B.n31 pfet_01v8_lvt_W14p21_L0p89_m1__nf1_gboth_sdfull_pc/B.n30 185
R129 pfet_01v8_lvt_W14p21_L0p89_m1__nf1_gboth_sdfull_pc/B.n30 pfet_01v8_lvt_W14p21_L0p89_m1__nf1_gboth_sdfull_pc/B.n29 185
R130 pfet_01v8_lvt_W14p21_L0p89_m1__nf1_gboth_sdfull_pc/B.n193 pfet_01v8_lvt_W14p21_L0p89_m1__nf1_gboth_sdfull_pc/B.n192 185
R131 pfet_01v8_lvt_W14p21_L0p89_m1__nf1_gboth_sdfull_pc/B.n192 pfet_01v8_lvt_W14p21_L0p89_m1__nf1_gboth_sdfull_pc/B.n191 185
R132 pfet_01v8_lvt_W14p21_L0p89_m1__nf1_gboth_sdfull_pc/B.n36 pfet_01v8_lvt_W14p21_L0p89_m1__nf1_gboth_sdfull_pc/B.n35 185
R133 pfet_01v8_lvt_W14p21_L0p89_m1__nf1_gboth_sdfull_pc/B.n190 pfet_01v8_lvt_W14p21_L0p89_m1__nf1_gboth_sdfull_pc/B.n36 185
R134 pfet_01v8_lvt_W14p21_L0p89_m1__nf1_gboth_sdfull_pc/B.n188 pfet_01v8_lvt_W14p21_L0p89_m1__nf1_gboth_sdfull_pc/B.n187 185
R135 pfet_01v8_lvt_W14p21_L0p89_m1__nf1_gboth_sdfull_pc/B.n189 pfet_01v8_lvt_W14p21_L0p89_m1__nf1_gboth_sdfull_pc/B.n188 185
R136 pfet_01v8_lvt_W14p21_L0p89_m1__nf1_gboth_sdfull_pc/B.n39 pfet_01v8_lvt_W14p21_L0p89_m1__nf1_gboth_sdfull_pc/B.n38 185
R137 pfet_01v8_lvt_W14p21_L0p89_m1__nf1_gboth_sdfull_pc/B.n38 pfet_01v8_lvt_W14p21_L0p89_m1__nf1_gboth_sdfull_pc/B.n37 185
R138 pfet_01v8_lvt_W14p21_L0p89_m1__nf1_gboth_sdfull_pc/B.n181 pfet_01v8_lvt_W14p21_L0p89_m1__nf1_gboth_sdfull_pc/B.n180 185
R139 pfet_01v8_lvt_W14p21_L0p89_m1__nf1_gboth_sdfull_pc/B.n180 pfet_01v8_lvt_W14p21_L0p89_m1__nf1_gboth_sdfull_pc/B.n179 185
R140 pfet_01v8_lvt_W14p21_L0p89_m1__nf1_gboth_sdfull_pc/B.n44 pfet_01v8_lvt_W14p21_L0p89_m1__nf1_gboth_sdfull_pc/B.n43 185
R141 pfet_01v8_lvt_W14p21_L0p89_m1__nf1_gboth_sdfull_pc/B.n178 pfet_01v8_lvt_W14p21_L0p89_m1__nf1_gboth_sdfull_pc/B.n44 185
R142 pfet_01v8_lvt_W14p21_L0p89_m1__nf1_gboth_sdfull_pc/B.n176 pfet_01v8_lvt_W14p21_L0p89_m1__nf1_gboth_sdfull_pc/B.n175 185
R143 pfet_01v8_lvt_W14p21_L0p89_m1__nf1_gboth_sdfull_pc/B.n177 pfet_01v8_lvt_W14p21_L0p89_m1__nf1_gboth_sdfull_pc/B.n176 185
R144 pfet_01v8_lvt_W14p21_L0p89_m1__nf1_gboth_sdfull_pc/B.n47 pfet_01v8_lvt_W14p21_L0p89_m1__nf1_gboth_sdfull_pc/B.n46 185
R145 pfet_01v8_lvt_W14p21_L0p89_m1__nf1_gboth_sdfull_pc/B.n46 pfet_01v8_lvt_W14p21_L0p89_m1__nf1_gboth_sdfull_pc/B.n45 185
R146 pfet_01v8_lvt_W14p21_L0p89_m1__nf1_gboth_sdfull_pc/B.n169 pfet_01v8_lvt_W14p21_L0p89_m1__nf1_gboth_sdfull_pc/B.n168 185
R147 pfet_01v8_lvt_W14p21_L0p89_m1__nf1_gboth_sdfull_pc/B.n168 pfet_01v8_lvt_W14p21_L0p89_m1__nf1_gboth_sdfull_pc/B.n167 185
R148 pfet_01v8_lvt_W14p21_L0p89_m1__nf1_gboth_sdfull_pc/B.n52 pfet_01v8_lvt_W14p21_L0p89_m1__nf1_gboth_sdfull_pc/B.n51 185
R149 pfet_01v8_lvt_W14p21_L0p89_m1__nf1_gboth_sdfull_pc/B.n166 pfet_01v8_lvt_W14p21_L0p89_m1__nf1_gboth_sdfull_pc/B.n52 185
R150 pfet_01v8_lvt_W14p21_L0p89_m1__nf1_gboth_sdfull_pc/B.n164 pfet_01v8_lvt_W14p21_L0p89_m1__nf1_gboth_sdfull_pc/B.n163 185
R151 pfet_01v8_lvt_W14p21_L0p89_m1__nf1_gboth_sdfull_pc/B.n165 pfet_01v8_lvt_W14p21_L0p89_m1__nf1_gboth_sdfull_pc/B.n164 185
R152 pfet_01v8_lvt_W14p21_L0p89_m1__nf1_gboth_sdfull_pc/B.n55 pfet_01v8_lvt_W14p21_L0p89_m1__nf1_gboth_sdfull_pc/B.n54 185
R153 pfet_01v8_lvt_W14p21_L0p89_m1__nf1_gboth_sdfull_pc/B.n54 pfet_01v8_lvt_W14p21_L0p89_m1__nf1_gboth_sdfull_pc/B.n53 185
R154 pfet_01v8_lvt_W14p21_L0p89_m1__nf1_gboth_sdfull_pc/B.n157 pfet_01v8_lvt_W14p21_L0p89_m1__nf1_gboth_sdfull_pc/B.n156 185
R155 pfet_01v8_lvt_W14p21_L0p89_m1__nf1_gboth_sdfull_pc/B.n156 pfet_01v8_lvt_W14p21_L0p89_m1__nf1_gboth_sdfull_pc/B.n155 185
R156 pfet_01v8_lvt_W14p21_L0p89_m1__nf1_gboth_sdfull_pc/B.n60 pfet_01v8_lvt_W14p21_L0p89_m1__nf1_gboth_sdfull_pc/B.n59 185
R157 pfet_01v8_lvt_W14p21_L0p89_m1__nf1_gboth_sdfull_pc/B.n154 pfet_01v8_lvt_W14p21_L0p89_m1__nf1_gboth_sdfull_pc/B.n60 185
R158 pfet_01v8_lvt_W14p21_L0p89_m1__nf1_gboth_sdfull_pc/B.n152 pfet_01v8_lvt_W14p21_L0p89_m1__nf1_gboth_sdfull_pc/B.n151 185
R159 pfet_01v8_lvt_W14p21_L0p89_m1__nf1_gboth_sdfull_pc/B.n153 pfet_01v8_lvt_W14p21_L0p89_m1__nf1_gboth_sdfull_pc/B.n152 185
R160 pfet_01v8_lvt_W14p21_L0p89_m1__nf1_gboth_sdfull_pc/B.n63 pfet_01v8_lvt_W14p21_L0p89_m1__nf1_gboth_sdfull_pc/B.n62 185
R161 pfet_01v8_lvt_W14p21_L0p89_m1__nf1_gboth_sdfull_pc/B.n62 pfet_01v8_lvt_W14p21_L0p89_m1__nf1_gboth_sdfull_pc/B.n61 185
R162 pfet_01v8_lvt_W14p21_L0p89_m1__nf1_gboth_sdfull_pc/B.n145 pfet_01v8_lvt_W14p21_L0p89_m1__nf1_gboth_sdfull_pc/B.n144 185
R163 pfet_01v8_lvt_W14p21_L0p89_m1__nf1_gboth_sdfull_pc/B.n144 pfet_01v8_lvt_W14p21_L0p89_m1__nf1_gboth_sdfull_pc/B.n143 185
R164 pfet_01v8_lvt_W14p21_L0p89_m1__nf1_gboth_sdfull_pc/B.n68 pfet_01v8_lvt_W14p21_L0p89_m1__nf1_gboth_sdfull_pc/B.n67 185
R165 pfet_01v8_lvt_W14p21_L0p89_m1__nf1_gboth_sdfull_pc/B.n142 pfet_01v8_lvt_W14p21_L0p89_m1__nf1_gboth_sdfull_pc/B.n68 185
R166 pfet_01v8_lvt_W14p21_L0p89_m1__nf1_gboth_sdfull_pc/B.n140 pfet_01v8_lvt_W14p21_L0p89_m1__nf1_gboth_sdfull_pc/B.n139 185
R167 pfet_01v8_lvt_W14p21_L0p89_m1__nf1_gboth_sdfull_pc/B.n141 pfet_01v8_lvt_W14p21_L0p89_m1__nf1_gboth_sdfull_pc/B.n140 185
R168 pfet_01v8_lvt_W14p21_L0p89_m1__nf1_gboth_sdfull_pc/B.n71 pfet_01v8_lvt_W14p21_L0p89_m1__nf1_gboth_sdfull_pc/B.n70 185
R169 pfet_01v8_lvt_W14p21_L0p89_m1__nf1_gboth_sdfull_pc/B.n70 pfet_01v8_lvt_W14p21_L0p89_m1__nf1_gboth_sdfull_pc/B.n69 185
R170 pfet_01v8_lvt_W14p21_L0p89_m1__nf1_gboth_sdfull_pc/B.n133 pfet_01v8_lvt_W14p21_L0p89_m1__nf1_gboth_sdfull_pc/B.n132 185
R171 pfet_01v8_lvt_W14p21_L0p89_m1__nf1_gboth_sdfull_pc/B.n132 pfet_01v8_lvt_W14p21_L0p89_m1__nf1_gboth_sdfull_pc/B.n131 185
R172 pfet_01v8_lvt_W14p21_L0p89_m1__nf1_gboth_sdfull_pc/B.n76 pfet_01v8_lvt_W14p21_L0p89_m1__nf1_gboth_sdfull_pc/B.n75 185
R173 pfet_01v8_lvt_W14p21_L0p89_m1__nf1_gboth_sdfull_pc/B.n130 pfet_01v8_lvt_W14p21_L0p89_m1__nf1_gboth_sdfull_pc/B.n76 185
R174 pfet_01v8_lvt_W14p21_L0p89_m1__nf1_gboth_sdfull_pc/B.n128 pfet_01v8_lvt_W14p21_L0p89_m1__nf1_gboth_sdfull_pc/B.n127 185
R175 pfet_01v8_lvt_W14p21_L0p89_m1__nf1_gboth_sdfull_pc/B.n129 pfet_01v8_lvt_W14p21_L0p89_m1__nf1_gboth_sdfull_pc/B.n128 185
R176 pfet_01v8_lvt_W14p21_L0p89_m1__nf1_gboth_sdfull_pc/B.n79 pfet_01v8_lvt_W14p21_L0p89_m1__nf1_gboth_sdfull_pc/B.n78 185
R177 pfet_01v8_lvt_W14p21_L0p89_m1__nf1_gboth_sdfull_pc/B.n78 pfet_01v8_lvt_W14p21_L0p89_m1__nf1_gboth_sdfull_pc/B.n77 185
R178 pfet_01v8_lvt_W14p21_L0p89_m1__nf1_gboth_sdfull_pc/B.n121 pfet_01v8_lvt_W14p21_L0p89_m1__nf1_gboth_sdfull_pc/B.n120 185
R179 pfet_01v8_lvt_W14p21_L0p89_m1__nf1_gboth_sdfull_pc/B.n120 pfet_01v8_lvt_W14p21_L0p89_m1__nf1_gboth_sdfull_pc/B.n119 185
R180 pfet_01v8_lvt_W14p21_L0p89_m1__nf1_gboth_sdfull_pc/B.n84 pfet_01v8_lvt_W14p21_L0p89_m1__nf1_gboth_sdfull_pc/B.n83 185
R181 pfet_01v8_lvt_W14p21_L0p89_m1__nf1_gboth_sdfull_pc/B.n118 pfet_01v8_lvt_W14p21_L0p89_m1__nf1_gboth_sdfull_pc/B.n84 185
R182 pfet_01v8_lvt_W14p21_L0p89_m1__nf1_gboth_sdfull_pc/B.n116 pfet_01v8_lvt_W14p21_L0p89_m1__nf1_gboth_sdfull_pc/B.n115 185
R183 pfet_01v8_lvt_W14p21_L0p89_m1__nf1_gboth_sdfull_pc/B.n117 pfet_01v8_lvt_W14p21_L0p89_m1__nf1_gboth_sdfull_pc/B.n116 185
R184 pfet_01v8_lvt_W14p21_L0p89_m1__nf1_gboth_sdfull_pc/B.n87 pfet_01v8_lvt_W14p21_L0p89_m1__nf1_gboth_sdfull_pc/B.n86 185
R185 pfet_01v8_lvt_W14p21_L0p89_m1__nf1_gboth_sdfull_pc/B.n86 pfet_01v8_lvt_W14p21_L0p89_m1__nf1_gboth_sdfull_pc/B.n85 185
R186 pfet_01v8_lvt_W14p21_L0p89_m1__nf1_gboth_sdfull_pc/B.n109 pfet_01v8_lvt_W14p21_L0p89_m1__nf1_gboth_sdfull_pc/B.n108 185
R187 pfet_01v8_lvt_W14p21_L0p89_m1__nf1_gboth_sdfull_pc/B.n108 pfet_01v8_lvt_W14p21_L0p89_m1__nf1_gboth_sdfull_pc/B.n107 185
R188 pfet_01v8_lvt_W14p21_L0p89_m1__nf1_gboth_sdfull_pc/B.n92 pfet_01v8_lvt_W14p21_L0p89_m1__nf1_gboth_sdfull_pc/B.n91 185
R189 pfet_01v8_lvt_W14p21_L0p89_m1__nf1_gboth_sdfull_pc/B.n106 pfet_01v8_lvt_W14p21_L0p89_m1__nf1_gboth_sdfull_pc/B.n92 185
R190 pfet_01v8_lvt_W14p21_L0p89_m1__nf1_gboth_sdfull_pc/B.n105 pfet_01v8_lvt_W14p21_L0p89_m1__nf1_gboth_sdfull_pc/B.n104 185
R191 pfet_01v8_lvt_W14p21_L0p89_m1__nf1_gboth_sdfull_pc/B.n94 pfet_01v8_lvt_W14p21_L0p89_m1__nf1_gboth_sdfull_pc/B.n93 185
R192 pfet_01v8_lvt_W14p21_L0p89_m1__nf1_gboth_sdfull_pc/B.n102 pfet_01v8_lvt_W14p21_L0p89_m1__nf1_gboth_sdfull_pc/B.n95 185
R193 pfet_01v8_lvt_W14p21_L0p89_m1__nf1_gboth_sdfull_pc/B.n97 pfet_01v8_lvt_W14p21_L0p89_m1__nf1_gboth_sdfull_pc/B.n95 185
R194 pfet_01v8_lvt_W14p21_L0p89_m1__nf1_gboth_sdfull_pc/B.n98 pfet_01v8_lvt_W14p21_L0p89_m1__nf1_gboth_sdfull_pc/B.n96 185
R195 pfet_01v8_lvt_W14p21_L0p89_m1__nf1_gboth_sdfull_pc/B.n100 pfet_01v8_lvt_W14p21_L0p89_m1__nf1_gboth_sdfull_pc/B.n99 185
R196 pfet_01v8_lvt_W14p21_L0p89_m1__nf1_gboth_sdfull_pc/B.n91 pfet_01v8_lvt_W14p21_L0p89_m1__nf1_gboth_sdfull_pc/B.n90 185
R197 pfet_01v8_lvt_W14p21_L0p89_m1__nf1_gboth_sdfull_pc/B.n90 pfet_01v8_lvt_W14p21_L0p89_m1__nf1_gboth_sdfull_pc/B.n89 185
R198 pfet_01v8_lvt_W14p21_L0p89_m1__nf1_gboth_sdfull_pc/B.n110 pfet_01v8_lvt_W14p21_L0p89_m1__nf1_gboth_sdfull_pc/B.n109 185
R199 pfet_01v8_lvt_W14p21_L0p89_m1__nf1_gboth_sdfull_pc/B.n111 pfet_01v8_lvt_W14p21_L0p89_m1__nf1_gboth_sdfull_pc/B.n110 185
R200 pfet_01v8_lvt_W14p21_L0p89_m1__nf1_gboth_sdfull_pc/B.n88 pfet_01v8_lvt_W14p21_L0p89_m1__nf1_gboth_sdfull_pc/B.n87 185
R201 pfet_01v8_lvt_W14p21_L0p89_m1__nf1_gboth_sdfull_pc/B.n112 pfet_01v8_lvt_W14p21_L0p89_m1__nf1_gboth_sdfull_pc/B.n88 185
R202 pfet_01v8_lvt_W14p21_L0p89_m1__nf1_gboth_sdfull_pc/B.n115 pfet_01v8_lvt_W14p21_L0p89_m1__nf1_gboth_sdfull_pc/B.n114 185
R203 pfet_01v8_lvt_W14p21_L0p89_m1__nf1_gboth_sdfull_pc/B.n114 pfet_01v8_lvt_W14p21_L0p89_m1__nf1_gboth_sdfull_pc/B.n113 185
R204 pfet_01v8_lvt_W14p21_L0p89_m1__nf1_gboth_sdfull_pc/B.n83 pfet_01v8_lvt_W14p21_L0p89_m1__nf1_gboth_sdfull_pc/B.n82 185
R205 pfet_01v8_lvt_W14p21_L0p89_m1__nf1_gboth_sdfull_pc/B.n82 pfet_01v8_lvt_W14p21_L0p89_m1__nf1_gboth_sdfull_pc/B.n81 185
R206 pfet_01v8_lvt_W14p21_L0p89_m1__nf1_gboth_sdfull_pc/B.n122 pfet_01v8_lvt_W14p21_L0p89_m1__nf1_gboth_sdfull_pc/B.n121 185
R207 pfet_01v8_lvt_W14p21_L0p89_m1__nf1_gboth_sdfull_pc/B.n123 pfet_01v8_lvt_W14p21_L0p89_m1__nf1_gboth_sdfull_pc/B.n122 185
R208 pfet_01v8_lvt_W14p21_L0p89_m1__nf1_gboth_sdfull_pc/B.n80 pfet_01v8_lvt_W14p21_L0p89_m1__nf1_gboth_sdfull_pc/B.n79 185
R209 pfet_01v8_lvt_W14p21_L0p89_m1__nf1_gboth_sdfull_pc/B.n124 pfet_01v8_lvt_W14p21_L0p89_m1__nf1_gboth_sdfull_pc/B.n80 185
R210 pfet_01v8_lvt_W14p21_L0p89_m1__nf1_gboth_sdfull_pc/B.n127 pfet_01v8_lvt_W14p21_L0p89_m1__nf1_gboth_sdfull_pc/B.n126 185
R211 pfet_01v8_lvt_W14p21_L0p89_m1__nf1_gboth_sdfull_pc/B.n126 pfet_01v8_lvt_W14p21_L0p89_m1__nf1_gboth_sdfull_pc/B.n125 185
R212 pfet_01v8_lvt_W14p21_L0p89_m1__nf1_gboth_sdfull_pc/B.n75 pfet_01v8_lvt_W14p21_L0p89_m1__nf1_gboth_sdfull_pc/B.n74 185
R213 pfet_01v8_lvt_W14p21_L0p89_m1__nf1_gboth_sdfull_pc/B.n74 pfet_01v8_lvt_W14p21_L0p89_m1__nf1_gboth_sdfull_pc/B.n73 185
R214 pfet_01v8_lvt_W14p21_L0p89_m1__nf1_gboth_sdfull_pc/B.n134 pfet_01v8_lvt_W14p21_L0p89_m1__nf1_gboth_sdfull_pc/B.n133 185
R215 pfet_01v8_lvt_W14p21_L0p89_m1__nf1_gboth_sdfull_pc/B.n135 pfet_01v8_lvt_W14p21_L0p89_m1__nf1_gboth_sdfull_pc/B.n134 185
R216 pfet_01v8_lvt_W14p21_L0p89_m1__nf1_gboth_sdfull_pc/B.n72 pfet_01v8_lvt_W14p21_L0p89_m1__nf1_gboth_sdfull_pc/B.n71 185
R217 pfet_01v8_lvt_W14p21_L0p89_m1__nf1_gboth_sdfull_pc/B.n136 pfet_01v8_lvt_W14p21_L0p89_m1__nf1_gboth_sdfull_pc/B.n72 185
R218 pfet_01v8_lvt_W14p21_L0p89_m1__nf1_gboth_sdfull_pc/B.n139 pfet_01v8_lvt_W14p21_L0p89_m1__nf1_gboth_sdfull_pc/B.n138 185
R219 pfet_01v8_lvt_W14p21_L0p89_m1__nf1_gboth_sdfull_pc/B.n138 pfet_01v8_lvt_W14p21_L0p89_m1__nf1_gboth_sdfull_pc/B.n137 185
R220 pfet_01v8_lvt_W14p21_L0p89_m1__nf1_gboth_sdfull_pc/B.n67 pfet_01v8_lvt_W14p21_L0p89_m1__nf1_gboth_sdfull_pc/B.n66 185
R221 pfet_01v8_lvt_W14p21_L0p89_m1__nf1_gboth_sdfull_pc/B.n66 pfet_01v8_lvt_W14p21_L0p89_m1__nf1_gboth_sdfull_pc/B.n65 185
R222 pfet_01v8_lvt_W14p21_L0p89_m1__nf1_gboth_sdfull_pc/B.n146 pfet_01v8_lvt_W14p21_L0p89_m1__nf1_gboth_sdfull_pc/B.n145 185
R223 pfet_01v8_lvt_W14p21_L0p89_m1__nf1_gboth_sdfull_pc/B.n147 pfet_01v8_lvt_W14p21_L0p89_m1__nf1_gboth_sdfull_pc/B.n146 185
R224 pfet_01v8_lvt_W14p21_L0p89_m1__nf1_gboth_sdfull_pc/B.n64 pfet_01v8_lvt_W14p21_L0p89_m1__nf1_gboth_sdfull_pc/B.n63 185
R225 pfet_01v8_lvt_W14p21_L0p89_m1__nf1_gboth_sdfull_pc/B.n148 pfet_01v8_lvt_W14p21_L0p89_m1__nf1_gboth_sdfull_pc/B.n64 185
R226 pfet_01v8_lvt_W14p21_L0p89_m1__nf1_gboth_sdfull_pc/B.n151 pfet_01v8_lvt_W14p21_L0p89_m1__nf1_gboth_sdfull_pc/B.n150 185
R227 pfet_01v8_lvt_W14p21_L0p89_m1__nf1_gboth_sdfull_pc/B.n150 pfet_01v8_lvt_W14p21_L0p89_m1__nf1_gboth_sdfull_pc/B.n149 185
R228 pfet_01v8_lvt_W14p21_L0p89_m1__nf1_gboth_sdfull_pc/B.n59 pfet_01v8_lvt_W14p21_L0p89_m1__nf1_gboth_sdfull_pc/B.n58 185
R229 pfet_01v8_lvt_W14p21_L0p89_m1__nf1_gboth_sdfull_pc/B.n58 pfet_01v8_lvt_W14p21_L0p89_m1__nf1_gboth_sdfull_pc/B.n57 185
R230 pfet_01v8_lvt_W14p21_L0p89_m1__nf1_gboth_sdfull_pc/B.n158 pfet_01v8_lvt_W14p21_L0p89_m1__nf1_gboth_sdfull_pc/B.n157 185
R231 pfet_01v8_lvt_W14p21_L0p89_m1__nf1_gboth_sdfull_pc/B.n159 pfet_01v8_lvt_W14p21_L0p89_m1__nf1_gboth_sdfull_pc/B.n158 185
R232 pfet_01v8_lvt_W14p21_L0p89_m1__nf1_gboth_sdfull_pc/B.n56 pfet_01v8_lvt_W14p21_L0p89_m1__nf1_gboth_sdfull_pc/B.n55 185
R233 pfet_01v8_lvt_W14p21_L0p89_m1__nf1_gboth_sdfull_pc/B.n160 pfet_01v8_lvt_W14p21_L0p89_m1__nf1_gboth_sdfull_pc/B.n56 185
R234 pfet_01v8_lvt_W14p21_L0p89_m1__nf1_gboth_sdfull_pc/B.n163 pfet_01v8_lvt_W14p21_L0p89_m1__nf1_gboth_sdfull_pc/B.n162 185
R235 pfet_01v8_lvt_W14p21_L0p89_m1__nf1_gboth_sdfull_pc/B.n162 pfet_01v8_lvt_W14p21_L0p89_m1__nf1_gboth_sdfull_pc/B.n161 185
R236 pfet_01v8_lvt_W14p21_L0p89_m1__nf1_gboth_sdfull_pc/B.n51 pfet_01v8_lvt_W14p21_L0p89_m1__nf1_gboth_sdfull_pc/B.n50 185
R237 pfet_01v8_lvt_W14p21_L0p89_m1__nf1_gboth_sdfull_pc/B.n50 pfet_01v8_lvt_W14p21_L0p89_m1__nf1_gboth_sdfull_pc/B.n49 185
R238 pfet_01v8_lvt_W14p21_L0p89_m1__nf1_gboth_sdfull_pc/B.n170 pfet_01v8_lvt_W14p21_L0p89_m1__nf1_gboth_sdfull_pc/B.n169 185
R239 pfet_01v8_lvt_W14p21_L0p89_m1__nf1_gboth_sdfull_pc/B.n171 pfet_01v8_lvt_W14p21_L0p89_m1__nf1_gboth_sdfull_pc/B.n170 185
R240 pfet_01v8_lvt_W14p21_L0p89_m1__nf1_gboth_sdfull_pc/B.n48 pfet_01v8_lvt_W14p21_L0p89_m1__nf1_gboth_sdfull_pc/B.n47 185
R241 pfet_01v8_lvt_W14p21_L0p89_m1__nf1_gboth_sdfull_pc/B.n172 pfet_01v8_lvt_W14p21_L0p89_m1__nf1_gboth_sdfull_pc/B.n48 185
R242 pfet_01v8_lvt_W14p21_L0p89_m1__nf1_gboth_sdfull_pc/B.n175 pfet_01v8_lvt_W14p21_L0p89_m1__nf1_gboth_sdfull_pc/B.n174 185
R243 pfet_01v8_lvt_W14p21_L0p89_m1__nf1_gboth_sdfull_pc/B.n174 pfet_01v8_lvt_W14p21_L0p89_m1__nf1_gboth_sdfull_pc/B.n173 185
R244 pfet_01v8_lvt_W14p21_L0p89_m1__nf1_gboth_sdfull_pc/B.n43 pfet_01v8_lvt_W14p21_L0p89_m1__nf1_gboth_sdfull_pc/B.n42 185
R245 pfet_01v8_lvt_W14p21_L0p89_m1__nf1_gboth_sdfull_pc/B.n42 pfet_01v8_lvt_W14p21_L0p89_m1__nf1_gboth_sdfull_pc/B.n41 185
R246 pfet_01v8_lvt_W14p21_L0p89_m1__nf1_gboth_sdfull_pc/B.n182 pfet_01v8_lvt_W14p21_L0p89_m1__nf1_gboth_sdfull_pc/B.n181 185
R247 pfet_01v8_lvt_W14p21_L0p89_m1__nf1_gboth_sdfull_pc/B.n183 pfet_01v8_lvt_W14p21_L0p89_m1__nf1_gboth_sdfull_pc/B.n182 185
R248 pfet_01v8_lvt_W14p21_L0p89_m1__nf1_gboth_sdfull_pc/B.n40 pfet_01v8_lvt_W14p21_L0p89_m1__nf1_gboth_sdfull_pc/B.n39 185
R249 pfet_01v8_lvt_W14p21_L0p89_m1__nf1_gboth_sdfull_pc/B.n184 pfet_01v8_lvt_W14p21_L0p89_m1__nf1_gboth_sdfull_pc/B.n40 185
R250 pfet_01v8_lvt_W14p21_L0p89_m1__nf1_gboth_sdfull_pc/B.n187 pfet_01v8_lvt_W14p21_L0p89_m1__nf1_gboth_sdfull_pc/B.n186 185
R251 pfet_01v8_lvt_W14p21_L0p89_m1__nf1_gboth_sdfull_pc/B.n186 pfet_01v8_lvt_W14p21_L0p89_m1__nf1_gboth_sdfull_pc/B.n185 185
R252 pfet_01v8_lvt_W14p21_L0p89_m1__nf1_gboth_sdfull_pc/B.n35 pfet_01v8_lvt_W14p21_L0p89_m1__nf1_gboth_sdfull_pc/B.n34 185
R253 pfet_01v8_lvt_W14p21_L0p89_m1__nf1_gboth_sdfull_pc/B.n34 pfet_01v8_lvt_W14p21_L0p89_m1__nf1_gboth_sdfull_pc/B.n33 185
R254 pfet_01v8_lvt_W14p21_L0p89_m1__nf1_gboth_sdfull_pc/B.n194 pfet_01v8_lvt_W14p21_L0p89_m1__nf1_gboth_sdfull_pc/B.n193 185
R255 pfet_01v8_lvt_W14p21_L0p89_m1__nf1_gboth_sdfull_pc/B.n195 pfet_01v8_lvt_W14p21_L0p89_m1__nf1_gboth_sdfull_pc/B.n194 185
R256 pfet_01v8_lvt_W14p21_L0p89_m1__nf1_gboth_sdfull_pc/B.n32 pfet_01v8_lvt_W14p21_L0p89_m1__nf1_gboth_sdfull_pc/B.n31 185
R257 pfet_01v8_lvt_W14p21_L0p89_m1__nf1_gboth_sdfull_pc/B.n196 pfet_01v8_lvt_W14p21_L0p89_m1__nf1_gboth_sdfull_pc/B.n32 185
R258 pfet_01v8_lvt_W14p21_L0p89_m1__nf1_gboth_sdfull_pc/B.n199 pfet_01v8_lvt_W14p21_L0p89_m1__nf1_gboth_sdfull_pc/B.n198 185
R259 pfet_01v8_lvt_W14p21_L0p89_m1__nf1_gboth_sdfull_pc/B.n198 pfet_01v8_lvt_W14p21_L0p89_m1__nf1_gboth_sdfull_pc/B.n197 185
R260 pfet_01v8_lvt_W14p21_L0p89_m1__nf1_gboth_sdfull_pc/B.n27 pfet_01v8_lvt_W14p21_L0p89_m1__nf1_gboth_sdfull_pc/B.n26 185
R261 pfet_01v8_lvt_W14p21_L0p89_m1__nf1_gboth_sdfull_pc/B.n26 pfet_01v8_lvt_W14p21_L0p89_m1__nf1_gboth_sdfull_pc/B.n25 185
R262 pfet_01v8_lvt_W14p21_L0p89_m1__nf1_gboth_sdfull_pc/B.n206 pfet_01v8_lvt_W14p21_L0p89_m1__nf1_gboth_sdfull_pc/B.n205 185
R263 pfet_01v8_lvt_W14p21_L0p89_m1__nf1_gboth_sdfull_pc/B.n207 pfet_01v8_lvt_W14p21_L0p89_m1__nf1_gboth_sdfull_pc/B.n206 185
R264 pfet_01v8_lvt_W14p21_L0p89_m1__nf1_gboth_sdfull_pc/B.n24 pfet_01v8_lvt_W14p21_L0p89_m1__nf1_gboth_sdfull_pc/B.n23 185
R265 pfet_01v8_lvt_W14p21_L0p89_m1__nf1_gboth_sdfull_pc/B.n208 pfet_01v8_lvt_W14p21_L0p89_m1__nf1_gboth_sdfull_pc/B.n24 185
R266 pfet_01v8_lvt_W14p21_L0p89_m1__nf1_gboth_sdfull_pc/B.n211 pfet_01v8_lvt_W14p21_L0p89_m1__nf1_gboth_sdfull_pc/B.n210 185
R267 pfet_01v8_lvt_W14p21_L0p89_m1__nf1_gboth_sdfull_pc/B.n210 pfet_01v8_lvt_W14p21_L0p89_m1__nf1_gboth_sdfull_pc/B.n209 185
R268 pfet_01v8_lvt_W14p21_L0p89_m1__nf1_gboth_sdfull_pc/B.n19 pfet_01v8_lvt_W14p21_L0p89_m1__nf1_gboth_sdfull_pc/B.n18 185
R269 pfet_01v8_lvt_W14p21_L0p89_m1__nf1_gboth_sdfull_pc/B.n18 pfet_01v8_lvt_W14p21_L0p89_m1__nf1_gboth_sdfull_pc/B.n17 185
R270 pfet_01v8_lvt_W14p21_L0p89_m1__nf1_gboth_sdfull_pc/B.n218 pfet_01v8_lvt_W14p21_L0p89_m1__nf1_gboth_sdfull_pc/B.n217 185
R271 pfet_01v8_lvt_W14p21_L0p89_m1__nf1_gboth_sdfull_pc/B.n219 pfet_01v8_lvt_W14p21_L0p89_m1__nf1_gboth_sdfull_pc/B.n218 185
R272 pfet_01v8_lvt_W14p21_L0p89_m1__nf1_gboth_sdfull_pc/B.n16 pfet_01v8_lvt_W14p21_L0p89_m1__nf1_gboth_sdfull_pc/B.n15 185
R273 pfet_01v8_lvt_W14p21_L0p89_m1__nf1_gboth_sdfull_pc/B.n220 pfet_01v8_lvt_W14p21_L0p89_m1__nf1_gboth_sdfull_pc/B.n16 185
R274 pfet_01v8_lvt_W14p21_L0p89_m1__nf1_gboth_sdfull_pc/B.n223 pfet_01v8_lvt_W14p21_L0p89_m1__nf1_gboth_sdfull_pc/B.n222 185
R275 pfet_01v8_lvt_W14p21_L0p89_m1__nf1_gboth_sdfull_pc/B.n222 pfet_01v8_lvt_W14p21_L0p89_m1__nf1_gboth_sdfull_pc/B.n221 185
R276 pfet_01v8_lvt_W14p21_L0p89_m1__nf1_gboth_sdfull_pc/B.n11 pfet_01v8_lvt_W14p21_L0p89_m1__nf1_gboth_sdfull_pc/B.n10 185
R277 pfet_01v8_lvt_W14p21_L0p89_m1__nf1_gboth_sdfull_pc/B.n10 pfet_01v8_lvt_W14p21_L0p89_m1__nf1_gboth_sdfull_pc/B.n9 185
R278 pfet_01v8_lvt_W14p21_L0p89_m1__nf1_gboth_sdfull_pc/B.n231 pfet_01v8_lvt_W14p21_L0p89_m1__nf1_gboth_sdfull_pc/B.n230 185
R279 pfet_01v8_lvt_W14p21_L0p89_m1__nf1_gboth_sdfull_pc/B.n232 pfet_01v8_lvt_W14p21_L0p89_m1__nf1_gboth_sdfull_pc/B.n231 185
R280 pfet_01v8_lvt_W14p21_L0p89_m1__nf1_gboth_sdfull_pc/B.n7 pfet_01v8_lvt_W14p21_L0p89_m1__nf1_gboth_sdfull_pc/B.n6 185
R281 pfet_01v8_lvt_W14p21_L0p89_m1__nf1_gboth_sdfull_pc/B.n233 pfet_01v8_lvt_W14p21_L0p89_m1__nf1_gboth_sdfull_pc/B.n7 185
R282 pfet_01v8_lvt_W14p21_L0p89_m1__nf1_gboth_sdfull_pc/B.n240 pfet_01v8_lvt_W14p21_L0p89_m1__nf1_gboth_sdfull_pc/B.n239 185
R283 pfet_01v8_lvt_W14p21_L0p89_m1__nf1_gboth_sdfull_pc/B.n239 pfet_01v8_lvt_W14p21_L0p89_m1__nf1_gboth_sdfull_pc/B.n238 185
R284 pfet_01v8_lvt_W14p21_L0p89_m1__nf1_gboth_sdfull_pc/B.n240 pfet_01v8_lvt_W14p21_L0p89_m1__nf1_gboth_sdfull_pc/B.n6 113.334
R285 pfet_01v8_lvt_W14p21_L0p89_m1__nf1_gboth_sdfull_pc/B.n230 pfet_01v8_lvt_W14p21_L0p89_m1__nf1_gboth_sdfull_pc/B.n6 113.334
R286 pfet_01v8_lvt_W14p21_L0p89_m1__nf1_gboth_sdfull_pc/B.n230 pfet_01v8_lvt_W14p21_L0p89_m1__nf1_gboth_sdfull_pc/B.n11 113.334
R287 pfet_01v8_lvt_W14p21_L0p89_m1__nf1_gboth_sdfull_pc/B.n223 pfet_01v8_lvt_W14p21_L0p89_m1__nf1_gboth_sdfull_pc/B.n11 113.334
R288 pfet_01v8_lvt_W14p21_L0p89_m1__nf1_gboth_sdfull_pc/B.n223 pfet_01v8_lvt_W14p21_L0p89_m1__nf1_gboth_sdfull_pc/B.n15 113.334
R289 pfet_01v8_lvt_W14p21_L0p89_m1__nf1_gboth_sdfull_pc/B.n217 pfet_01v8_lvt_W14p21_L0p89_m1__nf1_gboth_sdfull_pc/B.n15 113.334
R290 pfet_01v8_lvt_W14p21_L0p89_m1__nf1_gboth_sdfull_pc/B.n217 pfet_01v8_lvt_W14p21_L0p89_m1__nf1_gboth_sdfull_pc/B.n19 113.334
R291 pfet_01v8_lvt_W14p21_L0p89_m1__nf1_gboth_sdfull_pc/B.n211 pfet_01v8_lvt_W14p21_L0p89_m1__nf1_gboth_sdfull_pc/B.n19 113.334
R292 pfet_01v8_lvt_W14p21_L0p89_m1__nf1_gboth_sdfull_pc/B.n211 pfet_01v8_lvt_W14p21_L0p89_m1__nf1_gboth_sdfull_pc/B.n23 113.334
R293 pfet_01v8_lvt_W14p21_L0p89_m1__nf1_gboth_sdfull_pc/B.n205 pfet_01v8_lvt_W14p21_L0p89_m1__nf1_gboth_sdfull_pc/B.n23 113.334
R294 pfet_01v8_lvt_W14p21_L0p89_m1__nf1_gboth_sdfull_pc/B.n205 pfet_01v8_lvt_W14p21_L0p89_m1__nf1_gboth_sdfull_pc/B.n27 113.334
R295 pfet_01v8_lvt_W14p21_L0p89_m1__nf1_gboth_sdfull_pc/B.n199 pfet_01v8_lvt_W14p21_L0p89_m1__nf1_gboth_sdfull_pc/B.n27 113.334
R296 pfet_01v8_lvt_W14p21_L0p89_m1__nf1_gboth_sdfull_pc/B.n199 pfet_01v8_lvt_W14p21_L0p89_m1__nf1_gboth_sdfull_pc/B.n31 113.334
R297 pfet_01v8_lvt_W14p21_L0p89_m1__nf1_gboth_sdfull_pc/B.n193 pfet_01v8_lvt_W14p21_L0p89_m1__nf1_gboth_sdfull_pc/B.n31 113.334
R298 pfet_01v8_lvt_W14p21_L0p89_m1__nf1_gboth_sdfull_pc/B.n193 pfet_01v8_lvt_W14p21_L0p89_m1__nf1_gboth_sdfull_pc/B.n35 113.334
R299 pfet_01v8_lvt_W14p21_L0p89_m1__nf1_gboth_sdfull_pc/B.n187 pfet_01v8_lvt_W14p21_L0p89_m1__nf1_gboth_sdfull_pc/B.n35 113.334
R300 pfet_01v8_lvt_W14p21_L0p89_m1__nf1_gboth_sdfull_pc/B.n187 pfet_01v8_lvt_W14p21_L0p89_m1__nf1_gboth_sdfull_pc/B.n39 113.334
R301 pfet_01v8_lvt_W14p21_L0p89_m1__nf1_gboth_sdfull_pc/B.n181 pfet_01v8_lvt_W14p21_L0p89_m1__nf1_gboth_sdfull_pc/B.n39 113.334
R302 pfet_01v8_lvt_W14p21_L0p89_m1__nf1_gboth_sdfull_pc/B.n181 pfet_01v8_lvt_W14p21_L0p89_m1__nf1_gboth_sdfull_pc/B.n43 113.334
R303 pfet_01v8_lvt_W14p21_L0p89_m1__nf1_gboth_sdfull_pc/B.n175 pfet_01v8_lvt_W14p21_L0p89_m1__nf1_gboth_sdfull_pc/B.n43 113.334
R304 pfet_01v8_lvt_W14p21_L0p89_m1__nf1_gboth_sdfull_pc/B.n175 pfet_01v8_lvt_W14p21_L0p89_m1__nf1_gboth_sdfull_pc/B.n47 113.334
R305 pfet_01v8_lvt_W14p21_L0p89_m1__nf1_gboth_sdfull_pc/B.n169 pfet_01v8_lvt_W14p21_L0p89_m1__nf1_gboth_sdfull_pc/B.n51 113.334
R306 pfet_01v8_lvt_W14p21_L0p89_m1__nf1_gboth_sdfull_pc/B.n163 pfet_01v8_lvt_W14p21_L0p89_m1__nf1_gboth_sdfull_pc/B.n51 113.334
R307 pfet_01v8_lvt_W14p21_L0p89_m1__nf1_gboth_sdfull_pc/B.n163 pfet_01v8_lvt_W14p21_L0p89_m1__nf1_gboth_sdfull_pc/B.n55 113.334
R308 pfet_01v8_lvt_W14p21_L0p89_m1__nf1_gboth_sdfull_pc/B.n157 pfet_01v8_lvt_W14p21_L0p89_m1__nf1_gboth_sdfull_pc/B.n55 113.334
R309 pfet_01v8_lvt_W14p21_L0p89_m1__nf1_gboth_sdfull_pc/B.n157 pfet_01v8_lvt_W14p21_L0p89_m1__nf1_gboth_sdfull_pc/B.n59 113.334
R310 pfet_01v8_lvt_W14p21_L0p89_m1__nf1_gboth_sdfull_pc/B.n151 pfet_01v8_lvt_W14p21_L0p89_m1__nf1_gboth_sdfull_pc/B.n59 113.334
R311 pfet_01v8_lvt_W14p21_L0p89_m1__nf1_gboth_sdfull_pc/B.n151 pfet_01v8_lvt_W14p21_L0p89_m1__nf1_gboth_sdfull_pc/B.n63 113.334
R312 pfet_01v8_lvt_W14p21_L0p89_m1__nf1_gboth_sdfull_pc/B.n145 pfet_01v8_lvt_W14p21_L0p89_m1__nf1_gboth_sdfull_pc/B.n63 113.334
R313 pfet_01v8_lvt_W14p21_L0p89_m1__nf1_gboth_sdfull_pc/B.n145 pfet_01v8_lvt_W14p21_L0p89_m1__nf1_gboth_sdfull_pc/B.n67 113.334
R314 pfet_01v8_lvt_W14p21_L0p89_m1__nf1_gboth_sdfull_pc/B.n139 pfet_01v8_lvt_W14p21_L0p89_m1__nf1_gboth_sdfull_pc/B.n67 113.334
R315 pfet_01v8_lvt_W14p21_L0p89_m1__nf1_gboth_sdfull_pc/B.n139 pfet_01v8_lvt_W14p21_L0p89_m1__nf1_gboth_sdfull_pc/B.n71 113.334
R316 pfet_01v8_lvt_W14p21_L0p89_m1__nf1_gboth_sdfull_pc/B.n133 pfet_01v8_lvt_W14p21_L0p89_m1__nf1_gboth_sdfull_pc/B.n71 113.334
R317 pfet_01v8_lvt_W14p21_L0p89_m1__nf1_gboth_sdfull_pc/B.n133 pfet_01v8_lvt_W14p21_L0p89_m1__nf1_gboth_sdfull_pc/B.n75 113.334
R318 pfet_01v8_lvt_W14p21_L0p89_m1__nf1_gboth_sdfull_pc/B.n127 pfet_01v8_lvt_W14p21_L0p89_m1__nf1_gboth_sdfull_pc/B.n75 113.334
R319 pfet_01v8_lvt_W14p21_L0p89_m1__nf1_gboth_sdfull_pc/B.n127 pfet_01v8_lvt_W14p21_L0p89_m1__nf1_gboth_sdfull_pc/B.n79 113.334
R320 pfet_01v8_lvt_W14p21_L0p89_m1__nf1_gboth_sdfull_pc/B.n121 pfet_01v8_lvt_W14p21_L0p89_m1__nf1_gboth_sdfull_pc/B.n79 113.334
R321 pfet_01v8_lvt_W14p21_L0p89_m1__nf1_gboth_sdfull_pc/B.n121 pfet_01v8_lvt_W14p21_L0p89_m1__nf1_gboth_sdfull_pc/B.n83 113.334
R322 pfet_01v8_lvt_W14p21_L0p89_m1__nf1_gboth_sdfull_pc/B.n115 pfet_01v8_lvt_W14p21_L0p89_m1__nf1_gboth_sdfull_pc/B.n83 113.334
R323 pfet_01v8_lvt_W14p21_L0p89_m1__nf1_gboth_sdfull_pc/B.n115 pfet_01v8_lvt_W14p21_L0p89_m1__nf1_gboth_sdfull_pc/B.n87 113.334
R324 pfet_01v8_lvt_W14p21_L0p89_m1__nf1_gboth_sdfull_pc/B.n109 pfet_01v8_lvt_W14p21_L0p89_m1__nf1_gboth_sdfull_pc/B.n87 113.334
R325 pfet_01v8_lvt_W14p21_L0p89_m1__nf1_gboth_sdfull_pc/B.n109 pfet_01v8_lvt_W14p21_L0p89_m1__nf1_gboth_sdfull_pc/B.n91 113.334
R326 pfet_01v8_lvt_W14p21_L0p89_m1__nf1_gboth_sdfull_pc/B.n5 pfet_01v8_lvt_W14p21_L0p89_m1__nf1_gboth_sdfull_pc/B.n1 76.8005
R327 pfet_01v8_lvt_W14p21_L0p89_m1__nf1_gboth_sdfull_pc/B.n106 pfet_01v8_lvt_W14p21_L0p89_m1__nf1_gboth_sdfull_pc/B.n105 76.8005
R328 pfet_01v8_lvt_W14p21_L0p89_m1__nf1_gboth_sdfull_pc/B.n238 pfet_01v8_lvt_W14p21_L0p89_m1__nf1_gboth_sdfull_pc/B.n237 76.8005
R329 pfet_01v8_lvt_W14p21_L0p89_m1__nf1_gboth_sdfull_pc/B.n99 pfet_01v8_lvt_W14p21_L0p89_m1__nf1_gboth_sdfull_pc/B.n89 76.8005
R330 pfet_01v8_lvt_W14p21_L0p89_m1__nf1_gboth_sdfull_pc/B.n235 pfet_01v8_lvt_W14p21_L0p89_m1__nf1_gboth_sdfull_pc/B.n234 72.7879
R331 pfet_01v8_lvt_W14p21_L0p89_m1__nf1_gboth_sdfull_pc/B.n244 pfet_01v8_lvt_W14p21_L0p89_m1__nf1_gboth_sdfull_pc/B.n243 72.7879
R332 pfet_01v8_lvt_W14p21_L0p89_m1__nf1_gboth_sdfull_pc/B.n104 pfet_01v8_lvt_W14p21_L0p89_m1__nf1_gboth_sdfull_pc/B.n103 72.7879
R333 pfet_01v8_lvt_W14p21_L0p89_m1__nf1_gboth_sdfull_pc/B.n101 pfet_01v8_lvt_W14p21_L0p89_m1__nf1_gboth_sdfull_pc/B.n96 72.7879
R334 pfet_01v8_lvt_W14p21_L0p89_m1__nf1_gboth_sdfull_pc/B.n243 pfet_01v8_lvt_W14p21_L0p89_m1__nf1_gboth_sdfull_pc/B.n242 72.7879
R335 pfet_01v8_lvt_W14p21_L0p89_m1__nf1_gboth_sdfull_pc/B.n234 pfet_01v8_lvt_W14p21_L0p89_m1__nf1_gboth_sdfull_pc/B.n2 72.7879
R336 pfet_01v8_lvt_W14p21_L0p89_m1__nf1_gboth_sdfull_pc/B.n103 pfet_01v8_lvt_W14p21_L0p89_m1__nf1_gboth_sdfull_pc/B.n94 72.7879
R337 pfet_01v8_lvt_W14p21_L0p89_m1__nf1_gboth_sdfull_pc/B.n101 pfet_01v8_lvt_W14p21_L0p89_m1__nf1_gboth_sdfull_pc/B.n100 72.7879
R338 pfet_01v8_lvt_W14p21_L0p89_m1__nf1_gboth_sdfull_pc/B.t0 pfet_01v8_lvt_W14p21_L0p89_m1__nf1_gboth_sdfull_pc/B.n47 56.6672
R339 pfet_01v8_lvt_W14p21_L0p89_m1__nf1_gboth_sdfull_pc/B.n169 pfet_01v8_lvt_W14p21_L0p89_m1__nf1_gboth_sdfull_pc/B.t0 56.6672
R340 pfet_01v8_lvt_W14p21_L0p89_m1__nf1_gboth_sdfull_pc/B.n234 pfet_01v8_lvt_W14p21_L0p89_m1__nf1_gboth_sdfull_pc/B.n3 56.1076
R341 pfet_01v8_lvt_W14p21_L0p89_m1__nf1_gboth_sdfull_pc/B.n243 pfet_01v8_lvt_W14p21_L0p89_m1__nf1_gboth_sdfull_pc/B.n3 56.1076
R342 pfet_01v8_lvt_W14p21_L0p89_m1__nf1_gboth_sdfull_pc/B.n103 pfet_01v8_lvt_W14p21_L0p89_m1__nf1_gboth_sdfull_pc/B.n102 56.1076
R343 pfet_01v8_lvt_W14p21_L0p89_m1__nf1_gboth_sdfull_pc/B.n102 pfet_01v8_lvt_W14p21_L0p89_m1__nf1_gboth_sdfull_pc/B.n101 56.1076
R344 pfet_01v8_lvt_W14p21_L0p89_m1__nf1_gboth_sdfull_pc/B.n245 pfet_01v8_lvt_W14p21_L0p89_m1__nf1_gboth_sdfull_pc/B.n1 25.6005
R345 pfet_01v8_lvt_W14p21_L0p89_m1__nf1_gboth_sdfull_pc/B.n236 pfet_01v8_lvt_W14p21_L0p89_m1__nf1_gboth_sdfull_pc/B.n0 25.6005
R346 pfet_01v8_lvt_W14p21_L0p89_m1__nf1_gboth_sdfull_pc/B.n237 pfet_01v8_lvt_W14p21_L0p89_m1__nf1_gboth_sdfull_pc/B.n236 25.6005
R347 pfet_01v8_lvt_W14p21_L0p89_m1__nf1_gboth_sdfull_pc/B.n227 pfet_01v8_lvt_W14p21_L0p89_m1__nf1_gboth_sdfull_pc/B.n5 25.6005
R348 pfet_01v8_lvt_W14p21_L0p89_m1__nf1_gboth_sdfull_pc/B.n228 pfet_01v8_lvt_W14p21_L0p89_m1__nf1_gboth_sdfull_pc/B.n227 25.6005
R349 pfet_01v8_lvt_W14p21_L0p89_m1__nf1_gboth_sdfull_pc/B.n228 pfet_01v8_lvt_W14p21_L0p89_m1__nf1_gboth_sdfull_pc/B.n226 25.6005
R350 pfet_01v8_lvt_W14p21_L0p89_m1__nf1_gboth_sdfull_pc/B.n226 pfet_01v8_lvt_W14p21_L0p89_m1__nf1_gboth_sdfull_pc/B.n225 25.6005
R351 pfet_01v8_lvt_W14p21_L0p89_m1__nf1_gboth_sdfull_pc/B.n225 pfet_01v8_lvt_W14p21_L0p89_m1__nf1_gboth_sdfull_pc/B.n13 25.6005
R352 pfet_01v8_lvt_W14p21_L0p89_m1__nf1_gboth_sdfull_pc/B.n215 pfet_01v8_lvt_W14p21_L0p89_m1__nf1_gboth_sdfull_pc/B.n13 25.6005
R353 pfet_01v8_lvt_W14p21_L0p89_m1__nf1_gboth_sdfull_pc/B.n215 pfet_01v8_lvt_W14p21_L0p89_m1__nf1_gboth_sdfull_pc/B.n214 25.6005
R354 pfet_01v8_lvt_W14p21_L0p89_m1__nf1_gboth_sdfull_pc/B.n214 pfet_01v8_lvt_W14p21_L0p89_m1__nf1_gboth_sdfull_pc/B.n213 25.6005
R355 pfet_01v8_lvt_W14p21_L0p89_m1__nf1_gboth_sdfull_pc/B.n213 pfet_01v8_lvt_W14p21_L0p89_m1__nf1_gboth_sdfull_pc/B.n21 25.6005
R356 pfet_01v8_lvt_W14p21_L0p89_m1__nf1_gboth_sdfull_pc/B.n203 pfet_01v8_lvt_W14p21_L0p89_m1__nf1_gboth_sdfull_pc/B.n21 25.6005
R357 pfet_01v8_lvt_W14p21_L0p89_m1__nf1_gboth_sdfull_pc/B.n203 pfet_01v8_lvt_W14p21_L0p89_m1__nf1_gboth_sdfull_pc/B.n202 25.6005
R358 pfet_01v8_lvt_W14p21_L0p89_m1__nf1_gboth_sdfull_pc/B.n202 pfet_01v8_lvt_W14p21_L0p89_m1__nf1_gboth_sdfull_pc/B.n201 25.6005
R359 pfet_01v8_lvt_W14p21_L0p89_m1__nf1_gboth_sdfull_pc/B.n201 pfet_01v8_lvt_W14p21_L0p89_m1__nf1_gboth_sdfull_pc/B.n29 25.6005
R360 pfet_01v8_lvt_W14p21_L0p89_m1__nf1_gboth_sdfull_pc/B.n191 pfet_01v8_lvt_W14p21_L0p89_m1__nf1_gboth_sdfull_pc/B.n29 25.6005
R361 pfet_01v8_lvt_W14p21_L0p89_m1__nf1_gboth_sdfull_pc/B.n191 pfet_01v8_lvt_W14p21_L0p89_m1__nf1_gboth_sdfull_pc/B.n190 25.6005
R362 pfet_01v8_lvt_W14p21_L0p89_m1__nf1_gboth_sdfull_pc/B.n190 pfet_01v8_lvt_W14p21_L0p89_m1__nf1_gboth_sdfull_pc/B.n189 25.6005
R363 pfet_01v8_lvt_W14p21_L0p89_m1__nf1_gboth_sdfull_pc/B.n189 pfet_01v8_lvt_W14p21_L0p89_m1__nf1_gboth_sdfull_pc/B.n37 25.6005
R364 pfet_01v8_lvt_W14p21_L0p89_m1__nf1_gboth_sdfull_pc/B.n179 pfet_01v8_lvt_W14p21_L0p89_m1__nf1_gboth_sdfull_pc/B.n37 25.6005
R365 pfet_01v8_lvt_W14p21_L0p89_m1__nf1_gboth_sdfull_pc/B.n179 pfet_01v8_lvt_W14p21_L0p89_m1__nf1_gboth_sdfull_pc/B.n178 25.6005
R366 pfet_01v8_lvt_W14p21_L0p89_m1__nf1_gboth_sdfull_pc/B.n178 pfet_01v8_lvt_W14p21_L0p89_m1__nf1_gboth_sdfull_pc/B.n177 25.6005
R367 pfet_01v8_lvt_W14p21_L0p89_m1__nf1_gboth_sdfull_pc/B.n177 pfet_01v8_lvt_W14p21_L0p89_m1__nf1_gboth_sdfull_pc/B.n45 25.6005
R368 pfet_01v8_lvt_W14p21_L0p89_m1__nf1_gboth_sdfull_pc/B.n167 pfet_01v8_lvt_W14p21_L0p89_m1__nf1_gboth_sdfull_pc/B.n45 25.6005
R369 pfet_01v8_lvt_W14p21_L0p89_m1__nf1_gboth_sdfull_pc/B.n167 pfet_01v8_lvt_W14p21_L0p89_m1__nf1_gboth_sdfull_pc/B.n166 25.6005
R370 pfet_01v8_lvt_W14p21_L0p89_m1__nf1_gboth_sdfull_pc/B.n166 pfet_01v8_lvt_W14p21_L0p89_m1__nf1_gboth_sdfull_pc/B.n165 25.6005
R371 pfet_01v8_lvt_W14p21_L0p89_m1__nf1_gboth_sdfull_pc/B.n165 pfet_01v8_lvt_W14p21_L0p89_m1__nf1_gboth_sdfull_pc/B.n53 25.6005
R372 pfet_01v8_lvt_W14p21_L0p89_m1__nf1_gboth_sdfull_pc/B.n155 pfet_01v8_lvt_W14p21_L0p89_m1__nf1_gboth_sdfull_pc/B.n53 25.6005
R373 pfet_01v8_lvt_W14p21_L0p89_m1__nf1_gboth_sdfull_pc/B.n155 pfet_01v8_lvt_W14p21_L0p89_m1__nf1_gboth_sdfull_pc/B.n154 25.6005
R374 pfet_01v8_lvt_W14p21_L0p89_m1__nf1_gboth_sdfull_pc/B.n154 pfet_01v8_lvt_W14p21_L0p89_m1__nf1_gboth_sdfull_pc/B.n153 25.6005
R375 pfet_01v8_lvt_W14p21_L0p89_m1__nf1_gboth_sdfull_pc/B.n153 pfet_01v8_lvt_W14p21_L0p89_m1__nf1_gboth_sdfull_pc/B.n61 25.6005
R376 pfet_01v8_lvt_W14p21_L0p89_m1__nf1_gboth_sdfull_pc/B.n143 pfet_01v8_lvt_W14p21_L0p89_m1__nf1_gboth_sdfull_pc/B.n61 25.6005
R377 pfet_01v8_lvt_W14p21_L0p89_m1__nf1_gboth_sdfull_pc/B.n143 pfet_01v8_lvt_W14p21_L0p89_m1__nf1_gboth_sdfull_pc/B.n142 25.6005
R378 pfet_01v8_lvt_W14p21_L0p89_m1__nf1_gboth_sdfull_pc/B.n142 pfet_01v8_lvt_W14p21_L0p89_m1__nf1_gboth_sdfull_pc/B.n141 25.6005
R379 pfet_01v8_lvt_W14p21_L0p89_m1__nf1_gboth_sdfull_pc/B.n141 pfet_01v8_lvt_W14p21_L0p89_m1__nf1_gboth_sdfull_pc/B.n69 25.6005
R380 pfet_01v8_lvt_W14p21_L0p89_m1__nf1_gboth_sdfull_pc/B.n131 pfet_01v8_lvt_W14p21_L0p89_m1__nf1_gboth_sdfull_pc/B.n69 25.6005
R381 pfet_01v8_lvt_W14p21_L0p89_m1__nf1_gboth_sdfull_pc/B.n131 pfet_01v8_lvt_W14p21_L0p89_m1__nf1_gboth_sdfull_pc/B.n130 25.6005
R382 pfet_01v8_lvt_W14p21_L0p89_m1__nf1_gboth_sdfull_pc/B.n130 pfet_01v8_lvt_W14p21_L0p89_m1__nf1_gboth_sdfull_pc/B.n129 25.6005
R383 pfet_01v8_lvt_W14p21_L0p89_m1__nf1_gboth_sdfull_pc/B.n129 pfet_01v8_lvt_W14p21_L0p89_m1__nf1_gboth_sdfull_pc/B.n77 25.6005
R384 pfet_01v8_lvt_W14p21_L0p89_m1__nf1_gboth_sdfull_pc/B.n119 pfet_01v8_lvt_W14p21_L0p89_m1__nf1_gboth_sdfull_pc/B.n77 25.6005
R385 pfet_01v8_lvt_W14p21_L0p89_m1__nf1_gboth_sdfull_pc/B.n119 pfet_01v8_lvt_W14p21_L0p89_m1__nf1_gboth_sdfull_pc/B.n118 25.6005
R386 pfet_01v8_lvt_W14p21_L0p89_m1__nf1_gboth_sdfull_pc/B.n118 pfet_01v8_lvt_W14p21_L0p89_m1__nf1_gboth_sdfull_pc/B.n117 25.6005
R387 pfet_01v8_lvt_W14p21_L0p89_m1__nf1_gboth_sdfull_pc/B.n117 pfet_01v8_lvt_W14p21_L0p89_m1__nf1_gboth_sdfull_pc/B.n85 25.6005
R388 pfet_01v8_lvt_W14p21_L0p89_m1__nf1_gboth_sdfull_pc/B.n107 pfet_01v8_lvt_W14p21_L0p89_m1__nf1_gboth_sdfull_pc/B.n85 25.6005
R389 pfet_01v8_lvt_W14p21_L0p89_m1__nf1_gboth_sdfull_pc/B.n107 pfet_01v8_lvt_W14p21_L0p89_m1__nf1_gboth_sdfull_pc/B.n106 25.6005
R390 pfet_01v8_lvt_W14p21_L0p89_m1__nf1_gboth_sdfull_pc/B.n105 pfet_01v8_lvt_W14p21_L0p89_m1__nf1_gboth_sdfull_pc/B.n93 25.6005
R391 pfet_01v8_lvt_W14p21_L0p89_m1__nf1_gboth_sdfull_pc/B.n97 pfet_01v8_lvt_W14p21_L0p89_m1__nf1_gboth_sdfull_pc/B.n93 25.6005
R392 pfet_01v8_lvt_W14p21_L0p89_m1__nf1_gboth_sdfull_pc/B.n98 pfet_01v8_lvt_W14p21_L0p89_m1__nf1_gboth_sdfull_pc/B.n97 25.6005
R393 pfet_01v8_lvt_W14p21_L0p89_m1__nf1_gboth_sdfull_pc/B.n99 pfet_01v8_lvt_W14p21_L0p89_m1__nf1_gboth_sdfull_pc/B.n98 25.6005
R394 pfet_01v8_lvt_W14p21_L0p89_m1__nf1_gboth_sdfull_pc/B.n238 pfet_01v8_lvt_W14p21_L0p89_m1__nf1_gboth_sdfull_pc/B.n233 25.6005
R395 pfet_01v8_lvt_W14p21_L0p89_m1__nf1_gboth_sdfull_pc/B.n233 pfet_01v8_lvt_W14p21_L0p89_m1__nf1_gboth_sdfull_pc/B.n232 25.6005
R396 pfet_01v8_lvt_W14p21_L0p89_m1__nf1_gboth_sdfull_pc/B.n232 pfet_01v8_lvt_W14p21_L0p89_m1__nf1_gboth_sdfull_pc/B.n9 25.6005
R397 pfet_01v8_lvt_W14p21_L0p89_m1__nf1_gboth_sdfull_pc/B.n221 pfet_01v8_lvt_W14p21_L0p89_m1__nf1_gboth_sdfull_pc/B.n9 25.6005
R398 pfet_01v8_lvt_W14p21_L0p89_m1__nf1_gboth_sdfull_pc/B.n221 pfet_01v8_lvt_W14p21_L0p89_m1__nf1_gboth_sdfull_pc/B.n220 25.6005
R399 pfet_01v8_lvt_W14p21_L0p89_m1__nf1_gboth_sdfull_pc/B.n220 pfet_01v8_lvt_W14p21_L0p89_m1__nf1_gboth_sdfull_pc/B.n219 25.6005
R400 pfet_01v8_lvt_W14p21_L0p89_m1__nf1_gboth_sdfull_pc/B.n219 pfet_01v8_lvt_W14p21_L0p89_m1__nf1_gboth_sdfull_pc/B.n17 25.6005
R401 pfet_01v8_lvt_W14p21_L0p89_m1__nf1_gboth_sdfull_pc/B.n209 pfet_01v8_lvt_W14p21_L0p89_m1__nf1_gboth_sdfull_pc/B.n17 25.6005
R402 pfet_01v8_lvt_W14p21_L0p89_m1__nf1_gboth_sdfull_pc/B.n209 pfet_01v8_lvt_W14p21_L0p89_m1__nf1_gboth_sdfull_pc/B.n208 25.6005
R403 pfet_01v8_lvt_W14p21_L0p89_m1__nf1_gboth_sdfull_pc/B.n208 pfet_01v8_lvt_W14p21_L0p89_m1__nf1_gboth_sdfull_pc/B.n207 25.6005
R404 pfet_01v8_lvt_W14p21_L0p89_m1__nf1_gboth_sdfull_pc/B.n207 pfet_01v8_lvt_W14p21_L0p89_m1__nf1_gboth_sdfull_pc/B.n25 25.6005
R405 pfet_01v8_lvt_W14p21_L0p89_m1__nf1_gboth_sdfull_pc/B.n197 pfet_01v8_lvt_W14p21_L0p89_m1__nf1_gboth_sdfull_pc/B.n25 25.6005
R406 pfet_01v8_lvt_W14p21_L0p89_m1__nf1_gboth_sdfull_pc/B.n197 pfet_01v8_lvt_W14p21_L0p89_m1__nf1_gboth_sdfull_pc/B.n196 25.6005
R407 pfet_01v8_lvt_W14p21_L0p89_m1__nf1_gboth_sdfull_pc/B.n196 pfet_01v8_lvt_W14p21_L0p89_m1__nf1_gboth_sdfull_pc/B.n195 25.6005
R408 pfet_01v8_lvt_W14p21_L0p89_m1__nf1_gboth_sdfull_pc/B.n195 pfet_01v8_lvt_W14p21_L0p89_m1__nf1_gboth_sdfull_pc/B.n33 25.6005
R409 pfet_01v8_lvt_W14p21_L0p89_m1__nf1_gboth_sdfull_pc/B.n185 pfet_01v8_lvt_W14p21_L0p89_m1__nf1_gboth_sdfull_pc/B.n33 25.6005
R410 pfet_01v8_lvt_W14p21_L0p89_m1__nf1_gboth_sdfull_pc/B.n185 pfet_01v8_lvt_W14p21_L0p89_m1__nf1_gboth_sdfull_pc/B.n184 25.6005
R411 pfet_01v8_lvt_W14p21_L0p89_m1__nf1_gboth_sdfull_pc/B.n184 pfet_01v8_lvt_W14p21_L0p89_m1__nf1_gboth_sdfull_pc/B.n183 25.6005
R412 pfet_01v8_lvt_W14p21_L0p89_m1__nf1_gboth_sdfull_pc/B.n183 pfet_01v8_lvt_W14p21_L0p89_m1__nf1_gboth_sdfull_pc/B.n41 25.6005
R413 pfet_01v8_lvt_W14p21_L0p89_m1__nf1_gboth_sdfull_pc/B.n173 pfet_01v8_lvt_W14p21_L0p89_m1__nf1_gboth_sdfull_pc/B.n41 25.6005
R414 pfet_01v8_lvt_W14p21_L0p89_m1__nf1_gboth_sdfull_pc/B.n173 pfet_01v8_lvt_W14p21_L0p89_m1__nf1_gboth_sdfull_pc/B.n172 25.6005
R415 pfet_01v8_lvt_W14p21_L0p89_m1__nf1_gboth_sdfull_pc/B.n172 pfet_01v8_lvt_W14p21_L0p89_m1__nf1_gboth_sdfull_pc/B.n171 25.6005
R416 pfet_01v8_lvt_W14p21_L0p89_m1__nf1_gboth_sdfull_pc/B.n171 pfet_01v8_lvt_W14p21_L0p89_m1__nf1_gboth_sdfull_pc/B.n49 25.6005
R417 pfet_01v8_lvt_W14p21_L0p89_m1__nf1_gboth_sdfull_pc/B.n161 pfet_01v8_lvt_W14p21_L0p89_m1__nf1_gboth_sdfull_pc/B.n49 25.6005
R418 pfet_01v8_lvt_W14p21_L0p89_m1__nf1_gboth_sdfull_pc/B.n161 pfet_01v8_lvt_W14p21_L0p89_m1__nf1_gboth_sdfull_pc/B.n160 25.6005
R419 pfet_01v8_lvt_W14p21_L0p89_m1__nf1_gboth_sdfull_pc/B.n160 pfet_01v8_lvt_W14p21_L0p89_m1__nf1_gboth_sdfull_pc/B.n159 25.6005
R420 pfet_01v8_lvt_W14p21_L0p89_m1__nf1_gboth_sdfull_pc/B.n159 pfet_01v8_lvt_W14p21_L0p89_m1__nf1_gboth_sdfull_pc/B.n57 25.6005
R421 pfet_01v8_lvt_W14p21_L0p89_m1__nf1_gboth_sdfull_pc/B.n149 pfet_01v8_lvt_W14p21_L0p89_m1__nf1_gboth_sdfull_pc/B.n57 25.6005
R422 pfet_01v8_lvt_W14p21_L0p89_m1__nf1_gboth_sdfull_pc/B.n149 pfet_01v8_lvt_W14p21_L0p89_m1__nf1_gboth_sdfull_pc/B.n148 25.6005
R423 pfet_01v8_lvt_W14p21_L0p89_m1__nf1_gboth_sdfull_pc/B.n148 pfet_01v8_lvt_W14p21_L0p89_m1__nf1_gboth_sdfull_pc/B.n147 25.6005
R424 pfet_01v8_lvt_W14p21_L0p89_m1__nf1_gboth_sdfull_pc/B.n147 pfet_01v8_lvt_W14p21_L0p89_m1__nf1_gboth_sdfull_pc/B.n65 25.6005
R425 pfet_01v8_lvt_W14p21_L0p89_m1__nf1_gboth_sdfull_pc/B.n137 pfet_01v8_lvt_W14p21_L0p89_m1__nf1_gboth_sdfull_pc/B.n65 25.6005
R426 pfet_01v8_lvt_W14p21_L0p89_m1__nf1_gboth_sdfull_pc/B.n137 pfet_01v8_lvt_W14p21_L0p89_m1__nf1_gboth_sdfull_pc/B.n136 25.6005
R427 pfet_01v8_lvt_W14p21_L0p89_m1__nf1_gboth_sdfull_pc/B.n136 pfet_01v8_lvt_W14p21_L0p89_m1__nf1_gboth_sdfull_pc/B.n135 25.6005
R428 pfet_01v8_lvt_W14p21_L0p89_m1__nf1_gboth_sdfull_pc/B.n135 pfet_01v8_lvt_W14p21_L0p89_m1__nf1_gboth_sdfull_pc/B.n73 25.6005
R429 pfet_01v8_lvt_W14p21_L0p89_m1__nf1_gboth_sdfull_pc/B.n125 pfet_01v8_lvt_W14p21_L0p89_m1__nf1_gboth_sdfull_pc/B.n73 25.6005
R430 pfet_01v8_lvt_W14p21_L0p89_m1__nf1_gboth_sdfull_pc/B.n125 pfet_01v8_lvt_W14p21_L0p89_m1__nf1_gboth_sdfull_pc/B.n124 25.6005
R431 pfet_01v8_lvt_W14p21_L0p89_m1__nf1_gboth_sdfull_pc/B.n124 pfet_01v8_lvt_W14p21_L0p89_m1__nf1_gboth_sdfull_pc/B.n123 25.6005
R432 pfet_01v8_lvt_W14p21_L0p89_m1__nf1_gboth_sdfull_pc/B.n123 pfet_01v8_lvt_W14p21_L0p89_m1__nf1_gboth_sdfull_pc/B.n81 25.6005
R433 pfet_01v8_lvt_W14p21_L0p89_m1__nf1_gboth_sdfull_pc/B.n113 pfet_01v8_lvt_W14p21_L0p89_m1__nf1_gboth_sdfull_pc/B.n81 25.6005
R434 pfet_01v8_lvt_W14p21_L0p89_m1__nf1_gboth_sdfull_pc/B.n113 pfet_01v8_lvt_W14p21_L0p89_m1__nf1_gboth_sdfull_pc/B.n112 25.6005
R435 pfet_01v8_lvt_W14p21_L0p89_m1__nf1_gboth_sdfull_pc/B.n112 pfet_01v8_lvt_W14p21_L0p89_m1__nf1_gboth_sdfull_pc/B.n111 25.6005
R436 pfet_01v8_lvt_W14p21_L0p89_m1__nf1_gboth_sdfull_pc/B.n111 pfet_01v8_lvt_W14p21_L0p89_m1__nf1_gboth_sdfull_pc/B.n89 25.6005
R437 B pfet_01v8_lvt_W14p21_L0p89_m1__nf1_gboth_sdfull_pc/B.n245 19.2005
R438 B pfet_01v8_lvt_W14p21_L0p89_m1__nf1_gboth_sdfull_pc/B.n0 6.4005
R439 B.n239 B.n8 720
R440 B.n242 B.n241 720
R441 B.n104 B.n92 720
R442 B.n97 B.n90 720
R443 B.n239 B.n7 240
R444 B.n231 B.n7 240
R445 B.n231 B.n10 240
R446 B.n222 B.n10 240
R447 B.n222 B.n16 240
R448 B.n218 B.n16 240
R449 B.n218 B.n18 240
R450 B.n210 B.n18 240
R451 B.n210 B.n24 240
R452 B.n206 B.n24 240
R453 B.n206 B.n26 240
R454 B.n198 B.n26 240
R455 B.n198 B.n32 240
R456 B.n194 B.n32 240
R457 B.n194 B.n34 240
R458 B.n186 B.n34 240
R459 B.n186 B.n40 240
R460 B.n182 B.n40 240
R461 B.n182 B.n42 240
R462 B.n174 B.n42 240
R463 B.n174 B.n48 240
R464 B.n170 B.n48 240
R465 B.n170 B.n50 240
R466 B.n162 B.n50 240
R467 B.n162 B.n56 240
R468 B.n158 B.n56 240
R469 B.n158 B.n58 240
R470 B.n150 B.n58 240
R471 B.n150 B.n64 240
R472 B.n146 B.n64 240
R473 B.n146 B.n66 240
R474 B.n138 B.n66 240
R475 B.n138 B.n72 240
R476 B.n134 B.n72 240
R477 B.n134 B.n74 240
R478 B.n126 B.n74 240
R479 B.n126 B.n80 240
R480 B.n122 B.n80 240
R481 B.n122 B.n82 240
R482 B.n114 B.n82 240
R483 B.n114 B.n88 240
R484 B.n110 B.n88 240
R485 B.n110 B.n90 240
R486 B.n244 B.n2 240
R487 B.n235 B.n8 240
R488 B.n241 B.n4 240
R489 B.n229 B.n4 240
R490 B.n229 B.n12 240
R491 B.n224 B.n12 240
R492 B.n224 B.n14 240
R493 B.n216 B.n14 240
R494 B.n216 B.n20 240
R495 B.n212 B.n20 240
R496 B.n212 B.n22 240
R497 B.n204 B.n22 240
R498 B.n204 B.n28 240
R499 B.n200 B.n28 240
R500 B.n200 B.n30 240
R501 B.n192 B.n30 240
R502 B.n192 B.n36 240
R503 B.n188 B.n36 240
R504 B.n188 B.n38 240
R505 B.n180 B.n38 240
R506 B.n180 B.n44 240
R507 B.n176 B.n44 240
R508 B.n176 B.n46 240
R509 B.n168 B.n46 240
R510 B.n168 B.n52 240
R511 B.n164 B.n52 240
R512 B.n164 B.n54 240
R513 B.n156 B.n54 240
R514 B.n156 B.n60 240
R515 B.n152 B.n60 240
R516 B.n152 B.n62 240
R517 B.n144 B.n62 240
R518 B.n144 B.n68 240
R519 B.n140 B.n68 240
R520 B.n140 B.n70 240
R521 B.n132 B.n70 240
R522 B.n132 B.n76 240
R523 B.n128 B.n76 240
R524 B.n128 B.n78 240
R525 B.n120 B.n78 240
R526 B.n120 B.n84 240
R527 B.n116 B.n84 240
R528 B.n116 B.n86 240
R529 B.n108 B.n86 240
R530 B.n108 B.n92 240
R531 B.n104 B.n94 240
R532 B.n101 B.n96 240
R533 B.n240 B.n3 208.333
R534 B.n103 B.n91 208.333
R535 B.n8 B.n3 185
R536 B.n237 B.n8 185
R537 B.n236 B.n235 185
R538 B.n2 B.n0 185
R539 B.n245 B.n244 185
R540 B.n242 B.n1 185
R541 B.n241 B.n240 185
R542 B.n241 B.n5 185
R543 B.n6 B.n4 185
R544 B.n227 B.n4 185
R545 B.n230 B.n229 185
R546 B.n229 B.n228 185
R547 B.n12 B.n11 185
R548 B.n226 B.n12 185
R549 B.n224 B.n223 185
R550 B.n225 B.n224 185
R551 B.n15 B.n14 185
R552 B.n14 B.n13 185
R553 B.n217 B.n216 185
R554 B.n216 B.n215 185
R555 B.n20 B.n19 185
R556 B.n214 B.n20 185
R557 B.n212 B.n211 185
R558 B.n213 B.n212 185
R559 B.n23 B.n22 185
R560 B.n22 B.n21 185
R561 B.n205 B.n204 185
R562 B.n204 B.n203 185
R563 B.n28 B.n27 185
R564 B.n202 B.n28 185
R565 B.n200 B.n199 185
R566 B.n201 B.n200 185
R567 B.n31 B.n30 185
R568 B.n30 B.n29 185
R569 B.n193 B.n192 185
R570 B.n192 B.n191 185
R571 B.n36 B.n35 185
R572 B.n190 B.n36 185
R573 B.n188 B.n187 185
R574 B.n189 B.n188 185
R575 B.n39 B.n38 185
R576 B.n38 B.n37 185
R577 B.n181 B.n180 185
R578 B.n180 B.n179 185
R579 B.n44 B.n43 185
R580 B.n178 B.n44 185
R581 B.n176 B.n175 185
R582 B.n177 B.n176 185
R583 B.n47 B.n46 185
R584 B.n46 B.n45 185
R585 B.n169 B.n168 185
R586 B.n168 B.n167 185
R587 B.n52 B.n51 185
R588 B.n166 B.n52 185
R589 B.n164 B.n163 185
R590 B.n165 B.n164 185
R591 B.n55 B.n54 185
R592 B.n54 B.n53 185
R593 B.n157 B.n156 185
R594 B.n156 B.n155 185
R595 B.n60 B.n59 185
R596 B.n154 B.n60 185
R597 B.n152 B.n151 185
R598 B.n153 B.n152 185
R599 B.n63 B.n62 185
R600 B.n62 B.n61 185
R601 B.n145 B.n144 185
R602 B.n144 B.n143 185
R603 B.n68 B.n67 185
R604 B.n142 B.n68 185
R605 B.n140 B.n139 185
R606 B.n141 B.n140 185
R607 B.n71 B.n70 185
R608 B.n70 B.n69 185
R609 B.n133 B.n132 185
R610 B.n132 B.n131 185
R611 B.n76 B.n75 185
R612 B.n130 B.n76 185
R613 B.n128 B.n127 185
R614 B.n129 B.n128 185
R615 B.n79 B.n78 185
R616 B.n78 B.n77 185
R617 B.n121 B.n120 185
R618 B.n120 B.n119 185
R619 B.n84 B.n83 185
R620 B.n118 B.n84 185
R621 B.n116 B.n115 185
R622 B.n117 B.n116 185
R623 B.n87 B.n86 185
R624 B.n86 B.n85 185
R625 B.n109 B.n108 185
R626 B.n108 B.n107 185
R627 B.n92 B.n91 185
R628 B.n106 B.n92 185
R629 B.n104 B.n103 185
R630 B.n105 B.n104 185
R631 B.n94 B.n93 185
R632 B.n101 B.n100 185
R633 B.n99 B.n96 185
R634 B.n98 B.n97 185
R635 B.n91 B.n90 185
R636 B.n90 B.n89 185
R637 B.n110 B.n109 185
R638 B.n111 B.n110 185
R639 B.n88 B.n87 185
R640 B.n112 B.n88 185
R641 B.n115 B.n114 185
R642 B.n114 B.n113 185
R643 B.n83 B.n82 185
R644 B.n82 B.n81 185
R645 B.n122 B.n121 185
R646 B.n123 B.n122 185
R647 B.n80 B.n79 185
R648 B.n124 B.n80 185
R649 B.n127 B.n126 185
R650 B.n126 B.n125 185
R651 B.n75 B.n74 185
R652 B.n74 B.n73 185
R653 B.n134 B.n133 185
R654 B.n135 B.n134 185
R655 B.n72 B.n71 185
R656 B.n136 B.n72 185
R657 B.n139 B.n138 185
R658 B.n138 B.n137 185
R659 B.n67 B.n66 185
R660 B.n66 B.n65 185
R661 B.n146 B.n145 185
R662 B.n147 B.n146 185
R663 B.n64 B.n63 185
R664 B.n148 B.n64 185
R665 B.n151 B.n150 185
R666 B.n150 B.n149 185
R667 B.n59 B.n58 185
R668 B.n58 B.n57 185
R669 B.n158 B.n157 185
R670 B.n159 B.n158 185
R671 B.n56 B.n55 185
R672 B.n160 B.n56 185
R673 B.n163 B.n162 185
R674 B.n162 B.n161 185
R675 B.n51 B.n50 185
R676 B.n50 B.n49 185
R677 B.n170 B.n169 185
R678 B.n171 B.n170 185
R679 B.n48 B.n47 185
R680 B.n172 B.n48 185
R681 B.n175 B.n174 185
R682 B.n174 B.n173 185
R683 B.n43 B.n42 185
R684 B.n42 B.n41 185
R685 B.n182 B.n181 185
R686 B.n183 B.n182 185
R687 B.n40 B.n39 185
R688 B.n184 B.n40 185
R689 B.n187 B.n186 185
R690 B.n186 B.n185 185
R691 B.n35 B.n34 185
R692 B.n34 B.n33 185
R693 B.n194 B.n193 185
R694 B.n195 B.n194 185
R695 B.n32 B.n31 185
R696 B.n196 B.n32 185
R697 B.n199 B.n198 185
R698 B.n198 B.n197 185
R699 B.n27 B.n26 185
R700 B.n26 B.n25 185
R701 B.n206 B.n205 185
R702 B.n207 B.n206 185
R703 B.n24 B.n23 185
R704 B.n208 B.n24 185
R705 B.n211 B.n210 185
R706 B.n210 B.n209 185
R707 B.n19 B.n18 185
R708 B.n18 B.n17 185
R709 B.n218 B.n217 185
R710 B.n219 B.n218 185
R711 B.n16 B.n15 185
R712 B.n220 B.n16 185
R713 B.n223 B.n222 185
R714 B.n222 B.n221 185
R715 B.n11 B.n10 185
R716 B.n10 B.n9 185
R717 B.n231 B.n230 185
R718 B.n232 B.n231 185
R719 B.n7 B.n6 185
R720 B.n233 B.n7 185
R721 B.n240 B.n239 185
R722 B.n239 B.n238 185
R723 B.n240 B.n6 113.334
R724 B.n230 B.n6 113.334
R725 B.n230 B.n11 113.334
R726 B.n223 B.n11 113.334
R727 B.n223 B.n15 113.334
R728 B.n217 B.n15 113.334
R729 B.n217 B.n19 113.334
R730 B.n211 B.n19 113.334
R731 B.n211 B.n23 113.334
R732 B.n205 B.n23 113.334
R733 B.n205 B.n27 113.334
R734 B.n199 B.n27 113.334
R735 B.n199 B.n31 113.334
R736 B.n193 B.n31 113.334
R737 B.n193 B.n35 113.334
R738 B.n187 B.n35 113.334
R739 B.n187 B.n39 113.334
R740 B.n181 B.n39 113.334
R741 B.n181 B.n43 113.334
R742 B.n175 B.n43 113.334
R743 B.n175 B.n47 113.334
R744 B.n169 B.n47 113.334
R745 B.n169 B.n51 113.334
R746 B.n163 B.n51 113.334
R747 B.n163 B.n55 113.334
R748 B.n157 B.n55 113.334
R749 B.n157 B.n59 113.334
R750 B.n151 B.n59 113.334
R751 B.n151 B.n63 113.334
R752 B.n145 B.n63 113.334
R753 B.n145 B.n67 113.334
R754 B.n139 B.n67 113.334
R755 B.n139 B.n71 113.334
R756 B.n133 B.n71 113.334
R757 B.n133 B.n75 113.334
R758 B.n127 B.n75 113.334
R759 B.n127 B.n79 113.334
R760 B.n121 B.n79 113.334
R761 B.n121 B.n83 113.334
R762 B.n115 B.n83 113.334
R763 B.n115 B.n87 113.334
R764 B.n109 B.n87 113.334
R765 B.n109 B.n91 113.334
R766 B.n5 B.n1 76.8005
R767 B.n106 B.n105 76.8005
R768 B.n238 B.n237 76.8005
R769 B.n98 B.n89 76.8005
R770 B.n235 B.n234 72.7879
R771 B.n244 B.n243 72.7879
R772 B.n102 B.n94 72.7879
R773 B.n96 B.n95 72.7879
R774 B.n243 B.n242 72.7879
R775 B.n234 B.n2 72.7879
R776 B.n102 B.n101 72.7879
R777 B.n97 B.n95 72.7879
R778 B.n234 B.n3 56.1076
R779 B.n243 B.n3 56.1076
R780 B.n103 B.n102 56.1076
R781 B.n103 B.n95 56.1076
R782 B.n245 B.n1 25.6005
R783 B.n236 B.n0 25.6005
R784 B.n237 B.n236 25.6005
R785 B.n227 B.n5 25.6005
R786 B.n228 B.n227 25.6005
R787 B.n228 B.n226 25.6005
R788 B.n226 B.n225 25.6005
R789 B.n225 B.n13 25.6005
R790 B.n215 B.n13 25.6005
R791 B.n215 B.n214 25.6005
R792 B.n214 B.n213 25.6005
R793 B.n213 B.n21 25.6005
R794 B.n203 B.n21 25.6005
R795 B.n203 B.n202 25.6005
R796 B.n202 B.n201 25.6005
R797 B.n201 B.n29 25.6005
R798 B.n191 B.n29 25.6005
R799 B.n191 B.n190 25.6005
R800 B.n190 B.n189 25.6005
R801 B.n189 B.n37 25.6005
R802 B.n179 B.n37 25.6005
R803 B.n179 B.n178 25.6005
R804 B.n178 B.n177 25.6005
R805 B.n177 B.n45 25.6005
R806 B.n167 B.n45 25.6005
R807 B.n167 B.n166 25.6005
R808 B.n166 B.n165 25.6005
R809 B.n165 B.n53 25.6005
R810 B.n155 B.n53 25.6005
R811 B.n155 B.n154 25.6005
R812 B.n154 B.n153 25.6005
R813 B.n153 B.n61 25.6005
R814 B.n143 B.n61 25.6005
R815 B.n143 B.n142 25.6005
R816 B.n142 B.n141 25.6005
R817 B.n141 B.n69 25.6005
R818 B.n131 B.n69 25.6005
R819 B.n131 B.n130 25.6005
R820 B.n130 B.n129 25.6005
R821 B.n129 B.n77 25.6005
R822 B.n119 B.n77 25.6005
R823 B.n119 B.n118 25.6005
R824 B.n118 B.n117 25.6005
R825 B.n117 B.n85 25.6005
R826 B.n107 B.n85 25.6005
R827 B.n107 B.n106 25.6005
R828 B.n105 B.n93 25.6005
R829 B.n100 B.n93 25.6005
R830 B.n100 B.n99 25.6005
R831 B.n99 B.n98 25.6005
R832 B.n238 B.n233 25.6005
R833 B.n233 B.n232 25.6005
R834 B.n232 B.n9 25.6005
R835 B.n221 B.n9 25.6005
R836 B.n221 B.n220 25.6005
R837 B.n220 B.n219 25.6005
R838 B.n219 B.n17 25.6005
R839 B.n209 B.n17 25.6005
R840 B.n209 B.n208 25.6005
R841 B.n208 B.n207 25.6005
R842 B.n207 B.n25 25.6005
R843 B.n197 B.n25 25.6005
R844 B.n197 B.n196 25.6005
R845 B.n196 B.n195 25.6005
R846 B.n195 B.n33 25.6005
R847 B.n185 B.n33 25.6005
R848 B.n185 B.n184 25.6005
R849 B.n184 B.n183 25.6005
R850 B.n183 B.n41 25.6005
R851 B.n173 B.n41 25.6005
R852 B.n173 B.n172 25.6005
R853 B.n172 B.n171 25.6005
R854 B.n171 B.n49 25.6005
R855 B.n161 B.n49 25.6005
R856 B.n161 B.n160 25.6005
R857 B.n160 B.n159 25.6005
R858 B.n159 B.n57 25.6005
R859 B.n149 B.n57 25.6005
R860 B.n149 B.n148 25.6005
R861 B.n148 B.n147 25.6005
R862 B.n147 B.n65 25.6005
R863 B.n137 B.n65 25.6005
R864 B.n137 B.n136 25.6005
R865 B.n136 B.n135 25.6005
R866 B.n135 B.n73 25.6005
R867 B.n125 B.n73 25.6005
R868 B.n125 B.n124 25.6005
R869 B.n124 B.n123 25.6005
R870 B.n123 B.n81 25.6005
R871 B.n113 B.n81 25.6005
R872 B.n113 B.n112 25.6005
R873 B.n112 B.n111 25.6005
R874 B.n111 B.n89 25.6005
R875 B B.n245 19.2005
R876 B B.n0 6.4005
C6 S VSUBS 0.38764f
C7 D VSUBS 0.38764f
C8 G VSUBS 0.16759f
C9 B VSUBS 6.94238f
C10 pfet_01v8_lvt_W14p21_L0p89_m1__nf1_gboth_sdfull_pc/B.n0 VSUBS 0.00129f ; **FLOATING
C11 pfet_01v8_lvt_W14p21_L0p89_m1__nf1_gboth_sdfull_pc/B.n1 VSUBS 0.0044f ; **FLOATING
C12 pfet_01v8_lvt_W14p21_L0p89_m1__nf1_gboth_sdfull_pc/B.n2 VSUBS 0.00206f ; **FLOATING
C13 pfet_01v8_lvt_W14p21_L0p89_m1__nf1_gboth_sdfull_pc/B.n3 VSUBS 0.05879f ; **FLOATING
C14 pfet_01v8_lvt_W14p21_L0p89_m1__nf1_gboth_sdfull_pc/B.n4 VSUBS 0.00206f ; **FLOATING
C15 pfet_01v8_lvt_W14p21_L0p89_m1__nf1_gboth_sdfull_pc/B.n5 VSUBS 0.00437f ; **FLOATING
C16 pfet_01v8_lvt_W14p21_L0p89_m1__nf1_gboth_sdfull_pc/B.n6 VSUBS 0.03461f ; **FLOATING
C17 pfet_01v8_lvt_W14p21_L0p89_m1__nf1_gboth_sdfull_pc/B.n7 VSUBS 0.00206f ; **FLOATING
C18 pfet_01v8_lvt_W14p21_L0p89_m1__nf1_gboth_sdfull_pc/B.n8 VSUBS 0.0044f ; **FLOATING
C19 pfet_01v8_lvt_W14p21_L0p89_m1__nf1_gboth_sdfull_pc/B.n9 VSUBS 0.00206f ; **FLOATING
C20 pfet_01v8_lvt_W14p21_L0p89_m1__nf1_gboth_sdfull_pc/B.n10 VSUBS 0.00206f ; **FLOATING
C21 pfet_01v8_lvt_W14p21_L0p89_m1__nf1_gboth_sdfull_pc/B.n11 VSUBS 0.03461f ; **FLOATING
C22 pfet_01v8_lvt_W14p21_L0p89_m1__nf1_gboth_sdfull_pc/B.n12 VSUBS 0.00206f ; **FLOATING
C23 pfet_01v8_lvt_W14p21_L0p89_m1__nf1_gboth_sdfull_pc/B.n13 VSUBS 0.00206f ; **FLOATING
C24 pfet_01v8_lvt_W14p21_L0p89_m1__nf1_gboth_sdfull_pc/B.n14 VSUBS 0.00206f ; **FLOATING
C25 pfet_01v8_lvt_W14p21_L0p89_m1__nf1_gboth_sdfull_pc/B.n15 VSUBS 0.03461f ; **FLOATING
C26 pfet_01v8_lvt_W14p21_L0p89_m1__nf1_gboth_sdfull_pc/B.n16 VSUBS 0.00206f ; **FLOATING
C27 pfet_01v8_lvt_W14p21_L0p89_m1__nf1_gboth_sdfull_pc/B.n17 VSUBS 0.00206f ; **FLOATING
C28 pfet_01v8_lvt_W14p21_L0p89_m1__nf1_gboth_sdfull_pc/B.n18 VSUBS 0.00206f ; **FLOATING
C29 pfet_01v8_lvt_W14p21_L0p89_m1__nf1_gboth_sdfull_pc/B.n19 VSUBS 0.03461f ; **FLOATING
C30 pfet_01v8_lvt_W14p21_L0p89_m1__nf1_gboth_sdfull_pc/B.n20 VSUBS 0.00206f ; **FLOATING
C31 pfet_01v8_lvt_W14p21_L0p89_m1__nf1_gboth_sdfull_pc/B.n21 VSUBS 0.00206f ; **FLOATING
C32 pfet_01v8_lvt_W14p21_L0p89_m1__nf1_gboth_sdfull_pc/B.n22 VSUBS 0.00206f ; **FLOATING
C33 pfet_01v8_lvt_W14p21_L0p89_m1__nf1_gboth_sdfull_pc/B.n23 VSUBS 0.03461f ; **FLOATING
C34 pfet_01v8_lvt_W14p21_L0p89_m1__nf1_gboth_sdfull_pc/B.n24 VSUBS 0.00206f ; **FLOATING
C35 pfet_01v8_lvt_W14p21_L0p89_m1__nf1_gboth_sdfull_pc/B.n25 VSUBS 0.00206f ; **FLOATING
C36 pfet_01v8_lvt_W14p21_L0p89_m1__nf1_gboth_sdfull_pc/B.n26 VSUBS 0.00206f ; **FLOATING
C37 pfet_01v8_lvt_W14p21_L0p89_m1__nf1_gboth_sdfull_pc/B.n27 VSUBS 0.03461f ; **FLOATING
C38 pfet_01v8_lvt_W14p21_L0p89_m1__nf1_gboth_sdfull_pc/B.n28 VSUBS 0.00206f ; **FLOATING
C39 pfet_01v8_lvt_W14p21_L0p89_m1__nf1_gboth_sdfull_pc/B.n29 VSUBS 0.00206f ; **FLOATING
C40 pfet_01v8_lvt_W14p21_L0p89_m1__nf1_gboth_sdfull_pc/B.n30 VSUBS 0.00206f ; **FLOATING
C41 pfet_01v8_lvt_W14p21_L0p89_m1__nf1_gboth_sdfull_pc/B.n31 VSUBS 0.03461f ; **FLOATING
C42 pfet_01v8_lvt_W14p21_L0p89_m1__nf1_gboth_sdfull_pc/B.n32 VSUBS 0.00206f ; **FLOATING
C43 pfet_01v8_lvt_W14p21_L0p89_m1__nf1_gboth_sdfull_pc/B.n33 VSUBS 0.00206f ; **FLOATING
C44 pfet_01v8_lvt_W14p21_L0p89_m1__nf1_gboth_sdfull_pc/B.n34 VSUBS 0.00206f ; **FLOATING
C45 pfet_01v8_lvt_W14p21_L0p89_m1__nf1_gboth_sdfull_pc/B.n35 VSUBS 0.03461f ; **FLOATING
C46 pfet_01v8_lvt_W14p21_L0p89_m1__nf1_gboth_sdfull_pc/B.n36 VSUBS 0.00206f ; **FLOATING
C47 pfet_01v8_lvt_W14p21_L0p89_m1__nf1_gboth_sdfull_pc/B.n37 VSUBS 0.00206f ; **FLOATING
C48 pfet_01v8_lvt_W14p21_L0p89_m1__nf1_gboth_sdfull_pc/B.n38 VSUBS 0.00206f ; **FLOATING
C49 pfet_01v8_lvt_W14p21_L0p89_m1__nf1_gboth_sdfull_pc/B.n39 VSUBS 0.03461f ; **FLOATING
C50 pfet_01v8_lvt_W14p21_L0p89_m1__nf1_gboth_sdfull_pc/B.n40 VSUBS 0.00206f ; **FLOATING
C51 pfet_01v8_lvt_W14p21_L0p89_m1__nf1_gboth_sdfull_pc/B.n41 VSUBS 0.00206f ; **FLOATING
C52 pfet_01v8_lvt_W14p21_L0p89_m1__nf1_gboth_sdfull_pc/B.n42 VSUBS 0.00206f ; **FLOATING
C53 pfet_01v8_lvt_W14p21_L0p89_m1__nf1_gboth_sdfull_pc/B.n43 VSUBS 0.03461f ; **FLOATING
C54 pfet_01v8_lvt_W14p21_L0p89_m1__nf1_gboth_sdfull_pc/B.n44 VSUBS 0.00206f ; **FLOATING
C55 pfet_01v8_lvt_W14p21_L0p89_m1__nf1_gboth_sdfull_pc/B.n45 VSUBS 0.00206f ; **FLOATING
C56 pfet_01v8_lvt_W14p21_L0p89_m1__nf1_gboth_sdfull_pc/B.n46 VSUBS 0.00206f ; **FLOATING
C57 pfet_01v8_lvt_W14p21_L0p89_m1__nf1_gboth_sdfull_pc/B.n47 VSUBS 0.02596f ; **FLOATING
C58 pfet_01v8_lvt_W14p21_L0p89_m1__nf1_gboth_sdfull_pc/B.n48 VSUBS 0.00206f ; **FLOATING
C59 pfet_01v8_lvt_W14p21_L0p89_m1__nf1_gboth_sdfull_pc/B.n49 VSUBS 0.00206f ; **FLOATING
C60 pfet_01v8_lvt_W14p21_L0p89_m1__nf1_gboth_sdfull_pc/B.n50 VSUBS 0.00206f ; **FLOATING
C61 pfet_01v8_lvt_W14p21_L0p89_m1__nf1_gboth_sdfull_pc/B.n51 VSUBS 0.03461f ; **FLOATING
C62 pfet_01v8_lvt_W14p21_L0p89_m1__nf1_gboth_sdfull_pc/B.n52 VSUBS 0.00206f ; **FLOATING
C63 pfet_01v8_lvt_W14p21_L0p89_m1__nf1_gboth_sdfull_pc/B.n53 VSUBS 0.00206f ; **FLOATING
C64 pfet_01v8_lvt_W14p21_L0p89_m1__nf1_gboth_sdfull_pc/B.n54 VSUBS 0.00206f ; **FLOATING
C65 pfet_01v8_lvt_W14p21_L0p89_m1__nf1_gboth_sdfull_pc/B.n55 VSUBS 0.03461f ; **FLOATING
C66 pfet_01v8_lvt_W14p21_L0p89_m1__nf1_gboth_sdfull_pc/B.n56 VSUBS 0.00206f ; **FLOATING
C67 pfet_01v8_lvt_W14p21_L0p89_m1__nf1_gboth_sdfull_pc/B.n57 VSUBS 0.00206f ; **FLOATING
C68 pfet_01v8_lvt_W14p21_L0p89_m1__nf1_gboth_sdfull_pc/B.n58 VSUBS 0.00206f ; **FLOATING
C69 pfet_01v8_lvt_W14p21_L0p89_m1__nf1_gboth_sdfull_pc/B.n59 VSUBS 0.03461f ; **FLOATING
C70 pfet_01v8_lvt_W14p21_L0p89_m1__nf1_gboth_sdfull_pc/B.n60 VSUBS 0.00206f ; **FLOATING
C71 pfet_01v8_lvt_W14p21_L0p89_m1__nf1_gboth_sdfull_pc/B.n61 VSUBS 0.00206f ; **FLOATING
C72 pfet_01v8_lvt_W14p21_L0p89_m1__nf1_gboth_sdfull_pc/B.n62 VSUBS 0.00206f ; **FLOATING
C73 pfet_01v8_lvt_W14p21_L0p89_m1__nf1_gboth_sdfull_pc/B.n63 VSUBS 0.03461f ; **FLOATING
C74 pfet_01v8_lvt_W14p21_L0p89_m1__nf1_gboth_sdfull_pc/B.n64 VSUBS 0.00206f ; **FLOATING
C75 pfet_01v8_lvt_W14p21_L0p89_m1__nf1_gboth_sdfull_pc/B.n65 VSUBS 0.00206f ; **FLOATING
C76 pfet_01v8_lvt_W14p21_L0p89_m1__nf1_gboth_sdfull_pc/B.n66 VSUBS 0.00206f ; **FLOATING
C77 pfet_01v8_lvt_W14p21_L0p89_m1__nf1_gboth_sdfull_pc/B.n67 VSUBS 0.03461f ; **FLOATING
C78 pfet_01v8_lvt_W14p21_L0p89_m1__nf1_gboth_sdfull_pc/B.n68 VSUBS 0.00206f ; **FLOATING
C79 pfet_01v8_lvt_W14p21_L0p89_m1__nf1_gboth_sdfull_pc/B.n69 VSUBS 0.00206f ; **FLOATING
C80 pfet_01v8_lvt_W14p21_L0p89_m1__nf1_gboth_sdfull_pc/B.n70 VSUBS 0.00206f ; **FLOATING
C81 pfet_01v8_lvt_W14p21_L0p89_m1__nf1_gboth_sdfull_pc/B.n71 VSUBS 0.03461f ; **FLOATING
C82 pfet_01v8_lvt_W14p21_L0p89_m1__nf1_gboth_sdfull_pc/B.n72 VSUBS 0.00206f ; **FLOATING
C83 pfet_01v8_lvt_W14p21_L0p89_m1__nf1_gboth_sdfull_pc/B.n73 VSUBS 0.00206f ; **FLOATING
C84 pfet_01v8_lvt_W14p21_L0p89_m1__nf1_gboth_sdfull_pc/B.n74 VSUBS 0.00206f ; **FLOATING
C85 pfet_01v8_lvt_W14p21_L0p89_m1__nf1_gboth_sdfull_pc/B.n75 VSUBS 0.03461f ; **FLOATING
C86 pfet_01v8_lvt_W14p21_L0p89_m1__nf1_gboth_sdfull_pc/B.n76 VSUBS 0.00206f ; **FLOATING
C87 pfet_01v8_lvt_W14p21_L0p89_m1__nf1_gboth_sdfull_pc/B.n77 VSUBS 0.00206f ; **FLOATING
C88 pfet_01v8_lvt_W14p21_L0p89_m1__nf1_gboth_sdfull_pc/B.n78 VSUBS 0.00206f ; **FLOATING
C89 pfet_01v8_lvt_W14p21_L0p89_m1__nf1_gboth_sdfull_pc/B.n79 VSUBS 0.03461f ; **FLOATING
C90 pfet_01v8_lvt_W14p21_L0p89_m1__nf1_gboth_sdfull_pc/B.n80 VSUBS 0.00206f ; **FLOATING
C91 pfet_01v8_lvt_W14p21_L0p89_m1__nf1_gboth_sdfull_pc/B.n81 VSUBS 0.00206f ; **FLOATING
C92 pfet_01v8_lvt_W14p21_L0p89_m1__nf1_gboth_sdfull_pc/B.n82 VSUBS 0.00206f ; **FLOATING
C93 pfet_01v8_lvt_W14p21_L0p89_m1__nf1_gboth_sdfull_pc/B.n83 VSUBS 0.03461f ; **FLOATING
C94 pfet_01v8_lvt_W14p21_L0p89_m1__nf1_gboth_sdfull_pc/B.n84 VSUBS 0.00206f ; **FLOATING
C95 pfet_01v8_lvt_W14p21_L0p89_m1__nf1_gboth_sdfull_pc/B.n85 VSUBS 0.00206f ; **FLOATING
C96 pfet_01v8_lvt_W14p21_L0p89_m1__nf1_gboth_sdfull_pc/B.n86 VSUBS 0.00206f ; **FLOATING
C97 pfet_01v8_lvt_W14p21_L0p89_m1__nf1_gboth_sdfull_pc/B.n87 VSUBS 0.03461f ; **FLOATING
C98 pfet_01v8_lvt_W14p21_L0p89_m1__nf1_gboth_sdfull_pc/B.n88 VSUBS 0.00206f ; **FLOATING
C99 pfet_01v8_lvt_W14p21_L0p89_m1__nf1_gboth_sdfull_pc/B.n89 VSUBS 0.00437f ; **FLOATING
C100 pfet_01v8_lvt_W14p21_L0p89_m1__nf1_gboth_sdfull_pc/B.n90 VSUBS 0.00437f ; **FLOATING
C101 pfet_01v8_lvt_W14p21_L0p89_m1__nf1_gboth_sdfull_pc/B.n91 VSUBS 0.04912f ; **FLOATING
C102 pfet_01v8_lvt_W14p21_L0p89_m1__nf1_gboth_sdfull_pc/B.n92 VSUBS 0.00437f ; **FLOATING
C103 pfet_01v8_lvt_W14p21_L0p89_m1__nf1_gboth_sdfull_pc/B.n93 VSUBS 0.00206f ; **FLOATING
C104 pfet_01v8_lvt_W14p21_L0p89_m1__nf1_gboth_sdfull_pc/B.n94 VSUBS 0.00206f ; **FLOATING
C105 pfet_01v8_lvt_W14p21_L0p89_m1__nf1_gboth_sdfull_pc/B.n95 VSUBS 0.00206f ; **FLOATING
C106 pfet_01v8_lvt_W14p21_L0p89_m1__nf1_gboth_sdfull_pc/B.n96 VSUBS 0.00206f ; **FLOATING
C107 pfet_01v8_lvt_W14p21_L0p89_m1__nf1_gboth_sdfull_pc/B.n97 VSUBS 0.00206f ; **FLOATING
C108 pfet_01v8_lvt_W14p21_L0p89_m1__nf1_gboth_sdfull_pc/B.n98 VSUBS 0.00206f ; **FLOATING
C109 pfet_01v8_lvt_W14p21_L0p89_m1__nf1_gboth_sdfull_pc/B.n99 VSUBS 0.0044f ; **FLOATING
C110 pfet_01v8_lvt_W14p21_L0p89_m1__nf1_gboth_sdfull_pc/B.n100 VSUBS 0.0044f ; **FLOATING
C111 pfet_01v8_lvt_W14p21_L0p89_m1__nf1_gboth_sdfull_pc/B.n102 VSUBS 0.05879f ; **FLOATING
C112 pfet_01v8_lvt_W14p21_L0p89_m1__nf1_gboth_sdfull_pc/B.n104 VSUBS 0.0044f ; **FLOATING
C113 pfet_01v8_lvt_W14p21_L0p89_m1__nf1_gboth_sdfull_pc/B.n105 VSUBS 0.0044f ; **FLOATING
C114 pfet_01v8_lvt_W14p21_L0p89_m1__nf1_gboth_sdfull_pc/B.n106 VSUBS 0.00437f ; **FLOATING
C115 pfet_01v8_lvt_W14p21_L0p89_m1__nf1_gboth_sdfull_pc/B.n107 VSUBS 0.00206f ; **FLOATING
C116 pfet_01v8_lvt_W14p21_L0p89_m1__nf1_gboth_sdfull_pc/B.n108 VSUBS 0.00206f ; **FLOATING
C117 pfet_01v8_lvt_W14p21_L0p89_m1__nf1_gboth_sdfull_pc/B.n109 VSUBS 0.03461f ; **FLOATING
C118 pfet_01v8_lvt_W14p21_L0p89_m1__nf1_gboth_sdfull_pc/B.n110 VSUBS 0.00206f ; **FLOATING
C119 pfet_01v8_lvt_W14p21_L0p89_m1__nf1_gboth_sdfull_pc/B.n111 VSUBS 0.00206f ; **FLOATING
C120 pfet_01v8_lvt_W14p21_L0p89_m1__nf1_gboth_sdfull_pc/B.n112 VSUBS 0.00206f ; **FLOATING
C121 pfet_01v8_lvt_W14p21_L0p89_m1__nf1_gboth_sdfull_pc/B.n113 VSUBS 0.00206f ; **FLOATING
C122 pfet_01v8_lvt_W14p21_L0p89_m1__nf1_gboth_sdfull_pc/B.n114 VSUBS 0.00206f ; **FLOATING
C123 pfet_01v8_lvt_W14p21_L0p89_m1__nf1_gboth_sdfull_pc/B.n115 VSUBS 0.03461f ; **FLOATING
C124 pfet_01v8_lvt_W14p21_L0p89_m1__nf1_gboth_sdfull_pc/B.n116 VSUBS 0.00206f ; **FLOATING
C125 pfet_01v8_lvt_W14p21_L0p89_m1__nf1_gboth_sdfull_pc/B.n117 VSUBS 0.00206f ; **FLOATING
C126 pfet_01v8_lvt_W14p21_L0p89_m1__nf1_gboth_sdfull_pc/B.n118 VSUBS 0.00206f ; **FLOATING
C127 pfet_01v8_lvt_W14p21_L0p89_m1__nf1_gboth_sdfull_pc/B.n119 VSUBS 0.00206f ; **FLOATING
C128 pfet_01v8_lvt_W14p21_L0p89_m1__nf1_gboth_sdfull_pc/B.n120 VSUBS 0.00206f ; **FLOATING
C129 pfet_01v8_lvt_W14p21_L0p89_m1__nf1_gboth_sdfull_pc/B.n121 VSUBS 0.03461f ; **FLOATING
C130 pfet_01v8_lvt_W14p21_L0p89_m1__nf1_gboth_sdfull_pc/B.n122 VSUBS 0.00206f ; **FLOATING
C131 pfet_01v8_lvt_W14p21_L0p89_m1__nf1_gboth_sdfull_pc/B.n123 VSUBS 0.00206f ; **FLOATING
C132 pfet_01v8_lvt_W14p21_L0p89_m1__nf1_gboth_sdfull_pc/B.n124 VSUBS 0.00206f ; **FLOATING
C133 pfet_01v8_lvt_W14p21_L0p89_m1__nf1_gboth_sdfull_pc/B.n125 VSUBS 0.00206f ; **FLOATING
C134 pfet_01v8_lvt_W14p21_L0p89_m1__nf1_gboth_sdfull_pc/B.n126 VSUBS 0.00206f ; **FLOATING
C135 pfet_01v8_lvt_W14p21_L0p89_m1__nf1_gboth_sdfull_pc/B.n127 VSUBS 0.03461f ; **FLOATING
C136 pfet_01v8_lvt_W14p21_L0p89_m1__nf1_gboth_sdfull_pc/B.n128 VSUBS 0.00206f ; **FLOATING
C137 pfet_01v8_lvt_W14p21_L0p89_m1__nf1_gboth_sdfull_pc/B.n129 VSUBS 0.00206f ; **FLOATING
C138 pfet_01v8_lvt_W14p21_L0p89_m1__nf1_gboth_sdfull_pc/B.n130 VSUBS 0.00206f ; **FLOATING
C139 pfet_01v8_lvt_W14p21_L0p89_m1__nf1_gboth_sdfull_pc/B.n131 VSUBS 0.00206f ; **FLOATING
C140 pfet_01v8_lvt_W14p21_L0p89_m1__nf1_gboth_sdfull_pc/B.n132 VSUBS 0.00206f ; **FLOATING
C141 pfet_01v8_lvt_W14p21_L0p89_m1__nf1_gboth_sdfull_pc/B.n133 VSUBS 0.03461f ; **FLOATING
C142 pfet_01v8_lvt_W14p21_L0p89_m1__nf1_gboth_sdfull_pc/B.n134 VSUBS 0.00206f ; **FLOATING
C143 pfet_01v8_lvt_W14p21_L0p89_m1__nf1_gboth_sdfull_pc/B.n135 VSUBS 0.00206f ; **FLOATING
C144 pfet_01v8_lvt_W14p21_L0p89_m1__nf1_gboth_sdfull_pc/B.n136 VSUBS 0.00206f ; **FLOATING
C145 pfet_01v8_lvt_W14p21_L0p89_m1__nf1_gboth_sdfull_pc/B.n137 VSUBS 0.00206f ; **FLOATING
C146 pfet_01v8_lvt_W14p21_L0p89_m1__nf1_gboth_sdfull_pc/B.n138 VSUBS 0.00206f ; **FLOATING
C147 pfet_01v8_lvt_W14p21_L0p89_m1__nf1_gboth_sdfull_pc/B.n139 VSUBS 0.03461f ; **FLOATING
C148 pfet_01v8_lvt_W14p21_L0p89_m1__nf1_gboth_sdfull_pc/B.n140 VSUBS 0.00206f ; **FLOATING
C149 pfet_01v8_lvt_W14p21_L0p89_m1__nf1_gboth_sdfull_pc/B.n141 VSUBS 0.00206f ; **FLOATING
C150 pfet_01v8_lvt_W14p21_L0p89_m1__nf1_gboth_sdfull_pc/B.n142 VSUBS 0.00206f ; **FLOATING
C151 pfet_01v8_lvt_W14p21_L0p89_m1__nf1_gboth_sdfull_pc/B.n143 VSUBS 0.00206f ; **FLOATING
C152 pfet_01v8_lvt_W14p21_L0p89_m1__nf1_gboth_sdfull_pc/B.n144 VSUBS 0.00206f ; **FLOATING
C153 pfet_01v8_lvt_W14p21_L0p89_m1__nf1_gboth_sdfull_pc/B.n145 VSUBS 0.03461f ; **FLOATING
C154 pfet_01v8_lvt_W14p21_L0p89_m1__nf1_gboth_sdfull_pc/B.n146 VSUBS 0.00206f ; **FLOATING
C155 pfet_01v8_lvt_W14p21_L0p89_m1__nf1_gboth_sdfull_pc/B.n147 VSUBS 0.00206f ; **FLOATING
C156 pfet_01v8_lvt_W14p21_L0p89_m1__nf1_gboth_sdfull_pc/B.n148 VSUBS 0.00206f ; **FLOATING
C157 pfet_01v8_lvt_W14p21_L0p89_m1__nf1_gboth_sdfull_pc/B.n149 VSUBS 0.00206f ; **FLOATING
C158 pfet_01v8_lvt_W14p21_L0p89_m1__nf1_gboth_sdfull_pc/B.n150 VSUBS 0.00206f ; **FLOATING
C159 pfet_01v8_lvt_W14p21_L0p89_m1__nf1_gboth_sdfull_pc/B.n151 VSUBS 0.03461f ; **FLOATING
C160 pfet_01v8_lvt_W14p21_L0p89_m1__nf1_gboth_sdfull_pc/B.n152 VSUBS 0.00206f ; **FLOATING
C161 pfet_01v8_lvt_W14p21_L0p89_m1__nf1_gboth_sdfull_pc/B.n153 VSUBS 0.00206f ; **FLOATING
C162 pfet_01v8_lvt_W14p21_L0p89_m1__nf1_gboth_sdfull_pc/B.n154 VSUBS 0.00206f ; **FLOATING
C163 pfet_01v8_lvt_W14p21_L0p89_m1__nf1_gboth_sdfull_pc/B.n155 VSUBS 0.00206f ; **FLOATING
C164 pfet_01v8_lvt_W14p21_L0p89_m1__nf1_gboth_sdfull_pc/B.n156 VSUBS 0.00206f ; **FLOATING
C165 pfet_01v8_lvt_W14p21_L0p89_m1__nf1_gboth_sdfull_pc/B.n157 VSUBS 0.03461f ; **FLOATING
C166 pfet_01v8_lvt_W14p21_L0p89_m1__nf1_gboth_sdfull_pc/B.n158 VSUBS 0.00206f ; **FLOATING
C167 pfet_01v8_lvt_W14p21_L0p89_m1__nf1_gboth_sdfull_pc/B.n159 VSUBS 0.00206f ; **FLOATING
C168 pfet_01v8_lvt_W14p21_L0p89_m1__nf1_gboth_sdfull_pc/B.n160 VSUBS 0.00206f ; **FLOATING
C169 pfet_01v8_lvt_W14p21_L0p89_m1__nf1_gboth_sdfull_pc/B.n161 VSUBS 0.00206f ; **FLOATING
C170 pfet_01v8_lvt_W14p21_L0p89_m1__nf1_gboth_sdfull_pc/B.n162 VSUBS 0.00206f ; **FLOATING
C171 pfet_01v8_lvt_W14p21_L0p89_m1__nf1_gboth_sdfull_pc/B.n163 VSUBS 0.03461f ; **FLOATING
C172 pfet_01v8_lvt_W14p21_L0p89_m1__nf1_gboth_sdfull_pc/B.n164 VSUBS 0.00206f ; **FLOATING
C173 pfet_01v8_lvt_W14p21_L0p89_m1__nf1_gboth_sdfull_pc/B.n165 VSUBS 0.00206f ; **FLOATING
C174 pfet_01v8_lvt_W14p21_L0p89_m1__nf1_gboth_sdfull_pc/B.n166 VSUBS 0.00206f ; **FLOATING
C175 pfet_01v8_lvt_W14p21_L0p89_m1__nf1_gboth_sdfull_pc/B.n167 VSUBS 0.00206f ; **FLOATING
C176 pfet_01v8_lvt_W14p21_L0p89_m1__nf1_gboth_sdfull_pc/B.n168 VSUBS 0.00206f ; **FLOATING
C177 pfet_01v8_lvt_W14p21_L0p89_m1__nf1_gboth_sdfull_pc/B.t0 VSUBS 0.01731f ; **FLOATING
C178 pfet_01v8_lvt_W14p21_L0p89_m1__nf1_gboth_sdfull_pc/B.n169 VSUBS 0.02596f ; **FLOATING
C179 pfet_01v8_lvt_W14p21_L0p89_m1__nf1_gboth_sdfull_pc/B.n170 VSUBS 0.00206f ; **FLOATING
C180 pfet_01v8_lvt_W14p21_L0p89_m1__nf1_gboth_sdfull_pc/B.n171 VSUBS 0.00206f ; **FLOATING
C181 pfet_01v8_lvt_W14p21_L0p89_m1__nf1_gboth_sdfull_pc/B.n172 VSUBS 0.00206f ; **FLOATING
C182 pfet_01v8_lvt_W14p21_L0p89_m1__nf1_gboth_sdfull_pc/B.n173 VSUBS 0.00206f ; **FLOATING
C183 pfet_01v8_lvt_W14p21_L0p89_m1__nf1_gboth_sdfull_pc/B.n174 VSUBS 0.00206f ; **FLOATING
C184 pfet_01v8_lvt_W14p21_L0p89_m1__nf1_gboth_sdfull_pc/B.n175 VSUBS 0.03461f ; **FLOATING
C185 pfet_01v8_lvt_W14p21_L0p89_m1__nf1_gboth_sdfull_pc/B.n176 VSUBS 0.00206f ; **FLOATING
C186 pfet_01v8_lvt_W14p21_L0p89_m1__nf1_gboth_sdfull_pc/B.n177 VSUBS 0.00206f ; **FLOATING
C187 pfet_01v8_lvt_W14p21_L0p89_m1__nf1_gboth_sdfull_pc/B.n178 VSUBS 0.00206f ; **FLOATING
C188 pfet_01v8_lvt_W14p21_L0p89_m1__nf1_gboth_sdfull_pc/B.n179 VSUBS 0.00206f ; **FLOATING
C189 pfet_01v8_lvt_W14p21_L0p89_m1__nf1_gboth_sdfull_pc/B.n180 VSUBS 0.00206f ; **FLOATING
C190 pfet_01v8_lvt_W14p21_L0p89_m1__nf1_gboth_sdfull_pc/B.n181 VSUBS 0.03461f ; **FLOATING
C191 pfet_01v8_lvt_W14p21_L0p89_m1__nf1_gboth_sdfull_pc/B.n182 VSUBS 0.00206f ; **FLOATING
C192 pfet_01v8_lvt_W14p21_L0p89_m1__nf1_gboth_sdfull_pc/B.n183 VSUBS 0.00206f ; **FLOATING
C193 pfet_01v8_lvt_W14p21_L0p89_m1__nf1_gboth_sdfull_pc/B.n184 VSUBS 0.00206f ; **FLOATING
C194 pfet_01v8_lvt_W14p21_L0p89_m1__nf1_gboth_sdfull_pc/B.n185 VSUBS 0.00206f ; **FLOATING
C195 pfet_01v8_lvt_W14p21_L0p89_m1__nf1_gboth_sdfull_pc/B.n186 VSUBS 0.00206f ; **FLOATING
C196 pfet_01v8_lvt_W14p21_L0p89_m1__nf1_gboth_sdfull_pc/B.n187 VSUBS 0.03461f ; **FLOATING
C197 pfet_01v8_lvt_W14p21_L0p89_m1__nf1_gboth_sdfull_pc/B.n188 VSUBS 0.00206f ; **FLOATING
C198 pfet_01v8_lvt_W14p21_L0p89_m1__nf1_gboth_sdfull_pc/B.n189 VSUBS 0.00206f ; **FLOATING
C199 pfet_01v8_lvt_W14p21_L0p89_m1__nf1_gboth_sdfull_pc/B.n190 VSUBS 0.00206f ; **FLOATING
C200 pfet_01v8_lvt_W14p21_L0p89_m1__nf1_gboth_sdfull_pc/B.n191 VSUBS 0.00206f ; **FLOATING
C201 pfet_01v8_lvt_W14p21_L0p89_m1__nf1_gboth_sdfull_pc/B.n192 VSUBS 0.00206f ; **FLOATING
C202 pfet_01v8_lvt_W14p21_L0p89_m1__nf1_gboth_sdfull_pc/B.n193 VSUBS 0.03461f ; **FLOATING
C203 pfet_01v8_lvt_W14p21_L0p89_m1__nf1_gboth_sdfull_pc/B.n194 VSUBS 0.00206f ; **FLOATING
C204 pfet_01v8_lvt_W14p21_L0p89_m1__nf1_gboth_sdfull_pc/B.n195 VSUBS 0.00206f ; **FLOATING
C205 pfet_01v8_lvt_W14p21_L0p89_m1__nf1_gboth_sdfull_pc/B.n196 VSUBS 0.00206f ; **FLOATING
C206 pfet_01v8_lvt_W14p21_L0p89_m1__nf1_gboth_sdfull_pc/B.n197 VSUBS 0.00206f ; **FLOATING
C207 pfet_01v8_lvt_W14p21_L0p89_m1__nf1_gboth_sdfull_pc/B.n198 VSUBS 0.00206f ; **FLOATING
C208 pfet_01v8_lvt_W14p21_L0p89_m1__nf1_gboth_sdfull_pc/B.n199 VSUBS 0.03461f ; **FLOATING
C209 pfet_01v8_lvt_W14p21_L0p89_m1__nf1_gboth_sdfull_pc/B.n200 VSUBS 0.00206f ; **FLOATING
C210 pfet_01v8_lvt_W14p21_L0p89_m1__nf1_gboth_sdfull_pc/B.n201 VSUBS 0.00206f ; **FLOATING
C211 pfet_01v8_lvt_W14p21_L0p89_m1__nf1_gboth_sdfull_pc/B.n202 VSUBS 0.00206f ; **FLOATING
C212 pfet_01v8_lvt_W14p21_L0p89_m1__nf1_gboth_sdfull_pc/B.n203 VSUBS 0.00206f ; **FLOATING
C213 pfet_01v8_lvt_W14p21_L0p89_m1__nf1_gboth_sdfull_pc/B.n204 VSUBS 0.00206f ; **FLOATING
C214 pfet_01v8_lvt_W14p21_L0p89_m1__nf1_gboth_sdfull_pc/B.n205 VSUBS 0.03461f ; **FLOATING
C215 pfet_01v8_lvt_W14p21_L0p89_m1__nf1_gboth_sdfull_pc/B.n206 VSUBS 0.00206f ; **FLOATING
C216 pfet_01v8_lvt_W14p21_L0p89_m1__nf1_gboth_sdfull_pc/B.n207 VSUBS 0.00206f ; **FLOATING
C217 pfet_01v8_lvt_W14p21_L0p89_m1__nf1_gboth_sdfull_pc/B.n208 VSUBS 0.00206f ; **FLOATING
C218 pfet_01v8_lvt_W14p21_L0p89_m1__nf1_gboth_sdfull_pc/B.n209 VSUBS 0.00206f ; **FLOATING
C219 pfet_01v8_lvt_W14p21_L0p89_m1__nf1_gboth_sdfull_pc/B.n210 VSUBS 0.00206f ; **FLOATING
C220 pfet_01v8_lvt_W14p21_L0p89_m1__nf1_gboth_sdfull_pc/B.n211 VSUBS 0.03461f ; **FLOATING
C221 pfet_01v8_lvt_W14p21_L0p89_m1__nf1_gboth_sdfull_pc/B.n212 VSUBS 0.00206f ; **FLOATING
C222 pfet_01v8_lvt_W14p21_L0p89_m1__nf1_gboth_sdfull_pc/B.n213 VSUBS 0.00206f ; **FLOATING
C223 pfet_01v8_lvt_W14p21_L0p89_m1__nf1_gboth_sdfull_pc/B.n214 VSUBS 0.00206f ; **FLOATING
C224 pfet_01v8_lvt_W14p21_L0p89_m1__nf1_gboth_sdfull_pc/B.n215 VSUBS 0.00206f ; **FLOATING
C225 pfet_01v8_lvt_W14p21_L0p89_m1__nf1_gboth_sdfull_pc/B.n216 VSUBS 0.00206f ; **FLOATING
C226 pfet_01v8_lvt_W14p21_L0p89_m1__nf1_gboth_sdfull_pc/B.n217 VSUBS 0.03461f ; **FLOATING
C227 pfet_01v8_lvt_W14p21_L0p89_m1__nf1_gboth_sdfull_pc/B.n218 VSUBS 0.00206f ; **FLOATING
C228 pfet_01v8_lvt_W14p21_L0p89_m1__nf1_gboth_sdfull_pc/B.n219 VSUBS 0.00206f ; **FLOATING
C229 pfet_01v8_lvt_W14p21_L0p89_m1__nf1_gboth_sdfull_pc/B.n220 VSUBS 0.00206f ; **FLOATING
C230 pfet_01v8_lvt_W14p21_L0p89_m1__nf1_gboth_sdfull_pc/B.n221 VSUBS 0.00206f ; **FLOATING
C231 pfet_01v8_lvt_W14p21_L0p89_m1__nf1_gboth_sdfull_pc/B.n222 VSUBS 0.00206f ; **FLOATING
C232 pfet_01v8_lvt_W14p21_L0p89_m1__nf1_gboth_sdfull_pc/B.n223 VSUBS 0.03461f ; **FLOATING
C233 pfet_01v8_lvt_W14p21_L0p89_m1__nf1_gboth_sdfull_pc/B.n224 VSUBS 0.00206f ; **FLOATING
C234 pfet_01v8_lvt_W14p21_L0p89_m1__nf1_gboth_sdfull_pc/B.n225 VSUBS 0.00206f ; **FLOATING
C235 pfet_01v8_lvt_W14p21_L0p89_m1__nf1_gboth_sdfull_pc/B.n226 VSUBS 0.00206f ; **FLOATING
C236 pfet_01v8_lvt_W14p21_L0p89_m1__nf1_gboth_sdfull_pc/B.n227 VSUBS 0.00206f ; **FLOATING
C237 pfet_01v8_lvt_W14p21_L0p89_m1__nf1_gboth_sdfull_pc/B.n228 VSUBS 0.00206f ; **FLOATING
C238 pfet_01v8_lvt_W14p21_L0p89_m1__nf1_gboth_sdfull_pc/B.n229 VSUBS 0.00206f ; **FLOATING
C239 pfet_01v8_lvt_W14p21_L0p89_m1__nf1_gboth_sdfull_pc/B.n230 VSUBS 0.03461f ; **FLOATING
C240 pfet_01v8_lvt_W14p21_L0p89_m1__nf1_gboth_sdfull_pc/B.n231 VSUBS 0.00206f ; **FLOATING
C241 pfet_01v8_lvt_W14p21_L0p89_m1__nf1_gboth_sdfull_pc/B.n232 VSUBS 0.00206f ; **FLOATING
C242 pfet_01v8_lvt_W14p21_L0p89_m1__nf1_gboth_sdfull_pc/B.n233 VSUBS 0.00206f ; **FLOATING
C243 pfet_01v8_lvt_W14p21_L0p89_m1__nf1_gboth_sdfull_pc/B.n235 VSUBS 0.00206f ; **FLOATING
C244 pfet_01v8_lvt_W14p21_L0p89_m1__nf1_gboth_sdfull_pc/B.n236 VSUBS 0.00206f ; **FLOATING
C245 pfet_01v8_lvt_W14p21_L0p89_m1__nf1_gboth_sdfull_pc/B.n237 VSUBS 0.0044f ; **FLOATING
C246 pfet_01v8_lvt_W14p21_L0p89_m1__nf1_gboth_sdfull_pc/B.n238 VSUBS 0.00437f ; **FLOATING
C247 pfet_01v8_lvt_W14p21_L0p89_m1__nf1_gboth_sdfull_pc/B.n239 VSUBS 0.00437f ; **FLOATING
C248 pfet_01v8_lvt_W14p21_L0p89_m1__nf1_gboth_sdfull_pc/B.n240 VSUBS 0.04912f ; **FLOATING
C249 pfet_01v8_lvt_W14p21_L0p89_m1__nf1_gboth_sdfull_pc/B.n241 VSUBS 0.00437f ; **FLOATING
C250 pfet_01v8_lvt_W14p21_L0p89_m1__nf1_gboth_sdfull_pc/B.n242 VSUBS 0.0044f ; **FLOATING
C251 pfet_01v8_lvt_W14p21_L0p89_m1__nf1_gboth_sdfull_pc/B.n244 VSUBS 0.00206f ; **FLOATING
C252 pfet_01v8_lvt_W14p21_L0p89_m1__nf1_gboth_sdfull_pc/B.n245 VSUBS 0.00181f ; **FLOATING
