.subckt pfet_01v8_lvt_W14p21_L0p89_m1__nf1_gboth_sdfull D G S B
Xpfet_01v8_lvt_W14p21_L0p89_m1__nf1_gboth_sdfull D G S B sky130_fd_pr__pfet_01v8_lvt L=0.89 W=14.21 nf=1
.ends
