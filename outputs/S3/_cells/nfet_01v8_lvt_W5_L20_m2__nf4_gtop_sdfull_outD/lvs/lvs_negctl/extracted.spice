* NGSPICE file created from nfet_01v8_lvt_W5_L20_m2__nf4_gtop_sdfull_outD.ext - technology: sky130A

.subckt sky130_fd_pr__nfet_01v8_lvt_4RWNTH G B D2 D0 a_8087_n156# S3 S1
X0 D2 G S1 B sky130_fd_pr__nfet_01v8_lvt ad=0.18125 pd=1.54 as=0.18125 ps=1.54 w=1.25 l=20
X1 S3 G D2 B sky130_fd_pr__nfet_01v8_lvt ad=0.18125 pd=1.54 as=0.18125 ps=1.54 w=1.25 l=20
X2 S1 G D0 B sky130_fd_pr__nfet_01v8_lvt ad=0.18125 pd=1.54 as=0.3625 ps=3.08 w=1.25 l=20
X3 a_8087_n156# G S3 B sky130_fd_pr__nfet_01v8_lvt ad=0.3625 pd=3.08 as=0.18125 ps=1.54 w=1.25 l=20
.ends

.subckt nfet_01v8_lvt_W5_L20_m2__nf4_gtop_sdfull_outD S D G B
Xnfet_01v8_lvt_W5_L20_m2__nf4_gtop_sdfull_outD_pc G B D D D S S sky130_fd_pr__nfet_01v8_lvt_4RWNTH
.ends
