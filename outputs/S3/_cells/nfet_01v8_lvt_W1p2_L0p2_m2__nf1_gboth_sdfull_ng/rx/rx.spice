* NGSPICE file created from nfet_01v8_lvt_W1p2_L0p2_m2__nf1_gboth_sdfull_ng.ext - technology: sky130A

X0 S G D B sky130_fd_pr__nfet_01v8_lvt ad=0.348 pd=2.98 as=0.348 ps=2.98 w=1.2 l=0.2
C0 G S 0.0329f
C1 G D 0.0329f
C2 S D 0.09394f
C3 G B 0.30012f
C4 S B 0.12738f
C5 D B 0.12738f
