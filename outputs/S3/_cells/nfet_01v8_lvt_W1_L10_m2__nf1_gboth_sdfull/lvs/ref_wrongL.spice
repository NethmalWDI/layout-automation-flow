.subckt nfet_01v8_lvt_W1_L10_m2__nf1_gboth_sdfull D G S B
Xnfet_01v8_lvt_W1_L10_m2__nf1_gboth_sdfull D G S B sky130_fd_pr__nfet_01v8_lvt L=11 W=1 nf=1
.ends
