* NGSPICE file created from nfet_01v8_lvt_W1_L10_m2__nf1_gboth_sdfull.ext - technology: sky130A

X0 S G D nfet_01v8_lvt_W1_L10_m2__nf1_gboth_sdfull_pc/B.t0 sky130_fd_pr__nfet_01v8_lvt ad=0.29 pd=2.58 as=0.29 ps=2.58 w=1 l=10
C0 D G 0.08977f
C1 G S 0.08977f
R0 nfet_01v8_lvt_W1_L10_m2__nf1_gboth_sdfull_pc/B.n138 nfet_01v8_lvt_W1_L10_m2__nf1_gboth_sdfull_pc/B.n119 1315.26
R1 nfet_01v8_lvt_W1_L10_m2__nf1_gboth_sdfull_pc/B.n51 nfet_01v8_lvt_W1_L10_m2__nf1_gboth_sdfull_pc/B.n36 1315.26
R2 nfet_01v8_lvt_W1_L10_m2__nf1_gboth_sdfull_pc/B.n148 nfet_01v8_lvt_W1_L10_m2__nf1_gboth_sdfull_pc/B.n118 1315.26
R3 nfet_01v8_lvt_W1_L10_m2__nf1_gboth_sdfull_pc/B.n49 nfet_01v8_lvt_W1_L10_m2__nf1_gboth_sdfull_pc/B.n38 1315.26
R4 nfet_01v8_lvt_W1_L10_m2__nf1_gboth_sdfull_pc/B.n147 nfet_01v8_lvt_W1_L10_m2__nf1_gboth_sdfull_pc/B.n146 902
R5 nfet_01v8_lvt_W1_L10_m2__nf1_gboth_sdfull_pc/B.n50 nfet_01v8_lvt_W1_L10_m2__nf1_gboth_sdfull_pc/B.n37 902
R6 nfet_01v8_lvt_W1_L10_m2__nf1_gboth_sdfull_pc/B.n148 nfet_01v8_lvt_W1_L10_m2__nf1_gboth_sdfull_pc/B.n147 585
R7 nfet_01v8_lvt_W1_L10_m2__nf1_gboth_sdfull_pc/B.n149 nfet_01v8_lvt_W1_L10_m2__nf1_gboth_sdfull_pc/B.n148 585
R8 nfet_01v8_lvt_W1_L10_m2__nf1_gboth_sdfull_pc/B.n116 nfet_01v8_lvt_W1_L10_m2__nf1_gboth_sdfull_pc/B.n115 585
R9 nfet_01v8_lvt_W1_L10_m2__nf1_gboth_sdfull_pc/B.n150 nfet_01v8_lvt_W1_L10_m2__nf1_gboth_sdfull_pc/B.n116 585
R10 nfet_01v8_lvt_W1_L10_m2__nf1_gboth_sdfull_pc/B.n153 nfet_01v8_lvt_W1_L10_m2__nf1_gboth_sdfull_pc/B.n152 585
R11 nfet_01v8_lvt_W1_L10_m2__nf1_gboth_sdfull_pc/B.n152 nfet_01v8_lvt_W1_L10_m2__nf1_gboth_sdfull_pc/B.n151 585
R12 nfet_01v8_lvt_W1_L10_m2__nf1_gboth_sdfull_pc/B.n154 nfet_01v8_lvt_W1_L10_m2__nf1_gboth_sdfull_pc/B.n111 585
R13 nfet_01v8_lvt_W1_L10_m2__nf1_gboth_sdfull_pc/B.n111 nfet_01v8_lvt_W1_L10_m2__nf1_gboth_sdfull_pc/B.n110 585
R14 nfet_01v8_lvt_W1_L10_m2__nf1_gboth_sdfull_pc/B.n156 nfet_01v8_lvt_W1_L10_m2__nf1_gboth_sdfull_pc/B.n155 585
R15 nfet_01v8_lvt_W1_L10_m2__nf1_gboth_sdfull_pc/B.n157 nfet_01v8_lvt_W1_L10_m2__nf1_gboth_sdfull_pc/B.n156 585
R16 nfet_01v8_lvt_W1_L10_m2__nf1_gboth_sdfull_pc/B.n109 nfet_01v8_lvt_W1_L10_m2__nf1_gboth_sdfull_pc/B.n108 585
R17 nfet_01v8_lvt_W1_L10_m2__nf1_gboth_sdfull_pc/B.n158 nfet_01v8_lvt_W1_L10_m2__nf1_gboth_sdfull_pc/B.n109 585
R18 nfet_01v8_lvt_W1_L10_m2__nf1_gboth_sdfull_pc/B.n161 nfet_01v8_lvt_W1_L10_m2__nf1_gboth_sdfull_pc/B.n160 585
R19 nfet_01v8_lvt_W1_L10_m2__nf1_gboth_sdfull_pc/B.n160 nfet_01v8_lvt_W1_L10_m2__nf1_gboth_sdfull_pc/B.n159 585
R20 nfet_01v8_lvt_W1_L10_m2__nf1_gboth_sdfull_pc/B.n162 nfet_01v8_lvt_W1_L10_m2__nf1_gboth_sdfull_pc/B.n104 585
R21 nfet_01v8_lvt_W1_L10_m2__nf1_gboth_sdfull_pc/B.n104 nfet_01v8_lvt_W1_L10_m2__nf1_gboth_sdfull_pc/B.n103 585
R22 nfet_01v8_lvt_W1_L10_m2__nf1_gboth_sdfull_pc/B.n164 nfet_01v8_lvt_W1_L10_m2__nf1_gboth_sdfull_pc/B.n163 585
R23 nfet_01v8_lvt_W1_L10_m2__nf1_gboth_sdfull_pc/B.n165 nfet_01v8_lvt_W1_L10_m2__nf1_gboth_sdfull_pc/B.n164 585
R24 nfet_01v8_lvt_W1_L10_m2__nf1_gboth_sdfull_pc/B.n102 nfet_01v8_lvt_W1_L10_m2__nf1_gboth_sdfull_pc/B.n101 585
R25 nfet_01v8_lvt_W1_L10_m2__nf1_gboth_sdfull_pc/B.n166 nfet_01v8_lvt_W1_L10_m2__nf1_gboth_sdfull_pc/B.n102 585
R26 nfet_01v8_lvt_W1_L10_m2__nf1_gboth_sdfull_pc/B.n169 nfet_01v8_lvt_W1_L10_m2__nf1_gboth_sdfull_pc/B.n168 585
R27 nfet_01v8_lvt_W1_L10_m2__nf1_gboth_sdfull_pc/B.n168 nfet_01v8_lvt_W1_L10_m2__nf1_gboth_sdfull_pc/B.n167 585
R28 nfet_01v8_lvt_W1_L10_m2__nf1_gboth_sdfull_pc/B.n170 nfet_01v8_lvt_W1_L10_m2__nf1_gboth_sdfull_pc/B.n97 585
R29 nfet_01v8_lvt_W1_L10_m2__nf1_gboth_sdfull_pc/B.n97 nfet_01v8_lvt_W1_L10_m2__nf1_gboth_sdfull_pc/B.n96 585
R30 nfet_01v8_lvt_W1_L10_m2__nf1_gboth_sdfull_pc/B.n172 nfet_01v8_lvt_W1_L10_m2__nf1_gboth_sdfull_pc/B.n171 585
R31 nfet_01v8_lvt_W1_L10_m2__nf1_gboth_sdfull_pc/B.n173 nfet_01v8_lvt_W1_L10_m2__nf1_gboth_sdfull_pc/B.n172 585
R32 nfet_01v8_lvt_W1_L10_m2__nf1_gboth_sdfull_pc/B.n6 nfet_01v8_lvt_W1_L10_m2__nf1_gboth_sdfull_pc/B.n4 585
R33 nfet_01v8_lvt_W1_L10_m2__nf1_gboth_sdfull_pc/B.n174 nfet_01v8_lvt_W1_L10_m2__nf1_gboth_sdfull_pc/B.n6 585
R34 nfet_01v8_lvt_W1_L10_m2__nf1_gboth_sdfull_pc/B.n177 nfet_01v8_lvt_W1_L10_m2__nf1_gboth_sdfull_pc/B.n176 585
R35 nfet_01v8_lvt_W1_L10_m2__nf1_gboth_sdfull_pc/B.n176 nfet_01v8_lvt_W1_L10_m2__nf1_gboth_sdfull_pc/B.n175 585
R36 nfet_01v8_lvt_W1_L10_m2__nf1_gboth_sdfull_pc/B.n5 nfet_01v8_lvt_W1_L10_m2__nf1_gboth_sdfull_pc/B.t0 585
R37 nfet_01v8_lvt_W1_L10_m2__nf1_gboth_sdfull_pc/B.n95 nfet_01v8_lvt_W1_L10_m2__nf1_gboth_sdfull_pc/B.n5 585
R38 nfet_01v8_lvt_W1_L10_m2__nf1_gboth_sdfull_pc/B.n93 nfet_01v8_lvt_W1_L10_m2__nf1_gboth_sdfull_pc/B.n92 585
R39 nfet_01v8_lvt_W1_L10_m2__nf1_gboth_sdfull_pc/B.n94 nfet_01v8_lvt_W1_L10_m2__nf1_gboth_sdfull_pc/B.n93 585
R40 nfet_01v8_lvt_W1_L10_m2__nf1_gboth_sdfull_pc/B.n9 nfet_01v8_lvt_W1_L10_m2__nf1_gboth_sdfull_pc/B.n8 585
R41 nfet_01v8_lvt_W1_L10_m2__nf1_gboth_sdfull_pc/B.n8 nfet_01v8_lvt_W1_L10_m2__nf1_gboth_sdfull_pc/B.n7 585
R42 nfet_01v8_lvt_W1_L10_m2__nf1_gboth_sdfull_pc/B.n86 nfet_01v8_lvt_W1_L10_m2__nf1_gboth_sdfull_pc/B.n85 585
R43 nfet_01v8_lvt_W1_L10_m2__nf1_gboth_sdfull_pc/B.n85 nfet_01v8_lvt_W1_L10_m2__nf1_gboth_sdfull_pc/B.n84 585
R44 nfet_01v8_lvt_W1_L10_m2__nf1_gboth_sdfull_pc/B.n14 nfet_01v8_lvt_W1_L10_m2__nf1_gboth_sdfull_pc/B.n13 585
R45 nfet_01v8_lvt_W1_L10_m2__nf1_gboth_sdfull_pc/B.n83 nfet_01v8_lvt_W1_L10_m2__nf1_gboth_sdfull_pc/B.n14 585
R46 nfet_01v8_lvt_W1_L10_m2__nf1_gboth_sdfull_pc/B.n81 nfet_01v8_lvt_W1_L10_m2__nf1_gboth_sdfull_pc/B.n80 585
R47 nfet_01v8_lvt_W1_L10_m2__nf1_gboth_sdfull_pc/B.n82 nfet_01v8_lvt_W1_L10_m2__nf1_gboth_sdfull_pc/B.n81 585
R48 nfet_01v8_lvt_W1_L10_m2__nf1_gboth_sdfull_pc/B.n17 nfet_01v8_lvt_W1_L10_m2__nf1_gboth_sdfull_pc/B.n16 585
R49 nfet_01v8_lvt_W1_L10_m2__nf1_gboth_sdfull_pc/B.n16 nfet_01v8_lvt_W1_L10_m2__nf1_gboth_sdfull_pc/B.n15 585
R50 nfet_01v8_lvt_W1_L10_m2__nf1_gboth_sdfull_pc/B.n74 nfet_01v8_lvt_W1_L10_m2__nf1_gboth_sdfull_pc/B.n73 585
R51 nfet_01v8_lvt_W1_L10_m2__nf1_gboth_sdfull_pc/B.n73 nfet_01v8_lvt_W1_L10_m2__nf1_gboth_sdfull_pc/B.n72 585
R52 nfet_01v8_lvt_W1_L10_m2__nf1_gboth_sdfull_pc/B.n22 nfet_01v8_lvt_W1_L10_m2__nf1_gboth_sdfull_pc/B.n21 585
R53 nfet_01v8_lvt_W1_L10_m2__nf1_gboth_sdfull_pc/B.n71 nfet_01v8_lvt_W1_L10_m2__nf1_gboth_sdfull_pc/B.n22 585
R54 nfet_01v8_lvt_W1_L10_m2__nf1_gboth_sdfull_pc/B.n69 nfet_01v8_lvt_W1_L10_m2__nf1_gboth_sdfull_pc/B.n68 585
R55 nfet_01v8_lvt_W1_L10_m2__nf1_gboth_sdfull_pc/B.n70 nfet_01v8_lvt_W1_L10_m2__nf1_gboth_sdfull_pc/B.n69 585
R56 nfet_01v8_lvt_W1_L10_m2__nf1_gboth_sdfull_pc/B.n25 nfet_01v8_lvt_W1_L10_m2__nf1_gboth_sdfull_pc/B.n24 585
R57 nfet_01v8_lvt_W1_L10_m2__nf1_gboth_sdfull_pc/B.n24 nfet_01v8_lvt_W1_L10_m2__nf1_gboth_sdfull_pc/B.n23 585
R58 nfet_01v8_lvt_W1_L10_m2__nf1_gboth_sdfull_pc/B.n62 nfet_01v8_lvt_W1_L10_m2__nf1_gboth_sdfull_pc/B.n61 585
R59 nfet_01v8_lvt_W1_L10_m2__nf1_gboth_sdfull_pc/B.n61 nfet_01v8_lvt_W1_L10_m2__nf1_gboth_sdfull_pc/B.n60 585
R60 nfet_01v8_lvt_W1_L10_m2__nf1_gboth_sdfull_pc/B.n30 nfet_01v8_lvt_W1_L10_m2__nf1_gboth_sdfull_pc/B.n29 585
R61 nfet_01v8_lvt_W1_L10_m2__nf1_gboth_sdfull_pc/B.n59 nfet_01v8_lvt_W1_L10_m2__nf1_gboth_sdfull_pc/B.n30 585
R62 nfet_01v8_lvt_W1_L10_m2__nf1_gboth_sdfull_pc/B.n57 nfet_01v8_lvt_W1_L10_m2__nf1_gboth_sdfull_pc/B.n56 585
R63 nfet_01v8_lvt_W1_L10_m2__nf1_gboth_sdfull_pc/B.n58 nfet_01v8_lvt_W1_L10_m2__nf1_gboth_sdfull_pc/B.n57 585
R64 nfet_01v8_lvt_W1_L10_m2__nf1_gboth_sdfull_pc/B.n33 nfet_01v8_lvt_W1_L10_m2__nf1_gboth_sdfull_pc/B.n32 585
R65 nfet_01v8_lvt_W1_L10_m2__nf1_gboth_sdfull_pc/B.n32 nfet_01v8_lvt_W1_L10_m2__nf1_gboth_sdfull_pc/B.n31 585
R66 nfet_01v8_lvt_W1_L10_m2__nf1_gboth_sdfull_pc/B.n50 nfet_01v8_lvt_W1_L10_m2__nf1_gboth_sdfull_pc/B.n49 585
R67 nfet_01v8_lvt_W1_L10_m2__nf1_gboth_sdfull_pc/B.n49 nfet_01v8_lvt_W1_L10_m2__nf1_gboth_sdfull_pc/B.n48 585
R68 nfet_01v8_lvt_W1_L10_m2__nf1_gboth_sdfull_pc/B.n38 nfet_01v8_lvt_W1_L10_m2__nf1_gboth_sdfull_pc/B.n37 585
R69 nfet_01v8_lvt_W1_L10_m2__nf1_gboth_sdfull_pc/B.n47 nfet_01v8_lvt_W1_L10_m2__nf1_gboth_sdfull_pc/B.n38 585
R70 nfet_01v8_lvt_W1_L10_m2__nf1_gboth_sdfull_pc/B.n46 nfet_01v8_lvt_W1_L10_m2__nf1_gboth_sdfull_pc/B.n45 585
R71 nfet_01v8_lvt_W1_L10_m2__nf1_gboth_sdfull_pc/B.n43 nfet_01v8_lvt_W1_L10_m2__nf1_gboth_sdfull_pc/B.n39 585
R72 nfet_01v8_lvt_W1_L10_m2__nf1_gboth_sdfull_pc/B.n42 nfet_01v8_lvt_W1_L10_m2__nf1_gboth_sdfull_pc/B.n40 585
R73 nfet_01v8_lvt_W1_L10_m2__nf1_gboth_sdfull_pc/B.n36 nfet_01v8_lvt_W1_L10_m2__nf1_gboth_sdfull_pc/B.n35 585
R74 nfet_01v8_lvt_W1_L10_m2__nf1_gboth_sdfull_pc/B.n51 nfet_01v8_lvt_W1_L10_m2__nf1_gboth_sdfull_pc/B.n50 585
R75 nfet_01v8_lvt_W1_L10_m2__nf1_gboth_sdfull_pc/B.n52 nfet_01v8_lvt_W1_L10_m2__nf1_gboth_sdfull_pc/B.n51 585
R76 nfet_01v8_lvt_W1_L10_m2__nf1_gboth_sdfull_pc/B.n34 nfet_01v8_lvt_W1_L10_m2__nf1_gboth_sdfull_pc/B.n33 585
R77 nfet_01v8_lvt_W1_L10_m2__nf1_gboth_sdfull_pc/B.n53 nfet_01v8_lvt_W1_L10_m2__nf1_gboth_sdfull_pc/B.n34 585
R78 nfet_01v8_lvt_W1_L10_m2__nf1_gboth_sdfull_pc/B.n56 nfet_01v8_lvt_W1_L10_m2__nf1_gboth_sdfull_pc/B.n55 585
R79 nfet_01v8_lvt_W1_L10_m2__nf1_gboth_sdfull_pc/B.n55 nfet_01v8_lvt_W1_L10_m2__nf1_gboth_sdfull_pc/B.n54 585
R80 nfet_01v8_lvt_W1_L10_m2__nf1_gboth_sdfull_pc/B.n29 nfet_01v8_lvt_W1_L10_m2__nf1_gboth_sdfull_pc/B.n28 585
R81 nfet_01v8_lvt_W1_L10_m2__nf1_gboth_sdfull_pc/B.n28 nfet_01v8_lvt_W1_L10_m2__nf1_gboth_sdfull_pc/B.n27 585
R82 nfet_01v8_lvt_W1_L10_m2__nf1_gboth_sdfull_pc/B.n63 nfet_01v8_lvt_W1_L10_m2__nf1_gboth_sdfull_pc/B.n62 585
R83 nfet_01v8_lvt_W1_L10_m2__nf1_gboth_sdfull_pc/B.n64 nfet_01v8_lvt_W1_L10_m2__nf1_gboth_sdfull_pc/B.n63 585
R84 nfet_01v8_lvt_W1_L10_m2__nf1_gboth_sdfull_pc/B.n26 nfet_01v8_lvt_W1_L10_m2__nf1_gboth_sdfull_pc/B.n25 585
R85 nfet_01v8_lvt_W1_L10_m2__nf1_gboth_sdfull_pc/B.n65 nfet_01v8_lvt_W1_L10_m2__nf1_gboth_sdfull_pc/B.n26 585
R86 nfet_01v8_lvt_W1_L10_m2__nf1_gboth_sdfull_pc/B.n68 nfet_01v8_lvt_W1_L10_m2__nf1_gboth_sdfull_pc/B.n67 585
R87 nfet_01v8_lvt_W1_L10_m2__nf1_gboth_sdfull_pc/B.n67 nfet_01v8_lvt_W1_L10_m2__nf1_gboth_sdfull_pc/B.n66 585
R88 nfet_01v8_lvt_W1_L10_m2__nf1_gboth_sdfull_pc/B.n21 nfet_01v8_lvt_W1_L10_m2__nf1_gboth_sdfull_pc/B.n20 585
R89 nfet_01v8_lvt_W1_L10_m2__nf1_gboth_sdfull_pc/B.n20 nfet_01v8_lvt_W1_L10_m2__nf1_gboth_sdfull_pc/B.n19 585
R90 nfet_01v8_lvt_W1_L10_m2__nf1_gboth_sdfull_pc/B.n75 nfet_01v8_lvt_W1_L10_m2__nf1_gboth_sdfull_pc/B.n74 585
R91 nfet_01v8_lvt_W1_L10_m2__nf1_gboth_sdfull_pc/B.n76 nfet_01v8_lvt_W1_L10_m2__nf1_gboth_sdfull_pc/B.n75 585
R92 nfet_01v8_lvt_W1_L10_m2__nf1_gboth_sdfull_pc/B.n18 nfet_01v8_lvt_W1_L10_m2__nf1_gboth_sdfull_pc/B.n17 585
R93 nfet_01v8_lvt_W1_L10_m2__nf1_gboth_sdfull_pc/B.n77 nfet_01v8_lvt_W1_L10_m2__nf1_gboth_sdfull_pc/B.n18 585
R94 nfet_01v8_lvt_W1_L10_m2__nf1_gboth_sdfull_pc/B.n80 nfet_01v8_lvt_W1_L10_m2__nf1_gboth_sdfull_pc/B.n79 585
R95 nfet_01v8_lvt_W1_L10_m2__nf1_gboth_sdfull_pc/B.n79 nfet_01v8_lvt_W1_L10_m2__nf1_gboth_sdfull_pc/B.n78 585
R96 nfet_01v8_lvt_W1_L10_m2__nf1_gboth_sdfull_pc/B.n13 nfet_01v8_lvt_W1_L10_m2__nf1_gboth_sdfull_pc/B.n12 585
R97 nfet_01v8_lvt_W1_L10_m2__nf1_gboth_sdfull_pc/B.n12 nfet_01v8_lvt_W1_L10_m2__nf1_gboth_sdfull_pc/B.n11 585
R98 nfet_01v8_lvt_W1_L10_m2__nf1_gboth_sdfull_pc/B.n87 nfet_01v8_lvt_W1_L10_m2__nf1_gboth_sdfull_pc/B.n86 585
R99 nfet_01v8_lvt_W1_L10_m2__nf1_gboth_sdfull_pc/B.n88 nfet_01v8_lvt_W1_L10_m2__nf1_gboth_sdfull_pc/B.n87 585
R100 nfet_01v8_lvt_W1_L10_m2__nf1_gboth_sdfull_pc/B.n10 nfet_01v8_lvt_W1_L10_m2__nf1_gboth_sdfull_pc/B.n9 585
R101 nfet_01v8_lvt_W1_L10_m2__nf1_gboth_sdfull_pc/B.n89 nfet_01v8_lvt_W1_L10_m2__nf1_gboth_sdfull_pc/B.n10 585
R102 nfet_01v8_lvt_W1_L10_m2__nf1_gboth_sdfull_pc/B.n92 nfet_01v8_lvt_W1_L10_m2__nf1_gboth_sdfull_pc/B.n91 585
R103 nfet_01v8_lvt_W1_L10_m2__nf1_gboth_sdfull_pc/B.n91 nfet_01v8_lvt_W1_L10_m2__nf1_gboth_sdfull_pc/B.n90 585
R104 nfet_01v8_lvt_W1_L10_m2__nf1_gboth_sdfull_pc/B.t0 nfet_01v8_lvt_W1_L10_m2__nf1_gboth_sdfull_pc/B.n2 585
R105 nfet_01v8_lvt_W1_L10_m2__nf1_gboth_sdfull_pc/B.n2 nfet_01v8_lvt_W1_L10_m2__nf1_gboth_sdfull_pc/B.n0 585
R106 nfet_01v8_lvt_W1_L10_m2__nf1_gboth_sdfull_pc/B.n178 nfet_01v8_lvt_W1_L10_m2__nf1_gboth_sdfull_pc/B.n177 585
R107 nfet_01v8_lvt_W1_L10_m2__nf1_gboth_sdfull_pc/B.n179 nfet_01v8_lvt_W1_L10_m2__nf1_gboth_sdfull_pc/B.n178 585
R108 nfet_01v8_lvt_W1_L10_m2__nf1_gboth_sdfull_pc/B.n4 nfet_01v8_lvt_W1_L10_m2__nf1_gboth_sdfull_pc/B.n3 585
R109 nfet_01v8_lvt_W1_L10_m2__nf1_gboth_sdfull_pc/B.n3 nfet_01v8_lvt_W1_L10_m2__nf1_gboth_sdfull_pc/B.n1 585
R110 nfet_01v8_lvt_W1_L10_m2__nf1_gboth_sdfull_pc/B.n171 nfet_01v8_lvt_W1_L10_m2__nf1_gboth_sdfull_pc/B.n98 585
R111 nfet_01v8_lvt_W1_L10_m2__nf1_gboth_sdfull_pc/B.n122 nfet_01v8_lvt_W1_L10_m2__nf1_gboth_sdfull_pc/B.n98 585
R112 nfet_01v8_lvt_W1_L10_m2__nf1_gboth_sdfull_pc/B.n170 nfet_01v8_lvt_W1_L10_m2__nf1_gboth_sdfull_pc/B.n99 585
R113 nfet_01v8_lvt_W1_L10_m2__nf1_gboth_sdfull_pc/B.n123 nfet_01v8_lvt_W1_L10_m2__nf1_gboth_sdfull_pc/B.n99 585
R114 nfet_01v8_lvt_W1_L10_m2__nf1_gboth_sdfull_pc/B.n169 nfet_01v8_lvt_W1_L10_m2__nf1_gboth_sdfull_pc/B.n100 585
R115 nfet_01v8_lvt_W1_L10_m2__nf1_gboth_sdfull_pc/B.n124 nfet_01v8_lvt_W1_L10_m2__nf1_gboth_sdfull_pc/B.n100 585
R116 nfet_01v8_lvt_W1_L10_m2__nf1_gboth_sdfull_pc/B.n125 nfet_01v8_lvt_W1_L10_m2__nf1_gboth_sdfull_pc/B.n101 585
R117 nfet_01v8_lvt_W1_L10_m2__nf1_gboth_sdfull_pc/B.n126 nfet_01v8_lvt_W1_L10_m2__nf1_gboth_sdfull_pc/B.n125 585
R118 nfet_01v8_lvt_W1_L10_m2__nf1_gboth_sdfull_pc/B.n163 nfet_01v8_lvt_W1_L10_m2__nf1_gboth_sdfull_pc/B.n105 585
R119 nfet_01v8_lvt_W1_L10_m2__nf1_gboth_sdfull_pc/B.n127 nfet_01v8_lvt_W1_L10_m2__nf1_gboth_sdfull_pc/B.n105 585
R120 nfet_01v8_lvt_W1_L10_m2__nf1_gboth_sdfull_pc/B.n162 nfet_01v8_lvt_W1_L10_m2__nf1_gboth_sdfull_pc/B.n106 585
R121 nfet_01v8_lvt_W1_L10_m2__nf1_gboth_sdfull_pc/B.n128 nfet_01v8_lvt_W1_L10_m2__nf1_gboth_sdfull_pc/B.n106 585
R122 nfet_01v8_lvt_W1_L10_m2__nf1_gboth_sdfull_pc/B.n161 nfet_01v8_lvt_W1_L10_m2__nf1_gboth_sdfull_pc/B.n107 585
R123 nfet_01v8_lvt_W1_L10_m2__nf1_gboth_sdfull_pc/B.n129 nfet_01v8_lvt_W1_L10_m2__nf1_gboth_sdfull_pc/B.n107 585
R124 nfet_01v8_lvt_W1_L10_m2__nf1_gboth_sdfull_pc/B.n130 nfet_01v8_lvt_W1_L10_m2__nf1_gboth_sdfull_pc/B.n108 585
R125 nfet_01v8_lvt_W1_L10_m2__nf1_gboth_sdfull_pc/B.n131 nfet_01v8_lvt_W1_L10_m2__nf1_gboth_sdfull_pc/B.n130 585
R126 nfet_01v8_lvt_W1_L10_m2__nf1_gboth_sdfull_pc/B.n155 nfet_01v8_lvt_W1_L10_m2__nf1_gboth_sdfull_pc/B.n112 585
R127 nfet_01v8_lvt_W1_L10_m2__nf1_gboth_sdfull_pc/B.n132 nfet_01v8_lvt_W1_L10_m2__nf1_gboth_sdfull_pc/B.n112 585
R128 nfet_01v8_lvt_W1_L10_m2__nf1_gboth_sdfull_pc/B.n154 nfet_01v8_lvt_W1_L10_m2__nf1_gboth_sdfull_pc/B.n113 585
R129 nfet_01v8_lvt_W1_L10_m2__nf1_gboth_sdfull_pc/B.n133 nfet_01v8_lvt_W1_L10_m2__nf1_gboth_sdfull_pc/B.n113 585
R130 nfet_01v8_lvt_W1_L10_m2__nf1_gboth_sdfull_pc/B.n153 nfet_01v8_lvt_W1_L10_m2__nf1_gboth_sdfull_pc/B.n114 585
R131 nfet_01v8_lvt_W1_L10_m2__nf1_gboth_sdfull_pc/B.n134 nfet_01v8_lvt_W1_L10_m2__nf1_gboth_sdfull_pc/B.n114 585
R132 nfet_01v8_lvt_W1_L10_m2__nf1_gboth_sdfull_pc/B.n135 nfet_01v8_lvt_W1_L10_m2__nf1_gboth_sdfull_pc/B.n115 585
R133 nfet_01v8_lvt_W1_L10_m2__nf1_gboth_sdfull_pc/B.n136 nfet_01v8_lvt_W1_L10_m2__nf1_gboth_sdfull_pc/B.n135 585
R134 nfet_01v8_lvt_W1_L10_m2__nf1_gboth_sdfull_pc/B.n147 nfet_01v8_lvt_W1_L10_m2__nf1_gboth_sdfull_pc/B.n119 585
R135 nfet_01v8_lvt_W1_L10_m2__nf1_gboth_sdfull_pc/B.n137 nfet_01v8_lvt_W1_L10_m2__nf1_gboth_sdfull_pc/B.n119 585
R136 nfet_01v8_lvt_W1_L10_m2__nf1_gboth_sdfull_pc/B.n139 nfet_01v8_lvt_W1_L10_m2__nf1_gboth_sdfull_pc/B.n138 585
R137 nfet_01v8_lvt_W1_L10_m2__nf1_gboth_sdfull_pc/B.n141 nfet_01v8_lvt_W1_L10_m2__nf1_gboth_sdfull_pc/B.n140 585
R138 nfet_01v8_lvt_W1_L10_m2__nf1_gboth_sdfull_pc/B.n146 nfet_01v8_lvt_W1_L10_m2__nf1_gboth_sdfull_pc/B.n121 585
R139 nfet_01v8_lvt_W1_L10_m2__nf1_gboth_sdfull_pc/B.n142 nfet_01v8_lvt_W1_L10_m2__nf1_gboth_sdfull_pc/B.n121 585
R140 nfet_01v8_lvt_W1_L10_m2__nf1_gboth_sdfull_pc/B.n144 nfet_01v8_lvt_W1_L10_m2__nf1_gboth_sdfull_pc/B.n143 585
R141 nfet_01v8_lvt_W1_L10_m2__nf1_gboth_sdfull_pc/B.n118 nfet_01v8_lvt_W1_L10_m2__nf1_gboth_sdfull_pc/B.n117 585
R142 nfet_01v8_lvt_W1_L10_m2__nf1_gboth_sdfull_pc/B.n147 nfet_01v8_lvt_W1_L10_m2__nf1_gboth_sdfull_pc/B.n115 498.668
R143 nfet_01v8_lvt_W1_L10_m2__nf1_gboth_sdfull_pc/B.n153 nfet_01v8_lvt_W1_L10_m2__nf1_gboth_sdfull_pc/B.n115 498.668
R144 nfet_01v8_lvt_W1_L10_m2__nf1_gboth_sdfull_pc/B.n154 nfet_01v8_lvt_W1_L10_m2__nf1_gboth_sdfull_pc/B.n153 498.668
R145 nfet_01v8_lvt_W1_L10_m2__nf1_gboth_sdfull_pc/B.n155 nfet_01v8_lvt_W1_L10_m2__nf1_gboth_sdfull_pc/B.n154 498.668
R146 nfet_01v8_lvt_W1_L10_m2__nf1_gboth_sdfull_pc/B.n155 nfet_01v8_lvt_W1_L10_m2__nf1_gboth_sdfull_pc/B.n108 498.668
R147 nfet_01v8_lvt_W1_L10_m2__nf1_gboth_sdfull_pc/B.n161 nfet_01v8_lvt_W1_L10_m2__nf1_gboth_sdfull_pc/B.n108 498.668
R148 nfet_01v8_lvt_W1_L10_m2__nf1_gboth_sdfull_pc/B.n162 nfet_01v8_lvt_W1_L10_m2__nf1_gboth_sdfull_pc/B.n161 498.668
R149 nfet_01v8_lvt_W1_L10_m2__nf1_gboth_sdfull_pc/B.n163 nfet_01v8_lvt_W1_L10_m2__nf1_gboth_sdfull_pc/B.n162 498.668
R150 nfet_01v8_lvt_W1_L10_m2__nf1_gboth_sdfull_pc/B.n163 nfet_01v8_lvt_W1_L10_m2__nf1_gboth_sdfull_pc/B.n101 498.668
R151 nfet_01v8_lvt_W1_L10_m2__nf1_gboth_sdfull_pc/B.n169 nfet_01v8_lvt_W1_L10_m2__nf1_gboth_sdfull_pc/B.n101 498.668
R152 nfet_01v8_lvt_W1_L10_m2__nf1_gboth_sdfull_pc/B.n170 nfet_01v8_lvt_W1_L10_m2__nf1_gboth_sdfull_pc/B.n169 498.668
R153 nfet_01v8_lvt_W1_L10_m2__nf1_gboth_sdfull_pc/B.n171 nfet_01v8_lvt_W1_L10_m2__nf1_gboth_sdfull_pc/B.n170 498.668
R154 nfet_01v8_lvt_W1_L10_m2__nf1_gboth_sdfull_pc/B.n171 nfet_01v8_lvt_W1_L10_m2__nf1_gboth_sdfull_pc/B.n4 498.668
R155 nfet_01v8_lvt_W1_L10_m2__nf1_gboth_sdfull_pc/B.n177 nfet_01v8_lvt_W1_L10_m2__nf1_gboth_sdfull_pc/B.n4 498.668
R156 nfet_01v8_lvt_W1_L10_m2__nf1_gboth_sdfull_pc/B.n177 nfet_01v8_lvt_W1_L10_m2__nf1_gboth_sdfull_pc/B.t0 498.668
R157 nfet_01v8_lvt_W1_L10_m2__nf1_gboth_sdfull_pc/B.n92 nfet_01v8_lvt_W1_L10_m2__nf1_gboth_sdfull_pc/B.t0 498.668
R158 nfet_01v8_lvt_W1_L10_m2__nf1_gboth_sdfull_pc/B.n92 nfet_01v8_lvt_W1_L10_m2__nf1_gboth_sdfull_pc/B.n9 498.668
R159 nfet_01v8_lvt_W1_L10_m2__nf1_gboth_sdfull_pc/B.n86 nfet_01v8_lvt_W1_L10_m2__nf1_gboth_sdfull_pc/B.n9 498.668
R160 nfet_01v8_lvt_W1_L10_m2__nf1_gboth_sdfull_pc/B.n86 nfet_01v8_lvt_W1_L10_m2__nf1_gboth_sdfull_pc/B.n13 498.668
R161 nfet_01v8_lvt_W1_L10_m2__nf1_gboth_sdfull_pc/B.n80 nfet_01v8_lvt_W1_L10_m2__nf1_gboth_sdfull_pc/B.n13 498.668
R162 nfet_01v8_lvt_W1_L10_m2__nf1_gboth_sdfull_pc/B.n80 nfet_01v8_lvt_W1_L10_m2__nf1_gboth_sdfull_pc/B.n17 498.668
R163 nfet_01v8_lvt_W1_L10_m2__nf1_gboth_sdfull_pc/B.n74 nfet_01v8_lvt_W1_L10_m2__nf1_gboth_sdfull_pc/B.n17 498.668
R164 nfet_01v8_lvt_W1_L10_m2__nf1_gboth_sdfull_pc/B.n74 nfet_01v8_lvt_W1_L10_m2__nf1_gboth_sdfull_pc/B.n21 498.668
R165 nfet_01v8_lvt_W1_L10_m2__nf1_gboth_sdfull_pc/B.n68 nfet_01v8_lvt_W1_L10_m2__nf1_gboth_sdfull_pc/B.n21 498.668
R166 nfet_01v8_lvt_W1_L10_m2__nf1_gboth_sdfull_pc/B.n68 nfet_01v8_lvt_W1_L10_m2__nf1_gboth_sdfull_pc/B.n25 498.668
R167 nfet_01v8_lvt_W1_L10_m2__nf1_gboth_sdfull_pc/B.n62 nfet_01v8_lvt_W1_L10_m2__nf1_gboth_sdfull_pc/B.n25 498.668
R168 nfet_01v8_lvt_W1_L10_m2__nf1_gboth_sdfull_pc/B.n62 nfet_01v8_lvt_W1_L10_m2__nf1_gboth_sdfull_pc/B.n29 498.668
R169 nfet_01v8_lvt_W1_L10_m2__nf1_gboth_sdfull_pc/B.n56 nfet_01v8_lvt_W1_L10_m2__nf1_gboth_sdfull_pc/B.n29 498.668
R170 nfet_01v8_lvt_W1_L10_m2__nf1_gboth_sdfull_pc/B.n56 nfet_01v8_lvt_W1_L10_m2__nf1_gboth_sdfull_pc/B.n33 498.668
R171 nfet_01v8_lvt_W1_L10_m2__nf1_gboth_sdfull_pc/B.n50 nfet_01v8_lvt_W1_L10_m2__nf1_gboth_sdfull_pc/B.n33 498.668
R172 nfet_01v8_lvt_W1_L10_m2__nf1_gboth_sdfull_pc/B.n140 nfet_01v8_lvt_W1_L10_m2__nf1_gboth_sdfull_pc/B.n121 394
R173 nfet_01v8_lvt_W1_L10_m2__nf1_gboth_sdfull_pc/B.n144 nfet_01v8_lvt_W1_L10_m2__nf1_gboth_sdfull_pc/B.n121 394
R174 nfet_01v8_lvt_W1_L10_m2__nf1_gboth_sdfull_pc/B.n135 nfet_01v8_lvt_W1_L10_m2__nf1_gboth_sdfull_pc/B.n119 394
R175 nfet_01v8_lvt_W1_L10_m2__nf1_gboth_sdfull_pc/B.n135 nfet_01v8_lvt_W1_L10_m2__nf1_gboth_sdfull_pc/B.n114 394
R176 nfet_01v8_lvt_W1_L10_m2__nf1_gboth_sdfull_pc/B.n114 nfet_01v8_lvt_W1_L10_m2__nf1_gboth_sdfull_pc/B.n113 394
R177 nfet_01v8_lvt_W1_L10_m2__nf1_gboth_sdfull_pc/B.n113 nfet_01v8_lvt_W1_L10_m2__nf1_gboth_sdfull_pc/B.n112 394
R178 nfet_01v8_lvt_W1_L10_m2__nf1_gboth_sdfull_pc/B.n130 nfet_01v8_lvt_W1_L10_m2__nf1_gboth_sdfull_pc/B.n112 394
R179 nfet_01v8_lvt_W1_L10_m2__nf1_gboth_sdfull_pc/B.n130 nfet_01v8_lvt_W1_L10_m2__nf1_gboth_sdfull_pc/B.n107 394
R180 nfet_01v8_lvt_W1_L10_m2__nf1_gboth_sdfull_pc/B.n107 nfet_01v8_lvt_W1_L10_m2__nf1_gboth_sdfull_pc/B.n106 394
R181 nfet_01v8_lvt_W1_L10_m2__nf1_gboth_sdfull_pc/B.n106 nfet_01v8_lvt_W1_L10_m2__nf1_gboth_sdfull_pc/B.n105 394
R182 nfet_01v8_lvt_W1_L10_m2__nf1_gboth_sdfull_pc/B.n125 nfet_01v8_lvt_W1_L10_m2__nf1_gboth_sdfull_pc/B.n105 394
R183 nfet_01v8_lvt_W1_L10_m2__nf1_gboth_sdfull_pc/B.n125 nfet_01v8_lvt_W1_L10_m2__nf1_gboth_sdfull_pc/B.n100 394
R184 nfet_01v8_lvt_W1_L10_m2__nf1_gboth_sdfull_pc/B.n100 nfet_01v8_lvt_W1_L10_m2__nf1_gboth_sdfull_pc/B.n99 394
R185 nfet_01v8_lvt_W1_L10_m2__nf1_gboth_sdfull_pc/B.n99 nfet_01v8_lvt_W1_L10_m2__nf1_gboth_sdfull_pc/B.n98 394
R186 nfet_01v8_lvt_W1_L10_m2__nf1_gboth_sdfull_pc/B.n98 nfet_01v8_lvt_W1_L10_m2__nf1_gboth_sdfull_pc/B.n3 394
R187 nfet_01v8_lvt_W1_L10_m2__nf1_gboth_sdfull_pc/B.n178 nfet_01v8_lvt_W1_L10_m2__nf1_gboth_sdfull_pc/B.n3 394
R188 nfet_01v8_lvt_W1_L10_m2__nf1_gboth_sdfull_pc/B.n178 nfet_01v8_lvt_W1_L10_m2__nf1_gboth_sdfull_pc/B.n2 394
R189 nfet_01v8_lvt_W1_L10_m2__nf1_gboth_sdfull_pc/B.n91 nfet_01v8_lvt_W1_L10_m2__nf1_gboth_sdfull_pc/B.n2 394
R190 nfet_01v8_lvt_W1_L10_m2__nf1_gboth_sdfull_pc/B.n91 nfet_01v8_lvt_W1_L10_m2__nf1_gboth_sdfull_pc/B.n10 394
R191 nfet_01v8_lvt_W1_L10_m2__nf1_gboth_sdfull_pc/B.n87 nfet_01v8_lvt_W1_L10_m2__nf1_gboth_sdfull_pc/B.n10 394
R192 nfet_01v8_lvt_W1_L10_m2__nf1_gboth_sdfull_pc/B.n87 nfet_01v8_lvt_W1_L10_m2__nf1_gboth_sdfull_pc/B.n12 394
R193 nfet_01v8_lvt_W1_L10_m2__nf1_gboth_sdfull_pc/B.n79 nfet_01v8_lvt_W1_L10_m2__nf1_gboth_sdfull_pc/B.n12 394
R194 nfet_01v8_lvt_W1_L10_m2__nf1_gboth_sdfull_pc/B.n79 nfet_01v8_lvt_W1_L10_m2__nf1_gboth_sdfull_pc/B.n18 394
R195 nfet_01v8_lvt_W1_L10_m2__nf1_gboth_sdfull_pc/B.n75 nfet_01v8_lvt_W1_L10_m2__nf1_gboth_sdfull_pc/B.n18 394
R196 nfet_01v8_lvt_W1_L10_m2__nf1_gboth_sdfull_pc/B.n75 nfet_01v8_lvt_W1_L10_m2__nf1_gboth_sdfull_pc/B.n20 394
R197 nfet_01v8_lvt_W1_L10_m2__nf1_gboth_sdfull_pc/B.n67 nfet_01v8_lvt_W1_L10_m2__nf1_gboth_sdfull_pc/B.n20 394
R198 nfet_01v8_lvt_W1_L10_m2__nf1_gboth_sdfull_pc/B.n67 nfet_01v8_lvt_W1_L10_m2__nf1_gboth_sdfull_pc/B.n26 394
R199 nfet_01v8_lvt_W1_L10_m2__nf1_gboth_sdfull_pc/B.n63 nfet_01v8_lvt_W1_L10_m2__nf1_gboth_sdfull_pc/B.n26 394
R200 nfet_01v8_lvt_W1_L10_m2__nf1_gboth_sdfull_pc/B.n63 nfet_01v8_lvt_W1_L10_m2__nf1_gboth_sdfull_pc/B.n28 394
R201 nfet_01v8_lvt_W1_L10_m2__nf1_gboth_sdfull_pc/B.n55 nfet_01v8_lvt_W1_L10_m2__nf1_gboth_sdfull_pc/B.n28 394
R202 nfet_01v8_lvt_W1_L10_m2__nf1_gboth_sdfull_pc/B.n55 nfet_01v8_lvt_W1_L10_m2__nf1_gboth_sdfull_pc/B.n34 394
R203 nfet_01v8_lvt_W1_L10_m2__nf1_gboth_sdfull_pc/B.n51 nfet_01v8_lvt_W1_L10_m2__nf1_gboth_sdfull_pc/B.n34 394
R204 nfet_01v8_lvt_W1_L10_m2__nf1_gboth_sdfull_pc/B.n43 nfet_01v8_lvt_W1_L10_m2__nf1_gboth_sdfull_pc/B.n42 394
R205 nfet_01v8_lvt_W1_L10_m2__nf1_gboth_sdfull_pc/B.n45 nfet_01v8_lvt_W1_L10_m2__nf1_gboth_sdfull_pc/B.n38 394
R206 nfet_01v8_lvt_W1_L10_m2__nf1_gboth_sdfull_pc/B.n148 nfet_01v8_lvt_W1_L10_m2__nf1_gboth_sdfull_pc/B.n116 394
R207 nfet_01v8_lvt_W1_L10_m2__nf1_gboth_sdfull_pc/B.n152 nfet_01v8_lvt_W1_L10_m2__nf1_gboth_sdfull_pc/B.n116 394
R208 nfet_01v8_lvt_W1_L10_m2__nf1_gboth_sdfull_pc/B.n152 nfet_01v8_lvt_W1_L10_m2__nf1_gboth_sdfull_pc/B.n111 394
R209 nfet_01v8_lvt_W1_L10_m2__nf1_gboth_sdfull_pc/B.n156 nfet_01v8_lvt_W1_L10_m2__nf1_gboth_sdfull_pc/B.n111 394
R210 nfet_01v8_lvt_W1_L10_m2__nf1_gboth_sdfull_pc/B.n156 nfet_01v8_lvt_W1_L10_m2__nf1_gboth_sdfull_pc/B.n109 394
R211 nfet_01v8_lvt_W1_L10_m2__nf1_gboth_sdfull_pc/B.n160 nfet_01v8_lvt_W1_L10_m2__nf1_gboth_sdfull_pc/B.n109 394
R212 nfet_01v8_lvt_W1_L10_m2__nf1_gboth_sdfull_pc/B.n160 nfet_01v8_lvt_W1_L10_m2__nf1_gboth_sdfull_pc/B.n104 394
R213 nfet_01v8_lvt_W1_L10_m2__nf1_gboth_sdfull_pc/B.n164 nfet_01v8_lvt_W1_L10_m2__nf1_gboth_sdfull_pc/B.n104 394
R214 nfet_01v8_lvt_W1_L10_m2__nf1_gboth_sdfull_pc/B.n164 nfet_01v8_lvt_W1_L10_m2__nf1_gboth_sdfull_pc/B.n102 394
R215 nfet_01v8_lvt_W1_L10_m2__nf1_gboth_sdfull_pc/B.n168 nfet_01v8_lvt_W1_L10_m2__nf1_gboth_sdfull_pc/B.n102 394
R216 nfet_01v8_lvt_W1_L10_m2__nf1_gboth_sdfull_pc/B.n168 nfet_01v8_lvt_W1_L10_m2__nf1_gboth_sdfull_pc/B.n97 394
R217 nfet_01v8_lvt_W1_L10_m2__nf1_gboth_sdfull_pc/B.n172 nfet_01v8_lvt_W1_L10_m2__nf1_gboth_sdfull_pc/B.n97 394
R218 nfet_01v8_lvt_W1_L10_m2__nf1_gboth_sdfull_pc/B.n172 nfet_01v8_lvt_W1_L10_m2__nf1_gboth_sdfull_pc/B.n6 394
R219 nfet_01v8_lvt_W1_L10_m2__nf1_gboth_sdfull_pc/B.n176 nfet_01v8_lvt_W1_L10_m2__nf1_gboth_sdfull_pc/B.n6 394
R220 nfet_01v8_lvt_W1_L10_m2__nf1_gboth_sdfull_pc/B.n176 nfet_01v8_lvt_W1_L10_m2__nf1_gboth_sdfull_pc/B.n5 394
R221 nfet_01v8_lvt_W1_L10_m2__nf1_gboth_sdfull_pc/B.n93 nfet_01v8_lvt_W1_L10_m2__nf1_gboth_sdfull_pc/B.n5 394
R222 nfet_01v8_lvt_W1_L10_m2__nf1_gboth_sdfull_pc/B.n93 nfet_01v8_lvt_W1_L10_m2__nf1_gboth_sdfull_pc/B.n8 394
R223 nfet_01v8_lvt_W1_L10_m2__nf1_gboth_sdfull_pc/B.n85 nfet_01v8_lvt_W1_L10_m2__nf1_gboth_sdfull_pc/B.n8 394
R224 nfet_01v8_lvt_W1_L10_m2__nf1_gboth_sdfull_pc/B.n85 nfet_01v8_lvt_W1_L10_m2__nf1_gboth_sdfull_pc/B.n14 394
R225 nfet_01v8_lvt_W1_L10_m2__nf1_gboth_sdfull_pc/B.n81 nfet_01v8_lvt_W1_L10_m2__nf1_gboth_sdfull_pc/B.n14 394
R226 nfet_01v8_lvt_W1_L10_m2__nf1_gboth_sdfull_pc/B.n81 nfet_01v8_lvt_W1_L10_m2__nf1_gboth_sdfull_pc/B.n16 394
R227 nfet_01v8_lvt_W1_L10_m2__nf1_gboth_sdfull_pc/B.n73 nfet_01v8_lvt_W1_L10_m2__nf1_gboth_sdfull_pc/B.n16 394
R228 nfet_01v8_lvt_W1_L10_m2__nf1_gboth_sdfull_pc/B.n73 nfet_01v8_lvt_W1_L10_m2__nf1_gboth_sdfull_pc/B.n22 394
R229 nfet_01v8_lvt_W1_L10_m2__nf1_gboth_sdfull_pc/B.n69 nfet_01v8_lvt_W1_L10_m2__nf1_gboth_sdfull_pc/B.n22 394
R230 nfet_01v8_lvt_W1_L10_m2__nf1_gboth_sdfull_pc/B.n69 nfet_01v8_lvt_W1_L10_m2__nf1_gboth_sdfull_pc/B.n24 394
R231 nfet_01v8_lvt_W1_L10_m2__nf1_gboth_sdfull_pc/B.n61 nfet_01v8_lvt_W1_L10_m2__nf1_gboth_sdfull_pc/B.n24 394
R232 nfet_01v8_lvt_W1_L10_m2__nf1_gboth_sdfull_pc/B.n61 nfet_01v8_lvt_W1_L10_m2__nf1_gboth_sdfull_pc/B.n30 394
R233 nfet_01v8_lvt_W1_L10_m2__nf1_gboth_sdfull_pc/B.n57 nfet_01v8_lvt_W1_L10_m2__nf1_gboth_sdfull_pc/B.n30 394
R234 nfet_01v8_lvt_W1_L10_m2__nf1_gboth_sdfull_pc/B.n57 nfet_01v8_lvt_W1_L10_m2__nf1_gboth_sdfull_pc/B.n32 394
R235 nfet_01v8_lvt_W1_L10_m2__nf1_gboth_sdfull_pc/B.n49 nfet_01v8_lvt_W1_L10_m2__nf1_gboth_sdfull_pc/B.n32 394
R236 nfet_01v8_lvt_W1_L10_m2__nf1_gboth_sdfull_pc/B.n146 B 315.334
R237 nfet_01v8_lvt_W1_L10_m2__nf1_gboth_sdfull_pc/B.n44 nfet_01v8_lvt_W1_L10_m2__nf1_gboth_sdfull_pc/B.n37 218.815
R238 nfet_01v8_lvt_W1_L10_m2__nf1_gboth_sdfull_pc/B.n41 nfet_01v8_lvt_W1_L10_m2__nf1_gboth_sdfull_pc/B.n37 218.815
R239 nfet_01v8_lvt_W1_L10_m2__nf1_gboth_sdfull_pc/B.n146 nfet_01v8_lvt_W1_L10_m2__nf1_gboth_sdfull_pc/B.n120 218.815
R240 nfet_01v8_lvt_W1_L10_m2__nf1_gboth_sdfull_pc/B.n146 nfet_01v8_lvt_W1_L10_m2__nf1_gboth_sdfull_pc/B.n145 218.815
R241 nfet_01v8_lvt_W1_L10_m2__nf1_gboth_sdfull_pc/B.n45 nfet_01v8_lvt_W1_L10_m2__nf1_gboth_sdfull_pc/B.n44 147.374
R242 nfet_01v8_lvt_W1_L10_m2__nf1_gboth_sdfull_pc/B.n42 nfet_01v8_lvt_W1_L10_m2__nf1_gboth_sdfull_pc/B.n41 147.374
R243 nfet_01v8_lvt_W1_L10_m2__nf1_gboth_sdfull_pc/B.n138 nfet_01v8_lvt_W1_L10_m2__nf1_gboth_sdfull_pc/B.n120 147.374
R244 nfet_01v8_lvt_W1_L10_m2__nf1_gboth_sdfull_pc/B.n145 nfet_01v8_lvt_W1_L10_m2__nf1_gboth_sdfull_pc/B.n144 147.374
R245 nfet_01v8_lvt_W1_L10_m2__nf1_gboth_sdfull_pc/B.n140 nfet_01v8_lvt_W1_L10_m2__nf1_gboth_sdfull_pc/B.n120 147.374
R246 nfet_01v8_lvt_W1_L10_m2__nf1_gboth_sdfull_pc/B.n145 nfet_01v8_lvt_W1_L10_m2__nf1_gboth_sdfull_pc/B.n118 147.374
R247 nfet_01v8_lvt_W1_L10_m2__nf1_gboth_sdfull_pc/B.n41 nfet_01v8_lvt_W1_L10_m2__nf1_gboth_sdfull_pc/B.n36 147.374
R248 nfet_01v8_lvt_W1_L10_m2__nf1_gboth_sdfull_pc/B.n44 nfet_01v8_lvt_W1_L10_m2__nf1_gboth_sdfull_pc/B.n43 147.374
R249 nfet_01v8_lvt_W1_L10_m2__nf1_gboth_sdfull_pc/B.n139 nfet_01v8_lvt_W1_L10_m2__nf1_gboth_sdfull_pc/B.n137 85.4593
R250 nfet_01v8_lvt_W1_L10_m2__nf1_gboth_sdfull_pc/B.n52 nfet_01v8_lvt_W1_L10_m2__nf1_gboth_sdfull_pc/B.n35 85.4593
R251 nfet_01v8_lvt_W1_L10_m2__nf1_gboth_sdfull_pc/B.n149 nfet_01v8_lvt_W1_L10_m2__nf1_gboth_sdfull_pc/B.n117 85.4593
R252 nfet_01v8_lvt_W1_L10_m2__nf1_gboth_sdfull_pc/B.n48 nfet_01v8_lvt_W1_L10_m2__nf1_gboth_sdfull_pc/B.n47 85.4593
R253 nfet_01v8_lvt_W1_L10_m2__nf1_gboth_sdfull_pc/B.n141 nfet_01v8_lvt_W1_L10_m2__nf1_gboth_sdfull_pc/B.n139 25.6005
R254 nfet_01v8_lvt_W1_L10_m2__nf1_gboth_sdfull_pc/B.n142 nfet_01v8_lvt_W1_L10_m2__nf1_gboth_sdfull_pc/B.n141 25.6005
R255 nfet_01v8_lvt_W1_L10_m2__nf1_gboth_sdfull_pc/B.n143 nfet_01v8_lvt_W1_L10_m2__nf1_gboth_sdfull_pc/B.n142 25.6005
R256 nfet_01v8_lvt_W1_L10_m2__nf1_gboth_sdfull_pc/B.n143 nfet_01v8_lvt_W1_L10_m2__nf1_gboth_sdfull_pc/B.n117 25.6005
R257 nfet_01v8_lvt_W1_L10_m2__nf1_gboth_sdfull_pc/B.n137 nfet_01v8_lvt_W1_L10_m2__nf1_gboth_sdfull_pc/B.n136 25.6005
R258 nfet_01v8_lvt_W1_L10_m2__nf1_gboth_sdfull_pc/B.n136 nfet_01v8_lvt_W1_L10_m2__nf1_gboth_sdfull_pc/B.n134 25.6005
R259 nfet_01v8_lvt_W1_L10_m2__nf1_gboth_sdfull_pc/B.n134 nfet_01v8_lvt_W1_L10_m2__nf1_gboth_sdfull_pc/B.n133 25.6005
R260 nfet_01v8_lvt_W1_L10_m2__nf1_gboth_sdfull_pc/B.n133 nfet_01v8_lvt_W1_L10_m2__nf1_gboth_sdfull_pc/B.n132 25.6005
R261 nfet_01v8_lvt_W1_L10_m2__nf1_gboth_sdfull_pc/B.n132 nfet_01v8_lvt_W1_L10_m2__nf1_gboth_sdfull_pc/B.n131 25.6005
R262 nfet_01v8_lvt_W1_L10_m2__nf1_gboth_sdfull_pc/B.n131 nfet_01v8_lvt_W1_L10_m2__nf1_gboth_sdfull_pc/B.n129 25.6005
R263 nfet_01v8_lvt_W1_L10_m2__nf1_gboth_sdfull_pc/B.n129 nfet_01v8_lvt_W1_L10_m2__nf1_gboth_sdfull_pc/B.n128 25.6005
R264 nfet_01v8_lvt_W1_L10_m2__nf1_gboth_sdfull_pc/B.n128 nfet_01v8_lvt_W1_L10_m2__nf1_gboth_sdfull_pc/B.n127 25.6005
R265 nfet_01v8_lvt_W1_L10_m2__nf1_gboth_sdfull_pc/B.n127 nfet_01v8_lvt_W1_L10_m2__nf1_gboth_sdfull_pc/B.n126 25.6005
R266 nfet_01v8_lvt_W1_L10_m2__nf1_gboth_sdfull_pc/B.n126 nfet_01v8_lvt_W1_L10_m2__nf1_gboth_sdfull_pc/B.n124 25.6005
R267 nfet_01v8_lvt_W1_L10_m2__nf1_gboth_sdfull_pc/B.n124 nfet_01v8_lvt_W1_L10_m2__nf1_gboth_sdfull_pc/B.n123 25.6005
R268 nfet_01v8_lvt_W1_L10_m2__nf1_gboth_sdfull_pc/B.n123 nfet_01v8_lvt_W1_L10_m2__nf1_gboth_sdfull_pc/B.n122 25.6005
R269 nfet_01v8_lvt_W1_L10_m2__nf1_gboth_sdfull_pc/B.n122 nfet_01v8_lvt_W1_L10_m2__nf1_gboth_sdfull_pc/B.n1 25.6005
R270 nfet_01v8_lvt_W1_L10_m2__nf1_gboth_sdfull_pc/B.n179 nfet_01v8_lvt_W1_L10_m2__nf1_gboth_sdfull_pc/B.n1 25.6005
R271 nfet_01v8_lvt_W1_L10_m2__nf1_gboth_sdfull_pc/B.n90 nfet_01v8_lvt_W1_L10_m2__nf1_gboth_sdfull_pc/B.n0 25.6005
R272 nfet_01v8_lvt_W1_L10_m2__nf1_gboth_sdfull_pc/B.n90 nfet_01v8_lvt_W1_L10_m2__nf1_gboth_sdfull_pc/B.n89 25.6005
R273 nfet_01v8_lvt_W1_L10_m2__nf1_gboth_sdfull_pc/B.n89 nfet_01v8_lvt_W1_L10_m2__nf1_gboth_sdfull_pc/B.n88 25.6005
R274 nfet_01v8_lvt_W1_L10_m2__nf1_gboth_sdfull_pc/B.n88 nfet_01v8_lvt_W1_L10_m2__nf1_gboth_sdfull_pc/B.n11 25.6005
R275 nfet_01v8_lvt_W1_L10_m2__nf1_gboth_sdfull_pc/B.n78 nfet_01v8_lvt_W1_L10_m2__nf1_gboth_sdfull_pc/B.n11 25.6005
R276 nfet_01v8_lvt_W1_L10_m2__nf1_gboth_sdfull_pc/B.n78 nfet_01v8_lvt_W1_L10_m2__nf1_gboth_sdfull_pc/B.n77 25.6005
R277 nfet_01v8_lvt_W1_L10_m2__nf1_gboth_sdfull_pc/B.n77 nfet_01v8_lvt_W1_L10_m2__nf1_gboth_sdfull_pc/B.n76 25.6005
R278 nfet_01v8_lvt_W1_L10_m2__nf1_gboth_sdfull_pc/B.n76 nfet_01v8_lvt_W1_L10_m2__nf1_gboth_sdfull_pc/B.n19 25.6005
R279 nfet_01v8_lvt_W1_L10_m2__nf1_gboth_sdfull_pc/B.n66 nfet_01v8_lvt_W1_L10_m2__nf1_gboth_sdfull_pc/B.n19 25.6005
R280 nfet_01v8_lvt_W1_L10_m2__nf1_gboth_sdfull_pc/B.n66 nfet_01v8_lvt_W1_L10_m2__nf1_gboth_sdfull_pc/B.n65 25.6005
R281 nfet_01v8_lvt_W1_L10_m2__nf1_gboth_sdfull_pc/B.n65 nfet_01v8_lvt_W1_L10_m2__nf1_gboth_sdfull_pc/B.n64 25.6005
R282 nfet_01v8_lvt_W1_L10_m2__nf1_gboth_sdfull_pc/B.n64 nfet_01v8_lvt_W1_L10_m2__nf1_gboth_sdfull_pc/B.n27 25.6005
R283 nfet_01v8_lvt_W1_L10_m2__nf1_gboth_sdfull_pc/B.n54 nfet_01v8_lvt_W1_L10_m2__nf1_gboth_sdfull_pc/B.n27 25.6005
R284 nfet_01v8_lvt_W1_L10_m2__nf1_gboth_sdfull_pc/B.n54 nfet_01v8_lvt_W1_L10_m2__nf1_gboth_sdfull_pc/B.n53 25.6005
R285 nfet_01v8_lvt_W1_L10_m2__nf1_gboth_sdfull_pc/B.n53 nfet_01v8_lvt_W1_L10_m2__nf1_gboth_sdfull_pc/B.n52 25.6005
R286 nfet_01v8_lvt_W1_L10_m2__nf1_gboth_sdfull_pc/B.n40 nfet_01v8_lvt_W1_L10_m2__nf1_gboth_sdfull_pc/B.n35 25.6005
R287 nfet_01v8_lvt_W1_L10_m2__nf1_gboth_sdfull_pc/B.n40 nfet_01v8_lvt_W1_L10_m2__nf1_gboth_sdfull_pc/B.n39 25.6005
R288 nfet_01v8_lvt_W1_L10_m2__nf1_gboth_sdfull_pc/B.n46 nfet_01v8_lvt_W1_L10_m2__nf1_gboth_sdfull_pc/B.n39 25.6005
R289 nfet_01v8_lvt_W1_L10_m2__nf1_gboth_sdfull_pc/B.n47 nfet_01v8_lvt_W1_L10_m2__nf1_gboth_sdfull_pc/B.n46 25.6005
R290 nfet_01v8_lvt_W1_L10_m2__nf1_gboth_sdfull_pc/B.n150 nfet_01v8_lvt_W1_L10_m2__nf1_gboth_sdfull_pc/B.n149 25.6005
R291 nfet_01v8_lvt_W1_L10_m2__nf1_gboth_sdfull_pc/B.n151 nfet_01v8_lvt_W1_L10_m2__nf1_gboth_sdfull_pc/B.n150 25.6005
R292 nfet_01v8_lvt_W1_L10_m2__nf1_gboth_sdfull_pc/B.n151 nfet_01v8_lvt_W1_L10_m2__nf1_gboth_sdfull_pc/B.n110 25.6005
R293 nfet_01v8_lvt_W1_L10_m2__nf1_gboth_sdfull_pc/B.n157 nfet_01v8_lvt_W1_L10_m2__nf1_gboth_sdfull_pc/B.n110 25.6005
R294 nfet_01v8_lvt_W1_L10_m2__nf1_gboth_sdfull_pc/B.n158 nfet_01v8_lvt_W1_L10_m2__nf1_gboth_sdfull_pc/B.n157 25.6005
R295 nfet_01v8_lvt_W1_L10_m2__nf1_gboth_sdfull_pc/B.n159 nfet_01v8_lvt_W1_L10_m2__nf1_gboth_sdfull_pc/B.n158 25.6005
R296 nfet_01v8_lvt_W1_L10_m2__nf1_gboth_sdfull_pc/B.n159 nfet_01v8_lvt_W1_L10_m2__nf1_gboth_sdfull_pc/B.n103 25.6005
R297 nfet_01v8_lvt_W1_L10_m2__nf1_gboth_sdfull_pc/B.n165 nfet_01v8_lvt_W1_L10_m2__nf1_gboth_sdfull_pc/B.n103 25.6005
R298 nfet_01v8_lvt_W1_L10_m2__nf1_gboth_sdfull_pc/B.n166 nfet_01v8_lvt_W1_L10_m2__nf1_gboth_sdfull_pc/B.n165 25.6005
R299 nfet_01v8_lvt_W1_L10_m2__nf1_gboth_sdfull_pc/B.n167 nfet_01v8_lvt_W1_L10_m2__nf1_gboth_sdfull_pc/B.n166 25.6005
R300 nfet_01v8_lvt_W1_L10_m2__nf1_gboth_sdfull_pc/B.n167 nfet_01v8_lvt_W1_L10_m2__nf1_gboth_sdfull_pc/B.n96 25.6005
R301 nfet_01v8_lvt_W1_L10_m2__nf1_gboth_sdfull_pc/B.n173 nfet_01v8_lvt_W1_L10_m2__nf1_gboth_sdfull_pc/B.n96 25.6005
R302 nfet_01v8_lvt_W1_L10_m2__nf1_gboth_sdfull_pc/B.n174 nfet_01v8_lvt_W1_L10_m2__nf1_gboth_sdfull_pc/B.n173 25.6005
R303 nfet_01v8_lvt_W1_L10_m2__nf1_gboth_sdfull_pc/B.n175 nfet_01v8_lvt_W1_L10_m2__nf1_gboth_sdfull_pc/B.n174 25.6005
R304 nfet_01v8_lvt_W1_L10_m2__nf1_gboth_sdfull_pc/B.n175 nfet_01v8_lvt_W1_L10_m2__nf1_gboth_sdfull_pc/B.n95 25.6005
R305 nfet_01v8_lvt_W1_L10_m2__nf1_gboth_sdfull_pc/B.n95 nfet_01v8_lvt_W1_L10_m2__nf1_gboth_sdfull_pc/B.n94 25.6005
R306 nfet_01v8_lvt_W1_L10_m2__nf1_gboth_sdfull_pc/B.n94 nfet_01v8_lvt_W1_L10_m2__nf1_gboth_sdfull_pc/B.n7 25.6005
R307 nfet_01v8_lvt_W1_L10_m2__nf1_gboth_sdfull_pc/B.n84 nfet_01v8_lvt_W1_L10_m2__nf1_gboth_sdfull_pc/B.n7 25.6005
R308 nfet_01v8_lvt_W1_L10_m2__nf1_gboth_sdfull_pc/B.n84 nfet_01v8_lvt_W1_L10_m2__nf1_gboth_sdfull_pc/B.n83 25.6005
R309 nfet_01v8_lvt_W1_L10_m2__nf1_gboth_sdfull_pc/B.n83 nfet_01v8_lvt_W1_L10_m2__nf1_gboth_sdfull_pc/B.n82 25.6005
R310 nfet_01v8_lvt_W1_L10_m2__nf1_gboth_sdfull_pc/B.n82 nfet_01v8_lvt_W1_L10_m2__nf1_gboth_sdfull_pc/B.n15 25.6005
R311 nfet_01v8_lvt_W1_L10_m2__nf1_gboth_sdfull_pc/B.n72 nfet_01v8_lvt_W1_L10_m2__nf1_gboth_sdfull_pc/B.n15 25.6005
R312 nfet_01v8_lvt_W1_L10_m2__nf1_gboth_sdfull_pc/B.n72 nfet_01v8_lvt_W1_L10_m2__nf1_gboth_sdfull_pc/B.n71 25.6005
R313 nfet_01v8_lvt_W1_L10_m2__nf1_gboth_sdfull_pc/B.n71 nfet_01v8_lvt_W1_L10_m2__nf1_gboth_sdfull_pc/B.n70 25.6005
R314 nfet_01v8_lvt_W1_L10_m2__nf1_gboth_sdfull_pc/B.n70 nfet_01v8_lvt_W1_L10_m2__nf1_gboth_sdfull_pc/B.n23 25.6005
R315 nfet_01v8_lvt_W1_L10_m2__nf1_gboth_sdfull_pc/B.n60 nfet_01v8_lvt_W1_L10_m2__nf1_gboth_sdfull_pc/B.n23 25.6005
R316 nfet_01v8_lvt_W1_L10_m2__nf1_gboth_sdfull_pc/B.n60 nfet_01v8_lvt_W1_L10_m2__nf1_gboth_sdfull_pc/B.n59 25.6005
R317 nfet_01v8_lvt_W1_L10_m2__nf1_gboth_sdfull_pc/B.n59 nfet_01v8_lvt_W1_L10_m2__nf1_gboth_sdfull_pc/B.n58 25.6005
R318 nfet_01v8_lvt_W1_L10_m2__nf1_gboth_sdfull_pc/B.n58 nfet_01v8_lvt_W1_L10_m2__nf1_gboth_sdfull_pc/B.n31 25.6005
R319 nfet_01v8_lvt_W1_L10_m2__nf1_gboth_sdfull_pc/B.n48 nfet_01v8_lvt_W1_L10_m2__nf1_gboth_sdfull_pc/B.n31 25.6005
R320 B nfet_01v8_lvt_W1_L10_m2__nf1_gboth_sdfull_pc/B.n179 19.2005
R321 B nfet_01v8_lvt_W1_L10_m2__nf1_gboth_sdfull_pc/B.n0 6.4005
R322 B.n75 B.n64 1315.26
R323 B.n179 B.n4 1315.26
R324 B.n169 B.n10 1315.26
R325 B.n78 B.n66 1315.26
R326 B.n180 B.n0 902
R327 B.n76 B.n65 902
R328 B.n65 B.n64 585
R329 B.n64 B.n63 585
R330 B.n84 B.n83 585
R331 B.n85 B.n84 585
R332 B.n62 B.n61 585
R333 B.n86 B.n62 585
R334 B.n89 B.n88 585
R335 B.n88 B.n87 585
R336 B.n57 B.n56 585
R337 B.n56 B.n55 585
R338 B.n96 B.n95 585
R339 B.n97 B.n96 585
R340 B.n54 B.n53 585
R341 B.n98 B.n54 585
R342 B.n101 B.n100 585
R343 B.n100 B.n99 585
R344 B.n49 B.n48 585
R345 B.n48 B.n47 585
R346 B.n108 B.n107 585
R347 B.n109 B.n108 585
R348 B.n46 B.n45 585
R349 B.n110 B.n46 585
R350 B.n113 B.n112 585
R351 B.n112 B.n111 585
R352 B.n41 B.n40 585
R353 B.n40 B.n39 585
R354 B.n120 B.n119 585
R355 B.n121 B.n120 585
R356 B.n38 B.n37 585
R357 B.n122 B.n38 585
R358 B.n125 B.n124 585
R359 B.n124 B.n123 585
R360 B.n33 B.n32 585
R361 B.n32 B.n31 585
R362 B.n132 B.n131 585
R363 B.n133 B.n132 585
R364 B.n30 B.n29 585
R365 B.n134 B.n30 585
R366 B.n137 B.n136 585
R367 B.n136 B.n135 585
R368 B.n25 B.n24 585
R369 B.n24 B.n23 585
R370 B.n144 B.n143 585
R371 B.n145 B.n144 585
R372 B.n22 B.n21 585
R373 B.n146 B.n22 585
R374 B.n149 B.n148 585
R375 B.n148 B.n147 585
R376 B.n17 B.n16 585
R377 B.n16 B.n15 585
R378 B.n156 B.n155 585
R379 B.n157 B.n156 585
R380 B.n14 B.n13 585
R381 B.n158 B.n14 585
R382 B.n161 B.n160 585
R383 B.n160 B.n159 585
R384 B.n8 B.n7 585
R385 B.n7 B.n6 585
R386 B.n175 B.n174 585
R387 B.n176 B.n175 585
R388 B.n4 B.n0 585
R389 B.n177 B.n4 585
R390 B.n180 B.n179 585
R391 B.n179 B.n178 585
R392 B.n5 B.n3 585
R393 B.n166 B.n165 585
R394 B.n168 B.n167 585
R395 B.n170 B.n169 585
R396 B.n10 B.n0 585
R397 B.n171 B.n10 585
R398 B.n174 B.n173 585
R399 B.n173 B.n172 585
R400 B.n9 B.n8 585
R401 B.n164 B.n9 585
R402 B.n162 B.n161 585
R403 B.n163 B.n162 585
R404 B.n13 B.n12 585
R405 B.n12 B.n11 585
R406 B.n155 B.n154 585
R407 B.n154 B.n153 585
R408 B.n18 B.n17 585
R409 B.n152 B.n18 585
R410 B.n150 B.n149 585
R411 B.n151 B.n150 585
R412 B.n21 B.n20 585
R413 B.n20 B.n19 585
R414 B.n143 B.n142 585
R415 B.n142 B.n141 585
R416 B.n26 B.n25 585
R417 B.n140 B.n26 585
R418 B.n138 B.n137 585
R419 B.n139 B.n138 585
R420 B.n29 B.n28 585
R421 B.n28 B.n27 585
R422 B.n131 B.n130 585
R423 B.n130 B.n129 585
R424 B.n34 B.n33 585
R425 B.n128 B.n34 585
R426 B.n126 B.n125 585
R427 B.n127 B.n126 585
R428 B.n37 B.n36 585
R429 B.n36 B.n35 585
R430 B.n119 B.n118 585
R431 B.n118 B.n117 585
R432 B.n42 B.n41 585
R433 B.n116 B.n42 585
R434 B.n114 B.n113 585
R435 B.n115 B.n114 585
R436 B.n45 B.n44 585
R437 B.n44 B.n43 585
R438 B.n107 B.n106 585
R439 B.n106 B.n105 585
R440 B.n50 B.n49 585
R441 B.n104 B.n50 585
R442 B.n102 B.n101 585
R443 B.n103 B.n102 585
R444 B.n53 B.n52 585
R445 B.n52 B.n51 585
R446 B.n95 B.n94 585
R447 B.n94 B.n93 585
R448 B.n58 B.n57 585
R449 B.n92 B.n58 585
R450 B.n90 B.n89 585
R451 B.n91 B.n90 585
R452 B.n61 B.n60 585
R453 B.n60 B.n59 585
R454 B.n83 B.n82 585
R455 B.n82 B.n81 585
R456 B.n66 B.n65 585
R457 B.n80 B.n66 585
R458 B.n79 B.n78 585
R459 B.n68 B.n67 585
R460 B.n72 B.n71 585
R461 B.n73 B.n70 585
R462 B.n76 B.n75 585
R463 B.n75 B.n74 585
R464 B.n174 B.n0 498.668
R465 B.n174 B.n8 498.668
R466 B.n161 B.n8 498.668
R467 B.n161 B.n13 498.668
R468 B.n155 B.n13 498.668
R469 B.n155 B.n17 498.668
R470 B.n149 B.n17 498.668
R471 B.n149 B.n21 498.668
R472 B.n143 B.n21 498.668
R473 B.n143 B.n25 498.668
R474 B.n137 B.n25 498.668
R475 B.n137 B.n29 498.668
R476 B.n131 B.n29 498.668
R477 B.n131 B.n33 498.668
R478 B.n125 B.n33 498.668
R479 B.n125 B.n37 498.668
R480 B.n119 B.n37 498.668
R481 B.n119 B.n41 498.668
R482 B.n113 B.n41 498.668
R483 B.n113 B.n45 498.668
R484 B.n107 B.n45 498.668
R485 B.n107 B.n49 498.668
R486 B.n101 B.n49 498.668
R487 B.n101 B.n53 498.668
R488 B.n95 B.n53 498.668
R489 B.n95 B.n57 498.668
R490 B.n89 B.n57 498.668
R491 B.n89 B.n61 498.668
R492 B.n83 B.n61 498.668
R493 B.n83 B.n65 498.668
R494 B.n75 B.n70 394
R495 B.n71 B.n68 394
R496 B.n175 B.n4 394
R497 B.n175 B.n7 394
R498 B.n160 B.n7 394
R499 B.n160 B.n14 394
R500 B.n156 B.n14 394
R501 B.n156 B.n16 394
R502 B.n148 B.n16 394
R503 B.n148 B.n22 394
R504 B.n144 B.n22 394
R505 B.n144 B.n24 394
R506 B.n136 B.n24 394
R507 B.n136 B.n30 394
R508 B.n132 B.n30 394
R509 B.n132 B.n32 394
R510 B.n124 B.n32 394
R511 B.n124 B.n38 394
R512 B.n120 B.n38 394
R513 B.n120 B.n40 394
R514 B.n112 B.n40 394
R515 B.n112 B.n46 394
R516 B.n108 B.n46 394
R517 B.n108 B.n48 394
R518 B.n100 B.n48 394
R519 B.n100 B.n54 394
R520 B.n96 B.n54 394
R521 B.n96 B.n56 394
R522 B.n88 B.n56 394
R523 B.n88 B.n62 394
R524 B.n84 B.n62 394
R525 B.n84 B.n64 394
R526 B.n179 B.n3 394
R527 B.n167 B.n166 394
R528 B.n173 B.n10 394
R529 B.n173 B.n9 394
R530 B.n162 B.n9 394
R531 B.n162 B.n12 394
R532 B.n154 B.n12 394
R533 B.n154 B.n18 394
R534 B.n150 B.n18 394
R535 B.n150 B.n20 394
R536 B.n142 B.n20 394
R537 B.n142 B.n26 394
R538 B.n138 B.n26 394
R539 B.n138 B.n28 394
R540 B.n130 B.n28 394
R541 B.n130 B.n34 394
R542 B.n126 B.n34 394
R543 B.n126 B.n36 394
R544 B.n118 B.n36 394
R545 B.n118 B.n42 394
R546 B.n114 B.n42 394
R547 B.n114 B.n44 394
R548 B.n106 B.n44 394
R549 B.n106 B.n50 394
R550 B.n102 B.n50 394
R551 B.n102 B.n52 394
R552 B.n94 B.n52 394
R553 B.n94 B.n58 394
R554 B.n90 B.n58 394
R555 B.n90 B.n60 394
R556 B.n82 B.n60 394
R557 B.n82 B.n66 394
R558 B B.n180 315.334
R559 B.n180 B.n2 218.815
R560 B.n180 B.n1 218.815
R561 B.n77 B.n76 218.815
R562 B.n76 B.n69 218.815
R563 B.n3 B.n2 147.374
R564 B.n167 B.n1 147.374
R565 B.n77 B.n68 147.374
R566 B.n70 B.n69 147.374
R567 B.n71 B.n69 147.374
R568 B.n78 B.n77 147.374
R569 B.n166 B.n2 147.374
R570 B.n169 B.n1 147.374
R571 B.n178 B.n177 85.4593
R572 B.n171 B.n170 85.4593
R573 B.n74 B.n63 85.4593
R574 B.n80 B.n79 85.4593
R575 B.n177 B.n176 25.6005
R576 B.n176 B.n6 25.6005
R577 B.n159 B.n6 25.6005
R578 B.n159 B.n158 25.6005
R579 B.n158 B.n157 25.6005
R580 B.n157 B.n15 25.6005
R581 B.n147 B.n15 25.6005
R582 B.n147 B.n146 25.6005
R583 B.n146 B.n145 25.6005
R584 B.n145 B.n23 25.6005
R585 B.n135 B.n23 25.6005
R586 B.n135 B.n134 25.6005
R587 B.n134 B.n133 25.6005
R588 B.n133 B.n31 25.6005
R589 B.n123 B.n122 25.6005
R590 B.n122 B.n121 25.6005
R591 B.n121 B.n39 25.6005
R592 B.n111 B.n39 25.6005
R593 B.n111 B.n110 25.6005
R594 B.n110 B.n109 25.6005
R595 B.n109 B.n47 25.6005
R596 B.n99 B.n47 25.6005
R597 B.n99 B.n98 25.6005
R598 B.n98 B.n97 25.6005
R599 B.n97 B.n55 25.6005
R600 B.n87 B.n55 25.6005
R601 B.n87 B.n86 25.6005
R602 B.n86 B.n85 25.6005
R603 B.n85 B.n63 25.6005
R604 B.n178 B.n5 25.6005
R605 B.n165 B.n5 25.6005
R606 B.n168 B.n165 25.6005
R607 B.n170 B.n168 25.6005
R608 B.n172 B.n171 25.6005
R609 B.n172 B.n164 25.6005
R610 B.n164 B.n163 25.6005
R611 B.n163 B.n11 25.6005
R612 B.n153 B.n11 25.6005
R613 B.n153 B.n152 25.6005
R614 B.n152 B.n151 25.6005
R615 B.n151 B.n19 25.6005
R616 B.n141 B.n19 25.6005
R617 B.n141 B.n140 25.6005
R618 B.n140 B.n139 25.6005
R619 B.n139 B.n27 25.6005
R620 B.n129 B.n27 25.6005
R621 B.n129 B.n128 25.6005
R622 B.n128 B.n127 25.6005
R623 B.n127 B.n35 25.6005
R624 B.n117 B.n35 25.6005
R625 B.n117 B.n116 25.6005
R626 B.n116 B.n115 25.6005
R627 B.n115 B.n43 25.6005
R628 B.n105 B.n43 25.6005
R629 B.n105 B.n104 25.6005
R630 B.n104 B.n103 25.6005
R631 B.n103 B.n51 25.6005
R632 B.n93 B.n51 25.6005
R633 B.n93 B.n92 25.6005
R634 B.n92 B.n91 25.6005
R635 B.n91 B.n59 25.6005
R636 B.n81 B.n59 25.6005
R637 B.n81 B.n80 25.6005
R638 B.n74 B.n73 25.6005
R639 B.n73 B.n72 25.6005
R640 B.n72 B.n67 25.6005
R641 B.n79 B.n67 25.6005
R642 B B.n31 19.2005
R643 B.n123 B 6.4005
R644 w_n43_n43.n146 w_n43_n43.n120 1315.26
R645 w_n43_n43.n52 w_n43_n43.n37 1315.26
R646 w_n43_n43.n149 w_n43_n43.n119 1315.26
R647 w_n43_n43.n50 w_n43_n43.n39 1315.26
R648 w_n43_n43.n148 w_n43_n43.n147 902
R649 w_n43_n43.n51 w_n43_n43.n38 902
R650 w_n43_n43.n149 w_n43_n43.n148 585
R651 w_n43_n43.n150 w_n43_n43.n149 585
R652 w_n43_n43.n117 w_n43_n43.n116 585
R653 w_n43_n43.n151 w_n43_n43.n117 585
R654 w_n43_n43.n154 w_n43_n43.n153 585
R655 w_n43_n43.n153 w_n43_n43.n152 585
R656 w_n43_n43.n155 w_n43_n43.n112 585
R657 w_n43_n43.n112 w_n43_n43.n111 585
R658 w_n43_n43.n157 w_n43_n43.n156 585
R659 w_n43_n43.n158 w_n43_n43.n157 585
R660 w_n43_n43.n110 w_n43_n43.n109 585
R661 w_n43_n43.n159 w_n43_n43.n110 585
R662 w_n43_n43.n162 w_n43_n43.n161 585
R663 w_n43_n43.n161 w_n43_n43.n160 585
R664 w_n43_n43.n163 w_n43_n43.n105 585
R665 w_n43_n43.n105 w_n43_n43.n104 585
R666 w_n43_n43.n165 w_n43_n43.n164 585
R667 w_n43_n43.n166 w_n43_n43.n165 585
R668 w_n43_n43.n103 w_n43_n43.n102 585
R669 w_n43_n43.n167 w_n43_n43.n103 585
R670 w_n43_n43.n170 w_n43_n43.n169 585
R671 w_n43_n43.n169 w_n43_n43.n168 585
R672 w_n43_n43.n171 w_n43_n43.n98 585
R673 w_n43_n43.n98 w_n43_n43.n97 585
R674 w_n43_n43.n173 w_n43_n43.n172 585
R675 w_n43_n43.n174 w_n43_n43.n173 585
R676 w_n43_n43.n7 w_n43_n43.n5 585
R677 w_n43_n43.n175 w_n43_n43.n7 585
R678 w_n43_n43.n178 w_n43_n43.n177 585
R679 w_n43_n43.n177 w_n43_n43.n176 585
R680 w_n43_n43.n6 w_n43_n43.n4 585
R681 w_n43_n43.n96 w_n43_n43.n6 585
R682 w_n43_n43.n94 w_n43_n43.n93 585
R683 w_n43_n43.n95 w_n43_n43.n94 585
R684 w_n43_n43.n10 w_n43_n43.n9 585
R685 w_n43_n43.n9 w_n43_n43.n8 585
R686 w_n43_n43.n87 w_n43_n43.n86 585
R687 w_n43_n43.n86 w_n43_n43.n85 585
R688 w_n43_n43.n15 w_n43_n43.n14 585
R689 w_n43_n43.n84 w_n43_n43.n15 585
R690 w_n43_n43.n82 w_n43_n43.n81 585
R691 w_n43_n43.n83 w_n43_n43.n82 585
R692 w_n43_n43.n18 w_n43_n43.n17 585
R693 w_n43_n43.n17 w_n43_n43.n16 585
R694 w_n43_n43.n75 w_n43_n43.n74 585
R695 w_n43_n43.n74 w_n43_n43.n73 585
R696 w_n43_n43.n23 w_n43_n43.n22 585
R697 w_n43_n43.n72 w_n43_n43.n23 585
R698 w_n43_n43.n70 w_n43_n43.n69 585
R699 w_n43_n43.n71 w_n43_n43.n70 585
R700 w_n43_n43.n26 w_n43_n43.n25 585
R701 w_n43_n43.n25 w_n43_n43.n24 585
R702 w_n43_n43.n63 w_n43_n43.n62 585
R703 w_n43_n43.n62 w_n43_n43.n61 585
R704 w_n43_n43.n31 w_n43_n43.n30 585
R705 w_n43_n43.n60 w_n43_n43.n31 585
R706 w_n43_n43.n58 w_n43_n43.n57 585
R707 w_n43_n43.n59 w_n43_n43.n58 585
R708 w_n43_n43.n34 w_n43_n43.n33 585
R709 w_n43_n43.n33 w_n43_n43.n32 585
R710 w_n43_n43.n51 w_n43_n43.n50 585
R711 w_n43_n43.n50 w_n43_n43.n49 585
R712 w_n43_n43.n39 w_n43_n43.n38 585
R713 w_n43_n43.n48 w_n43_n43.n39 585
R714 w_n43_n43.n47 w_n43_n43.n46 585
R715 w_n43_n43.n44 w_n43_n43.n40 585
R716 w_n43_n43.n43 w_n43_n43.n41 585
R717 w_n43_n43.n37 w_n43_n43.n36 585
R718 w_n43_n43.n52 w_n43_n43.n51 585
R719 w_n43_n43.n53 w_n43_n43.n52 585
R720 w_n43_n43.n35 w_n43_n43.n34 585
R721 w_n43_n43.n54 w_n43_n43.n35 585
R722 w_n43_n43.n57 w_n43_n43.n56 585
R723 w_n43_n43.n56 w_n43_n43.n55 585
R724 w_n43_n43.n30 w_n43_n43.n29 585
R725 w_n43_n43.n29 w_n43_n43.n28 585
R726 w_n43_n43.n64 w_n43_n43.n63 585
R727 w_n43_n43.n65 w_n43_n43.n64 585
R728 w_n43_n43.n27 w_n43_n43.n26 585
R729 w_n43_n43.n66 w_n43_n43.n27 585
R730 w_n43_n43.n69 w_n43_n43.n68 585
R731 w_n43_n43.n68 w_n43_n43.n67 585
R732 w_n43_n43.n22 w_n43_n43.n21 585
R733 w_n43_n43.n21 w_n43_n43.n20 585
R734 w_n43_n43.n76 w_n43_n43.n75 585
R735 w_n43_n43.n77 w_n43_n43.n76 585
R736 w_n43_n43.n19 w_n43_n43.n18 585
R737 w_n43_n43.n78 w_n43_n43.n19 585
R738 w_n43_n43.n81 w_n43_n43.n80 585
R739 w_n43_n43.n80 w_n43_n43.n79 585
R740 w_n43_n43.n14 w_n43_n43.n13 585
R741 w_n43_n43.n13 w_n43_n43.n12 585
R742 w_n43_n43.n88 w_n43_n43.n87 585
R743 w_n43_n43.n89 w_n43_n43.n88 585
R744 w_n43_n43.n11 w_n43_n43.n10 585
R745 w_n43_n43.n90 w_n43_n43.n11 585
R746 w_n43_n43.n93 w_n43_n43.n92 585
R747 w_n43_n43.n92 w_n43_n43.n91 585
R748 w_n43_n43.n4 w_n43_n43.n2 585
R749 w_n43_n43.n2 w_n43_n43.n0 585
R750 w_n43_n43.n179 w_n43_n43.n178 585
R751 w_n43_n43.n180 w_n43_n43.n179 585
R752 w_n43_n43.n5 w_n43_n43.n3 585
R753 w_n43_n43.n3 w_n43_n43.n1 585
R754 w_n43_n43.n172 w_n43_n43.n99 585
R755 w_n43_n43.n129 w_n43_n43.n99 585
R756 w_n43_n43.n171 w_n43_n43.n100 585
R757 w_n43_n43.n130 w_n43_n43.n100 585
R758 w_n43_n43.n170 w_n43_n43.n101 585
R759 w_n43_n43.n131 w_n43_n43.n101 585
R760 w_n43_n43.n132 w_n43_n43.n102 585
R761 w_n43_n43.n133 w_n43_n43.n132 585
R762 w_n43_n43.n164 w_n43_n43.n106 585
R763 w_n43_n43.n134 w_n43_n43.n106 585
R764 w_n43_n43.n163 w_n43_n43.n107 585
R765 w_n43_n43.n135 w_n43_n43.n107 585
R766 w_n43_n43.n162 w_n43_n43.n108 585
R767 w_n43_n43.n136 w_n43_n43.n108 585
R768 w_n43_n43.n137 w_n43_n43.n109 585
R769 w_n43_n43.n138 w_n43_n43.n137 585
R770 w_n43_n43.n156 w_n43_n43.n113 585
R771 w_n43_n43.n139 w_n43_n43.n113 585
R772 w_n43_n43.n155 w_n43_n43.n114 585
R773 w_n43_n43.n140 w_n43_n43.n114 585
R774 w_n43_n43.n154 w_n43_n43.n115 585
R775 w_n43_n43.n141 w_n43_n43.n115 585
R776 w_n43_n43.n142 w_n43_n43.n116 585
R777 w_n43_n43.n143 w_n43_n43.n142 585
R778 w_n43_n43.n148 w_n43_n43.n120 585
R779 w_n43_n43.n144 w_n43_n43.n120 585
R780 w_n43_n43.n147 w_n43_n43.n146 585
R781 w_n43_n43.n146 w_n43_n43.n145 585
R782 w_n43_n43.n128 w_n43_n43.n123 585
R783 w_n43_n43.n127 w_n43_n43.n126 585
R784 w_n43_n43.n125 w_n43_n43.n124 585
R785 w_n43_n43.n119 w_n43_n43.n118 585
R786 w_n43_n43.n148 w_n43_n43.n116 498.668
R787 w_n43_n43.n154 w_n43_n43.n116 498.668
R788 w_n43_n43.n155 w_n43_n43.n154 498.668
R789 w_n43_n43.n156 w_n43_n43.n155 498.668
R790 w_n43_n43.n156 w_n43_n43.n109 498.668
R791 w_n43_n43.n162 w_n43_n43.n109 498.668
R792 w_n43_n43.n163 w_n43_n43.n162 498.668
R793 w_n43_n43.n164 w_n43_n43.n163 498.668
R794 w_n43_n43.n164 w_n43_n43.n102 498.668
R795 w_n43_n43.n170 w_n43_n43.n102 498.668
R796 w_n43_n43.n171 w_n43_n43.n170 498.668
R797 w_n43_n43.n172 w_n43_n43.n171 498.668
R798 w_n43_n43.n172 w_n43_n43.n5 498.668
R799 w_n43_n43.n178 w_n43_n43.n5 498.668
R800 w_n43_n43.n178 w_n43_n43.n4 498.668
R801 w_n43_n43.n93 w_n43_n43.n4 498.668
R802 w_n43_n43.n93 w_n43_n43.n10 498.668
R803 w_n43_n43.n87 w_n43_n43.n10 498.668
R804 w_n43_n43.n87 w_n43_n43.n14 498.668
R805 w_n43_n43.n81 w_n43_n43.n14 498.668
R806 w_n43_n43.n81 w_n43_n43.n18 498.668
R807 w_n43_n43.n75 w_n43_n43.n18 498.668
R808 w_n43_n43.n75 w_n43_n43.n22 498.668
R809 w_n43_n43.n69 w_n43_n43.n22 498.668
R810 w_n43_n43.n69 w_n43_n43.n26 498.668
R811 w_n43_n43.n63 w_n43_n43.n26 498.668
R812 w_n43_n43.n63 w_n43_n43.n30 498.668
R813 w_n43_n43.n57 w_n43_n43.n30 498.668
R814 w_n43_n43.n57 w_n43_n43.n34 498.668
R815 w_n43_n43.n51 w_n43_n43.n34 498.668
R816 w_n43_n43.n146 w_n43_n43.n123 394
R817 w_n43_n43.n126 w_n43_n43.n125 394
R818 w_n43_n43.n142 w_n43_n43.n120 394
R819 w_n43_n43.n142 w_n43_n43.n115 394
R820 w_n43_n43.n115 w_n43_n43.n114 394
R821 w_n43_n43.n114 w_n43_n43.n113 394
R822 w_n43_n43.n137 w_n43_n43.n113 394
R823 w_n43_n43.n137 w_n43_n43.n108 394
R824 w_n43_n43.n108 w_n43_n43.n107 394
R825 w_n43_n43.n107 w_n43_n43.n106 394
R826 w_n43_n43.n132 w_n43_n43.n106 394
R827 w_n43_n43.n132 w_n43_n43.n101 394
R828 w_n43_n43.n101 w_n43_n43.n100 394
R829 w_n43_n43.n100 w_n43_n43.n99 394
R830 w_n43_n43.n99 w_n43_n43.n3 394
R831 w_n43_n43.n179 w_n43_n43.n3 394
R832 w_n43_n43.n179 w_n43_n43.n2 394
R833 w_n43_n43.n92 w_n43_n43.n2 394
R834 w_n43_n43.n92 w_n43_n43.n11 394
R835 w_n43_n43.n88 w_n43_n43.n11 394
R836 w_n43_n43.n88 w_n43_n43.n13 394
R837 w_n43_n43.n80 w_n43_n43.n13 394
R838 w_n43_n43.n80 w_n43_n43.n19 394
R839 w_n43_n43.n76 w_n43_n43.n19 394
R840 w_n43_n43.n76 w_n43_n43.n21 394
R841 w_n43_n43.n68 w_n43_n43.n21 394
R842 w_n43_n43.n68 w_n43_n43.n27 394
R843 w_n43_n43.n64 w_n43_n43.n27 394
R844 w_n43_n43.n64 w_n43_n43.n29 394
R845 w_n43_n43.n56 w_n43_n43.n29 394
R846 w_n43_n43.n56 w_n43_n43.n35 394
R847 w_n43_n43.n52 w_n43_n43.n35 394
R848 w_n43_n43.n44 w_n43_n43.n43 394
R849 w_n43_n43.n46 w_n43_n43.n39 394
R850 w_n43_n43.n149 w_n43_n43.n117 394
R851 w_n43_n43.n153 w_n43_n43.n117 394
R852 w_n43_n43.n153 w_n43_n43.n112 394
R853 w_n43_n43.n157 w_n43_n43.n112 394
R854 w_n43_n43.n157 w_n43_n43.n110 394
R855 w_n43_n43.n161 w_n43_n43.n110 394
R856 w_n43_n43.n161 w_n43_n43.n105 394
R857 w_n43_n43.n165 w_n43_n43.n105 394
R858 w_n43_n43.n165 w_n43_n43.n103 394
R859 w_n43_n43.n169 w_n43_n43.n103 394
R860 w_n43_n43.n169 w_n43_n43.n98 394
R861 w_n43_n43.n173 w_n43_n43.n98 394
R862 w_n43_n43.n173 w_n43_n43.n7 394
R863 w_n43_n43.n177 w_n43_n43.n7 394
R864 w_n43_n43.n177 w_n43_n43.n6 394
R865 w_n43_n43.n94 w_n43_n43.n6 394
R866 w_n43_n43.n94 w_n43_n43.n9 394
R867 w_n43_n43.n86 w_n43_n43.n9 394
R868 w_n43_n43.n86 w_n43_n43.n15 394
R869 w_n43_n43.n82 w_n43_n43.n15 394
R870 w_n43_n43.n82 w_n43_n43.n17 394
R871 w_n43_n43.n74 w_n43_n43.n17 394
R872 w_n43_n43.n74 w_n43_n43.n23 394
R873 w_n43_n43.n70 w_n43_n43.n23 394
R874 w_n43_n43.n70 w_n43_n43.n25 394
R875 w_n43_n43.n62 w_n43_n43.n25 394
R876 w_n43_n43.n62 w_n43_n43.n31 394
R877 w_n43_n43.n58 w_n43_n43.n31 394
R878 w_n43_n43.n58 w_n43_n43.n33 394
R879 w_n43_n43.n50 w_n43_n43.n33 394
R880 w_n43_n43.n147 B 315.334
R881 w_n43_n43.n45 w_n43_n43.n38 218.815
R882 w_n43_n43.n42 w_n43_n43.n38 218.815
R883 w_n43_n43.n147 w_n43_n43.n122 218.815
R884 w_n43_n43.n147 w_n43_n43.n121 218.815
R885 w_n43_n43.n46 w_n43_n43.n45 147.374
R886 w_n43_n43.n43 w_n43_n43.n42 147.374
R887 w_n43_n43.n123 w_n43_n43.n122 147.374
R888 w_n43_n43.n125 w_n43_n43.n121 147.374
R889 w_n43_n43.n126 w_n43_n43.n122 147.374
R890 w_n43_n43.n121 w_n43_n43.n119 147.374
R891 w_n43_n43.n42 w_n43_n43.n37 147.374
R892 w_n43_n43.n45 w_n43_n43.n44 147.374
R893 w_n43_n43.n145 w_n43_n43.n144 85.4593
R894 w_n43_n43.n53 w_n43_n43.n36 85.4593
R895 w_n43_n43.n150 w_n43_n43.n118 85.4593
R896 w_n43_n43.n49 w_n43_n43.n48 85.4593
R897 w_n43_n43.n145 w_n43_n43.n128 25.6005
R898 w_n43_n43.n128 w_n43_n43.n127 25.6005
R899 w_n43_n43.n127 w_n43_n43.n124 25.6005
R900 w_n43_n43.n124 w_n43_n43.n118 25.6005
R901 w_n43_n43.n144 w_n43_n43.n143 25.6005
R902 w_n43_n43.n143 w_n43_n43.n141 25.6005
R903 w_n43_n43.n141 w_n43_n43.n140 25.6005
R904 w_n43_n43.n140 w_n43_n43.n139 25.6005
R905 w_n43_n43.n139 w_n43_n43.n138 25.6005
R906 w_n43_n43.n138 w_n43_n43.n136 25.6005
R907 w_n43_n43.n136 w_n43_n43.n135 25.6005
R908 w_n43_n43.n135 w_n43_n43.n134 25.6005
R909 w_n43_n43.n134 w_n43_n43.n133 25.6005
R910 w_n43_n43.n133 w_n43_n43.n131 25.6005
R911 w_n43_n43.n131 w_n43_n43.n130 25.6005
R912 w_n43_n43.n130 w_n43_n43.n129 25.6005
R913 w_n43_n43.n129 w_n43_n43.n1 25.6005
R914 w_n43_n43.n180 w_n43_n43.n1 25.6005
R915 w_n43_n43.n91 w_n43_n43.n0 25.6005
R916 w_n43_n43.n91 w_n43_n43.n90 25.6005
R917 w_n43_n43.n90 w_n43_n43.n89 25.6005
R918 w_n43_n43.n89 w_n43_n43.n12 25.6005
R919 w_n43_n43.n79 w_n43_n43.n12 25.6005
R920 w_n43_n43.n79 w_n43_n43.n78 25.6005
R921 w_n43_n43.n78 w_n43_n43.n77 25.6005
R922 w_n43_n43.n77 w_n43_n43.n20 25.6005
R923 w_n43_n43.n67 w_n43_n43.n20 25.6005
R924 w_n43_n43.n67 w_n43_n43.n66 25.6005
R925 w_n43_n43.n66 w_n43_n43.n65 25.6005
R926 w_n43_n43.n65 w_n43_n43.n28 25.6005
R927 w_n43_n43.n55 w_n43_n43.n28 25.6005
R928 w_n43_n43.n55 w_n43_n43.n54 25.6005
R929 w_n43_n43.n54 w_n43_n43.n53 25.6005
R930 w_n43_n43.n41 w_n43_n43.n36 25.6005
R931 w_n43_n43.n41 w_n43_n43.n40 25.6005
R932 w_n43_n43.n47 w_n43_n43.n40 25.6005
R933 w_n43_n43.n48 w_n43_n43.n47 25.6005
R934 w_n43_n43.n151 w_n43_n43.n150 25.6005
R935 w_n43_n43.n152 w_n43_n43.n151 25.6005
R936 w_n43_n43.n152 w_n43_n43.n111 25.6005
R937 w_n43_n43.n158 w_n43_n43.n111 25.6005
R938 w_n43_n43.n159 w_n43_n43.n158 25.6005
R939 w_n43_n43.n160 w_n43_n43.n159 25.6005
R940 w_n43_n43.n160 w_n43_n43.n104 25.6005
R941 w_n43_n43.n166 w_n43_n43.n104 25.6005
R942 w_n43_n43.n167 w_n43_n43.n166 25.6005
R943 w_n43_n43.n168 w_n43_n43.n167 25.6005
R944 w_n43_n43.n168 w_n43_n43.n97 25.6005
R945 w_n43_n43.n174 w_n43_n43.n97 25.6005
R946 w_n43_n43.n175 w_n43_n43.n174 25.6005
R947 w_n43_n43.n176 w_n43_n43.n175 25.6005
R948 w_n43_n43.n176 w_n43_n43.n96 25.6005
R949 w_n43_n43.n96 w_n43_n43.n95 25.6005
R950 w_n43_n43.n95 w_n43_n43.n8 25.6005
R951 w_n43_n43.n85 w_n43_n43.n8 25.6005
R952 w_n43_n43.n85 w_n43_n43.n84 25.6005
R953 w_n43_n43.n84 w_n43_n43.n83 25.6005
R954 w_n43_n43.n83 w_n43_n43.n16 25.6005
R955 w_n43_n43.n73 w_n43_n43.n16 25.6005
R956 w_n43_n43.n73 w_n43_n43.n72 25.6005
R957 w_n43_n43.n72 w_n43_n43.n71 25.6005
R958 w_n43_n43.n71 w_n43_n43.n24 25.6005
R959 w_n43_n43.n61 w_n43_n43.n24 25.6005
R960 w_n43_n43.n61 w_n43_n43.n60 25.6005
R961 w_n43_n43.n60 w_n43_n43.n59 25.6005
R962 w_n43_n43.n59 w_n43_n43.n32 25.6005
R963 w_n43_n43.n49 w_n43_n43.n32 25.6005
R964 B w_n43_n43.n180 19.2005
R965 B w_n43_n43.n0 6.4005
C2 B.n0 B 0 ; **FLOATING
C3 B.n3 B 0 ; **FLOATING
C4 B.n4 B 0 ; **FLOATING
C5 B.n5 B 0 ; **FLOATING
C6 B.n6 B 0 ; **FLOATING
C7 B.n7 B 0 ; **FLOATING
C8 B.n8 B 0 ; **FLOATING
C9 B.n9 B 0 ; **FLOATING
C10 B.n10 B 0 ; **FLOATING
C11 B.n11 B 0 ; **FLOATING
C12 B.n12 B 0 ; **FLOATING
C13 B.n13 B 0 ; **FLOATING
C14 B.n14 B 0 ; **FLOATING
C15 B.n15 B 0 ; **FLOATING
C16 B.n16 B 0 ; **FLOATING
C17 B.n17 B 0 ; **FLOATING
C18 B.n18 B 0 ; **FLOATING
C19 B.n19 B 0 ; **FLOATING
C20 B.n20 B 0 ; **FLOATING
C21 B.n21 B 0 ; **FLOATING
C22 B.n22 B 0 ; **FLOATING
C23 B.n23 B 0 ; **FLOATING
C24 B.n24 B 0 ; **FLOATING
C25 B.n25 B 0 ; **FLOATING
C26 B.n26 B 0 ; **FLOATING
C27 B.n27 B 0 ; **FLOATING
C28 B.n28 B 0 ; **FLOATING
C29 B.n29 B 0 ; **FLOATING
C30 B.n30 B 0 ; **FLOATING
C31 B.n31 B 0 ; **FLOATING
C32 B.n32 B 0 ; **FLOATING
C33 B.n33 B 0 ; **FLOATING
C34 B.n34 B 0 ; **FLOATING
C35 B.n35 B 0 ; **FLOATING
C36 B.n36 B 0 ; **FLOATING
C37 B.n37 B 0 ; **FLOATING
C38 B.n38 B 0 ; **FLOATING
C39 B.n39 B 0 ; **FLOATING
C40 B.n40 B 0 ; **FLOATING
C41 B.n41 B 0 ; **FLOATING
C42 B.n42 B 0 ; **FLOATING
C43 B.n43 B 0 ; **FLOATING
C44 B.n44 B 0 ; **FLOATING
C45 B.n45 B 0 ; **FLOATING
C46 B.n46 B 0 ; **FLOATING
C47 B.n47 B 0 ; **FLOATING
C48 B.n48 B 0 ; **FLOATING
C49 B.n49 B 0 ; **FLOATING
C50 B.n50 B 0 ; **FLOATING
C51 B.n51 B 0 ; **FLOATING
C52 B.n52 B 0 ; **FLOATING
C53 B.n53 B 0 ; **FLOATING
C54 B.n54 B 0 ; **FLOATING
C55 B.n55 B 0 ; **FLOATING
C56 B.n56 B 0 ; **FLOATING
C57 B.n57 B 0 ; **FLOATING
C58 B.n58 B 0 ; **FLOATING
C59 B.n59 B 0 ; **FLOATING
C60 B.n60 B 0 ; **FLOATING
C61 B.n61 B 0 ; **FLOATING
C62 B.n62 B 0 ; **FLOATING
C63 B.n63 B 0 ; **FLOATING
C64 B.n64 B 0 ; **FLOATING
C65 B.n65 B 0 ; **FLOATING
C66 B.n66 B 0 ; **FLOATING
C67 B.n67 B 0 ; **FLOATING
C68 B.n68 B 0 ; **FLOATING
C69 B.n70 B 0 ; **FLOATING
C70 B.n71 B 0 ; **FLOATING
C71 B.n72 B 0 ; **FLOATING
C72 B.n73 B 0 ; **FLOATING
C73 B.n74 B 0 ; **FLOATING
C74 B.n75 B 0 ; **FLOATING
C75 B.n76 B 0 ; **FLOATING
C76 B.n78 B 0 ; **FLOATING
C77 B.n79 B 0 ; **FLOATING
C78 B.n80 B 0 ; **FLOATING
C79 B.n81 B 0 ; **FLOATING
C80 B.n82 B 0 ; **FLOATING
C81 B.n83 B 0 ; **FLOATING
C82 B.n84 B 0 ; **FLOATING
C83 B.n85 B 0 ; **FLOATING
C84 B.n86 B 0 ; **FLOATING
C85 B.n87 B 0 ; **FLOATING
C86 B.n88 B 0 ; **FLOATING
C87 B.n89 B 0 ; **FLOATING
C88 B.n90 B 0 ; **FLOATING
C89 B.n91 B 0 ; **FLOATING
C90 B.n92 B 0 ; **FLOATING
C91 B.n93 B 0 ; **FLOATING
C92 B.n94 B 0 ; **FLOATING
C93 B.n95 B 0 ; **FLOATING
C94 B.n96 B 0 ; **FLOATING
C95 B.n97 B 0 ; **FLOATING
C96 B.n98 B 0 ; **FLOATING
C97 B.n99 B 0 ; **FLOATING
C98 B.n100 B 0 ; **FLOATING
C99 B.n101 B 0 ; **FLOATING
C100 B.n102 B 0 ; **FLOATING
C101 B.n103 B 0 ; **FLOATING
C102 B.n104 B 0 ; **FLOATING
C103 B.n105 B 0 ; **FLOATING
C104 B.n106 B 0 ; **FLOATING
C105 B.n107 B 0 ; **FLOATING
C106 B.n108 B 0 ; **FLOATING
C107 B.n109 B 0 ; **FLOATING
C108 B.n110 B 0 ; **FLOATING
C109 B.n111 B 0 ; **FLOATING
C110 B.n112 B 0 ; **FLOATING
C111 B.n113 B 0 ; **FLOATING
C112 B.n114 B 0 ; **FLOATING
C113 B.n115 B 0 ; **FLOATING
C114 B.n116 B 0 ; **FLOATING
C115 B.n117 B 0 ; **FLOATING
C116 B.n118 B 0 ; **FLOATING
C117 B.n119 B 0 ; **FLOATING
C118 B.n120 B 0 ; **FLOATING
C119 B.n121 B 0 ; **FLOATING
C120 B.n122 B 0 ; **FLOATING
C121 B.n123 B 0 ; **FLOATING
C122 B.n124 B 0 ; **FLOATING
C123 B.n125 B 0 ; **FLOATING
C124 B.n126 B 0 ; **FLOATING
C125 B.n127 B 0 ; **FLOATING
C126 B.n128 B 0 ; **FLOATING
C127 B.n129 B 0 ; **FLOATING
C128 B.n130 B 0 ; **FLOATING
C129 B.n131 B 0 ; **FLOATING
C130 B.n132 B 0 ; **FLOATING
C131 B.n133 B 0 ; **FLOATING
C132 B.n134 B 0 ; **FLOATING
C133 B.n135 B 0 ; **FLOATING
C134 B.n136 B 0 ; **FLOATING
C135 B.n137 B 0 ; **FLOATING
C136 B.n138 B 0 ; **FLOATING
C137 B.n139 B 0 ; **FLOATING
C138 B.n140 B 0 ; **FLOATING
C139 B.n141 B 0 ; **FLOATING
C140 B.n142 B 0 ; **FLOATING
C141 B.n143 B 0 ; **FLOATING
C142 B.n144 B 0 ; **FLOATING
C143 B.n145 B 0 ; **FLOATING
C144 B.n146 B 0 ; **FLOATING
C145 B.n147 B 0 ; **FLOATING
C146 B.n148 B 0 ; **FLOATING
C147 B.n149 B 0 ; **FLOATING
C148 B.n150 B 0 ; **FLOATING
C149 B.n151 B 0 ; **FLOATING
C150 B.n152 B 0 ; **FLOATING
C151 B.n153 B 0 ; **FLOATING
C152 B.n154 B 0 ; **FLOATING
C153 B.n155 B 0 ; **FLOATING
C154 B.n156 B 0 ; **FLOATING
C155 B.n157 B 0 ; **FLOATING
C156 B.n158 B 0 ; **FLOATING
C157 B.n159 B 0 ; **FLOATING
C158 B.n160 B 0 ; **FLOATING
C159 B.n161 B 0 ; **FLOATING
C160 B.n162 B 0 ; **FLOATING
C161 B.n163 B 0 ; **FLOATING
C162 B.n164 B 0 ; **FLOATING
C163 B.n165 B 0 ; **FLOATING
C164 B.n166 B 0 ; **FLOATING
C165 B.n167 B 0 ; **FLOATING
C166 B.n168 B 0 ; **FLOATING
C167 B.n169 B 0 ; **FLOATING
C168 B.n170 B 0 ; **FLOATING
C169 B.n171 B 0 ; **FLOATING
C170 B.n172 B 0 ; **FLOATING
C171 B.n173 B 0 ; **FLOATING
C172 B.n174 B 0 ; **FLOATING
C173 B.n175 B 0 ; **FLOATING
C174 B.n176 B 0 ; **FLOATING
C175 B.n177 B 0 ; **FLOATING
C176 B.n178 B 0 ; **FLOATING
C177 B.n179 B 0 ; **FLOATING
C178 B.n180 B 0 ; **FLOATING
C179 S B 0.15176f
C180 D B 0.15176f
C181 G B 4.16166f
