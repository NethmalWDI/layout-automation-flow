* NGSPICE file created from nfet_01v8_lvt_W66p13_L2p03_m1__nf8_gtop_sdhalf_outS.ext - technology: sky130A

.subckt sky130_fd_pr__nfet_01v8_lvt_QZJ5WQ G B D6 a_1827_n858# D4 D2 D0 S7 S5 S3 S1
X0 D4 G S3 B sky130_fd_pr__nfet_01v8_lvt ad=1.19915 pd=8.56 as=1.19915 ps=8.56 w=8.27 l=2.03
X1 S3 G D2 B sky130_fd_pr__nfet_01v8_lvt ad=1.19915 pd=8.56 as=1.19915 ps=8.56 w=8.27 l=2.03
X2 S1 G D0 B sky130_fd_pr__nfet_01v8_lvt ad=1.19915 pd=8.56 as=2.3983 ps=17.12 w=8.27 l=2.03
X3 D2 G S1 B sky130_fd_pr__nfet_01v8_lvt ad=1.19915 pd=8.56 as=1.19915 ps=8.56 w=8.27 l=2.03
X4 S7 G D6 B sky130_fd_pr__nfet_01v8_lvt ad=1.19915 pd=8.56 as=1.19915 ps=8.56 w=8.27 l=2.03
X5 D6 G S5 B sky130_fd_pr__nfet_01v8_lvt ad=1.19915 pd=8.56 as=1.19915 ps=8.56 w=8.27 l=2.03
X6 a_1827_n858# G S7 B sky130_fd_pr__nfet_01v8_lvt ad=2.3983 pd=17.12 as=1.19915 ps=8.56 w=8.27 l=2.03
X7 S5 G D4 B sky130_fd_pr__nfet_01v8_lvt ad=1.19915 pd=8.56 as=1.19915 ps=8.56 w=8.27 l=2.03
.ends

.subckt nfet_01v8_lvt_W66p13_L2p03_m1__nf8_gtop_sdhalf_outS S D G B
Xnfet_01v8_lvt_W66p13_L2p03_m1__nf8_gtop_sdhalf_outS_pc G B S S S S S D D D D sky130_fd_pr__nfet_01v8_lvt_QZJ5WQ
.ends
