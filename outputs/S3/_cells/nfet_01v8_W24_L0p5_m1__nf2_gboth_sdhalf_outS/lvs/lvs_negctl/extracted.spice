* NGSPICE file created from nfet_01v8_W24_L0p5_m1__nf2_gboth_sdhalf_outS.ext - technology: sky130A

.subckt sky130_fd_pr__nfet_01v8_P68KAC a_129_n1200# G B D0 S1
X0 S1 G D0 B sky130_fd_pr__nfet_01v8 ad=1.74 pd=12.29 as=3.48 ps=24.58 w=12 l=0.5
X1 a_129_n1200# G S1 B sky130_fd_pr__nfet_01v8 ad=3.48 pd=24.58 as=1.74 ps=12.29 w=12 l=0.5
.ends

.subckt nfet_01v8_W24_L0p5_m1__nf2_gboth_sdhalf_outS S D G B
Xnfet_01v8_W24_L0p5_m1__nf2_gboth_sdhalf_outS_pc S G B S D sky130_fd_pr__nfet_01v8_P68KAC
.ends
