* NGSPICE file created from pfet_01v8_lvt_W887p03_L0p74_m1__nf32_gboth_sdfull_outS.ext - technology: sky130A

.subckt sky130_fd_pr__pfet_01v8_lvt_BMU26W S27 D22 S17 D10 D20 S15 G D30 S25 S13 S23
+ S11 B S21 S31 D8 D6 D4 D2 a_3267_n2772# D0 S9 S7 D18 D28 S5 D16 D26 S3 D14 D24 S19
+ S1 S29 D12
X0 S23 G D22 B sky130_fd_pr__pfet_01v8_lvt ad=4.0194 pd=28.01 as=4.0194 ps=28.01 w=27.72 l=0.74
X1 a_3267_n2772# G S31 B sky130_fd_pr__pfet_01v8_lvt ad=8.0388 pd=56.02 as=4.0194 ps=28.01 w=27.72 l=0.74
X2 D10 G S9 B sky130_fd_pr__pfet_01v8_lvt ad=4.0194 pd=28.01 as=4.0194 ps=28.01 w=27.72 l=0.74
X3 S3 G D2 B sky130_fd_pr__pfet_01v8_lvt ad=4.0194 pd=28.01 as=4.0194 ps=28.01 w=27.72 l=0.74
X4 S9 G D8 B sky130_fd_pr__pfet_01v8_lvt ad=4.0194 pd=28.01 as=4.0194 ps=28.01 w=27.72 l=0.74
X5 S31 G D30 B sky130_fd_pr__pfet_01v8_lvt ad=4.0194 pd=28.01 as=4.0194 ps=28.01 w=27.72 l=0.74
X6 S13 G D12 B sky130_fd_pr__pfet_01v8_lvt ad=4.0194 pd=28.01 as=4.0194 ps=28.01 w=27.72 l=0.74
X7 D22 G S21 B sky130_fd_pr__pfet_01v8_lvt ad=4.0194 pd=28.01 as=4.0194 ps=28.01 w=27.72 l=0.74
X8 D28 G S27 B sky130_fd_pr__pfet_01v8_lvt ad=4.0194 pd=28.01 as=4.0194 ps=28.01 w=27.72 l=0.74
X9 D12 G S11 B sky130_fd_pr__pfet_01v8_lvt ad=4.0194 pd=28.01 as=4.0194 ps=28.01 w=27.72 l=0.74
X10 S11 G D10 B sky130_fd_pr__pfet_01v8_lvt ad=4.0194 pd=28.01 as=4.0194 ps=28.01 w=27.72 l=0.74
X11 D4 G S3 B sky130_fd_pr__pfet_01v8_lvt ad=4.0194 pd=28.01 as=4.0194 ps=28.01 w=27.72 l=0.74
X12 S5 G D4 B sky130_fd_pr__pfet_01v8_lvt ad=4.0194 pd=28.01 as=4.0194 ps=28.01 w=27.72 l=0.74
X13 S29 G D28 B sky130_fd_pr__pfet_01v8_lvt ad=4.0194 pd=28.01 as=4.0194 ps=28.01 w=27.72 l=0.74
X14 D30 G S29 B sky130_fd_pr__pfet_01v8_lvt ad=4.0194 pd=28.01 as=4.0194 ps=28.01 w=27.72 l=0.74
X15 S15 G D14 B sky130_fd_pr__pfet_01v8_lvt ad=4.0194 pd=28.01 as=4.0194 ps=28.01 w=27.72 l=0.74
X16 S17 G D16 B sky130_fd_pr__pfet_01v8_lvt ad=4.0194 pd=28.01 as=4.0194 ps=28.01 w=27.72 l=0.74
X17 S21 G D20 B sky130_fd_pr__pfet_01v8_lvt ad=4.0194 pd=28.01 as=4.0194 ps=28.01 w=27.72 l=0.74
X18 D14 G S13 B sky130_fd_pr__pfet_01v8_lvt ad=4.0194 pd=28.01 as=4.0194 ps=28.01 w=27.72 l=0.74
X19 S27 G D26 B sky130_fd_pr__pfet_01v8_lvt ad=4.0194 pd=28.01 as=4.0194 ps=28.01 w=27.72 l=0.74
X20 S7 G D6 B sky130_fd_pr__pfet_01v8_lvt ad=4.0194 pd=28.01 as=4.0194 ps=28.01 w=27.72 l=0.74
X21 D6 G S5 B sky130_fd_pr__pfet_01v8_lvt ad=4.0194 pd=28.01 as=4.0194 ps=28.01 w=27.72 l=0.74
X22 D26 G S25 B sky130_fd_pr__pfet_01v8_lvt ad=4.0194 pd=28.01 as=4.0194 ps=28.01 w=27.72 l=0.74
X23 S19 G D18 B sky130_fd_pr__pfet_01v8_lvt ad=4.0194 pd=28.01 as=4.0194 ps=28.01 w=27.72 l=0.74
X24 D16 G S15 B sky130_fd_pr__pfet_01v8_lvt ad=4.0194 pd=28.01 as=4.0194 ps=28.01 w=27.72 l=0.74
X25 D20 G S19 B sky130_fd_pr__pfet_01v8_lvt ad=4.0194 pd=28.01 as=4.0194 ps=28.01 w=27.72 l=0.74
X26 D2 G S1 B sky130_fd_pr__pfet_01v8_lvt ad=4.0194 pd=28.01 as=4.0194 ps=28.01 w=27.72 l=0.74
X27 D24 G S23 B sky130_fd_pr__pfet_01v8_lvt ad=4.0194 pd=28.01 as=4.0194 ps=28.01 w=27.72 l=0.74
X28 S25 G D24 B sky130_fd_pr__pfet_01v8_lvt ad=4.0194 pd=28.01 as=4.0194 ps=28.01 w=27.72 l=0.74
X29 S1 G D0 B sky130_fd_pr__pfet_01v8_lvt ad=4.0194 pd=28.01 as=8.0388 ps=56.02 w=27.72 l=0.74
X30 D18 G S17 B sky130_fd_pr__pfet_01v8_lvt ad=4.0194 pd=28.01 as=4.0194 ps=28.01 w=27.72 l=0.74
X31 D8 G S7 B sky130_fd_pr__pfet_01v8_lvt ad=4.0194 pd=28.01 as=4.0194 ps=28.01 w=27.72 l=0.74
.ends

.subckt pfet_01v8_lvt_W887p03_L0p74_m1__nf32_gboth_sdfull_outS S D G B
Xpfet_01v8_lvt_W887p03_L0p74_m1__nf32_gboth_sdfull_outS_pc D S D S S D G S D D D D
+ B D D S S S S S S D D S S D S S D S S D D D S sky130_fd_pr__pfet_01v8_lvt_BMU26W
.ends
