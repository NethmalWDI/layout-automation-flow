* NGSPICE file created from nfet_01v8_W24_L0p5_m1__nf4_gboth_sdhalf_outD_ng.ext - technology: sky130A

.subckt nfet_01v8_W24_L0p5_m1__nf4_gboth_sdhalf_outD_ng S D G B
X0 S G D B sky130_fd_pr__nfet_01v8 ad=0.87 pd=6.29 as=1.74 ps=12.58 w=6 l=0.5
X1 D G S B sky130_fd_pr__nfet_01v8 ad=1.74 pd=12.58 as=0.87 ps=6.29 w=6 l=0.5
X2 S G D B sky130_fd_pr__nfet_01v8 ad=0.87 pd=6.29 as=0.87 ps=6.29 w=6 l=0.5
X3 D G S B sky130_fd_pr__nfet_01v8 ad=0.87 pd=6.29 as=0.87 ps=6.29 w=6 l=0.5
C0 G D 0.61955f
C1 S D 0.87688f
C2 S G 0.61986f
C3 S B 0.09307f
C4 D B 0.58938f
C5 G B 1.20614f
.ends
