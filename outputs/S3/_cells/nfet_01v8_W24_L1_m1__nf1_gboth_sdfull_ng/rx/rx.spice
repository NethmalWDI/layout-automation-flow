* NGSPICE file created from nfet_01v8_W24_L1_m1__nf1_gboth_sdfull_ng.ext - technology: sky130A

X0 nfet_01v8_W24_L1_m1__nf1_gboth_sdfull_ng_pc/S.t0 nfet_01v8_W24_L1_m1__nf1_gboth_sdfull_ng_pc/G.t0 nfet_01v8_W24_L1_m1__nf1_gboth_sdfull_ng_pc/D.t0 B sky130_fd_pr__nfet_01v8 ad=6.96 pd=48.58 as=6.96 ps=48.58 w=24 l=1
C0 D G 1.30173f
C1 S D 0.71055f
C2 S G 1.30173f
R0 nfet_01v8_W24_L1_m1__nf1_gboth_sdfull_ng_pc/S.t0 nfet_01v8_W24_L1_m1__nf1_gboth_sdfull_ng_pc/S.n0 174.852
R1 nfet_01v8_W24_L1_m1__nf1_gboth_sdfull_ng_pc/S.n1 nfet_01v8_W24_L1_m1__nf1_gboth_sdfull_ng_pc/S.t0 174.852
R2 S nfet_01v8_W24_L1_m1__nf1_gboth_sdfull_ng_pc/S.n0 15.6336
R3 S nfet_01v8_W24_L1_m1__nf1_gboth_sdfull_ng_pc/S.n1 15.6336
R4 nfet_01v8_W24_L1_m1__nf1_gboth_sdfull_ng_pc/S.n1 S 5.29285
R5 S nfet_01v8_W24_L1_m1__nf1_gboth_sdfull_ng_pc/S.n0 5.18959
R6 nfet_01v8_W24_L1_m1__nf1_gboth_sdfull_ng_pc/D.t0 nfet_01v8_W24_L1_m1__nf1_gboth_sdfull_ng_pc/D.n0 174.852
R7 nfet_01v8_W24_L1_m1__nf1_gboth_sdfull_ng_pc/D.n1 nfet_01v8_W24_L1_m1__nf1_gboth_sdfull_ng_pc/D.t0 174.852
R8 D nfet_01v8_W24_L1_m1__nf1_gboth_sdfull_ng_pc/D.n0 15.6336
R9 D nfet_01v8_W24_L1_m1__nf1_gboth_sdfull_ng_pc/D.n1 15.6336
R10 nfet_01v8_W24_L1_m1__nf1_gboth_sdfull_ng_pc/D.n1 D 5.29285
R11 D nfet_01v8_W24_L1_m1__nf1_gboth_sdfull_ng_pc/D.n0 5.18959
R12 nfet_01v8_W24_L1_m1__nf1_gboth_sdfull_ng_pc/G.n1 nfet_01v8_W24_L1_m1__nf1_gboth_sdfull_ng_pc/G.t0 578.4
R13 nfet_01v8_W24_L1_m1__nf1_gboth_sdfull_ng_pc/G.n1 nfet_01v8_W24_L1_m1__nf1_gboth_sdfull_ng_pc/G.n0 170.624
R14 nfet_01v8_W24_L1_m1__nf1_gboth_sdfull_ng_pc/G.n2 nfet_01v8_W24_L1_m1__nf1_gboth_sdfull_ng_pc/G.n1 170.624
R15 G nfet_01v8_W24_L1_m1__nf1_gboth_sdfull_ng_pc/G.n0 12.8005
R16 G nfet_01v8_W24_L1_m1__nf1_gboth_sdfull_ng_pc/G.n2 12.8005
R17 G nfet_01v8_W24_L1_m1__nf1_gboth_sdfull_ng_pc/G.n0 10.2491
R18 nfet_01v8_W24_L1_m1__nf1_gboth_sdfull_ng_pc/G.n2 G 10.0534
C3 S B 4.07777f
C4 D B 4.07777f
C5 G B 0.59289f
C6 nfet_01v8_W24_L1_m1__nf1_gboth_sdfull_ng_pc/G.n0 B 0.00898f ; **FLOATING
C7 nfet_01v8_W24_L1_m1__nf1_gboth_sdfull_ng_pc/G.t0 B 1.91045f ; **FLOATING
C8 nfet_01v8_W24_L1_m1__nf1_gboth_sdfull_ng_pc/G.n1 B 0.64932f ; **FLOATING
C9 nfet_01v8_W24_L1_m1__nf1_gboth_sdfull_ng_pc/G.n2 B 0.00876f ; **FLOATING
C10 nfet_01v8_W24_L1_m1__nf1_gboth_sdfull_ng_pc/D.n0 B 0.03706f ; **FLOATING
C11 nfet_01v8_W24_L1_m1__nf1_gboth_sdfull_ng_pc/D.t0 B 0.0294f ; **FLOATING
C12 nfet_01v8_W24_L1_m1__nf1_gboth_sdfull_ng_pc/D.n1 B 0.05562f ; **FLOATING
C13 nfet_01v8_W24_L1_m1__nf1_gboth_sdfull_ng_pc/S.n0 B 0.03706f ; **FLOATING
C14 nfet_01v8_W24_L1_m1__nf1_gboth_sdfull_ng_pc/S.t0 B 0.0294f ; **FLOATING
C15 nfet_01v8_W24_L1_m1__nf1_gboth_sdfull_ng_pc/S.n1 B 0.05562f ; **FLOATING
