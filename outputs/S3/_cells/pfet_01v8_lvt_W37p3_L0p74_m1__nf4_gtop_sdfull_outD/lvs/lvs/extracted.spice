* NGSPICE file created from pfet_01v8_lvt_W37p3_L0p74_m1__nf4_gtop_sdfull_outD.ext - technology: sky130A

.subckt sky130_fd_pr__pfet_01v8_lvt_Z3FU2W G B D2 D0 a_383_n969# S3 S1
X0 S3 G D2 B sky130_fd_pr__pfet_01v8_lvt ad=1.35285 pd=9.62 as=1.35285 ps=9.62 w=9.33 l=0.74
X1 D2 G S1 B sky130_fd_pr__pfet_01v8_lvt ad=1.35285 pd=9.62 as=1.35285 ps=9.62 w=9.33 l=0.74
X2 S1 G D0 B sky130_fd_pr__pfet_01v8_lvt ad=1.35285 pd=9.62 as=2.7057 ps=19.24 w=9.33 l=0.74
X3 a_383_n969# G S3 B sky130_fd_pr__pfet_01v8_lvt ad=2.7057 pd=19.24 as=1.35285 ps=9.62 w=9.33 l=0.74
.ends

.subckt pfet_01v8_lvt_W37p3_L0p74_m1__nf4_gtop_sdfull_outD S D G B
Xpfet_01v8_lvt_W37p3_L0p74_m1__nf4_gtop_sdfull_outD_pc G B D D D S S sky130_fd_pr__pfet_01v8_lvt_Z3FU2W
.ends
