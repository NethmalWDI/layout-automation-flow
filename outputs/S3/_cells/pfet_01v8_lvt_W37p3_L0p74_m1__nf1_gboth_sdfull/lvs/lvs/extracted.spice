* NGSPICE file created from pfet_01v8_lvt_W37p3_L0p74_m1__nf1_gboth_sdfull.ext - technology: sky130A

.subckt sky130_fd_pr__pfet_01v8_lvt_NBSFYG G D B S
X0 S G D B sky130_fd_pr__pfet_01v8_lvt ad=10.817 pd=75.18 as=10.817 ps=75.18 w=37.3 l=0.74
.ends

.subckt pfet_01v8_lvt_W37p3_L0p74_m1__nf1_gboth_sdfull D S G B
Xpfet_01v8_lvt_W37p3_L0p74_m1__nf1_gboth_sdfull_pc G D B S sky130_fd_pr__pfet_01v8_lvt_NBSFYG
.ends
