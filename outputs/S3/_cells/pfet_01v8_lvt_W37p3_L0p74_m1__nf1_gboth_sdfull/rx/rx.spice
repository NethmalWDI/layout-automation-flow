* NGSPICE file created from pfet_01v8_lvt_W37p3_L0p74_m1__nf1_gboth_sdfull.ext - technology: sky130A

X0 S pfet_01v8_lvt_W37p3_L0p74_m1__nf1_gboth_sdfull_pc/G.t0 D pfet_01v8_lvt_W37p3_L0p74_m1__nf1_gboth_sdfull_pc/B.t0 sky130_fd_pr__pfet_01v8_lvt ad=10.817 pd=75.18 as=10.817 ps=75.18 w=37.3 l=0.74
C0 D S 1.38952f
C1 B S 2.17456f
C2 D B 2.17456f
C3 G S 1.71558f
C4 D G 1.71558f
C5 G B 0.35539f
R0 pfet_01v8_lvt_W37p3_L0p74_m1__nf1_gboth_sdfull_pc/G.n1 pfet_01v8_lvt_W37p3_L0p74_m1__nf1_gboth_sdfull_pc/G.t0 1214.77
R1 pfet_01v8_lvt_W37p3_L0p74_m1__nf1_gboth_sdfull_pc/G.n1 pfet_01v8_lvt_W37p3_L0p74_m1__nf1_gboth_sdfull_pc/G.n0 168.895
R2 pfet_01v8_lvt_W37p3_L0p74_m1__nf1_gboth_sdfull_pc/G.n2 pfet_01v8_lvt_W37p3_L0p74_m1__nf1_gboth_sdfull_pc/G.n1 168.895
R3 G pfet_01v8_lvt_W37p3_L0p74_m1__nf1_gboth_sdfull_pc/G.n0 12.8005
R4 G pfet_01v8_lvt_W37p3_L0p74_m1__nf1_gboth_sdfull_pc/G.n2 12.8005
R5 G pfet_01v8_lvt_W37p3_L0p74_m1__nf1_gboth_sdfull_pc/G.n0 10.2491
R6 pfet_01v8_lvt_W37p3_L0p74_m1__nf1_gboth_sdfull_pc/G.n2 G 10.0534
R7 pfet_01v8_lvt_W37p3_L0p74_m1__nf1_gboth_sdfull_pc/B.n284 pfet_01v8_lvt_W37p3_L0p74_m1__nf1_gboth_sdfull_pc/B.n10 776.471
R8 pfet_01v8_lvt_W37p3_L0p74_m1__nf1_gboth_sdfull_pc/B.n326 pfet_01v8_lvt_W37p3_L0p74_m1__nf1_gboth_sdfull_pc/B.n3 776.471
R9 pfet_01v8_lvt_W37p3_L0p74_m1__nf1_gboth_sdfull_pc/B.n559 pfet_01v8_lvt_W37p3_L0p74_m1__nf1_gboth_sdfull_pc/B.n6 776.471
R10 pfet_01v8_lvt_W37p3_L0p74_m1__nf1_gboth_sdfull_pc/B.n287 pfet_01v8_lvt_W37p3_L0p74_m1__nf1_gboth_sdfull_pc/B.n8 776.471
R11 pfet_01v8_lvt_W37p3_L0p74_m1__nf1_gboth_sdfull_pc/B.n280 pfet_01v8_lvt_W37p3_L0p74_m1__nf1_gboth_sdfull_pc/B.n278 240
R12 pfet_01v8_lvt_W37p3_L0p74_m1__nf1_gboth_sdfull_pc/B.n276 pfet_01v8_lvt_W37p3_L0p74_m1__nf1_gboth_sdfull_pc/B.n12 240
R13 pfet_01v8_lvt_W37p3_L0p74_m1__nf1_gboth_sdfull_pc/B.n272 pfet_01v8_lvt_W37p3_L0p74_m1__nf1_gboth_sdfull_pc/B.n270 240
R14 pfet_01v8_lvt_W37p3_L0p74_m1__nf1_gboth_sdfull_pc/B.n270 pfet_01v8_lvt_W37p3_L0p74_m1__nf1_gboth_sdfull_pc/B.n269 240
R15 pfet_01v8_lvt_W37p3_L0p74_m1__nf1_gboth_sdfull_pc/B.n266 pfet_01v8_lvt_W37p3_L0p74_m1__nf1_gboth_sdfull_pc/B.n265 240
R16 pfet_01v8_lvt_W37p3_L0p74_m1__nf1_gboth_sdfull_pc/B.n265 pfet_01v8_lvt_W37p3_L0p74_m1__nf1_gboth_sdfull_pc/B.n264 240
R17 pfet_01v8_lvt_W37p3_L0p74_m1__nf1_gboth_sdfull_pc/B.n261 pfet_01v8_lvt_W37p3_L0p74_m1__nf1_gboth_sdfull_pc/B.n260 240
R18 pfet_01v8_lvt_W37p3_L0p74_m1__nf1_gboth_sdfull_pc/B.n258 pfet_01v8_lvt_W37p3_L0p74_m1__nf1_gboth_sdfull_pc/B.n18 240
R19 pfet_01v8_lvt_W37p3_L0p74_m1__nf1_gboth_sdfull_pc/B.n254 pfet_01v8_lvt_W37p3_L0p74_m1__nf1_gboth_sdfull_pc/B.n252 240
R20 pfet_01v8_lvt_W37p3_L0p74_m1__nf1_gboth_sdfull_pc/B.n250 pfet_01v8_lvt_W37p3_L0p74_m1__nf1_gboth_sdfull_pc/B.n20 240
R21 pfet_01v8_lvt_W37p3_L0p74_m1__nf1_gboth_sdfull_pc/B.n246 pfet_01v8_lvt_W37p3_L0p74_m1__nf1_gboth_sdfull_pc/B.n244 240
R22 pfet_01v8_lvt_W37p3_L0p74_m1__nf1_gboth_sdfull_pc/B.n244 pfet_01v8_lvt_W37p3_L0p74_m1__nf1_gboth_sdfull_pc/B.n243 240
R23 pfet_01v8_lvt_W37p3_L0p74_m1__nf1_gboth_sdfull_pc/B.n240 pfet_01v8_lvt_W37p3_L0p74_m1__nf1_gboth_sdfull_pc/B.n239 240
R24 pfet_01v8_lvt_W37p3_L0p74_m1__nf1_gboth_sdfull_pc/B.n237 pfet_01v8_lvt_W37p3_L0p74_m1__nf1_gboth_sdfull_pc/B.n24 240
R25 pfet_01v8_lvt_W37p3_L0p74_m1__nf1_gboth_sdfull_pc/B.n233 pfet_01v8_lvt_W37p3_L0p74_m1__nf1_gboth_sdfull_pc/B.n231 240
R26 pfet_01v8_lvt_W37p3_L0p74_m1__nf1_gboth_sdfull_pc/B.n229 pfet_01v8_lvt_W37p3_L0p74_m1__nf1_gboth_sdfull_pc/B.n26 240
R27 pfet_01v8_lvt_W37p3_L0p74_m1__nf1_gboth_sdfull_pc/B.n225 pfet_01v8_lvt_W37p3_L0p74_m1__nf1_gboth_sdfull_pc/B.n223 240
R28 pfet_01v8_lvt_W37p3_L0p74_m1__nf1_gboth_sdfull_pc/B.n221 pfet_01v8_lvt_W37p3_L0p74_m1__nf1_gboth_sdfull_pc/B.n28 240
R29 pfet_01v8_lvt_W37p3_L0p74_m1__nf1_gboth_sdfull_pc/B.n217 pfet_01v8_lvt_W37p3_L0p74_m1__nf1_gboth_sdfull_pc/B.n215 240
R30 pfet_01v8_lvt_W37p3_L0p74_m1__nf1_gboth_sdfull_pc/B.n213 pfet_01v8_lvt_W37p3_L0p74_m1__nf1_gboth_sdfull_pc/B.n30 240
R31 pfet_01v8_lvt_W37p3_L0p74_m1__nf1_gboth_sdfull_pc/B.n209 pfet_01v8_lvt_W37p3_L0p74_m1__nf1_gboth_sdfull_pc/B.n30 240
R32 pfet_01v8_lvt_W37p3_L0p74_m1__nf1_gboth_sdfull_pc/B.n207 pfet_01v8_lvt_W37p3_L0p74_m1__nf1_gboth_sdfull_pc/B.n206 240
R33 pfet_01v8_lvt_W37p3_L0p74_m1__nf1_gboth_sdfull_pc/B.n203 pfet_01v8_lvt_W37p3_L0p74_m1__nf1_gboth_sdfull_pc/B.n202 240
R34 pfet_01v8_lvt_W37p3_L0p74_m1__nf1_gboth_sdfull_pc/B.n200 pfet_01v8_lvt_W37p3_L0p74_m1__nf1_gboth_sdfull_pc/B.n34 240
R35 pfet_01v8_lvt_W37p3_L0p74_m1__nf1_gboth_sdfull_pc/B.n196 pfet_01v8_lvt_W37p3_L0p74_m1__nf1_gboth_sdfull_pc/B.n34 240
R36 pfet_01v8_lvt_W37p3_L0p74_m1__nf1_gboth_sdfull_pc/B.n194 pfet_01v8_lvt_W37p3_L0p74_m1__nf1_gboth_sdfull_pc/B.n193 240
R37 pfet_01v8_lvt_W37p3_L0p74_m1__nf1_gboth_sdfull_pc/B.n190 pfet_01v8_lvt_W37p3_L0p74_m1__nf1_gboth_sdfull_pc/B.n189 240
R38 pfet_01v8_lvt_W37p3_L0p74_m1__nf1_gboth_sdfull_pc/B.n187 pfet_01v8_lvt_W37p3_L0p74_m1__nf1_gboth_sdfull_pc/B.n38 240
R39 pfet_01v8_lvt_W37p3_L0p74_m1__nf1_gboth_sdfull_pc/B.n183 pfet_01v8_lvt_W37p3_L0p74_m1__nf1_gboth_sdfull_pc/B.n181 240
R40 pfet_01v8_lvt_W37p3_L0p74_m1__nf1_gboth_sdfull_pc/B.n179 pfet_01v8_lvt_W37p3_L0p74_m1__nf1_gboth_sdfull_pc/B.n40 240
R41 pfet_01v8_lvt_W37p3_L0p74_m1__nf1_gboth_sdfull_pc/B.n175 pfet_01v8_lvt_W37p3_L0p74_m1__nf1_gboth_sdfull_pc/B.n173 240
R42 pfet_01v8_lvt_W37p3_L0p74_m1__nf1_gboth_sdfull_pc/B.n171 pfet_01v8_lvt_W37p3_L0p74_m1__nf1_gboth_sdfull_pc/B.n42 240
R43 pfet_01v8_lvt_W37p3_L0p74_m1__nf1_gboth_sdfull_pc/B.n167 pfet_01v8_lvt_W37p3_L0p74_m1__nf1_gboth_sdfull_pc/B.n165 240
R44 pfet_01v8_lvt_W37p3_L0p74_m1__nf1_gboth_sdfull_pc/B.n163 pfet_01v8_lvt_W37p3_L0p74_m1__nf1_gboth_sdfull_pc/B.n44 240
R45 pfet_01v8_lvt_W37p3_L0p74_m1__nf1_gboth_sdfull_pc/B.n159 pfet_01v8_lvt_W37p3_L0p74_m1__nf1_gboth_sdfull_pc/B.n157 240
R46 pfet_01v8_lvt_W37p3_L0p74_m1__nf1_gboth_sdfull_pc/B.n155 pfet_01v8_lvt_W37p3_L0p74_m1__nf1_gboth_sdfull_pc/B.n46 240
R47 pfet_01v8_lvt_W37p3_L0p74_m1__nf1_gboth_sdfull_pc/B.n151 pfet_01v8_lvt_W37p3_L0p74_m1__nf1_gboth_sdfull_pc/B.n46 240
R48 pfet_01v8_lvt_W37p3_L0p74_m1__nf1_gboth_sdfull_pc/B.n149 pfet_01v8_lvt_W37p3_L0p74_m1__nf1_gboth_sdfull_pc/B.n148 240
R49 pfet_01v8_lvt_W37p3_L0p74_m1__nf1_gboth_sdfull_pc/B.n145 pfet_01v8_lvt_W37p3_L0p74_m1__nf1_gboth_sdfull_pc/B.n144 240
R50 pfet_01v8_lvt_W37p3_L0p74_m1__nf1_gboth_sdfull_pc/B.n142 pfet_01v8_lvt_W37p3_L0p74_m1__nf1_gboth_sdfull_pc/B.n50 240
R51 pfet_01v8_lvt_W37p3_L0p74_m1__nf1_gboth_sdfull_pc/B.n138 pfet_01v8_lvt_W37p3_L0p74_m1__nf1_gboth_sdfull_pc/B.n50 240
R52 pfet_01v8_lvt_W37p3_L0p74_m1__nf1_gboth_sdfull_pc/B.n136 pfet_01v8_lvt_W37p3_L0p74_m1__nf1_gboth_sdfull_pc/B.n135 240
R53 pfet_01v8_lvt_W37p3_L0p74_m1__nf1_gboth_sdfull_pc/B.n133 pfet_01v8_lvt_W37p3_L0p74_m1__nf1_gboth_sdfull_pc/B.n53 240
R54 pfet_01v8_lvt_W37p3_L0p74_m1__nf1_gboth_sdfull_pc/B.n129 pfet_01v8_lvt_W37p3_L0p74_m1__nf1_gboth_sdfull_pc/B.n127 240
R55 pfet_01v8_lvt_W37p3_L0p74_m1__nf1_gboth_sdfull_pc/B.n127 pfet_01v8_lvt_W37p3_L0p74_m1__nf1_gboth_sdfull_pc/B.n126 240
R56 pfet_01v8_lvt_W37p3_L0p74_m1__nf1_gboth_sdfull_pc/B.n123 pfet_01v8_lvt_W37p3_L0p74_m1__nf1_gboth_sdfull_pc/B.n122 240
R57 pfet_01v8_lvt_W37p3_L0p74_m1__nf1_gboth_sdfull_pc/B.n120 pfet_01v8_lvt_W37p3_L0p74_m1__nf1_gboth_sdfull_pc/B.n57 240
R58 pfet_01v8_lvt_W37p3_L0p74_m1__nf1_gboth_sdfull_pc/B.n116 pfet_01v8_lvt_W37p3_L0p74_m1__nf1_gboth_sdfull_pc/B.n57 240
R59 pfet_01v8_lvt_W37p3_L0p74_m1__nf1_gboth_sdfull_pc/B.n114 pfet_01v8_lvt_W37p3_L0p74_m1__nf1_gboth_sdfull_pc/B.n113 240
R60 pfet_01v8_lvt_W37p3_L0p74_m1__nf1_gboth_sdfull_pc/B.n110 pfet_01v8_lvt_W37p3_L0p74_m1__nf1_gboth_sdfull_pc/B.n109 240
R61 pfet_01v8_lvt_W37p3_L0p74_m1__nf1_gboth_sdfull_pc/B.n107 pfet_01v8_lvt_W37p3_L0p74_m1__nf1_gboth_sdfull_pc/B.n61 240
R62 pfet_01v8_lvt_W37p3_L0p74_m1__nf1_gboth_sdfull_pc/B.n103 pfet_01v8_lvt_W37p3_L0p74_m1__nf1_gboth_sdfull_pc/B.n101 240
R63 pfet_01v8_lvt_W37p3_L0p74_m1__nf1_gboth_sdfull_pc/B.n99 pfet_01v8_lvt_W37p3_L0p74_m1__nf1_gboth_sdfull_pc/B.n63 240
R64 pfet_01v8_lvt_W37p3_L0p74_m1__nf1_gboth_sdfull_pc/B.n95 pfet_01v8_lvt_W37p3_L0p74_m1__nf1_gboth_sdfull_pc/B.n93 240
R65 pfet_01v8_lvt_W37p3_L0p74_m1__nf1_gboth_sdfull_pc/B.n91 pfet_01v8_lvt_W37p3_L0p74_m1__nf1_gboth_sdfull_pc/B.n65 240
R66 pfet_01v8_lvt_W37p3_L0p74_m1__nf1_gboth_sdfull_pc/B.n87 pfet_01v8_lvt_W37p3_L0p74_m1__nf1_gboth_sdfull_pc/B.n65 240
R67 pfet_01v8_lvt_W37p3_L0p74_m1__nf1_gboth_sdfull_pc/B.n85 pfet_01v8_lvt_W37p3_L0p74_m1__nf1_gboth_sdfull_pc/B.n84 240
R68 pfet_01v8_lvt_W37p3_L0p74_m1__nf1_gboth_sdfull_pc/B.n81 pfet_01v8_lvt_W37p3_L0p74_m1__nf1_gboth_sdfull_pc/B.n80 240
R69 pfet_01v8_lvt_W37p3_L0p74_m1__nf1_gboth_sdfull_pc/B.n78 pfet_01v8_lvt_W37p3_L0p74_m1__nf1_gboth_sdfull_pc/B.n69 240
R70 pfet_01v8_lvt_W37p3_L0p74_m1__nf1_gboth_sdfull_pc/B.n74 pfet_01v8_lvt_W37p3_L0p74_m1__nf1_gboth_sdfull_pc/B.n72 240
R71 pfet_01v8_lvt_W37p3_L0p74_m1__nf1_gboth_sdfull_pc/B.n565 pfet_01v8_lvt_W37p3_L0p74_m1__nf1_gboth_sdfull_pc/B.n3 240
R72 pfet_01v8_lvt_W37p3_L0p74_m1__nf1_gboth_sdfull_pc/B.n565 pfet_01v8_lvt_W37p3_L0p74_m1__nf1_gboth_sdfull_pc/B.n2 240
R73 pfet_01v8_lvt_W37p3_L0p74_m1__nf1_gboth_sdfull_pc/B.n284 pfet_01v8_lvt_W37p3_L0p74_m1__nf1_gboth_sdfull_pc/B.n2 240
R74 pfet_01v8_lvt_W37p3_L0p74_m1__nf1_gboth_sdfull_pc/B.n366 pfet_01v8_lvt_W37p3_L0p74_m1__nf1_gboth_sdfull_pc/B.n326 240
R75 pfet_01v8_lvt_W37p3_L0p74_m1__nf1_gboth_sdfull_pc/B.n370 pfet_01v8_lvt_W37p3_L0p74_m1__nf1_gboth_sdfull_pc/B.n369 240
R76 pfet_01v8_lvt_W37p3_L0p74_m1__nf1_gboth_sdfull_pc/B.n372 pfet_01v8_lvt_W37p3_L0p74_m1__nf1_gboth_sdfull_pc/B.n329 240
R77 pfet_01v8_lvt_W37p3_L0p74_m1__nf1_gboth_sdfull_pc/B.n375 pfet_01v8_lvt_W37p3_L0p74_m1__nf1_gboth_sdfull_pc/B.n329 240
R78 pfet_01v8_lvt_W37p3_L0p74_m1__nf1_gboth_sdfull_pc/B.n379 pfet_01v8_lvt_W37p3_L0p74_m1__nf1_gboth_sdfull_pc/B.n378 240
R79 pfet_01v8_lvt_W37p3_L0p74_m1__nf1_gboth_sdfull_pc/B.n383 pfet_01v8_lvt_W37p3_L0p74_m1__nf1_gboth_sdfull_pc/B.n382 240
R80 pfet_01v8_lvt_W37p3_L0p74_m1__nf1_gboth_sdfull_pc/B.n387 pfet_01v8_lvt_W37p3_L0p74_m1__nf1_gboth_sdfull_pc/B.n386 240
R81 pfet_01v8_lvt_W37p3_L0p74_m1__nf1_gboth_sdfull_pc/B.n391 pfet_01v8_lvt_W37p3_L0p74_m1__nf1_gboth_sdfull_pc/B.n390 240
R82 pfet_01v8_lvt_W37p3_L0p74_m1__nf1_gboth_sdfull_pc/B.n395 pfet_01v8_lvt_W37p3_L0p74_m1__nf1_gboth_sdfull_pc/B.n394 240
R83 pfet_01v8_lvt_W37p3_L0p74_m1__nf1_gboth_sdfull_pc/B.n397 pfet_01v8_lvt_W37p3_L0p74_m1__nf1_gboth_sdfull_pc/B.n320 240
R84 pfet_01v8_lvt_W37p3_L0p74_m1__nf1_gboth_sdfull_pc/B.n400 pfet_01v8_lvt_W37p3_L0p74_m1__nf1_gboth_sdfull_pc/B.n320 240
R85 pfet_01v8_lvt_W37p3_L0p74_m1__nf1_gboth_sdfull_pc/B.n402 pfet_01v8_lvt_W37p3_L0p74_m1__nf1_gboth_sdfull_pc/B.n332 240
R86 pfet_01v8_lvt_W37p3_L0p74_m1__nf1_gboth_sdfull_pc/B.n405 pfet_01v8_lvt_W37p3_L0p74_m1__nf1_gboth_sdfull_pc/B.n332 240
R87 pfet_01v8_lvt_W37p3_L0p74_m1__nf1_gboth_sdfull_pc/B.n409 pfet_01v8_lvt_W37p3_L0p74_m1__nf1_gboth_sdfull_pc/B.n408 240
R88 pfet_01v8_lvt_W37p3_L0p74_m1__nf1_gboth_sdfull_pc/B.n413 pfet_01v8_lvt_W37p3_L0p74_m1__nf1_gboth_sdfull_pc/B.n412 240
R89 pfet_01v8_lvt_W37p3_L0p74_m1__nf1_gboth_sdfull_pc/B.n415 pfet_01v8_lvt_W37p3_L0p74_m1__nf1_gboth_sdfull_pc/B.n317 240
R90 pfet_01v8_lvt_W37p3_L0p74_m1__nf1_gboth_sdfull_pc/B.n418 pfet_01v8_lvt_W37p3_L0p74_m1__nf1_gboth_sdfull_pc/B.n317 240
R91 pfet_01v8_lvt_W37p3_L0p74_m1__nf1_gboth_sdfull_pc/B.n420 pfet_01v8_lvt_W37p3_L0p74_m1__nf1_gboth_sdfull_pc/B.n335 240
R92 pfet_01v8_lvt_W37p3_L0p74_m1__nf1_gboth_sdfull_pc/B.n423 pfet_01v8_lvt_W37p3_L0p74_m1__nf1_gboth_sdfull_pc/B.n335 240
R93 pfet_01v8_lvt_W37p3_L0p74_m1__nf1_gboth_sdfull_pc/B.n425 pfet_01v8_lvt_W37p3_L0p74_m1__nf1_gboth_sdfull_pc/B.n315 240
R94 pfet_01v8_lvt_W37p3_L0p74_m1__nf1_gboth_sdfull_pc/B.n428 pfet_01v8_lvt_W37p3_L0p74_m1__nf1_gboth_sdfull_pc/B.n315 240
R95 pfet_01v8_lvt_W37p3_L0p74_m1__nf1_gboth_sdfull_pc/B.n432 pfet_01v8_lvt_W37p3_L0p74_m1__nf1_gboth_sdfull_pc/B.n431 240
R96 pfet_01v8_lvt_W37p3_L0p74_m1__nf1_gboth_sdfull_pc/B.n434 pfet_01v8_lvt_W37p3_L0p74_m1__nf1_gboth_sdfull_pc/B.n337 240
R97 pfet_01v8_lvt_W37p3_L0p74_m1__nf1_gboth_sdfull_pc/B.n437 pfet_01v8_lvt_W37p3_L0p74_m1__nf1_gboth_sdfull_pc/B.n337 240
R98 pfet_01v8_lvt_W37p3_L0p74_m1__nf1_gboth_sdfull_pc/B.n439 pfet_01v8_lvt_W37p3_L0p74_m1__nf1_gboth_sdfull_pc/B.n312 240
R99 pfet_01v8_lvt_W37p3_L0p74_m1__nf1_gboth_sdfull_pc/B.n442 pfet_01v8_lvt_W37p3_L0p74_m1__nf1_gboth_sdfull_pc/B.n312 240
R100 pfet_01v8_lvt_W37p3_L0p74_m1__nf1_gboth_sdfull_pc/B.n446 pfet_01v8_lvt_W37p3_L0p74_m1__nf1_gboth_sdfull_pc/B.n445 240
R101 pfet_01v8_lvt_W37p3_L0p74_m1__nf1_gboth_sdfull_pc/B.n448 pfet_01v8_lvt_W37p3_L0p74_m1__nf1_gboth_sdfull_pc/B.n340 240
R102 pfet_01v8_lvt_W37p3_L0p74_m1__nf1_gboth_sdfull_pc/B.n451 pfet_01v8_lvt_W37p3_L0p74_m1__nf1_gboth_sdfull_pc/B.n340 240
R103 pfet_01v8_lvt_W37p3_L0p74_m1__nf1_gboth_sdfull_pc/B.n455 pfet_01v8_lvt_W37p3_L0p74_m1__nf1_gboth_sdfull_pc/B.n454 240
R104 pfet_01v8_lvt_W37p3_L0p74_m1__nf1_gboth_sdfull_pc/B.n459 pfet_01v8_lvt_W37p3_L0p74_m1__nf1_gboth_sdfull_pc/B.n458 240
R105 pfet_01v8_lvt_W37p3_L0p74_m1__nf1_gboth_sdfull_pc/B.n463 pfet_01v8_lvt_W37p3_L0p74_m1__nf1_gboth_sdfull_pc/B.n462 240
R106 pfet_01v8_lvt_W37p3_L0p74_m1__nf1_gboth_sdfull_pc/B.n465 pfet_01v8_lvt_W37p3_L0p74_m1__nf1_gboth_sdfull_pc/B.n307 240
R107 pfet_01v8_lvt_W37p3_L0p74_m1__nf1_gboth_sdfull_pc/B.n468 pfet_01v8_lvt_W37p3_L0p74_m1__nf1_gboth_sdfull_pc/B.n307 240
R108 pfet_01v8_lvt_W37p3_L0p74_m1__nf1_gboth_sdfull_pc/B.n472 pfet_01v8_lvt_W37p3_L0p74_m1__nf1_gboth_sdfull_pc/B.n471 240
R109 pfet_01v8_lvt_W37p3_L0p74_m1__nf1_gboth_sdfull_pc/B.n474 pfet_01v8_lvt_W37p3_L0p74_m1__nf1_gboth_sdfull_pc/B.n342 240
R110 pfet_01v8_lvt_W37p3_L0p74_m1__nf1_gboth_sdfull_pc/B.n477 pfet_01v8_lvt_W37p3_L0p74_m1__nf1_gboth_sdfull_pc/B.n342 240
R111 pfet_01v8_lvt_W37p3_L0p74_m1__nf1_gboth_sdfull_pc/B.n481 pfet_01v8_lvt_W37p3_L0p74_m1__nf1_gboth_sdfull_pc/B.n480 240
R112 pfet_01v8_lvt_W37p3_L0p74_m1__nf1_gboth_sdfull_pc/B.n485 pfet_01v8_lvt_W37p3_L0p74_m1__nf1_gboth_sdfull_pc/B.n484 240
R113 pfet_01v8_lvt_W37p3_L0p74_m1__nf1_gboth_sdfull_pc/B.n489 pfet_01v8_lvt_W37p3_L0p74_m1__nf1_gboth_sdfull_pc/B.n488 240
R114 pfet_01v8_lvt_W37p3_L0p74_m1__nf1_gboth_sdfull_pc/B.n493 pfet_01v8_lvt_W37p3_L0p74_m1__nf1_gboth_sdfull_pc/B.n492 240
R115 pfet_01v8_lvt_W37p3_L0p74_m1__nf1_gboth_sdfull_pc/B.n497 pfet_01v8_lvt_W37p3_L0p74_m1__nf1_gboth_sdfull_pc/B.n496 240
R116 pfet_01v8_lvt_W37p3_L0p74_m1__nf1_gboth_sdfull_pc/B.n499 pfet_01v8_lvt_W37p3_L0p74_m1__nf1_gboth_sdfull_pc/B.n301 240
R117 pfet_01v8_lvt_W37p3_L0p74_m1__nf1_gboth_sdfull_pc/B.n502 pfet_01v8_lvt_W37p3_L0p74_m1__nf1_gboth_sdfull_pc/B.n301 240
R118 pfet_01v8_lvt_W37p3_L0p74_m1__nf1_gboth_sdfull_pc/B.n506 pfet_01v8_lvt_W37p3_L0p74_m1__nf1_gboth_sdfull_pc/B.n505 240
R119 pfet_01v8_lvt_W37p3_L0p74_m1__nf1_gboth_sdfull_pc/B.n508 pfet_01v8_lvt_W37p3_L0p74_m1__nf1_gboth_sdfull_pc/B.n347 240
R120 pfet_01v8_lvt_W37p3_L0p74_m1__nf1_gboth_sdfull_pc/B.n511 pfet_01v8_lvt_W37p3_L0p74_m1__nf1_gboth_sdfull_pc/B.n347 240
R121 pfet_01v8_lvt_W37p3_L0p74_m1__nf1_gboth_sdfull_pc/B.n513 pfet_01v8_lvt_W37p3_L0p74_m1__nf1_gboth_sdfull_pc/B.n299 240
R122 pfet_01v8_lvt_W37p3_L0p74_m1__nf1_gboth_sdfull_pc/B.n516 pfet_01v8_lvt_W37p3_L0p74_m1__nf1_gboth_sdfull_pc/B.n299 240
R123 pfet_01v8_lvt_W37p3_L0p74_m1__nf1_gboth_sdfull_pc/B.n520 pfet_01v8_lvt_W37p3_L0p74_m1__nf1_gboth_sdfull_pc/B.n519 240
R124 pfet_01v8_lvt_W37p3_L0p74_m1__nf1_gboth_sdfull_pc/B.n524 pfet_01v8_lvt_W37p3_L0p74_m1__nf1_gboth_sdfull_pc/B.n523 240
R125 pfet_01v8_lvt_W37p3_L0p74_m1__nf1_gboth_sdfull_pc/B.n528 pfet_01v8_lvt_W37p3_L0p74_m1__nf1_gboth_sdfull_pc/B.n527 240
R126 pfet_01v8_lvt_W37p3_L0p74_m1__nf1_gboth_sdfull_pc/B.n532 pfet_01v8_lvt_W37p3_L0p74_m1__nf1_gboth_sdfull_pc/B.n531 240
R127 pfet_01v8_lvt_W37p3_L0p74_m1__nf1_gboth_sdfull_pc/B.n534 pfet_01v8_lvt_W37p3_L0p74_m1__nf1_gboth_sdfull_pc/B.n352 240
R128 pfet_01v8_lvt_W37p3_L0p74_m1__nf1_gboth_sdfull_pc/B.n537 pfet_01v8_lvt_W37p3_L0p74_m1__nf1_gboth_sdfull_pc/B.n352 240
R129 pfet_01v8_lvt_W37p3_L0p74_m1__nf1_gboth_sdfull_pc/B.n539 pfet_01v8_lvt_W37p3_L0p74_m1__nf1_gboth_sdfull_pc/B.n296 240
R130 pfet_01v8_lvt_W37p3_L0p74_m1__nf1_gboth_sdfull_pc/B.n542 pfet_01v8_lvt_W37p3_L0p74_m1__nf1_gboth_sdfull_pc/B.n296 240
R131 pfet_01v8_lvt_W37p3_L0p74_m1__nf1_gboth_sdfull_pc/B.n544 pfet_01v8_lvt_W37p3_L0p74_m1__nf1_gboth_sdfull_pc/B.n354 240
R132 pfet_01v8_lvt_W37p3_L0p74_m1__nf1_gboth_sdfull_pc/B.n547 pfet_01v8_lvt_W37p3_L0p74_m1__nf1_gboth_sdfull_pc/B.n354 240
R133 pfet_01v8_lvt_W37p3_L0p74_m1__nf1_gboth_sdfull_pc/B.n549 pfet_01v8_lvt_W37p3_L0p74_m1__nf1_gboth_sdfull_pc/B.n294 240
R134 pfet_01v8_lvt_W37p3_L0p74_m1__nf1_gboth_sdfull_pc/B.n552 pfet_01v8_lvt_W37p3_L0p74_m1__nf1_gboth_sdfull_pc/B.n294 240
R135 pfet_01v8_lvt_W37p3_L0p74_m1__nf1_gboth_sdfull_pc/B.n556 pfet_01v8_lvt_W37p3_L0p74_m1__nf1_gboth_sdfull_pc/B.n357 240
R136 pfet_01v8_lvt_W37p3_L0p74_m1__nf1_gboth_sdfull_pc/B.n556 pfet_01v8_lvt_W37p3_L0p74_m1__nf1_gboth_sdfull_pc/B.n356 240
R137 pfet_01v8_lvt_W37p3_L0p74_m1__nf1_gboth_sdfull_pc/B.n362 pfet_01v8_lvt_W37p3_L0p74_m1__nf1_gboth_sdfull_pc/B.n361 240
R138 pfet_01v8_lvt_W37p3_L0p74_m1__nf1_gboth_sdfull_pc/B.n358 pfet_01v8_lvt_W37p3_L0p74_m1__nf1_gboth_sdfull_pc/B.n291 240
R139 pfet_01v8_lvt_W37p3_L0p74_m1__nf1_gboth_sdfull_pc/B.n563 pfet_01v8_lvt_W37p3_L0p74_m1__nf1_gboth_sdfull_pc/B.n6 240
R140 pfet_01v8_lvt_W37p3_L0p74_m1__nf1_gboth_sdfull_pc/B.n563 pfet_01v8_lvt_W37p3_L0p74_m1__nf1_gboth_sdfull_pc/B.n5 240
R141 pfet_01v8_lvt_W37p3_L0p74_m1__nf1_gboth_sdfull_pc/B.n287 pfet_01v8_lvt_W37p3_L0p74_m1__nf1_gboth_sdfull_pc/B.n5 240
R142 pfet_01v8_lvt_W37p3_L0p74_m1__nf1_gboth_sdfull_pc/B.n286 pfet_01v8_lvt_W37p3_L0p74_m1__nf1_gboth_sdfull_pc/B.n284 185
R143 pfet_01v8_lvt_W37p3_L0p74_m1__nf1_gboth_sdfull_pc/B.n284 pfet_01v8_lvt_W37p3_L0p74_m1__nf1_gboth_sdfull_pc/B.n283 185
R144 pfet_01v8_lvt_W37p3_L0p74_m1__nf1_gboth_sdfull_pc/B.n285 pfet_01v8_lvt_W37p3_L0p74_m1__nf1_gboth_sdfull_pc/B.n2 185
R145 pfet_01v8_lvt_W37p3_L0p74_m1__nf1_gboth_sdfull_pc/B.n2 pfet_01v8_lvt_W37p3_L0p74_m1__nf1_gboth_sdfull_pc/B.n0 185
R146 pfet_01v8_lvt_W37p3_L0p74_m1__nf1_gboth_sdfull_pc/B.n565 pfet_01v8_lvt_W37p3_L0p74_m1__nf1_gboth_sdfull_pc/B.n564 185
R147 pfet_01v8_lvt_W37p3_L0p74_m1__nf1_gboth_sdfull_pc/B.n566 pfet_01v8_lvt_W37p3_L0p74_m1__nf1_gboth_sdfull_pc/B.n565 185
R148 pfet_01v8_lvt_W37p3_L0p74_m1__nf1_gboth_sdfull_pc/B.n4 pfet_01v8_lvt_W37p3_L0p74_m1__nf1_gboth_sdfull_pc/B.n3 185
R149 pfet_01v8_lvt_W37p3_L0p74_m1__nf1_gboth_sdfull_pc/B.n3 pfet_01v8_lvt_W37p3_L0p74_m1__nf1_gboth_sdfull_pc/B.n1 185
R150 pfet_01v8_lvt_W37p3_L0p74_m1__nf1_gboth_sdfull_pc/B.n557 pfet_01v8_lvt_W37p3_L0p74_m1__nf1_gboth_sdfull_pc/B.n326 185
R151 pfet_01v8_lvt_W37p3_L0p74_m1__nf1_gboth_sdfull_pc/B.n365 pfet_01v8_lvt_W37p3_L0p74_m1__nf1_gboth_sdfull_pc/B.n326 185
R152 pfet_01v8_lvt_W37p3_L0p74_m1__nf1_gboth_sdfull_pc/B.n367 pfet_01v8_lvt_W37p3_L0p74_m1__nf1_gboth_sdfull_pc/B.n366 185
R153 pfet_01v8_lvt_W37p3_L0p74_m1__nf1_gboth_sdfull_pc/B.n369 pfet_01v8_lvt_W37p3_L0p74_m1__nf1_gboth_sdfull_pc/B.n368 185
R154 pfet_01v8_lvt_W37p3_L0p74_m1__nf1_gboth_sdfull_pc/B.n371 pfet_01v8_lvt_W37p3_L0p74_m1__nf1_gboth_sdfull_pc/B.n370 185
R155 pfet_01v8_lvt_W37p3_L0p74_m1__nf1_gboth_sdfull_pc/B.n373 pfet_01v8_lvt_W37p3_L0p74_m1__nf1_gboth_sdfull_pc/B.n372 185
R156 pfet_01v8_lvt_W37p3_L0p74_m1__nf1_gboth_sdfull_pc/B.n557 pfet_01v8_lvt_W37p3_L0p74_m1__nf1_gboth_sdfull_pc/B.n329 185
R157 pfet_01v8_lvt_W37p3_L0p74_m1__nf1_gboth_sdfull_pc/B.n374 pfet_01v8_lvt_W37p3_L0p74_m1__nf1_gboth_sdfull_pc/B.n329 185
R158 pfet_01v8_lvt_W37p3_L0p74_m1__nf1_gboth_sdfull_pc/B.n376 pfet_01v8_lvt_W37p3_L0p74_m1__nf1_gboth_sdfull_pc/B.n375 185
R159 pfet_01v8_lvt_W37p3_L0p74_m1__nf1_gboth_sdfull_pc/B.n378 pfet_01v8_lvt_W37p3_L0p74_m1__nf1_gboth_sdfull_pc/B.n377 185
R160 pfet_01v8_lvt_W37p3_L0p74_m1__nf1_gboth_sdfull_pc/B.n380 pfet_01v8_lvt_W37p3_L0p74_m1__nf1_gboth_sdfull_pc/B.n379 185
R161 pfet_01v8_lvt_W37p3_L0p74_m1__nf1_gboth_sdfull_pc/B.n382 pfet_01v8_lvt_W37p3_L0p74_m1__nf1_gboth_sdfull_pc/B.n381 185
R162 pfet_01v8_lvt_W37p3_L0p74_m1__nf1_gboth_sdfull_pc/B.n384 pfet_01v8_lvt_W37p3_L0p74_m1__nf1_gboth_sdfull_pc/B.n383 185
R163 pfet_01v8_lvt_W37p3_L0p74_m1__nf1_gboth_sdfull_pc/B.n386 pfet_01v8_lvt_W37p3_L0p74_m1__nf1_gboth_sdfull_pc/B.n385 185
R164 pfet_01v8_lvt_W37p3_L0p74_m1__nf1_gboth_sdfull_pc/B.n388 pfet_01v8_lvt_W37p3_L0p74_m1__nf1_gboth_sdfull_pc/B.n387 185
R165 pfet_01v8_lvt_W37p3_L0p74_m1__nf1_gboth_sdfull_pc/B.n390 pfet_01v8_lvt_W37p3_L0p74_m1__nf1_gboth_sdfull_pc/B.n389 185
R166 pfet_01v8_lvt_W37p3_L0p74_m1__nf1_gboth_sdfull_pc/B.n392 pfet_01v8_lvt_W37p3_L0p74_m1__nf1_gboth_sdfull_pc/B.n391 185
R167 pfet_01v8_lvt_W37p3_L0p74_m1__nf1_gboth_sdfull_pc/B.n394 pfet_01v8_lvt_W37p3_L0p74_m1__nf1_gboth_sdfull_pc/B.n393 185
R168 pfet_01v8_lvt_W37p3_L0p74_m1__nf1_gboth_sdfull_pc/B.n396 pfet_01v8_lvt_W37p3_L0p74_m1__nf1_gboth_sdfull_pc/B.n395 185
R169 pfet_01v8_lvt_W37p3_L0p74_m1__nf1_gboth_sdfull_pc/B.n398 pfet_01v8_lvt_W37p3_L0p74_m1__nf1_gboth_sdfull_pc/B.n397 185
R170 pfet_01v8_lvt_W37p3_L0p74_m1__nf1_gboth_sdfull_pc/B.n557 pfet_01v8_lvt_W37p3_L0p74_m1__nf1_gboth_sdfull_pc/B.n320 185
R171 pfet_01v8_lvt_W37p3_L0p74_m1__nf1_gboth_sdfull_pc/B.n399 pfet_01v8_lvt_W37p3_L0p74_m1__nf1_gboth_sdfull_pc/B.n320 185
R172 pfet_01v8_lvt_W37p3_L0p74_m1__nf1_gboth_sdfull_pc/B.n401 pfet_01v8_lvt_W37p3_L0p74_m1__nf1_gboth_sdfull_pc/B.n400 185
R173 pfet_01v8_lvt_W37p3_L0p74_m1__nf1_gboth_sdfull_pc/B.n403 pfet_01v8_lvt_W37p3_L0p74_m1__nf1_gboth_sdfull_pc/B.n402 185
R174 pfet_01v8_lvt_W37p3_L0p74_m1__nf1_gboth_sdfull_pc/B.n557 pfet_01v8_lvt_W37p3_L0p74_m1__nf1_gboth_sdfull_pc/B.n332 185
R175 pfet_01v8_lvt_W37p3_L0p74_m1__nf1_gboth_sdfull_pc/B.n404 pfet_01v8_lvt_W37p3_L0p74_m1__nf1_gboth_sdfull_pc/B.n332 185
R176 pfet_01v8_lvt_W37p3_L0p74_m1__nf1_gboth_sdfull_pc/B.n406 pfet_01v8_lvt_W37p3_L0p74_m1__nf1_gboth_sdfull_pc/B.n405 185
R177 pfet_01v8_lvt_W37p3_L0p74_m1__nf1_gboth_sdfull_pc/B.n408 pfet_01v8_lvt_W37p3_L0p74_m1__nf1_gboth_sdfull_pc/B.n407 185
R178 pfet_01v8_lvt_W37p3_L0p74_m1__nf1_gboth_sdfull_pc/B.n410 pfet_01v8_lvt_W37p3_L0p74_m1__nf1_gboth_sdfull_pc/B.n409 185
R179 pfet_01v8_lvt_W37p3_L0p74_m1__nf1_gboth_sdfull_pc/B.n412 pfet_01v8_lvt_W37p3_L0p74_m1__nf1_gboth_sdfull_pc/B.n411 185
R180 pfet_01v8_lvt_W37p3_L0p74_m1__nf1_gboth_sdfull_pc/B.n414 pfet_01v8_lvt_W37p3_L0p74_m1__nf1_gboth_sdfull_pc/B.n413 185
R181 pfet_01v8_lvt_W37p3_L0p74_m1__nf1_gboth_sdfull_pc/B.n416 pfet_01v8_lvt_W37p3_L0p74_m1__nf1_gboth_sdfull_pc/B.n415 185
R182 pfet_01v8_lvt_W37p3_L0p74_m1__nf1_gboth_sdfull_pc/B.n557 pfet_01v8_lvt_W37p3_L0p74_m1__nf1_gboth_sdfull_pc/B.n317 185
R183 pfet_01v8_lvt_W37p3_L0p74_m1__nf1_gboth_sdfull_pc/B.n417 pfet_01v8_lvt_W37p3_L0p74_m1__nf1_gboth_sdfull_pc/B.n317 185
R184 pfet_01v8_lvt_W37p3_L0p74_m1__nf1_gboth_sdfull_pc/B.n419 pfet_01v8_lvt_W37p3_L0p74_m1__nf1_gboth_sdfull_pc/B.n418 185
R185 pfet_01v8_lvt_W37p3_L0p74_m1__nf1_gboth_sdfull_pc/B.n421 pfet_01v8_lvt_W37p3_L0p74_m1__nf1_gboth_sdfull_pc/B.n420 185
R186 pfet_01v8_lvt_W37p3_L0p74_m1__nf1_gboth_sdfull_pc/B.n557 pfet_01v8_lvt_W37p3_L0p74_m1__nf1_gboth_sdfull_pc/B.n335 185
R187 pfet_01v8_lvt_W37p3_L0p74_m1__nf1_gboth_sdfull_pc/B.n422 pfet_01v8_lvt_W37p3_L0p74_m1__nf1_gboth_sdfull_pc/B.n335 185
R188 pfet_01v8_lvt_W37p3_L0p74_m1__nf1_gboth_sdfull_pc/B.n424 pfet_01v8_lvt_W37p3_L0p74_m1__nf1_gboth_sdfull_pc/B.n423 185
R189 pfet_01v8_lvt_W37p3_L0p74_m1__nf1_gboth_sdfull_pc/B.n426 pfet_01v8_lvt_W37p3_L0p74_m1__nf1_gboth_sdfull_pc/B.n425 185
R190 pfet_01v8_lvt_W37p3_L0p74_m1__nf1_gboth_sdfull_pc/B.n557 pfet_01v8_lvt_W37p3_L0p74_m1__nf1_gboth_sdfull_pc/B.n315 185
R191 pfet_01v8_lvt_W37p3_L0p74_m1__nf1_gboth_sdfull_pc/B.n427 pfet_01v8_lvt_W37p3_L0p74_m1__nf1_gboth_sdfull_pc/B.n315 185
R192 pfet_01v8_lvt_W37p3_L0p74_m1__nf1_gboth_sdfull_pc/B.n429 pfet_01v8_lvt_W37p3_L0p74_m1__nf1_gboth_sdfull_pc/B.n428 185
R193 pfet_01v8_lvt_W37p3_L0p74_m1__nf1_gboth_sdfull_pc/B.n431 pfet_01v8_lvt_W37p3_L0p74_m1__nf1_gboth_sdfull_pc/B.n430 185
R194 pfet_01v8_lvt_W37p3_L0p74_m1__nf1_gboth_sdfull_pc/B.n433 pfet_01v8_lvt_W37p3_L0p74_m1__nf1_gboth_sdfull_pc/B.n432 185
R195 pfet_01v8_lvt_W37p3_L0p74_m1__nf1_gboth_sdfull_pc/B.n435 pfet_01v8_lvt_W37p3_L0p74_m1__nf1_gboth_sdfull_pc/B.n434 185
R196 pfet_01v8_lvt_W37p3_L0p74_m1__nf1_gboth_sdfull_pc/B.n557 pfet_01v8_lvt_W37p3_L0p74_m1__nf1_gboth_sdfull_pc/B.n337 185
R197 pfet_01v8_lvt_W37p3_L0p74_m1__nf1_gboth_sdfull_pc/B.n436 pfet_01v8_lvt_W37p3_L0p74_m1__nf1_gboth_sdfull_pc/B.n337 185
R198 pfet_01v8_lvt_W37p3_L0p74_m1__nf1_gboth_sdfull_pc/B.n438 pfet_01v8_lvt_W37p3_L0p74_m1__nf1_gboth_sdfull_pc/B.n437 185
R199 pfet_01v8_lvt_W37p3_L0p74_m1__nf1_gboth_sdfull_pc/B.n440 pfet_01v8_lvt_W37p3_L0p74_m1__nf1_gboth_sdfull_pc/B.n439 185
R200 pfet_01v8_lvt_W37p3_L0p74_m1__nf1_gboth_sdfull_pc/B.n557 pfet_01v8_lvt_W37p3_L0p74_m1__nf1_gboth_sdfull_pc/B.n312 185
R201 pfet_01v8_lvt_W37p3_L0p74_m1__nf1_gboth_sdfull_pc/B.n441 pfet_01v8_lvt_W37p3_L0p74_m1__nf1_gboth_sdfull_pc/B.n312 185
R202 pfet_01v8_lvt_W37p3_L0p74_m1__nf1_gboth_sdfull_pc/B.n443 pfet_01v8_lvt_W37p3_L0p74_m1__nf1_gboth_sdfull_pc/B.n442 185
R203 pfet_01v8_lvt_W37p3_L0p74_m1__nf1_gboth_sdfull_pc/B.n445 pfet_01v8_lvt_W37p3_L0p74_m1__nf1_gboth_sdfull_pc/B.n444 185
R204 pfet_01v8_lvt_W37p3_L0p74_m1__nf1_gboth_sdfull_pc/B.n447 pfet_01v8_lvt_W37p3_L0p74_m1__nf1_gboth_sdfull_pc/B.n446 185
R205 pfet_01v8_lvt_W37p3_L0p74_m1__nf1_gboth_sdfull_pc/B.n449 pfet_01v8_lvt_W37p3_L0p74_m1__nf1_gboth_sdfull_pc/B.n448 185
R206 pfet_01v8_lvt_W37p3_L0p74_m1__nf1_gboth_sdfull_pc/B.n557 pfet_01v8_lvt_W37p3_L0p74_m1__nf1_gboth_sdfull_pc/B.n340 185
R207 pfet_01v8_lvt_W37p3_L0p74_m1__nf1_gboth_sdfull_pc/B.n450 pfet_01v8_lvt_W37p3_L0p74_m1__nf1_gboth_sdfull_pc/B.n340 185
R208 pfet_01v8_lvt_W37p3_L0p74_m1__nf1_gboth_sdfull_pc/B.n452 pfet_01v8_lvt_W37p3_L0p74_m1__nf1_gboth_sdfull_pc/B.n451 185
R209 pfet_01v8_lvt_W37p3_L0p74_m1__nf1_gboth_sdfull_pc/B.n454 pfet_01v8_lvt_W37p3_L0p74_m1__nf1_gboth_sdfull_pc/B.n453 185
R210 pfet_01v8_lvt_W37p3_L0p74_m1__nf1_gboth_sdfull_pc/B.n456 pfet_01v8_lvt_W37p3_L0p74_m1__nf1_gboth_sdfull_pc/B.n455 185
R211 pfet_01v8_lvt_W37p3_L0p74_m1__nf1_gboth_sdfull_pc/B.n458 pfet_01v8_lvt_W37p3_L0p74_m1__nf1_gboth_sdfull_pc/B.n457 185
R212 pfet_01v8_lvt_W37p3_L0p74_m1__nf1_gboth_sdfull_pc/B.n460 pfet_01v8_lvt_W37p3_L0p74_m1__nf1_gboth_sdfull_pc/B.n459 185
R213 pfet_01v8_lvt_W37p3_L0p74_m1__nf1_gboth_sdfull_pc/B.n462 pfet_01v8_lvt_W37p3_L0p74_m1__nf1_gboth_sdfull_pc/B.n461 185
R214 pfet_01v8_lvt_W37p3_L0p74_m1__nf1_gboth_sdfull_pc/B.n464 pfet_01v8_lvt_W37p3_L0p74_m1__nf1_gboth_sdfull_pc/B.n463 185
R215 pfet_01v8_lvt_W37p3_L0p74_m1__nf1_gboth_sdfull_pc/B.n466 pfet_01v8_lvt_W37p3_L0p74_m1__nf1_gboth_sdfull_pc/B.n465 185
R216 pfet_01v8_lvt_W37p3_L0p74_m1__nf1_gboth_sdfull_pc/B.n557 pfet_01v8_lvt_W37p3_L0p74_m1__nf1_gboth_sdfull_pc/B.n307 185
R217 pfet_01v8_lvt_W37p3_L0p74_m1__nf1_gboth_sdfull_pc/B.n467 pfet_01v8_lvt_W37p3_L0p74_m1__nf1_gboth_sdfull_pc/B.n307 185
R218 pfet_01v8_lvt_W37p3_L0p74_m1__nf1_gboth_sdfull_pc/B.n469 pfet_01v8_lvt_W37p3_L0p74_m1__nf1_gboth_sdfull_pc/B.n468 185
R219 pfet_01v8_lvt_W37p3_L0p74_m1__nf1_gboth_sdfull_pc/B.n471 pfet_01v8_lvt_W37p3_L0p74_m1__nf1_gboth_sdfull_pc/B.n470 185
R220 pfet_01v8_lvt_W37p3_L0p74_m1__nf1_gboth_sdfull_pc/B.n473 pfet_01v8_lvt_W37p3_L0p74_m1__nf1_gboth_sdfull_pc/B.n472 185
R221 pfet_01v8_lvt_W37p3_L0p74_m1__nf1_gboth_sdfull_pc/B.n475 pfet_01v8_lvt_W37p3_L0p74_m1__nf1_gboth_sdfull_pc/B.n474 185
R222 pfet_01v8_lvt_W37p3_L0p74_m1__nf1_gboth_sdfull_pc/B.n557 pfet_01v8_lvt_W37p3_L0p74_m1__nf1_gboth_sdfull_pc/B.n342 185
R223 pfet_01v8_lvt_W37p3_L0p74_m1__nf1_gboth_sdfull_pc/B.n476 pfet_01v8_lvt_W37p3_L0p74_m1__nf1_gboth_sdfull_pc/B.n342 185
R224 pfet_01v8_lvt_W37p3_L0p74_m1__nf1_gboth_sdfull_pc/B.n478 pfet_01v8_lvt_W37p3_L0p74_m1__nf1_gboth_sdfull_pc/B.n477 185
R225 pfet_01v8_lvt_W37p3_L0p74_m1__nf1_gboth_sdfull_pc/B.n480 pfet_01v8_lvt_W37p3_L0p74_m1__nf1_gboth_sdfull_pc/B.n479 185
R226 pfet_01v8_lvt_W37p3_L0p74_m1__nf1_gboth_sdfull_pc/B.n482 pfet_01v8_lvt_W37p3_L0p74_m1__nf1_gboth_sdfull_pc/B.n481 185
R227 pfet_01v8_lvt_W37p3_L0p74_m1__nf1_gboth_sdfull_pc/B.n484 pfet_01v8_lvt_W37p3_L0p74_m1__nf1_gboth_sdfull_pc/B.n483 185
R228 pfet_01v8_lvt_W37p3_L0p74_m1__nf1_gboth_sdfull_pc/B.n486 pfet_01v8_lvt_W37p3_L0p74_m1__nf1_gboth_sdfull_pc/B.n485 185
R229 pfet_01v8_lvt_W37p3_L0p74_m1__nf1_gboth_sdfull_pc/B.n488 pfet_01v8_lvt_W37p3_L0p74_m1__nf1_gboth_sdfull_pc/B.n487 185
R230 pfet_01v8_lvt_W37p3_L0p74_m1__nf1_gboth_sdfull_pc/B.n490 pfet_01v8_lvt_W37p3_L0p74_m1__nf1_gboth_sdfull_pc/B.n489 185
R231 pfet_01v8_lvt_W37p3_L0p74_m1__nf1_gboth_sdfull_pc/B.n492 pfet_01v8_lvt_W37p3_L0p74_m1__nf1_gboth_sdfull_pc/B.n491 185
R232 pfet_01v8_lvt_W37p3_L0p74_m1__nf1_gboth_sdfull_pc/B.n494 pfet_01v8_lvt_W37p3_L0p74_m1__nf1_gboth_sdfull_pc/B.n493 185
R233 pfet_01v8_lvt_W37p3_L0p74_m1__nf1_gboth_sdfull_pc/B.n496 pfet_01v8_lvt_W37p3_L0p74_m1__nf1_gboth_sdfull_pc/B.n495 185
R234 pfet_01v8_lvt_W37p3_L0p74_m1__nf1_gboth_sdfull_pc/B.n498 pfet_01v8_lvt_W37p3_L0p74_m1__nf1_gboth_sdfull_pc/B.n497 185
R235 pfet_01v8_lvt_W37p3_L0p74_m1__nf1_gboth_sdfull_pc/B.n500 pfet_01v8_lvt_W37p3_L0p74_m1__nf1_gboth_sdfull_pc/B.n499 185
R236 pfet_01v8_lvt_W37p3_L0p74_m1__nf1_gboth_sdfull_pc/B.n557 pfet_01v8_lvt_W37p3_L0p74_m1__nf1_gboth_sdfull_pc/B.n301 185
R237 pfet_01v8_lvt_W37p3_L0p74_m1__nf1_gboth_sdfull_pc/B.n501 pfet_01v8_lvt_W37p3_L0p74_m1__nf1_gboth_sdfull_pc/B.n301 185
R238 pfet_01v8_lvt_W37p3_L0p74_m1__nf1_gboth_sdfull_pc/B.n503 pfet_01v8_lvt_W37p3_L0p74_m1__nf1_gboth_sdfull_pc/B.n502 185
R239 pfet_01v8_lvt_W37p3_L0p74_m1__nf1_gboth_sdfull_pc/B.n505 pfet_01v8_lvt_W37p3_L0p74_m1__nf1_gboth_sdfull_pc/B.n504 185
R240 pfet_01v8_lvt_W37p3_L0p74_m1__nf1_gboth_sdfull_pc/B.n507 pfet_01v8_lvt_W37p3_L0p74_m1__nf1_gboth_sdfull_pc/B.n506 185
R241 pfet_01v8_lvt_W37p3_L0p74_m1__nf1_gboth_sdfull_pc/B.n509 pfet_01v8_lvt_W37p3_L0p74_m1__nf1_gboth_sdfull_pc/B.n508 185
R242 pfet_01v8_lvt_W37p3_L0p74_m1__nf1_gboth_sdfull_pc/B.n557 pfet_01v8_lvt_W37p3_L0p74_m1__nf1_gboth_sdfull_pc/B.n347 185
R243 pfet_01v8_lvt_W37p3_L0p74_m1__nf1_gboth_sdfull_pc/B.n510 pfet_01v8_lvt_W37p3_L0p74_m1__nf1_gboth_sdfull_pc/B.n347 185
R244 pfet_01v8_lvt_W37p3_L0p74_m1__nf1_gboth_sdfull_pc/B.n512 pfet_01v8_lvt_W37p3_L0p74_m1__nf1_gboth_sdfull_pc/B.n511 185
R245 pfet_01v8_lvt_W37p3_L0p74_m1__nf1_gboth_sdfull_pc/B.n514 pfet_01v8_lvt_W37p3_L0p74_m1__nf1_gboth_sdfull_pc/B.n513 185
R246 pfet_01v8_lvt_W37p3_L0p74_m1__nf1_gboth_sdfull_pc/B.n557 pfet_01v8_lvt_W37p3_L0p74_m1__nf1_gboth_sdfull_pc/B.n299 185
R247 pfet_01v8_lvt_W37p3_L0p74_m1__nf1_gboth_sdfull_pc/B.n515 pfet_01v8_lvt_W37p3_L0p74_m1__nf1_gboth_sdfull_pc/B.n299 185
R248 pfet_01v8_lvt_W37p3_L0p74_m1__nf1_gboth_sdfull_pc/B.n517 pfet_01v8_lvt_W37p3_L0p74_m1__nf1_gboth_sdfull_pc/B.n516 185
R249 pfet_01v8_lvt_W37p3_L0p74_m1__nf1_gboth_sdfull_pc/B.n519 pfet_01v8_lvt_W37p3_L0p74_m1__nf1_gboth_sdfull_pc/B.n518 185
R250 pfet_01v8_lvt_W37p3_L0p74_m1__nf1_gboth_sdfull_pc/B.n521 pfet_01v8_lvt_W37p3_L0p74_m1__nf1_gboth_sdfull_pc/B.n520 185
R251 pfet_01v8_lvt_W37p3_L0p74_m1__nf1_gboth_sdfull_pc/B.n523 pfet_01v8_lvt_W37p3_L0p74_m1__nf1_gboth_sdfull_pc/B.n522 185
R252 pfet_01v8_lvt_W37p3_L0p74_m1__nf1_gboth_sdfull_pc/B.n525 pfet_01v8_lvt_W37p3_L0p74_m1__nf1_gboth_sdfull_pc/B.n524 185
R253 pfet_01v8_lvt_W37p3_L0p74_m1__nf1_gboth_sdfull_pc/B.n527 pfet_01v8_lvt_W37p3_L0p74_m1__nf1_gboth_sdfull_pc/B.n526 185
R254 pfet_01v8_lvt_W37p3_L0p74_m1__nf1_gboth_sdfull_pc/B.n529 pfet_01v8_lvt_W37p3_L0p74_m1__nf1_gboth_sdfull_pc/B.n528 185
R255 pfet_01v8_lvt_W37p3_L0p74_m1__nf1_gboth_sdfull_pc/B.n531 pfet_01v8_lvt_W37p3_L0p74_m1__nf1_gboth_sdfull_pc/B.n530 185
R256 pfet_01v8_lvt_W37p3_L0p74_m1__nf1_gboth_sdfull_pc/B.n533 pfet_01v8_lvt_W37p3_L0p74_m1__nf1_gboth_sdfull_pc/B.n532 185
R257 pfet_01v8_lvt_W37p3_L0p74_m1__nf1_gboth_sdfull_pc/B.n535 pfet_01v8_lvt_W37p3_L0p74_m1__nf1_gboth_sdfull_pc/B.n534 185
R258 pfet_01v8_lvt_W37p3_L0p74_m1__nf1_gboth_sdfull_pc/B.n557 pfet_01v8_lvt_W37p3_L0p74_m1__nf1_gboth_sdfull_pc/B.n352 185
R259 pfet_01v8_lvt_W37p3_L0p74_m1__nf1_gboth_sdfull_pc/B.n536 pfet_01v8_lvt_W37p3_L0p74_m1__nf1_gboth_sdfull_pc/B.n352 185
R260 pfet_01v8_lvt_W37p3_L0p74_m1__nf1_gboth_sdfull_pc/B.n538 pfet_01v8_lvt_W37p3_L0p74_m1__nf1_gboth_sdfull_pc/B.n537 185
R261 pfet_01v8_lvt_W37p3_L0p74_m1__nf1_gboth_sdfull_pc/B.n540 pfet_01v8_lvt_W37p3_L0p74_m1__nf1_gboth_sdfull_pc/B.n539 185
R262 pfet_01v8_lvt_W37p3_L0p74_m1__nf1_gboth_sdfull_pc/B.n557 pfet_01v8_lvt_W37p3_L0p74_m1__nf1_gboth_sdfull_pc/B.n296 185
R263 pfet_01v8_lvt_W37p3_L0p74_m1__nf1_gboth_sdfull_pc/B.n541 pfet_01v8_lvt_W37p3_L0p74_m1__nf1_gboth_sdfull_pc/B.n296 185
R264 pfet_01v8_lvt_W37p3_L0p74_m1__nf1_gboth_sdfull_pc/B.n543 pfet_01v8_lvt_W37p3_L0p74_m1__nf1_gboth_sdfull_pc/B.n542 185
R265 pfet_01v8_lvt_W37p3_L0p74_m1__nf1_gboth_sdfull_pc/B.n545 pfet_01v8_lvt_W37p3_L0p74_m1__nf1_gboth_sdfull_pc/B.n544 185
R266 pfet_01v8_lvt_W37p3_L0p74_m1__nf1_gboth_sdfull_pc/B.n557 pfet_01v8_lvt_W37p3_L0p74_m1__nf1_gboth_sdfull_pc/B.n354 185
R267 pfet_01v8_lvt_W37p3_L0p74_m1__nf1_gboth_sdfull_pc/B.n546 pfet_01v8_lvt_W37p3_L0p74_m1__nf1_gboth_sdfull_pc/B.n354 185
R268 pfet_01v8_lvt_W37p3_L0p74_m1__nf1_gboth_sdfull_pc/B.n548 pfet_01v8_lvt_W37p3_L0p74_m1__nf1_gboth_sdfull_pc/B.n547 185
R269 pfet_01v8_lvt_W37p3_L0p74_m1__nf1_gboth_sdfull_pc/B.n550 pfet_01v8_lvt_W37p3_L0p74_m1__nf1_gboth_sdfull_pc/B.n549 185
R270 pfet_01v8_lvt_W37p3_L0p74_m1__nf1_gboth_sdfull_pc/B.n557 pfet_01v8_lvt_W37p3_L0p74_m1__nf1_gboth_sdfull_pc/B.n294 185
R271 pfet_01v8_lvt_W37p3_L0p74_m1__nf1_gboth_sdfull_pc/B.n551 pfet_01v8_lvt_W37p3_L0p74_m1__nf1_gboth_sdfull_pc/B.n294 185
R272 pfet_01v8_lvt_W37p3_L0p74_m1__nf1_gboth_sdfull_pc/B.n553 pfet_01v8_lvt_W37p3_L0p74_m1__nf1_gboth_sdfull_pc/B.n552 185
R273 pfet_01v8_lvt_W37p3_L0p74_m1__nf1_gboth_sdfull_pc/B.n554 pfet_01v8_lvt_W37p3_L0p74_m1__nf1_gboth_sdfull_pc/B.n357 185
R274 pfet_01v8_lvt_W37p3_L0p74_m1__nf1_gboth_sdfull_pc/B.n557 pfet_01v8_lvt_W37p3_L0p74_m1__nf1_gboth_sdfull_pc/B.n556 185
R275 pfet_01v8_lvt_W37p3_L0p74_m1__nf1_gboth_sdfull_pc/B.n556 pfet_01v8_lvt_W37p3_L0p74_m1__nf1_gboth_sdfull_pc/B.n555 185
R276 pfet_01v8_lvt_W37p3_L0p74_m1__nf1_gboth_sdfull_pc/B.n364 pfet_01v8_lvt_W37p3_L0p74_m1__nf1_gboth_sdfull_pc/B.n356 185
R277 pfet_01v8_lvt_W37p3_L0p74_m1__nf1_gboth_sdfull_pc/B.n363 pfet_01v8_lvt_W37p3_L0p74_m1__nf1_gboth_sdfull_pc/B.n362 185
R278 pfet_01v8_lvt_W37p3_L0p74_m1__nf1_gboth_sdfull_pc/B.n361 pfet_01v8_lvt_W37p3_L0p74_m1__nf1_gboth_sdfull_pc/B.n360 185
R279 pfet_01v8_lvt_W37p3_L0p74_m1__nf1_gboth_sdfull_pc/B.n359 pfet_01v8_lvt_W37p3_L0p74_m1__nf1_gboth_sdfull_pc/B.n358 185
R280 pfet_01v8_lvt_W37p3_L0p74_m1__nf1_gboth_sdfull_pc/B.n291 pfet_01v8_lvt_W37p3_L0p74_m1__nf1_gboth_sdfull_pc/B.n290 185
R281 pfet_01v8_lvt_W37p3_L0p74_m1__nf1_gboth_sdfull_pc/B.n560 pfet_01v8_lvt_W37p3_L0p74_m1__nf1_gboth_sdfull_pc/B.n559 185
R282 pfet_01v8_lvt_W37p3_L0p74_m1__nf1_gboth_sdfull_pc/B.n6 pfet_01v8_lvt_W37p3_L0p74_m1__nf1_gboth_sdfull_pc/B.n4 185
R283 pfet_01v8_lvt_W37p3_L0p74_m1__nf1_gboth_sdfull_pc/B.n561 pfet_01v8_lvt_W37p3_L0p74_m1__nf1_gboth_sdfull_pc/B.n6 185
R284 pfet_01v8_lvt_W37p3_L0p74_m1__nf1_gboth_sdfull_pc/B.n564 pfet_01v8_lvt_W37p3_L0p74_m1__nf1_gboth_sdfull_pc/B.n563 185
R285 pfet_01v8_lvt_W37p3_L0p74_m1__nf1_gboth_sdfull_pc/B.n563 pfet_01v8_lvt_W37p3_L0p74_m1__nf1_gboth_sdfull_pc/B.n562 185
R286 pfet_01v8_lvt_W37p3_L0p74_m1__nf1_gboth_sdfull_pc/B.n285 pfet_01v8_lvt_W37p3_L0p74_m1__nf1_gboth_sdfull_pc/B.n5 185
R287 pfet_01v8_lvt_W37p3_L0p74_m1__nf1_gboth_sdfull_pc/B.n289 pfet_01v8_lvt_W37p3_L0p74_m1__nf1_gboth_sdfull_pc/B.n5 185
R288 pfet_01v8_lvt_W37p3_L0p74_m1__nf1_gboth_sdfull_pc/B.n287 pfet_01v8_lvt_W37p3_L0p74_m1__nf1_gboth_sdfull_pc/B.n286 185
R289 pfet_01v8_lvt_W37p3_L0p74_m1__nf1_gboth_sdfull_pc/B.n288 pfet_01v8_lvt_W37p3_L0p74_m1__nf1_gboth_sdfull_pc/B.n287 185
R290 pfet_01v8_lvt_W37p3_L0p74_m1__nf1_gboth_sdfull_pc/B.n8 pfet_01v8_lvt_W37p3_L0p74_m1__nf1_gboth_sdfull_pc/B.n7 185
R291 pfet_01v8_lvt_W37p3_L0p74_m1__nf1_gboth_sdfull_pc/B.n72 pfet_01v8_lvt_W37p3_L0p74_m1__nf1_gboth_sdfull_pc/B.n70 185
R292 pfet_01v8_lvt_W37p3_L0p74_m1__nf1_gboth_sdfull_pc/B.n75 pfet_01v8_lvt_W37p3_L0p74_m1__nf1_gboth_sdfull_pc/B.n74 185
R293 pfet_01v8_lvt_W37p3_L0p74_m1__nf1_gboth_sdfull_pc/B.n76 pfet_01v8_lvt_W37p3_L0p74_m1__nf1_gboth_sdfull_pc/B.n69 185
R294 pfet_01v8_lvt_W37p3_L0p74_m1__nf1_gboth_sdfull_pc/B.n78 pfet_01v8_lvt_W37p3_L0p74_m1__nf1_gboth_sdfull_pc/B.n77 185
R295 pfet_01v8_lvt_W37p3_L0p74_m1__nf1_gboth_sdfull_pc/B.n80 pfet_01v8_lvt_W37p3_L0p74_m1__nf1_gboth_sdfull_pc/B.n68 185
R296 pfet_01v8_lvt_W37p3_L0p74_m1__nf1_gboth_sdfull_pc/B.n82 pfet_01v8_lvt_W37p3_L0p74_m1__nf1_gboth_sdfull_pc/B.n81 185
R297 pfet_01v8_lvt_W37p3_L0p74_m1__nf1_gboth_sdfull_pc/B.n84 pfet_01v8_lvt_W37p3_L0p74_m1__nf1_gboth_sdfull_pc/B.n83 185
R298 pfet_01v8_lvt_W37p3_L0p74_m1__nf1_gboth_sdfull_pc/B.n85 pfet_01v8_lvt_W37p3_L0p74_m1__nf1_gboth_sdfull_pc/B.n66 185
R299 pfet_01v8_lvt_W37p3_L0p74_m1__nf1_gboth_sdfull_pc/B.n88 pfet_01v8_lvt_W37p3_L0p74_m1__nf1_gboth_sdfull_pc/B.n87 185
R300 pfet_01v8_lvt_W37p3_L0p74_m1__nf1_gboth_sdfull_pc/B.n65 pfet_01v8_lvt_W37p3_L0p74_m1__nf1_gboth_sdfull_pc/B.n9 185
R301 pfet_01v8_lvt_W37p3_L0p74_m1__nf1_gboth_sdfull_pc/B.n89 pfet_01v8_lvt_W37p3_L0p74_m1__nf1_gboth_sdfull_pc/B.n65 185
R302 pfet_01v8_lvt_W37p3_L0p74_m1__nf1_gboth_sdfull_pc/B.n91 pfet_01v8_lvt_W37p3_L0p74_m1__nf1_gboth_sdfull_pc/B.n90 185
R303 pfet_01v8_lvt_W37p3_L0p74_m1__nf1_gboth_sdfull_pc/B.n93 pfet_01v8_lvt_W37p3_L0p74_m1__nf1_gboth_sdfull_pc/B.n64 185
R304 pfet_01v8_lvt_W37p3_L0p74_m1__nf1_gboth_sdfull_pc/B.n96 pfet_01v8_lvt_W37p3_L0p74_m1__nf1_gboth_sdfull_pc/B.n95 185
R305 pfet_01v8_lvt_W37p3_L0p74_m1__nf1_gboth_sdfull_pc/B.n97 pfet_01v8_lvt_W37p3_L0p74_m1__nf1_gboth_sdfull_pc/B.n63 185
R306 pfet_01v8_lvt_W37p3_L0p74_m1__nf1_gboth_sdfull_pc/B.n99 pfet_01v8_lvt_W37p3_L0p74_m1__nf1_gboth_sdfull_pc/B.n98 185
R307 pfet_01v8_lvt_W37p3_L0p74_m1__nf1_gboth_sdfull_pc/B.n101 pfet_01v8_lvt_W37p3_L0p74_m1__nf1_gboth_sdfull_pc/B.n62 185
R308 pfet_01v8_lvt_W37p3_L0p74_m1__nf1_gboth_sdfull_pc/B.n104 pfet_01v8_lvt_W37p3_L0p74_m1__nf1_gboth_sdfull_pc/B.n103 185
R309 pfet_01v8_lvt_W37p3_L0p74_m1__nf1_gboth_sdfull_pc/B.n105 pfet_01v8_lvt_W37p3_L0p74_m1__nf1_gboth_sdfull_pc/B.n61 185
R310 pfet_01v8_lvt_W37p3_L0p74_m1__nf1_gboth_sdfull_pc/B.n107 pfet_01v8_lvt_W37p3_L0p74_m1__nf1_gboth_sdfull_pc/B.n106 185
R311 pfet_01v8_lvt_W37p3_L0p74_m1__nf1_gboth_sdfull_pc/B.n109 pfet_01v8_lvt_W37p3_L0p74_m1__nf1_gboth_sdfull_pc/B.n60 185
R312 pfet_01v8_lvt_W37p3_L0p74_m1__nf1_gboth_sdfull_pc/B.n111 pfet_01v8_lvt_W37p3_L0p74_m1__nf1_gboth_sdfull_pc/B.n110 185
R313 pfet_01v8_lvt_W37p3_L0p74_m1__nf1_gboth_sdfull_pc/B.n113 pfet_01v8_lvt_W37p3_L0p74_m1__nf1_gboth_sdfull_pc/B.n112 185
R314 pfet_01v8_lvt_W37p3_L0p74_m1__nf1_gboth_sdfull_pc/B.n114 pfet_01v8_lvt_W37p3_L0p74_m1__nf1_gboth_sdfull_pc/B.n58 185
R315 pfet_01v8_lvt_W37p3_L0p74_m1__nf1_gboth_sdfull_pc/B.n117 pfet_01v8_lvt_W37p3_L0p74_m1__nf1_gboth_sdfull_pc/B.n116 185
R316 pfet_01v8_lvt_W37p3_L0p74_m1__nf1_gboth_sdfull_pc/B.n57 pfet_01v8_lvt_W37p3_L0p74_m1__nf1_gboth_sdfull_pc/B.n9 185
R317 pfet_01v8_lvt_W37p3_L0p74_m1__nf1_gboth_sdfull_pc/B.n118 pfet_01v8_lvt_W37p3_L0p74_m1__nf1_gboth_sdfull_pc/B.n57 185
R318 pfet_01v8_lvt_W37p3_L0p74_m1__nf1_gboth_sdfull_pc/B.n120 pfet_01v8_lvt_W37p3_L0p74_m1__nf1_gboth_sdfull_pc/B.n119 185
R319 pfet_01v8_lvt_W37p3_L0p74_m1__nf1_gboth_sdfull_pc/B.n122 pfet_01v8_lvt_W37p3_L0p74_m1__nf1_gboth_sdfull_pc/B.n56 185
R320 pfet_01v8_lvt_W37p3_L0p74_m1__nf1_gboth_sdfull_pc/B.n124 pfet_01v8_lvt_W37p3_L0p74_m1__nf1_gboth_sdfull_pc/B.n123 185
R321 pfet_01v8_lvt_W37p3_L0p74_m1__nf1_gboth_sdfull_pc/B.n126 pfet_01v8_lvt_W37p3_L0p74_m1__nf1_gboth_sdfull_pc/B.n125 185
R322 pfet_01v8_lvt_W37p3_L0p74_m1__nf1_gboth_sdfull_pc/B.n127 pfet_01v8_lvt_W37p3_L0p74_m1__nf1_gboth_sdfull_pc/B.n9 185
R323 pfet_01v8_lvt_W37p3_L0p74_m1__nf1_gboth_sdfull_pc/B.n127 pfet_01v8_lvt_W37p3_L0p74_m1__nf1_gboth_sdfull_pc/B.n54 185
R324 pfet_01v8_lvt_W37p3_L0p74_m1__nf1_gboth_sdfull_pc/B.n130 pfet_01v8_lvt_W37p3_L0p74_m1__nf1_gboth_sdfull_pc/B.n129 185
R325 pfet_01v8_lvt_W37p3_L0p74_m1__nf1_gboth_sdfull_pc/B.n131 pfet_01v8_lvt_W37p3_L0p74_m1__nf1_gboth_sdfull_pc/B.n53 185
R326 pfet_01v8_lvt_W37p3_L0p74_m1__nf1_gboth_sdfull_pc/B.n133 pfet_01v8_lvt_W37p3_L0p74_m1__nf1_gboth_sdfull_pc/B.n132 185
R327 pfet_01v8_lvt_W37p3_L0p74_m1__nf1_gboth_sdfull_pc/B.n135 pfet_01v8_lvt_W37p3_L0p74_m1__nf1_gboth_sdfull_pc/B.n52 185
R328 pfet_01v8_lvt_W37p3_L0p74_m1__nf1_gboth_sdfull_pc/B.n136 pfet_01v8_lvt_W37p3_L0p74_m1__nf1_gboth_sdfull_pc/B.n51 185
R329 pfet_01v8_lvt_W37p3_L0p74_m1__nf1_gboth_sdfull_pc/B.n139 pfet_01v8_lvt_W37p3_L0p74_m1__nf1_gboth_sdfull_pc/B.n138 185
R330 pfet_01v8_lvt_W37p3_L0p74_m1__nf1_gboth_sdfull_pc/B.n50 pfet_01v8_lvt_W37p3_L0p74_m1__nf1_gboth_sdfull_pc/B.n9 185
R331 pfet_01v8_lvt_W37p3_L0p74_m1__nf1_gboth_sdfull_pc/B.n140 pfet_01v8_lvt_W37p3_L0p74_m1__nf1_gboth_sdfull_pc/B.n50 185
R332 pfet_01v8_lvt_W37p3_L0p74_m1__nf1_gboth_sdfull_pc/B.n142 pfet_01v8_lvt_W37p3_L0p74_m1__nf1_gboth_sdfull_pc/B.n141 185
R333 pfet_01v8_lvt_W37p3_L0p74_m1__nf1_gboth_sdfull_pc/B.n144 pfet_01v8_lvt_W37p3_L0p74_m1__nf1_gboth_sdfull_pc/B.n49 185
R334 pfet_01v8_lvt_W37p3_L0p74_m1__nf1_gboth_sdfull_pc/B.n146 pfet_01v8_lvt_W37p3_L0p74_m1__nf1_gboth_sdfull_pc/B.n145 185
R335 pfet_01v8_lvt_W37p3_L0p74_m1__nf1_gboth_sdfull_pc/B.n148 pfet_01v8_lvt_W37p3_L0p74_m1__nf1_gboth_sdfull_pc/B.n147 185
R336 pfet_01v8_lvt_W37p3_L0p74_m1__nf1_gboth_sdfull_pc/B.n149 pfet_01v8_lvt_W37p3_L0p74_m1__nf1_gboth_sdfull_pc/B.n47 185
R337 pfet_01v8_lvt_W37p3_L0p74_m1__nf1_gboth_sdfull_pc/B.n152 pfet_01v8_lvt_W37p3_L0p74_m1__nf1_gboth_sdfull_pc/B.n151 185
R338 pfet_01v8_lvt_W37p3_L0p74_m1__nf1_gboth_sdfull_pc/B.n46 pfet_01v8_lvt_W37p3_L0p74_m1__nf1_gboth_sdfull_pc/B.n9 185
R339 pfet_01v8_lvt_W37p3_L0p74_m1__nf1_gboth_sdfull_pc/B.n153 pfet_01v8_lvt_W37p3_L0p74_m1__nf1_gboth_sdfull_pc/B.n46 185
R340 pfet_01v8_lvt_W37p3_L0p74_m1__nf1_gboth_sdfull_pc/B.n155 pfet_01v8_lvt_W37p3_L0p74_m1__nf1_gboth_sdfull_pc/B.n154 185
R341 pfet_01v8_lvt_W37p3_L0p74_m1__nf1_gboth_sdfull_pc/B.n157 pfet_01v8_lvt_W37p3_L0p74_m1__nf1_gboth_sdfull_pc/B.n45 185
R342 pfet_01v8_lvt_W37p3_L0p74_m1__nf1_gboth_sdfull_pc/B.n160 pfet_01v8_lvt_W37p3_L0p74_m1__nf1_gboth_sdfull_pc/B.n159 185
R343 pfet_01v8_lvt_W37p3_L0p74_m1__nf1_gboth_sdfull_pc/B.n161 pfet_01v8_lvt_W37p3_L0p74_m1__nf1_gboth_sdfull_pc/B.n44 185
R344 pfet_01v8_lvt_W37p3_L0p74_m1__nf1_gboth_sdfull_pc/B.n163 pfet_01v8_lvt_W37p3_L0p74_m1__nf1_gboth_sdfull_pc/B.n162 185
R345 pfet_01v8_lvt_W37p3_L0p74_m1__nf1_gboth_sdfull_pc/B.n165 pfet_01v8_lvt_W37p3_L0p74_m1__nf1_gboth_sdfull_pc/B.n43 185
R346 pfet_01v8_lvt_W37p3_L0p74_m1__nf1_gboth_sdfull_pc/B.n168 pfet_01v8_lvt_W37p3_L0p74_m1__nf1_gboth_sdfull_pc/B.n167 185
R347 pfet_01v8_lvt_W37p3_L0p74_m1__nf1_gboth_sdfull_pc/B.n169 pfet_01v8_lvt_W37p3_L0p74_m1__nf1_gboth_sdfull_pc/B.n42 185
R348 pfet_01v8_lvt_W37p3_L0p74_m1__nf1_gboth_sdfull_pc/B.n171 pfet_01v8_lvt_W37p3_L0p74_m1__nf1_gboth_sdfull_pc/B.n170 185
R349 pfet_01v8_lvt_W37p3_L0p74_m1__nf1_gboth_sdfull_pc/B.n173 pfet_01v8_lvt_W37p3_L0p74_m1__nf1_gboth_sdfull_pc/B.n41 185
R350 pfet_01v8_lvt_W37p3_L0p74_m1__nf1_gboth_sdfull_pc/B.n176 pfet_01v8_lvt_W37p3_L0p74_m1__nf1_gboth_sdfull_pc/B.n175 185
R351 pfet_01v8_lvt_W37p3_L0p74_m1__nf1_gboth_sdfull_pc/B.n177 pfet_01v8_lvt_W37p3_L0p74_m1__nf1_gboth_sdfull_pc/B.n40 185
R352 pfet_01v8_lvt_W37p3_L0p74_m1__nf1_gboth_sdfull_pc/B.n179 pfet_01v8_lvt_W37p3_L0p74_m1__nf1_gboth_sdfull_pc/B.n178 185
R353 pfet_01v8_lvt_W37p3_L0p74_m1__nf1_gboth_sdfull_pc/B.n181 pfet_01v8_lvt_W37p3_L0p74_m1__nf1_gboth_sdfull_pc/B.n39 185
R354 pfet_01v8_lvt_W37p3_L0p74_m1__nf1_gboth_sdfull_pc/B.n184 pfet_01v8_lvt_W37p3_L0p74_m1__nf1_gboth_sdfull_pc/B.n183 185
R355 pfet_01v8_lvt_W37p3_L0p74_m1__nf1_gboth_sdfull_pc/B.n185 pfet_01v8_lvt_W37p3_L0p74_m1__nf1_gboth_sdfull_pc/B.n38 185
R356 pfet_01v8_lvt_W37p3_L0p74_m1__nf1_gboth_sdfull_pc/B.n187 pfet_01v8_lvt_W37p3_L0p74_m1__nf1_gboth_sdfull_pc/B.n186 185
R357 pfet_01v8_lvt_W37p3_L0p74_m1__nf1_gboth_sdfull_pc/B.n189 pfet_01v8_lvt_W37p3_L0p74_m1__nf1_gboth_sdfull_pc/B.n37 185
R358 pfet_01v8_lvt_W37p3_L0p74_m1__nf1_gboth_sdfull_pc/B.n191 pfet_01v8_lvt_W37p3_L0p74_m1__nf1_gboth_sdfull_pc/B.n190 185
R359 pfet_01v8_lvt_W37p3_L0p74_m1__nf1_gboth_sdfull_pc/B.n193 pfet_01v8_lvt_W37p3_L0p74_m1__nf1_gboth_sdfull_pc/B.n192 185
R360 pfet_01v8_lvt_W37p3_L0p74_m1__nf1_gboth_sdfull_pc/B.n194 pfet_01v8_lvt_W37p3_L0p74_m1__nf1_gboth_sdfull_pc/B.n35 185
R361 pfet_01v8_lvt_W37p3_L0p74_m1__nf1_gboth_sdfull_pc/B.n197 pfet_01v8_lvt_W37p3_L0p74_m1__nf1_gboth_sdfull_pc/B.n196 185
R362 pfet_01v8_lvt_W37p3_L0p74_m1__nf1_gboth_sdfull_pc/B.n34 pfet_01v8_lvt_W37p3_L0p74_m1__nf1_gboth_sdfull_pc/B.n9 185
R363 pfet_01v8_lvt_W37p3_L0p74_m1__nf1_gboth_sdfull_pc/B.n198 pfet_01v8_lvt_W37p3_L0p74_m1__nf1_gboth_sdfull_pc/B.n34 185
R364 pfet_01v8_lvt_W37p3_L0p74_m1__nf1_gboth_sdfull_pc/B.n200 pfet_01v8_lvt_W37p3_L0p74_m1__nf1_gboth_sdfull_pc/B.n199 185
R365 pfet_01v8_lvt_W37p3_L0p74_m1__nf1_gboth_sdfull_pc/B.n202 pfet_01v8_lvt_W37p3_L0p74_m1__nf1_gboth_sdfull_pc/B.n33 185
R366 pfet_01v8_lvt_W37p3_L0p74_m1__nf1_gboth_sdfull_pc/B.n204 pfet_01v8_lvt_W37p3_L0p74_m1__nf1_gboth_sdfull_pc/B.n203 185
R367 pfet_01v8_lvt_W37p3_L0p74_m1__nf1_gboth_sdfull_pc/B.n206 pfet_01v8_lvt_W37p3_L0p74_m1__nf1_gboth_sdfull_pc/B.n205 185
R368 pfet_01v8_lvt_W37p3_L0p74_m1__nf1_gboth_sdfull_pc/B.n207 pfet_01v8_lvt_W37p3_L0p74_m1__nf1_gboth_sdfull_pc/B.n31 185
R369 pfet_01v8_lvt_W37p3_L0p74_m1__nf1_gboth_sdfull_pc/B.n210 pfet_01v8_lvt_W37p3_L0p74_m1__nf1_gboth_sdfull_pc/B.n209 185
R370 pfet_01v8_lvt_W37p3_L0p74_m1__nf1_gboth_sdfull_pc/B.n30 pfet_01v8_lvt_W37p3_L0p74_m1__nf1_gboth_sdfull_pc/B.n9 185
R371 pfet_01v8_lvt_W37p3_L0p74_m1__nf1_gboth_sdfull_pc/B.n211 pfet_01v8_lvt_W37p3_L0p74_m1__nf1_gboth_sdfull_pc/B.n30 185
R372 pfet_01v8_lvt_W37p3_L0p74_m1__nf1_gboth_sdfull_pc/B.n213 pfet_01v8_lvt_W37p3_L0p74_m1__nf1_gboth_sdfull_pc/B.n212 185
R373 pfet_01v8_lvt_W37p3_L0p74_m1__nf1_gboth_sdfull_pc/B.n215 pfet_01v8_lvt_W37p3_L0p74_m1__nf1_gboth_sdfull_pc/B.n29 185
R374 pfet_01v8_lvt_W37p3_L0p74_m1__nf1_gboth_sdfull_pc/B.n218 pfet_01v8_lvt_W37p3_L0p74_m1__nf1_gboth_sdfull_pc/B.n217 185
R375 pfet_01v8_lvt_W37p3_L0p74_m1__nf1_gboth_sdfull_pc/B.n219 pfet_01v8_lvt_W37p3_L0p74_m1__nf1_gboth_sdfull_pc/B.n28 185
R376 pfet_01v8_lvt_W37p3_L0p74_m1__nf1_gboth_sdfull_pc/B.n221 pfet_01v8_lvt_W37p3_L0p74_m1__nf1_gboth_sdfull_pc/B.n220 185
R377 pfet_01v8_lvt_W37p3_L0p74_m1__nf1_gboth_sdfull_pc/B.n223 pfet_01v8_lvt_W37p3_L0p74_m1__nf1_gboth_sdfull_pc/B.n27 185
R378 pfet_01v8_lvt_W37p3_L0p74_m1__nf1_gboth_sdfull_pc/B.n226 pfet_01v8_lvt_W37p3_L0p74_m1__nf1_gboth_sdfull_pc/B.n225 185
R379 pfet_01v8_lvt_W37p3_L0p74_m1__nf1_gboth_sdfull_pc/B.n227 pfet_01v8_lvt_W37p3_L0p74_m1__nf1_gboth_sdfull_pc/B.n26 185
R380 pfet_01v8_lvt_W37p3_L0p74_m1__nf1_gboth_sdfull_pc/B.n229 pfet_01v8_lvt_W37p3_L0p74_m1__nf1_gboth_sdfull_pc/B.n228 185
R381 pfet_01v8_lvt_W37p3_L0p74_m1__nf1_gboth_sdfull_pc/B.n231 pfet_01v8_lvt_W37p3_L0p74_m1__nf1_gboth_sdfull_pc/B.n25 185
R382 pfet_01v8_lvt_W37p3_L0p74_m1__nf1_gboth_sdfull_pc/B.n234 pfet_01v8_lvt_W37p3_L0p74_m1__nf1_gboth_sdfull_pc/B.n233 185
R383 pfet_01v8_lvt_W37p3_L0p74_m1__nf1_gboth_sdfull_pc/B.n235 pfet_01v8_lvt_W37p3_L0p74_m1__nf1_gboth_sdfull_pc/B.n24 185
R384 pfet_01v8_lvt_W37p3_L0p74_m1__nf1_gboth_sdfull_pc/B.n237 pfet_01v8_lvt_W37p3_L0p74_m1__nf1_gboth_sdfull_pc/B.n236 185
R385 pfet_01v8_lvt_W37p3_L0p74_m1__nf1_gboth_sdfull_pc/B.n239 pfet_01v8_lvt_W37p3_L0p74_m1__nf1_gboth_sdfull_pc/B.n23 185
R386 pfet_01v8_lvt_W37p3_L0p74_m1__nf1_gboth_sdfull_pc/B.n241 pfet_01v8_lvt_W37p3_L0p74_m1__nf1_gboth_sdfull_pc/B.n240 185
R387 pfet_01v8_lvt_W37p3_L0p74_m1__nf1_gboth_sdfull_pc/B.n243 pfet_01v8_lvt_W37p3_L0p74_m1__nf1_gboth_sdfull_pc/B.n242 185
R388 pfet_01v8_lvt_W37p3_L0p74_m1__nf1_gboth_sdfull_pc/B.n244 pfet_01v8_lvt_W37p3_L0p74_m1__nf1_gboth_sdfull_pc/B.n9 185
R389 pfet_01v8_lvt_W37p3_L0p74_m1__nf1_gboth_sdfull_pc/B.n244 pfet_01v8_lvt_W37p3_L0p74_m1__nf1_gboth_sdfull_pc/B.n21 185
R390 pfet_01v8_lvt_W37p3_L0p74_m1__nf1_gboth_sdfull_pc/B.n247 pfet_01v8_lvt_W37p3_L0p74_m1__nf1_gboth_sdfull_pc/B.n246 185
R391 pfet_01v8_lvt_W37p3_L0p74_m1__nf1_gboth_sdfull_pc/B.n248 pfet_01v8_lvt_W37p3_L0p74_m1__nf1_gboth_sdfull_pc/B.n20 185
R392 pfet_01v8_lvt_W37p3_L0p74_m1__nf1_gboth_sdfull_pc/B.n250 pfet_01v8_lvt_W37p3_L0p74_m1__nf1_gboth_sdfull_pc/B.n249 185
R393 pfet_01v8_lvt_W37p3_L0p74_m1__nf1_gboth_sdfull_pc/B.n252 pfet_01v8_lvt_W37p3_L0p74_m1__nf1_gboth_sdfull_pc/B.n19 185
R394 pfet_01v8_lvt_W37p3_L0p74_m1__nf1_gboth_sdfull_pc/B.n255 pfet_01v8_lvt_W37p3_L0p74_m1__nf1_gboth_sdfull_pc/B.n254 185
R395 pfet_01v8_lvt_W37p3_L0p74_m1__nf1_gboth_sdfull_pc/B.n256 pfet_01v8_lvt_W37p3_L0p74_m1__nf1_gboth_sdfull_pc/B.n18 185
R396 pfet_01v8_lvt_W37p3_L0p74_m1__nf1_gboth_sdfull_pc/B.n258 pfet_01v8_lvt_W37p3_L0p74_m1__nf1_gboth_sdfull_pc/B.n257 185
R397 pfet_01v8_lvt_W37p3_L0p74_m1__nf1_gboth_sdfull_pc/B.n260 pfet_01v8_lvt_W37p3_L0p74_m1__nf1_gboth_sdfull_pc/B.n17 185
R398 pfet_01v8_lvt_W37p3_L0p74_m1__nf1_gboth_sdfull_pc/B.n262 pfet_01v8_lvt_W37p3_L0p74_m1__nf1_gboth_sdfull_pc/B.n261 185
R399 pfet_01v8_lvt_W37p3_L0p74_m1__nf1_gboth_sdfull_pc/B.n264 pfet_01v8_lvt_W37p3_L0p74_m1__nf1_gboth_sdfull_pc/B.n263 185
R400 pfet_01v8_lvt_W37p3_L0p74_m1__nf1_gboth_sdfull_pc/B.n265 pfet_01v8_lvt_W37p3_L0p74_m1__nf1_gboth_sdfull_pc/B.n9 185
R401 pfet_01v8_lvt_W37p3_L0p74_m1__nf1_gboth_sdfull_pc/B.n265 pfet_01v8_lvt_W37p3_L0p74_m1__nf1_gboth_sdfull_pc/B.n15 185
R402 pfet_01v8_lvt_W37p3_L0p74_m1__nf1_gboth_sdfull_pc/B.n267 pfet_01v8_lvt_W37p3_L0p74_m1__nf1_gboth_sdfull_pc/B.n266 185
R403 pfet_01v8_lvt_W37p3_L0p74_m1__nf1_gboth_sdfull_pc/B.n269 pfet_01v8_lvt_W37p3_L0p74_m1__nf1_gboth_sdfull_pc/B.n268 185
R404 pfet_01v8_lvt_W37p3_L0p74_m1__nf1_gboth_sdfull_pc/B.n270 pfet_01v8_lvt_W37p3_L0p74_m1__nf1_gboth_sdfull_pc/B.n9 185
R405 pfet_01v8_lvt_W37p3_L0p74_m1__nf1_gboth_sdfull_pc/B.n270 pfet_01v8_lvt_W37p3_L0p74_m1__nf1_gboth_sdfull_pc/B.n13 185
R406 pfet_01v8_lvt_W37p3_L0p74_m1__nf1_gboth_sdfull_pc/B.n273 pfet_01v8_lvt_W37p3_L0p74_m1__nf1_gboth_sdfull_pc/B.n272 185
R407 pfet_01v8_lvt_W37p3_L0p74_m1__nf1_gboth_sdfull_pc/B.n274 pfet_01v8_lvt_W37p3_L0p74_m1__nf1_gboth_sdfull_pc/B.n12 185
R408 pfet_01v8_lvt_W37p3_L0p74_m1__nf1_gboth_sdfull_pc/B.n276 pfet_01v8_lvt_W37p3_L0p74_m1__nf1_gboth_sdfull_pc/B.n275 185
R409 pfet_01v8_lvt_W37p3_L0p74_m1__nf1_gboth_sdfull_pc/B.n278 pfet_01v8_lvt_W37p3_L0p74_m1__nf1_gboth_sdfull_pc/B.n11 185
R410 pfet_01v8_lvt_W37p3_L0p74_m1__nf1_gboth_sdfull_pc/B.n281 pfet_01v8_lvt_W37p3_L0p74_m1__nf1_gboth_sdfull_pc/B.n280 185
R411 pfet_01v8_lvt_W37p3_L0p74_m1__nf1_gboth_sdfull_pc/B.n282 pfet_01v8_lvt_W37p3_L0p74_m1__nf1_gboth_sdfull_pc/B.n10 185
R412 pfet_01v8_lvt_W37p3_L0p74_m1__nf1_gboth_sdfull_pc/B.n365 pfet_01v8_lvt_W37p3_L0p74_m1__nf1_gboth_sdfull_pc/B.n1 82.824
R413 pfet_01v8_lvt_W37p3_L0p74_m1__nf1_gboth_sdfull_pc/B.n561 pfet_01v8_lvt_W37p3_L0p74_m1__nf1_gboth_sdfull_pc/B.n560 82.824
R414 pfet_01v8_lvt_W37p3_L0p74_m1__nf1_gboth_sdfull_pc/B.n283 pfet_01v8_lvt_W37p3_L0p74_m1__nf1_gboth_sdfull_pc/B.n282 82.824
R415 pfet_01v8_lvt_W37p3_L0p74_m1__nf1_gboth_sdfull_pc/B.n288 pfet_01v8_lvt_W37p3_L0p74_m1__nf1_gboth_sdfull_pc/B.n7 82.824
R416 pfet_01v8_lvt_W37p3_L0p74_m1__nf1_gboth_sdfull_pc/B.n369 pfet_01v8_lvt_W37p3_L0p74_m1__nf1_gboth_sdfull_pc/B.n327 72.7879
R417 pfet_01v8_lvt_W37p3_L0p74_m1__nf1_gboth_sdfull_pc/B.n372 pfet_01v8_lvt_W37p3_L0p74_m1__nf1_gboth_sdfull_pc/B.n328 72.7879
R418 pfet_01v8_lvt_W37p3_L0p74_m1__nf1_gboth_sdfull_pc/B.n375 pfet_01v8_lvt_W37p3_L0p74_m1__nf1_gboth_sdfull_pc/B.n330 72.7879
R419 pfet_01v8_lvt_W37p3_L0p74_m1__nf1_gboth_sdfull_pc/B.n382 pfet_01v8_lvt_W37p3_L0p74_m1__nf1_gboth_sdfull_pc/B.n325 72.7879
R420 pfet_01v8_lvt_W37p3_L0p74_m1__nf1_gboth_sdfull_pc/B.n386 pfet_01v8_lvt_W37p3_L0p74_m1__nf1_gboth_sdfull_pc/B.n324 72.7879
R421 pfet_01v8_lvt_W37p3_L0p74_m1__nf1_gboth_sdfull_pc/B.n390 pfet_01v8_lvt_W37p3_L0p74_m1__nf1_gboth_sdfull_pc/B.n323 72.7879
R422 pfet_01v8_lvt_W37p3_L0p74_m1__nf1_gboth_sdfull_pc/B.n394 pfet_01v8_lvt_W37p3_L0p74_m1__nf1_gboth_sdfull_pc/B.n322 72.7879
R423 pfet_01v8_lvt_W37p3_L0p74_m1__nf1_gboth_sdfull_pc/B.n397 pfet_01v8_lvt_W37p3_L0p74_m1__nf1_gboth_sdfull_pc/B.n321 72.7879
R424 pfet_01v8_lvt_W37p3_L0p74_m1__nf1_gboth_sdfull_pc/B.n402 pfet_01v8_lvt_W37p3_L0p74_m1__nf1_gboth_sdfull_pc/B.n331 72.7879
R425 pfet_01v8_lvt_W37p3_L0p74_m1__nf1_gboth_sdfull_pc/B.n408 pfet_01v8_lvt_W37p3_L0p74_m1__nf1_gboth_sdfull_pc/B.n319 72.7879
R426 pfet_01v8_lvt_W37p3_L0p74_m1__nf1_gboth_sdfull_pc/B.n409 pfet_01v8_lvt_W37p3_L0p74_m1__nf1_gboth_sdfull_pc/B.n333 72.7879
R427 pfet_01v8_lvt_W37p3_L0p74_m1__nf1_gboth_sdfull_pc/B.n415 pfet_01v8_lvt_W37p3_L0p74_m1__nf1_gboth_sdfull_pc/B.n318 72.7879
R428 pfet_01v8_lvt_W37p3_L0p74_m1__nf1_gboth_sdfull_pc/B.n420 pfet_01v8_lvt_W37p3_L0p74_m1__nf1_gboth_sdfull_pc/B.n334 72.7879
R429 pfet_01v8_lvt_W37p3_L0p74_m1__nf1_gboth_sdfull_pc/B.n425 pfet_01v8_lvt_W37p3_L0p74_m1__nf1_gboth_sdfull_pc/B.n316 72.7879
R430 pfet_01v8_lvt_W37p3_L0p74_m1__nf1_gboth_sdfull_pc/B.n428 pfet_01v8_lvt_W37p3_L0p74_m1__nf1_gboth_sdfull_pc/B.n314 72.7879
R431 pfet_01v8_lvt_W37p3_L0p74_m1__nf1_gboth_sdfull_pc/B.n434 pfet_01v8_lvt_W37p3_L0p74_m1__nf1_gboth_sdfull_pc/B.n336 72.7879
R432 pfet_01v8_lvt_W37p3_L0p74_m1__nf1_gboth_sdfull_pc/B.n439 pfet_01v8_lvt_W37p3_L0p74_m1__nf1_gboth_sdfull_pc/B.n313 72.7879
R433 pfet_01v8_lvt_W37p3_L0p74_m1__nf1_gboth_sdfull_pc/B.n445 pfet_01v8_lvt_W37p3_L0p74_m1__nf1_gboth_sdfull_pc/B.n338 72.7879
R434 pfet_01v8_lvt_W37p3_L0p74_m1__nf1_gboth_sdfull_pc/B.n448 pfet_01v8_lvt_W37p3_L0p74_m1__nf1_gboth_sdfull_pc/B.n339 72.7879
R435 pfet_01v8_lvt_W37p3_L0p74_m1__nf1_gboth_sdfull_pc/B.n454 pfet_01v8_lvt_W37p3_L0p74_m1__nf1_gboth_sdfull_pc/B.n311 72.7879
R436 pfet_01v8_lvt_W37p3_L0p74_m1__nf1_gboth_sdfull_pc/B.n458 pfet_01v8_lvt_W37p3_L0p74_m1__nf1_gboth_sdfull_pc/B.n310 72.7879
R437 pfet_01v8_lvt_W37p3_L0p74_m1__nf1_gboth_sdfull_pc/B.n462 pfet_01v8_lvt_W37p3_L0p74_m1__nf1_gboth_sdfull_pc/B.n309 72.7879
R438 pfet_01v8_lvt_W37p3_L0p74_m1__nf1_gboth_sdfull_pc/B.n465 pfet_01v8_lvt_W37p3_L0p74_m1__nf1_gboth_sdfull_pc/B.n308 72.7879
R439 pfet_01v8_lvt_W37p3_L0p74_m1__nf1_gboth_sdfull_pc/B.n468 pfet_01v8_lvt_W37p3_L0p74_m1__nf1_gboth_sdfull_pc/B.n306 72.7879
R440 pfet_01v8_lvt_W37p3_L0p74_m1__nf1_gboth_sdfull_pc/B.n474 pfet_01v8_lvt_W37p3_L0p74_m1__nf1_gboth_sdfull_pc/B.n341 72.7879
R441 pfet_01v8_lvt_W37p3_L0p74_m1__nf1_gboth_sdfull_pc/B.n477 pfet_01v8_lvt_W37p3_L0p74_m1__nf1_gboth_sdfull_pc/B.n343 72.7879
R442 pfet_01v8_lvt_W37p3_L0p74_m1__nf1_gboth_sdfull_pc/B.n484 pfet_01v8_lvt_W37p3_L0p74_m1__nf1_gboth_sdfull_pc/B.n305 72.7879
R443 pfet_01v8_lvt_W37p3_L0p74_m1__nf1_gboth_sdfull_pc/B.n488 pfet_01v8_lvt_W37p3_L0p74_m1__nf1_gboth_sdfull_pc/B.n304 72.7879
R444 pfet_01v8_lvt_W37p3_L0p74_m1__nf1_gboth_sdfull_pc/B.n492 pfet_01v8_lvt_W37p3_L0p74_m1__nf1_gboth_sdfull_pc/B.n303 72.7879
R445 pfet_01v8_lvt_W37p3_L0p74_m1__nf1_gboth_sdfull_pc/B.n493 pfet_01v8_lvt_W37p3_L0p74_m1__nf1_gboth_sdfull_pc/B.n344 72.7879
R446 pfet_01v8_lvt_W37p3_L0p74_m1__nf1_gboth_sdfull_pc/B.n499 pfet_01v8_lvt_W37p3_L0p74_m1__nf1_gboth_sdfull_pc/B.n302 72.7879
R447 pfet_01v8_lvt_W37p3_L0p74_m1__nf1_gboth_sdfull_pc/B.n505 pfet_01v8_lvt_W37p3_L0p74_m1__nf1_gboth_sdfull_pc/B.n345 72.7879
R448 pfet_01v8_lvt_W37p3_L0p74_m1__nf1_gboth_sdfull_pc/B.n508 pfet_01v8_lvt_W37p3_L0p74_m1__nf1_gboth_sdfull_pc/B.n346 72.7879
R449 pfet_01v8_lvt_W37p3_L0p74_m1__nf1_gboth_sdfull_pc/B.n513 pfet_01v8_lvt_W37p3_L0p74_m1__nf1_gboth_sdfull_pc/B.n300 72.7879
R450 pfet_01v8_lvt_W37p3_L0p74_m1__nf1_gboth_sdfull_pc/B.n519 pfet_01v8_lvt_W37p3_L0p74_m1__nf1_gboth_sdfull_pc/B.n348 72.7879
R451 pfet_01v8_lvt_W37p3_L0p74_m1__nf1_gboth_sdfull_pc/B.n523 pfet_01v8_lvt_W37p3_L0p74_m1__nf1_gboth_sdfull_pc/B.n349 72.7879
R452 pfet_01v8_lvt_W37p3_L0p74_m1__nf1_gboth_sdfull_pc/B.n524 pfet_01v8_lvt_W37p3_L0p74_m1__nf1_gboth_sdfull_pc/B.n298 72.7879
R453 pfet_01v8_lvt_W37p3_L0p74_m1__nf1_gboth_sdfull_pc/B.n531 pfet_01v8_lvt_W37p3_L0p74_m1__nf1_gboth_sdfull_pc/B.n350 72.7879
R454 pfet_01v8_lvt_W37p3_L0p74_m1__nf1_gboth_sdfull_pc/B.n534 pfet_01v8_lvt_W37p3_L0p74_m1__nf1_gboth_sdfull_pc/B.n351 72.7879
R455 pfet_01v8_lvt_W37p3_L0p74_m1__nf1_gboth_sdfull_pc/B.n539 pfet_01v8_lvt_W37p3_L0p74_m1__nf1_gboth_sdfull_pc/B.n297 72.7879
R456 pfet_01v8_lvt_W37p3_L0p74_m1__nf1_gboth_sdfull_pc/B.n544 pfet_01v8_lvt_W37p3_L0p74_m1__nf1_gboth_sdfull_pc/B.n353 72.7879
R457 pfet_01v8_lvt_W37p3_L0p74_m1__nf1_gboth_sdfull_pc/B.n549 pfet_01v8_lvt_W37p3_L0p74_m1__nf1_gboth_sdfull_pc/B.n295 72.7879
R458 pfet_01v8_lvt_W37p3_L0p74_m1__nf1_gboth_sdfull_pc/B.n357 pfet_01v8_lvt_W37p3_L0p74_m1__nf1_gboth_sdfull_pc/B.n355 72.7879
R459 pfet_01v8_lvt_W37p3_L0p74_m1__nf1_gboth_sdfull_pc/B.n362 pfet_01v8_lvt_W37p3_L0p74_m1__nf1_gboth_sdfull_pc/B.n293 72.7879
R460 pfet_01v8_lvt_W37p3_L0p74_m1__nf1_gboth_sdfull_pc/B.n358 pfet_01v8_lvt_W37p3_L0p74_m1__nf1_gboth_sdfull_pc/B.n292 72.7879
R461 pfet_01v8_lvt_W37p3_L0p74_m1__nf1_gboth_sdfull_pc/B.n558 pfet_01v8_lvt_W37p3_L0p74_m1__nf1_gboth_sdfull_pc/B.n291 72.7879
R462 pfet_01v8_lvt_W37p3_L0p74_m1__nf1_gboth_sdfull_pc/B.n71 pfet_01v8_lvt_W37p3_L0p74_m1__nf1_gboth_sdfull_pc/B.n8 72.7879
R463 pfet_01v8_lvt_W37p3_L0p74_m1__nf1_gboth_sdfull_pc/B.n74 pfet_01v8_lvt_W37p3_L0p74_m1__nf1_gboth_sdfull_pc/B.n73 72.7879
R464 pfet_01v8_lvt_W37p3_L0p74_m1__nf1_gboth_sdfull_pc/B.n79 pfet_01v8_lvt_W37p3_L0p74_m1__nf1_gboth_sdfull_pc/B.n78 72.7879
R465 pfet_01v8_lvt_W37p3_L0p74_m1__nf1_gboth_sdfull_pc/B.n81 pfet_01v8_lvt_W37p3_L0p74_m1__nf1_gboth_sdfull_pc/B.n67 72.7879
R466 pfet_01v8_lvt_W37p3_L0p74_m1__nf1_gboth_sdfull_pc/B.n86 pfet_01v8_lvt_W37p3_L0p74_m1__nf1_gboth_sdfull_pc/B.n85 72.7879
R467 pfet_01v8_lvt_W37p3_L0p74_m1__nf1_gboth_sdfull_pc/B.n92 pfet_01v8_lvt_W37p3_L0p74_m1__nf1_gboth_sdfull_pc/B.n91 72.7879
R468 pfet_01v8_lvt_W37p3_L0p74_m1__nf1_gboth_sdfull_pc/B.n95 pfet_01v8_lvt_W37p3_L0p74_m1__nf1_gboth_sdfull_pc/B.n94 72.7879
R469 pfet_01v8_lvt_W37p3_L0p74_m1__nf1_gboth_sdfull_pc/B.n100 pfet_01v8_lvt_W37p3_L0p74_m1__nf1_gboth_sdfull_pc/B.n99 72.7879
R470 pfet_01v8_lvt_W37p3_L0p74_m1__nf1_gboth_sdfull_pc/B.n103 pfet_01v8_lvt_W37p3_L0p74_m1__nf1_gboth_sdfull_pc/B.n102 72.7879
R471 pfet_01v8_lvt_W37p3_L0p74_m1__nf1_gboth_sdfull_pc/B.n108 pfet_01v8_lvt_W37p3_L0p74_m1__nf1_gboth_sdfull_pc/B.n107 72.7879
R472 pfet_01v8_lvt_W37p3_L0p74_m1__nf1_gboth_sdfull_pc/B.n110 pfet_01v8_lvt_W37p3_L0p74_m1__nf1_gboth_sdfull_pc/B.n59 72.7879
R473 pfet_01v8_lvt_W37p3_L0p74_m1__nf1_gboth_sdfull_pc/B.n115 pfet_01v8_lvt_W37p3_L0p74_m1__nf1_gboth_sdfull_pc/B.n114 72.7879
R474 pfet_01v8_lvt_W37p3_L0p74_m1__nf1_gboth_sdfull_pc/B.n121 pfet_01v8_lvt_W37p3_L0p74_m1__nf1_gboth_sdfull_pc/B.n120 72.7879
R475 pfet_01v8_lvt_W37p3_L0p74_m1__nf1_gboth_sdfull_pc/B.n123 pfet_01v8_lvt_W37p3_L0p74_m1__nf1_gboth_sdfull_pc/B.n55 72.7879
R476 pfet_01v8_lvt_W37p3_L0p74_m1__nf1_gboth_sdfull_pc/B.n129 pfet_01v8_lvt_W37p3_L0p74_m1__nf1_gboth_sdfull_pc/B.n128 72.7879
R477 pfet_01v8_lvt_W37p3_L0p74_m1__nf1_gboth_sdfull_pc/B.n135 pfet_01v8_lvt_W37p3_L0p74_m1__nf1_gboth_sdfull_pc/B.n134 72.7879
R478 pfet_01v8_lvt_W37p3_L0p74_m1__nf1_gboth_sdfull_pc/B.n137 pfet_01v8_lvt_W37p3_L0p74_m1__nf1_gboth_sdfull_pc/B.n136 72.7879
R479 pfet_01v8_lvt_W37p3_L0p74_m1__nf1_gboth_sdfull_pc/B.n143 pfet_01v8_lvt_W37p3_L0p74_m1__nf1_gboth_sdfull_pc/B.n142 72.7879
R480 pfet_01v8_lvt_W37p3_L0p74_m1__nf1_gboth_sdfull_pc/B.n145 pfet_01v8_lvt_W37p3_L0p74_m1__nf1_gboth_sdfull_pc/B.n48 72.7879
R481 pfet_01v8_lvt_W37p3_L0p74_m1__nf1_gboth_sdfull_pc/B.n150 pfet_01v8_lvt_W37p3_L0p74_m1__nf1_gboth_sdfull_pc/B.n149 72.7879
R482 pfet_01v8_lvt_W37p3_L0p74_m1__nf1_gboth_sdfull_pc/B.n156 pfet_01v8_lvt_W37p3_L0p74_m1__nf1_gboth_sdfull_pc/B.n155 72.7879
R483 pfet_01v8_lvt_W37p3_L0p74_m1__nf1_gboth_sdfull_pc/B.n159 pfet_01v8_lvt_W37p3_L0p74_m1__nf1_gboth_sdfull_pc/B.n158 72.7879
R484 pfet_01v8_lvt_W37p3_L0p74_m1__nf1_gboth_sdfull_pc/B.n164 pfet_01v8_lvt_W37p3_L0p74_m1__nf1_gboth_sdfull_pc/B.n163 72.7879
R485 pfet_01v8_lvt_W37p3_L0p74_m1__nf1_gboth_sdfull_pc/B.n167 pfet_01v8_lvt_W37p3_L0p74_m1__nf1_gboth_sdfull_pc/B.n166 72.7879
R486 pfet_01v8_lvt_W37p3_L0p74_m1__nf1_gboth_sdfull_pc/B.n172 pfet_01v8_lvt_W37p3_L0p74_m1__nf1_gboth_sdfull_pc/B.n171 72.7879
R487 pfet_01v8_lvt_W37p3_L0p74_m1__nf1_gboth_sdfull_pc/B.n175 pfet_01v8_lvt_W37p3_L0p74_m1__nf1_gboth_sdfull_pc/B.n174 72.7879
R488 pfet_01v8_lvt_W37p3_L0p74_m1__nf1_gboth_sdfull_pc/B.n180 pfet_01v8_lvt_W37p3_L0p74_m1__nf1_gboth_sdfull_pc/B.n179 72.7879
R489 pfet_01v8_lvt_W37p3_L0p74_m1__nf1_gboth_sdfull_pc/B.n183 pfet_01v8_lvt_W37p3_L0p74_m1__nf1_gboth_sdfull_pc/B.n182 72.7879
R490 pfet_01v8_lvt_W37p3_L0p74_m1__nf1_gboth_sdfull_pc/B.n188 pfet_01v8_lvt_W37p3_L0p74_m1__nf1_gboth_sdfull_pc/B.n187 72.7879
R491 pfet_01v8_lvt_W37p3_L0p74_m1__nf1_gboth_sdfull_pc/B.n190 pfet_01v8_lvt_W37p3_L0p74_m1__nf1_gboth_sdfull_pc/B.n36 72.7879
R492 pfet_01v8_lvt_W37p3_L0p74_m1__nf1_gboth_sdfull_pc/B.n195 pfet_01v8_lvt_W37p3_L0p74_m1__nf1_gboth_sdfull_pc/B.n194 72.7879
R493 pfet_01v8_lvt_W37p3_L0p74_m1__nf1_gboth_sdfull_pc/B.n201 pfet_01v8_lvt_W37p3_L0p74_m1__nf1_gboth_sdfull_pc/B.n200 72.7879
R494 pfet_01v8_lvt_W37p3_L0p74_m1__nf1_gboth_sdfull_pc/B.n203 pfet_01v8_lvt_W37p3_L0p74_m1__nf1_gboth_sdfull_pc/B.n32 72.7879
R495 pfet_01v8_lvt_W37p3_L0p74_m1__nf1_gboth_sdfull_pc/B.n208 pfet_01v8_lvt_W37p3_L0p74_m1__nf1_gboth_sdfull_pc/B.n207 72.7879
R496 pfet_01v8_lvt_W37p3_L0p74_m1__nf1_gboth_sdfull_pc/B.n214 pfet_01v8_lvt_W37p3_L0p74_m1__nf1_gboth_sdfull_pc/B.n213 72.7879
R497 pfet_01v8_lvt_W37p3_L0p74_m1__nf1_gboth_sdfull_pc/B.n217 pfet_01v8_lvt_W37p3_L0p74_m1__nf1_gboth_sdfull_pc/B.n216 72.7879
R498 pfet_01v8_lvt_W37p3_L0p74_m1__nf1_gboth_sdfull_pc/B.n222 pfet_01v8_lvt_W37p3_L0p74_m1__nf1_gboth_sdfull_pc/B.n221 72.7879
R499 pfet_01v8_lvt_W37p3_L0p74_m1__nf1_gboth_sdfull_pc/B.n225 pfet_01v8_lvt_W37p3_L0p74_m1__nf1_gboth_sdfull_pc/B.n224 72.7879
R500 pfet_01v8_lvt_W37p3_L0p74_m1__nf1_gboth_sdfull_pc/B.n230 pfet_01v8_lvt_W37p3_L0p74_m1__nf1_gboth_sdfull_pc/B.n229 72.7879
R501 pfet_01v8_lvt_W37p3_L0p74_m1__nf1_gboth_sdfull_pc/B.n233 pfet_01v8_lvt_W37p3_L0p74_m1__nf1_gboth_sdfull_pc/B.n232 72.7879
R502 pfet_01v8_lvt_W37p3_L0p74_m1__nf1_gboth_sdfull_pc/B.n238 pfet_01v8_lvt_W37p3_L0p74_m1__nf1_gboth_sdfull_pc/B.n237 72.7879
R503 pfet_01v8_lvt_W37p3_L0p74_m1__nf1_gboth_sdfull_pc/B.n240 pfet_01v8_lvt_W37p3_L0p74_m1__nf1_gboth_sdfull_pc/B.n22 72.7879
R504 pfet_01v8_lvt_W37p3_L0p74_m1__nf1_gboth_sdfull_pc/B.n246 pfet_01v8_lvt_W37p3_L0p74_m1__nf1_gboth_sdfull_pc/B.n245 72.7879
R505 pfet_01v8_lvt_W37p3_L0p74_m1__nf1_gboth_sdfull_pc/B.n251 pfet_01v8_lvt_W37p3_L0p74_m1__nf1_gboth_sdfull_pc/B.n250 72.7879
R506 pfet_01v8_lvt_W37p3_L0p74_m1__nf1_gboth_sdfull_pc/B.n253 pfet_01v8_lvt_W37p3_L0p74_m1__nf1_gboth_sdfull_pc/B.n18 72.7879
R507 pfet_01v8_lvt_W37p3_L0p74_m1__nf1_gboth_sdfull_pc/B.n259 pfet_01v8_lvt_W37p3_L0p74_m1__nf1_gboth_sdfull_pc/B.n258 72.7879
R508 pfet_01v8_lvt_W37p3_L0p74_m1__nf1_gboth_sdfull_pc/B.n261 pfet_01v8_lvt_W37p3_L0p74_m1__nf1_gboth_sdfull_pc/B.n16 72.7879
R509 pfet_01v8_lvt_W37p3_L0p74_m1__nf1_gboth_sdfull_pc/B.n266 pfet_01v8_lvt_W37p3_L0p74_m1__nf1_gboth_sdfull_pc/B.n14 72.7879
R510 pfet_01v8_lvt_W37p3_L0p74_m1__nf1_gboth_sdfull_pc/B.n272 pfet_01v8_lvt_W37p3_L0p74_m1__nf1_gboth_sdfull_pc/B.n271 72.7879
R511 pfet_01v8_lvt_W37p3_L0p74_m1__nf1_gboth_sdfull_pc/B.n277 pfet_01v8_lvt_W37p3_L0p74_m1__nf1_gboth_sdfull_pc/B.n276 72.7879
R512 pfet_01v8_lvt_W37p3_L0p74_m1__nf1_gboth_sdfull_pc/B.n280 pfet_01v8_lvt_W37p3_L0p74_m1__nf1_gboth_sdfull_pc/B.n279 72.7879
R513 pfet_01v8_lvt_W37p3_L0p74_m1__nf1_gboth_sdfull_pc/B.n279 pfet_01v8_lvt_W37p3_L0p74_m1__nf1_gboth_sdfull_pc/B.n10 72.7879
R514 pfet_01v8_lvt_W37p3_L0p74_m1__nf1_gboth_sdfull_pc/B.n278 pfet_01v8_lvt_W37p3_L0p74_m1__nf1_gboth_sdfull_pc/B.n277 72.7879
R515 pfet_01v8_lvt_W37p3_L0p74_m1__nf1_gboth_sdfull_pc/B.n271 pfet_01v8_lvt_W37p3_L0p74_m1__nf1_gboth_sdfull_pc/B.n12 72.7879
R516 pfet_01v8_lvt_W37p3_L0p74_m1__nf1_gboth_sdfull_pc/B.n269 pfet_01v8_lvt_W37p3_L0p74_m1__nf1_gboth_sdfull_pc/B.n14 72.7879
R517 pfet_01v8_lvt_W37p3_L0p74_m1__nf1_gboth_sdfull_pc/B.n264 pfet_01v8_lvt_W37p3_L0p74_m1__nf1_gboth_sdfull_pc/B.n16 72.7879
R518 pfet_01v8_lvt_W37p3_L0p74_m1__nf1_gboth_sdfull_pc/B.n260 pfet_01v8_lvt_W37p3_L0p74_m1__nf1_gboth_sdfull_pc/B.n259 72.7879
R519 pfet_01v8_lvt_W37p3_L0p74_m1__nf1_gboth_sdfull_pc/B.n254 pfet_01v8_lvt_W37p3_L0p74_m1__nf1_gboth_sdfull_pc/B.n253 72.7879
R520 pfet_01v8_lvt_W37p3_L0p74_m1__nf1_gboth_sdfull_pc/B.n252 pfet_01v8_lvt_W37p3_L0p74_m1__nf1_gboth_sdfull_pc/B.n251 72.7879
R521 pfet_01v8_lvt_W37p3_L0p74_m1__nf1_gboth_sdfull_pc/B.n245 pfet_01v8_lvt_W37p3_L0p74_m1__nf1_gboth_sdfull_pc/B.n20 72.7879
R522 pfet_01v8_lvt_W37p3_L0p74_m1__nf1_gboth_sdfull_pc/B.n243 pfet_01v8_lvt_W37p3_L0p74_m1__nf1_gboth_sdfull_pc/B.n22 72.7879
R523 pfet_01v8_lvt_W37p3_L0p74_m1__nf1_gboth_sdfull_pc/B.n239 pfet_01v8_lvt_W37p3_L0p74_m1__nf1_gboth_sdfull_pc/B.n238 72.7879
R524 pfet_01v8_lvt_W37p3_L0p74_m1__nf1_gboth_sdfull_pc/B.n232 pfet_01v8_lvt_W37p3_L0p74_m1__nf1_gboth_sdfull_pc/B.n24 72.7879
R525 pfet_01v8_lvt_W37p3_L0p74_m1__nf1_gboth_sdfull_pc/B.n231 pfet_01v8_lvt_W37p3_L0p74_m1__nf1_gboth_sdfull_pc/B.n230 72.7879
R526 pfet_01v8_lvt_W37p3_L0p74_m1__nf1_gboth_sdfull_pc/B.n224 pfet_01v8_lvt_W37p3_L0p74_m1__nf1_gboth_sdfull_pc/B.n26 72.7879
R527 pfet_01v8_lvt_W37p3_L0p74_m1__nf1_gboth_sdfull_pc/B.n223 pfet_01v8_lvt_W37p3_L0p74_m1__nf1_gboth_sdfull_pc/B.n222 72.7879
R528 pfet_01v8_lvt_W37p3_L0p74_m1__nf1_gboth_sdfull_pc/B.n216 pfet_01v8_lvt_W37p3_L0p74_m1__nf1_gboth_sdfull_pc/B.n28 72.7879
R529 pfet_01v8_lvt_W37p3_L0p74_m1__nf1_gboth_sdfull_pc/B.n215 pfet_01v8_lvt_W37p3_L0p74_m1__nf1_gboth_sdfull_pc/B.n214 72.7879
R530 pfet_01v8_lvt_W37p3_L0p74_m1__nf1_gboth_sdfull_pc/B.n209 pfet_01v8_lvt_W37p3_L0p74_m1__nf1_gboth_sdfull_pc/B.n208 72.7879
R531 pfet_01v8_lvt_W37p3_L0p74_m1__nf1_gboth_sdfull_pc/B.n206 pfet_01v8_lvt_W37p3_L0p74_m1__nf1_gboth_sdfull_pc/B.n32 72.7879
R532 pfet_01v8_lvt_W37p3_L0p74_m1__nf1_gboth_sdfull_pc/B.n202 pfet_01v8_lvt_W37p3_L0p74_m1__nf1_gboth_sdfull_pc/B.n201 72.7879
R533 pfet_01v8_lvt_W37p3_L0p74_m1__nf1_gboth_sdfull_pc/B.n196 pfet_01v8_lvt_W37p3_L0p74_m1__nf1_gboth_sdfull_pc/B.n195 72.7879
R534 pfet_01v8_lvt_W37p3_L0p74_m1__nf1_gboth_sdfull_pc/B.n193 pfet_01v8_lvt_W37p3_L0p74_m1__nf1_gboth_sdfull_pc/B.n36 72.7879
R535 pfet_01v8_lvt_W37p3_L0p74_m1__nf1_gboth_sdfull_pc/B.n189 pfet_01v8_lvt_W37p3_L0p74_m1__nf1_gboth_sdfull_pc/B.n188 72.7879
R536 pfet_01v8_lvt_W37p3_L0p74_m1__nf1_gboth_sdfull_pc/B.n182 pfet_01v8_lvt_W37p3_L0p74_m1__nf1_gboth_sdfull_pc/B.n38 72.7879
R537 pfet_01v8_lvt_W37p3_L0p74_m1__nf1_gboth_sdfull_pc/B.n181 pfet_01v8_lvt_W37p3_L0p74_m1__nf1_gboth_sdfull_pc/B.n180 72.7879
R538 pfet_01v8_lvt_W37p3_L0p74_m1__nf1_gboth_sdfull_pc/B.n174 pfet_01v8_lvt_W37p3_L0p74_m1__nf1_gboth_sdfull_pc/B.n40 72.7879
R539 pfet_01v8_lvt_W37p3_L0p74_m1__nf1_gboth_sdfull_pc/B.n173 pfet_01v8_lvt_W37p3_L0p74_m1__nf1_gboth_sdfull_pc/B.n172 72.7879
R540 pfet_01v8_lvt_W37p3_L0p74_m1__nf1_gboth_sdfull_pc/B.n166 pfet_01v8_lvt_W37p3_L0p74_m1__nf1_gboth_sdfull_pc/B.n42 72.7879
R541 pfet_01v8_lvt_W37p3_L0p74_m1__nf1_gboth_sdfull_pc/B.n165 pfet_01v8_lvt_W37p3_L0p74_m1__nf1_gboth_sdfull_pc/B.n164 72.7879
R542 pfet_01v8_lvt_W37p3_L0p74_m1__nf1_gboth_sdfull_pc/B.n158 pfet_01v8_lvt_W37p3_L0p74_m1__nf1_gboth_sdfull_pc/B.n44 72.7879
R543 pfet_01v8_lvt_W37p3_L0p74_m1__nf1_gboth_sdfull_pc/B.n157 pfet_01v8_lvt_W37p3_L0p74_m1__nf1_gboth_sdfull_pc/B.n156 72.7879
R544 pfet_01v8_lvt_W37p3_L0p74_m1__nf1_gboth_sdfull_pc/B.n151 pfet_01v8_lvt_W37p3_L0p74_m1__nf1_gboth_sdfull_pc/B.n150 72.7879
R545 pfet_01v8_lvt_W37p3_L0p74_m1__nf1_gboth_sdfull_pc/B.n148 pfet_01v8_lvt_W37p3_L0p74_m1__nf1_gboth_sdfull_pc/B.n48 72.7879
R546 pfet_01v8_lvt_W37p3_L0p74_m1__nf1_gboth_sdfull_pc/B.n144 pfet_01v8_lvt_W37p3_L0p74_m1__nf1_gboth_sdfull_pc/B.n143 72.7879
R547 pfet_01v8_lvt_W37p3_L0p74_m1__nf1_gboth_sdfull_pc/B.n138 pfet_01v8_lvt_W37p3_L0p74_m1__nf1_gboth_sdfull_pc/B.n137 72.7879
R548 pfet_01v8_lvt_W37p3_L0p74_m1__nf1_gboth_sdfull_pc/B.n134 pfet_01v8_lvt_W37p3_L0p74_m1__nf1_gboth_sdfull_pc/B.n133 72.7879
R549 pfet_01v8_lvt_W37p3_L0p74_m1__nf1_gboth_sdfull_pc/B.n128 pfet_01v8_lvt_W37p3_L0p74_m1__nf1_gboth_sdfull_pc/B.n53 72.7879
R550 pfet_01v8_lvt_W37p3_L0p74_m1__nf1_gboth_sdfull_pc/B.n126 pfet_01v8_lvt_W37p3_L0p74_m1__nf1_gboth_sdfull_pc/B.n55 72.7879
R551 pfet_01v8_lvt_W37p3_L0p74_m1__nf1_gboth_sdfull_pc/B.n122 pfet_01v8_lvt_W37p3_L0p74_m1__nf1_gboth_sdfull_pc/B.n121 72.7879
R552 pfet_01v8_lvt_W37p3_L0p74_m1__nf1_gboth_sdfull_pc/B.n116 pfet_01v8_lvt_W37p3_L0p74_m1__nf1_gboth_sdfull_pc/B.n115 72.7879
R553 pfet_01v8_lvt_W37p3_L0p74_m1__nf1_gboth_sdfull_pc/B.n113 pfet_01v8_lvt_W37p3_L0p74_m1__nf1_gboth_sdfull_pc/B.n59 72.7879
R554 pfet_01v8_lvt_W37p3_L0p74_m1__nf1_gboth_sdfull_pc/B.n109 pfet_01v8_lvt_W37p3_L0p74_m1__nf1_gboth_sdfull_pc/B.n108 72.7879
R555 pfet_01v8_lvt_W37p3_L0p74_m1__nf1_gboth_sdfull_pc/B.n102 pfet_01v8_lvt_W37p3_L0p74_m1__nf1_gboth_sdfull_pc/B.n61 72.7879
R556 pfet_01v8_lvt_W37p3_L0p74_m1__nf1_gboth_sdfull_pc/B.n101 pfet_01v8_lvt_W37p3_L0p74_m1__nf1_gboth_sdfull_pc/B.n100 72.7879
R557 pfet_01v8_lvt_W37p3_L0p74_m1__nf1_gboth_sdfull_pc/B.n94 pfet_01v8_lvt_W37p3_L0p74_m1__nf1_gboth_sdfull_pc/B.n63 72.7879
R558 pfet_01v8_lvt_W37p3_L0p74_m1__nf1_gboth_sdfull_pc/B.n93 pfet_01v8_lvt_W37p3_L0p74_m1__nf1_gboth_sdfull_pc/B.n92 72.7879
R559 pfet_01v8_lvt_W37p3_L0p74_m1__nf1_gboth_sdfull_pc/B.n87 pfet_01v8_lvt_W37p3_L0p74_m1__nf1_gboth_sdfull_pc/B.n86 72.7879
R560 pfet_01v8_lvt_W37p3_L0p74_m1__nf1_gboth_sdfull_pc/B.n84 pfet_01v8_lvt_W37p3_L0p74_m1__nf1_gboth_sdfull_pc/B.n67 72.7879
R561 pfet_01v8_lvt_W37p3_L0p74_m1__nf1_gboth_sdfull_pc/B.n80 pfet_01v8_lvt_W37p3_L0p74_m1__nf1_gboth_sdfull_pc/B.n79 72.7879
R562 pfet_01v8_lvt_W37p3_L0p74_m1__nf1_gboth_sdfull_pc/B.n73 pfet_01v8_lvt_W37p3_L0p74_m1__nf1_gboth_sdfull_pc/B.n69 72.7879
R563 pfet_01v8_lvt_W37p3_L0p74_m1__nf1_gboth_sdfull_pc/B.n72 pfet_01v8_lvt_W37p3_L0p74_m1__nf1_gboth_sdfull_pc/B.n71 72.7879
R564 pfet_01v8_lvt_W37p3_L0p74_m1__nf1_gboth_sdfull_pc/B.n366 pfet_01v8_lvt_W37p3_L0p74_m1__nf1_gboth_sdfull_pc/B.n327 72.7879
R565 pfet_01v8_lvt_W37p3_L0p74_m1__nf1_gboth_sdfull_pc/B.n370 pfet_01v8_lvt_W37p3_L0p74_m1__nf1_gboth_sdfull_pc/B.n328 72.7879
R566 pfet_01v8_lvt_W37p3_L0p74_m1__nf1_gboth_sdfull_pc/B.n378 pfet_01v8_lvt_W37p3_L0p74_m1__nf1_gboth_sdfull_pc/B.n330 72.7879
R567 pfet_01v8_lvt_W37p3_L0p74_m1__nf1_gboth_sdfull_pc/B.n379 pfet_01v8_lvt_W37p3_L0p74_m1__nf1_gboth_sdfull_pc/B.n325 72.7879
R568 pfet_01v8_lvt_W37p3_L0p74_m1__nf1_gboth_sdfull_pc/B.n383 pfet_01v8_lvt_W37p3_L0p74_m1__nf1_gboth_sdfull_pc/B.n324 72.7879
R569 pfet_01v8_lvt_W37p3_L0p74_m1__nf1_gboth_sdfull_pc/B.n387 pfet_01v8_lvt_W37p3_L0p74_m1__nf1_gboth_sdfull_pc/B.n323 72.7879
R570 pfet_01v8_lvt_W37p3_L0p74_m1__nf1_gboth_sdfull_pc/B.n391 pfet_01v8_lvt_W37p3_L0p74_m1__nf1_gboth_sdfull_pc/B.n322 72.7879
R571 pfet_01v8_lvt_W37p3_L0p74_m1__nf1_gboth_sdfull_pc/B.n395 pfet_01v8_lvt_W37p3_L0p74_m1__nf1_gboth_sdfull_pc/B.n321 72.7879
R572 pfet_01v8_lvt_W37p3_L0p74_m1__nf1_gboth_sdfull_pc/B.n400 pfet_01v8_lvt_W37p3_L0p74_m1__nf1_gboth_sdfull_pc/B.n331 72.7879
R573 pfet_01v8_lvt_W37p3_L0p74_m1__nf1_gboth_sdfull_pc/B.n405 pfet_01v8_lvt_W37p3_L0p74_m1__nf1_gboth_sdfull_pc/B.n319 72.7879
R574 pfet_01v8_lvt_W37p3_L0p74_m1__nf1_gboth_sdfull_pc/B.n412 pfet_01v8_lvt_W37p3_L0p74_m1__nf1_gboth_sdfull_pc/B.n333 72.7879
R575 pfet_01v8_lvt_W37p3_L0p74_m1__nf1_gboth_sdfull_pc/B.n413 pfet_01v8_lvt_W37p3_L0p74_m1__nf1_gboth_sdfull_pc/B.n318 72.7879
R576 pfet_01v8_lvt_W37p3_L0p74_m1__nf1_gboth_sdfull_pc/B.n418 pfet_01v8_lvt_W37p3_L0p74_m1__nf1_gboth_sdfull_pc/B.n334 72.7879
R577 pfet_01v8_lvt_W37p3_L0p74_m1__nf1_gboth_sdfull_pc/B.n423 pfet_01v8_lvt_W37p3_L0p74_m1__nf1_gboth_sdfull_pc/B.n316 72.7879
R578 pfet_01v8_lvt_W37p3_L0p74_m1__nf1_gboth_sdfull_pc/B.n431 pfet_01v8_lvt_W37p3_L0p74_m1__nf1_gboth_sdfull_pc/B.n314 72.7879
R579 pfet_01v8_lvt_W37p3_L0p74_m1__nf1_gboth_sdfull_pc/B.n432 pfet_01v8_lvt_W37p3_L0p74_m1__nf1_gboth_sdfull_pc/B.n336 72.7879
R580 pfet_01v8_lvt_W37p3_L0p74_m1__nf1_gboth_sdfull_pc/B.n437 pfet_01v8_lvt_W37p3_L0p74_m1__nf1_gboth_sdfull_pc/B.n313 72.7879
R581 pfet_01v8_lvt_W37p3_L0p74_m1__nf1_gboth_sdfull_pc/B.n442 pfet_01v8_lvt_W37p3_L0p74_m1__nf1_gboth_sdfull_pc/B.n338 72.7879
R582 pfet_01v8_lvt_W37p3_L0p74_m1__nf1_gboth_sdfull_pc/B.n446 pfet_01v8_lvt_W37p3_L0p74_m1__nf1_gboth_sdfull_pc/B.n339 72.7879
R583 pfet_01v8_lvt_W37p3_L0p74_m1__nf1_gboth_sdfull_pc/B.n451 pfet_01v8_lvt_W37p3_L0p74_m1__nf1_gboth_sdfull_pc/B.n311 72.7879
R584 pfet_01v8_lvt_W37p3_L0p74_m1__nf1_gboth_sdfull_pc/B.n455 pfet_01v8_lvt_W37p3_L0p74_m1__nf1_gboth_sdfull_pc/B.n310 72.7879
R585 pfet_01v8_lvt_W37p3_L0p74_m1__nf1_gboth_sdfull_pc/B.n459 pfet_01v8_lvt_W37p3_L0p74_m1__nf1_gboth_sdfull_pc/B.n309 72.7879
R586 pfet_01v8_lvt_W37p3_L0p74_m1__nf1_gboth_sdfull_pc/B.n463 pfet_01v8_lvt_W37p3_L0p74_m1__nf1_gboth_sdfull_pc/B.n308 72.7879
R587 pfet_01v8_lvt_W37p3_L0p74_m1__nf1_gboth_sdfull_pc/B.n471 pfet_01v8_lvt_W37p3_L0p74_m1__nf1_gboth_sdfull_pc/B.n306 72.7879
R588 pfet_01v8_lvt_W37p3_L0p74_m1__nf1_gboth_sdfull_pc/B.n472 pfet_01v8_lvt_W37p3_L0p74_m1__nf1_gboth_sdfull_pc/B.n341 72.7879
R589 pfet_01v8_lvt_W37p3_L0p74_m1__nf1_gboth_sdfull_pc/B.n480 pfet_01v8_lvt_W37p3_L0p74_m1__nf1_gboth_sdfull_pc/B.n343 72.7879
R590 pfet_01v8_lvt_W37p3_L0p74_m1__nf1_gboth_sdfull_pc/B.n481 pfet_01v8_lvt_W37p3_L0p74_m1__nf1_gboth_sdfull_pc/B.n305 72.7879
R591 pfet_01v8_lvt_W37p3_L0p74_m1__nf1_gboth_sdfull_pc/B.n485 pfet_01v8_lvt_W37p3_L0p74_m1__nf1_gboth_sdfull_pc/B.n304 72.7879
R592 pfet_01v8_lvt_W37p3_L0p74_m1__nf1_gboth_sdfull_pc/B.n489 pfet_01v8_lvt_W37p3_L0p74_m1__nf1_gboth_sdfull_pc/B.n303 72.7879
R593 pfet_01v8_lvt_W37p3_L0p74_m1__nf1_gboth_sdfull_pc/B.n496 pfet_01v8_lvt_W37p3_L0p74_m1__nf1_gboth_sdfull_pc/B.n344 72.7879
R594 pfet_01v8_lvt_W37p3_L0p74_m1__nf1_gboth_sdfull_pc/B.n497 pfet_01v8_lvt_W37p3_L0p74_m1__nf1_gboth_sdfull_pc/B.n302 72.7879
R595 pfet_01v8_lvt_W37p3_L0p74_m1__nf1_gboth_sdfull_pc/B.n502 pfet_01v8_lvt_W37p3_L0p74_m1__nf1_gboth_sdfull_pc/B.n345 72.7879
R596 pfet_01v8_lvt_W37p3_L0p74_m1__nf1_gboth_sdfull_pc/B.n506 pfet_01v8_lvt_W37p3_L0p74_m1__nf1_gboth_sdfull_pc/B.n346 72.7879
R597 pfet_01v8_lvt_W37p3_L0p74_m1__nf1_gboth_sdfull_pc/B.n511 pfet_01v8_lvt_W37p3_L0p74_m1__nf1_gboth_sdfull_pc/B.n300 72.7879
R598 pfet_01v8_lvt_W37p3_L0p74_m1__nf1_gboth_sdfull_pc/B.n516 pfet_01v8_lvt_W37p3_L0p74_m1__nf1_gboth_sdfull_pc/B.n348 72.7879
R599 pfet_01v8_lvt_W37p3_L0p74_m1__nf1_gboth_sdfull_pc/B.n520 pfet_01v8_lvt_W37p3_L0p74_m1__nf1_gboth_sdfull_pc/B.n349 72.7879
R600 pfet_01v8_lvt_W37p3_L0p74_m1__nf1_gboth_sdfull_pc/B.n527 pfet_01v8_lvt_W37p3_L0p74_m1__nf1_gboth_sdfull_pc/B.n298 72.7879
R601 pfet_01v8_lvt_W37p3_L0p74_m1__nf1_gboth_sdfull_pc/B.n528 pfet_01v8_lvt_W37p3_L0p74_m1__nf1_gboth_sdfull_pc/B.n350 72.7879
R602 pfet_01v8_lvt_W37p3_L0p74_m1__nf1_gboth_sdfull_pc/B.n532 pfet_01v8_lvt_W37p3_L0p74_m1__nf1_gboth_sdfull_pc/B.n351 72.7879
R603 pfet_01v8_lvt_W37p3_L0p74_m1__nf1_gboth_sdfull_pc/B.n537 pfet_01v8_lvt_W37p3_L0p74_m1__nf1_gboth_sdfull_pc/B.n297 72.7879
R604 pfet_01v8_lvt_W37p3_L0p74_m1__nf1_gboth_sdfull_pc/B.n542 pfet_01v8_lvt_W37p3_L0p74_m1__nf1_gboth_sdfull_pc/B.n353 72.7879
R605 pfet_01v8_lvt_W37p3_L0p74_m1__nf1_gboth_sdfull_pc/B.n547 pfet_01v8_lvt_W37p3_L0p74_m1__nf1_gboth_sdfull_pc/B.n295 72.7879
R606 pfet_01v8_lvt_W37p3_L0p74_m1__nf1_gboth_sdfull_pc/B.n552 pfet_01v8_lvt_W37p3_L0p74_m1__nf1_gboth_sdfull_pc/B.n355 72.7879
R607 pfet_01v8_lvt_W37p3_L0p74_m1__nf1_gboth_sdfull_pc/B.n356 pfet_01v8_lvt_W37p3_L0p74_m1__nf1_gboth_sdfull_pc/B.n293 72.7879
R608 pfet_01v8_lvt_W37p3_L0p74_m1__nf1_gboth_sdfull_pc/B.n361 pfet_01v8_lvt_W37p3_L0p74_m1__nf1_gboth_sdfull_pc/B.n292 72.7879
R609 pfet_01v8_lvt_W37p3_L0p74_m1__nf1_gboth_sdfull_pc/B.n559 pfet_01v8_lvt_W37p3_L0p74_m1__nf1_gboth_sdfull_pc/B.n558 72.7879
R610 pfet_01v8_lvt_W37p3_L0p74_m1__nf1_gboth_sdfull_pc/B.n557 pfet_01v8_lvt_W37p3_L0p74_m1__nf1_gboth_sdfull_pc/B.n327 56.1076
R611 pfet_01v8_lvt_W37p3_L0p74_m1__nf1_gboth_sdfull_pc/B.n557 pfet_01v8_lvt_W37p3_L0p74_m1__nf1_gboth_sdfull_pc/B.n328 56.1076
R612 pfet_01v8_lvt_W37p3_L0p74_m1__nf1_gboth_sdfull_pc/B.n557 pfet_01v8_lvt_W37p3_L0p74_m1__nf1_gboth_sdfull_pc/B.n330 56.1076
R613 pfet_01v8_lvt_W37p3_L0p74_m1__nf1_gboth_sdfull_pc/B.n557 pfet_01v8_lvt_W37p3_L0p74_m1__nf1_gboth_sdfull_pc/B.n325 56.1076
R614 pfet_01v8_lvt_W37p3_L0p74_m1__nf1_gboth_sdfull_pc/B.n557 pfet_01v8_lvt_W37p3_L0p74_m1__nf1_gboth_sdfull_pc/B.n324 56.1076
R615 pfet_01v8_lvt_W37p3_L0p74_m1__nf1_gboth_sdfull_pc/B.n557 pfet_01v8_lvt_W37p3_L0p74_m1__nf1_gboth_sdfull_pc/B.n323 56.1076
R616 pfet_01v8_lvt_W37p3_L0p74_m1__nf1_gboth_sdfull_pc/B.n557 pfet_01v8_lvt_W37p3_L0p74_m1__nf1_gboth_sdfull_pc/B.n322 56.1076
R617 pfet_01v8_lvt_W37p3_L0p74_m1__nf1_gboth_sdfull_pc/B.n557 pfet_01v8_lvt_W37p3_L0p74_m1__nf1_gboth_sdfull_pc/B.n321 56.1076
R618 pfet_01v8_lvt_W37p3_L0p74_m1__nf1_gboth_sdfull_pc/B.n557 pfet_01v8_lvt_W37p3_L0p74_m1__nf1_gboth_sdfull_pc/B.n331 56.1076
R619 pfet_01v8_lvt_W37p3_L0p74_m1__nf1_gboth_sdfull_pc/B.n557 pfet_01v8_lvt_W37p3_L0p74_m1__nf1_gboth_sdfull_pc/B.n319 56.1076
R620 pfet_01v8_lvt_W37p3_L0p74_m1__nf1_gboth_sdfull_pc/B.n557 pfet_01v8_lvt_W37p3_L0p74_m1__nf1_gboth_sdfull_pc/B.n333 56.1076
R621 pfet_01v8_lvt_W37p3_L0p74_m1__nf1_gboth_sdfull_pc/B.n557 pfet_01v8_lvt_W37p3_L0p74_m1__nf1_gboth_sdfull_pc/B.n318 56.1076
R622 pfet_01v8_lvt_W37p3_L0p74_m1__nf1_gboth_sdfull_pc/B.n557 pfet_01v8_lvt_W37p3_L0p74_m1__nf1_gboth_sdfull_pc/B.n334 56.1076
R623 pfet_01v8_lvt_W37p3_L0p74_m1__nf1_gboth_sdfull_pc/B.n557 pfet_01v8_lvt_W37p3_L0p74_m1__nf1_gboth_sdfull_pc/B.n316 56.1076
R624 pfet_01v8_lvt_W37p3_L0p74_m1__nf1_gboth_sdfull_pc/B.n557 pfet_01v8_lvt_W37p3_L0p74_m1__nf1_gboth_sdfull_pc/B.n314 56.1076
R625 pfet_01v8_lvt_W37p3_L0p74_m1__nf1_gboth_sdfull_pc/B.n557 pfet_01v8_lvt_W37p3_L0p74_m1__nf1_gboth_sdfull_pc/B.n336 56.1076
R626 pfet_01v8_lvt_W37p3_L0p74_m1__nf1_gboth_sdfull_pc/B.n557 pfet_01v8_lvt_W37p3_L0p74_m1__nf1_gboth_sdfull_pc/B.n313 56.1076
R627 pfet_01v8_lvt_W37p3_L0p74_m1__nf1_gboth_sdfull_pc/B.n557 pfet_01v8_lvt_W37p3_L0p74_m1__nf1_gboth_sdfull_pc/B.n338 56.1076
R628 pfet_01v8_lvt_W37p3_L0p74_m1__nf1_gboth_sdfull_pc/B.n557 pfet_01v8_lvt_W37p3_L0p74_m1__nf1_gboth_sdfull_pc/B.n339 56.1076
R629 pfet_01v8_lvt_W37p3_L0p74_m1__nf1_gboth_sdfull_pc/B.n557 pfet_01v8_lvt_W37p3_L0p74_m1__nf1_gboth_sdfull_pc/B.n311 56.1076
R630 pfet_01v8_lvt_W37p3_L0p74_m1__nf1_gboth_sdfull_pc/B.n557 pfet_01v8_lvt_W37p3_L0p74_m1__nf1_gboth_sdfull_pc/B.n310 56.1076
R631 pfet_01v8_lvt_W37p3_L0p74_m1__nf1_gboth_sdfull_pc/B.n557 pfet_01v8_lvt_W37p3_L0p74_m1__nf1_gboth_sdfull_pc/B.n309 56.1076
R632 pfet_01v8_lvt_W37p3_L0p74_m1__nf1_gboth_sdfull_pc/B.n557 pfet_01v8_lvt_W37p3_L0p74_m1__nf1_gboth_sdfull_pc/B.n308 56.1076
R633 pfet_01v8_lvt_W37p3_L0p74_m1__nf1_gboth_sdfull_pc/B.n557 pfet_01v8_lvt_W37p3_L0p74_m1__nf1_gboth_sdfull_pc/B.n306 56.1076
R634 pfet_01v8_lvt_W37p3_L0p74_m1__nf1_gboth_sdfull_pc/B.n557 pfet_01v8_lvt_W37p3_L0p74_m1__nf1_gboth_sdfull_pc/B.n341 56.1076
R635 pfet_01v8_lvt_W37p3_L0p74_m1__nf1_gboth_sdfull_pc/B.n557 pfet_01v8_lvt_W37p3_L0p74_m1__nf1_gboth_sdfull_pc/B.n343 56.1076
R636 pfet_01v8_lvt_W37p3_L0p74_m1__nf1_gboth_sdfull_pc/B.n557 pfet_01v8_lvt_W37p3_L0p74_m1__nf1_gboth_sdfull_pc/B.n305 56.1076
R637 pfet_01v8_lvt_W37p3_L0p74_m1__nf1_gboth_sdfull_pc/B.n557 pfet_01v8_lvt_W37p3_L0p74_m1__nf1_gboth_sdfull_pc/B.n304 56.1076
R638 pfet_01v8_lvt_W37p3_L0p74_m1__nf1_gboth_sdfull_pc/B.n557 pfet_01v8_lvt_W37p3_L0p74_m1__nf1_gboth_sdfull_pc/B.n303 56.1076
R639 pfet_01v8_lvt_W37p3_L0p74_m1__nf1_gboth_sdfull_pc/B.n557 pfet_01v8_lvt_W37p3_L0p74_m1__nf1_gboth_sdfull_pc/B.n344 56.1076
R640 pfet_01v8_lvt_W37p3_L0p74_m1__nf1_gboth_sdfull_pc/B.n557 pfet_01v8_lvt_W37p3_L0p74_m1__nf1_gboth_sdfull_pc/B.n302 56.1076
R641 pfet_01v8_lvt_W37p3_L0p74_m1__nf1_gboth_sdfull_pc/B.n557 pfet_01v8_lvt_W37p3_L0p74_m1__nf1_gboth_sdfull_pc/B.n345 56.1076
R642 pfet_01v8_lvt_W37p3_L0p74_m1__nf1_gboth_sdfull_pc/B.n557 pfet_01v8_lvt_W37p3_L0p74_m1__nf1_gboth_sdfull_pc/B.n346 56.1076
R643 pfet_01v8_lvt_W37p3_L0p74_m1__nf1_gboth_sdfull_pc/B.n557 pfet_01v8_lvt_W37p3_L0p74_m1__nf1_gboth_sdfull_pc/B.n300 56.1076
R644 pfet_01v8_lvt_W37p3_L0p74_m1__nf1_gboth_sdfull_pc/B.n557 pfet_01v8_lvt_W37p3_L0p74_m1__nf1_gboth_sdfull_pc/B.n348 56.1076
R645 pfet_01v8_lvt_W37p3_L0p74_m1__nf1_gboth_sdfull_pc/B.n557 pfet_01v8_lvt_W37p3_L0p74_m1__nf1_gboth_sdfull_pc/B.n349 56.1076
R646 pfet_01v8_lvt_W37p3_L0p74_m1__nf1_gboth_sdfull_pc/B.n557 pfet_01v8_lvt_W37p3_L0p74_m1__nf1_gboth_sdfull_pc/B.n298 56.1076
R647 pfet_01v8_lvt_W37p3_L0p74_m1__nf1_gboth_sdfull_pc/B.n557 pfet_01v8_lvt_W37p3_L0p74_m1__nf1_gboth_sdfull_pc/B.n350 56.1076
R648 pfet_01v8_lvt_W37p3_L0p74_m1__nf1_gboth_sdfull_pc/B.n557 pfet_01v8_lvt_W37p3_L0p74_m1__nf1_gboth_sdfull_pc/B.n351 56.1076
R649 pfet_01v8_lvt_W37p3_L0p74_m1__nf1_gboth_sdfull_pc/B.n557 pfet_01v8_lvt_W37p3_L0p74_m1__nf1_gboth_sdfull_pc/B.n297 56.1076
R650 pfet_01v8_lvt_W37p3_L0p74_m1__nf1_gboth_sdfull_pc/B.n557 pfet_01v8_lvt_W37p3_L0p74_m1__nf1_gboth_sdfull_pc/B.n353 56.1076
R651 pfet_01v8_lvt_W37p3_L0p74_m1__nf1_gboth_sdfull_pc/B.n557 pfet_01v8_lvt_W37p3_L0p74_m1__nf1_gboth_sdfull_pc/B.n295 56.1076
R652 pfet_01v8_lvt_W37p3_L0p74_m1__nf1_gboth_sdfull_pc/B.n557 pfet_01v8_lvt_W37p3_L0p74_m1__nf1_gboth_sdfull_pc/B.n355 56.1076
R653 pfet_01v8_lvt_W37p3_L0p74_m1__nf1_gboth_sdfull_pc/B.n557 pfet_01v8_lvt_W37p3_L0p74_m1__nf1_gboth_sdfull_pc/B.n293 56.1076
R654 pfet_01v8_lvt_W37p3_L0p74_m1__nf1_gboth_sdfull_pc/B.n557 pfet_01v8_lvt_W37p3_L0p74_m1__nf1_gboth_sdfull_pc/B.n292 56.1076
R655 pfet_01v8_lvt_W37p3_L0p74_m1__nf1_gboth_sdfull_pc/B.n558 pfet_01v8_lvt_W37p3_L0p74_m1__nf1_gboth_sdfull_pc/B.n557 56.1076
R656 pfet_01v8_lvt_W37p3_L0p74_m1__nf1_gboth_sdfull_pc/B.n71 pfet_01v8_lvt_W37p3_L0p74_m1__nf1_gboth_sdfull_pc/B.n9 56.1076
R657 pfet_01v8_lvt_W37p3_L0p74_m1__nf1_gboth_sdfull_pc/B.n73 pfet_01v8_lvt_W37p3_L0p74_m1__nf1_gboth_sdfull_pc/B.n9 56.1076
R658 pfet_01v8_lvt_W37p3_L0p74_m1__nf1_gboth_sdfull_pc/B.n79 pfet_01v8_lvt_W37p3_L0p74_m1__nf1_gboth_sdfull_pc/B.n9 56.1076
R659 pfet_01v8_lvt_W37p3_L0p74_m1__nf1_gboth_sdfull_pc/B.n67 pfet_01v8_lvt_W37p3_L0p74_m1__nf1_gboth_sdfull_pc/B.n9 56.1076
R660 pfet_01v8_lvt_W37p3_L0p74_m1__nf1_gboth_sdfull_pc/B.n86 pfet_01v8_lvt_W37p3_L0p74_m1__nf1_gboth_sdfull_pc/B.n9 56.1076
R661 pfet_01v8_lvt_W37p3_L0p74_m1__nf1_gboth_sdfull_pc/B.n92 pfet_01v8_lvt_W37p3_L0p74_m1__nf1_gboth_sdfull_pc/B.n9 56.1076
R662 pfet_01v8_lvt_W37p3_L0p74_m1__nf1_gboth_sdfull_pc/B.n94 pfet_01v8_lvt_W37p3_L0p74_m1__nf1_gboth_sdfull_pc/B.n9 56.1076
R663 pfet_01v8_lvt_W37p3_L0p74_m1__nf1_gboth_sdfull_pc/B.n100 pfet_01v8_lvt_W37p3_L0p74_m1__nf1_gboth_sdfull_pc/B.n9 56.1076
R664 pfet_01v8_lvt_W37p3_L0p74_m1__nf1_gboth_sdfull_pc/B.n102 pfet_01v8_lvt_W37p3_L0p74_m1__nf1_gboth_sdfull_pc/B.n9 56.1076
R665 pfet_01v8_lvt_W37p3_L0p74_m1__nf1_gboth_sdfull_pc/B.n108 pfet_01v8_lvt_W37p3_L0p74_m1__nf1_gboth_sdfull_pc/B.n9 56.1076
R666 pfet_01v8_lvt_W37p3_L0p74_m1__nf1_gboth_sdfull_pc/B.n59 pfet_01v8_lvt_W37p3_L0p74_m1__nf1_gboth_sdfull_pc/B.n9 56.1076
R667 pfet_01v8_lvt_W37p3_L0p74_m1__nf1_gboth_sdfull_pc/B.n115 pfet_01v8_lvt_W37p3_L0p74_m1__nf1_gboth_sdfull_pc/B.n9 56.1076
R668 pfet_01v8_lvt_W37p3_L0p74_m1__nf1_gboth_sdfull_pc/B.n121 pfet_01v8_lvt_W37p3_L0p74_m1__nf1_gboth_sdfull_pc/B.n9 56.1076
R669 pfet_01v8_lvt_W37p3_L0p74_m1__nf1_gboth_sdfull_pc/B.n55 pfet_01v8_lvt_W37p3_L0p74_m1__nf1_gboth_sdfull_pc/B.n9 56.1076
R670 pfet_01v8_lvt_W37p3_L0p74_m1__nf1_gboth_sdfull_pc/B.n128 pfet_01v8_lvt_W37p3_L0p74_m1__nf1_gboth_sdfull_pc/B.n9 56.1076
R671 pfet_01v8_lvt_W37p3_L0p74_m1__nf1_gboth_sdfull_pc/B.n134 pfet_01v8_lvt_W37p3_L0p74_m1__nf1_gboth_sdfull_pc/B.n9 56.1076
R672 pfet_01v8_lvt_W37p3_L0p74_m1__nf1_gboth_sdfull_pc/B.n137 pfet_01v8_lvt_W37p3_L0p74_m1__nf1_gboth_sdfull_pc/B.n9 56.1076
R673 pfet_01v8_lvt_W37p3_L0p74_m1__nf1_gboth_sdfull_pc/B.n143 pfet_01v8_lvt_W37p3_L0p74_m1__nf1_gboth_sdfull_pc/B.n9 56.1076
R674 pfet_01v8_lvt_W37p3_L0p74_m1__nf1_gboth_sdfull_pc/B.n48 pfet_01v8_lvt_W37p3_L0p74_m1__nf1_gboth_sdfull_pc/B.n9 56.1076
R675 pfet_01v8_lvt_W37p3_L0p74_m1__nf1_gboth_sdfull_pc/B.n150 pfet_01v8_lvt_W37p3_L0p74_m1__nf1_gboth_sdfull_pc/B.n9 56.1076
R676 pfet_01v8_lvt_W37p3_L0p74_m1__nf1_gboth_sdfull_pc/B.n156 pfet_01v8_lvt_W37p3_L0p74_m1__nf1_gboth_sdfull_pc/B.n9 56.1076
R677 pfet_01v8_lvt_W37p3_L0p74_m1__nf1_gboth_sdfull_pc/B.n158 pfet_01v8_lvt_W37p3_L0p74_m1__nf1_gboth_sdfull_pc/B.n9 56.1076
R678 pfet_01v8_lvt_W37p3_L0p74_m1__nf1_gboth_sdfull_pc/B.n164 pfet_01v8_lvt_W37p3_L0p74_m1__nf1_gboth_sdfull_pc/B.n9 56.1076
R679 pfet_01v8_lvt_W37p3_L0p74_m1__nf1_gboth_sdfull_pc/B.n166 pfet_01v8_lvt_W37p3_L0p74_m1__nf1_gboth_sdfull_pc/B.n9 56.1076
R680 pfet_01v8_lvt_W37p3_L0p74_m1__nf1_gboth_sdfull_pc/B.n172 pfet_01v8_lvt_W37p3_L0p74_m1__nf1_gboth_sdfull_pc/B.n9 56.1076
R681 pfet_01v8_lvt_W37p3_L0p74_m1__nf1_gboth_sdfull_pc/B.n174 pfet_01v8_lvt_W37p3_L0p74_m1__nf1_gboth_sdfull_pc/B.n9 56.1076
R682 pfet_01v8_lvt_W37p3_L0p74_m1__nf1_gboth_sdfull_pc/B.n180 pfet_01v8_lvt_W37p3_L0p74_m1__nf1_gboth_sdfull_pc/B.n9 56.1076
R683 pfet_01v8_lvt_W37p3_L0p74_m1__nf1_gboth_sdfull_pc/B.n182 pfet_01v8_lvt_W37p3_L0p74_m1__nf1_gboth_sdfull_pc/B.n9 56.1076
R684 pfet_01v8_lvt_W37p3_L0p74_m1__nf1_gboth_sdfull_pc/B.n188 pfet_01v8_lvt_W37p3_L0p74_m1__nf1_gboth_sdfull_pc/B.n9 56.1076
R685 pfet_01v8_lvt_W37p3_L0p74_m1__nf1_gboth_sdfull_pc/B.n36 pfet_01v8_lvt_W37p3_L0p74_m1__nf1_gboth_sdfull_pc/B.n9 56.1076
R686 pfet_01v8_lvt_W37p3_L0p74_m1__nf1_gboth_sdfull_pc/B.n195 pfet_01v8_lvt_W37p3_L0p74_m1__nf1_gboth_sdfull_pc/B.n9 56.1076
R687 pfet_01v8_lvt_W37p3_L0p74_m1__nf1_gboth_sdfull_pc/B.n201 pfet_01v8_lvt_W37p3_L0p74_m1__nf1_gboth_sdfull_pc/B.n9 56.1076
R688 pfet_01v8_lvt_W37p3_L0p74_m1__nf1_gboth_sdfull_pc/B.n32 pfet_01v8_lvt_W37p3_L0p74_m1__nf1_gboth_sdfull_pc/B.n9 56.1076
R689 pfet_01v8_lvt_W37p3_L0p74_m1__nf1_gboth_sdfull_pc/B.n208 pfet_01v8_lvt_W37p3_L0p74_m1__nf1_gboth_sdfull_pc/B.n9 56.1076
R690 pfet_01v8_lvt_W37p3_L0p74_m1__nf1_gboth_sdfull_pc/B.n214 pfet_01v8_lvt_W37p3_L0p74_m1__nf1_gboth_sdfull_pc/B.n9 56.1076
R691 pfet_01v8_lvt_W37p3_L0p74_m1__nf1_gboth_sdfull_pc/B.n216 pfet_01v8_lvt_W37p3_L0p74_m1__nf1_gboth_sdfull_pc/B.n9 56.1076
R692 pfet_01v8_lvt_W37p3_L0p74_m1__nf1_gboth_sdfull_pc/B.n222 pfet_01v8_lvt_W37p3_L0p74_m1__nf1_gboth_sdfull_pc/B.n9 56.1076
R693 pfet_01v8_lvt_W37p3_L0p74_m1__nf1_gboth_sdfull_pc/B.n224 pfet_01v8_lvt_W37p3_L0p74_m1__nf1_gboth_sdfull_pc/B.n9 56.1076
R694 pfet_01v8_lvt_W37p3_L0p74_m1__nf1_gboth_sdfull_pc/B.n230 pfet_01v8_lvt_W37p3_L0p74_m1__nf1_gboth_sdfull_pc/B.n9 56.1076
R695 pfet_01v8_lvt_W37p3_L0p74_m1__nf1_gboth_sdfull_pc/B.n232 pfet_01v8_lvt_W37p3_L0p74_m1__nf1_gboth_sdfull_pc/B.n9 56.1076
R696 pfet_01v8_lvt_W37p3_L0p74_m1__nf1_gboth_sdfull_pc/B.n238 pfet_01v8_lvt_W37p3_L0p74_m1__nf1_gboth_sdfull_pc/B.n9 56.1076
R697 pfet_01v8_lvt_W37p3_L0p74_m1__nf1_gboth_sdfull_pc/B.n22 pfet_01v8_lvt_W37p3_L0p74_m1__nf1_gboth_sdfull_pc/B.n9 56.1076
R698 pfet_01v8_lvt_W37p3_L0p74_m1__nf1_gboth_sdfull_pc/B.n245 pfet_01v8_lvt_W37p3_L0p74_m1__nf1_gboth_sdfull_pc/B.n9 56.1076
R699 pfet_01v8_lvt_W37p3_L0p74_m1__nf1_gboth_sdfull_pc/B.n251 pfet_01v8_lvt_W37p3_L0p74_m1__nf1_gboth_sdfull_pc/B.n9 56.1076
R700 pfet_01v8_lvt_W37p3_L0p74_m1__nf1_gboth_sdfull_pc/B.n253 pfet_01v8_lvt_W37p3_L0p74_m1__nf1_gboth_sdfull_pc/B.n9 56.1076
R701 pfet_01v8_lvt_W37p3_L0p74_m1__nf1_gboth_sdfull_pc/B.n259 pfet_01v8_lvt_W37p3_L0p74_m1__nf1_gboth_sdfull_pc/B.n9 56.1076
R702 pfet_01v8_lvt_W37p3_L0p74_m1__nf1_gboth_sdfull_pc/B.n16 pfet_01v8_lvt_W37p3_L0p74_m1__nf1_gboth_sdfull_pc/B.n9 56.1076
R703 pfet_01v8_lvt_W37p3_L0p74_m1__nf1_gboth_sdfull_pc/B.n14 pfet_01v8_lvt_W37p3_L0p74_m1__nf1_gboth_sdfull_pc/B.n9 56.1076
R704 pfet_01v8_lvt_W37p3_L0p74_m1__nf1_gboth_sdfull_pc/B.n271 pfet_01v8_lvt_W37p3_L0p74_m1__nf1_gboth_sdfull_pc/B.n9 56.1076
R705 pfet_01v8_lvt_W37p3_L0p74_m1__nf1_gboth_sdfull_pc/B.n277 pfet_01v8_lvt_W37p3_L0p74_m1__nf1_gboth_sdfull_pc/B.n9 56.1076
R706 pfet_01v8_lvt_W37p3_L0p74_m1__nf1_gboth_sdfull_pc/B.n279 pfet_01v8_lvt_W37p3_L0p74_m1__nf1_gboth_sdfull_pc/B.n9 56.1076
R707 pfet_01v8_lvt_W37p3_L0p74_m1__nf1_gboth_sdfull_pc/B.n566 pfet_01v8_lvt_W37p3_L0p74_m1__nf1_gboth_sdfull_pc/B.n1 25.6005
R708 pfet_01v8_lvt_W37p3_L0p74_m1__nf1_gboth_sdfull_pc/B.n283 pfet_01v8_lvt_W37p3_L0p74_m1__nf1_gboth_sdfull_pc/B.n0 25.6005
R709 pfet_01v8_lvt_W37p3_L0p74_m1__nf1_gboth_sdfull_pc/B.n367 pfet_01v8_lvt_W37p3_L0p74_m1__nf1_gboth_sdfull_pc/B.n365 25.6005
R710 pfet_01v8_lvt_W37p3_L0p74_m1__nf1_gboth_sdfull_pc/B.n368 pfet_01v8_lvt_W37p3_L0p74_m1__nf1_gboth_sdfull_pc/B.n367 25.6005
R711 pfet_01v8_lvt_W37p3_L0p74_m1__nf1_gboth_sdfull_pc/B.n371 pfet_01v8_lvt_W37p3_L0p74_m1__nf1_gboth_sdfull_pc/B.n368 25.6005
R712 pfet_01v8_lvt_W37p3_L0p74_m1__nf1_gboth_sdfull_pc/B.n373 pfet_01v8_lvt_W37p3_L0p74_m1__nf1_gboth_sdfull_pc/B.n371 25.6005
R713 pfet_01v8_lvt_W37p3_L0p74_m1__nf1_gboth_sdfull_pc/B.n374 pfet_01v8_lvt_W37p3_L0p74_m1__nf1_gboth_sdfull_pc/B.n373 25.6005
R714 pfet_01v8_lvt_W37p3_L0p74_m1__nf1_gboth_sdfull_pc/B.n376 pfet_01v8_lvt_W37p3_L0p74_m1__nf1_gboth_sdfull_pc/B.n374 25.6005
R715 pfet_01v8_lvt_W37p3_L0p74_m1__nf1_gboth_sdfull_pc/B.n377 pfet_01v8_lvt_W37p3_L0p74_m1__nf1_gboth_sdfull_pc/B.n376 25.6005
R716 pfet_01v8_lvt_W37p3_L0p74_m1__nf1_gboth_sdfull_pc/B.n380 pfet_01v8_lvt_W37p3_L0p74_m1__nf1_gboth_sdfull_pc/B.n377 25.6005
R717 pfet_01v8_lvt_W37p3_L0p74_m1__nf1_gboth_sdfull_pc/B.n381 pfet_01v8_lvt_W37p3_L0p74_m1__nf1_gboth_sdfull_pc/B.n380 25.6005
R718 pfet_01v8_lvt_W37p3_L0p74_m1__nf1_gboth_sdfull_pc/B.n384 pfet_01v8_lvt_W37p3_L0p74_m1__nf1_gboth_sdfull_pc/B.n381 25.6005
R719 pfet_01v8_lvt_W37p3_L0p74_m1__nf1_gboth_sdfull_pc/B.n385 pfet_01v8_lvt_W37p3_L0p74_m1__nf1_gboth_sdfull_pc/B.n384 25.6005
R720 pfet_01v8_lvt_W37p3_L0p74_m1__nf1_gboth_sdfull_pc/B.n388 pfet_01v8_lvt_W37p3_L0p74_m1__nf1_gboth_sdfull_pc/B.n385 25.6005
R721 pfet_01v8_lvt_W37p3_L0p74_m1__nf1_gboth_sdfull_pc/B.n389 pfet_01v8_lvt_W37p3_L0p74_m1__nf1_gboth_sdfull_pc/B.n388 25.6005
R722 pfet_01v8_lvt_W37p3_L0p74_m1__nf1_gboth_sdfull_pc/B.n392 pfet_01v8_lvt_W37p3_L0p74_m1__nf1_gboth_sdfull_pc/B.n389 25.6005
R723 pfet_01v8_lvt_W37p3_L0p74_m1__nf1_gboth_sdfull_pc/B.n393 pfet_01v8_lvt_W37p3_L0p74_m1__nf1_gboth_sdfull_pc/B.n392 25.6005
R724 pfet_01v8_lvt_W37p3_L0p74_m1__nf1_gboth_sdfull_pc/B.n396 pfet_01v8_lvt_W37p3_L0p74_m1__nf1_gboth_sdfull_pc/B.n393 25.6005
R725 pfet_01v8_lvt_W37p3_L0p74_m1__nf1_gboth_sdfull_pc/B.n398 pfet_01v8_lvt_W37p3_L0p74_m1__nf1_gboth_sdfull_pc/B.n396 25.6005
R726 pfet_01v8_lvt_W37p3_L0p74_m1__nf1_gboth_sdfull_pc/B.n399 pfet_01v8_lvt_W37p3_L0p74_m1__nf1_gboth_sdfull_pc/B.n398 25.6005
R727 pfet_01v8_lvt_W37p3_L0p74_m1__nf1_gboth_sdfull_pc/B.n401 pfet_01v8_lvt_W37p3_L0p74_m1__nf1_gboth_sdfull_pc/B.n399 25.6005
R728 pfet_01v8_lvt_W37p3_L0p74_m1__nf1_gboth_sdfull_pc/B.n403 pfet_01v8_lvt_W37p3_L0p74_m1__nf1_gboth_sdfull_pc/B.n401 25.6005
R729 pfet_01v8_lvt_W37p3_L0p74_m1__nf1_gboth_sdfull_pc/B.n404 pfet_01v8_lvt_W37p3_L0p74_m1__nf1_gboth_sdfull_pc/B.n403 25.6005
R730 pfet_01v8_lvt_W37p3_L0p74_m1__nf1_gboth_sdfull_pc/B.n406 pfet_01v8_lvt_W37p3_L0p74_m1__nf1_gboth_sdfull_pc/B.n404 25.6005
R731 pfet_01v8_lvt_W37p3_L0p74_m1__nf1_gboth_sdfull_pc/B.n407 pfet_01v8_lvt_W37p3_L0p74_m1__nf1_gboth_sdfull_pc/B.n406 25.6005
R732 pfet_01v8_lvt_W37p3_L0p74_m1__nf1_gboth_sdfull_pc/B.n410 pfet_01v8_lvt_W37p3_L0p74_m1__nf1_gboth_sdfull_pc/B.n407 25.6005
R733 pfet_01v8_lvt_W37p3_L0p74_m1__nf1_gboth_sdfull_pc/B.n411 pfet_01v8_lvt_W37p3_L0p74_m1__nf1_gboth_sdfull_pc/B.n410 25.6005
R734 pfet_01v8_lvt_W37p3_L0p74_m1__nf1_gboth_sdfull_pc/B.n414 pfet_01v8_lvt_W37p3_L0p74_m1__nf1_gboth_sdfull_pc/B.n411 25.6005
R735 pfet_01v8_lvt_W37p3_L0p74_m1__nf1_gboth_sdfull_pc/B.n416 pfet_01v8_lvt_W37p3_L0p74_m1__nf1_gboth_sdfull_pc/B.n414 25.6005
R736 pfet_01v8_lvt_W37p3_L0p74_m1__nf1_gboth_sdfull_pc/B.n417 pfet_01v8_lvt_W37p3_L0p74_m1__nf1_gboth_sdfull_pc/B.n416 25.6005
R737 pfet_01v8_lvt_W37p3_L0p74_m1__nf1_gboth_sdfull_pc/B.n419 pfet_01v8_lvt_W37p3_L0p74_m1__nf1_gboth_sdfull_pc/B.n417 25.6005
R738 pfet_01v8_lvt_W37p3_L0p74_m1__nf1_gboth_sdfull_pc/B.n421 pfet_01v8_lvt_W37p3_L0p74_m1__nf1_gboth_sdfull_pc/B.n419 25.6005
R739 pfet_01v8_lvt_W37p3_L0p74_m1__nf1_gboth_sdfull_pc/B.n422 pfet_01v8_lvt_W37p3_L0p74_m1__nf1_gboth_sdfull_pc/B.n421 25.6005
R740 pfet_01v8_lvt_W37p3_L0p74_m1__nf1_gboth_sdfull_pc/B.n424 pfet_01v8_lvt_W37p3_L0p74_m1__nf1_gboth_sdfull_pc/B.n422 25.6005
R741 pfet_01v8_lvt_W37p3_L0p74_m1__nf1_gboth_sdfull_pc/B.n426 pfet_01v8_lvt_W37p3_L0p74_m1__nf1_gboth_sdfull_pc/B.n424 25.6005
R742 pfet_01v8_lvt_W37p3_L0p74_m1__nf1_gboth_sdfull_pc/B.n427 pfet_01v8_lvt_W37p3_L0p74_m1__nf1_gboth_sdfull_pc/B.n426 25.6005
R743 pfet_01v8_lvt_W37p3_L0p74_m1__nf1_gboth_sdfull_pc/B.n429 pfet_01v8_lvt_W37p3_L0p74_m1__nf1_gboth_sdfull_pc/B.n427 25.6005
R744 pfet_01v8_lvt_W37p3_L0p74_m1__nf1_gboth_sdfull_pc/B.n430 pfet_01v8_lvt_W37p3_L0p74_m1__nf1_gboth_sdfull_pc/B.n429 25.6005
R745 pfet_01v8_lvt_W37p3_L0p74_m1__nf1_gboth_sdfull_pc/B.n433 pfet_01v8_lvt_W37p3_L0p74_m1__nf1_gboth_sdfull_pc/B.n430 25.6005
R746 pfet_01v8_lvt_W37p3_L0p74_m1__nf1_gboth_sdfull_pc/B.n435 pfet_01v8_lvt_W37p3_L0p74_m1__nf1_gboth_sdfull_pc/B.n433 25.6005
R747 pfet_01v8_lvt_W37p3_L0p74_m1__nf1_gboth_sdfull_pc/B.n436 pfet_01v8_lvt_W37p3_L0p74_m1__nf1_gboth_sdfull_pc/B.n435 25.6005
R748 pfet_01v8_lvt_W37p3_L0p74_m1__nf1_gboth_sdfull_pc/B.n438 pfet_01v8_lvt_W37p3_L0p74_m1__nf1_gboth_sdfull_pc/B.n436 25.6005
R749 pfet_01v8_lvt_W37p3_L0p74_m1__nf1_gboth_sdfull_pc/B.n440 pfet_01v8_lvt_W37p3_L0p74_m1__nf1_gboth_sdfull_pc/B.n438 25.6005
R750 pfet_01v8_lvt_W37p3_L0p74_m1__nf1_gboth_sdfull_pc/B.n441 pfet_01v8_lvt_W37p3_L0p74_m1__nf1_gboth_sdfull_pc/B.n440 25.6005
R751 pfet_01v8_lvt_W37p3_L0p74_m1__nf1_gboth_sdfull_pc/B.n443 pfet_01v8_lvt_W37p3_L0p74_m1__nf1_gboth_sdfull_pc/B.n441 25.6005
R752 pfet_01v8_lvt_W37p3_L0p74_m1__nf1_gboth_sdfull_pc/B.n444 pfet_01v8_lvt_W37p3_L0p74_m1__nf1_gboth_sdfull_pc/B.n443 25.6005
R753 pfet_01v8_lvt_W37p3_L0p74_m1__nf1_gboth_sdfull_pc/B.n447 pfet_01v8_lvt_W37p3_L0p74_m1__nf1_gboth_sdfull_pc/B.n444 25.6005
R754 pfet_01v8_lvt_W37p3_L0p74_m1__nf1_gboth_sdfull_pc/B.n449 pfet_01v8_lvt_W37p3_L0p74_m1__nf1_gboth_sdfull_pc/B.n447 25.6005
R755 pfet_01v8_lvt_W37p3_L0p74_m1__nf1_gboth_sdfull_pc/B.n450 pfet_01v8_lvt_W37p3_L0p74_m1__nf1_gboth_sdfull_pc/B.n449 25.6005
R756 pfet_01v8_lvt_W37p3_L0p74_m1__nf1_gboth_sdfull_pc/B.n452 pfet_01v8_lvt_W37p3_L0p74_m1__nf1_gboth_sdfull_pc/B.n450 25.6005
R757 pfet_01v8_lvt_W37p3_L0p74_m1__nf1_gboth_sdfull_pc/B.n453 pfet_01v8_lvt_W37p3_L0p74_m1__nf1_gboth_sdfull_pc/B.n452 25.6005
R758 pfet_01v8_lvt_W37p3_L0p74_m1__nf1_gboth_sdfull_pc/B.n456 pfet_01v8_lvt_W37p3_L0p74_m1__nf1_gboth_sdfull_pc/B.n453 25.6005
R759 pfet_01v8_lvt_W37p3_L0p74_m1__nf1_gboth_sdfull_pc/B.n457 pfet_01v8_lvt_W37p3_L0p74_m1__nf1_gboth_sdfull_pc/B.n456 25.6005
R760 pfet_01v8_lvt_W37p3_L0p74_m1__nf1_gboth_sdfull_pc/B.n460 pfet_01v8_lvt_W37p3_L0p74_m1__nf1_gboth_sdfull_pc/B.n457 25.6005
R761 pfet_01v8_lvt_W37p3_L0p74_m1__nf1_gboth_sdfull_pc/B.n461 pfet_01v8_lvt_W37p3_L0p74_m1__nf1_gboth_sdfull_pc/B.n460 25.6005
R762 pfet_01v8_lvt_W37p3_L0p74_m1__nf1_gboth_sdfull_pc/B.n464 pfet_01v8_lvt_W37p3_L0p74_m1__nf1_gboth_sdfull_pc/B.n461 25.6005
R763 pfet_01v8_lvt_W37p3_L0p74_m1__nf1_gboth_sdfull_pc/B.n466 pfet_01v8_lvt_W37p3_L0p74_m1__nf1_gboth_sdfull_pc/B.n464 25.6005
R764 pfet_01v8_lvt_W37p3_L0p74_m1__nf1_gboth_sdfull_pc/B.n467 pfet_01v8_lvt_W37p3_L0p74_m1__nf1_gboth_sdfull_pc/B.n466 25.6005
R765 pfet_01v8_lvt_W37p3_L0p74_m1__nf1_gboth_sdfull_pc/B.n469 pfet_01v8_lvt_W37p3_L0p74_m1__nf1_gboth_sdfull_pc/B.n467 25.6005
R766 pfet_01v8_lvt_W37p3_L0p74_m1__nf1_gboth_sdfull_pc/B.n470 pfet_01v8_lvt_W37p3_L0p74_m1__nf1_gboth_sdfull_pc/B.n469 25.6005
R767 pfet_01v8_lvt_W37p3_L0p74_m1__nf1_gboth_sdfull_pc/B.n473 pfet_01v8_lvt_W37p3_L0p74_m1__nf1_gboth_sdfull_pc/B.n470 25.6005
R768 pfet_01v8_lvt_W37p3_L0p74_m1__nf1_gboth_sdfull_pc/B.n475 pfet_01v8_lvt_W37p3_L0p74_m1__nf1_gboth_sdfull_pc/B.n473 25.6005
R769 pfet_01v8_lvt_W37p3_L0p74_m1__nf1_gboth_sdfull_pc/B.n476 pfet_01v8_lvt_W37p3_L0p74_m1__nf1_gboth_sdfull_pc/B.n475 25.6005
R770 pfet_01v8_lvt_W37p3_L0p74_m1__nf1_gboth_sdfull_pc/B.n478 pfet_01v8_lvt_W37p3_L0p74_m1__nf1_gboth_sdfull_pc/B.n476 25.6005
R771 pfet_01v8_lvt_W37p3_L0p74_m1__nf1_gboth_sdfull_pc/B.n479 pfet_01v8_lvt_W37p3_L0p74_m1__nf1_gboth_sdfull_pc/B.n478 25.6005
R772 pfet_01v8_lvt_W37p3_L0p74_m1__nf1_gboth_sdfull_pc/B.n482 pfet_01v8_lvt_W37p3_L0p74_m1__nf1_gboth_sdfull_pc/B.n479 25.6005
R773 pfet_01v8_lvt_W37p3_L0p74_m1__nf1_gboth_sdfull_pc/B.n483 pfet_01v8_lvt_W37p3_L0p74_m1__nf1_gboth_sdfull_pc/B.n482 25.6005
R774 pfet_01v8_lvt_W37p3_L0p74_m1__nf1_gboth_sdfull_pc/B.n486 pfet_01v8_lvt_W37p3_L0p74_m1__nf1_gboth_sdfull_pc/B.n483 25.6005
R775 pfet_01v8_lvt_W37p3_L0p74_m1__nf1_gboth_sdfull_pc/B.n487 pfet_01v8_lvt_W37p3_L0p74_m1__nf1_gboth_sdfull_pc/B.n486 25.6005
R776 pfet_01v8_lvt_W37p3_L0p74_m1__nf1_gboth_sdfull_pc/B.n490 pfet_01v8_lvt_W37p3_L0p74_m1__nf1_gboth_sdfull_pc/B.n487 25.6005
R777 pfet_01v8_lvt_W37p3_L0p74_m1__nf1_gboth_sdfull_pc/B.n491 pfet_01v8_lvt_W37p3_L0p74_m1__nf1_gboth_sdfull_pc/B.n490 25.6005
R778 pfet_01v8_lvt_W37p3_L0p74_m1__nf1_gboth_sdfull_pc/B.n494 pfet_01v8_lvt_W37p3_L0p74_m1__nf1_gboth_sdfull_pc/B.n491 25.6005
R779 pfet_01v8_lvt_W37p3_L0p74_m1__nf1_gboth_sdfull_pc/B.n495 pfet_01v8_lvt_W37p3_L0p74_m1__nf1_gboth_sdfull_pc/B.n494 25.6005
R780 pfet_01v8_lvt_W37p3_L0p74_m1__nf1_gboth_sdfull_pc/B.n498 pfet_01v8_lvt_W37p3_L0p74_m1__nf1_gboth_sdfull_pc/B.n495 25.6005
R781 pfet_01v8_lvt_W37p3_L0p74_m1__nf1_gboth_sdfull_pc/B.n500 pfet_01v8_lvt_W37p3_L0p74_m1__nf1_gboth_sdfull_pc/B.n498 25.6005
R782 pfet_01v8_lvt_W37p3_L0p74_m1__nf1_gboth_sdfull_pc/B.n501 pfet_01v8_lvt_W37p3_L0p74_m1__nf1_gboth_sdfull_pc/B.n500 25.6005
R783 pfet_01v8_lvt_W37p3_L0p74_m1__nf1_gboth_sdfull_pc/B.n503 pfet_01v8_lvt_W37p3_L0p74_m1__nf1_gboth_sdfull_pc/B.n501 25.6005
R784 pfet_01v8_lvt_W37p3_L0p74_m1__nf1_gboth_sdfull_pc/B.n504 pfet_01v8_lvt_W37p3_L0p74_m1__nf1_gboth_sdfull_pc/B.n503 25.6005
R785 pfet_01v8_lvt_W37p3_L0p74_m1__nf1_gboth_sdfull_pc/B.n507 pfet_01v8_lvt_W37p3_L0p74_m1__nf1_gboth_sdfull_pc/B.n504 25.6005
R786 pfet_01v8_lvt_W37p3_L0p74_m1__nf1_gboth_sdfull_pc/B.n509 pfet_01v8_lvt_W37p3_L0p74_m1__nf1_gboth_sdfull_pc/B.n507 25.6005
R787 pfet_01v8_lvt_W37p3_L0p74_m1__nf1_gboth_sdfull_pc/B.n510 pfet_01v8_lvt_W37p3_L0p74_m1__nf1_gboth_sdfull_pc/B.n509 25.6005
R788 pfet_01v8_lvt_W37p3_L0p74_m1__nf1_gboth_sdfull_pc/B.n512 pfet_01v8_lvt_W37p3_L0p74_m1__nf1_gboth_sdfull_pc/B.n510 25.6005
R789 pfet_01v8_lvt_W37p3_L0p74_m1__nf1_gboth_sdfull_pc/B.n514 pfet_01v8_lvt_W37p3_L0p74_m1__nf1_gboth_sdfull_pc/B.n512 25.6005
R790 pfet_01v8_lvt_W37p3_L0p74_m1__nf1_gboth_sdfull_pc/B.n515 pfet_01v8_lvt_W37p3_L0p74_m1__nf1_gboth_sdfull_pc/B.n514 25.6005
R791 pfet_01v8_lvt_W37p3_L0p74_m1__nf1_gboth_sdfull_pc/B.n517 pfet_01v8_lvt_W37p3_L0p74_m1__nf1_gboth_sdfull_pc/B.n515 25.6005
R792 pfet_01v8_lvt_W37p3_L0p74_m1__nf1_gboth_sdfull_pc/B.n518 pfet_01v8_lvt_W37p3_L0p74_m1__nf1_gboth_sdfull_pc/B.n517 25.6005
R793 pfet_01v8_lvt_W37p3_L0p74_m1__nf1_gboth_sdfull_pc/B.n521 pfet_01v8_lvt_W37p3_L0p74_m1__nf1_gboth_sdfull_pc/B.n518 25.6005
R794 pfet_01v8_lvt_W37p3_L0p74_m1__nf1_gboth_sdfull_pc/B.n522 pfet_01v8_lvt_W37p3_L0p74_m1__nf1_gboth_sdfull_pc/B.n521 25.6005
R795 pfet_01v8_lvt_W37p3_L0p74_m1__nf1_gboth_sdfull_pc/B.n525 pfet_01v8_lvt_W37p3_L0p74_m1__nf1_gboth_sdfull_pc/B.n522 25.6005
R796 pfet_01v8_lvt_W37p3_L0p74_m1__nf1_gboth_sdfull_pc/B.n526 pfet_01v8_lvt_W37p3_L0p74_m1__nf1_gboth_sdfull_pc/B.n525 25.6005
R797 pfet_01v8_lvt_W37p3_L0p74_m1__nf1_gboth_sdfull_pc/B.n529 pfet_01v8_lvt_W37p3_L0p74_m1__nf1_gboth_sdfull_pc/B.n526 25.6005
R798 pfet_01v8_lvt_W37p3_L0p74_m1__nf1_gboth_sdfull_pc/B.n530 pfet_01v8_lvt_W37p3_L0p74_m1__nf1_gboth_sdfull_pc/B.n529 25.6005
R799 pfet_01v8_lvt_W37p3_L0p74_m1__nf1_gboth_sdfull_pc/B.n533 pfet_01v8_lvt_W37p3_L0p74_m1__nf1_gboth_sdfull_pc/B.n530 25.6005
R800 pfet_01v8_lvt_W37p3_L0p74_m1__nf1_gboth_sdfull_pc/B.n535 pfet_01v8_lvt_W37p3_L0p74_m1__nf1_gboth_sdfull_pc/B.n533 25.6005
R801 pfet_01v8_lvt_W37p3_L0p74_m1__nf1_gboth_sdfull_pc/B.n536 pfet_01v8_lvt_W37p3_L0p74_m1__nf1_gboth_sdfull_pc/B.n535 25.6005
R802 pfet_01v8_lvt_W37p3_L0p74_m1__nf1_gboth_sdfull_pc/B.n538 pfet_01v8_lvt_W37p3_L0p74_m1__nf1_gboth_sdfull_pc/B.n536 25.6005
R803 pfet_01v8_lvt_W37p3_L0p74_m1__nf1_gboth_sdfull_pc/B.n540 pfet_01v8_lvt_W37p3_L0p74_m1__nf1_gboth_sdfull_pc/B.n538 25.6005
R804 pfet_01v8_lvt_W37p3_L0p74_m1__nf1_gboth_sdfull_pc/B.n541 pfet_01v8_lvt_W37p3_L0p74_m1__nf1_gboth_sdfull_pc/B.n540 25.6005
R805 pfet_01v8_lvt_W37p3_L0p74_m1__nf1_gboth_sdfull_pc/B.n543 pfet_01v8_lvt_W37p3_L0p74_m1__nf1_gboth_sdfull_pc/B.n541 25.6005
R806 pfet_01v8_lvt_W37p3_L0p74_m1__nf1_gboth_sdfull_pc/B.n545 pfet_01v8_lvt_W37p3_L0p74_m1__nf1_gboth_sdfull_pc/B.n543 25.6005
R807 pfet_01v8_lvt_W37p3_L0p74_m1__nf1_gboth_sdfull_pc/B.n546 pfet_01v8_lvt_W37p3_L0p74_m1__nf1_gboth_sdfull_pc/B.n545 25.6005
R808 pfet_01v8_lvt_W37p3_L0p74_m1__nf1_gboth_sdfull_pc/B.n548 pfet_01v8_lvt_W37p3_L0p74_m1__nf1_gboth_sdfull_pc/B.n546 25.6005
R809 pfet_01v8_lvt_W37p3_L0p74_m1__nf1_gboth_sdfull_pc/B.n550 pfet_01v8_lvt_W37p3_L0p74_m1__nf1_gboth_sdfull_pc/B.n548 25.6005
R810 pfet_01v8_lvt_W37p3_L0p74_m1__nf1_gboth_sdfull_pc/B.n551 pfet_01v8_lvt_W37p3_L0p74_m1__nf1_gboth_sdfull_pc/B.n550 25.6005
R811 pfet_01v8_lvt_W37p3_L0p74_m1__nf1_gboth_sdfull_pc/B.n553 pfet_01v8_lvt_W37p3_L0p74_m1__nf1_gboth_sdfull_pc/B.n551 25.6005
R812 pfet_01v8_lvt_W37p3_L0p74_m1__nf1_gboth_sdfull_pc/B.n554 pfet_01v8_lvt_W37p3_L0p74_m1__nf1_gboth_sdfull_pc/B.n553 25.6005
R813 pfet_01v8_lvt_W37p3_L0p74_m1__nf1_gboth_sdfull_pc/B.n555 pfet_01v8_lvt_W37p3_L0p74_m1__nf1_gboth_sdfull_pc/B.n554 25.6005
R814 pfet_01v8_lvt_W37p3_L0p74_m1__nf1_gboth_sdfull_pc/B.n555 pfet_01v8_lvt_W37p3_L0p74_m1__nf1_gboth_sdfull_pc/B.n364 25.6005
R815 pfet_01v8_lvt_W37p3_L0p74_m1__nf1_gboth_sdfull_pc/B.n364 pfet_01v8_lvt_W37p3_L0p74_m1__nf1_gboth_sdfull_pc/B.n363 25.6005
R816 pfet_01v8_lvt_W37p3_L0p74_m1__nf1_gboth_sdfull_pc/B.n363 pfet_01v8_lvt_W37p3_L0p74_m1__nf1_gboth_sdfull_pc/B.n360 25.6005
R817 pfet_01v8_lvt_W37p3_L0p74_m1__nf1_gboth_sdfull_pc/B.n360 pfet_01v8_lvt_W37p3_L0p74_m1__nf1_gboth_sdfull_pc/B.n359 25.6005
R818 pfet_01v8_lvt_W37p3_L0p74_m1__nf1_gboth_sdfull_pc/B.n359 pfet_01v8_lvt_W37p3_L0p74_m1__nf1_gboth_sdfull_pc/B.n290 25.6005
R819 pfet_01v8_lvt_W37p3_L0p74_m1__nf1_gboth_sdfull_pc/B.n560 pfet_01v8_lvt_W37p3_L0p74_m1__nf1_gboth_sdfull_pc/B.n290 25.6005
R820 pfet_01v8_lvt_W37p3_L0p74_m1__nf1_gboth_sdfull_pc/B.n562 pfet_01v8_lvt_W37p3_L0p74_m1__nf1_gboth_sdfull_pc/B.n561 25.6005
R821 pfet_01v8_lvt_W37p3_L0p74_m1__nf1_gboth_sdfull_pc/B.n562 pfet_01v8_lvt_W37p3_L0p74_m1__nf1_gboth_sdfull_pc/B.n289 25.6005
R822 pfet_01v8_lvt_W37p3_L0p74_m1__nf1_gboth_sdfull_pc/B.n289 pfet_01v8_lvt_W37p3_L0p74_m1__nf1_gboth_sdfull_pc/B.n288 25.6005
R823 pfet_01v8_lvt_W37p3_L0p74_m1__nf1_gboth_sdfull_pc/B.n282 pfet_01v8_lvt_W37p3_L0p74_m1__nf1_gboth_sdfull_pc/B.n281 25.6005
R824 pfet_01v8_lvt_W37p3_L0p74_m1__nf1_gboth_sdfull_pc/B.n281 pfet_01v8_lvt_W37p3_L0p74_m1__nf1_gboth_sdfull_pc/B.n11 25.6005
R825 pfet_01v8_lvt_W37p3_L0p74_m1__nf1_gboth_sdfull_pc/B.n275 pfet_01v8_lvt_W37p3_L0p74_m1__nf1_gboth_sdfull_pc/B.n11 25.6005
R826 pfet_01v8_lvt_W37p3_L0p74_m1__nf1_gboth_sdfull_pc/B.n275 pfet_01v8_lvt_W37p3_L0p74_m1__nf1_gboth_sdfull_pc/B.n274 25.6005
R827 pfet_01v8_lvt_W37p3_L0p74_m1__nf1_gboth_sdfull_pc/B.n274 pfet_01v8_lvt_W37p3_L0p74_m1__nf1_gboth_sdfull_pc/B.n273 25.6005
R828 pfet_01v8_lvt_W37p3_L0p74_m1__nf1_gboth_sdfull_pc/B.n273 pfet_01v8_lvt_W37p3_L0p74_m1__nf1_gboth_sdfull_pc/B.n13 25.6005
R829 pfet_01v8_lvt_W37p3_L0p74_m1__nf1_gboth_sdfull_pc/B.n268 pfet_01v8_lvt_W37p3_L0p74_m1__nf1_gboth_sdfull_pc/B.n13 25.6005
R830 pfet_01v8_lvt_W37p3_L0p74_m1__nf1_gboth_sdfull_pc/B.n268 pfet_01v8_lvt_W37p3_L0p74_m1__nf1_gboth_sdfull_pc/B.n267 25.6005
R831 pfet_01v8_lvt_W37p3_L0p74_m1__nf1_gboth_sdfull_pc/B.n267 pfet_01v8_lvt_W37p3_L0p74_m1__nf1_gboth_sdfull_pc/B.n15 25.6005
R832 pfet_01v8_lvt_W37p3_L0p74_m1__nf1_gboth_sdfull_pc/B.n263 pfet_01v8_lvt_W37p3_L0p74_m1__nf1_gboth_sdfull_pc/B.n15 25.6005
R833 pfet_01v8_lvt_W37p3_L0p74_m1__nf1_gboth_sdfull_pc/B.n263 pfet_01v8_lvt_W37p3_L0p74_m1__nf1_gboth_sdfull_pc/B.n262 25.6005
R834 pfet_01v8_lvt_W37p3_L0p74_m1__nf1_gboth_sdfull_pc/B.n262 pfet_01v8_lvt_W37p3_L0p74_m1__nf1_gboth_sdfull_pc/B.n17 25.6005
R835 pfet_01v8_lvt_W37p3_L0p74_m1__nf1_gboth_sdfull_pc/B.n257 pfet_01v8_lvt_W37p3_L0p74_m1__nf1_gboth_sdfull_pc/B.n17 25.6005
R836 pfet_01v8_lvt_W37p3_L0p74_m1__nf1_gboth_sdfull_pc/B.n257 pfet_01v8_lvt_W37p3_L0p74_m1__nf1_gboth_sdfull_pc/B.n256 25.6005
R837 pfet_01v8_lvt_W37p3_L0p74_m1__nf1_gboth_sdfull_pc/B.n256 pfet_01v8_lvt_W37p3_L0p74_m1__nf1_gboth_sdfull_pc/B.n255 25.6005
R838 pfet_01v8_lvt_W37p3_L0p74_m1__nf1_gboth_sdfull_pc/B.n255 pfet_01v8_lvt_W37p3_L0p74_m1__nf1_gboth_sdfull_pc/B.n19 25.6005
R839 pfet_01v8_lvt_W37p3_L0p74_m1__nf1_gboth_sdfull_pc/B.n249 pfet_01v8_lvt_W37p3_L0p74_m1__nf1_gboth_sdfull_pc/B.n19 25.6005
R840 pfet_01v8_lvt_W37p3_L0p74_m1__nf1_gboth_sdfull_pc/B.n249 pfet_01v8_lvt_W37p3_L0p74_m1__nf1_gboth_sdfull_pc/B.n248 25.6005
R841 pfet_01v8_lvt_W37p3_L0p74_m1__nf1_gboth_sdfull_pc/B.n248 pfet_01v8_lvt_W37p3_L0p74_m1__nf1_gboth_sdfull_pc/B.n247 25.6005
R842 pfet_01v8_lvt_W37p3_L0p74_m1__nf1_gboth_sdfull_pc/B.n247 pfet_01v8_lvt_W37p3_L0p74_m1__nf1_gboth_sdfull_pc/B.n21 25.6005
R843 pfet_01v8_lvt_W37p3_L0p74_m1__nf1_gboth_sdfull_pc/B.n242 pfet_01v8_lvt_W37p3_L0p74_m1__nf1_gboth_sdfull_pc/B.n21 25.6005
R844 pfet_01v8_lvt_W37p3_L0p74_m1__nf1_gboth_sdfull_pc/B.n242 pfet_01v8_lvt_W37p3_L0p74_m1__nf1_gboth_sdfull_pc/B.n241 25.6005
R845 pfet_01v8_lvt_W37p3_L0p74_m1__nf1_gboth_sdfull_pc/B.n241 pfet_01v8_lvt_W37p3_L0p74_m1__nf1_gboth_sdfull_pc/B.n23 25.6005
R846 pfet_01v8_lvt_W37p3_L0p74_m1__nf1_gboth_sdfull_pc/B.n236 pfet_01v8_lvt_W37p3_L0p74_m1__nf1_gboth_sdfull_pc/B.n23 25.6005
R847 pfet_01v8_lvt_W37p3_L0p74_m1__nf1_gboth_sdfull_pc/B.n236 pfet_01v8_lvt_W37p3_L0p74_m1__nf1_gboth_sdfull_pc/B.n235 25.6005
R848 pfet_01v8_lvt_W37p3_L0p74_m1__nf1_gboth_sdfull_pc/B.n235 pfet_01v8_lvt_W37p3_L0p74_m1__nf1_gboth_sdfull_pc/B.n234 25.6005
R849 pfet_01v8_lvt_W37p3_L0p74_m1__nf1_gboth_sdfull_pc/B.n234 pfet_01v8_lvt_W37p3_L0p74_m1__nf1_gboth_sdfull_pc/B.n25 25.6005
R850 pfet_01v8_lvt_W37p3_L0p74_m1__nf1_gboth_sdfull_pc/B.n228 pfet_01v8_lvt_W37p3_L0p74_m1__nf1_gboth_sdfull_pc/B.n25 25.6005
R851 pfet_01v8_lvt_W37p3_L0p74_m1__nf1_gboth_sdfull_pc/B.n228 pfet_01v8_lvt_W37p3_L0p74_m1__nf1_gboth_sdfull_pc/B.n227 25.6005
R852 pfet_01v8_lvt_W37p3_L0p74_m1__nf1_gboth_sdfull_pc/B.n227 pfet_01v8_lvt_W37p3_L0p74_m1__nf1_gboth_sdfull_pc/B.n226 25.6005
R853 pfet_01v8_lvt_W37p3_L0p74_m1__nf1_gboth_sdfull_pc/B.n226 pfet_01v8_lvt_W37p3_L0p74_m1__nf1_gboth_sdfull_pc/B.n27 25.6005
R854 pfet_01v8_lvt_W37p3_L0p74_m1__nf1_gboth_sdfull_pc/B.n220 pfet_01v8_lvt_W37p3_L0p74_m1__nf1_gboth_sdfull_pc/B.n27 25.6005
R855 pfet_01v8_lvt_W37p3_L0p74_m1__nf1_gboth_sdfull_pc/B.n220 pfet_01v8_lvt_W37p3_L0p74_m1__nf1_gboth_sdfull_pc/B.n219 25.6005
R856 pfet_01v8_lvt_W37p3_L0p74_m1__nf1_gboth_sdfull_pc/B.n219 pfet_01v8_lvt_W37p3_L0p74_m1__nf1_gboth_sdfull_pc/B.n218 25.6005
R857 pfet_01v8_lvt_W37p3_L0p74_m1__nf1_gboth_sdfull_pc/B.n218 pfet_01v8_lvt_W37p3_L0p74_m1__nf1_gboth_sdfull_pc/B.n29 25.6005
R858 pfet_01v8_lvt_W37p3_L0p74_m1__nf1_gboth_sdfull_pc/B.n212 pfet_01v8_lvt_W37p3_L0p74_m1__nf1_gboth_sdfull_pc/B.n29 25.6005
R859 pfet_01v8_lvt_W37p3_L0p74_m1__nf1_gboth_sdfull_pc/B.n212 pfet_01v8_lvt_W37p3_L0p74_m1__nf1_gboth_sdfull_pc/B.n211 25.6005
R860 pfet_01v8_lvt_W37p3_L0p74_m1__nf1_gboth_sdfull_pc/B.n211 pfet_01v8_lvt_W37p3_L0p74_m1__nf1_gboth_sdfull_pc/B.n210 25.6005
R861 pfet_01v8_lvt_W37p3_L0p74_m1__nf1_gboth_sdfull_pc/B.n210 pfet_01v8_lvt_W37p3_L0p74_m1__nf1_gboth_sdfull_pc/B.n31 25.6005
R862 pfet_01v8_lvt_W37p3_L0p74_m1__nf1_gboth_sdfull_pc/B.n205 pfet_01v8_lvt_W37p3_L0p74_m1__nf1_gboth_sdfull_pc/B.n31 25.6005
R863 pfet_01v8_lvt_W37p3_L0p74_m1__nf1_gboth_sdfull_pc/B.n205 pfet_01v8_lvt_W37p3_L0p74_m1__nf1_gboth_sdfull_pc/B.n204 25.6005
R864 pfet_01v8_lvt_W37p3_L0p74_m1__nf1_gboth_sdfull_pc/B.n204 pfet_01v8_lvt_W37p3_L0p74_m1__nf1_gboth_sdfull_pc/B.n33 25.6005
R865 pfet_01v8_lvt_W37p3_L0p74_m1__nf1_gboth_sdfull_pc/B.n199 pfet_01v8_lvt_W37p3_L0p74_m1__nf1_gboth_sdfull_pc/B.n33 25.6005
R866 pfet_01v8_lvt_W37p3_L0p74_m1__nf1_gboth_sdfull_pc/B.n199 pfet_01v8_lvt_W37p3_L0p74_m1__nf1_gboth_sdfull_pc/B.n198 25.6005
R867 pfet_01v8_lvt_W37p3_L0p74_m1__nf1_gboth_sdfull_pc/B.n198 pfet_01v8_lvt_W37p3_L0p74_m1__nf1_gboth_sdfull_pc/B.n197 25.6005
R868 pfet_01v8_lvt_W37p3_L0p74_m1__nf1_gboth_sdfull_pc/B.n197 pfet_01v8_lvt_W37p3_L0p74_m1__nf1_gboth_sdfull_pc/B.n35 25.6005
R869 pfet_01v8_lvt_W37p3_L0p74_m1__nf1_gboth_sdfull_pc/B.n192 pfet_01v8_lvt_W37p3_L0p74_m1__nf1_gboth_sdfull_pc/B.n35 25.6005
R870 pfet_01v8_lvt_W37p3_L0p74_m1__nf1_gboth_sdfull_pc/B.n192 pfet_01v8_lvt_W37p3_L0p74_m1__nf1_gboth_sdfull_pc/B.n191 25.6005
R871 pfet_01v8_lvt_W37p3_L0p74_m1__nf1_gboth_sdfull_pc/B.n191 pfet_01v8_lvt_W37p3_L0p74_m1__nf1_gboth_sdfull_pc/B.n37 25.6005
R872 pfet_01v8_lvt_W37p3_L0p74_m1__nf1_gboth_sdfull_pc/B.n186 pfet_01v8_lvt_W37p3_L0p74_m1__nf1_gboth_sdfull_pc/B.n37 25.6005
R873 pfet_01v8_lvt_W37p3_L0p74_m1__nf1_gboth_sdfull_pc/B.n186 pfet_01v8_lvt_W37p3_L0p74_m1__nf1_gboth_sdfull_pc/B.n185 25.6005
R874 pfet_01v8_lvt_W37p3_L0p74_m1__nf1_gboth_sdfull_pc/B.n185 pfet_01v8_lvt_W37p3_L0p74_m1__nf1_gboth_sdfull_pc/B.n184 25.6005
R875 pfet_01v8_lvt_W37p3_L0p74_m1__nf1_gboth_sdfull_pc/B.n184 pfet_01v8_lvt_W37p3_L0p74_m1__nf1_gboth_sdfull_pc/B.n39 25.6005
R876 pfet_01v8_lvt_W37p3_L0p74_m1__nf1_gboth_sdfull_pc/B.n178 pfet_01v8_lvt_W37p3_L0p74_m1__nf1_gboth_sdfull_pc/B.n39 25.6005
R877 pfet_01v8_lvt_W37p3_L0p74_m1__nf1_gboth_sdfull_pc/B.n178 pfet_01v8_lvt_W37p3_L0p74_m1__nf1_gboth_sdfull_pc/B.n177 25.6005
R878 pfet_01v8_lvt_W37p3_L0p74_m1__nf1_gboth_sdfull_pc/B.n177 pfet_01v8_lvt_W37p3_L0p74_m1__nf1_gboth_sdfull_pc/B.n176 25.6005
R879 pfet_01v8_lvt_W37p3_L0p74_m1__nf1_gboth_sdfull_pc/B.n176 pfet_01v8_lvt_W37p3_L0p74_m1__nf1_gboth_sdfull_pc/B.n41 25.6005
R880 pfet_01v8_lvt_W37p3_L0p74_m1__nf1_gboth_sdfull_pc/B.n170 pfet_01v8_lvt_W37p3_L0p74_m1__nf1_gboth_sdfull_pc/B.n41 25.6005
R881 pfet_01v8_lvt_W37p3_L0p74_m1__nf1_gboth_sdfull_pc/B.n170 pfet_01v8_lvt_W37p3_L0p74_m1__nf1_gboth_sdfull_pc/B.n169 25.6005
R882 pfet_01v8_lvt_W37p3_L0p74_m1__nf1_gboth_sdfull_pc/B.n169 pfet_01v8_lvt_W37p3_L0p74_m1__nf1_gboth_sdfull_pc/B.n168 25.6005
R883 pfet_01v8_lvt_W37p3_L0p74_m1__nf1_gboth_sdfull_pc/B.n168 pfet_01v8_lvt_W37p3_L0p74_m1__nf1_gboth_sdfull_pc/B.n43 25.6005
R884 pfet_01v8_lvt_W37p3_L0p74_m1__nf1_gboth_sdfull_pc/B.n162 pfet_01v8_lvt_W37p3_L0p74_m1__nf1_gboth_sdfull_pc/B.n43 25.6005
R885 pfet_01v8_lvt_W37p3_L0p74_m1__nf1_gboth_sdfull_pc/B.n162 pfet_01v8_lvt_W37p3_L0p74_m1__nf1_gboth_sdfull_pc/B.n161 25.6005
R886 pfet_01v8_lvt_W37p3_L0p74_m1__nf1_gboth_sdfull_pc/B.n161 pfet_01v8_lvt_W37p3_L0p74_m1__nf1_gboth_sdfull_pc/B.n160 25.6005
R887 pfet_01v8_lvt_W37p3_L0p74_m1__nf1_gboth_sdfull_pc/B.n160 pfet_01v8_lvt_W37p3_L0p74_m1__nf1_gboth_sdfull_pc/B.n45 25.6005
R888 pfet_01v8_lvt_W37p3_L0p74_m1__nf1_gboth_sdfull_pc/B.n154 pfet_01v8_lvt_W37p3_L0p74_m1__nf1_gboth_sdfull_pc/B.n45 25.6005
R889 pfet_01v8_lvt_W37p3_L0p74_m1__nf1_gboth_sdfull_pc/B.n154 pfet_01v8_lvt_W37p3_L0p74_m1__nf1_gboth_sdfull_pc/B.n153 25.6005
R890 pfet_01v8_lvt_W37p3_L0p74_m1__nf1_gboth_sdfull_pc/B.n153 pfet_01v8_lvt_W37p3_L0p74_m1__nf1_gboth_sdfull_pc/B.n152 25.6005
R891 pfet_01v8_lvt_W37p3_L0p74_m1__nf1_gboth_sdfull_pc/B.n152 pfet_01v8_lvt_W37p3_L0p74_m1__nf1_gboth_sdfull_pc/B.n47 25.6005
R892 pfet_01v8_lvt_W37p3_L0p74_m1__nf1_gboth_sdfull_pc/B.n147 pfet_01v8_lvt_W37p3_L0p74_m1__nf1_gboth_sdfull_pc/B.n47 25.6005
R893 pfet_01v8_lvt_W37p3_L0p74_m1__nf1_gboth_sdfull_pc/B.n147 pfet_01v8_lvt_W37p3_L0p74_m1__nf1_gboth_sdfull_pc/B.n146 25.6005
R894 pfet_01v8_lvt_W37p3_L0p74_m1__nf1_gboth_sdfull_pc/B.n146 pfet_01v8_lvt_W37p3_L0p74_m1__nf1_gboth_sdfull_pc/B.n49 25.6005
R895 pfet_01v8_lvt_W37p3_L0p74_m1__nf1_gboth_sdfull_pc/B.n141 pfet_01v8_lvt_W37p3_L0p74_m1__nf1_gboth_sdfull_pc/B.n49 25.6005
R896 pfet_01v8_lvt_W37p3_L0p74_m1__nf1_gboth_sdfull_pc/B.n141 pfet_01v8_lvt_W37p3_L0p74_m1__nf1_gboth_sdfull_pc/B.n140 25.6005
R897 pfet_01v8_lvt_W37p3_L0p74_m1__nf1_gboth_sdfull_pc/B.n140 pfet_01v8_lvt_W37p3_L0p74_m1__nf1_gboth_sdfull_pc/B.n139 25.6005
R898 pfet_01v8_lvt_W37p3_L0p74_m1__nf1_gboth_sdfull_pc/B.n139 pfet_01v8_lvt_W37p3_L0p74_m1__nf1_gboth_sdfull_pc/B.n51 25.6005
R899 pfet_01v8_lvt_W37p3_L0p74_m1__nf1_gboth_sdfull_pc/B.n52 pfet_01v8_lvt_W37p3_L0p74_m1__nf1_gboth_sdfull_pc/B.n51 25.6005
R900 pfet_01v8_lvt_W37p3_L0p74_m1__nf1_gboth_sdfull_pc/B.n132 pfet_01v8_lvt_W37p3_L0p74_m1__nf1_gboth_sdfull_pc/B.n52 25.6005
R901 pfet_01v8_lvt_W37p3_L0p74_m1__nf1_gboth_sdfull_pc/B.n132 pfet_01v8_lvt_W37p3_L0p74_m1__nf1_gboth_sdfull_pc/B.n131 25.6005
R902 pfet_01v8_lvt_W37p3_L0p74_m1__nf1_gboth_sdfull_pc/B.n131 pfet_01v8_lvt_W37p3_L0p74_m1__nf1_gboth_sdfull_pc/B.n130 25.6005
R903 pfet_01v8_lvt_W37p3_L0p74_m1__nf1_gboth_sdfull_pc/B.n130 pfet_01v8_lvt_W37p3_L0p74_m1__nf1_gboth_sdfull_pc/B.n54 25.6005
R904 pfet_01v8_lvt_W37p3_L0p74_m1__nf1_gboth_sdfull_pc/B.n125 pfet_01v8_lvt_W37p3_L0p74_m1__nf1_gboth_sdfull_pc/B.n54 25.6005
R905 pfet_01v8_lvt_W37p3_L0p74_m1__nf1_gboth_sdfull_pc/B.n125 pfet_01v8_lvt_W37p3_L0p74_m1__nf1_gboth_sdfull_pc/B.n124 25.6005
R906 pfet_01v8_lvt_W37p3_L0p74_m1__nf1_gboth_sdfull_pc/B.n124 pfet_01v8_lvt_W37p3_L0p74_m1__nf1_gboth_sdfull_pc/B.n56 25.6005
R907 pfet_01v8_lvt_W37p3_L0p74_m1__nf1_gboth_sdfull_pc/B.n119 pfet_01v8_lvt_W37p3_L0p74_m1__nf1_gboth_sdfull_pc/B.n56 25.6005
R908 pfet_01v8_lvt_W37p3_L0p74_m1__nf1_gboth_sdfull_pc/B.n119 pfet_01v8_lvt_W37p3_L0p74_m1__nf1_gboth_sdfull_pc/B.n118 25.6005
R909 pfet_01v8_lvt_W37p3_L0p74_m1__nf1_gboth_sdfull_pc/B.n118 pfet_01v8_lvt_W37p3_L0p74_m1__nf1_gboth_sdfull_pc/B.n117 25.6005
R910 pfet_01v8_lvt_W37p3_L0p74_m1__nf1_gboth_sdfull_pc/B.n117 pfet_01v8_lvt_W37p3_L0p74_m1__nf1_gboth_sdfull_pc/B.n58 25.6005
R911 pfet_01v8_lvt_W37p3_L0p74_m1__nf1_gboth_sdfull_pc/B.n112 pfet_01v8_lvt_W37p3_L0p74_m1__nf1_gboth_sdfull_pc/B.n58 25.6005
R912 pfet_01v8_lvt_W37p3_L0p74_m1__nf1_gboth_sdfull_pc/B.n112 pfet_01v8_lvt_W37p3_L0p74_m1__nf1_gboth_sdfull_pc/B.n111 25.6005
R913 pfet_01v8_lvt_W37p3_L0p74_m1__nf1_gboth_sdfull_pc/B.n111 pfet_01v8_lvt_W37p3_L0p74_m1__nf1_gboth_sdfull_pc/B.n60 25.6005
R914 pfet_01v8_lvt_W37p3_L0p74_m1__nf1_gboth_sdfull_pc/B.n106 pfet_01v8_lvt_W37p3_L0p74_m1__nf1_gboth_sdfull_pc/B.n60 25.6005
R915 pfet_01v8_lvt_W37p3_L0p74_m1__nf1_gboth_sdfull_pc/B.n106 pfet_01v8_lvt_W37p3_L0p74_m1__nf1_gboth_sdfull_pc/B.n105 25.6005
R916 pfet_01v8_lvt_W37p3_L0p74_m1__nf1_gboth_sdfull_pc/B.n105 pfet_01v8_lvt_W37p3_L0p74_m1__nf1_gboth_sdfull_pc/B.n104 25.6005
R917 pfet_01v8_lvt_W37p3_L0p74_m1__nf1_gboth_sdfull_pc/B.n104 pfet_01v8_lvt_W37p3_L0p74_m1__nf1_gboth_sdfull_pc/B.n62 25.6005
R918 pfet_01v8_lvt_W37p3_L0p74_m1__nf1_gboth_sdfull_pc/B.n98 pfet_01v8_lvt_W37p3_L0p74_m1__nf1_gboth_sdfull_pc/B.n62 25.6005
R919 pfet_01v8_lvt_W37p3_L0p74_m1__nf1_gboth_sdfull_pc/B.n98 pfet_01v8_lvt_W37p3_L0p74_m1__nf1_gboth_sdfull_pc/B.n97 25.6005
R920 pfet_01v8_lvt_W37p3_L0p74_m1__nf1_gboth_sdfull_pc/B.n97 pfet_01v8_lvt_W37p3_L0p74_m1__nf1_gboth_sdfull_pc/B.n96 25.6005
R921 pfet_01v8_lvt_W37p3_L0p74_m1__nf1_gboth_sdfull_pc/B.n96 pfet_01v8_lvt_W37p3_L0p74_m1__nf1_gboth_sdfull_pc/B.n64 25.6005
R922 pfet_01v8_lvt_W37p3_L0p74_m1__nf1_gboth_sdfull_pc/B.n90 pfet_01v8_lvt_W37p3_L0p74_m1__nf1_gboth_sdfull_pc/B.n64 25.6005
R923 pfet_01v8_lvt_W37p3_L0p74_m1__nf1_gboth_sdfull_pc/B.n90 pfet_01v8_lvt_W37p3_L0p74_m1__nf1_gboth_sdfull_pc/B.n89 25.6005
R924 pfet_01v8_lvt_W37p3_L0p74_m1__nf1_gboth_sdfull_pc/B.n89 pfet_01v8_lvt_W37p3_L0p74_m1__nf1_gboth_sdfull_pc/B.n88 25.6005
R925 pfet_01v8_lvt_W37p3_L0p74_m1__nf1_gboth_sdfull_pc/B.n88 pfet_01v8_lvt_W37p3_L0p74_m1__nf1_gboth_sdfull_pc/B.n66 25.6005
R926 pfet_01v8_lvt_W37p3_L0p74_m1__nf1_gboth_sdfull_pc/B.n83 pfet_01v8_lvt_W37p3_L0p74_m1__nf1_gboth_sdfull_pc/B.n66 25.6005
R927 pfet_01v8_lvt_W37p3_L0p74_m1__nf1_gboth_sdfull_pc/B.n83 pfet_01v8_lvt_W37p3_L0p74_m1__nf1_gboth_sdfull_pc/B.n82 25.6005
R928 pfet_01v8_lvt_W37p3_L0p74_m1__nf1_gboth_sdfull_pc/B.n82 pfet_01v8_lvt_W37p3_L0p74_m1__nf1_gboth_sdfull_pc/B.n68 25.6005
R929 pfet_01v8_lvt_W37p3_L0p74_m1__nf1_gboth_sdfull_pc/B.n77 pfet_01v8_lvt_W37p3_L0p74_m1__nf1_gboth_sdfull_pc/B.n68 25.6005
R930 pfet_01v8_lvt_W37p3_L0p74_m1__nf1_gboth_sdfull_pc/B.n77 pfet_01v8_lvt_W37p3_L0p74_m1__nf1_gboth_sdfull_pc/B.n76 25.6005
R931 pfet_01v8_lvt_W37p3_L0p74_m1__nf1_gboth_sdfull_pc/B.n76 pfet_01v8_lvt_W37p3_L0p74_m1__nf1_gboth_sdfull_pc/B.n75 25.6005
R932 pfet_01v8_lvt_W37p3_L0p74_m1__nf1_gboth_sdfull_pc/B.n75 pfet_01v8_lvt_W37p3_L0p74_m1__nf1_gboth_sdfull_pc/B.n70 25.6005
R933 pfet_01v8_lvt_W37p3_L0p74_m1__nf1_gboth_sdfull_pc/B.n70 pfet_01v8_lvt_W37p3_L0p74_m1__nf1_gboth_sdfull_pc/B.n7 25.6005
R934 pfet_01v8_lvt_W37p3_L0p74_m1__nf1_gboth_sdfull_pc/B.n557 pfet_01v8_lvt_W37p3_L0p74_m1__nf1_gboth_sdfull_pc/B.n4 13.8331
R935 pfet_01v8_lvt_W37p3_L0p74_m1__nf1_gboth_sdfull_pc/B.n286 pfet_01v8_lvt_W37p3_L0p74_m1__nf1_gboth_sdfull_pc/B.n9 13.8331
R936 B pfet_01v8_lvt_W37p3_L0p74_m1__nf1_gboth_sdfull_pc/B.n0 12.8005
R937 pfet_01v8_lvt_W37p3_L0p74_m1__nf1_gboth_sdfull_pc/B.n564 pfet_01v8_lvt_W37p3_L0p74_m1__nf1_gboth_sdfull_pc/B.n4 8.17979
R938 pfet_01v8_lvt_W37p3_L0p74_m1__nf1_gboth_sdfull_pc/B.n286 pfet_01v8_lvt_W37p3_L0p74_m1__nf1_gboth_sdfull_pc/B.n285 8.17979
R939 B pfet_01v8_lvt_W37p3_L0p74_m1__nf1_gboth_sdfull_pc/B.n566 6.4005
R940 pfet_01v8_lvt_W37p3_L0p74_m1__nf1_gboth_sdfull_pc/B.n564 pfet_01v8_lvt_W37p3_L0p74_m1__nf1_gboth_sdfull_pc/B.t0 4.09014
R941 pfet_01v8_lvt_W37p3_L0p74_m1__nf1_gboth_sdfull_pc/B.n285 pfet_01v8_lvt_W37p3_L0p74_m1__nf1_gboth_sdfull_pc/B.t0 4.09014
R942 B.n575 B.n8 776.471
R943 B.n578 B.n577 776.471
R944 B.n238 B.n228 776.471
R945 B.n233 B.n226 776.471
R946 B.n575 B.n6 240
R947 B.n569 B.n6 240
R948 B.n569 B.n10 240
R949 B.n560 B.n10 240
R950 B.n560 B.n16 240
R951 B.n556 B.n16 240
R952 B.n556 B.n18 240
R953 B.n548 B.n18 240
R954 B.n548 B.n24 240
R955 B.n544 B.n24 240
R956 B.n544 B.n26 240
R957 B.n536 B.n26 240
R958 B.n536 B.n32 240
R959 B.n532 B.n32 240
R960 B.n532 B.n34 240
R961 B.n524 B.n34 240
R962 B.n524 B.n40 240
R963 B.n520 B.n40 240
R964 B.n520 B.n42 240
R965 B.n512 B.n42 240
R966 B.n512 B.n48 240
R967 B.n508 B.n48 240
R968 B.n508 B.n50 240
R969 B.n500 B.n50 240
R970 B.n500 B.n56 240
R971 B.n496 B.n56 240
R972 B.n496 B.n58 240
R973 B.n488 B.n58 240
R974 B.n488 B.n64 240
R975 B.n484 B.n64 240
R976 B.n484 B.n66 240
R977 B.n476 B.n66 240
R978 B.n476 B.n72 240
R979 B.n472 B.n72 240
R980 B.n472 B.n74 240
R981 B.n464 B.n74 240
R982 B.n464 B.n80 240
R983 B.n460 B.n80 240
R984 B.n460 B.n82 240
R985 B.n452 B.n82 240
R986 B.n452 B.n88 240
R987 B.n448 B.n88 240
R988 B.n448 B.n90 240
R989 B.n440 B.n90 240
R990 B.n440 B.n96 240
R991 B.n436 B.n96 240
R992 B.n436 B.n98 240
R993 B.n428 B.n98 240
R994 B.n428 B.n104 240
R995 B.n424 B.n104 240
R996 B.n424 B.n106 240
R997 B.n416 B.n106 240
R998 B.n416 B.n112 240
R999 B.n412 B.n112 240
R1000 B.n412 B.n114 240
R1001 B.n404 B.n114 240
R1002 B.n404 B.n120 240
R1003 B.n400 B.n120 240
R1004 B.n400 B.n122 240
R1005 B.n392 B.n122 240
R1006 B.n392 B.n128 240
R1007 B.n388 B.n128 240
R1008 B.n388 B.n130 240
R1009 B.n380 B.n130 240
R1010 B.n380 B.n136 240
R1011 B.n376 B.n136 240
R1012 B.n376 B.n138 240
R1013 B.n368 B.n138 240
R1014 B.n368 B.n144 240
R1015 B.n364 B.n144 240
R1016 B.n364 B.n146 240
R1017 B.n356 B.n146 240
R1018 B.n356 B.n152 240
R1019 B.n352 B.n152 240
R1020 B.n352 B.n154 240
R1021 B.n344 B.n154 240
R1022 B.n344 B.n160 240
R1023 B.n340 B.n160 240
R1024 B.n340 B.n162 240
R1025 B.n332 B.n162 240
R1026 B.n332 B.n168 240
R1027 B.n328 B.n168 240
R1028 B.n328 B.n170 240
R1029 B.n320 B.n170 240
R1030 B.n320 B.n176 240
R1031 B.n316 B.n176 240
R1032 B.n316 B.n178 240
R1033 B.n308 B.n178 240
R1034 B.n308 B.n184 240
R1035 B.n304 B.n184 240
R1036 B.n304 B.n186 240
R1037 B.n296 B.n186 240
R1038 B.n296 B.n192 240
R1039 B.n292 B.n192 240
R1040 B.n292 B.n194 240
R1041 B.n284 B.n194 240
R1042 B.n284 B.n200 240
R1043 B.n280 B.n200 240
R1044 B.n280 B.n202 240
R1045 B.n272 B.n202 240
R1046 B.n272 B.n208 240
R1047 B.n268 B.n208 240
R1048 B.n268 B.n210 240
R1049 B.n260 B.n210 240
R1050 B.n260 B.n216 240
R1051 B.n256 B.n216 240
R1052 B.n256 B.n218 240
R1053 B.n248 B.n218 240
R1054 B.n248 B.n224 240
R1055 B.n244 B.n224 240
R1056 B.n244 B.n226 240
R1057 B.n580 B.n1 240
R1058 B.n577 B.n3 240
R1059 B.n567 B.n3 240
R1060 B.n567 B.n12 240
R1061 B.n562 B.n12 240
R1062 B.n562 B.n14 240
R1063 B.n554 B.n14 240
R1064 B.n554 B.n20 240
R1065 B.n550 B.n20 240
R1066 B.n550 B.n22 240
R1067 B.n542 B.n22 240
R1068 B.n542 B.n28 240
R1069 B.n538 B.n28 240
R1070 B.n538 B.n30 240
R1071 B.n530 B.n30 240
R1072 B.n530 B.n36 240
R1073 B.n526 B.n36 240
R1074 B.n526 B.n38 240
R1075 B.n518 B.n38 240
R1076 B.n518 B.n44 240
R1077 B.n514 B.n44 240
R1078 B.n514 B.n46 240
R1079 B.n506 B.n46 240
R1080 B.n506 B.n52 240
R1081 B.n502 B.n52 240
R1082 B.n502 B.n54 240
R1083 B.n494 B.n54 240
R1084 B.n494 B.n60 240
R1085 B.n490 B.n60 240
R1086 B.n490 B.n62 240
R1087 B.n482 B.n62 240
R1088 B.n482 B.n68 240
R1089 B.n478 B.n68 240
R1090 B.n478 B.n70 240
R1091 B.n470 B.n70 240
R1092 B.n470 B.n76 240
R1093 B.n466 B.n76 240
R1094 B.n466 B.n78 240
R1095 B.n458 B.n78 240
R1096 B.n458 B.n84 240
R1097 B.n454 B.n84 240
R1098 B.n454 B.n86 240
R1099 B.n446 B.n86 240
R1100 B.n446 B.n92 240
R1101 B.n442 B.n92 240
R1102 B.n442 B.n94 240
R1103 B.n434 B.n94 240
R1104 B.n434 B.n100 240
R1105 B.n430 B.n100 240
R1106 B.n430 B.n102 240
R1107 B.n422 B.n102 240
R1108 B.n422 B.n108 240
R1109 B.n418 B.n108 240
R1110 B.n418 B.n110 240
R1111 B.n410 B.n110 240
R1112 B.n410 B.n116 240
R1113 B.n406 B.n116 240
R1114 B.n406 B.n118 240
R1115 B.n398 B.n118 240
R1116 B.n398 B.n124 240
R1117 B.n394 B.n124 240
R1118 B.n394 B.n126 240
R1119 B.n386 B.n126 240
R1120 B.n386 B.n132 240
R1121 B.n382 B.n132 240
R1122 B.n382 B.n134 240
R1123 B.n374 B.n134 240
R1124 B.n374 B.n140 240
R1125 B.n370 B.n140 240
R1126 B.n370 B.n142 240
R1127 B.n362 B.n142 240
R1128 B.n362 B.n148 240
R1129 B.n358 B.n148 240
R1130 B.n358 B.n150 240
R1131 B.n350 B.n150 240
R1132 B.n350 B.n156 240
R1133 B.n346 B.n156 240
R1134 B.n346 B.n158 240
R1135 B.n338 B.n158 240
R1136 B.n338 B.n164 240
R1137 B.n334 B.n164 240
R1138 B.n334 B.n166 240
R1139 B.n326 B.n166 240
R1140 B.n326 B.n172 240
R1141 B.n322 B.n172 240
R1142 B.n322 B.n174 240
R1143 B.n314 B.n174 240
R1144 B.n314 B.n180 240
R1145 B.n310 B.n180 240
R1146 B.n310 B.n182 240
R1147 B.n302 B.n182 240
R1148 B.n302 B.n188 240
R1149 B.n298 B.n188 240
R1150 B.n298 B.n190 240
R1151 B.n290 B.n190 240
R1152 B.n290 B.n196 240
R1153 B.n286 B.n196 240
R1154 B.n286 B.n198 240
R1155 B.n278 B.n198 240
R1156 B.n278 B.n204 240
R1157 B.n274 B.n204 240
R1158 B.n274 B.n206 240
R1159 B.n266 B.n206 240
R1160 B.n266 B.n212 240
R1161 B.n262 B.n212 240
R1162 B.n262 B.n214 240
R1163 B.n254 B.n214 240
R1164 B.n254 B.n220 240
R1165 B.n250 B.n220 240
R1166 B.n250 B.n222 240
R1167 B.n242 B.n222 240
R1168 B.n242 B.n228 240
R1169 B.n236 B.n235 240
R1170 B.n576 B.n2 214.631
R1171 B.n230 B.n227 214.631
R1172 B.n573 B.n8 185
R1173 B.n572 B.n1 185
R1174 B.n581 B.n580 185
R1175 B.n578 B.n0 185
R1176 B.n577 B.n576 185
R1177 B.n577 B.n4 185
R1178 B.n5 B.n3 185
R1179 B.n565 B.n3 185
R1180 B.n568 B.n567 185
R1181 B.n567 B.n566 185
R1182 B.n12 B.n11 185
R1183 B.n564 B.n12 185
R1184 B.n562 B.n561 185
R1185 B.n563 B.n562 185
R1186 B.n15 B.n14 185
R1187 B.n14 B.n13 185
R1188 B.n555 B.n554 185
R1189 B.n554 B.n553 185
R1190 B.n20 B.n19 185
R1191 B.n552 B.n20 185
R1192 B.n550 B.n549 185
R1193 B.n551 B.n550 185
R1194 B.n23 B.n22 185
R1195 B.n22 B.n21 185
R1196 B.n543 B.n542 185
R1197 B.n542 B.n541 185
R1198 B.n28 B.n27 185
R1199 B.n540 B.n28 185
R1200 B.n538 B.n537 185
R1201 B.n539 B.n538 185
R1202 B.n31 B.n30 185
R1203 B.n30 B.n29 185
R1204 B.n531 B.n530 185
R1205 B.n530 B.n529 185
R1206 B.n36 B.n35 185
R1207 B.n528 B.n36 185
R1208 B.n526 B.n525 185
R1209 B.n527 B.n526 185
R1210 B.n39 B.n38 185
R1211 B.n38 B.n37 185
R1212 B.n519 B.n518 185
R1213 B.n518 B.n517 185
R1214 B.n44 B.n43 185
R1215 B.n516 B.n44 185
R1216 B.n514 B.n513 185
R1217 B.n515 B.n514 185
R1218 B.n47 B.n46 185
R1219 B.n46 B.n45 185
R1220 B.n507 B.n506 185
R1221 B.n506 B.n505 185
R1222 B.n52 B.n51 185
R1223 B.n504 B.n52 185
R1224 B.n502 B.n501 185
R1225 B.n503 B.n502 185
R1226 B.n55 B.n54 185
R1227 B.n54 B.n53 185
R1228 B.n495 B.n494 185
R1229 B.n494 B.n493 185
R1230 B.n60 B.n59 185
R1231 B.n492 B.n60 185
R1232 B.n490 B.n489 185
R1233 B.n491 B.n490 185
R1234 B.n63 B.n62 185
R1235 B.n62 B.n61 185
R1236 B.n483 B.n482 185
R1237 B.n482 B.n481 185
R1238 B.n68 B.n67 185
R1239 B.n480 B.n68 185
R1240 B.n478 B.n477 185
R1241 B.n479 B.n478 185
R1242 B.n71 B.n70 185
R1243 B.n70 B.n69 185
R1244 B.n471 B.n470 185
R1245 B.n470 B.n469 185
R1246 B.n76 B.n75 185
R1247 B.n468 B.n76 185
R1248 B.n466 B.n465 185
R1249 B.n467 B.n466 185
R1250 B.n79 B.n78 185
R1251 B.n78 B.n77 185
R1252 B.n459 B.n458 185
R1253 B.n458 B.n457 185
R1254 B.n84 B.n83 185
R1255 B.n456 B.n84 185
R1256 B.n454 B.n453 185
R1257 B.n455 B.n454 185
R1258 B.n87 B.n86 185
R1259 B.n86 B.n85 185
R1260 B.n447 B.n446 185
R1261 B.n446 B.n445 185
R1262 B.n92 B.n91 185
R1263 B.n444 B.n92 185
R1264 B.n442 B.n441 185
R1265 B.n443 B.n442 185
R1266 B.n95 B.n94 185
R1267 B.n94 B.n93 185
R1268 B.n435 B.n434 185
R1269 B.n434 B.n433 185
R1270 B.n100 B.n99 185
R1271 B.n432 B.n100 185
R1272 B.n430 B.n429 185
R1273 B.n431 B.n430 185
R1274 B.n103 B.n102 185
R1275 B.n102 B.n101 185
R1276 B.n423 B.n422 185
R1277 B.n422 B.n421 185
R1278 B.n108 B.n107 185
R1279 B.n420 B.n108 185
R1280 B.n418 B.n417 185
R1281 B.n419 B.n418 185
R1282 B.n111 B.n110 185
R1283 B.n110 B.n109 185
R1284 B.n411 B.n410 185
R1285 B.n410 B.n409 185
R1286 B.n116 B.n115 185
R1287 B.n408 B.n116 185
R1288 B.n406 B.n405 185
R1289 B.n407 B.n406 185
R1290 B.n119 B.n118 185
R1291 B.n118 B.n117 185
R1292 B.n399 B.n398 185
R1293 B.n398 B.n397 185
R1294 B.n124 B.n123 185
R1295 B.n396 B.n124 185
R1296 B.n394 B.n393 185
R1297 B.n395 B.n394 185
R1298 B.n127 B.n126 185
R1299 B.n126 B.n125 185
R1300 B.n387 B.n386 185
R1301 B.n386 B.n385 185
R1302 B.n132 B.n131 185
R1303 B.n384 B.n132 185
R1304 B.n382 B.n381 185
R1305 B.n383 B.n382 185
R1306 B.n135 B.n134 185
R1307 B.n134 B.n133 185
R1308 B.n375 B.n374 185
R1309 B.n374 B.n373 185
R1310 B.n140 B.n139 185
R1311 B.n372 B.n140 185
R1312 B.n370 B.n369 185
R1313 B.n371 B.n370 185
R1314 B.n143 B.n142 185
R1315 B.n142 B.n141 185
R1316 B.n363 B.n362 185
R1317 B.n362 B.n361 185
R1318 B.n148 B.n147 185
R1319 B.n360 B.n148 185
R1320 B.n358 B.n357 185
R1321 B.n359 B.n358 185
R1322 B.n151 B.n150 185
R1323 B.n150 B.n149 185
R1324 B.n351 B.n350 185
R1325 B.n350 B.n349 185
R1326 B.n156 B.n155 185
R1327 B.n348 B.n156 185
R1328 B.n346 B.n345 185
R1329 B.n347 B.n346 185
R1330 B.n159 B.n158 185
R1331 B.n158 B.n157 185
R1332 B.n339 B.n338 185
R1333 B.n338 B.n337 185
R1334 B.n164 B.n163 185
R1335 B.n336 B.n164 185
R1336 B.n334 B.n333 185
R1337 B.n335 B.n334 185
R1338 B.n167 B.n166 185
R1339 B.n166 B.n165 185
R1340 B.n327 B.n326 185
R1341 B.n326 B.n325 185
R1342 B.n172 B.n171 185
R1343 B.n324 B.n172 185
R1344 B.n322 B.n321 185
R1345 B.n323 B.n322 185
R1346 B.n175 B.n174 185
R1347 B.n174 B.n173 185
R1348 B.n315 B.n314 185
R1349 B.n314 B.n313 185
R1350 B.n180 B.n179 185
R1351 B.n312 B.n180 185
R1352 B.n310 B.n309 185
R1353 B.n311 B.n310 185
R1354 B.n183 B.n182 185
R1355 B.n182 B.n181 185
R1356 B.n303 B.n302 185
R1357 B.n302 B.n301 185
R1358 B.n188 B.n187 185
R1359 B.n300 B.n188 185
R1360 B.n298 B.n297 185
R1361 B.n299 B.n298 185
R1362 B.n191 B.n190 185
R1363 B.n190 B.n189 185
R1364 B.n291 B.n290 185
R1365 B.n290 B.n289 185
R1366 B.n196 B.n195 185
R1367 B.n288 B.n196 185
R1368 B.n286 B.n285 185
R1369 B.n287 B.n286 185
R1370 B.n199 B.n198 185
R1371 B.n198 B.n197 185
R1372 B.n279 B.n278 185
R1373 B.n278 B.n277 185
R1374 B.n204 B.n203 185
R1375 B.n276 B.n204 185
R1376 B.n274 B.n273 185
R1377 B.n275 B.n274 185
R1378 B.n207 B.n206 185
R1379 B.n206 B.n205 185
R1380 B.n267 B.n266 185
R1381 B.n266 B.n265 185
R1382 B.n212 B.n211 185
R1383 B.n264 B.n212 185
R1384 B.n262 B.n261 185
R1385 B.n263 B.n262 185
R1386 B.n215 B.n214 185
R1387 B.n214 B.n213 185
R1388 B.n255 B.n254 185
R1389 B.n254 B.n253 185
R1390 B.n220 B.n219 185
R1391 B.n252 B.n220 185
R1392 B.n250 B.n249 185
R1393 B.n251 B.n250 185
R1394 B.n223 B.n222 185
R1395 B.n222 B.n221 185
R1396 B.n243 B.n242 185
R1397 B.n242 B.n241 185
R1398 B.n228 B.n227 185
R1399 B.n240 B.n228 185
R1400 B.n239 B.n238 185
R1401 B.n236 B.n229 185
R1402 B.n235 B.n231 185
R1403 B.n233 B.n232 185
R1404 B.n227 B.n226 185
R1405 B.n226 B.n225 185
R1406 B.n244 B.n243 185
R1407 B.n245 B.n244 185
R1408 B.n224 B.n223 185
R1409 B.n246 B.n224 185
R1410 B.n249 B.n248 185
R1411 B.n248 B.n247 185
R1412 B.n219 B.n218 185
R1413 B.n218 B.n217 185
R1414 B.n256 B.n255 185
R1415 B.n257 B.n256 185
R1416 B.n216 B.n215 185
R1417 B.n258 B.n216 185
R1418 B.n261 B.n260 185
R1419 B.n260 B.n259 185
R1420 B.n211 B.n210 185
R1421 B.n210 B.n209 185
R1422 B.n268 B.n267 185
R1423 B.n269 B.n268 185
R1424 B.n208 B.n207 185
R1425 B.n270 B.n208 185
R1426 B.n273 B.n272 185
R1427 B.n272 B.n271 185
R1428 B.n203 B.n202 185
R1429 B.n202 B.n201 185
R1430 B.n280 B.n279 185
R1431 B.n281 B.n280 185
R1432 B.n200 B.n199 185
R1433 B.n282 B.n200 185
R1434 B.n285 B.n284 185
R1435 B.n284 B.n283 185
R1436 B.n195 B.n194 185
R1437 B.n194 B.n193 185
R1438 B.n292 B.n291 185
R1439 B.n293 B.n292 185
R1440 B.n192 B.n191 185
R1441 B.n294 B.n192 185
R1442 B.n297 B.n296 185
R1443 B.n296 B.n295 185
R1444 B.n187 B.n186 185
R1445 B.n186 B.n185 185
R1446 B.n304 B.n303 185
R1447 B.n305 B.n304 185
R1448 B.n184 B.n183 185
R1449 B.n306 B.n184 185
R1450 B.n309 B.n308 185
R1451 B.n308 B.n307 185
R1452 B.n179 B.n178 185
R1453 B.n178 B.n177 185
R1454 B.n316 B.n315 185
R1455 B.n317 B.n316 185
R1456 B.n176 B.n175 185
R1457 B.n318 B.n176 185
R1458 B.n321 B.n320 185
R1459 B.n320 B.n319 185
R1460 B.n171 B.n170 185
R1461 B.n170 B.n169 185
R1462 B.n328 B.n327 185
R1463 B.n329 B.n328 185
R1464 B.n168 B.n167 185
R1465 B.n330 B.n168 185
R1466 B.n333 B.n332 185
R1467 B.n332 B.n331 185
R1468 B.n163 B.n162 185
R1469 B.n162 B.n161 185
R1470 B.n340 B.n339 185
R1471 B.n341 B.n340 185
R1472 B.n160 B.n159 185
R1473 B.n342 B.n160 185
R1474 B.n345 B.n344 185
R1475 B.n344 B.n343 185
R1476 B.n155 B.n154 185
R1477 B.n154 B.n153 185
R1478 B.n352 B.n351 185
R1479 B.n353 B.n352 185
R1480 B.n152 B.n151 185
R1481 B.n354 B.n152 185
R1482 B.n357 B.n356 185
R1483 B.n356 B.n355 185
R1484 B.n147 B.n146 185
R1485 B.n146 B.n145 185
R1486 B.n364 B.n363 185
R1487 B.n365 B.n364 185
R1488 B.n144 B.n143 185
R1489 B.n366 B.n144 185
R1490 B.n369 B.n368 185
R1491 B.n368 B.n367 185
R1492 B.n139 B.n138 185
R1493 B.n138 B.n137 185
R1494 B.n376 B.n375 185
R1495 B.n377 B.n376 185
R1496 B.n136 B.n135 185
R1497 B.n378 B.n136 185
R1498 B.n381 B.n380 185
R1499 B.n380 B.n379 185
R1500 B.n131 B.n130 185
R1501 B.n130 B.n129 185
R1502 B.n388 B.n387 185
R1503 B.n389 B.n388 185
R1504 B.n128 B.n127 185
R1505 B.n390 B.n128 185
R1506 B.n393 B.n392 185
R1507 B.n392 B.n391 185
R1508 B.n123 B.n122 185
R1509 B.n122 B.n121 185
R1510 B.n400 B.n399 185
R1511 B.n401 B.n400 185
R1512 B.n120 B.n119 185
R1513 B.n402 B.n120 185
R1514 B.n405 B.n404 185
R1515 B.n404 B.n403 185
R1516 B.n115 B.n114 185
R1517 B.n114 B.n113 185
R1518 B.n412 B.n411 185
R1519 B.n413 B.n412 185
R1520 B.n112 B.n111 185
R1521 B.n414 B.n112 185
R1522 B.n417 B.n416 185
R1523 B.n416 B.n415 185
R1524 B.n107 B.n106 185
R1525 B.n106 B.n105 185
R1526 B.n424 B.n423 185
R1527 B.n425 B.n424 185
R1528 B.n104 B.n103 185
R1529 B.n426 B.n104 185
R1530 B.n429 B.n428 185
R1531 B.n428 B.n427 185
R1532 B.n99 B.n98 185
R1533 B.n98 B.n97 185
R1534 B.n436 B.n435 185
R1535 B.n437 B.n436 185
R1536 B.n96 B.n95 185
R1537 B.n438 B.n96 185
R1538 B.n441 B.n440 185
R1539 B.n440 B.n439 185
R1540 B.n91 B.n90 185
R1541 B.n90 B.n89 185
R1542 B.n448 B.n447 185
R1543 B.n449 B.n448 185
R1544 B.n88 B.n87 185
R1545 B.n450 B.n88 185
R1546 B.n453 B.n452 185
R1547 B.n452 B.n451 185
R1548 B.n83 B.n82 185
R1549 B.n82 B.n81 185
R1550 B.n460 B.n459 185
R1551 B.n461 B.n460 185
R1552 B.n80 B.n79 185
R1553 B.n462 B.n80 185
R1554 B.n465 B.n464 185
R1555 B.n464 B.n463 185
R1556 B.n75 B.n74 185
R1557 B.n74 B.n73 185
R1558 B.n472 B.n471 185
R1559 B.n473 B.n472 185
R1560 B.n72 B.n71 185
R1561 B.n474 B.n72 185
R1562 B.n477 B.n476 185
R1563 B.n476 B.n475 185
R1564 B.n67 B.n66 185
R1565 B.n66 B.n65 185
R1566 B.n484 B.n483 185
R1567 B.n485 B.n484 185
R1568 B.n64 B.n63 185
R1569 B.n486 B.n64 185
R1570 B.n489 B.n488 185
R1571 B.n488 B.n487 185
R1572 B.n59 B.n58 185
R1573 B.n58 B.n57 185
R1574 B.n496 B.n495 185
R1575 B.n497 B.n496 185
R1576 B.n56 B.n55 185
R1577 B.n498 B.n56 185
R1578 B.n501 B.n500 185
R1579 B.n500 B.n499 185
R1580 B.n51 B.n50 185
R1581 B.n50 B.n49 185
R1582 B.n508 B.n507 185
R1583 B.n509 B.n508 185
R1584 B.n48 B.n47 185
R1585 B.n510 B.n48 185
R1586 B.n513 B.n512 185
R1587 B.n512 B.n511 185
R1588 B.n43 B.n42 185
R1589 B.n42 B.n41 185
R1590 B.n520 B.n519 185
R1591 B.n521 B.n520 185
R1592 B.n40 B.n39 185
R1593 B.n522 B.n40 185
R1594 B.n525 B.n524 185
R1595 B.n524 B.n523 185
R1596 B.n35 B.n34 185
R1597 B.n34 B.n33 185
R1598 B.n532 B.n531 185
R1599 B.n533 B.n532 185
R1600 B.n32 B.n31 185
R1601 B.n534 B.n32 185
R1602 B.n537 B.n536 185
R1603 B.n536 B.n535 185
R1604 B.n27 B.n26 185
R1605 B.n26 B.n25 185
R1606 B.n544 B.n543 185
R1607 B.n545 B.n544 185
R1608 B.n24 B.n23 185
R1609 B.n546 B.n24 185
R1610 B.n549 B.n548 185
R1611 B.n548 B.n547 185
R1612 B.n19 B.n18 185
R1613 B.n18 B.n17 185
R1614 B.n556 B.n555 185
R1615 B.n557 B.n556 185
R1616 B.n16 B.n15 185
R1617 B.n558 B.n16 185
R1618 B.n561 B.n560 185
R1619 B.n560 B.n559 185
R1620 B.n11 B.n10 185
R1621 B.n10 B.n9 185
R1622 B.n569 B.n568 185
R1623 B.n570 B.n569 185
R1624 B.n6 B.n5 185
R1625 B.n571 B.n6 185
R1626 B.n576 B.n575 185
R1627 B.n575 B.n574 185
R1628 B.n576 B.n5 119.63
R1629 B.n568 B.n5 119.63
R1630 B.n568 B.n11 119.63
R1631 B.n561 B.n11 119.63
R1632 B.n561 B.n15 119.63
R1633 B.n555 B.n15 119.63
R1634 B.n555 B.n19 119.63
R1635 B.n549 B.n19 119.63
R1636 B.n549 B.n23 119.63
R1637 B.n543 B.n23 119.63
R1638 B.n543 B.n27 119.63
R1639 B.n537 B.n27 119.63
R1640 B.n537 B.n31 119.63
R1641 B.n531 B.n31 119.63
R1642 B.n531 B.n35 119.63
R1643 B.n525 B.n35 119.63
R1644 B.n525 B.n39 119.63
R1645 B.n519 B.n39 119.63
R1646 B.n519 B.n43 119.63
R1647 B.n513 B.n43 119.63
R1648 B.n513 B.n47 119.63
R1649 B.n507 B.n47 119.63
R1650 B.n507 B.n51 119.63
R1651 B.n501 B.n51 119.63
R1652 B.n501 B.n55 119.63
R1653 B.n495 B.n55 119.63
R1654 B.n495 B.n59 119.63
R1655 B.n489 B.n59 119.63
R1656 B.n489 B.n63 119.63
R1657 B.n483 B.n63 119.63
R1658 B.n483 B.n67 119.63
R1659 B.n477 B.n67 119.63
R1660 B.n477 B.n71 119.63
R1661 B.n471 B.n71 119.63
R1662 B.n471 B.n75 119.63
R1663 B.n465 B.n75 119.63
R1664 B.n465 B.n79 119.63
R1665 B.n459 B.n79 119.63
R1666 B.n459 B.n83 119.63
R1667 B.n453 B.n83 119.63
R1668 B.n453 B.n87 119.63
R1669 B.n447 B.n87 119.63
R1670 B.n447 B.n91 119.63
R1671 B.n441 B.n91 119.63
R1672 B.n441 B.n95 119.63
R1673 B.n435 B.n95 119.63
R1674 B.n435 B.n99 119.63
R1675 B.n429 B.n99 119.63
R1676 B.n429 B.n103 119.63
R1677 B.n423 B.n103 119.63
R1678 B.n423 B.n107 119.63
R1679 B.n417 B.n107 119.63
R1680 B.n417 B.n111 119.63
R1681 B.n411 B.n111 119.63
R1682 B.n411 B.n115 119.63
R1683 B.n405 B.n115 119.63
R1684 B.n405 B.n119 119.63
R1685 B.n399 B.n119 119.63
R1686 B.n399 B.n123 119.63
R1687 B.n393 B.n123 119.63
R1688 B.n393 B.n127 119.63
R1689 B.n387 B.n127 119.63
R1690 B.n387 B.n131 119.63
R1691 B.n381 B.n131 119.63
R1692 B.n381 B.n135 119.63
R1693 B.n375 B.n135 119.63
R1694 B.n375 B.n139 119.63
R1695 B.n369 B.n139 119.63
R1696 B.n369 B.n143 119.63
R1697 B.n363 B.n143 119.63
R1698 B.n363 B.n147 119.63
R1699 B.n357 B.n147 119.63
R1700 B.n357 B.n151 119.63
R1701 B.n351 B.n151 119.63
R1702 B.n351 B.n155 119.63
R1703 B.n345 B.n155 119.63
R1704 B.n345 B.n159 119.63
R1705 B.n339 B.n159 119.63
R1706 B.n339 B.n163 119.63
R1707 B.n333 B.n163 119.63
R1708 B.n333 B.n167 119.63
R1709 B.n327 B.n167 119.63
R1710 B.n327 B.n171 119.63
R1711 B.n321 B.n171 119.63
R1712 B.n321 B.n175 119.63
R1713 B.n315 B.n175 119.63
R1714 B.n315 B.n179 119.63
R1715 B.n309 B.n179 119.63
R1716 B.n309 B.n183 119.63
R1717 B.n303 B.n183 119.63
R1718 B.n303 B.n187 119.63
R1719 B.n297 B.n187 119.63
R1720 B.n297 B.n191 119.63
R1721 B.n291 B.n191 119.63
R1722 B.n291 B.n195 119.63
R1723 B.n285 B.n195 119.63
R1724 B.n285 B.n199 119.63
R1725 B.n279 B.n199 119.63
R1726 B.n279 B.n203 119.63
R1727 B.n273 B.n203 119.63
R1728 B.n273 B.n207 119.63
R1729 B.n267 B.n207 119.63
R1730 B.n267 B.n211 119.63
R1731 B.n261 B.n211 119.63
R1732 B.n261 B.n215 119.63
R1733 B.n255 B.n215 119.63
R1734 B.n255 B.n219 119.63
R1735 B.n249 B.n219 119.63
R1736 B.n249 B.n223 119.63
R1737 B.n243 B.n223 119.63
R1738 B.n243 B.n227 119.63
R1739 B.n4 B.n0 82.824
R1740 B.n240 B.n239 82.824
R1741 B.n574 B.n573 82.824
R1742 B.n232 B.n225 82.824
R1743 B.n8 B.n7 72.7879
R1744 B.n580 B.n579 72.7879
R1745 B.n238 B.n237 72.7879
R1746 B.n235 B.n234 72.7879
R1747 B.n579 B.n578 72.7879
R1748 B.n7 B.n1 72.7879
R1749 B.n237 B.n236 72.7879
R1750 B.n234 B.n233 72.7879
R1751 B.n7 B.n2 56.1076
R1752 B.n579 B.n2 56.1076
R1753 B.n237 B.n230 56.1076
R1754 B.n234 B.n230 56.1076
R1755 B.n581 B.n0 25.6005
R1756 B.n573 B.n572 25.6005
R1757 B.n565 B.n4 25.6005
R1758 B.n566 B.n565 25.6005
R1759 B.n566 B.n564 25.6005
R1760 B.n564 B.n563 25.6005
R1761 B.n563 B.n13 25.6005
R1762 B.n553 B.n13 25.6005
R1763 B.n553 B.n552 25.6005
R1764 B.n552 B.n551 25.6005
R1765 B.n551 B.n21 25.6005
R1766 B.n541 B.n21 25.6005
R1767 B.n541 B.n540 25.6005
R1768 B.n540 B.n539 25.6005
R1769 B.n539 B.n29 25.6005
R1770 B.n529 B.n29 25.6005
R1771 B.n529 B.n528 25.6005
R1772 B.n528 B.n527 25.6005
R1773 B.n527 B.n37 25.6005
R1774 B.n517 B.n37 25.6005
R1775 B.n517 B.n516 25.6005
R1776 B.n516 B.n515 25.6005
R1777 B.n515 B.n45 25.6005
R1778 B.n505 B.n45 25.6005
R1779 B.n505 B.n504 25.6005
R1780 B.n504 B.n503 25.6005
R1781 B.n503 B.n53 25.6005
R1782 B.n493 B.n53 25.6005
R1783 B.n493 B.n492 25.6005
R1784 B.n492 B.n491 25.6005
R1785 B.n491 B.n61 25.6005
R1786 B.n481 B.n61 25.6005
R1787 B.n481 B.n480 25.6005
R1788 B.n480 B.n479 25.6005
R1789 B.n479 B.n69 25.6005
R1790 B.n469 B.n69 25.6005
R1791 B.n469 B.n468 25.6005
R1792 B.n468 B.n467 25.6005
R1793 B.n467 B.n77 25.6005
R1794 B.n457 B.n77 25.6005
R1795 B.n457 B.n456 25.6005
R1796 B.n456 B.n455 25.6005
R1797 B.n455 B.n85 25.6005
R1798 B.n445 B.n85 25.6005
R1799 B.n445 B.n444 25.6005
R1800 B.n444 B.n443 25.6005
R1801 B.n443 B.n93 25.6005
R1802 B.n433 B.n93 25.6005
R1803 B.n433 B.n432 25.6005
R1804 B.n432 B.n431 25.6005
R1805 B.n431 B.n101 25.6005
R1806 B.n421 B.n101 25.6005
R1807 B.n421 B.n420 25.6005
R1808 B.n420 B.n419 25.6005
R1809 B.n419 B.n109 25.6005
R1810 B.n409 B.n109 25.6005
R1811 B.n409 B.n408 25.6005
R1812 B.n408 B.n407 25.6005
R1813 B.n407 B.n117 25.6005
R1814 B.n397 B.n117 25.6005
R1815 B.n397 B.n396 25.6005
R1816 B.n396 B.n395 25.6005
R1817 B.n395 B.n125 25.6005
R1818 B.n385 B.n125 25.6005
R1819 B.n385 B.n384 25.6005
R1820 B.n384 B.n383 25.6005
R1821 B.n383 B.n133 25.6005
R1822 B.n373 B.n133 25.6005
R1823 B.n373 B.n372 25.6005
R1824 B.n372 B.n371 25.6005
R1825 B.n371 B.n141 25.6005
R1826 B.n361 B.n141 25.6005
R1827 B.n361 B.n360 25.6005
R1828 B.n360 B.n359 25.6005
R1829 B.n359 B.n149 25.6005
R1830 B.n349 B.n149 25.6005
R1831 B.n349 B.n348 25.6005
R1832 B.n348 B.n347 25.6005
R1833 B.n347 B.n157 25.6005
R1834 B.n337 B.n157 25.6005
R1835 B.n337 B.n336 25.6005
R1836 B.n336 B.n335 25.6005
R1837 B.n335 B.n165 25.6005
R1838 B.n325 B.n165 25.6005
R1839 B.n325 B.n324 25.6005
R1840 B.n324 B.n323 25.6005
R1841 B.n323 B.n173 25.6005
R1842 B.n313 B.n173 25.6005
R1843 B.n313 B.n312 25.6005
R1844 B.n312 B.n311 25.6005
R1845 B.n311 B.n181 25.6005
R1846 B.n301 B.n181 25.6005
R1847 B.n301 B.n300 25.6005
R1848 B.n300 B.n299 25.6005
R1849 B.n299 B.n189 25.6005
R1850 B.n289 B.n189 25.6005
R1851 B.n289 B.n288 25.6005
R1852 B.n288 B.n287 25.6005
R1853 B.n287 B.n197 25.6005
R1854 B.n277 B.n197 25.6005
R1855 B.n277 B.n276 25.6005
R1856 B.n276 B.n275 25.6005
R1857 B.n275 B.n205 25.6005
R1858 B.n265 B.n205 25.6005
R1859 B.n265 B.n264 25.6005
R1860 B.n264 B.n263 25.6005
R1861 B.n263 B.n213 25.6005
R1862 B.n253 B.n213 25.6005
R1863 B.n253 B.n252 25.6005
R1864 B.n252 B.n251 25.6005
R1865 B.n251 B.n221 25.6005
R1866 B.n241 B.n221 25.6005
R1867 B.n241 B.n240 25.6005
R1868 B.n239 B.n229 25.6005
R1869 B.n231 B.n229 25.6005
R1870 B.n232 B.n231 25.6005
R1871 B.n574 B.n571 25.6005
R1872 B.n571 B.n570 25.6005
R1873 B.n570 B.n9 25.6005
R1874 B.n559 B.n9 25.6005
R1875 B.n559 B.n558 25.6005
R1876 B.n558 B.n557 25.6005
R1877 B.n557 B.n17 25.6005
R1878 B.n547 B.n17 25.6005
R1879 B.n547 B.n546 25.6005
R1880 B.n546 B.n545 25.6005
R1881 B.n545 B.n25 25.6005
R1882 B.n535 B.n25 25.6005
R1883 B.n535 B.n534 25.6005
R1884 B.n534 B.n533 25.6005
R1885 B.n533 B.n33 25.6005
R1886 B.n523 B.n33 25.6005
R1887 B.n523 B.n522 25.6005
R1888 B.n522 B.n521 25.6005
R1889 B.n521 B.n41 25.6005
R1890 B.n511 B.n41 25.6005
R1891 B.n511 B.n510 25.6005
R1892 B.n510 B.n509 25.6005
R1893 B.n509 B.n49 25.6005
R1894 B.n499 B.n49 25.6005
R1895 B.n499 B.n498 25.6005
R1896 B.n498 B.n497 25.6005
R1897 B.n497 B.n57 25.6005
R1898 B.n487 B.n57 25.6005
R1899 B.n487 B.n486 25.6005
R1900 B.n486 B.n485 25.6005
R1901 B.n485 B.n65 25.6005
R1902 B.n475 B.n65 25.6005
R1903 B.n475 B.n474 25.6005
R1904 B.n474 B.n473 25.6005
R1905 B.n473 B.n73 25.6005
R1906 B.n463 B.n73 25.6005
R1907 B.n463 B.n462 25.6005
R1908 B.n462 B.n461 25.6005
R1909 B.n461 B.n81 25.6005
R1910 B.n451 B.n81 25.6005
R1911 B.n451 B.n450 25.6005
R1912 B.n450 B.n449 25.6005
R1913 B.n449 B.n89 25.6005
R1914 B.n439 B.n89 25.6005
R1915 B.n439 B.n438 25.6005
R1916 B.n438 B.n437 25.6005
R1917 B.n437 B.n97 25.6005
R1918 B.n427 B.n97 25.6005
R1919 B.n427 B.n426 25.6005
R1920 B.n426 B.n425 25.6005
R1921 B.n425 B.n105 25.6005
R1922 B.n415 B.n105 25.6005
R1923 B.n415 B.n414 25.6005
R1924 B.n414 B.n413 25.6005
R1925 B.n413 B.n113 25.6005
R1926 B.n403 B.n113 25.6005
R1927 B.n403 B.n402 25.6005
R1928 B.n402 B.n401 25.6005
R1929 B.n401 B.n121 25.6005
R1930 B.n391 B.n121 25.6005
R1931 B.n391 B.n390 25.6005
R1932 B.n390 B.n389 25.6005
R1933 B.n389 B.n129 25.6005
R1934 B.n379 B.n129 25.6005
R1935 B.n379 B.n378 25.6005
R1936 B.n378 B.n377 25.6005
R1937 B.n377 B.n137 25.6005
R1938 B.n367 B.n137 25.6005
R1939 B.n367 B.n366 25.6005
R1940 B.n366 B.n365 25.6005
R1941 B.n365 B.n145 25.6005
R1942 B.n355 B.n145 25.6005
R1943 B.n355 B.n354 25.6005
R1944 B.n354 B.n353 25.6005
R1945 B.n353 B.n153 25.6005
R1946 B.n343 B.n153 25.6005
R1947 B.n343 B.n342 25.6005
R1948 B.n342 B.n341 25.6005
R1949 B.n341 B.n161 25.6005
R1950 B.n331 B.n161 25.6005
R1951 B.n331 B.n330 25.6005
R1952 B.n330 B.n329 25.6005
R1953 B.n329 B.n169 25.6005
R1954 B.n319 B.n169 25.6005
R1955 B.n319 B.n318 25.6005
R1956 B.n318 B.n317 25.6005
R1957 B.n317 B.n177 25.6005
R1958 B.n307 B.n177 25.6005
R1959 B.n307 B.n306 25.6005
R1960 B.n306 B.n305 25.6005
R1961 B.n305 B.n185 25.6005
R1962 B.n295 B.n185 25.6005
R1963 B.n295 B.n294 25.6005
R1964 B.n294 B.n293 25.6005
R1965 B.n293 B.n193 25.6005
R1966 B.n283 B.n193 25.6005
R1967 B.n283 B.n282 25.6005
R1968 B.n282 B.n281 25.6005
R1969 B.n281 B.n201 25.6005
R1970 B.n271 B.n201 25.6005
R1971 B.n271 B.n270 25.6005
R1972 B.n270 B.n269 25.6005
R1973 B.n269 B.n209 25.6005
R1974 B.n259 B.n209 25.6005
R1975 B.n259 B.n258 25.6005
R1976 B.n258 B.n257 25.6005
R1977 B.n257 B.n217 25.6005
R1978 B.n247 B.n217 25.6005
R1979 B.n247 B.n246 25.6005
R1980 B.n246 B.n245 25.6005
R1981 B.n245 B.n225 25.6005
R1982 B.n572 B 19.2005
R1983 B B.n581 6.4005
C6 S VSUBS 1.00725f
C7 D VSUBS 1.00725f
C8 G VSUBS 0.1732f
C9 B VSUBS 15.79116f
C10 pfet_01v8_lvt_W37p3_L0p74_m1__nf1_gboth_sdfull_pc/B.n0 VSUBS 0.00152f ; **FLOATING
C11 pfet_01v8_lvt_W37p3_L0p74_m1__nf1_gboth_sdfull_pc/B.n1 VSUBS 0.00452f ; **FLOATING
C12 pfet_01v8_lvt_W37p3_L0p74_m1__nf1_gboth_sdfull_pc/B.n2 VSUBS 0.00202f ; **FLOATING
C13 pfet_01v8_lvt_W37p3_L0p74_m1__nf1_gboth_sdfull_pc/B.n3 VSUBS 0.00452f ; **FLOATING
C14 pfet_01v8_lvt_W37p3_L0p74_m1__nf1_gboth_sdfull_pc/B.t0 VSUBS 0.23466f ; **FLOATING
C15 pfet_01v8_lvt_W37p3_L0p74_m1__nf1_gboth_sdfull_pc/B.n4 VSUBS 0.6315f ; **FLOATING
C16 pfet_01v8_lvt_W37p3_L0p74_m1__nf1_gboth_sdfull_pc/B.n5 VSUBS 0.00202f ; **FLOATING
C17 pfet_01v8_lvt_W37p3_L0p74_m1__nf1_gboth_sdfull_pc/B.n6 VSUBS 0.00452f ; **FLOATING
C18 pfet_01v8_lvt_W37p3_L0p74_m1__nf1_gboth_sdfull_pc/B.n7 VSUBS 0.00454f ; **FLOATING
C19 pfet_01v8_lvt_W37p3_L0p74_m1__nf1_gboth_sdfull_pc/B.n8 VSUBS 0.00454f ; **FLOATING
C20 pfet_01v8_lvt_W37p3_L0p74_m1__nf1_gboth_sdfull_pc/B.n9 VSUBS 0.76263f ; **FLOATING
C21 pfet_01v8_lvt_W37p3_L0p74_m1__nf1_gboth_sdfull_pc/B.n10 VSUBS 0.00454f ; **FLOATING
C22 pfet_01v8_lvt_W37p3_L0p74_m1__nf1_gboth_sdfull_pc/B.n11 VSUBS 0.00202f ; **FLOATING
C23 pfet_01v8_lvt_W37p3_L0p74_m1__nf1_gboth_sdfull_pc/B.n12 VSUBS 0.00202f ; **FLOATING
C24 pfet_01v8_lvt_W37p3_L0p74_m1__nf1_gboth_sdfull_pc/B.n13 VSUBS 0.00202f ; **FLOATING
C25 pfet_01v8_lvt_W37p3_L0p74_m1__nf1_gboth_sdfull_pc/B.n15 VSUBS 0.00202f ; **FLOATING
C26 pfet_01v8_lvt_W37p3_L0p74_m1__nf1_gboth_sdfull_pc/B.n17 VSUBS 0.00202f ; **FLOATING
C27 pfet_01v8_lvt_W37p3_L0p74_m1__nf1_gboth_sdfull_pc/B.n18 VSUBS 0.00202f ; **FLOATING
C28 pfet_01v8_lvt_W37p3_L0p74_m1__nf1_gboth_sdfull_pc/B.n19 VSUBS 0.00202f ; **FLOATING
C29 pfet_01v8_lvt_W37p3_L0p74_m1__nf1_gboth_sdfull_pc/B.n20 VSUBS 0.00202f ; **FLOATING
C30 pfet_01v8_lvt_W37p3_L0p74_m1__nf1_gboth_sdfull_pc/B.n21 VSUBS 0.00202f ; **FLOATING
C31 pfet_01v8_lvt_W37p3_L0p74_m1__nf1_gboth_sdfull_pc/B.n23 VSUBS 0.00202f ; **FLOATING
C32 pfet_01v8_lvt_W37p3_L0p74_m1__nf1_gboth_sdfull_pc/B.n24 VSUBS 0.00202f ; **FLOATING
C33 pfet_01v8_lvt_W37p3_L0p74_m1__nf1_gboth_sdfull_pc/B.n25 VSUBS 0.00202f ; **FLOATING
C34 pfet_01v8_lvt_W37p3_L0p74_m1__nf1_gboth_sdfull_pc/B.n26 VSUBS 0.00202f ; **FLOATING
C35 pfet_01v8_lvt_W37p3_L0p74_m1__nf1_gboth_sdfull_pc/B.n27 VSUBS 0.00202f ; **FLOATING
C36 pfet_01v8_lvt_W37p3_L0p74_m1__nf1_gboth_sdfull_pc/B.n28 VSUBS 0.00202f ; **FLOATING
C37 pfet_01v8_lvt_W37p3_L0p74_m1__nf1_gboth_sdfull_pc/B.n29 VSUBS 0.00202f ; **FLOATING
C38 pfet_01v8_lvt_W37p3_L0p74_m1__nf1_gboth_sdfull_pc/B.n30 VSUBS 0.00202f ; **FLOATING
C39 pfet_01v8_lvt_W37p3_L0p74_m1__nf1_gboth_sdfull_pc/B.n31 VSUBS 0.00202f ; **FLOATING
C40 pfet_01v8_lvt_W37p3_L0p74_m1__nf1_gboth_sdfull_pc/B.n33 VSUBS 0.00202f ; **FLOATING
C41 pfet_01v8_lvt_W37p3_L0p74_m1__nf1_gboth_sdfull_pc/B.n34 VSUBS 0.00202f ; **FLOATING
C42 pfet_01v8_lvt_W37p3_L0p74_m1__nf1_gboth_sdfull_pc/B.n35 VSUBS 0.00202f ; **FLOATING
C43 pfet_01v8_lvt_W37p3_L0p74_m1__nf1_gboth_sdfull_pc/B.n37 VSUBS 0.00202f ; **FLOATING
C44 pfet_01v8_lvt_W37p3_L0p74_m1__nf1_gboth_sdfull_pc/B.n38 VSUBS 0.00202f ; **FLOATING
C45 pfet_01v8_lvt_W37p3_L0p74_m1__nf1_gboth_sdfull_pc/B.n39 VSUBS 0.00202f ; **FLOATING
C46 pfet_01v8_lvt_W37p3_L0p74_m1__nf1_gboth_sdfull_pc/B.n40 VSUBS 0.00202f ; **FLOATING
C47 pfet_01v8_lvt_W37p3_L0p74_m1__nf1_gboth_sdfull_pc/B.n41 VSUBS 0.00202f ; **FLOATING
C48 pfet_01v8_lvt_W37p3_L0p74_m1__nf1_gboth_sdfull_pc/B.n42 VSUBS 0.00202f ; **FLOATING
C49 pfet_01v8_lvt_W37p3_L0p74_m1__nf1_gboth_sdfull_pc/B.n43 VSUBS 0.00202f ; **FLOATING
C50 pfet_01v8_lvt_W37p3_L0p74_m1__nf1_gboth_sdfull_pc/B.n44 VSUBS 0.00202f ; **FLOATING
C51 pfet_01v8_lvt_W37p3_L0p74_m1__nf1_gboth_sdfull_pc/B.n45 VSUBS 0.00202f ; **FLOATING
C52 pfet_01v8_lvt_W37p3_L0p74_m1__nf1_gboth_sdfull_pc/B.n46 VSUBS 0.00202f ; **FLOATING
C53 pfet_01v8_lvt_W37p3_L0p74_m1__nf1_gboth_sdfull_pc/B.n47 VSUBS 0.00202f ; **FLOATING
C54 pfet_01v8_lvt_W37p3_L0p74_m1__nf1_gboth_sdfull_pc/B.n49 VSUBS 0.00202f ; **FLOATING
C55 pfet_01v8_lvt_W37p3_L0p74_m1__nf1_gboth_sdfull_pc/B.n50 VSUBS 0.00202f ; **FLOATING
C56 pfet_01v8_lvt_W37p3_L0p74_m1__nf1_gboth_sdfull_pc/B.n51 VSUBS 0.00202f ; **FLOATING
C57 pfet_01v8_lvt_W37p3_L0p74_m1__nf1_gboth_sdfull_pc/B.n52 VSUBS 0.00202f ; **FLOATING
C58 pfet_01v8_lvt_W37p3_L0p74_m1__nf1_gboth_sdfull_pc/B.n53 VSUBS 0.00202f ; **FLOATING
C59 pfet_01v8_lvt_W37p3_L0p74_m1__nf1_gboth_sdfull_pc/B.n54 VSUBS 0.00202f ; **FLOATING
C60 pfet_01v8_lvt_W37p3_L0p74_m1__nf1_gboth_sdfull_pc/B.n56 VSUBS 0.00202f ; **FLOATING
C61 pfet_01v8_lvt_W37p3_L0p74_m1__nf1_gboth_sdfull_pc/B.n57 VSUBS 0.00202f ; **FLOATING
C62 pfet_01v8_lvt_W37p3_L0p74_m1__nf1_gboth_sdfull_pc/B.n58 VSUBS 0.00202f ; **FLOATING
C63 pfet_01v8_lvt_W37p3_L0p74_m1__nf1_gboth_sdfull_pc/B.n60 VSUBS 0.00202f ; **FLOATING
C64 pfet_01v8_lvt_W37p3_L0p74_m1__nf1_gboth_sdfull_pc/B.n61 VSUBS 0.00202f ; **FLOATING
C65 pfet_01v8_lvt_W37p3_L0p74_m1__nf1_gboth_sdfull_pc/B.n62 VSUBS 0.00202f ; **FLOATING
C66 pfet_01v8_lvt_W37p3_L0p74_m1__nf1_gboth_sdfull_pc/B.n63 VSUBS 0.00202f ; **FLOATING
C67 pfet_01v8_lvt_W37p3_L0p74_m1__nf1_gboth_sdfull_pc/B.n64 VSUBS 0.00202f ; **FLOATING
C68 pfet_01v8_lvt_W37p3_L0p74_m1__nf1_gboth_sdfull_pc/B.n65 VSUBS 0.00202f ; **FLOATING
C69 pfet_01v8_lvt_W37p3_L0p74_m1__nf1_gboth_sdfull_pc/B.n66 VSUBS 0.00202f ; **FLOATING
C70 pfet_01v8_lvt_W37p3_L0p74_m1__nf1_gboth_sdfull_pc/B.n68 VSUBS 0.00202f ; **FLOATING
C71 pfet_01v8_lvt_W37p3_L0p74_m1__nf1_gboth_sdfull_pc/B.n69 VSUBS 0.00202f ; **FLOATING
C72 pfet_01v8_lvt_W37p3_L0p74_m1__nf1_gboth_sdfull_pc/B.n70 VSUBS 0.00202f ; **FLOATING
C73 pfet_01v8_lvt_W37p3_L0p74_m1__nf1_gboth_sdfull_pc/B.n72 VSUBS 0.00202f ; **FLOATING
C74 pfet_01v8_lvt_W37p3_L0p74_m1__nf1_gboth_sdfull_pc/B.n74 VSUBS 0.00202f ; **FLOATING
C75 pfet_01v8_lvt_W37p3_L0p74_m1__nf1_gboth_sdfull_pc/B.n75 VSUBS 0.00202f ; **FLOATING
C76 pfet_01v8_lvt_W37p3_L0p74_m1__nf1_gboth_sdfull_pc/B.n76 VSUBS 0.00202f ; **FLOATING
C77 pfet_01v8_lvt_W37p3_L0p74_m1__nf1_gboth_sdfull_pc/B.n77 VSUBS 0.00202f ; **FLOATING
C78 pfet_01v8_lvt_W37p3_L0p74_m1__nf1_gboth_sdfull_pc/B.n78 VSUBS 0.00202f ; **FLOATING
C79 pfet_01v8_lvt_W37p3_L0p74_m1__nf1_gboth_sdfull_pc/B.n80 VSUBS 0.00202f ; **FLOATING
C80 pfet_01v8_lvt_W37p3_L0p74_m1__nf1_gboth_sdfull_pc/B.n81 VSUBS 0.00202f ; **FLOATING
C81 pfet_01v8_lvt_W37p3_L0p74_m1__nf1_gboth_sdfull_pc/B.n82 VSUBS 0.00202f ; **FLOATING
C82 pfet_01v8_lvt_W37p3_L0p74_m1__nf1_gboth_sdfull_pc/B.n83 VSUBS 0.00202f ; **FLOATING
C83 pfet_01v8_lvt_W37p3_L0p74_m1__nf1_gboth_sdfull_pc/B.n84 VSUBS 0.00202f ; **FLOATING
C84 pfet_01v8_lvt_W37p3_L0p74_m1__nf1_gboth_sdfull_pc/B.n85 VSUBS 0.00202f ; **FLOATING
C85 pfet_01v8_lvt_W37p3_L0p74_m1__nf1_gboth_sdfull_pc/B.n87 VSUBS 0.00202f ; **FLOATING
C86 pfet_01v8_lvt_W37p3_L0p74_m1__nf1_gboth_sdfull_pc/B.n88 VSUBS 0.00202f ; **FLOATING
C87 pfet_01v8_lvt_W37p3_L0p74_m1__nf1_gboth_sdfull_pc/B.n89 VSUBS 0.00202f ; **FLOATING
C88 pfet_01v8_lvt_W37p3_L0p74_m1__nf1_gboth_sdfull_pc/B.n90 VSUBS 0.00202f ; **FLOATING
C89 pfet_01v8_lvt_W37p3_L0p74_m1__nf1_gboth_sdfull_pc/B.n91 VSUBS 0.00202f ; **FLOATING
C90 pfet_01v8_lvt_W37p3_L0p74_m1__nf1_gboth_sdfull_pc/B.n93 VSUBS 0.00202f ; **FLOATING
C91 pfet_01v8_lvt_W37p3_L0p74_m1__nf1_gboth_sdfull_pc/B.n95 VSUBS 0.00202f ; **FLOATING
C92 pfet_01v8_lvt_W37p3_L0p74_m1__nf1_gboth_sdfull_pc/B.n96 VSUBS 0.00202f ; **FLOATING
C93 pfet_01v8_lvt_W37p3_L0p74_m1__nf1_gboth_sdfull_pc/B.n97 VSUBS 0.00202f ; **FLOATING
C94 pfet_01v8_lvt_W37p3_L0p74_m1__nf1_gboth_sdfull_pc/B.n98 VSUBS 0.00202f ; **FLOATING
C95 pfet_01v8_lvt_W37p3_L0p74_m1__nf1_gboth_sdfull_pc/B.n99 VSUBS 0.00202f ; **FLOATING
C96 pfet_01v8_lvt_W37p3_L0p74_m1__nf1_gboth_sdfull_pc/B.n101 VSUBS 0.00202f ; **FLOATING
C97 pfet_01v8_lvt_W37p3_L0p74_m1__nf1_gboth_sdfull_pc/B.n103 VSUBS 0.00202f ; **FLOATING
C98 pfet_01v8_lvt_W37p3_L0p74_m1__nf1_gboth_sdfull_pc/B.n104 VSUBS 0.00202f ; **FLOATING
C99 pfet_01v8_lvt_W37p3_L0p74_m1__nf1_gboth_sdfull_pc/B.n105 VSUBS 0.00202f ; **FLOATING
C100 pfet_01v8_lvt_W37p3_L0p74_m1__nf1_gboth_sdfull_pc/B.n106 VSUBS 0.00202f ; **FLOATING
C101 pfet_01v8_lvt_W37p3_L0p74_m1__nf1_gboth_sdfull_pc/B.n107 VSUBS 0.00202f ; **FLOATING
C102 pfet_01v8_lvt_W37p3_L0p74_m1__nf1_gboth_sdfull_pc/B.n109 VSUBS 0.00202f ; **FLOATING
C103 pfet_01v8_lvt_W37p3_L0p74_m1__nf1_gboth_sdfull_pc/B.n110 VSUBS 0.00202f ; **FLOATING
C104 pfet_01v8_lvt_W37p3_L0p74_m1__nf1_gboth_sdfull_pc/B.n111 VSUBS 0.00202f ; **FLOATING
C105 pfet_01v8_lvt_W37p3_L0p74_m1__nf1_gboth_sdfull_pc/B.n112 VSUBS 0.00202f ; **FLOATING
C106 pfet_01v8_lvt_W37p3_L0p74_m1__nf1_gboth_sdfull_pc/B.n113 VSUBS 0.00202f ; **FLOATING
C107 pfet_01v8_lvt_W37p3_L0p74_m1__nf1_gboth_sdfull_pc/B.n114 VSUBS 0.00202f ; **FLOATING
C108 pfet_01v8_lvt_W37p3_L0p74_m1__nf1_gboth_sdfull_pc/B.n116 VSUBS 0.00202f ; **FLOATING
C109 pfet_01v8_lvt_W37p3_L0p74_m1__nf1_gboth_sdfull_pc/B.n117 VSUBS 0.00202f ; **FLOATING
C110 pfet_01v8_lvt_W37p3_L0p74_m1__nf1_gboth_sdfull_pc/B.n118 VSUBS 0.00202f ; **FLOATING
C111 pfet_01v8_lvt_W37p3_L0p74_m1__nf1_gboth_sdfull_pc/B.n119 VSUBS 0.00202f ; **FLOATING
C112 pfet_01v8_lvt_W37p3_L0p74_m1__nf1_gboth_sdfull_pc/B.n120 VSUBS 0.00202f ; **FLOATING
C113 pfet_01v8_lvt_W37p3_L0p74_m1__nf1_gboth_sdfull_pc/B.n122 VSUBS 0.00202f ; **FLOATING
C114 pfet_01v8_lvt_W37p3_L0p74_m1__nf1_gboth_sdfull_pc/B.n123 VSUBS 0.00202f ; **FLOATING
C115 pfet_01v8_lvt_W37p3_L0p74_m1__nf1_gboth_sdfull_pc/B.n124 VSUBS 0.00202f ; **FLOATING
C116 pfet_01v8_lvt_W37p3_L0p74_m1__nf1_gboth_sdfull_pc/B.n125 VSUBS 0.00202f ; **FLOATING
C117 pfet_01v8_lvt_W37p3_L0p74_m1__nf1_gboth_sdfull_pc/B.n126 VSUBS 0.00202f ; **FLOATING
C118 pfet_01v8_lvt_W37p3_L0p74_m1__nf1_gboth_sdfull_pc/B.n127 VSUBS 0.00202f ; **FLOATING
C119 pfet_01v8_lvt_W37p3_L0p74_m1__nf1_gboth_sdfull_pc/B.n129 VSUBS 0.00202f ; **FLOATING
C120 pfet_01v8_lvt_W37p3_L0p74_m1__nf1_gboth_sdfull_pc/B.n130 VSUBS 0.00202f ; **FLOATING
C121 pfet_01v8_lvt_W37p3_L0p74_m1__nf1_gboth_sdfull_pc/B.n131 VSUBS 0.00202f ; **FLOATING
C122 pfet_01v8_lvt_W37p3_L0p74_m1__nf1_gboth_sdfull_pc/B.n132 VSUBS 0.00202f ; **FLOATING
C123 pfet_01v8_lvt_W37p3_L0p74_m1__nf1_gboth_sdfull_pc/B.n133 VSUBS 0.00202f ; **FLOATING
C124 pfet_01v8_lvt_W37p3_L0p74_m1__nf1_gboth_sdfull_pc/B.n135 VSUBS 0.00202f ; **FLOATING
C125 pfet_01v8_lvt_W37p3_L0p74_m1__nf1_gboth_sdfull_pc/B.n136 VSUBS 0.00202f ; **FLOATING
C126 pfet_01v8_lvt_W37p3_L0p74_m1__nf1_gboth_sdfull_pc/B.n138 VSUBS 0.00202f ; **FLOATING
C127 pfet_01v8_lvt_W37p3_L0p74_m1__nf1_gboth_sdfull_pc/B.n139 VSUBS 0.00202f ; **FLOATING
C128 pfet_01v8_lvt_W37p3_L0p74_m1__nf1_gboth_sdfull_pc/B.n140 VSUBS 0.00202f ; **FLOATING
C129 pfet_01v8_lvt_W37p3_L0p74_m1__nf1_gboth_sdfull_pc/B.n141 VSUBS 0.00202f ; **FLOATING
C130 pfet_01v8_lvt_W37p3_L0p74_m1__nf1_gboth_sdfull_pc/B.n142 VSUBS 0.00202f ; **FLOATING
C131 pfet_01v8_lvt_W37p3_L0p74_m1__nf1_gboth_sdfull_pc/B.n144 VSUBS 0.00202f ; **FLOATING
C132 pfet_01v8_lvt_W37p3_L0p74_m1__nf1_gboth_sdfull_pc/B.n145 VSUBS 0.00202f ; **FLOATING
C133 pfet_01v8_lvt_W37p3_L0p74_m1__nf1_gboth_sdfull_pc/B.n146 VSUBS 0.00202f ; **FLOATING
C134 pfet_01v8_lvt_W37p3_L0p74_m1__nf1_gboth_sdfull_pc/B.n147 VSUBS 0.00202f ; **FLOATING
C135 pfet_01v8_lvt_W37p3_L0p74_m1__nf1_gboth_sdfull_pc/B.n148 VSUBS 0.00202f ; **FLOATING
C136 pfet_01v8_lvt_W37p3_L0p74_m1__nf1_gboth_sdfull_pc/B.n149 VSUBS 0.00202f ; **FLOATING
C137 pfet_01v8_lvt_W37p3_L0p74_m1__nf1_gboth_sdfull_pc/B.n151 VSUBS 0.00202f ; **FLOATING
C138 pfet_01v8_lvt_W37p3_L0p74_m1__nf1_gboth_sdfull_pc/B.n152 VSUBS 0.00202f ; **FLOATING
C139 pfet_01v8_lvt_W37p3_L0p74_m1__nf1_gboth_sdfull_pc/B.n153 VSUBS 0.00202f ; **FLOATING
C140 pfet_01v8_lvt_W37p3_L0p74_m1__nf1_gboth_sdfull_pc/B.n154 VSUBS 0.00202f ; **FLOATING
C141 pfet_01v8_lvt_W37p3_L0p74_m1__nf1_gboth_sdfull_pc/B.n155 VSUBS 0.00202f ; **FLOATING
C142 pfet_01v8_lvt_W37p3_L0p74_m1__nf1_gboth_sdfull_pc/B.n157 VSUBS 0.00202f ; **FLOATING
C143 pfet_01v8_lvt_W37p3_L0p74_m1__nf1_gboth_sdfull_pc/B.n159 VSUBS 0.00202f ; **FLOATING
C144 pfet_01v8_lvt_W37p3_L0p74_m1__nf1_gboth_sdfull_pc/B.n160 VSUBS 0.00202f ; **FLOATING
C145 pfet_01v8_lvt_W37p3_L0p74_m1__nf1_gboth_sdfull_pc/B.n161 VSUBS 0.00202f ; **FLOATING
C146 pfet_01v8_lvt_W37p3_L0p74_m1__nf1_gboth_sdfull_pc/B.n162 VSUBS 0.00202f ; **FLOATING
C147 pfet_01v8_lvt_W37p3_L0p74_m1__nf1_gboth_sdfull_pc/B.n163 VSUBS 0.00202f ; **FLOATING
C148 pfet_01v8_lvt_W37p3_L0p74_m1__nf1_gboth_sdfull_pc/B.n165 VSUBS 0.00202f ; **FLOATING
C149 pfet_01v8_lvt_W37p3_L0p74_m1__nf1_gboth_sdfull_pc/B.n167 VSUBS 0.00202f ; **FLOATING
C150 pfet_01v8_lvt_W37p3_L0p74_m1__nf1_gboth_sdfull_pc/B.n168 VSUBS 0.00202f ; **FLOATING
C151 pfet_01v8_lvt_W37p3_L0p74_m1__nf1_gboth_sdfull_pc/B.n169 VSUBS 0.00202f ; **FLOATING
C152 pfet_01v8_lvt_W37p3_L0p74_m1__nf1_gboth_sdfull_pc/B.n170 VSUBS 0.00202f ; **FLOATING
C153 pfet_01v8_lvt_W37p3_L0p74_m1__nf1_gboth_sdfull_pc/B.n171 VSUBS 0.00202f ; **FLOATING
C154 pfet_01v8_lvt_W37p3_L0p74_m1__nf1_gboth_sdfull_pc/B.n173 VSUBS 0.00202f ; **FLOATING
C155 pfet_01v8_lvt_W37p3_L0p74_m1__nf1_gboth_sdfull_pc/B.n175 VSUBS 0.00202f ; **FLOATING
C156 pfet_01v8_lvt_W37p3_L0p74_m1__nf1_gboth_sdfull_pc/B.n176 VSUBS 0.00202f ; **FLOATING
C157 pfet_01v8_lvt_W37p3_L0p74_m1__nf1_gboth_sdfull_pc/B.n177 VSUBS 0.00202f ; **FLOATING
C158 pfet_01v8_lvt_W37p3_L0p74_m1__nf1_gboth_sdfull_pc/B.n178 VSUBS 0.00202f ; **FLOATING
C159 pfet_01v8_lvt_W37p3_L0p74_m1__nf1_gboth_sdfull_pc/B.n179 VSUBS 0.00202f ; **FLOATING
C160 pfet_01v8_lvt_W37p3_L0p74_m1__nf1_gboth_sdfull_pc/B.n181 VSUBS 0.00202f ; **FLOATING
C161 pfet_01v8_lvt_W37p3_L0p74_m1__nf1_gboth_sdfull_pc/B.n183 VSUBS 0.00202f ; **FLOATING
C162 pfet_01v8_lvt_W37p3_L0p74_m1__nf1_gboth_sdfull_pc/B.n184 VSUBS 0.00202f ; **FLOATING
C163 pfet_01v8_lvt_W37p3_L0p74_m1__nf1_gboth_sdfull_pc/B.n185 VSUBS 0.00202f ; **FLOATING
C164 pfet_01v8_lvt_W37p3_L0p74_m1__nf1_gboth_sdfull_pc/B.n186 VSUBS 0.00202f ; **FLOATING
C165 pfet_01v8_lvt_W37p3_L0p74_m1__nf1_gboth_sdfull_pc/B.n187 VSUBS 0.00202f ; **FLOATING
C166 pfet_01v8_lvt_W37p3_L0p74_m1__nf1_gboth_sdfull_pc/B.n189 VSUBS 0.00202f ; **FLOATING
C167 pfet_01v8_lvt_W37p3_L0p74_m1__nf1_gboth_sdfull_pc/B.n190 VSUBS 0.00202f ; **FLOATING
C168 pfet_01v8_lvt_W37p3_L0p74_m1__nf1_gboth_sdfull_pc/B.n191 VSUBS 0.00202f ; **FLOATING
C169 pfet_01v8_lvt_W37p3_L0p74_m1__nf1_gboth_sdfull_pc/B.n192 VSUBS 0.00202f ; **FLOATING
C170 pfet_01v8_lvt_W37p3_L0p74_m1__nf1_gboth_sdfull_pc/B.n193 VSUBS 0.00202f ; **FLOATING
C171 pfet_01v8_lvt_W37p3_L0p74_m1__nf1_gboth_sdfull_pc/B.n194 VSUBS 0.00202f ; **FLOATING
C172 pfet_01v8_lvt_W37p3_L0p74_m1__nf1_gboth_sdfull_pc/B.n196 VSUBS 0.00202f ; **FLOATING
C173 pfet_01v8_lvt_W37p3_L0p74_m1__nf1_gboth_sdfull_pc/B.n197 VSUBS 0.00202f ; **FLOATING
C174 pfet_01v8_lvt_W37p3_L0p74_m1__nf1_gboth_sdfull_pc/B.n198 VSUBS 0.00202f ; **FLOATING
C175 pfet_01v8_lvt_W37p3_L0p74_m1__nf1_gboth_sdfull_pc/B.n199 VSUBS 0.00202f ; **FLOATING
C176 pfet_01v8_lvt_W37p3_L0p74_m1__nf1_gboth_sdfull_pc/B.n200 VSUBS 0.00202f ; **FLOATING
C177 pfet_01v8_lvt_W37p3_L0p74_m1__nf1_gboth_sdfull_pc/B.n202 VSUBS 0.00202f ; **FLOATING
C178 pfet_01v8_lvt_W37p3_L0p74_m1__nf1_gboth_sdfull_pc/B.n203 VSUBS 0.00202f ; **FLOATING
C179 pfet_01v8_lvt_W37p3_L0p74_m1__nf1_gboth_sdfull_pc/B.n204 VSUBS 0.00202f ; **FLOATING
C180 pfet_01v8_lvt_W37p3_L0p74_m1__nf1_gboth_sdfull_pc/B.n205 VSUBS 0.00202f ; **FLOATING
C181 pfet_01v8_lvt_W37p3_L0p74_m1__nf1_gboth_sdfull_pc/B.n206 VSUBS 0.00202f ; **FLOATING
C182 pfet_01v8_lvt_W37p3_L0p74_m1__nf1_gboth_sdfull_pc/B.n207 VSUBS 0.00202f ; **FLOATING
C183 pfet_01v8_lvt_W37p3_L0p74_m1__nf1_gboth_sdfull_pc/B.n209 VSUBS 0.00202f ; **FLOATING
C184 pfet_01v8_lvt_W37p3_L0p74_m1__nf1_gboth_sdfull_pc/B.n210 VSUBS 0.00202f ; **FLOATING
C185 pfet_01v8_lvt_W37p3_L0p74_m1__nf1_gboth_sdfull_pc/B.n211 VSUBS 0.00202f ; **FLOATING
C186 pfet_01v8_lvt_W37p3_L0p74_m1__nf1_gboth_sdfull_pc/B.n212 VSUBS 0.00202f ; **FLOATING
C187 pfet_01v8_lvt_W37p3_L0p74_m1__nf1_gboth_sdfull_pc/B.n213 VSUBS 0.00202f ; **FLOATING
C188 pfet_01v8_lvt_W37p3_L0p74_m1__nf1_gboth_sdfull_pc/B.n215 VSUBS 0.00202f ; **FLOATING
C189 pfet_01v8_lvt_W37p3_L0p74_m1__nf1_gboth_sdfull_pc/B.n217 VSUBS 0.00202f ; **FLOATING
C190 pfet_01v8_lvt_W37p3_L0p74_m1__nf1_gboth_sdfull_pc/B.n218 VSUBS 0.00202f ; **FLOATING
C191 pfet_01v8_lvt_W37p3_L0p74_m1__nf1_gboth_sdfull_pc/B.n219 VSUBS 0.00202f ; **FLOATING
C192 pfet_01v8_lvt_W37p3_L0p74_m1__nf1_gboth_sdfull_pc/B.n220 VSUBS 0.00202f ; **FLOATING
C193 pfet_01v8_lvt_W37p3_L0p74_m1__nf1_gboth_sdfull_pc/B.n221 VSUBS 0.00202f ; **FLOATING
C194 pfet_01v8_lvt_W37p3_L0p74_m1__nf1_gboth_sdfull_pc/B.n223 VSUBS 0.00202f ; **FLOATING
C195 pfet_01v8_lvt_W37p3_L0p74_m1__nf1_gboth_sdfull_pc/B.n225 VSUBS 0.00202f ; **FLOATING
C196 pfet_01v8_lvt_W37p3_L0p74_m1__nf1_gboth_sdfull_pc/B.n226 VSUBS 0.00202f ; **FLOATING
C197 pfet_01v8_lvt_W37p3_L0p74_m1__nf1_gboth_sdfull_pc/B.n227 VSUBS 0.00202f ; **FLOATING
C198 pfet_01v8_lvt_W37p3_L0p74_m1__nf1_gboth_sdfull_pc/B.n228 VSUBS 0.00202f ; **FLOATING
C199 pfet_01v8_lvt_W37p3_L0p74_m1__nf1_gboth_sdfull_pc/B.n229 VSUBS 0.00202f ; **FLOATING
C200 pfet_01v8_lvt_W37p3_L0p74_m1__nf1_gboth_sdfull_pc/B.n231 VSUBS 0.00202f ; **FLOATING
C201 pfet_01v8_lvt_W37p3_L0p74_m1__nf1_gboth_sdfull_pc/B.n233 VSUBS 0.00202f ; **FLOATING
C202 pfet_01v8_lvt_W37p3_L0p74_m1__nf1_gboth_sdfull_pc/B.n234 VSUBS 0.00202f ; **FLOATING
C203 pfet_01v8_lvt_W37p3_L0p74_m1__nf1_gboth_sdfull_pc/B.n235 VSUBS 0.00202f ; **FLOATING
C204 pfet_01v8_lvt_W37p3_L0p74_m1__nf1_gboth_sdfull_pc/B.n236 VSUBS 0.00202f ; **FLOATING
C205 pfet_01v8_lvt_W37p3_L0p74_m1__nf1_gboth_sdfull_pc/B.n237 VSUBS 0.00202f ; **FLOATING
C206 pfet_01v8_lvt_W37p3_L0p74_m1__nf1_gboth_sdfull_pc/B.n239 VSUBS 0.00202f ; **FLOATING
C207 pfet_01v8_lvt_W37p3_L0p74_m1__nf1_gboth_sdfull_pc/B.n240 VSUBS 0.00202f ; **FLOATING
C208 pfet_01v8_lvt_W37p3_L0p74_m1__nf1_gboth_sdfull_pc/B.n241 VSUBS 0.00202f ; **FLOATING
C209 pfet_01v8_lvt_W37p3_L0p74_m1__nf1_gboth_sdfull_pc/B.n242 VSUBS 0.00202f ; **FLOATING
C210 pfet_01v8_lvt_W37p3_L0p74_m1__nf1_gboth_sdfull_pc/B.n243 VSUBS 0.00202f ; **FLOATING
C211 pfet_01v8_lvt_W37p3_L0p74_m1__nf1_gboth_sdfull_pc/B.n244 VSUBS 0.00202f ; **FLOATING
C212 pfet_01v8_lvt_W37p3_L0p74_m1__nf1_gboth_sdfull_pc/B.n246 VSUBS 0.00202f ; **FLOATING
C213 pfet_01v8_lvt_W37p3_L0p74_m1__nf1_gboth_sdfull_pc/B.n247 VSUBS 0.00202f ; **FLOATING
C214 pfet_01v8_lvt_W37p3_L0p74_m1__nf1_gboth_sdfull_pc/B.n248 VSUBS 0.00202f ; **FLOATING
C215 pfet_01v8_lvt_W37p3_L0p74_m1__nf1_gboth_sdfull_pc/B.n249 VSUBS 0.00202f ; **FLOATING
C216 pfet_01v8_lvt_W37p3_L0p74_m1__nf1_gboth_sdfull_pc/B.n250 VSUBS 0.00202f ; **FLOATING
C217 pfet_01v8_lvt_W37p3_L0p74_m1__nf1_gboth_sdfull_pc/B.n252 VSUBS 0.00202f ; **FLOATING
C218 pfet_01v8_lvt_W37p3_L0p74_m1__nf1_gboth_sdfull_pc/B.n254 VSUBS 0.00202f ; **FLOATING
C219 pfet_01v8_lvt_W37p3_L0p74_m1__nf1_gboth_sdfull_pc/B.n255 VSUBS 0.00202f ; **FLOATING
C220 pfet_01v8_lvt_W37p3_L0p74_m1__nf1_gboth_sdfull_pc/B.n256 VSUBS 0.00202f ; **FLOATING
C221 pfet_01v8_lvt_W37p3_L0p74_m1__nf1_gboth_sdfull_pc/B.n257 VSUBS 0.00202f ; **FLOATING
C222 pfet_01v8_lvt_W37p3_L0p74_m1__nf1_gboth_sdfull_pc/B.n258 VSUBS 0.00202f ; **FLOATING
C223 pfet_01v8_lvt_W37p3_L0p74_m1__nf1_gboth_sdfull_pc/B.n260 VSUBS 0.00202f ; **FLOATING
C224 pfet_01v8_lvt_W37p3_L0p74_m1__nf1_gboth_sdfull_pc/B.n261 VSUBS 0.00202f ; **FLOATING
C225 pfet_01v8_lvt_W37p3_L0p74_m1__nf1_gboth_sdfull_pc/B.n262 VSUBS 0.00202f ; **FLOATING
C226 pfet_01v8_lvt_W37p3_L0p74_m1__nf1_gboth_sdfull_pc/B.n263 VSUBS 0.00202f ; **FLOATING
C227 pfet_01v8_lvt_W37p3_L0p74_m1__nf1_gboth_sdfull_pc/B.n264 VSUBS 0.00202f ; **FLOATING
C228 pfet_01v8_lvt_W37p3_L0p74_m1__nf1_gboth_sdfull_pc/B.n265 VSUBS 0.00202f ; **FLOATING
C229 pfet_01v8_lvt_W37p3_L0p74_m1__nf1_gboth_sdfull_pc/B.n266 VSUBS 0.00202f ; **FLOATING
C230 pfet_01v8_lvt_W37p3_L0p74_m1__nf1_gboth_sdfull_pc/B.n267 VSUBS 0.00202f ; **FLOATING
C231 pfet_01v8_lvt_W37p3_L0p74_m1__nf1_gboth_sdfull_pc/B.n268 VSUBS 0.00202f ; **FLOATING
C232 pfet_01v8_lvt_W37p3_L0p74_m1__nf1_gboth_sdfull_pc/B.n269 VSUBS 0.00202f ; **FLOATING
C233 pfet_01v8_lvt_W37p3_L0p74_m1__nf1_gboth_sdfull_pc/B.n270 VSUBS 0.00202f ; **FLOATING
C234 pfet_01v8_lvt_W37p3_L0p74_m1__nf1_gboth_sdfull_pc/B.n272 VSUBS 0.00202f ; **FLOATING
C235 pfet_01v8_lvt_W37p3_L0p74_m1__nf1_gboth_sdfull_pc/B.n273 VSUBS 0.00202f ; **FLOATING
C236 pfet_01v8_lvt_W37p3_L0p74_m1__nf1_gboth_sdfull_pc/B.n274 VSUBS 0.00202f ; **FLOATING
C237 pfet_01v8_lvt_W37p3_L0p74_m1__nf1_gboth_sdfull_pc/B.n275 VSUBS 0.00202f ; **FLOATING
C238 pfet_01v8_lvt_W37p3_L0p74_m1__nf1_gboth_sdfull_pc/B.n276 VSUBS 0.00202f ; **FLOATING
C239 pfet_01v8_lvt_W37p3_L0p74_m1__nf1_gboth_sdfull_pc/B.n278 VSUBS 0.00202f ; **FLOATING
C240 pfet_01v8_lvt_W37p3_L0p74_m1__nf1_gboth_sdfull_pc/B.n280 VSUBS 0.00202f ; **FLOATING
C241 pfet_01v8_lvt_W37p3_L0p74_m1__nf1_gboth_sdfull_pc/B.n281 VSUBS 0.00202f ; **FLOATING
C242 pfet_01v8_lvt_W37p3_L0p74_m1__nf1_gboth_sdfull_pc/B.n282 VSUBS 0.00454f ; **FLOATING
C243 pfet_01v8_lvt_W37p3_L0p74_m1__nf1_gboth_sdfull_pc/B.n283 VSUBS 0.00452f ; **FLOATING
C244 pfet_01v8_lvt_W37p3_L0p74_m1__nf1_gboth_sdfull_pc/B.n284 VSUBS 0.00452f ; **FLOATING
C245 pfet_01v8_lvt_W37p3_L0p74_m1__nf1_gboth_sdfull_pc/B.n285 VSUBS 0.35198f ; **FLOATING
C246 pfet_01v8_lvt_W37p3_L0p74_m1__nf1_gboth_sdfull_pc/B.n286 VSUBS 0.6315f ; **FLOATING
C247 pfet_01v8_lvt_W37p3_L0p74_m1__nf1_gboth_sdfull_pc/B.n287 VSUBS 0.00452f ; **FLOATING
C248 pfet_01v8_lvt_W37p3_L0p74_m1__nf1_gboth_sdfull_pc/B.n288 VSUBS 0.00452f ; **FLOATING
C249 pfet_01v8_lvt_W37p3_L0p74_m1__nf1_gboth_sdfull_pc/B.n289 VSUBS 0.00202f ; **FLOATING
C250 pfet_01v8_lvt_W37p3_L0p74_m1__nf1_gboth_sdfull_pc/B.n290 VSUBS 0.00202f ; **FLOATING
C251 pfet_01v8_lvt_W37p3_L0p74_m1__nf1_gboth_sdfull_pc/B.n291 VSUBS 0.00202f ; **FLOATING
C252 pfet_01v8_lvt_W37p3_L0p74_m1__nf1_gboth_sdfull_pc/B.n294 VSUBS 0.00202f ; **FLOATING
C253 pfet_01v8_lvt_W37p3_L0p74_m1__nf1_gboth_sdfull_pc/B.n296 VSUBS 0.00202f ; **FLOATING
C254 pfet_01v8_lvt_W37p3_L0p74_m1__nf1_gboth_sdfull_pc/B.n299 VSUBS 0.00202f ; **FLOATING
C255 pfet_01v8_lvt_W37p3_L0p74_m1__nf1_gboth_sdfull_pc/B.n301 VSUBS 0.00202f ; **FLOATING
C256 pfet_01v8_lvt_W37p3_L0p74_m1__nf1_gboth_sdfull_pc/B.n307 VSUBS 0.00202f ; **FLOATING
C257 pfet_01v8_lvt_W37p3_L0p74_m1__nf1_gboth_sdfull_pc/B.n312 VSUBS 0.00202f ; **FLOATING
C258 pfet_01v8_lvt_W37p3_L0p74_m1__nf1_gboth_sdfull_pc/B.n315 VSUBS 0.00202f ; **FLOATING
C259 pfet_01v8_lvt_W37p3_L0p74_m1__nf1_gboth_sdfull_pc/B.n317 VSUBS 0.00202f ; **FLOATING
C260 pfet_01v8_lvt_W37p3_L0p74_m1__nf1_gboth_sdfull_pc/B.n320 VSUBS 0.00202f ; **FLOATING
C261 pfet_01v8_lvt_W37p3_L0p74_m1__nf1_gboth_sdfull_pc/B.n326 VSUBS 0.00454f ; **FLOATING
C262 pfet_01v8_lvt_W37p3_L0p74_m1__nf1_gboth_sdfull_pc/B.n329 VSUBS 0.00202f ; **FLOATING
C263 pfet_01v8_lvt_W37p3_L0p74_m1__nf1_gboth_sdfull_pc/B.n332 VSUBS 0.00202f ; **FLOATING
C264 pfet_01v8_lvt_W37p3_L0p74_m1__nf1_gboth_sdfull_pc/B.n335 VSUBS 0.00202f ; **FLOATING
C265 pfet_01v8_lvt_W37p3_L0p74_m1__nf1_gboth_sdfull_pc/B.n337 VSUBS 0.00202f ; **FLOATING
C266 pfet_01v8_lvt_W37p3_L0p74_m1__nf1_gboth_sdfull_pc/B.n340 VSUBS 0.00202f ; **FLOATING
C267 pfet_01v8_lvt_W37p3_L0p74_m1__nf1_gboth_sdfull_pc/B.n342 VSUBS 0.00202f ; **FLOATING
C268 pfet_01v8_lvt_W37p3_L0p74_m1__nf1_gboth_sdfull_pc/B.n347 VSUBS 0.00202f ; **FLOATING
C269 pfet_01v8_lvt_W37p3_L0p74_m1__nf1_gboth_sdfull_pc/B.n352 VSUBS 0.00202f ; **FLOATING
C270 pfet_01v8_lvt_W37p3_L0p74_m1__nf1_gboth_sdfull_pc/B.n354 VSUBS 0.00202f ; **FLOATING
C271 pfet_01v8_lvt_W37p3_L0p74_m1__nf1_gboth_sdfull_pc/B.n356 VSUBS 0.00202f ; **FLOATING
C272 pfet_01v8_lvt_W37p3_L0p74_m1__nf1_gboth_sdfull_pc/B.n357 VSUBS 0.00202f ; **FLOATING
C273 pfet_01v8_lvt_W37p3_L0p74_m1__nf1_gboth_sdfull_pc/B.n358 VSUBS 0.00202f ; **FLOATING
C274 pfet_01v8_lvt_W37p3_L0p74_m1__nf1_gboth_sdfull_pc/B.n359 VSUBS 0.00202f ; **FLOATING
C275 pfet_01v8_lvt_W37p3_L0p74_m1__nf1_gboth_sdfull_pc/B.n360 VSUBS 0.00202f ; **FLOATING
C276 pfet_01v8_lvt_W37p3_L0p74_m1__nf1_gboth_sdfull_pc/B.n361 VSUBS 0.00202f ; **FLOATING
C277 pfet_01v8_lvt_W37p3_L0p74_m1__nf1_gboth_sdfull_pc/B.n362 VSUBS 0.00202f ; **FLOATING
C278 pfet_01v8_lvt_W37p3_L0p74_m1__nf1_gboth_sdfull_pc/B.n363 VSUBS 0.00202f ; **FLOATING
C279 pfet_01v8_lvt_W37p3_L0p74_m1__nf1_gboth_sdfull_pc/B.n364 VSUBS 0.00202f ; **FLOATING
C280 pfet_01v8_lvt_W37p3_L0p74_m1__nf1_gboth_sdfull_pc/B.n365 VSUBS 0.00454f ; **FLOATING
C281 pfet_01v8_lvt_W37p3_L0p74_m1__nf1_gboth_sdfull_pc/B.n366 VSUBS 0.00202f ; **FLOATING
C282 pfet_01v8_lvt_W37p3_L0p74_m1__nf1_gboth_sdfull_pc/B.n367 VSUBS 0.00202f ; **FLOATING
C283 pfet_01v8_lvt_W37p3_L0p74_m1__nf1_gboth_sdfull_pc/B.n368 VSUBS 0.00202f ; **FLOATING
C284 pfet_01v8_lvt_W37p3_L0p74_m1__nf1_gboth_sdfull_pc/B.n369 VSUBS 0.00202f ; **FLOATING
C285 pfet_01v8_lvt_W37p3_L0p74_m1__nf1_gboth_sdfull_pc/B.n370 VSUBS 0.00202f ; **FLOATING
C286 pfet_01v8_lvt_W37p3_L0p74_m1__nf1_gboth_sdfull_pc/B.n371 VSUBS 0.00202f ; **FLOATING
C287 pfet_01v8_lvt_W37p3_L0p74_m1__nf1_gboth_sdfull_pc/B.n372 VSUBS 0.00202f ; **FLOATING
C288 pfet_01v8_lvt_W37p3_L0p74_m1__nf1_gboth_sdfull_pc/B.n373 VSUBS 0.00202f ; **FLOATING
C289 pfet_01v8_lvt_W37p3_L0p74_m1__nf1_gboth_sdfull_pc/B.n374 VSUBS 0.00202f ; **FLOATING
C290 pfet_01v8_lvt_W37p3_L0p74_m1__nf1_gboth_sdfull_pc/B.n375 VSUBS 0.00202f ; **FLOATING
C291 pfet_01v8_lvt_W37p3_L0p74_m1__nf1_gboth_sdfull_pc/B.n376 VSUBS 0.00202f ; **FLOATING
C292 pfet_01v8_lvt_W37p3_L0p74_m1__nf1_gboth_sdfull_pc/B.n377 VSUBS 0.00202f ; **FLOATING
C293 pfet_01v8_lvt_W37p3_L0p74_m1__nf1_gboth_sdfull_pc/B.n378 VSUBS 0.00202f ; **FLOATING
C294 pfet_01v8_lvt_W37p3_L0p74_m1__nf1_gboth_sdfull_pc/B.n379 VSUBS 0.00202f ; **FLOATING
C295 pfet_01v8_lvt_W37p3_L0p74_m1__nf1_gboth_sdfull_pc/B.n380 VSUBS 0.00202f ; **FLOATING
C296 pfet_01v8_lvt_W37p3_L0p74_m1__nf1_gboth_sdfull_pc/B.n381 VSUBS 0.00202f ; **FLOATING
C297 pfet_01v8_lvt_W37p3_L0p74_m1__nf1_gboth_sdfull_pc/B.n382 VSUBS 0.00202f ; **FLOATING
C298 pfet_01v8_lvt_W37p3_L0p74_m1__nf1_gboth_sdfull_pc/B.n383 VSUBS 0.00202f ; **FLOATING
C299 pfet_01v8_lvt_W37p3_L0p74_m1__nf1_gboth_sdfull_pc/B.n384 VSUBS 0.00202f ; **FLOATING
C300 pfet_01v8_lvt_W37p3_L0p74_m1__nf1_gboth_sdfull_pc/B.n385 VSUBS 0.00202f ; **FLOATING
C301 pfet_01v8_lvt_W37p3_L0p74_m1__nf1_gboth_sdfull_pc/B.n386 VSUBS 0.00202f ; **FLOATING
C302 pfet_01v8_lvt_W37p3_L0p74_m1__nf1_gboth_sdfull_pc/B.n387 VSUBS 0.00202f ; **FLOATING
C303 pfet_01v8_lvt_W37p3_L0p74_m1__nf1_gboth_sdfull_pc/B.n388 VSUBS 0.00202f ; **FLOATING
C304 pfet_01v8_lvt_W37p3_L0p74_m1__nf1_gboth_sdfull_pc/B.n389 VSUBS 0.00202f ; **FLOATING
C305 pfet_01v8_lvt_W37p3_L0p74_m1__nf1_gboth_sdfull_pc/B.n390 VSUBS 0.00202f ; **FLOATING
C306 pfet_01v8_lvt_W37p3_L0p74_m1__nf1_gboth_sdfull_pc/B.n391 VSUBS 0.00202f ; **FLOATING
C307 pfet_01v8_lvt_W37p3_L0p74_m1__nf1_gboth_sdfull_pc/B.n392 VSUBS 0.00202f ; **FLOATING
C308 pfet_01v8_lvt_W37p3_L0p74_m1__nf1_gboth_sdfull_pc/B.n393 VSUBS 0.00202f ; **FLOATING
C309 pfet_01v8_lvt_W37p3_L0p74_m1__nf1_gboth_sdfull_pc/B.n394 VSUBS 0.00202f ; **FLOATING
C310 pfet_01v8_lvt_W37p3_L0p74_m1__nf1_gboth_sdfull_pc/B.n395 VSUBS 0.00202f ; **FLOATING
C311 pfet_01v8_lvt_W37p3_L0p74_m1__nf1_gboth_sdfull_pc/B.n396 VSUBS 0.00202f ; **FLOATING
C312 pfet_01v8_lvt_W37p3_L0p74_m1__nf1_gboth_sdfull_pc/B.n397 VSUBS 0.00202f ; **FLOATING
C313 pfet_01v8_lvt_W37p3_L0p74_m1__nf1_gboth_sdfull_pc/B.n398 VSUBS 0.00202f ; **FLOATING
C314 pfet_01v8_lvt_W37p3_L0p74_m1__nf1_gboth_sdfull_pc/B.n399 VSUBS 0.00202f ; **FLOATING
C315 pfet_01v8_lvt_W37p3_L0p74_m1__nf1_gboth_sdfull_pc/B.n400 VSUBS 0.00202f ; **FLOATING
C316 pfet_01v8_lvt_W37p3_L0p74_m1__nf1_gboth_sdfull_pc/B.n401 VSUBS 0.00202f ; **FLOATING
C317 pfet_01v8_lvt_W37p3_L0p74_m1__nf1_gboth_sdfull_pc/B.n402 VSUBS 0.00202f ; **FLOATING
C318 pfet_01v8_lvt_W37p3_L0p74_m1__nf1_gboth_sdfull_pc/B.n403 VSUBS 0.00202f ; **FLOATING
C319 pfet_01v8_lvt_W37p3_L0p74_m1__nf1_gboth_sdfull_pc/B.n404 VSUBS 0.00202f ; **FLOATING
C320 pfet_01v8_lvt_W37p3_L0p74_m1__nf1_gboth_sdfull_pc/B.n405 VSUBS 0.00202f ; **FLOATING
C321 pfet_01v8_lvt_W37p3_L0p74_m1__nf1_gboth_sdfull_pc/B.n406 VSUBS 0.00202f ; **FLOATING
C322 pfet_01v8_lvt_W37p3_L0p74_m1__nf1_gboth_sdfull_pc/B.n407 VSUBS 0.00202f ; **FLOATING
C323 pfet_01v8_lvt_W37p3_L0p74_m1__nf1_gboth_sdfull_pc/B.n408 VSUBS 0.00202f ; **FLOATING
C324 pfet_01v8_lvt_W37p3_L0p74_m1__nf1_gboth_sdfull_pc/B.n409 VSUBS 0.00202f ; **FLOATING
C325 pfet_01v8_lvt_W37p3_L0p74_m1__nf1_gboth_sdfull_pc/B.n410 VSUBS 0.00202f ; **FLOATING
C326 pfet_01v8_lvt_W37p3_L0p74_m1__nf1_gboth_sdfull_pc/B.n411 VSUBS 0.00202f ; **FLOATING
C327 pfet_01v8_lvt_W37p3_L0p74_m1__nf1_gboth_sdfull_pc/B.n412 VSUBS 0.00202f ; **FLOATING
C328 pfet_01v8_lvt_W37p3_L0p74_m1__nf1_gboth_sdfull_pc/B.n413 VSUBS 0.00202f ; **FLOATING
C329 pfet_01v8_lvt_W37p3_L0p74_m1__nf1_gboth_sdfull_pc/B.n414 VSUBS 0.00202f ; **FLOATING
C330 pfet_01v8_lvt_W37p3_L0p74_m1__nf1_gboth_sdfull_pc/B.n415 VSUBS 0.00202f ; **FLOATING
C331 pfet_01v8_lvt_W37p3_L0p74_m1__nf1_gboth_sdfull_pc/B.n416 VSUBS 0.00202f ; **FLOATING
C332 pfet_01v8_lvt_W37p3_L0p74_m1__nf1_gboth_sdfull_pc/B.n417 VSUBS 0.00202f ; **FLOATING
C333 pfet_01v8_lvt_W37p3_L0p74_m1__nf1_gboth_sdfull_pc/B.n418 VSUBS 0.00202f ; **FLOATING
C334 pfet_01v8_lvt_W37p3_L0p74_m1__nf1_gboth_sdfull_pc/B.n419 VSUBS 0.00202f ; **FLOATING
C335 pfet_01v8_lvt_W37p3_L0p74_m1__nf1_gboth_sdfull_pc/B.n420 VSUBS 0.00202f ; **FLOATING
C336 pfet_01v8_lvt_W37p3_L0p74_m1__nf1_gboth_sdfull_pc/B.n421 VSUBS 0.00202f ; **FLOATING
C337 pfet_01v8_lvt_W37p3_L0p74_m1__nf1_gboth_sdfull_pc/B.n422 VSUBS 0.00202f ; **FLOATING
C338 pfet_01v8_lvt_W37p3_L0p74_m1__nf1_gboth_sdfull_pc/B.n423 VSUBS 0.00202f ; **FLOATING
C339 pfet_01v8_lvt_W37p3_L0p74_m1__nf1_gboth_sdfull_pc/B.n424 VSUBS 0.00202f ; **FLOATING
C340 pfet_01v8_lvt_W37p3_L0p74_m1__nf1_gboth_sdfull_pc/B.n425 VSUBS 0.00202f ; **FLOATING
C341 pfet_01v8_lvt_W37p3_L0p74_m1__nf1_gboth_sdfull_pc/B.n426 VSUBS 0.00202f ; **FLOATING
C342 pfet_01v8_lvt_W37p3_L0p74_m1__nf1_gboth_sdfull_pc/B.n427 VSUBS 0.00202f ; **FLOATING
C343 pfet_01v8_lvt_W37p3_L0p74_m1__nf1_gboth_sdfull_pc/B.n428 VSUBS 0.00202f ; **FLOATING
C344 pfet_01v8_lvt_W37p3_L0p74_m1__nf1_gboth_sdfull_pc/B.n429 VSUBS 0.00202f ; **FLOATING
C345 pfet_01v8_lvt_W37p3_L0p74_m1__nf1_gboth_sdfull_pc/B.n430 VSUBS 0.00202f ; **FLOATING
C346 pfet_01v8_lvt_W37p3_L0p74_m1__nf1_gboth_sdfull_pc/B.n431 VSUBS 0.00202f ; **FLOATING
C347 pfet_01v8_lvt_W37p3_L0p74_m1__nf1_gboth_sdfull_pc/B.n432 VSUBS 0.00202f ; **FLOATING
C348 pfet_01v8_lvt_W37p3_L0p74_m1__nf1_gboth_sdfull_pc/B.n433 VSUBS 0.00202f ; **FLOATING
C349 pfet_01v8_lvt_W37p3_L0p74_m1__nf1_gboth_sdfull_pc/B.n434 VSUBS 0.00202f ; **FLOATING
C350 pfet_01v8_lvt_W37p3_L0p74_m1__nf1_gboth_sdfull_pc/B.n435 VSUBS 0.00202f ; **FLOATING
C351 pfet_01v8_lvt_W37p3_L0p74_m1__nf1_gboth_sdfull_pc/B.n436 VSUBS 0.00202f ; **FLOATING
C352 pfet_01v8_lvt_W37p3_L0p74_m1__nf1_gboth_sdfull_pc/B.n437 VSUBS 0.00202f ; **FLOATING
C353 pfet_01v8_lvt_W37p3_L0p74_m1__nf1_gboth_sdfull_pc/B.n438 VSUBS 0.00202f ; **FLOATING
C354 pfet_01v8_lvt_W37p3_L0p74_m1__nf1_gboth_sdfull_pc/B.n439 VSUBS 0.00202f ; **FLOATING
C355 pfet_01v8_lvt_W37p3_L0p74_m1__nf1_gboth_sdfull_pc/B.n440 VSUBS 0.00202f ; **FLOATING
C356 pfet_01v8_lvt_W37p3_L0p74_m1__nf1_gboth_sdfull_pc/B.n441 VSUBS 0.00202f ; **FLOATING
C357 pfet_01v8_lvt_W37p3_L0p74_m1__nf1_gboth_sdfull_pc/B.n442 VSUBS 0.00202f ; **FLOATING
C358 pfet_01v8_lvt_W37p3_L0p74_m1__nf1_gboth_sdfull_pc/B.n443 VSUBS 0.00202f ; **FLOATING
C359 pfet_01v8_lvt_W37p3_L0p74_m1__nf1_gboth_sdfull_pc/B.n444 VSUBS 0.00202f ; **FLOATING
C360 pfet_01v8_lvt_W37p3_L0p74_m1__nf1_gboth_sdfull_pc/B.n445 VSUBS 0.00202f ; **FLOATING
C361 pfet_01v8_lvt_W37p3_L0p74_m1__nf1_gboth_sdfull_pc/B.n446 VSUBS 0.00202f ; **FLOATING
C362 pfet_01v8_lvt_W37p3_L0p74_m1__nf1_gboth_sdfull_pc/B.n447 VSUBS 0.00202f ; **FLOATING
C363 pfet_01v8_lvt_W37p3_L0p74_m1__nf1_gboth_sdfull_pc/B.n448 VSUBS 0.00202f ; **FLOATING
C364 pfet_01v8_lvt_W37p3_L0p74_m1__nf1_gboth_sdfull_pc/B.n449 VSUBS 0.00202f ; **FLOATING
C365 pfet_01v8_lvt_W37p3_L0p74_m1__nf1_gboth_sdfull_pc/B.n450 VSUBS 0.00202f ; **FLOATING
C366 pfet_01v8_lvt_W37p3_L0p74_m1__nf1_gboth_sdfull_pc/B.n451 VSUBS 0.00202f ; **FLOATING
C367 pfet_01v8_lvt_W37p3_L0p74_m1__nf1_gboth_sdfull_pc/B.n452 VSUBS 0.00202f ; **FLOATING
C368 pfet_01v8_lvt_W37p3_L0p74_m1__nf1_gboth_sdfull_pc/B.n453 VSUBS 0.00202f ; **FLOATING
C369 pfet_01v8_lvt_W37p3_L0p74_m1__nf1_gboth_sdfull_pc/B.n454 VSUBS 0.00202f ; **FLOATING
C370 pfet_01v8_lvt_W37p3_L0p74_m1__nf1_gboth_sdfull_pc/B.n455 VSUBS 0.00202f ; **FLOATING
C371 pfet_01v8_lvt_W37p3_L0p74_m1__nf1_gboth_sdfull_pc/B.n456 VSUBS 0.00202f ; **FLOATING
C372 pfet_01v8_lvt_W37p3_L0p74_m1__nf1_gboth_sdfull_pc/B.n457 VSUBS 0.00202f ; **FLOATING
C373 pfet_01v8_lvt_W37p3_L0p74_m1__nf1_gboth_sdfull_pc/B.n458 VSUBS 0.00202f ; **FLOATING
C374 pfet_01v8_lvt_W37p3_L0p74_m1__nf1_gboth_sdfull_pc/B.n459 VSUBS 0.00202f ; **FLOATING
C375 pfet_01v8_lvt_W37p3_L0p74_m1__nf1_gboth_sdfull_pc/B.n460 VSUBS 0.00202f ; **FLOATING
C376 pfet_01v8_lvt_W37p3_L0p74_m1__nf1_gboth_sdfull_pc/B.n461 VSUBS 0.00202f ; **FLOATING
C377 pfet_01v8_lvt_W37p3_L0p74_m1__nf1_gboth_sdfull_pc/B.n462 VSUBS 0.00202f ; **FLOATING
C378 pfet_01v8_lvt_W37p3_L0p74_m1__nf1_gboth_sdfull_pc/B.n463 VSUBS 0.00202f ; **FLOATING
C379 pfet_01v8_lvt_W37p3_L0p74_m1__nf1_gboth_sdfull_pc/B.n464 VSUBS 0.00202f ; **FLOATING
C380 pfet_01v8_lvt_W37p3_L0p74_m1__nf1_gboth_sdfull_pc/B.n465 VSUBS 0.00202f ; **FLOATING
C381 pfet_01v8_lvt_W37p3_L0p74_m1__nf1_gboth_sdfull_pc/B.n466 VSUBS 0.00202f ; **FLOATING
C382 pfet_01v8_lvt_W37p3_L0p74_m1__nf1_gboth_sdfull_pc/B.n467 VSUBS 0.00202f ; **FLOATING
C383 pfet_01v8_lvt_W37p3_L0p74_m1__nf1_gboth_sdfull_pc/B.n468 VSUBS 0.00202f ; **FLOATING
C384 pfet_01v8_lvt_W37p3_L0p74_m1__nf1_gboth_sdfull_pc/B.n469 VSUBS 0.00202f ; **FLOATING
C385 pfet_01v8_lvt_W37p3_L0p74_m1__nf1_gboth_sdfull_pc/B.n470 VSUBS 0.00202f ; **FLOATING
C386 pfet_01v8_lvt_W37p3_L0p74_m1__nf1_gboth_sdfull_pc/B.n471 VSUBS 0.00202f ; **FLOATING
C387 pfet_01v8_lvt_W37p3_L0p74_m1__nf1_gboth_sdfull_pc/B.n472 VSUBS 0.00202f ; **FLOATING
C388 pfet_01v8_lvt_W37p3_L0p74_m1__nf1_gboth_sdfull_pc/B.n473 VSUBS 0.00202f ; **FLOATING
C389 pfet_01v8_lvt_W37p3_L0p74_m1__nf1_gboth_sdfull_pc/B.n474 VSUBS 0.00202f ; **FLOATING
C390 pfet_01v8_lvt_W37p3_L0p74_m1__nf1_gboth_sdfull_pc/B.n475 VSUBS 0.00202f ; **FLOATING
C391 pfet_01v8_lvt_W37p3_L0p74_m1__nf1_gboth_sdfull_pc/B.n476 VSUBS 0.00202f ; **FLOATING
C392 pfet_01v8_lvt_W37p3_L0p74_m1__nf1_gboth_sdfull_pc/B.n477 VSUBS 0.00202f ; **FLOATING
C393 pfet_01v8_lvt_W37p3_L0p74_m1__nf1_gboth_sdfull_pc/B.n478 VSUBS 0.00202f ; **FLOATING
C394 pfet_01v8_lvt_W37p3_L0p74_m1__nf1_gboth_sdfull_pc/B.n479 VSUBS 0.00202f ; **FLOATING
C395 pfet_01v8_lvt_W37p3_L0p74_m1__nf1_gboth_sdfull_pc/B.n480 VSUBS 0.00202f ; **FLOATING
C396 pfet_01v8_lvt_W37p3_L0p74_m1__nf1_gboth_sdfull_pc/B.n481 VSUBS 0.00202f ; **FLOATING
C397 pfet_01v8_lvt_W37p3_L0p74_m1__nf1_gboth_sdfull_pc/B.n482 VSUBS 0.00202f ; **FLOATING
C398 pfet_01v8_lvt_W37p3_L0p74_m1__nf1_gboth_sdfull_pc/B.n483 VSUBS 0.00202f ; **FLOATING
C399 pfet_01v8_lvt_W37p3_L0p74_m1__nf1_gboth_sdfull_pc/B.n484 VSUBS 0.00202f ; **FLOATING
C400 pfet_01v8_lvt_W37p3_L0p74_m1__nf1_gboth_sdfull_pc/B.n485 VSUBS 0.00202f ; **FLOATING
C401 pfet_01v8_lvt_W37p3_L0p74_m1__nf1_gboth_sdfull_pc/B.n486 VSUBS 0.00202f ; **FLOATING
C402 pfet_01v8_lvt_W37p3_L0p74_m1__nf1_gboth_sdfull_pc/B.n487 VSUBS 0.00202f ; **FLOATING
C403 pfet_01v8_lvt_W37p3_L0p74_m1__nf1_gboth_sdfull_pc/B.n488 VSUBS 0.00202f ; **FLOATING
C404 pfet_01v8_lvt_W37p3_L0p74_m1__nf1_gboth_sdfull_pc/B.n489 VSUBS 0.00202f ; **FLOATING
C405 pfet_01v8_lvt_W37p3_L0p74_m1__nf1_gboth_sdfull_pc/B.n490 VSUBS 0.00202f ; **FLOATING
C406 pfet_01v8_lvt_W37p3_L0p74_m1__nf1_gboth_sdfull_pc/B.n491 VSUBS 0.00202f ; **FLOATING
C407 pfet_01v8_lvt_W37p3_L0p74_m1__nf1_gboth_sdfull_pc/B.n492 VSUBS 0.00202f ; **FLOATING
C408 pfet_01v8_lvt_W37p3_L0p74_m1__nf1_gboth_sdfull_pc/B.n493 VSUBS 0.00202f ; **FLOATING
C409 pfet_01v8_lvt_W37p3_L0p74_m1__nf1_gboth_sdfull_pc/B.n494 VSUBS 0.00202f ; **FLOATING
C410 pfet_01v8_lvt_W37p3_L0p74_m1__nf1_gboth_sdfull_pc/B.n495 VSUBS 0.00202f ; **FLOATING
C411 pfet_01v8_lvt_W37p3_L0p74_m1__nf1_gboth_sdfull_pc/B.n496 VSUBS 0.00202f ; **FLOATING
C412 pfet_01v8_lvt_W37p3_L0p74_m1__nf1_gboth_sdfull_pc/B.n497 VSUBS 0.00202f ; **FLOATING
C413 pfet_01v8_lvt_W37p3_L0p74_m1__nf1_gboth_sdfull_pc/B.n498 VSUBS 0.00202f ; **FLOATING
C414 pfet_01v8_lvt_W37p3_L0p74_m1__nf1_gboth_sdfull_pc/B.n499 VSUBS 0.00202f ; **FLOATING
C415 pfet_01v8_lvt_W37p3_L0p74_m1__nf1_gboth_sdfull_pc/B.n500 VSUBS 0.00202f ; **FLOATING
C416 pfet_01v8_lvt_W37p3_L0p74_m1__nf1_gboth_sdfull_pc/B.n501 VSUBS 0.00202f ; **FLOATING
C417 pfet_01v8_lvt_W37p3_L0p74_m1__nf1_gboth_sdfull_pc/B.n502 VSUBS 0.00202f ; **FLOATING
C418 pfet_01v8_lvt_W37p3_L0p74_m1__nf1_gboth_sdfull_pc/B.n503 VSUBS 0.00202f ; **FLOATING
C419 pfet_01v8_lvt_W37p3_L0p74_m1__nf1_gboth_sdfull_pc/B.n504 VSUBS 0.00202f ; **FLOATING
C420 pfet_01v8_lvt_W37p3_L0p74_m1__nf1_gboth_sdfull_pc/B.n505 VSUBS 0.00202f ; **FLOATING
C421 pfet_01v8_lvt_W37p3_L0p74_m1__nf1_gboth_sdfull_pc/B.n506 VSUBS 0.00202f ; **FLOATING
C422 pfet_01v8_lvt_W37p3_L0p74_m1__nf1_gboth_sdfull_pc/B.n507 VSUBS 0.00202f ; **FLOATING
C423 pfet_01v8_lvt_W37p3_L0p74_m1__nf1_gboth_sdfull_pc/B.n508 VSUBS 0.00202f ; **FLOATING
C424 pfet_01v8_lvt_W37p3_L0p74_m1__nf1_gboth_sdfull_pc/B.n509 VSUBS 0.00202f ; **FLOATING
C425 pfet_01v8_lvt_W37p3_L0p74_m1__nf1_gboth_sdfull_pc/B.n510 VSUBS 0.00202f ; **FLOATING
C426 pfet_01v8_lvt_W37p3_L0p74_m1__nf1_gboth_sdfull_pc/B.n511 VSUBS 0.00202f ; **FLOATING
C427 pfet_01v8_lvt_W37p3_L0p74_m1__nf1_gboth_sdfull_pc/B.n512 VSUBS 0.00202f ; **FLOATING
C428 pfet_01v8_lvt_W37p3_L0p74_m1__nf1_gboth_sdfull_pc/B.n513 VSUBS 0.00202f ; **FLOATING
C429 pfet_01v8_lvt_W37p3_L0p74_m1__nf1_gboth_sdfull_pc/B.n514 VSUBS 0.00202f ; **FLOATING
C430 pfet_01v8_lvt_W37p3_L0p74_m1__nf1_gboth_sdfull_pc/B.n515 VSUBS 0.00202f ; **FLOATING
C431 pfet_01v8_lvt_W37p3_L0p74_m1__nf1_gboth_sdfull_pc/B.n516 VSUBS 0.00202f ; **FLOATING
C432 pfet_01v8_lvt_W37p3_L0p74_m1__nf1_gboth_sdfull_pc/B.n517 VSUBS 0.00202f ; **FLOATING
C433 pfet_01v8_lvt_W37p3_L0p74_m1__nf1_gboth_sdfull_pc/B.n518 VSUBS 0.00202f ; **FLOATING
C434 pfet_01v8_lvt_W37p3_L0p74_m1__nf1_gboth_sdfull_pc/B.n519 VSUBS 0.00202f ; **FLOATING
C435 pfet_01v8_lvt_W37p3_L0p74_m1__nf1_gboth_sdfull_pc/B.n520 VSUBS 0.00202f ; **FLOATING
C436 pfet_01v8_lvt_W37p3_L0p74_m1__nf1_gboth_sdfull_pc/B.n521 VSUBS 0.00202f ; **FLOATING
C437 pfet_01v8_lvt_W37p3_L0p74_m1__nf1_gboth_sdfull_pc/B.n522 VSUBS 0.00202f ; **FLOATING
C438 pfet_01v8_lvt_W37p3_L0p74_m1__nf1_gboth_sdfull_pc/B.n523 VSUBS 0.00202f ; **FLOATING
C439 pfet_01v8_lvt_W37p3_L0p74_m1__nf1_gboth_sdfull_pc/B.n524 VSUBS 0.00202f ; **FLOATING
C440 pfet_01v8_lvt_W37p3_L0p74_m1__nf1_gboth_sdfull_pc/B.n525 VSUBS 0.00202f ; **FLOATING
C441 pfet_01v8_lvt_W37p3_L0p74_m1__nf1_gboth_sdfull_pc/B.n526 VSUBS 0.00202f ; **FLOATING
C442 pfet_01v8_lvt_W37p3_L0p74_m1__nf1_gboth_sdfull_pc/B.n527 VSUBS 0.00202f ; **FLOATING
C443 pfet_01v8_lvt_W37p3_L0p74_m1__nf1_gboth_sdfull_pc/B.n528 VSUBS 0.00202f ; **FLOATING
C444 pfet_01v8_lvt_W37p3_L0p74_m1__nf1_gboth_sdfull_pc/B.n529 VSUBS 0.00202f ; **FLOATING
C445 pfet_01v8_lvt_W37p3_L0p74_m1__nf1_gboth_sdfull_pc/B.n530 VSUBS 0.00202f ; **FLOATING
C446 pfet_01v8_lvt_W37p3_L0p74_m1__nf1_gboth_sdfull_pc/B.n531 VSUBS 0.00202f ; **FLOATING
C447 pfet_01v8_lvt_W37p3_L0p74_m1__nf1_gboth_sdfull_pc/B.n532 VSUBS 0.00202f ; **FLOATING
C448 pfet_01v8_lvt_W37p3_L0p74_m1__nf1_gboth_sdfull_pc/B.n533 VSUBS 0.00202f ; **FLOATING
C449 pfet_01v8_lvt_W37p3_L0p74_m1__nf1_gboth_sdfull_pc/B.n534 VSUBS 0.00202f ; **FLOATING
C450 pfet_01v8_lvt_W37p3_L0p74_m1__nf1_gboth_sdfull_pc/B.n535 VSUBS 0.00202f ; **FLOATING
C451 pfet_01v8_lvt_W37p3_L0p74_m1__nf1_gboth_sdfull_pc/B.n536 VSUBS 0.00202f ; **FLOATING
C452 pfet_01v8_lvt_W37p3_L0p74_m1__nf1_gboth_sdfull_pc/B.n537 VSUBS 0.00202f ; **FLOATING
C453 pfet_01v8_lvt_W37p3_L0p74_m1__nf1_gboth_sdfull_pc/B.n538 VSUBS 0.00202f ; **FLOATING
C454 pfet_01v8_lvt_W37p3_L0p74_m1__nf1_gboth_sdfull_pc/B.n539 VSUBS 0.00202f ; **FLOATING
C455 pfet_01v8_lvt_W37p3_L0p74_m1__nf1_gboth_sdfull_pc/B.n540 VSUBS 0.00202f ; **FLOATING
C456 pfet_01v8_lvt_W37p3_L0p74_m1__nf1_gboth_sdfull_pc/B.n541 VSUBS 0.00202f ; **FLOATING
C457 pfet_01v8_lvt_W37p3_L0p74_m1__nf1_gboth_sdfull_pc/B.n542 VSUBS 0.00202f ; **FLOATING
C458 pfet_01v8_lvt_W37p3_L0p74_m1__nf1_gboth_sdfull_pc/B.n543 VSUBS 0.00202f ; **FLOATING
C459 pfet_01v8_lvt_W37p3_L0p74_m1__nf1_gboth_sdfull_pc/B.n544 VSUBS 0.00202f ; **FLOATING
C460 pfet_01v8_lvt_W37p3_L0p74_m1__nf1_gboth_sdfull_pc/B.n545 VSUBS 0.00202f ; **FLOATING
C461 pfet_01v8_lvt_W37p3_L0p74_m1__nf1_gboth_sdfull_pc/B.n546 VSUBS 0.00202f ; **FLOATING
C462 pfet_01v8_lvt_W37p3_L0p74_m1__nf1_gboth_sdfull_pc/B.n547 VSUBS 0.00202f ; **FLOATING
C463 pfet_01v8_lvt_W37p3_L0p74_m1__nf1_gboth_sdfull_pc/B.n548 VSUBS 0.00202f ; **FLOATING
C464 pfet_01v8_lvt_W37p3_L0p74_m1__nf1_gboth_sdfull_pc/B.n549 VSUBS 0.00202f ; **FLOATING
C465 pfet_01v8_lvt_W37p3_L0p74_m1__nf1_gboth_sdfull_pc/B.n550 VSUBS 0.00202f ; **FLOATING
C466 pfet_01v8_lvt_W37p3_L0p74_m1__nf1_gboth_sdfull_pc/B.n551 VSUBS 0.00202f ; **FLOATING
C467 pfet_01v8_lvt_W37p3_L0p74_m1__nf1_gboth_sdfull_pc/B.n552 VSUBS 0.00202f ; **FLOATING
C468 pfet_01v8_lvt_W37p3_L0p74_m1__nf1_gboth_sdfull_pc/B.n553 VSUBS 0.00202f ; **FLOATING
C469 pfet_01v8_lvt_W37p3_L0p74_m1__nf1_gboth_sdfull_pc/B.n554 VSUBS 0.00202f ; **FLOATING
C470 pfet_01v8_lvt_W37p3_L0p74_m1__nf1_gboth_sdfull_pc/B.n555 VSUBS 0.00202f ; **FLOATING
C471 pfet_01v8_lvt_W37p3_L0p74_m1__nf1_gboth_sdfull_pc/B.n556 VSUBS 0.00202f ; **FLOATING
C472 pfet_01v8_lvt_W37p3_L0p74_m1__nf1_gboth_sdfull_pc/B.n557 VSUBS 0.76263f ; **FLOATING
C473 pfet_01v8_lvt_W37p3_L0p74_m1__nf1_gboth_sdfull_pc/B.n559 VSUBS 0.00454f ; **FLOATING
C474 pfet_01v8_lvt_W37p3_L0p74_m1__nf1_gboth_sdfull_pc/B.n560 VSUBS 0.00454f ; **FLOATING
C475 pfet_01v8_lvt_W37p3_L0p74_m1__nf1_gboth_sdfull_pc/B.n561 VSUBS 0.00452f ; **FLOATING
C476 pfet_01v8_lvt_W37p3_L0p74_m1__nf1_gboth_sdfull_pc/B.n562 VSUBS 0.00202f ; **FLOATING
C477 pfet_01v8_lvt_W37p3_L0p74_m1__nf1_gboth_sdfull_pc/B.n563 VSUBS 0.00202f ; **FLOATING
C478 pfet_01v8_lvt_W37p3_L0p74_m1__nf1_gboth_sdfull_pc/B.n564 VSUBS 0.35198f ; **FLOATING
C479 pfet_01v8_lvt_W37p3_L0p74_m1__nf1_gboth_sdfull_pc/B.n565 VSUBS 0.00202f ; **FLOATING
C480 pfet_01v8_lvt_W37p3_L0p74_m1__nf1_gboth_sdfull_pc/B.n566 VSUBS 0.00126f ; **FLOATING
C481 pfet_01v8_lvt_W37p3_L0p74_m1__nf1_gboth_sdfull_pc/G.n0 VSUBS 0.00804f ; **FLOATING
C482 pfet_01v8_lvt_W37p3_L0p74_m1__nf1_gboth_sdfull_pc/G.t0 VSUBS 2.7976f ; **FLOATING
C483 pfet_01v8_lvt_W37p3_L0p74_m1__nf1_gboth_sdfull_pc/G.n1 VSUBS 0.94774f ; **FLOATING
C484 pfet_01v8_lvt_W37p3_L0p74_m1__nf1_gboth_sdfull_pc/G.n2 VSUBS 0.00784f ; **FLOATING
