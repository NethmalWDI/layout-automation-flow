* NGSPICE file created from nfet_01v8_lvt_W66p13_L2p03_m1__nf1_gboth_sdhalf_ng.ext - technology: sky130A

.subckt nfet_01v8_lvt_W66p13_L2p03_m1__nf1_gboth_sdhalf_ng D S G B
X0 S G D B sky130_fd_pr__nfet_01v8_lvt ad=19.1777 pd=132.84 as=19.1777 ps=132.84 w=66.13 l=2.03
C0 D S 0.53175f
C1 S G 2.35636f
C2 D G 2.35636f
C3 S B 2.57792f
C4 D B 2.57792f
C5 G B 0.93575f
.ends
