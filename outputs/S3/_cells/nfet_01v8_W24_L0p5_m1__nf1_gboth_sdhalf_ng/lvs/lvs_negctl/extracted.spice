* NGSPICE file created from nfet_01v8_W24_L0p5_m1__nf1_gboth_sdhalf_ng.ext - technology: sky130A

.subckt sky130_fd_pr__nfet_01v8_XMAUS8 G D S VSUBS
X0 S G D VSUBS sky130_fd_pr__nfet_01v8 ad=6.96 pd=48.58 as=6.96 ps=48.58 w=24 l=0.5
.ends

.subckt nfet_01v8_W24_L0p5_m1__nf1_gboth_sdhalf_ng D S G B
Xnfet_01v8_W24_L0p5_m1__nf1_gboth_sdhalf_ng_pc G D S B sky130_fd_pr__nfet_01v8_XMAUS8
.ends
