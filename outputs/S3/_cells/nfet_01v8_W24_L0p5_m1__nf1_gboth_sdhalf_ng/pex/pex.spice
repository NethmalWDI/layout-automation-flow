* NGSPICE file created from nfet_01v8_W24_L0p5_m1__nf1_gboth_sdhalf_ng.ext - technology: sky130A

.subckt nfet_01v8_W24_L0p5_m1__nf1_gboth_sdhalf_ng D S G B
X0 S G D B sky130_fd_pr__nfet_01v8 ad=6.96 pd=48.58 as=6.96 ps=48.58 w=24 l=0.5
C0 G D 0.42877f
C1 D S 0.58661f
C2 G S 0.42877f
C3 S B 0.95168f
C4 D B 0.95168f
C5 G B 0.34969f
.ends
