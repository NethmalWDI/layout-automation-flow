* NGSPICE file created from pfet_01v8_lvt_W14p21_L0p89_m1__nf1_gboth_sdhalf_ng.ext - technology: sky130A

.subckt pfet_01v8_lvt_W14p21_L0p89_m1__nf1_gboth_sdhalf_ng D S G B
X0 S G D B sky130_fd_pr__pfet_01v8_lvt ad=4.1209 pd=29 as=4.1209 ps=29 w=14.21 l=0.89
C0 D B 0.13243f
C1 G B 0.18681f
C2 G D 0.36705f
C3 S B 0.13243f
C4 S D 0.233f
C5 S G 0.36705f
C6 S VSUBS 0.51031f
C7 D VSUBS 0.51031f
C8 G VSUBS 0.35644f
C9 B VSUBS 3.0744f
.ends
