* NGSPICE file created from pfet_01v8_lvt_W14p21_L0p89_m1__nf1_gboth_sdhalf_ng.ext - technology: sky130A

.subckt sky130_fd_pr__pfet_01v8_lvt_YNN8PB G D S w_n183_n1521#
X0 S G D w_n183_n1521# sky130_fd_pr__pfet_01v8_lvt ad=4.1209 pd=29 as=4.1209 ps=29 w=14.21 l=0.89
.ends

.subckt pfet_01v8_lvt_W14p21_L0p89_m1__nf1_gboth_sdhalf_ng D S G B
Xpfet_01v8_lvt_W14p21_L0p89_m1__nf1_gboth_sdhalf_ng_pc G D S B sky130_fd_pr__pfet_01v8_lvt_YNN8PB
.ends
