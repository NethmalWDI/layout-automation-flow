* NGSPICE file created from pfet_01v8_lvt_W887p03_L0p74_m1__nf16_gboth_sdfull_outS.ext - technology: sky130A

.subckt sky130_fd_pr__pfet_01v8_lvt_JYTM63 D10 S15 G S13 S11 B D8 D6 D4 D2 D0 a_1619_n5544#
+ S9 S7 S5 S3 D14 S1 D12
X0 S15 G D14 B sky130_fd_pr__pfet_01v8_lvt ad=8.0388 pd=55.73 as=8.0388 ps=55.73 w=55.44 l=0.74
X1 D2 G S1 B sky130_fd_pr__pfet_01v8_lvt ad=8.0388 pd=55.73 as=8.0388 ps=55.73 w=55.44 l=0.74
X2 S1 G D0 B sky130_fd_pr__pfet_01v8_lvt ad=8.0388 pd=55.73 as=16.0776 ps=111.46 w=55.44 l=0.74
X3 S5 G D4 B sky130_fd_pr__pfet_01v8_lvt ad=8.0388 pd=55.73 as=8.0388 ps=55.73 w=55.44 l=0.74
X4 D14 G S13 B sky130_fd_pr__pfet_01v8_lvt ad=8.0388 pd=55.73 as=8.0388 ps=55.73 w=55.44 l=0.74
X5 D4 G S3 B sky130_fd_pr__pfet_01v8_lvt ad=8.0388 pd=55.73 as=8.0388 ps=55.73 w=55.44 l=0.74
X6 S3 G D2 B sky130_fd_pr__pfet_01v8_lvt ad=8.0388 pd=55.73 as=8.0388 ps=55.73 w=55.44 l=0.74
X7 S13 G D12 B sky130_fd_pr__pfet_01v8_lvt ad=8.0388 pd=55.73 as=8.0388 ps=55.73 w=55.44 l=0.74
X8 D6 G S5 B sky130_fd_pr__pfet_01v8_lvt ad=8.0388 pd=55.73 as=8.0388 ps=55.73 w=55.44 l=0.74
X9 S7 G D6 B sky130_fd_pr__pfet_01v8_lvt ad=8.0388 pd=55.73 as=8.0388 ps=55.73 w=55.44 l=0.74
X10 S9 G D8 B sky130_fd_pr__pfet_01v8_lvt ad=8.0388 pd=55.73 as=8.0388 ps=55.73 w=55.44 l=0.74
X11 S11 G D10 B sky130_fd_pr__pfet_01v8_lvt ad=8.0388 pd=55.73 as=8.0388 ps=55.73 w=55.44 l=0.74
X12 D12 G S11 B sky130_fd_pr__pfet_01v8_lvt ad=8.0388 pd=55.73 as=8.0388 ps=55.73 w=55.44 l=0.74
X13 D8 G S7 B sky130_fd_pr__pfet_01v8_lvt ad=8.0388 pd=55.73 as=8.0388 ps=55.73 w=55.44 l=0.74
X14 a_1619_n5544# G S15 B sky130_fd_pr__pfet_01v8_lvt ad=16.0776 pd=111.46 as=8.0388 ps=55.73 w=55.44 l=0.74
X15 D10 G S9 B sky130_fd_pr__pfet_01v8_lvt ad=8.0388 pd=55.73 as=8.0388 ps=55.73 w=55.44 l=0.74
.ends

.subckt pfet_01v8_lvt_W887p03_L0p74_m1__nf16_gboth_sdfull_outS S D G B
Xpfet_01v8_lvt_W887p03_L0p74_m1__nf16_gboth_sdfull_outS_pc S D G D D B S S S S S S
+ D D D D S D S sky130_fd_pr__pfet_01v8_lvt_JYTM63
.ends
