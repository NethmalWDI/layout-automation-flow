* NGSPICE file created from pfet_01v8_W1p4_L0p6_m20__nf1_gtop_sdhalf_ng.ext - technology: sky130A

.subckt sky130_fd_pr__pfet_01v8_FGX5XW G D w_n154_n238# S
X0 S G D w_n154_n238# sky130_fd_pr__pfet_01v8 ad=0.406 pd=3.38 as=0.406 ps=3.38 w=1.4 l=0.6
.ends

.subckt pfet_01v8_W1p4_L0p6_m20__nf1_gtop_sdhalf_ng D S G B
Xpfet_01v8_W1p4_L0p6_m20__nf1_gtop_sdhalf_ng_pc G D B S sky130_fd_pr__pfet_01v8_FGX5XW
.ends
