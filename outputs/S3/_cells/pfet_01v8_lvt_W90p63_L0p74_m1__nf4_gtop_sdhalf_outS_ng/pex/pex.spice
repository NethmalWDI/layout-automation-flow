* NGSPICE file created from pfet_01v8_lvt_W90p63_L0p74_m1__nf4_gtop_sdhalf_outS_ng.ext - technology: sky130A

.subckt pfet_01v8_lvt_W90p63_L0p74_m1__nf4_gtop_sdhalf_outS_ng S D G B
X0 S G D B sky130_fd_pr__pfet_01v8_lvt ad=3.2857 pd=22.95 as=3.2857 ps=22.95 w=22.66 l=0.74
X1 S G D B sky130_fd_pr__pfet_01v8_lvt ad=6.5714 pd=45.9 as=3.2857 ps=22.95 w=22.66 l=0.74
X2 D G S B sky130_fd_pr__pfet_01v8_lvt ad=3.2857 pd=22.95 as=6.5714 ps=45.9 w=22.66 l=0.74
X3 D G S B sky130_fd_pr__pfet_01v8_lvt ad=3.2857 pd=22.95 as=3.2857 ps=22.95 w=22.66 l=0.74
C0 B S 0.66092f
C1 S G 2.36283f
C2 B G 0.42068f
C3 S D 1.99241f
C4 B D 0.50963f
C5 G D 2.36102f
C6 D VSUBS 0.0793f
C7 S VSUBS 1.67725f
C8 G VSUBS 0.70325f
C9 B VSUBS 9.4274f
.ends
