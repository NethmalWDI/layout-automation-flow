* NGSPICE file created from pfet_01v8_lvt_W887p03_L0p74_m1__nf1_gtop_sdfull.ext - technology: sky130A

.subckt pfet_01v8_lvt_W887p03_L0p74_m1__nf1_gtop_sdfull D S G B
X0 S G D B sky130_fd_pr__pfet_01v8_lvt ad=257.23871 pd=1.77464k as=257.23871 ps=1.77464k w=887.03003 l=0.74
C0 G D 40.7675f
C1 B D 51.2665f
C2 D S 33.0325f
C3 G B 0.25301f
C4 G S 40.7675f
C5 B S 51.2665f
C6 S VSUBS 23.6433f
C7 D VSUBS 23.6433f
C8 G VSUBS 0.09501f
C9 B VSUBS 0.35247p
.ends
