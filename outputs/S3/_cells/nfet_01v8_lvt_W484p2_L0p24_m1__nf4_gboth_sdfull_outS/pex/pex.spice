* NGSPICE file created from nfet_01v8_lvt_W484p2_L0p24_m1__nf4_gboth_sdfull_outS.ext - technology: sky130A

.subckt nfet_01v8_lvt_W484p2_L0p24_m1__nf4_gboth_sdfull_outS S D G B
X0 S G D B sky130_fd_pr__nfet_01v8_lvt ad=35.1045 pd=242.67999 as=17.55225 ps=121.34 w=121.05 l=0.24
X1 D G S B sky130_fd_pr__nfet_01v8_lvt ad=17.55225 pd=121.34 as=17.55225 ps=121.34 w=121.05 l=0.24
X2 D G S B sky130_fd_pr__nfet_01v8_lvt ad=17.55225 pd=121.34 as=35.1045 ps=242.67999 w=121.05 l=0.24
X3 S G D B sky130_fd_pr__nfet_01v8_lvt ad=17.55225 pd=121.34 as=17.55225 ps=121.34 w=121.05 l=0.24
C0 S D 34.94498f
C1 G D 9.68174f
C2 S G 9.68493f
C3 D B 0.00889f
C4 S B 18.45504f
C5 G B 1.13247f
.ends
