* NGSPICE file created from pfet_01v8_lvt_W14p21_L0p89_m1__nf4_gtop_sdhalf_outS_ng.ext - technology: sky130A

.subckt pfet_01v8_lvt_W14p21_L0p89_m1__nf4_gtop_sdhalf_outS_ng S D G B
X0 D G S B sky130_fd_pr__pfet_01v8_lvt ad=0.51475 pd=3.84 as=1.0295 ps=7.68 w=3.55 l=0.89
X1 S G D B sky130_fd_pr__pfet_01v8_lvt ad=1.0295 pd=7.68 as=0.51475 ps=3.84 w=3.55 l=0.89
X2 D G S B sky130_fd_pr__pfet_01v8_lvt ad=0.51475 pd=3.84 as=0.51475 ps=3.84 w=3.55 l=0.89
X3 S G D B sky130_fd_pr__pfet_01v8_lvt ad=0.51475 pd=3.84 as=0.51475 ps=3.84 w=3.55 l=0.89
C0 D G 0.53792f
C1 G S 0.5628f
C2 D S 0.58217f
C3 G B 0.46565f
C4 D B 0.09059f
C5 B S 0.11391f
C6 D VSUBS 0.15264f
C7 S VSUBS 0.43223f
C8 G VSUBS 0.84782f
C9 B VSUBS 2.80958f
.ends
