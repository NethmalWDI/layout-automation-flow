* NGSPICE file created from pfet_01v8_lvt_W887p03_L0p74_m1__nf2_gboth_sdhalf_outD_ng.ext - technology: sky130A

.subckt pfet_01v8_lvt_W887p03_L0p74_m1__nf2_gboth_sdhalf_outD_ng S D G B
X0 D G S B sky130_fd_pr__pfet_01v8_lvt ad=128.6208 pd=887.62 as=64.3104 ps=443.81 w=443.51999 l=0.74
X1 S G D B sky130_fd_pr__pfet_01v8_lvt ad=64.3104 pd=443.81 as=128.6208 ps=887.62 w=443.51999 l=0.74
C0 G B 0.33175f
C1 S G 20.54485f
C2 S B 4.79574f
C3 G D 20.54485f
C4 D B 7.7396f
C5 S D 16.6893f
C6 S VSUBS 0.04802f
C7 D VSUBS 31.17388f
C8 G VSUBS 0.63421f
C9 B VSUBS 0.13932p
.ends
