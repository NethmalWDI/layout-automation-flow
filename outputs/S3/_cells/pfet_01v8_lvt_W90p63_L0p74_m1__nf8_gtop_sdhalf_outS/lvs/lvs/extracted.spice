* NGSPICE file created from pfet_01v8_lvt_W90p63_L0p74_m1__nf8_gtop_sdhalf_outS.ext - technology: sky130A

.subckt sky130_fd_pr__pfet_01v8_lvt_VAJYMV G B a_795_n1169# D6 D4 D2 D0 S7 S5 S3 S1
X0 D2 G S1 B sky130_fd_pr__pfet_01v8_lvt ad=1.64285 pd=11.62 as=1.64285 ps=11.62 w=11.33 l=0.74
X1 S5 G D4 B sky130_fd_pr__pfet_01v8_lvt ad=1.64285 pd=11.62 as=1.64285 ps=11.62 w=11.33 l=0.74
X2 S7 G D6 B sky130_fd_pr__pfet_01v8_lvt ad=1.64285 pd=11.62 as=1.64285 ps=11.62 w=11.33 l=0.74
X3 a_795_n1169# G S7 B sky130_fd_pr__pfet_01v8_lvt ad=3.2857 pd=23.24 as=1.64285 ps=11.62 w=11.33 l=0.74
X4 D4 G S3 B sky130_fd_pr__pfet_01v8_lvt ad=1.64285 pd=11.62 as=1.64285 ps=11.62 w=11.33 l=0.74
X5 D6 G S5 B sky130_fd_pr__pfet_01v8_lvt ad=1.64285 pd=11.62 as=1.64285 ps=11.62 w=11.33 l=0.74
X6 S1 G D0 B sky130_fd_pr__pfet_01v8_lvt ad=1.64285 pd=11.62 as=3.2857 ps=23.24 w=11.33 l=0.74
X7 S3 G D2 B sky130_fd_pr__pfet_01v8_lvt ad=1.64285 pd=11.62 as=1.64285 ps=11.62 w=11.33 l=0.74
.ends

.subckt pfet_01v8_lvt_W90p63_L0p74_m1__nf8_gtop_sdhalf_outS S D G B
Xpfet_01v8_lvt_W90p63_L0p74_m1__nf8_gtop_sdhalf_outS_pc G B S S S S S D D D D sky130_fd_pr__pfet_01v8_lvt_VAJYMV
.ends
