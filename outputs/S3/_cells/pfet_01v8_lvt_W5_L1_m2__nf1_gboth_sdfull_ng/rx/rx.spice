* NGSPICE file created from pfet_01v8_lvt_W5_L1_m2__nf1_gboth_sdfull_ng.ext - technology: sky130A

X0 pfet_01v8_lvt_W5_L1_m2__nf1_gboth_sdfull_ng_pc/S.t0 G pfet_01v8_lvt_W5_L1_m2__nf1_gboth_sdfull_ng_pc/D.t0 B sky130_fd_pr__pfet_01v8_lvt ad=1.45 pd=10.58 as=1.45 ps=10.58 w=5 l=1
C0 S D 0.14835f
C1 G D 0.27238f
C2 S B 0.09947f
C3 G B 0.19709f
C4 B D 0.09947f
C5 S G 0.27238f
R0 pfet_01v8_lvt_W5_L1_m2__nf1_gboth_sdfull_ng_pc/S.t0 pfet_01v8_lvt_W5_L1_m2__nf1_gboth_sdfull_ng_pc/S.n0 384.339
R1 pfet_01v8_lvt_W5_L1_m2__nf1_gboth_sdfull_ng_pc/S.n1 pfet_01v8_lvt_W5_L1_m2__nf1_gboth_sdfull_ng_pc/S.t0 384.339
R2 S pfet_01v8_lvt_W5_L1_m2__nf1_gboth_sdfull_ng_pc/S.n0 16.5167
R3 S pfet_01v8_lvt_W5_L1_m2__nf1_gboth_sdfull_ng_pc/S.n1 16.5167
R4 pfet_01v8_lvt_W5_L1_m2__nf1_gboth_sdfull_ng_pc/S.n1 S 4.47291
R5 S pfet_01v8_lvt_W5_L1_m2__nf1_gboth_sdfull_ng_pc/S.n0 4.36965
R6 pfet_01v8_lvt_W5_L1_m2__nf1_gboth_sdfull_ng_pc/D.t0 pfet_01v8_lvt_W5_L1_m2__nf1_gboth_sdfull_ng_pc/D.n0 384.339
R7 pfet_01v8_lvt_W5_L1_m2__nf1_gboth_sdfull_ng_pc/D.n1 pfet_01v8_lvt_W5_L1_m2__nf1_gboth_sdfull_ng_pc/D.t0 384.339
R8 D pfet_01v8_lvt_W5_L1_m2__nf1_gboth_sdfull_ng_pc/D.n0 16.5167
R9 D pfet_01v8_lvt_W5_L1_m2__nf1_gboth_sdfull_ng_pc/D.n1 16.5167
R10 pfet_01v8_lvt_W5_L1_m2__nf1_gboth_sdfull_ng_pc/D.n1 D 4.47291
R11 D pfet_01v8_lvt_W5_L1_m2__nf1_gboth_sdfull_ng_pc/D.n0 4.36965
C6 S VSUBS 0.79354f
C7 D VSUBS 0.79361f
C8 G VSUBS 0.36527f
C9 B VSUBS 1.3968f
C10 pfet_01v8_lvt_W5_L1_m2__nf1_gboth_sdfull_ng_pc/D.n0 VSUBS 0.02667f ; **FLOATING
C11 pfet_01v8_lvt_W5_L1_m2__nf1_gboth_sdfull_ng_pc/D.t0 VSUBS 0.04816f ; **FLOATING
C12 pfet_01v8_lvt_W5_L1_m2__nf1_gboth_sdfull_ng_pc/D.n1 VSUBS 0.03142f ; **FLOATING
C13 pfet_01v8_lvt_W5_L1_m2__nf1_gboth_sdfull_ng_pc/S.n0 VSUBS 0.02667f ; **FLOATING
C14 pfet_01v8_lvt_W5_L1_m2__nf1_gboth_sdfull_ng_pc/S.t0 VSUBS 0.04816f ; **FLOATING
C15 pfet_01v8_lvt_W5_L1_m2__nf1_gboth_sdfull_ng_pc/S.n1 VSUBS 0.03142f ; **FLOATING
