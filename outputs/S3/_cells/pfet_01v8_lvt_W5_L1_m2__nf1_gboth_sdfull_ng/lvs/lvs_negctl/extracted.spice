* NGSPICE file created from pfet_01v8_lvt_W5_L1_m2__nf1_gboth_sdfull_ng.ext - technology: sky130A

.subckt sky130_fd_pr__pfet_01v8_lvt_AYWKR6 G D w_n194_n600# S
X0 S G D w_n194_n600# sky130_fd_pr__pfet_01v8_lvt ad=1.45 pd=10.58 as=1.45 ps=10.58 w=5 l=1
.ends

.subckt pfet_01v8_lvt_W5_L1_m2__nf1_gboth_sdfull_ng D S G B
Xpfet_01v8_lvt_W5_L1_m2__nf1_gboth_sdfull_ng_pc G D B S sky130_fd_pr__pfet_01v8_lvt_AYWKR6
.ends
