* NGSPICE file created from pfet_01v8_W8_L1_m1__nf2_gboth_sdhalf_outD.ext - technology: sky130A

.subckt sky130_fd_pr__pfet_01v8_GST8CF G B D0 a_229_n400# S1
X0 S1 G D0 B sky130_fd_pr__pfet_01v8 ad=0.58 pd=4.29 as=1.16 ps=8.58 w=4 l=1
X1 a_229_n400# G S1 B sky130_fd_pr__pfet_01v8 ad=1.16 pd=8.58 as=0.58 ps=4.29 w=4 l=1
.ends

.subckt pfet_01v8_W8_L1_m1__nf2_gboth_sdhalf_outD S D G B
Xpfet_01v8_W8_L1_m1__nf2_gboth_sdhalf_outD_pc G B D D S sky130_fd_pr__pfet_01v8_GST8CF
.ends
