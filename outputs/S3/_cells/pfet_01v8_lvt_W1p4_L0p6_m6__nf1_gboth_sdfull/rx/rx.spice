* NGSPICE file created from pfet_01v8_lvt_W1p4_L0p6_m6__nf1_gboth_sdfull.ext - technology: sky130A

X0 S G D pfet_01v8_lvt_W1p4_L0p6_m6__nf1_gboth_sdfull_pc/B.t0 sky130_fd_pr__pfet_01v8_lvt ad=0.406 pd=3.38 as=0.406 ps=3.38 w=1.4 l=0.6
C0 B S 0.09677f
C1 D G 0.05758f
C2 D S 0.06099f
C3 G S 0.05758f
C4 B D 0.09677f
C5 B G 0.29689f
R0 pfet_01v8_lvt_W1p4_L0p6_m6__nf1_gboth_sdfull_pc/B.n26 pfet_01v8_lvt_W1p4_L0p6_m6__nf1_gboth_sdfull_pc/B.n10 656.471
R1 pfet_01v8_lvt_W1p4_L0p6_m6__nf1_gboth_sdfull_pc/B.n37 pfet_01v8_lvt_W1p4_L0p6_m6__nf1_gboth_sdfull_pc/B.n3 656.471
R2 pfet_01v8_lvt_W1p4_L0p6_m6__nf1_gboth_sdfull_pc/B.n48 pfet_01v8_lvt_W1p4_L0p6_m6__nf1_gboth_sdfull_pc/B.n6 656.471
R3 pfet_01v8_lvt_W1p4_L0p6_m6__nf1_gboth_sdfull_pc/B.n29 pfet_01v8_lvt_W1p4_L0p6_m6__nf1_gboth_sdfull_pc/B.n8 656.471
R4 pfet_01v8_lvt_W1p4_L0p6_m6__nf1_gboth_sdfull_pc/B.n22 pfet_01v8_lvt_W1p4_L0p6_m6__nf1_gboth_sdfull_pc/B.n10 240
R5 pfet_01v8_lvt_W1p4_L0p6_m6__nf1_gboth_sdfull_pc/B.n20 pfet_01v8_lvt_W1p4_L0p6_m6__nf1_gboth_sdfull_pc/B.n19 240
R6 pfet_01v8_lvt_W1p4_L0p6_m6__nf1_gboth_sdfull_pc/B.n17 pfet_01v8_lvt_W1p4_L0p6_m6__nf1_gboth_sdfull_pc/B.n14 240
R7 pfet_01v8_lvt_W1p4_L0p6_m6__nf1_gboth_sdfull_pc/B.n54 pfet_01v8_lvt_W1p4_L0p6_m6__nf1_gboth_sdfull_pc/B.n3 240
R8 pfet_01v8_lvt_W1p4_L0p6_m6__nf1_gboth_sdfull_pc/B.n54 pfet_01v8_lvt_W1p4_L0p6_m6__nf1_gboth_sdfull_pc/B.n2 240
R9 pfet_01v8_lvt_W1p4_L0p6_m6__nf1_gboth_sdfull_pc/B.n26 pfet_01v8_lvt_W1p4_L0p6_m6__nf1_gboth_sdfull_pc/B.n2 240
R10 pfet_01v8_lvt_W1p4_L0p6_m6__nf1_gboth_sdfull_pc/B.n41 pfet_01v8_lvt_W1p4_L0p6_m6__nf1_gboth_sdfull_pc/B.n40 240
R11 pfet_01v8_lvt_W1p4_L0p6_m6__nf1_gboth_sdfull_pc/B.n45 pfet_01v8_lvt_W1p4_L0p6_m6__nf1_gboth_sdfull_pc/B.n36 240
R12 pfet_01v8_lvt_W1p4_L0p6_m6__nf1_gboth_sdfull_pc/B.n45 pfet_01v8_lvt_W1p4_L0p6_m6__nf1_gboth_sdfull_pc/B.n33 240
R13 pfet_01v8_lvt_W1p4_L0p6_m6__nf1_gboth_sdfull_pc/B.n52 pfet_01v8_lvt_W1p4_L0p6_m6__nf1_gboth_sdfull_pc/B.n6 240
R14 pfet_01v8_lvt_W1p4_L0p6_m6__nf1_gboth_sdfull_pc/B.n52 pfet_01v8_lvt_W1p4_L0p6_m6__nf1_gboth_sdfull_pc/B.n5 240
R15 pfet_01v8_lvt_W1p4_L0p6_m6__nf1_gboth_sdfull_pc/B.n29 pfet_01v8_lvt_W1p4_L0p6_m6__nf1_gboth_sdfull_pc/B.n5 240
R16 pfet_01v8_lvt_W1p4_L0p6_m6__nf1_gboth_sdfull_pc/B.n28 pfet_01v8_lvt_W1p4_L0p6_m6__nf1_gboth_sdfull_pc/B.n26 185
R17 pfet_01v8_lvt_W1p4_L0p6_m6__nf1_gboth_sdfull_pc/B.n26 pfet_01v8_lvt_W1p4_L0p6_m6__nf1_gboth_sdfull_pc/B.n25 185
R18 pfet_01v8_lvt_W1p4_L0p6_m6__nf1_gboth_sdfull_pc/B.n27 pfet_01v8_lvt_W1p4_L0p6_m6__nf1_gboth_sdfull_pc/B.n2 185
R19 pfet_01v8_lvt_W1p4_L0p6_m6__nf1_gboth_sdfull_pc/B.n2 pfet_01v8_lvt_W1p4_L0p6_m6__nf1_gboth_sdfull_pc/B.n0 185
R20 pfet_01v8_lvt_W1p4_L0p6_m6__nf1_gboth_sdfull_pc/B.n54 pfet_01v8_lvt_W1p4_L0p6_m6__nf1_gboth_sdfull_pc/B.n53 185
R21 pfet_01v8_lvt_W1p4_L0p6_m6__nf1_gboth_sdfull_pc/B.n55 pfet_01v8_lvt_W1p4_L0p6_m6__nf1_gboth_sdfull_pc/B.n54 185
R22 pfet_01v8_lvt_W1p4_L0p6_m6__nf1_gboth_sdfull_pc/B.n4 pfet_01v8_lvt_W1p4_L0p6_m6__nf1_gboth_sdfull_pc/B.n3 185
R23 pfet_01v8_lvt_W1p4_L0p6_m6__nf1_gboth_sdfull_pc/B.n3 pfet_01v8_lvt_W1p4_L0p6_m6__nf1_gboth_sdfull_pc/B.n1 185
R24 pfet_01v8_lvt_W1p4_L0p6_m6__nf1_gboth_sdfull_pc/B.n38 pfet_01v8_lvt_W1p4_L0p6_m6__nf1_gboth_sdfull_pc/B.n37 185
R25 pfet_01v8_lvt_W1p4_L0p6_m6__nf1_gboth_sdfull_pc/B.n40 pfet_01v8_lvt_W1p4_L0p6_m6__nf1_gboth_sdfull_pc/B.n39 185
R26 pfet_01v8_lvt_W1p4_L0p6_m6__nf1_gboth_sdfull_pc/B.n42 pfet_01v8_lvt_W1p4_L0p6_m6__nf1_gboth_sdfull_pc/B.n41 185
R27 pfet_01v8_lvt_W1p4_L0p6_m6__nf1_gboth_sdfull_pc/B.n43 pfet_01v8_lvt_W1p4_L0p6_m6__nf1_gboth_sdfull_pc/B.n36 185
R28 pfet_01v8_lvt_W1p4_L0p6_m6__nf1_gboth_sdfull_pc/B.n46 pfet_01v8_lvt_W1p4_L0p6_m6__nf1_gboth_sdfull_pc/B.n45 185
R29 pfet_01v8_lvt_W1p4_L0p6_m6__nf1_gboth_sdfull_pc/B.n45 pfet_01v8_lvt_W1p4_L0p6_m6__nf1_gboth_sdfull_pc/B.n44 185
R30 pfet_01v8_lvt_W1p4_L0p6_m6__nf1_gboth_sdfull_pc/B.n33 pfet_01v8_lvt_W1p4_L0p6_m6__nf1_gboth_sdfull_pc/B.n32 185
R31 pfet_01v8_lvt_W1p4_L0p6_m6__nf1_gboth_sdfull_pc/B.n49 pfet_01v8_lvt_W1p4_L0p6_m6__nf1_gboth_sdfull_pc/B.n48 185
R32 pfet_01v8_lvt_W1p4_L0p6_m6__nf1_gboth_sdfull_pc/B.n6 pfet_01v8_lvt_W1p4_L0p6_m6__nf1_gboth_sdfull_pc/B.n4 185
R33 pfet_01v8_lvt_W1p4_L0p6_m6__nf1_gboth_sdfull_pc/B.n50 pfet_01v8_lvt_W1p4_L0p6_m6__nf1_gboth_sdfull_pc/B.n6 185
R34 pfet_01v8_lvt_W1p4_L0p6_m6__nf1_gboth_sdfull_pc/B.n53 pfet_01v8_lvt_W1p4_L0p6_m6__nf1_gboth_sdfull_pc/B.n52 185
R35 pfet_01v8_lvt_W1p4_L0p6_m6__nf1_gboth_sdfull_pc/B.n52 pfet_01v8_lvt_W1p4_L0p6_m6__nf1_gboth_sdfull_pc/B.n51 185
R36 pfet_01v8_lvt_W1p4_L0p6_m6__nf1_gboth_sdfull_pc/B.n27 pfet_01v8_lvt_W1p4_L0p6_m6__nf1_gboth_sdfull_pc/B.n5 185
R37 pfet_01v8_lvt_W1p4_L0p6_m6__nf1_gboth_sdfull_pc/B.n31 pfet_01v8_lvt_W1p4_L0p6_m6__nf1_gboth_sdfull_pc/B.n5 185
R38 pfet_01v8_lvt_W1p4_L0p6_m6__nf1_gboth_sdfull_pc/B.n29 pfet_01v8_lvt_W1p4_L0p6_m6__nf1_gboth_sdfull_pc/B.n28 185
R39 pfet_01v8_lvt_W1p4_L0p6_m6__nf1_gboth_sdfull_pc/B.n30 pfet_01v8_lvt_W1p4_L0p6_m6__nf1_gboth_sdfull_pc/B.n29 185
R40 pfet_01v8_lvt_W1p4_L0p6_m6__nf1_gboth_sdfull_pc/B.n8 pfet_01v8_lvt_W1p4_L0p6_m6__nf1_gboth_sdfull_pc/B.n7 185
R41 pfet_01v8_lvt_W1p4_L0p6_m6__nf1_gboth_sdfull_pc/B.n15 pfet_01v8_lvt_W1p4_L0p6_m6__nf1_gboth_sdfull_pc/B.n14 185
R42 pfet_01v8_lvt_W1p4_L0p6_m6__nf1_gboth_sdfull_pc/B.n17 pfet_01v8_lvt_W1p4_L0p6_m6__nf1_gboth_sdfull_pc/B.n16 185
R43 pfet_01v8_lvt_W1p4_L0p6_m6__nf1_gboth_sdfull_pc/B.n19 pfet_01v8_lvt_W1p4_L0p6_m6__nf1_gboth_sdfull_pc/B.n12 185
R44 pfet_01v8_lvt_W1p4_L0p6_m6__nf1_gboth_sdfull_pc/B.n20 pfet_01v8_lvt_W1p4_L0p6_m6__nf1_gboth_sdfull_pc/B.n11 185
R45 pfet_01v8_lvt_W1p4_L0p6_m6__nf1_gboth_sdfull_pc/B.n23 pfet_01v8_lvt_W1p4_L0p6_m6__nf1_gboth_sdfull_pc/B.n22 185
R46 pfet_01v8_lvt_W1p4_L0p6_m6__nf1_gboth_sdfull_pc/B.n10 pfet_01v8_lvt_W1p4_L0p6_m6__nf1_gboth_sdfull_pc/B.n9 185
R47 pfet_01v8_lvt_W1p4_L0p6_m6__nf1_gboth_sdfull_pc/B.n24 pfet_01v8_lvt_W1p4_L0p6_m6__nf1_gboth_sdfull_pc/B.n10 185
R48 pfet_01v8_lvt_W1p4_L0p6_m6__nf1_gboth_sdfull_pc/B.n46 pfet_01v8_lvt_W1p4_L0p6_m6__nf1_gboth_sdfull_pc/B.n4 133.636
R49 pfet_01v8_lvt_W1p4_L0p6_m6__nf1_gboth_sdfull_pc/B.n28 pfet_01v8_lvt_W1p4_L0p6_m6__nf1_gboth_sdfull_pc/B.n9 133.636
R50 pfet_01v8_lvt_W1p4_L0p6_m6__nf1_gboth_sdfull_pc/B.n53 pfet_01v8_lvt_W1p4_L0p6_m6__nf1_gboth_sdfull_pc/B.n4 89.9726
R51 pfet_01v8_lvt_W1p4_L0p6_m6__nf1_gboth_sdfull_pc/B.n28 pfet_01v8_lvt_W1p4_L0p6_m6__nf1_gboth_sdfull_pc/B.n27 89.9726
R52 pfet_01v8_lvt_W1p4_L0p6_m6__nf1_gboth_sdfull_pc/B.n37 pfet_01v8_lvt_W1p4_L0p6_m6__nf1_gboth_sdfull_pc/B.n35 72.7879
R53 pfet_01v8_lvt_W1p4_L0p6_m6__nf1_gboth_sdfull_pc/B.n41 pfet_01v8_lvt_W1p4_L0p6_m6__nf1_gboth_sdfull_pc/B.n34 72.7879
R54 pfet_01v8_lvt_W1p4_L0p6_m6__nf1_gboth_sdfull_pc/B.n47 pfet_01v8_lvt_W1p4_L0p6_m6__nf1_gboth_sdfull_pc/B.n33 72.7879
R55 pfet_01v8_lvt_W1p4_L0p6_m6__nf1_gboth_sdfull_pc/B.n14 pfet_01v8_lvt_W1p4_L0p6_m6__nf1_gboth_sdfull_pc/B.n13 72.7879
R56 pfet_01v8_lvt_W1p4_L0p6_m6__nf1_gboth_sdfull_pc/B.n19 pfet_01v8_lvt_W1p4_L0p6_m6__nf1_gboth_sdfull_pc/B.n18 72.7879
R57 pfet_01v8_lvt_W1p4_L0p6_m6__nf1_gboth_sdfull_pc/B.n22 pfet_01v8_lvt_W1p4_L0p6_m6__nf1_gboth_sdfull_pc/B.n21 72.7879
R58 pfet_01v8_lvt_W1p4_L0p6_m6__nf1_gboth_sdfull_pc/B.n21 pfet_01v8_lvt_W1p4_L0p6_m6__nf1_gboth_sdfull_pc/B.n20 72.7879
R59 pfet_01v8_lvt_W1p4_L0p6_m6__nf1_gboth_sdfull_pc/B.n18 pfet_01v8_lvt_W1p4_L0p6_m6__nf1_gboth_sdfull_pc/B.n17 72.7879
R60 pfet_01v8_lvt_W1p4_L0p6_m6__nf1_gboth_sdfull_pc/B.n13 pfet_01v8_lvt_W1p4_L0p6_m6__nf1_gboth_sdfull_pc/B.n8 72.7879
R61 pfet_01v8_lvt_W1p4_L0p6_m6__nf1_gboth_sdfull_pc/B.n40 pfet_01v8_lvt_W1p4_L0p6_m6__nf1_gboth_sdfull_pc/B.n35 72.7879
R62 pfet_01v8_lvt_W1p4_L0p6_m6__nf1_gboth_sdfull_pc/B.n36 pfet_01v8_lvt_W1p4_L0p6_m6__nf1_gboth_sdfull_pc/B.n34 72.7879
R63 pfet_01v8_lvt_W1p4_L0p6_m6__nf1_gboth_sdfull_pc/B.n48 pfet_01v8_lvt_W1p4_L0p6_m6__nf1_gboth_sdfull_pc/B.n47 72.7879
R64 pfet_01v8_lvt_W1p4_L0p6_m6__nf1_gboth_sdfull_pc/B.n38 pfet_01v8_lvt_W1p4_L0p6_m6__nf1_gboth_sdfull_pc/B.n1 70.024
R65 pfet_01v8_lvt_W1p4_L0p6_m6__nf1_gboth_sdfull_pc/B.n50 pfet_01v8_lvt_W1p4_L0p6_m6__nf1_gboth_sdfull_pc/B.n49 70.024
R66 pfet_01v8_lvt_W1p4_L0p6_m6__nf1_gboth_sdfull_pc/B.n25 pfet_01v8_lvt_W1p4_L0p6_m6__nf1_gboth_sdfull_pc/B.n24 70.024
R67 pfet_01v8_lvt_W1p4_L0p6_m6__nf1_gboth_sdfull_pc/B.n30 pfet_01v8_lvt_W1p4_L0p6_m6__nf1_gboth_sdfull_pc/B.n7 70.024
R68 pfet_01v8_lvt_W1p4_L0p6_m6__nf1_gboth_sdfull_pc/B.n46 pfet_01v8_lvt_W1p4_L0p6_m6__nf1_gboth_sdfull_pc/B.n35 56.1076
R69 pfet_01v8_lvt_W1p4_L0p6_m6__nf1_gboth_sdfull_pc/B.n46 pfet_01v8_lvt_W1p4_L0p6_m6__nf1_gboth_sdfull_pc/B.n34 56.1076
R70 pfet_01v8_lvt_W1p4_L0p6_m6__nf1_gboth_sdfull_pc/B.n47 pfet_01v8_lvt_W1p4_L0p6_m6__nf1_gboth_sdfull_pc/B.n46 56.1076
R71 pfet_01v8_lvt_W1p4_L0p6_m6__nf1_gboth_sdfull_pc/B.n13 pfet_01v8_lvt_W1p4_L0p6_m6__nf1_gboth_sdfull_pc/B.n9 56.1076
R72 pfet_01v8_lvt_W1p4_L0p6_m6__nf1_gboth_sdfull_pc/B.n18 pfet_01v8_lvt_W1p4_L0p6_m6__nf1_gboth_sdfull_pc/B.n9 56.1076
R73 pfet_01v8_lvt_W1p4_L0p6_m6__nf1_gboth_sdfull_pc/B.n21 pfet_01v8_lvt_W1p4_L0p6_m6__nf1_gboth_sdfull_pc/B.n9 56.1076
R74 pfet_01v8_lvt_W1p4_L0p6_m6__nf1_gboth_sdfull_pc/B.n53 pfet_01v8_lvt_W1p4_L0p6_m6__nf1_gboth_sdfull_pc/B.t0 44.9866
R75 pfet_01v8_lvt_W1p4_L0p6_m6__nf1_gboth_sdfull_pc/B.n27 pfet_01v8_lvt_W1p4_L0p6_m6__nf1_gboth_sdfull_pc/B.t0 44.9866
R76 pfet_01v8_lvt_W1p4_L0p6_m6__nf1_gboth_sdfull_pc/B.n55 pfet_01v8_lvt_W1p4_L0p6_m6__nf1_gboth_sdfull_pc/B.n1 25.6005
R77 pfet_01v8_lvt_W1p4_L0p6_m6__nf1_gboth_sdfull_pc/B.n25 pfet_01v8_lvt_W1p4_L0p6_m6__nf1_gboth_sdfull_pc/B.n0 25.6005
R78 pfet_01v8_lvt_W1p4_L0p6_m6__nf1_gboth_sdfull_pc/B.n39 pfet_01v8_lvt_W1p4_L0p6_m6__nf1_gboth_sdfull_pc/B.n38 25.6005
R79 pfet_01v8_lvt_W1p4_L0p6_m6__nf1_gboth_sdfull_pc/B.n42 pfet_01v8_lvt_W1p4_L0p6_m6__nf1_gboth_sdfull_pc/B.n39 25.6005
R80 pfet_01v8_lvt_W1p4_L0p6_m6__nf1_gboth_sdfull_pc/B.n43 pfet_01v8_lvt_W1p4_L0p6_m6__nf1_gboth_sdfull_pc/B.n42 25.6005
R81 pfet_01v8_lvt_W1p4_L0p6_m6__nf1_gboth_sdfull_pc/B.n44 pfet_01v8_lvt_W1p4_L0p6_m6__nf1_gboth_sdfull_pc/B.n43 25.6005
R82 pfet_01v8_lvt_W1p4_L0p6_m6__nf1_gboth_sdfull_pc/B.n44 pfet_01v8_lvt_W1p4_L0p6_m6__nf1_gboth_sdfull_pc/B.n32 25.6005
R83 pfet_01v8_lvt_W1p4_L0p6_m6__nf1_gboth_sdfull_pc/B.n49 pfet_01v8_lvt_W1p4_L0p6_m6__nf1_gboth_sdfull_pc/B.n32 25.6005
R84 pfet_01v8_lvt_W1p4_L0p6_m6__nf1_gboth_sdfull_pc/B.n51 pfet_01v8_lvt_W1p4_L0p6_m6__nf1_gboth_sdfull_pc/B.n50 25.6005
R85 pfet_01v8_lvt_W1p4_L0p6_m6__nf1_gboth_sdfull_pc/B.n51 pfet_01v8_lvt_W1p4_L0p6_m6__nf1_gboth_sdfull_pc/B.n31 25.6005
R86 pfet_01v8_lvt_W1p4_L0p6_m6__nf1_gboth_sdfull_pc/B.n31 pfet_01v8_lvt_W1p4_L0p6_m6__nf1_gboth_sdfull_pc/B.n30 25.6005
R87 pfet_01v8_lvt_W1p4_L0p6_m6__nf1_gboth_sdfull_pc/B.n24 pfet_01v8_lvt_W1p4_L0p6_m6__nf1_gboth_sdfull_pc/B.n23 25.6005
R88 pfet_01v8_lvt_W1p4_L0p6_m6__nf1_gboth_sdfull_pc/B.n23 pfet_01v8_lvt_W1p4_L0p6_m6__nf1_gboth_sdfull_pc/B.n11 25.6005
R89 pfet_01v8_lvt_W1p4_L0p6_m6__nf1_gboth_sdfull_pc/B.n12 pfet_01v8_lvt_W1p4_L0p6_m6__nf1_gboth_sdfull_pc/B.n11 25.6005
R90 pfet_01v8_lvt_W1p4_L0p6_m6__nf1_gboth_sdfull_pc/B.n16 pfet_01v8_lvt_W1p4_L0p6_m6__nf1_gboth_sdfull_pc/B.n12 25.6005
R91 pfet_01v8_lvt_W1p4_L0p6_m6__nf1_gboth_sdfull_pc/B.n16 pfet_01v8_lvt_W1p4_L0p6_m6__nf1_gboth_sdfull_pc/B.n15 25.6005
R92 pfet_01v8_lvt_W1p4_L0p6_m6__nf1_gboth_sdfull_pc/B.n15 pfet_01v8_lvt_W1p4_L0p6_m6__nf1_gboth_sdfull_pc/B.n7 25.6005
R93 B pfet_01v8_lvt_W1p4_L0p6_m6__nf1_gboth_sdfull_pc/B.n0 12.8005
R94 B pfet_01v8_lvt_W1p4_L0p6_m6__nf1_gboth_sdfull_pc/B.n55 6.4005
R95 B.n50 B.n8 656.471
R96 B.n53 B.n52 656.471
R97 B.n29 B.n20 656.471
R98 B.n31 B.n18 656.471
R99 B.n50 B.n6 240
R100 B.n44 B.n6 240
R101 B.n44 B.n10 240
R102 B.n35 B.n10 240
R103 B.n35 B.n16 240
R104 B.n31 B.n16 240
R105 B.n55 B.n1 240
R106 B.n52 B.n3 240
R107 B.n42 B.n3 240
R108 B.n42 B.n12 240
R109 B.n37 B.n12 240
R110 B.n37 B.n14 240
R111 B.n29 B.n14 240
R112 B.n25 B.n23 240
R113 B.n51 B.n2 189.258
R114 B.n30 B.n19 189.258
R115 B.n48 B.n8 185
R116 B.n47 B.n1 185
R117 B.n56 B.n55 185
R118 B.n53 B.n0 185
R119 B.n52 B.n51 185
R120 B.n52 B.n4 185
R121 B.n5 B.n3 185
R122 B.n40 B.n3 185
R123 B.n43 B.n42 185
R124 B.n42 B.n41 185
R125 B.n12 B.n11 185
R126 B.n39 B.n12 185
R127 B.n37 B.n36 185
R128 B.n38 B.n37 185
R129 B.n15 B.n14 185
R130 B.n14 B.n13 185
R131 B.n30 B.n29 185
R132 B.n29 B.n28 185
R133 B.n27 B.n20 185
R134 B.n26 B.n25 185
R135 B.n23 B.n21 185
R136 B.n18 B.n17 185
R137 B.n31 B.n30 185
R138 B.n32 B.n31 185
R139 B.n16 B.n15 185
R140 B.n33 B.n16 185
R141 B.n36 B.n35 185
R142 B.n35 B.n34 185
R143 B.n11 B.n10 185
R144 B.n10 B.n9 185
R145 B.n44 B.n43 185
R146 B.n45 B.n44 185
R147 B.n6 B.n5 185
R148 B.n46 B.n6 185
R149 B.n51 B.n50 185
R150 B.n50 B.n49 185
R151 B.n51 B.n5 126.172
R152 B.n43 B.n5 126.172
R153 B.n43 B.n11 126.172
R154 B.n36 B.n11 126.172
R155 B.n36 B.n15 126.172
R156 B.n30 B.n15 126.172
R157 B.n8 B.n7 72.7879
R158 B.n55 B.n54 72.7879
R159 B.n24 B.n20 72.7879
R160 B.n23 B.n22 72.7879
R161 B.n54 B.n53 72.7879
R162 B.n7 B.n1 72.7879
R163 B.n25 B.n24 72.7879
R164 B.n22 B.n18 72.7879
R165 B.n4 B.n0 70.024
R166 B.n28 B.n27 70.024
R167 B.n49 B.n48 70.024
R168 B.n32 B.n17 70.024
R169 B.n7 B.n2 56.1076
R170 B.n54 B.n2 56.1076
R171 B.n24 B.n19 56.1076
R172 B.n22 B.n19 56.1076
R173 B.n56 B.n0 25.6005
R174 B.n48 B.n47 25.6005
R175 B.n40 B.n4 25.6005
R176 B.n41 B.n40 25.6005
R177 B.n41 B.n39 25.6005
R178 B.n39 B.n38 25.6005
R179 B.n38 B.n13 25.6005
R180 B.n28 B.n13 25.6005
R181 B.n27 B.n26 25.6005
R182 B.n26 B.n21 25.6005
R183 B.n21 B.n17 25.6005
R184 B.n49 B.n46 25.6005
R185 B.n46 B.n45 25.6005
R186 B.n45 B.n9 25.6005
R187 B.n34 B.n9 25.6005
R188 B.n34 B.n33 25.6005
R189 B.n33 B.n32 25.6005
R190 B.n47 B 19.2005
R191 B B.n56 6.4005
C6 B.n0 VSUBS 0 ; **FLOATING
C7 B.n1 VSUBS 0 ; **FLOATING
C8 B.n2 VSUBS 0 ; **FLOATING
C9 B.n3 VSUBS 0 ; **FLOATING
C10 B.n4 VSUBS 0 ; **FLOATING
C11 B.n5 VSUBS 0 ; **FLOATING
C12 B.n6 VSUBS 0 ; **FLOATING
C13 B.n8 VSUBS 0 ; **FLOATING
C14 B.n9 VSUBS 0 ; **FLOATING
C15 B.n10 VSUBS 0 ; **FLOATING
C16 B.n11 VSUBS 0 ; **FLOATING
C17 B.n12 VSUBS 0 ; **FLOATING
C18 B.n13 VSUBS 0 ; **FLOATING
C19 B.n14 VSUBS 0 ; **FLOATING
C20 B.n15 VSUBS 0 ; **FLOATING
C21 B.n16 VSUBS 0 ; **FLOATING
C22 B.n17 VSUBS 0 ; **FLOATING
C23 B.n18 VSUBS 0 ; **FLOATING
C24 B.n19 VSUBS 0 ; **FLOATING
C25 B.n20 VSUBS 0 ; **FLOATING
C26 B.n21 VSUBS 0 ; **FLOATING
C27 B.n23 VSUBS 0 ; **FLOATING
C28 B.n25 VSUBS 0 ; **FLOATING
C29 B.n26 VSUBS 0 ; **FLOATING
C30 B.n27 VSUBS 0 ; **FLOATING
C31 B.n28 VSUBS 0 ; **FLOATING
C32 B.n29 VSUBS 0 ; **FLOATING
C33 B.n30 VSUBS 0 ; **FLOATING
C34 B.n31 VSUBS 0 ; **FLOATING
C35 B.n32 VSUBS 0 ; **FLOATING
C36 B.n33 VSUBS 0 ; **FLOATING
C37 B.n34 VSUBS 0 ; **FLOATING
C38 B.n35 VSUBS 0 ; **FLOATING
C39 B.n36 VSUBS 0 ; **FLOATING
C40 B.n37 VSUBS 0 ; **FLOATING
C41 B.n38 VSUBS 0 ; **FLOATING
C42 B.n39 VSUBS 0 ; **FLOATING
C43 B.n40 VSUBS 0 ; **FLOATING
C44 B.n41 VSUBS 0 ; **FLOATING
C45 B.n42 VSUBS 0 ; **FLOATING
C46 B.n43 VSUBS 0 ; **FLOATING
C47 B.n44 VSUBS 0 ; **FLOATING
C48 B.n45 VSUBS 0 ; **FLOATING
C49 B.n46 VSUBS 0 ; **FLOATING
C50 B.n47 VSUBS 0 ; **FLOATING
C51 B.n48 VSUBS 0 ; **FLOATING
C52 B.n49 VSUBS 0 ; **FLOATING
C53 B.n50 VSUBS 0 ; **FLOATING
C54 B.n51 VSUBS 0 ; **FLOATING
C55 B.n52 VSUBS 0 ; **FLOATING
C56 B.n53 VSUBS 0 ; **FLOATING
C57 B.n55 VSUBS 0 ; **FLOATING
C58 B.n56 VSUBS 0 ; **FLOATING
C59 S VSUBS 0.0502f
C60 D VSUBS 0.0502f
C61 G VSUBS 0.11627f
C62 B VSUBS 1.48874f
C63 pfet_01v8_lvt_W1p4_L0p6_m6__nf1_gboth_sdfull_pc/B.n0 VSUBS 0.00168f ; **FLOATING
C64 pfet_01v8_lvt_W1p4_L0p6_m6__nf1_gboth_sdfull_pc/B.n1 VSUBS 0.00444f ; **FLOATING
C65 pfet_01v8_lvt_W1p4_L0p6_m6__nf1_gboth_sdfull_pc/B.n2 VSUBS 0.00224f ; **FLOATING
C66 pfet_01v8_lvt_W1p4_L0p6_m6__nf1_gboth_sdfull_pc/B.n3 VSUBS 0.00444f ; **FLOATING
C67 pfet_01v8_lvt_W1p4_L0p6_m6__nf1_gboth_sdfull_pc/B.t0 VSUBS 0.02366f ; **FLOATING
C68 pfet_01v8_lvt_W1p4_L0p6_m6__nf1_gboth_sdfull_pc/B.n4 VSUBS 0.0588f ; **FLOATING
C69 pfet_01v8_lvt_W1p4_L0p6_m6__nf1_gboth_sdfull_pc/B.n5 VSUBS 0.00224f ; **FLOATING
C70 pfet_01v8_lvt_W1p4_L0p6_m6__nf1_gboth_sdfull_pc/B.n6 VSUBS 0.00444f ; **FLOATING
C71 pfet_01v8_lvt_W1p4_L0p6_m6__nf1_gboth_sdfull_pc/B.n7 VSUBS 0.00449f ; **FLOATING
C72 pfet_01v8_lvt_W1p4_L0p6_m6__nf1_gboth_sdfull_pc/B.n8 VSUBS 0.00449f ; **FLOATING
C73 pfet_01v8_lvt_W1p4_L0p6_m6__nf1_gboth_sdfull_pc/B.n9 VSUBS 0.07202f ; **FLOATING
C74 pfet_01v8_lvt_W1p4_L0p6_m6__nf1_gboth_sdfull_pc/B.n10 VSUBS 0.00449f ; **FLOATING
C75 pfet_01v8_lvt_W1p4_L0p6_m6__nf1_gboth_sdfull_pc/B.n11 VSUBS 0.00224f ; **FLOATING
C76 pfet_01v8_lvt_W1p4_L0p6_m6__nf1_gboth_sdfull_pc/B.n12 VSUBS 0.00224f ; **FLOATING
C77 pfet_01v8_lvt_W1p4_L0p6_m6__nf1_gboth_sdfull_pc/B.n14 VSUBS 0.00224f ; **FLOATING
C78 pfet_01v8_lvt_W1p4_L0p6_m6__nf1_gboth_sdfull_pc/B.n15 VSUBS 0.00224f ; **FLOATING
C79 pfet_01v8_lvt_W1p4_L0p6_m6__nf1_gboth_sdfull_pc/B.n16 VSUBS 0.00224f ; **FLOATING
C80 pfet_01v8_lvt_W1p4_L0p6_m6__nf1_gboth_sdfull_pc/B.n17 VSUBS 0.00224f ; **FLOATING
C81 pfet_01v8_lvt_W1p4_L0p6_m6__nf1_gboth_sdfull_pc/B.n19 VSUBS 0.00224f ; **FLOATING
C82 pfet_01v8_lvt_W1p4_L0p6_m6__nf1_gboth_sdfull_pc/B.n20 VSUBS 0.00224f ; **FLOATING
C83 pfet_01v8_lvt_W1p4_L0p6_m6__nf1_gboth_sdfull_pc/B.n22 VSUBS 0.00224f ; **FLOATING
C84 pfet_01v8_lvt_W1p4_L0p6_m6__nf1_gboth_sdfull_pc/B.n23 VSUBS 0.00224f ; **FLOATING
C85 pfet_01v8_lvt_W1p4_L0p6_m6__nf1_gboth_sdfull_pc/B.n24 VSUBS 0.00449f ; **FLOATING
C86 pfet_01v8_lvt_W1p4_L0p6_m6__nf1_gboth_sdfull_pc/B.n25 VSUBS 0.00444f ; **FLOATING
C87 pfet_01v8_lvt_W1p4_L0p6_m6__nf1_gboth_sdfull_pc/B.n26 VSUBS 0.00444f ; **FLOATING
C88 pfet_01v8_lvt_W1p4_L0p6_m6__nf1_gboth_sdfull_pc/B.n27 VSUBS 0.03549f ; **FLOATING
C89 pfet_01v8_lvt_W1p4_L0p6_m6__nf1_gboth_sdfull_pc/B.n28 VSUBS 0.0588f ; **FLOATING
C90 pfet_01v8_lvt_W1p4_L0p6_m6__nf1_gboth_sdfull_pc/B.n29 VSUBS 0.00444f ; **FLOATING
C91 pfet_01v8_lvt_W1p4_L0p6_m6__nf1_gboth_sdfull_pc/B.n30 VSUBS 0.00444f ; **FLOATING
C92 pfet_01v8_lvt_W1p4_L0p6_m6__nf1_gboth_sdfull_pc/B.n31 VSUBS 0.00224f ; **FLOATING
C93 pfet_01v8_lvt_W1p4_L0p6_m6__nf1_gboth_sdfull_pc/B.n32 VSUBS 0.00224f ; **FLOATING
C94 pfet_01v8_lvt_W1p4_L0p6_m6__nf1_gboth_sdfull_pc/B.n33 VSUBS 0.00224f ; **FLOATING
C95 pfet_01v8_lvt_W1p4_L0p6_m6__nf1_gboth_sdfull_pc/B.n36 VSUBS 0.00224f ; **FLOATING
C96 pfet_01v8_lvt_W1p4_L0p6_m6__nf1_gboth_sdfull_pc/B.n37 VSUBS 0.00449f ; **FLOATING
C97 pfet_01v8_lvt_W1p4_L0p6_m6__nf1_gboth_sdfull_pc/B.n38 VSUBS 0.00449f ; **FLOATING
C98 pfet_01v8_lvt_W1p4_L0p6_m6__nf1_gboth_sdfull_pc/B.n39 VSUBS 0.00224f ; **FLOATING
C99 pfet_01v8_lvt_W1p4_L0p6_m6__nf1_gboth_sdfull_pc/B.n40 VSUBS 0.00224f ; **FLOATING
C100 pfet_01v8_lvt_W1p4_L0p6_m6__nf1_gboth_sdfull_pc/B.n41 VSUBS 0.00224f ; **FLOATING
C101 pfet_01v8_lvt_W1p4_L0p6_m6__nf1_gboth_sdfull_pc/B.n42 VSUBS 0.00224f ; **FLOATING
C102 pfet_01v8_lvt_W1p4_L0p6_m6__nf1_gboth_sdfull_pc/B.n43 VSUBS 0.00224f ; **FLOATING
C103 pfet_01v8_lvt_W1p4_L0p6_m6__nf1_gboth_sdfull_pc/B.n44 VSUBS 0.00224f ; **FLOATING
C104 pfet_01v8_lvt_W1p4_L0p6_m6__nf1_gboth_sdfull_pc/B.n45 VSUBS 0.00224f ; **FLOATING
C105 pfet_01v8_lvt_W1p4_L0p6_m6__nf1_gboth_sdfull_pc/B.n46 VSUBS 0.07202f ; **FLOATING
C106 pfet_01v8_lvt_W1p4_L0p6_m6__nf1_gboth_sdfull_pc/B.n48 VSUBS 0.00449f ; **FLOATING
C107 pfet_01v8_lvt_W1p4_L0p6_m6__nf1_gboth_sdfull_pc/B.n49 VSUBS 0.00449f ; **FLOATING
C108 pfet_01v8_lvt_W1p4_L0p6_m6__nf1_gboth_sdfull_pc/B.n50 VSUBS 0.00444f ; **FLOATING
C109 pfet_01v8_lvt_W1p4_L0p6_m6__nf1_gboth_sdfull_pc/B.n51 VSUBS 0.00224f ; **FLOATING
C110 pfet_01v8_lvt_W1p4_L0p6_m6__nf1_gboth_sdfull_pc/B.n52 VSUBS 0.00224f ; **FLOATING
C111 pfet_01v8_lvt_W1p4_L0p6_m6__nf1_gboth_sdfull_pc/B.n53 VSUBS 0.03549f ; **FLOATING
C112 pfet_01v8_lvt_W1p4_L0p6_m6__nf1_gboth_sdfull_pc/B.n54 VSUBS 0.00224f ; **FLOATING
C113 pfet_01v8_lvt_W1p4_L0p6_m6__nf1_gboth_sdfull_pc/B.n55 VSUBS 0.0014f ; **FLOATING
