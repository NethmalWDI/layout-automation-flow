* NGSPICE file created from pfet_01v8_lvt_W90p63_L0p74_m1__nf1_gboth_sdfull_ng.ext - technology: sky130A

X0 S pfet_01v8_lvt_W90p63_L0p74_m1__nf1_gboth_sdfull_ng_pc/G.t0 D B sky130_fd_pr__pfet_01v8_lvt ad=26.2827 pd=181.84 as=26.2827 ps=181.84 w=90.63 l=0.74
C0 S B 1.59005f
C1 G S 4.16652f
C2 D B 1.59005f
C3 G D 4.16652f
C4 D S 3.37546f
C5 G B 0.17088f
R0 pfet_01v8_lvt_W90p63_L0p74_m1__nf1_gboth_sdfull_ng_pc/G.n1 pfet_01v8_lvt_W90p63_L0p74_m1__nf1_gboth_sdfull_ng_pc/G.t0 2951.6
R1 pfet_01v8_lvt_W90p63_L0p74_m1__nf1_gboth_sdfull_ng_pc/G.n1 pfet_01v8_lvt_W90p63_L0p74_m1__nf1_gboth_sdfull_ng_pc/G.n0 168.895
R2 pfet_01v8_lvt_W90p63_L0p74_m1__nf1_gboth_sdfull_ng_pc/G.n2 pfet_01v8_lvt_W90p63_L0p74_m1__nf1_gboth_sdfull_ng_pc/G.n1 168.895
R3 G pfet_01v8_lvt_W90p63_L0p74_m1__nf1_gboth_sdfull_ng_pc/G.n0 12.8005
R4 G pfet_01v8_lvt_W90p63_L0p74_m1__nf1_gboth_sdfull_ng_pc/G.n2 12.8005
R5 G pfet_01v8_lvt_W90p63_L0p74_m1__nf1_gboth_sdfull_ng_pc/G.n0 10.2491
R6 pfet_01v8_lvt_W90p63_L0p74_m1__nf1_gboth_sdfull_ng_pc/G.n2 G 10.0534
C6 S VSUBS 6.38753f
C7 D VSUBS 6.38753f
C8 G VSUBS 0.33752f
C9 B VSUBS 15.19458f
C10 pfet_01v8_lvt_W90p63_L0p74_m1__nf1_gboth_sdfull_ng_pc/G.n0 VSUBS 0.00764f ; **FLOATING
C11 pfet_01v8_lvt_W90p63_L0p74_m1__nf1_gboth_sdfull_ng_pc/G.t0 VSUBS 6.33778f ; **FLOATING
C12 pfet_01v8_lvt_W90p63_L0p74_m1__nf1_gboth_sdfull_ng_pc/G.n1 VSUBS 2.12703f ; **FLOATING
C13 pfet_01v8_lvt_W90p63_L0p74_m1__nf1_gboth_sdfull_ng_pc/G.n2 VSUBS 0.00744f ; **FLOATING
