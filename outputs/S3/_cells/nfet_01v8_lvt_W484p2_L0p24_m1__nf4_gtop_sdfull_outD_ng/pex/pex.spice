* NGSPICE file created from nfet_01v8_lvt_W484p2_L0p24_m1__nf4_gtop_sdfull_outD_ng.ext - technology: sky130A

.subckt nfet_01v8_lvt_W484p2_L0p24_m1__nf4_gtop_sdfull_outD_ng S D G B
X0 S G D B sky130_fd_pr__nfet_01v8_lvt ad=17.55225 pd=121.34 as=35.1045 ps=242.67999 w=121.05 l=0.24
X1 D G S B sky130_fd_pr__nfet_01v8_lvt ad=17.55225 pd=121.34 as=17.55225 ps=121.34 w=121.05 l=0.24
X2 D G S B sky130_fd_pr__nfet_01v8_lvt ad=35.1045 pd=242.67999 as=17.55225 ps=121.34 w=121.05 l=0.24
X3 S G D B sky130_fd_pr__nfet_01v8_lvt ad=17.55225 pd=121.34 as=17.55225 ps=121.34 w=121.05 l=0.24
C0 D G 9.56499f
C1 D S 34.94498f
C2 G S 9.62032f
C3 S B 0.10423f
C4 D B 19.24127f
C5 G B 0.64107f
.ends
