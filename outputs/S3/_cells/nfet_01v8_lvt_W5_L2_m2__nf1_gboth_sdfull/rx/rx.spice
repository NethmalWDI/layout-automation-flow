* NGSPICE file created from nfet_01v8_lvt_W5_L2_m2__nf1_gboth_sdfull.ext - technology: sky130A

X0 nfet_01v8_lvt_W5_L2_m2__nf1_gboth_sdfull_pc/S.t0 G nfet_01v8_lvt_W5_L2_m2__nf1_gboth_sdfull_pc/D.t0 nfet_01v8_lvt_W5_L2_m2__nf1_gboth_sdfull_pc/B.t0 sky130_fd_pr__nfet_01v8_lvt ad=1.45 pd=10.58 as=1.45 ps=10.58 w=5 l=2
C0 G S 0.35567f
C1 S D 0.08154f
C2 G D 0.35567f
R0 nfet_01v8_lvt_W5_L2_m2__nf1_gboth_sdfull_pc/S.t0 nfet_01v8_lvt_W5_L2_m2__nf1_gboth_sdfull_pc/S.n0 174.857
R1 nfet_01v8_lvt_W5_L2_m2__nf1_gboth_sdfull_pc/S.n1 nfet_01v8_lvt_W5_L2_m2__nf1_gboth_sdfull_pc/S.t0 174.857
R2 S nfet_01v8_lvt_W5_L2_m2__nf1_gboth_sdfull_pc/S.n0 15.6333
R3 S nfet_01v8_lvt_W5_L2_m2__nf1_gboth_sdfull_pc/S.n1 15.6333
R4 nfet_01v8_lvt_W5_L2_m2__nf1_gboth_sdfull_pc/S.n1 S 5.29315
R5 S nfet_01v8_lvt_W5_L2_m2__nf1_gboth_sdfull_pc/S.n0 5.18989
R6 nfet_01v8_lvt_W5_L2_m2__nf1_gboth_sdfull_pc/D.t0 nfet_01v8_lvt_W5_L2_m2__nf1_gboth_sdfull_pc/D.n0 174.857
R7 nfet_01v8_lvt_W5_L2_m2__nf1_gboth_sdfull_pc/D.n1 nfet_01v8_lvt_W5_L2_m2__nf1_gboth_sdfull_pc/D.t0 174.857
R8 D nfet_01v8_lvt_W5_L2_m2__nf1_gboth_sdfull_pc/D.n0 15.6333
R9 D nfet_01v8_lvt_W5_L2_m2__nf1_gboth_sdfull_pc/D.n1 15.6333
R10 nfet_01v8_lvt_W5_L2_m2__nf1_gboth_sdfull_pc/D.n1 D 5.29315
R11 D nfet_01v8_lvt_W5_L2_m2__nf1_gboth_sdfull_pc/D.n0 5.18989
R12 nfet_01v8_lvt_W5_L2_m2__nf1_gboth_sdfull_pc/B.n82 nfet_01v8_lvt_W5_L2_m2__nf1_gboth_sdfull_pc/B.n70 1164.62
R13 nfet_01v8_lvt_W5_L2_m2__nf1_gboth_sdfull_pc/B.n57 nfet_01v8_lvt_W5_L2_m2__nf1_gboth_sdfull_pc/B.n12 1164.62
R14 nfet_01v8_lvt_W5_L2_m2__nf1_gboth_sdfull_pc/B.n113 nfet_01v8_lvt_W5_L2_m2__nf1_gboth_sdfull_pc/B.n68 1164.62
R15 nfet_01v8_lvt_W5_L2_m2__nf1_gboth_sdfull_pc/B.n55 nfet_01v8_lvt_W5_L2_m2__nf1_gboth_sdfull_pc/B.n14 1164.62
R16 nfet_01v8_lvt_W5_L2_m2__nf1_gboth_sdfull_pc/B.n116 nfet_01v8_lvt_W5_L2_m2__nf1_gboth_sdfull_pc/B.n68 585
R17 nfet_01v8_lvt_W5_L2_m2__nf1_gboth_sdfull_pc/B.n68 nfet_01v8_lvt_W5_L2_m2__nf1_gboth_sdfull_pc/B.n67 585
R18 nfet_01v8_lvt_W5_L2_m2__nf1_gboth_sdfull_pc/B.n118 nfet_01v8_lvt_W5_L2_m2__nf1_gboth_sdfull_pc/B.n117 585
R19 nfet_01v8_lvt_W5_L2_m2__nf1_gboth_sdfull_pc/B.n119 nfet_01v8_lvt_W5_L2_m2__nf1_gboth_sdfull_pc/B.n118 585
R20 nfet_01v8_lvt_W5_L2_m2__nf1_gboth_sdfull_pc/B.n6 nfet_01v8_lvt_W5_L2_m2__nf1_gboth_sdfull_pc/B.n4 585
R21 nfet_01v8_lvt_W5_L2_m2__nf1_gboth_sdfull_pc/B.n120 nfet_01v8_lvt_W5_L2_m2__nf1_gboth_sdfull_pc/B.n6 585
R22 nfet_01v8_lvt_W5_L2_m2__nf1_gboth_sdfull_pc/B.n123 nfet_01v8_lvt_W5_L2_m2__nf1_gboth_sdfull_pc/B.n122 585
R23 nfet_01v8_lvt_W5_L2_m2__nf1_gboth_sdfull_pc/B.n122 nfet_01v8_lvt_W5_L2_m2__nf1_gboth_sdfull_pc/B.n121 585
R24 nfet_01v8_lvt_W5_L2_m2__nf1_gboth_sdfull_pc/B.n62 nfet_01v8_lvt_W5_L2_m2__nf1_gboth_sdfull_pc/B.n5 585
R25 nfet_01v8_lvt_W5_L2_m2__nf1_gboth_sdfull_pc/B.n66 nfet_01v8_lvt_W5_L2_m2__nf1_gboth_sdfull_pc/B.n5 585
R26 nfet_01v8_lvt_W5_L2_m2__nf1_gboth_sdfull_pc/B.n64 nfet_01v8_lvt_W5_L2_m2__nf1_gboth_sdfull_pc/B.n63 585
R27 nfet_01v8_lvt_W5_L2_m2__nf1_gboth_sdfull_pc/B.n65 nfet_01v8_lvt_W5_L2_m2__nf1_gboth_sdfull_pc/B.n64 585
R28 nfet_01v8_lvt_W5_L2_m2__nf1_gboth_sdfull_pc/B.n9 nfet_01v8_lvt_W5_L2_m2__nf1_gboth_sdfull_pc/B.n8 585
R29 nfet_01v8_lvt_W5_L2_m2__nf1_gboth_sdfull_pc/B.n8 nfet_01v8_lvt_W5_L2_m2__nf1_gboth_sdfull_pc/B.n7 585
R30 nfet_01v8_lvt_W5_L2_m2__nf1_gboth_sdfull_pc/B.n56 nfet_01v8_lvt_W5_L2_m2__nf1_gboth_sdfull_pc/B.n55 585
R31 nfet_01v8_lvt_W5_L2_m2__nf1_gboth_sdfull_pc/B.n55 nfet_01v8_lvt_W5_L2_m2__nf1_gboth_sdfull_pc/B.n54 585
R32 nfet_01v8_lvt_W5_L2_m2__nf1_gboth_sdfull_pc/B.n14 nfet_01v8_lvt_W5_L2_m2__nf1_gboth_sdfull_pc/B.n13 585
R33 nfet_01v8_lvt_W5_L2_m2__nf1_gboth_sdfull_pc/B.n53 nfet_01v8_lvt_W5_L2_m2__nf1_gboth_sdfull_pc/B.n14 585
R34 nfet_01v8_lvt_W5_L2_m2__nf1_gboth_sdfull_pc/B.n52 nfet_01v8_lvt_W5_L2_m2__nf1_gboth_sdfull_pc/B.n51 585
R35 nfet_01v8_lvt_W5_L2_m2__nf1_gboth_sdfull_pc/B.n49 nfet_01v8_lvt_W5_L2_m2__nf1_gboth_sdfull_pc/B.n15 585
R36 nfet_01v8_lvt_W5_L2_m2__nf1_gboth_sdfull_pc/B.n48 nfet_01v8_lvt_W5_L2_m2__nf1_gboth_sdfull_pc/B.n16 585
R37 nfet_01v8_lvt_W5_L2_m2__nf1_gboth_sdfull_pc/B.n46 nfet_01v8_lvt_W5_L2_m2__nf1_gboth_sdfull_pc/B.n45 585
R38 nfet_01v8_lvt_W5_L2_m2__nf1_gboth_sdfull_pc/B.n44 nfet_01v8_lvt_W5_L2_m2__nf1_gboth_sdfull_pc/B.n17 585
R39 nfet_01v8_lvt_W5_L2_m2__nf1_gboth_sdfull_pc/B.n43 nfet_01v8_lvt_W5_L2_m2__nf1_gboth_sdfull_pc/B.n42 585
R40 nfet_01v8_lvt_W5_L2_m2__nf1_gboth_sdfull_pc/B.n41 nfet_01v8_lvt_W5_L2_m2__nf1_gboth_sdfull_pc/B.n18 585
R41 nfet_01v8_lvt_W5_L2_m2__nf1_gboth_sdfull_pc/B.n39 nfet_01v8_lvt_W5_L2_m2__nf1_gboth_sdfull_pc/B.n38 585
R42 nfet_01v8_lvt_W5_L2_m2__nf1_gboth_sdfull_pc/B.n37 nfet_01v8_lvt_W5_L2_m2__nf1_gboth_sdfull_pc/B.n20 585
R43 nfet_01v8_lvt_W5_L2_m2__nf1_gboth_sdfull_pc/B.n36 nfet_01v8_lvt_W5_L2_m2__nf1_gboth_sdfull_pc/B.n35 585
R44 nfet_01v8_lvt_W5_L2_m2__nf1_gboth_sdfull_pc/B.n34 nfet_01v8_lvt_W5_L2_m2__nf1_gboth_sdfull_pc/B.n21 585
R45 nfet_01v8_lvt_W5_L2_m2__nf1_gboth_sdfull_pc/B.n32 nfet_01v8_lvt_W5_L2_m2__nf1_gboth_sdfull_pc/B.n31 585
R46 nfet_01v8_lvt_W5_L2_m2__nf1_gboth_sdfull_pc/B.n30 nfet_01v8_lvt_W5_L2_m2__nf1_gboth_sdfull_pc/B.n23 585
R47 nfet_01v8_lvt_W5_L2_m2__nf1_gboth_sdfull_pc/B.n29 nfet_01v8_lvt_W5_L2_m2__nf1_gboth_sdfull_pc/B.n28 585
R48 nfet_01v8_lvt_W5_L2_m2__nf1_gboth_sdfull_pc/B.n27 nfet_01v8_lvt_W5_L2_m2__nf1_gboth_sdfull_pc/B.n24 585
R49 nfet_01v8_lvt_W5_L2_m2__nf1_gboth_sdfull_pc/B.n12 nfet_01v8_lvt_W5_L2_m2__nf1_gboth_sdfull_pc/B.n11 585
R50 nfet_01v8_lvt_W5_L2_m2__nf1_gboth_sdfull_pc/B.n57 nfet_01v8_lvt_W5_L2_m2__nf1_gboth_sdfull_pc/B.n56 585
R51 nfet_01v8_lvt_W5_L2_m2__nf1_gboth_sdfull_pc/B.n58 nfet_01v8_lvt_W5_L2_m2__nf1_gboth_sdfull_pc/B.n57 585
R52 nfet_01v8_lvt_W5_L2_m2__nf1_gboth_sdfull_pc/B.n10 nfet_01v8_lvt_W5_L2_m2__nf1_gboth_sdfull_pc/B.n9 585
R53 nfet_01v8_lvt_W5_L2_m2__nf1_gboth_sdfull_pc/B.n59 nfet_01v8_lvt_W5_L2_m2__nf1_gboth_sdfull_pc/B.n10 585
R54 nfet_01v8_lvt_W5_L2_m2__nf1_gboth_sdfull_pc/B.n63 nfet_01v8_lvt_W5_L2_m2__nf1_gboth_sdfull_pc/B.n61 585
R55 nfet_01v8_lvt_W5_L2_m2__nf1_gboth_sdfull_pc/B.n61 nfet_01v8_lvt_W5_L2_m2__nf1_gboth_sdfull_pc/B.n60 585
R56 nfet_01v8_lvt_W5_L2_m2__nf1_gboth_sdfull_pc/B.n62 nfet_01v8_lvt_W5_L2_m2__nf1_gboth_sdfull_pc/B.n2 585
R57 nfet_01v8_lvt_W5_L2_m2__nf1_gboth_sdfull_pc/B.n2 nfet_01v8_lvt_W5_L2_m2__nf1_gboth_sdfull_pc/B.n0 585
R58 nfet_01v8_lvt_W5_L2_m2__nf1_gboth_sdfull_pc/B.n124 nfet_01v8_lvt_W5_L2_m2__nf1_gboth_sdfull_pc/B.n123 585
R59 nfet_01v8_lvt_W5_L2_m2__nf1_gboth_sdfull_pc/B.n125 nfet_01v8_lvt_W5_L2_m2__nf1_gboth_sdfull_pc/B.n124 585
R60 nfet_01v8_lvt_W5_L2_m2__nf1_gboth_sdfull_pc/B.n4 nfet_01v8_lvt_W5_L2_m2__nf1_gboth_sdfull_pc/B.n3 585
R61 nfet_01v8_lvt_W5_L2_m2__nf1_gboth_sdfull_pc/B.n3 nfet_01v8_lvt_W5_L2_m2__nf1_gboth_sdfull_pc/B.n1 585
R62 nfet_01v8_lvt_W5_L2_m2__nf1_gboth_sdfull_pc/B.n117 nfet_01v8_lvt_W5_L2_m2__nf1_gboth_sdfull_pc/B.n69 585
R63 nfet_01v8_lvt_W5_L2_m2__nf1_gboth_sdfull_pc/B.n80 nfet_01v8_lvt_W5_L2_m2__nf1_gboth_sdfull_pc/B.n69 585
R64 nfet_01v8_lvt_W5_L2_m2__nf1_gboth_sdfull_pc/B.n116 nfet_01v8_lvt_W5_L2_m2__nf1_gboth_sdfull_pc/B.n70 585
R65 nfet_01v8_lvt_W5_L2_m2__nf1_gboth_sdfull_pc/B.n81 nfet_01v8_lvt_W5_L2_m2__nf1_gboth_sdfull_pc/B.n70 585
R66 nfet_01v8_lvt_W5_L2_m2__nf1_gboth_sdfull_pc/B.n83 nfet_01v8_lvt_W5_L2_m2__nf1_gboth_sdfull_pc/B.n82 585
R67 nfet_01v8_lvt_W5_L2_m2__nf1_gboth_sdfull_pc/B.n85 nfet_01v8_lvt_W5_L2_m2__nf1_gboth_sdfull_pc/B.n84 585
R68 nfet_01v8_lvt_W5_L2_m2__nf1_gboth_sdfull_pc/B.n87 nfet_01v8_lvt_W5_L2_m2__nf1_gboth_sdfull_pc/B.n86 585
R69 nfet_01v8_lvt_W5_L2_m2__nf1_gboth_sdfull_pc/B.n89 nfet_01v8_lvt_W5_L2_m2__nf1_gboth_sdfull_pc/B.n88 585
R70 nfet_01v8_lvt_W5_L2_m2__nf1_gboth_sdfull_pc/B.n91 nfet_01v8_lvt_W5_L2_m2__nf1_gboth_sdfull_pc/B.n90 585
R71 nfet_01v8_lvt_W5_L2_m2__nf1_gboth_sdfull_pc/B.n93 nfet_01v8_lvt_W5_L2_m2__nf1_gboth_sdfull_pc/B.n92 585
R72 nfet_01v8_lvt_W5_L2_m2__nf1_gboth_sdfull_pc/B.n95 nfet_01v8_lvt_W5_L2_m2__nf1_gboth_sdfull_pc/B.n94 585
R73 nfet_01v8_lvt_W5_L2_m2__nf1_gboth_sdfull_pc/B.n97 nfet_01v8_lvt_W5_L2_m2__nf1_gboth_sdfull_pc/B.n96 585
R74 nfet_01v8_lvt_W5_L2_m2__nf1_gboth_sdfull_pc/B.n99 nfet_01v8_lvt_W5_L2_m2__nf1_gboth_sdfull_pc/B.n98 585
R75 nfet_01v8_lvt_W5_L2_m2__nf1_gboth_sdfull_pc/B.n101 nfet_01v8_lvt_W5_L2_m2__nf1_gboth_sdfull_pc/B.n100 585
R76 nfet_01v8_lvt_W5_L2_m2__nf1_gboth_sdfull_pc/B.n103 nfet_01v8_lvt_W5_L2_m2__nf1_gboth_sdfull_pc/B.n102 585
R77 nfet_01v8_lvt_W5_L2_m2__nf1_gboth_sdfull_pc/B.n105 nfet_01v8_lvt_W5_L2_m2__nf1_gboth_sdfull_pc/B.n104 585
R78 nfet_01v8_lvt_W5_L2_m2__nf1_gboth_sdfull_pc/B.n107 nfet_01v8_lvt_W5_L2_m2__nf1_gboth_sdfull_pc/B.n106 585
R79 nfet_01v8_lvt_W5_L2_m2__nf1_gboth_sdfull_pc/B.n109 nfet_01v8_lvt_W5_L2_m2__nf1_gboth_sdfull_pc/B.n108 585
R80 nfet_01v8_lvt_W5_L2_m2__nf1_gboth_sdfull_pc/B.n115 nfet_01v8_lvt_W5_L2_m2__nf1_gboth_sdfull_pc/B.n78 585
R81 nfet_01v8_lvt_W5_L2_m2__nf1_gboth_sdfull_pc/B.n110 nfet_01v8_lvt_W5_L2_m2__nf1_gboth_sdfull_pc/B.n78 585
R82 nfet_01v8_lvt_W5_L2_m2__nf1_gboth_sdfull_pc/B.n111 nfet_01v8_lvt_W5_L2_m2__nf1_gboth_sdfull_pc/B.n79 585
R83 nfet_01v8_lvt_W5_L2_m2__nf1_gboth_sdfull_pc/B.n113 nfet_01v8_lvt_W5_L2_m2__nf1_gboth_sdfull_pc/B.n112 585
R84 nfet_01v8_lvt_W5_L2_m2__nf1_gboth_sdfull_pc/B.n86 nfet_01v8_lvt_W5_L2_m2__nf1_gboth_sdfull_pc/B.n85 394
R85 nfet_01v8_lvt_W5_L2_m2__nf1_gboth_sdfull_pc/B.n90 nfet_01v8_lvt_W5_L2_m2__nf1_gboth_sdfull_pc/B.n89 394
R86 nfet_01v8_lvt_W5_L2_m2__nf1_gboth_sdfull_pc/B.n94 nfet_01v8_lvt_W5_L2_m2__nf1_gboth_sdfull_pc/B.n93 394
R87 nfet_01v8_lvt_W5_L2_m2__nf1_gboth_sdfull_pc/B.n98 nfet_01v8_lvt_W5_L2_m2__nf1_gboth_sdfull_pc/B.n97 394
R88 nfet_01v8_lvt_W5_L2_m2__nf1_gboth_sdfull_pc/B.n102 nfet_01v8_lvt_W5_L2_m2__nf1_gboth_sdfull_pc/B.n101 394
R89 nfet_01v8_lvt_W5_L2_m2__nf1_gboth_sdfull_pc/B.n106 nfet_01v8_lvt_W5_L2_m2__nf1_gboth_sdfull_pc/B.n105 394
R90 nfet_01v8_lvt_W5_L2_m2__nf1_gboth_sdfull_pc/B.n108 nfet_01v8_lvt_W5_L2_m2__nf1_gboth_sdfull_pc/B.n78 394
R91 nfet_01v8_lvt_W5_L2_m2__nf1_gboth_sdfull_pc/B.n79 nfet_01v8_lvt_W5_L2_m2__nf1_gboth_sdfull_pc/B.n78 394
R92 nfet_01v8_lvt_W5_L2_m2__nf1_gboth_sdfull_pc/B.n70 nfet_01v8_lvt_W5_L2_m2__nf1_gboth_sdfull_pc/B.n69 394
R93 nfet_01v8_lvt_W5_L2_m2__nf1_gboth_sdfull_pc/B.n69 nfet_01v8_lvt_W5_L2_m2__nf1_gboth_sdfull_pc/B.n3 394
R94 nfet_01v8_lvt_W5_L2_m2__nf1_gboth_sdfull_pc/B.n124 nfet_01v8_lvt_W5_L2_m2__nf1_gboth_sdfull_pc/B.n3 394
R95 nfet_01v8_lvt_W5_L2_m2__nf1_gboth_sdfull_pc/B.n124 nfet_01v8_lvt_W5_L2_m2__nf1_gboth_sdfull_pc/B.n2 394
R96 nfet_01v8_lvt_W5_L2_m2__nf1_gboth_sdfull_pc/B.n61 nfet_01v8_lvt_W5_L2_m2__nf1_gboth_sdfull_pc/B.n2 394
R97 nfet_01v8_lvt_W5_L2_m2__nf1_gboth_sdfull_pc/B.n61 nfet_01v8_lvt_W5_L2_m2__nf1_gboth_sdfull_pc/B.n10 394
R98 nfet_01v8_lvt_W5_L2_m2__nf1_gboth_sdfull_pc/B.n57 nfet_01v8_lvt_W5_L2_m2__nf1_gboth_sdfull_pc/B.n10 394
R99 nfet_01v8_lvt_W5_L2_m2__nf1_gboth_sdfull_pc/B.n28 nfet_01v8_lvt_W5_L2_m2__nf1_gboth_sdfull_pc/B.n27 394
R100 nfet_01v8_lvt_W5_L2_m2__nf1_gboth_sdfull_pc/B.n32 nfet_01v8_lvt_W5_L2_m2__nf1_gboth_sdfull_pc/B.n23 394
R101 nfet_01v8_lvt_W5_L2_m2__nf1_gboth_sdfull_pc/B.n35 nfet_01v8_lvt_W5_L2_m2__nf1_gboth_sdfull_pc/B.n34 394
R102 nfet_01v8_lvt_W5_L2_m2__nf1_gboth_sdfull_pc/B.n39 nfet_01v8_lvt_W5_L2_m2__nf1_gboth_sdfull_pc/B.n20 394
R103 nfet_01v8_lvt_W5_L2_m2__nf1_gboth_sdfull_pc/B.n42 nfet_01v8_lvt_W5_L2_m2__nf1_gboth_sdfull_pc/B.n41 394
R104 nfet_01v8_lvt_W5_L2_m2__nf1_gboth_sdfull_pc/B.n46 nfet_01v8_lvt_W5_L2_m2__nf1_gboth_sdfull_pc/B.n17 394
R105 nfet_01v8_lvt_W5_L2_m2__nf1_gboth_sdfull_pc/B.n49 nfet_01v8_lvt_W5_L2_m2__nf1_gboth_sdfull_pc/B.n48 394
R106 nfet_01v8_lvt_W5_L2_m2__nf1_gboth_sdfull_pc/B.n51 nfet_01v8_lvt_W5_L2_m2__nf1_gboth_sdfull_pc/B.n14 394
R107 nfet_01v8_lvt_W5_L2_m2__nf1_gboth_sdfull_pc/B.n118 nfet_01v8_lvt_W5_L2_m2__nf1_gboth_sdfull_pc/B.n68 394
R108 nfet_01v8_lvt_W5_L2_m2__nf1_gboth_sdfull_pc/B.n118 nfet_01v8_lvt_W5_L2_m2__nf1_gboth_sdfull_pc/B.n6 394
R109 nfet_01v8_lvt_W5_L2_m2__nf1_gboth_sdfull_pc/B.n122 nfet_01v8_lvt_W5_L2_m2__nf1_gboth_sdfull_pc/B.n6 394
R110 nfet_01v8_lvt_W5_L2_m2__nf1_gboth_sdfull_pc/B.n122 nfet_01v8_lvt_W5_L2_m2__nf1_gboth_sdfull_pc/B.n5 394
R111 nfet_01v8_lvt_W5_L2_m2__nf1_gboth_sdfull_pc/B.n64 nfet_01v8_lvt_W5_L2_m2__nf1_gboth_sdfull_pc/B.n5 394
R112 nfet_01v8_lvt_W5_L2_m2__nf1_gboth_sdfull_pc/B.n64 nfet_01v8_lvt_W5_L2_m2__nf1_gboth_sdfull_pc/B.n8 394
R113 nfet_01v8_lvt_W5_L2_m2__nf1_gboth_sdfull_pc/B.n55 nfet_01v8_lvt_W5_L2_m2__nf1_gboth_sdfull_pc/B.n8 394
R114 nfet_01v8_lvt_W5_L2_m2__nf1_gboth_sdfull_pc/B.n116 nfet_01v8_lvt_W5_L2_m2__nf1_gboth_sdfull_pc/B.n115 330
R115 nfet_01v8_lvt_W5_L2_m2__nf1_gboth_sdfull_pc/B.n56 nfet_01v8_lvt_W5_L2_m2__nf1_gboth_sdfull_pc/B.n13 330
R116 nfet_01v8_lvt_W5_L2_m2__nf1_gboth_sdfull_pc/B.n50 nfet_01v8_lvt_W5_L2_m2__nf1_gboth_sdfull_pc/B.n13 218.815
R117 nfet_01v8_lvt_W5_L2_m2__nf1_gboth_sdfull_pc/B.n47 nfet_01v8_lvt_W5_L2_m2__nf1_gboth_sdfull_pc/B.n13 218.815
R118 nfet_01v8_lvt_W5_L2_m2__nf1_gboth_sdfull_pc/B.n19 nfet_01v8_lvt_W5_L2_m2__nf1_gboth_sdfull_pc/B.n13 218.815
R119 nfet_01v8_lvt_W5_L2_m2__nf1_gboth_sdfull_pc/B.n40 nfet_01v8_lvt_W5_L2_m2__nf1_gboth_sdfull_pc/B.n13 218.815
R120 nfet_01v8_lvt_W5_L2_m2__nf1_gboth_sdfull_pc/B.n22 nfet_01v8_lvt_W5_L2_m2__nf1_gboth_sdfull_pc/B.n13 218.815
R121 nfet_01v8_lvt_W5_L2_m2__nf1_gboth_sdfull_pc/B.n33 nfet_01v8_lvt_W5_L2_m2__nf1_gboth_sdfull_pc/B.n13 218.815
R122 nfet_01v8_lvt_W5_L2_m2__nf1_gboth_sdfull_pc/B.n25 nfet_01v8_lvt_W5_L2_m2__nf1_gboth_sdfull_pc/B.n13 218.815
R123 nfet_01v8_lvt_W5_L2_m2__nf1_gboth_sdfull_pc/B.n26 nfet_01v8_lvt_W5_L2_m2__nf1_gboth_sdfull_pc/B.n13 218.815
R124 nfet_01v8_lvt_W5_L2_m2__nf1_gboth_sdfull_pc/B.n115 nfet_01v8_lvt_W5_L2_m2__nf1_gboth_sdfull_pc/B.n73 218.815
R125 nfet_01v8_lvt_W5_L2_m2__nf1_gboth_sdfull_pc/B.n115 nfet_01v8_lvt_W5_L2_m2__nf1_gboth_sdfull_pc/B.n72 218.815
R126 nfet_01v8_lvt_W5_L2_m2__nf1_gboth_sdfull_pc/B.n115 nfet_01v8_lvt_W5_L2_m2__nf1_gboth_sdfull_pc/B.n74 218.815
R127 nfet_01v8_lvt_W5_L2_m2__nf1_gboth_sdfull_pc/B.n115 nfet_01v8_lvt_W5_L2_m2__nf1_gboth_sdfull_pc/B.n75 218.815
R128 nfet_01v8_lvt_W5_L2_m2__nf1_gboth_sdfull_pc/B.n115 nfet_01v8_lvt_W5_L2_m2__nf1_gboth_sdfull_pc/B.n71 218.815
R129 nfet_01v8_lvt_W5_L2_m2__nf1_gboth_sdfull_pc/B.n115 nfet_01v8_lvt_W5_L2_m2__nf1_gboth_sdfull_pc/B.n76 218.815
R130 nfet_01v8_lvt_W5_L2_m2__nf1_gboth_sdfull_pc/B.n115 nfet_01v8_lvt_W5_L2_m2__nf1_gboth_sdfull_pc/B.n77 218.815
R131 nfet_01v8_lvt_W5_L2_m2__nf1_gboth_sdfull_pc/B.n115 nfet_01v8_lvt_W5_L2_m2__nf1_gboth_sdfull_pc/B.n114 218.815
R132 nfet_01v8_lvt_W5_L2_m2__nf1_gboth_sdfull_pc/B.n117 nfet_01v8_lvt_W5_L2_m2__nf1_gboth_sdfull_pc/B.n116 213.714
R133 nfet_01v8_lvt_W5_L2_m2__nf1_gboth_sdfull_pc/B.n117 nfet_01v8_lvt_W5_L2_m2__nf1_gboth_sdfull_pc/B.n4 213.714
R134 nfet_01v8_lvt_W5_L2_m2__nf1_gboth_sdfull_pc/B.n123 nfet_01v8_lvt_W5_L2_m2__nf1_gboth_sdfull_pc/B.n4 213.714
R135 nfet_01v8_lvt_W5_L2_m2__nf1_gboth_sdfull_pc/B.n63 nfet_01v8_lvt_W5_L2_m2__nf1_gboth_sdfull_pc/B.n62 213.714
R136 nfet_01v8_lvt_W5_L2_m2__nf1_gboth_sdfull_pc/B.n63 nfet_01v8_lvt_W5_L2_m2__nf1_gboth_sdfull_pc/B.n9 213.714
R137 nfet_01v8_lvt_W5_L2_m2__nf1_gboth_sdfull_pc/B.n56 nfet_01v8_lvt_W5_L2_m2__nf1_gboth_sdfull_pc/B.n9 213.714
R138 nfet_01v8_lvt_W5_L2_m2__nf1_gboth_sdfull_pc/B.n51 nfet_01v8_lvt_W5_L2_m2__nf1_gboth_sdfull_pc/B.n50 147.374
R139 nfet_01v8_lvt_W5_L2_m2__nf1_gboth_sdfull_pc/B.n48 nfet_01v8_lvt_W5_L2_m2__nf1_gboth_sdfull_pc/B.n47 147.374
R140 nfet_01v8_lvt_W5_L2_m2__nf1_gboth_sdfull_pc/B.n19 nfet_01v8_lvt_W5_L2_m2__nf1_gboth_sdfull_pc/B.n17 147.374
R141 nfet_01v8_lvt_W5_L2_m2__nf1_gboth_sdfull_pc/B.n41 nfet_01v8_lvt_W5_L2_m2__nf1_gboth_sdfull_pc/B.n40 147.374
R142 nfet_01v8_lvt_W5_L2_m2__nf1_gboth_sdfull_pc/B.n22 nfet_01v8_lvt_W5_L2_m2__nf1_gboth_sdfull_pc/B.n20 147.374
R143 nfet_01v8_lvt_W5_L2_m2__nf1_gboth_sdfull_pc/B.n34 nfet_01v8_lvt_W5_L2_m2__nf1_gboth_sdfull_pc/B.n33 147.374
R144 nfet_01v8_lvt_W5_L2_m2__nf1_gboth_sdfull_pc/B.n25 nfet_01v8_lvt_W5_L2_m2__nf1_gboth_sdfull_pc/B.n23 147.374
R145 nfet_01v8_lvt_W5_L2_m2__nf1_gboth_sdfull_pc/B.n27 nfet_01v8_lvt_W5_L2_m2__nf1_gboth_sdfull_pc/B.n26 147.374
R146 nfet_01v8_lvt_W5_L2_m2__nf1_gboth_sdfull_pc/B.n85 nfet_01v8_lvt_W5_L2_m2__nf1_gboth_sdfull_pc/B.n73 147.374
R147 nfet_01v8_lvt_W5_L2_m2__nf1_gboth_sdfull_pc/B.n86 nfet_01v8_lvt_W5_L2_m2__nf1_gboth_sdfull_pc/B.n72 147.374
R148 nfet_01v8_lvt_W5_L2_m2__nf1_gboth_sdfull_pc/B.n93 nfet_01v8_lvt_W5_L2_m2__nf1_gboth_sdfull_pc/B.n74 147.374
R149 nfet_01v8_lvt_W5_L2_m2__nf1_gboth_sdfull_pc/B.n97 nfet_01v8_lvt_W5_L2_m2__nf1_gboth_sdfull_pc/B.n75 147.374
R150 nfet_01v8_lvt_W5_L2_m2__nf1_gboth_sdfull_pc/B.n98 nfet_01v8_lvt_W5_L2_m2__nf1_gboth_sdfull_pc/B.n71 147.374
R151 nfet_01v8_lvt_W5_L2_m2__nf1_gboth_sdfull_pc/B.n105 nfet_01v8_lvt_W5_L2_m2__nf1_gboth_sdfull_pc/B.n76 147.374
R152 nfet_01v8_lvt_W5_L2_m2__nf1_gboth_sdfull_pc/B.n108 nfet_01v8_lvt_W5_L2_m2__nf1_gboth_sdfull_pc/B.n77 147.374
R153 nfet_01v8_lvt_W5_L2_m2__nf1_gboth_sdfull_pc/B.n114 nfet_01v8_lvt_W5_L2_m2__nf1_gboth_sdfull_pc/B.n79 147.374
R154 nfet_01v8_lvt_W5_L2_m2__nf1_gboth_sdfull_pc/B.n82 nfet_01v8_lvt_W5_L2_m2__nf1_gboth_sdfull_pc/B.n73 147.374
R155 nfet_01v8_lvt_W5_L2_m2__nf1_gboth_sdfull_pc/B.n89 nfet_01v8_lvt_W5_L2_m2__nf1_gboth_sdfull_pc/B.n72 147.374
R156 nfet_01v8_lvt_W5_L2_m2__nf1_gboth_sdfull_pc/B.n90 nfet_01v8_lvt_W5_L2_m2__nf1_gboth_sdfull_pc/B.n74 147.374
R157 nfet_01v8_lvt_W5_L2_m2__nf1_gboth_sdfull_pc/B.n94 nfet_01v8_lvt_W5_L2_m2__nf1_gboth_sdfull_pc/B.n75 147.374
R158 nfet_01v8_lvt_W5_L2_m2__nf1_gboth_sdfull_pc/B.n101 nfet_01v8_lvt_W5_L2_m2__nf1_gboth_sdfull_pc/B.n71 147.374
R159 nfet_01v8_lvt_W5_L2_m2__nf1_gboth_sdfull_pc/B.n102 nfet_01v8_lvt_W5_L2_m2__nf1_gboth_sdfull_pc/B.n76 147.374
R160 nfet_01v8_lvt_W5_L2_m2__nf1_gboth_sdfull_pc/B.n106 nfet_01v8_lvt_W5_L2_m2__nf1_gboth_sdfull_pc/B.n77 147.374
R161 nfet_01v8_lvt_W5_L2_m2__nf1_gboth_sdfull_pc/B.n114 nfet_01v8_lvt_W5_L2_m2__nf1_gboth_sdfull_pc/B.n113 147.374
R162 nfet_01v8_lvt_W5_L2_m2__nf1_gboth_sdfull_pc/B.n26 nfet_01v8_lvt_W5_L2_m2__nf1_gboth_sdfull_pc/B.n12 147.374
R163 nfet_01v8_lvt_W5_L2_m2__nf1_gboth_sdfull_pc/B.n28 nfet_01v8_lvt_W5_L2_m2__nf1_gboth_sdfull_pc/B.n25 147.374
R164 nfet_01v8_lvt_W5_L2_m2__nf1_gboth_sdfull_pc/B.n33 nfet_01v8_lvt_W5_L2_m2__nf1_gboth_sdfull_pc/B.n32 147.374
R165 nfet_01v8_lvt_W5_L2_m2__nf1_gboth_sdfull_pc/B.n35 nfet_01v8_lvt_W5_L2_m2__nf1_gboth_sdfull_pc/B.n22 147.374
R166 nfet_01v8_lvt_W5_L2_m2__nf1_gboth_sdfull_pc/B.n40 nfet_01v8_lvt_W5_L2_m2__nf1_gboth_sdfull_pc/B.n39 147.374
R167 nfet_01v8_lvt_W5_L2_m2__nf1_gboth_sdfull_pc/B.n42 nfet_01v8_lvt_W5_L2_m2__nf1_gboth_sdfull_pc/B.n19 147.374
R168 nfet_01v8_lvt_W5_L2_m2__nf1_gboth_sdfull_pc/B.n47 nfet_01v8_lvt_W5_L2_m2__nf1_gboth_sdfull_pc/B.n46 147.374
R169 nfet_01v8_lvt_W5_L2_m2__nf1_gboth_sdfull_pc/B.n50 nfet_01v8_lvt_W5_L2_m2__nf1_gboth_sdfull_pc/B.n49 147.374
R170 nfet_01v8_lvt_W5_L2_m2__nf1_gboth_sdfull_pc/B.n115 B 135.143
R171 nfet_01v8_lvt_W5_L2_m2__nf1_gboth_sdfull_pc/B.n123 nfet_01v8_lvt_W5_L2_m2__nf1_gboth_sdfull_pc/B.t0 106.858
R172 nfet_01v8_lvt_W5_L2_m2__nf1_gboth_sdfull_pc/B.n62 nfet_01v8_lvt_W5_L2_m2__nf1_gboth_sdfull_pc/B.t0 106.858
R173 nfet_01v8_lvt_W5_L2_m2__nf1_gboth_sdfull_pc/B.n83 nfet_01v8_lvt_W5_L2_m2__nf1_gboth_sdfull_pc/B.n81 75.6711
R174 nfet_01v8_lvt_W5_L2_m2__nf1_gboth_sdfull_pc/B.n58 nfet_01v8_lvt_W5_L2_m2__nf1_gboth_sdfull_pc/B.n11 75.6711
R175 nfet_01v8_lvt_W5_L2_m2__nf1_gboth_sdfull_pc/B.n112 nfet_01v8_lvt_W5_L2_m2__nf1_gboth_sdfull_pc/B.n67 75.6711
R176 nfet_01v8_lvt_W5_L2_m2__nf1_gboth_sdfull_pc/B.n54 nfet_01v8_lvt_W5_L2_m2__nf1_gboth_sdfull_pc/B.n53 75.6711
R177 nfet_01v8_lvt_W5_L2_m2__nf1_gboth_sdfull_pc/B.n84 nfet_01v8_lvt_W5_L2_m2__nf1_gboth_sdfull_pc/B.n83 25.6005
R178 nfet_01v8_lvt_W5_L2_m2__nf1_gboth_sdfull_pc/B.n87 nfet_01v8_lvt_W5_L2_m2__nf1_gboth_sdfull_pc/B.n84 25.6005
R179 nfet_01v8_lvt_W5_L2_m2__nf1_gboth_sdfull_pc/B.n88 nfet_01v8_lvt_W5_L2_m2__nf1_gboth_sdfull_pc/B.n87 25.6005
R180 nfet_01v8_lvt_W5_L2_m2__nf1_gboth_sdfull_pc/B.n91 nfet_01v8_lvt_W5_L2_m2__nf1_gboth_sdfull_pc/B.n88 25.6005
R181 nfet_01v8_lvt_W5_L2_m2__nf1_gboth_sdfull_pc/B.n92 nfet_01v8_lvt_W5_L2_m2__nf1_gboth_sdfull_pc/B.n91 25.6005
R182 nfet_01v8_lvt_W5_L2_m2__nf1_gboth_sdfull_pc/B.n95 nfet_01v8_lvt_W5_L2_m2__nf1_gboth_sdfull_pc/B.n92 25.6005
R183 nfet_01v8_lvt_W5_L2_m2__nf1_gboth_sdfull_pc/B.n96 nfet_01v8_lvt_W5_L2_m2__nf1_gboth_sdfull_pc/B.n95 25.6005
R184 nfet_01v8_lvt_W5_L2_m2__nf1_gboth_sdfull_pc/B.n99 nfet_01v8_lvt_W5_L2_m2__nf1_gboth_sdfull_pc/B.n96 25.6005
R185 nfet_01v8_lvt_W5_L2_m2__nf1_gboth_sdfull_pc/B.n100 nfet_01v8_lvt_W5_L2_m2__nf1_gboth_sdfull_pc/B.n99 25.6005
R186 nfet_01v8_lvt_W5_L2_m2__nf1_gboth_sdfull_pc/B.n103 nfet_01v8_lvt_W5_L2_m2__nf1_gboth_sdfull_pc/B.n100 25.6005
R187 nfet_01v8_lvt_W5_L2_m2__nf1_gboth_sdfull_pc/B.n104 nfet_01v8_lvt_W5_L2_m2__nf1_gboth_sdfull_pc/B.n103 25.6005
R188 nfet_01v8_lvt_W5_L2_m2__nf1_gboth_sdfull_pc/B.n107 nfet_01v8_lvt_W5_L2_m2__nf1_gboth_sdfull_pc/B.n104 25.6005
R189 nfet_01v8_lvt_W5_L2_m2__nf1_gboth_sdfull_pc/B.n109 nfet_01v8_lvt_W5_L2_m2__nf1_gboth_sdfull_pc/B.n107 25.6005
R190 nfet_01v8_lvt_W5_L2_m2__nf1_gboth_sdfull_pc/B.n110 nfet_01v8_lvt_W5_L2_m2__nf1_gboth_sdfull_pc/B.n109 25.6005
R191 nfet_01v8_lvt_W5_L2_m2__nf1_gboth_sdfull_pc/B.n111 nfet_01v8_lvt_W5_L2_m2__nf1_gboth_sdfull_pc/B.n110 25.6005
R192 nfet_01v8_lvt_W5_L2_m2__nf1_gboth_sdfull_pc/B.n112 nfet_01v8_lvt_W5_L2_m2__nf1_gboth_sdfull_pc/B.n111 25.6005
R193 nfet_01v8_lvt_W5_L2_m2__nf1_gboth_sdfull_pc/B.n81 nfet_01v8_lvt_W5_L2_m2__nf1_gboth_sdfull_pc/B.n80 25.6005
R194 nfet_01v8_lvt_W5_L2_m2__nf1_gboth_sdfull_pc/B.n80 nfet_01v8_lvt_W5_L2_m2__nf1_gboth_sdfull_pc/B.n1 25.6005
R195 nfet_01v8_lvt_W5_L2_m2__nf1_gboth_sdfull_pc/B.n125 nfet_01v8_lvt_W5_L2_m2__nf1_gboth_sdfull_pc/B.n1 25.6005
R196 nfet_01v8_lvt_W5_L2_m2__nf1_gboth_sdfull_pc/B.n60 nfet_01v8_lvt_W5_L2_m2__nf1_gboth_sdfull_pc/B.n0 25.6005
R197 nfet_01v8_lvt_W5_L2_m2__nf1_gboth_sdfull_pc/B.n60 nfet_01v8_lvt_W5_L2_m2__nf1_gboth_sdfull_pc/B.n59 25.6005
R198 nfet_01v8_lvt_W5_L2_m2__nf1_gboth_sdfull_pc/B.n59 nfet_01v8_lvt_W5_L2_m2__nf1_gboth_sdfull_pc/B.n58 25.6005
R199 nfet_01v8_lvt_W5_L2_m2__nf1_gboth_sdfull_pc/B.n24 nfet_01v8_lvt_W5_L2_m2__nf1_gboth_sdfull_pc/B.n11 25.6005
R200 nfet_01v8_lvt_W5_L2_m2__nf1_gboth_sdfull_pc/B.n29 nfet_01v8_lvt_W5_L2_m2__nf1_gboth_sdfull_pc/B.n24 25.6005
R201 nfet_01v8_lvt_W5_L2_m2__nf1_gboth_sdfull_pc/B.n30 nfet_01v8_lvt_W5_L2_m2__nf1_gboth_sdfull_pc/B.n29 25.6005
R202 nfet_01v8_lvt_W5_L2_m2__nf1_gboth_sdfull_pc/B.n31 nfet_01v8_lvt_W5_L2_m2__nf1_gboth_sdfull_pc/B.n30 25.6005
R203 nfet_01v8_lvt_W5_L2_m2__nf1_gboth_sdfull_pc/B.n31 nfet_01v8_lvt_W5_L2_m2__nf1_gboth_sdfull_pc/B.n21 25.6005
R204 nfet_01v8_lvt_W5_L2_m2__nf1_gboth_sdfull_pc/B.n36 nfet_01v8_lvt_W5_L2_m2__nf1_gboth_sdfull_pc/B.n21 25.6005
R205 nfet_01v8_lvt_W5_L2_m2__nf1_gboth_sdfull_pc/B.n37 nfet_01v8_lvt_W5_L2_m2__nf1_gboth_sdfull_pc/B.n36 25.6005
R206 nfet_01v8_lvt_W5_L2_m2__nf1_gboth_sdfull_pc/B.n38 nfet_01v8_lvt_W5_L2_m2__nf1_gboth_sdfull_pc/B.n37 25.6005
R207 nfet_01v8_lvt_W5_L2_m2__nf1_gboth_sdfull_pc/B.n38 nfet_01v8_lvt_W5_L2_m2__nf1_gboth_sdfull_pc/B.n18 25.6005
R208 nfet_01v8_lvt_W5_L2_m2__nf1_gboth_sdfull_pc/B.n43 nfet_01v8_lvt_W5_L2_m2__nf1_gboth_sdfull_pc/B.n18 25.6005
R209 nfet_01v8_lvt_W5_L2_m2__nf1_gboth_sdfull_pc/B.n44 nfet_01v8_lvt_W5_L2_m2__nf1_gboth_sdfull_pc/B.n43 25.6005
R210 nfet_01v8_lvt_W5_L2_m2__nf1_gboth_sdfull_pc/B.n45 nfet_01v8_lvt_W5_L2_m2__nf1_gboth_sdfull_pc/B.n44 25.6005
R211 nfet_01v8_lvt_W5_L2_m2__nf1_gboth_sdfull_pc/B.n45 nfet_01v8_lvt_W5_L2_m2__nf1_gboth_sdfull_pc/B.n16 25.6005
R212 nfet_01v8_lvt_W5_L2_m2__nf1_gboth_sdfull_pc/B.n16 nfet_01v8_lvt_W5_L2_m2__nf1_gboth_sdfull_pc/B.n15 25.6005
R213 nfet_01v8_lvt_W5_L2_m2__nf1_gboth_sdfull_pc/B.n52 nfet_01v8_lvt_W5_L2_m2__nf1_gboth_sdfull_pc/B.n15 25.6005
R214 nfet_01v8_lvt_W5_L2_m2__nf1_gboth_sdfull_pc/B.n53 nfet_01v8_lvt_W5_L2_m2__nf1_gboth_sdfull_pc/B.n52 25.6005
R215 nfet_01v8_lvt_W5_L2_m2__nf1_gboth_sdfull_pc/B.n119 nfet_01v8_lvt_W5_L2_m2__nf1_gboth_sdfull_pc/B.n67 25.6005
R216 nfet_01v8_lvt_W5_L2_m2__nf1_gboth_sdfull_pc/B.n120 nfet_01v8_lvt_W5_L2_m2__nf1_gboth_sdfull_pc/B.n119 25.6005
R217 nfet_01v8_lvt_W5_L2_m2__nf1_gboth_sdfull_pc/B.n121 nfet_01v8_lvt_W5_L2_m2__nf1_gboth_sdfull_pc/B.n120 25.6005
R218 nfet_01v8_lvt_W5_L2_m2__nf1_gboth_sdfull_pc/B.n121 nfet_01v8_lvt_W5_L2_m2__nf1_gboth_sdfull_pc/B.n66 25.6005
R219 nfet_01v8_lvt_W5_L2_m2__nf1_gboth_sdfull_pc/B.n66 nfet_01v8_lvt_W5_L2_m2__nf1_gboth_sdfull_pc/B.n65 25.6005
R220 nfet_01v8_lvt_W5_L2_m2__nf1_gboth_sdfull_pc/B.n65 nfet_01v8_lvt_W5_L2_m2__nf1_gboth_sdfull_pc/B.n7 25.6005
R221 nfet_01v8_lvt_W5_L2_m2__nf1_gboth_sdfull_pc/B.n54 nfet_01v8_lvt_W5_L2_m2__nf1_gboth_sdfull_pc/B.n7 25.6005
R222 B nfet_01v8_lvt_W5_L2_m2__nf1_gboth_sdfull_pc/B.n0 19.2005
R223 B nfet_01v8_lvt_W5_L2_m2__nf1_gboth_sdfull_pc/B.n125 6.4005
R224 B.n113 B.n9 1164.62
R225 B.n120 B.n4 1164.62
R226 B.n57 B.n37 1164.62
R227 B.n44 B.n35 1164.62
R228 B.n114 B.n2 644.042
R229 B.n39 B.n36 644.042
R230 B.n111 B.n9 585
R231 B.n110 B.n109 585
R232 B.n108 B.n105 585
R233 B.n104 B.n1 585
R234 B.n126 B.n125 585
R235 B.n123 B.n0 585
R236 B.n122 B.n3 585
R237 B.n120 B.n119 585
R238 B.n114 B.n4 585
R239 B.n118 B.n4 585
R240 B.n116 B.n115 585
R241 B.n117 B.n116 585
R242 B.n7 B.n6 585
R243 B.n6 B.n5 585
R244 B.n99 B.n98 585
R245 B.n98 B.n97 585
R246 B.n13 B.n12 585
R247 B.n96 B.n13 585
R248 B.n94 B.n93 585
R249 B.n95 B.n94 585
R250 B.n16 B.n15 585
R251 B.n15 B.n14 585
R252 B.n86 B.n85 585
R253 B.n85 B.n84 585
R254 B.n21 B.n20 585
R255 B.n83 B.n21 585
R256 B.n81 B.n80 585
R257 B.n82 B.n81 585
R258 B.n24 B.n23 585
R259 B.n23 B.n22 585
R260 B.n74 B.n73 585
R261 B.n73 B.n72 585
R262 B.n29 B.n28 585
R263 B.n71 B.n29 585
R264 B.n69 B.n68 585
R265 B.n70 B.n69 585
R266 B.n32 B.n31 585
R267 B.n31 B.n30 585
R268 B.n62 B.n61 585
R269 B.n61 B.n60 585
R270 B.n37 B.n36 585
R271 B.n59 B.n37 585
R272 B.n58 B.n57 585
R273 B.n55 B.n38 585
R274 B.n54 B.n40 585
R275 B.n52 B.n51 585
R276 B.n50 B.n41 585
R277 B.n49 B.n48 585
R278 B.n46 B.n42 585
R279 B.n44 B.n43 585
R280 B.n36 B.n35 585
R281 B.n35 B.n34 585
R282 B.n63 B.n62 585
R283 B.n64 B.n63 585
R284 B.n33 B.n32 585
R285 B.n65 B.n33 585
R286 B.n68 B.n67 585
R287 B.n67 B.n66 585
R288 B.n28 B.n27 585
R289 B.n27 B.n26 585
R290 B.n75 B.n74 585
R291 B.n76 B.n75 585
R292 B.n25 B.n24 585
R293 B.n77 B.n25 585
R294 B.n80 B.n79 585
R295 B.n79 B.n78 585
R296 B.n20 B.n19 585
R297 B.n19 B.n18 585
R298 B.n87 B.n86 585
R299 B.n88 B.n87 585
R300 B.n17 B.n16 585
R301 B.n89 B.n17 585
R302 B.n93 B.n92 585
R303 B.n92 B.n91 585
R304 B.n12 B.n11 585
R305 B.n90 B.n11 585
R306 B.n100 B.n99 585
R307 B.n100 B.n10 585
R308 B.n101 B.n7 585
R309 B.n102 B.n101 585
R310 B.n115 B.n8 585
R311 B.n103 B.n8 585
R312 B.n114 B.n113 585
R313 B.n113 B.n112 585
R314 B.n113 B.n8 394
R315 B.n101 B.n8 394
R316 B.n101 B.n100 394
R317 B.n100 B.n11 394
R318 B.n92 B.n11 394
R319 B.n92 B.n17 394
R320 B.n87 B.n17 394
R321 B.n87 B.n19 394
R322 B.n79 B.n19 394
R323 B.n79 B.n25 394
R324 B.n75 B.n25 394
R325 B.n75 B.n27 394
R326 B.n67 B.n27 394
R327 B.n67 B.n33 394
R328 B.n63 B.n33 394
R329 B.n63 B.n35 394
R330 B.n123 B.n122 394
R331 B.n125 B.n1 394
R332 B.n109 B.n108 394
R333 B.n116 B.n4 394
R334 B.n116 B.n6 394
R335 B.n98 B.n6 394
R336 B.n98 B.n13 394
R337 B.n94 B.n13 394
R338 B.n94 B.n15 394
R339 B.n85 B.n15 394
R340 B.n85 B.n21 394
R341 B.n81 B.n21 394
R342 B.n81 B.n23 394
R343 B.n73 B.n23 394
R344 B.n73 B.n29 394
R345 B.n69 B.n29 394
R346 B.n69 B.n31 394
R347 B.n61 B.n31 394
R348 B.n61 B.n37 394
R349 B.n55 B.n54 394
R350 B.n52 B.n41 394
R351 B.n48 B.n46 394
R352 B.n115 B.n114 387.565
R353 B.n115 B.n7 387.565
R354 B.n99 B.n7 387.565
R355 B.n99 B.n12 387.565
R356 B.n93 B.n12 387.565
R357 B.n93 B.n16 387.565
R358 B.n86 B.n16 387.565
R359 B.n86 B.n20 387.565
R360 B.n80 B.n20 387.565
R361 B.n80 B.n24 387.565
R362 B.n74 B.n24 387.565
R363 B.n74 B.n28 387.565
R364 B.n68 B.n28 387.565
R365 B.n68 B.n32 387.565
R366 B.n62 B.n32 387.565
R367 B.n62 B.n36 387.565
R368 B.n2 B 245.078
R369 B.n106 B.n2 218.815
R370 B.n107 B.n2 218.815
R371 B.n124 B.n2 218.815
R372 B.n121 B.n2 218.815
R373 B.n56 B.n39 218.815
R374 B.n53 B.n39 218.815
R375 B.n47 B.n39 218.815
R376 B.n45 B.n39 218.815
R377 B.n106 B.n9 147.374
R378 B.n108 B.n107 147.374
R379 B.n125 B.n124 147.374
R380 B.n122 B.n121 147.374
R381 B.n57 B.n56 147.374
R382 B.n54 B.n53 147.374
R383 B.n47 B.n41 147.374
R384 B.n46 B.n45 147.374
R385 B.n121 B.n120 147.374
R386 B.n124 B.n123 147.374
R387 B.n107 B.n1 147.374
R388 B.n109 B.n106 147.374
R389 B.n56 B.n55 147.374
R390 B.n53 B.n52 147.374
R391 B.n48 B.n47 147.374
R392 B.n45 B.n44 147.374
R393 B.n119 B.n118 75.6711
R394 B.n59 B.n58 75.6711
R395 B.n112 B.n111 75.6711
R396 B.n43 B.n34 75.6711
R397 B.n119 B.n3 25.6005
R398 B.n3 B.n0 25.6005
R399 B.n126 B.n0 25.6005
R400 B.n105 B.n104 25.6005
R401 B.n110 B.n105 25.6005
R402 B.n111 B.n110 25.6005
R403 B.n118 B.n117 25.6005
R404 B.n117 B.n5 25.6005
R405 B.n97 B.n5 25.6005
R406 B.n97 B.n96 25.6005
R407 B.n96 B.n95 25.6005
R408 B.n95 B.n14 25.6005
R409 B.n84 B.n14 25.6005
R410 B.n84 B.n83 25.6005
R411 B.n83 B.n82 25.6005
R412 B.n82 B.n22 25.6005
R413 B.n72 B.n22 25.6005
R414 B.n72 B.n71 25.6005
R415 B.n71 B.n70 25.6005
R416 B.n70 B.n30 25.6005
R417 B.n60 B.n30 25.6005
R418 B.n60 B.n59 25.6005
R419 B.n58 B.n38 25.6005
R420 B.n40 B.n38 25.6005
R421 B.n51 B.n40 25.6005
R422 B.n51 B.n50 25.6005
R423 B.n50 B.n49 25.6005
R424 B.n49 B.n42 25.6005
R425 B.n43 B.n42 25.6005
R426 B.n112 B.n103 25.6005
R427 B.n103 B.n102 25.6005
R428 B.n102 B.n10 25.6005
R429 B.n90 B.n10 25.6005
R430 B.n91 B.n90 25.6005
R431 B.n91 B.n89 25.6005
R432 B.n89 B.n88 25.6005
R433 B.n88 B.n18 25.6005
R434 B.n78 B.n18 25.6005
R435 B.n78 B.n77 25.6005
R436 B.n77 B.n76 25.6005
R437 B.n76 B.n26 25.6005
R438 B.n66 B.n26 25.6005
R439 B.n66 B.n65 25.6005
R440 B.n65 B.n64 25.6005
R441 B.n64 B.n34 25.6005
R442 B.n104 B 19.2005
R443 B B.n126 6.4005
R444 w_n43_n43.n120 w_n43_n43.n5 1164.62
R445 w_n43_n43.n110 w_n43_n43.n11 1164.62
R446 w_n43_n43.n59 w_n43_n43.n39 1164.62
R447 w_n43_n43.n46 w_n43_n43.n37 1164.62
R448 w_n43_n43.n9 w_n43_n43.n3 644.042
R449 w_n43_n43.n41 w_n43_n43.n38 644.042
R450 w_n43_n43.n60 w_n43_n43.n59 585
R451 w_n43_n43.n57 w_n43_n43.n40 585
R452 w_n43_n43.n56 w_n43_n43.n42 585
R453 w_n43_n43.n54 w_n43_n43.n53 585
R454 w_n43_n43.n52 w_n43_n43.n43 585
R455 w_n43_n43.n51 w_n43_n43.n50 585
R456 w_n43_n43.n48 w_n43_n43.n44 585
R457 w_n43_n43.n46 w_n43_n43.n45 585
R458 w_n43_n43.n38 w_n43_n43.n37 585
R459 w_n43_n43.n37 w_n43_n43.n36 585
R460 w_n43_n43.n65 w_n43_n43.n64 585
R461 w_n43_n43.n66 w_n43_n43.n65 585
R462 w_n43_n43.n35 w_n43_n43.n34 585
R463 w_n43_n43.n67 w_n43_n43.n35 585
R464 w_n43_n43.n70 w_n43_n43.n69 585
R465 w_n43_n43.n69 w_n43_n43.n68 585
R466 w_n43_n43.n30 w_n43_n43.n29 585
R467 w_n43_n43.n29 w_n43_n43.n28 585
R468 w_n43_n43.n77 w_n43_n43.n76 585
R469 w_n43_n43.n78 w_n43_n43.n77 585
R470 w_n43_n43.n27 w_n43_n43.n26 585
R471 w_n43_n43.n79 w_n43_n43.n27 585
R472 w_n43_n43.n82 w_n43_n43.n81 585
R473 w_n43_n43.n81 w_n43_n43.n80 585
R474 w_n43_n43.n22 w_n43_n43.n21 585
R475 w_n43_n43.n21 w_n43_n43.n20 585
R476 w_n43_n43.n89 w_n43_n43.n88 585
R477 w_n43_n43.n90 w_n43_n43.n89 585
R478 w_n43_n43.n19 w_n43_n43.n18 585
R479 w_n43_n43.n91 w_n43_n43.n19 585
R480 w_n43_n43.n94 w_n43_n43.n93 585
R481 w_n43_n43.n93 w_n43_n43.n92 585
R482 w_n43_n43.n14 w_n43_n43.n13 585
R483 w_n43_n43.n13 w_n43_n43.n12 585
R484 w_n43_n43.n101 w_n43_n43.n100 585
R485 w_n43_n43.n102 w_n43_n43.n101 585
R486 w_n43_n43.n10 w_n43_n43.n8 585
R487 w_n43_n43.n103 w_n43_n43.n10 585
R488 w_n43_n43.n115 w_n43_n43.n114 585
R489 w_n43_n43.n114 w_n43_n43.n113 585
R490 w_n43_n43.n11 w_n43_n43.n9 585
R491 w_n43_n43.n112 w_n43_n43.n11 585
R492 w_n43_n43.n111 w_n43_n43.n110 585
R493 w_n43_n43.n108 w_n43_n43.n104 585
R494 w_n43_n43.n107 w_n43_n43.n105 585
R495 w_n43_n43.n2 w_n43_n43.n0 585
R496 w_n43_n43.n126 w_n43_n43.n125 585
R497 w_n43_n43.n123 w_n43_n43.n1 585
R498 w_n43_n43.n122 w_n43_n43.n4 585
R499 w_n43_n43.n120 w_n43_n43.n119 585
R500 w_n43_n43.n9 w_n43_n43.n5 585
R501 w_n43_n43.n118 w_n43_n43.n5 585
R502 w_n43_n43.n116 w_n43_n43.n115 585
R503 w_n43_n43.n117 w_n43_n43.n116 585
R504 w_n43_n43.n8 w_n43_n43.n7 585
R505 w_n43_n43.n7 w_n43_n43.n6 585
R506 w_n43_n43.n100 w_n43_n43.n99 585
R507 w_n43_n43.n99 w_n43_n43.n98 585
R508 w_n43_n43.n15 w_n43_n43.n14 585
R509 w_n43_n43.n97 w_n43_n43.n15 585
R510 w_n43_n43.n95 w_n43_n43.n94 585
R511 w_n43_n43.n96 w_n43_n43.n95 585
R512 w_n43_n43.n18 w_n43_n43.n17 585
R513 w_n43_n43.n17 w_n43_n43.n16 585
R514 w_n43_n43.n88 w_n43_n43.n87 585
R515 w_n43_n43.n87 w_n43_n43.n86 585
R516 w_n43_n43.n23 w_n43_n43.n22 585
R517 w_n43_n43.n85 w_n43_n43.n23 585
R518 w_n43_n43.n83 w_n43_n43.n82 585
R519 w_n43_n43.n84 w_n43_n43.n83 585
R520 w_n43_n43.n26 w_n43_n43.n25 585
R521 w_n43_n43.n25 w_n43_n43.n24 585
R522 w_n43_n43.n76 w_n43_n43.n75 585
R523 w_n43_n43.n75 w_n43_n43.n74 585
R524 w_n43_n43.n31 w_n43_n43.n30 585
R525 w_n43_n43.n73 w_n43_n43.n31 585
R526 w_n43_n43.n71 w_n43_n43.n70 585
R527 w_n43_n43.n72 w_n43_n43.n71 585
R528 w_n43_n43.n34 w_n43_n43.n33 585
R529 w_n43_n43.n33 w_n43_n43.n32 585
R530 w_n43_n43.n64 w_n43_n43.n63 585
R531 w_n43_n43.n63 w_n43_n43.n62 585
R532 w_n43_n43.n39 w_n43_n43.n38 585
R533 w_n43_n43.n61 w_n43_n43.n39 585
R534 w_n43_n43.n116 w_n43_n43.n5 394
R535 w_n43_n43.n116 w_n43_n43.n7 394
R536 w_n43_n43.n99 w_n43_n43.n7 394
R537 w_n43_n43.n99 w_n43_n43.n15 394
R538 w_n43_n43.n95 w_n43_n43.n15 394
R539 w_n43_n43.n95 w_n43_n43.n17 394
R540 w_n43_n43.n87 w_n43_n43.n17 394
R541 w_n43_n43.n87 w_n43_n43.n23 394
R542 w_n43_n43.n83 w_n43_n43.n23 394
R543 w_n43_n43.n83 w_n43_n43.n25 394
R544 w_n43_n43.n75 w_n43_n43.n25 394
R545 w_n43_n43.n75 w_n43_n43.n31 394
R546 w_n43_n43.n71 w_n43_n43.n31 394
R547 w_n43_n43.n71 w_n43_n43.n33 394
R548 w_n43_n43.n63 w_n43_n43.n33 394
R549 w_n43_n43.n63 w_n43_n43.n39 394
R550 w_n43_n43.n123 w_n43_n43.n122 394
R551 w_n43_n43.n125 w_n43_n43.n2 394
R552 w_n43_n43.n108 w_n43_n43.n107 394
R553 w_n43_n43.n114 w_n43_n43.n11 394
R554 w_n43_n43.n114 w_n43_n43.n10 394
R555 w_n43_n43.n101 w_n43_n43.n10 394
R556 w_n43_n43.n101 w_n43_n43.n13 394
R557 w_n43_n43.n93 w_n43_n43.n13 394
R558 w_n43_n43.n93 w_n43_n43.n19 394
R559 w_n43_n43.n89 w_n43_n43.n19 394
R560 w_n43_n43.n89 w_n43_n43.n21 394
R561 w_n43_n43.n81 w_n43_n43.n21 394
R562 w_n43_n43.n81 w_n43_n43.n27 394
R563 w_n43_n43.n77 w_n43_n43.n27 394
R564 w_n43_n43.n77 w_n43_n43.n29 394
R565 w_n43_n43.n69 w_n43_n43.n29 394
R566 w_n43_n43.n69 w_n43_n43.n35 394
R567 w_n43_n43.n65 w_n43_n43.n35 394
R568 w_n43_n43.n65 w_n43_n43.n37 394
R569 w_n43_n43.n57 w_n43_n43.n56 394
R570 w_n43_n43.n54 w_n43_n43.n43 394
R571 w_n43_n43.n50 w_n43_n43.n48 394
R572 w_n43_n43.n115 w_n43_n43.n9 387.565
R573 w_n43_n43.n115 w_n43_n43.n8 387.565
R574 w_n43_n43.n100 w_n43_n43.n8 387.565
R575 w_n43_n43.n100 w_n43_n43.n14 387.565
R576 w_n43_n43.n94 w_n43_n43.n14 387.565
R577 w_n43_n43.n94 w_n43_n43.n18 387.565
R578 w_n43_n43.n88 w_n43_n43.n18 387.565
R579 w_n43_n43.n88 w_n43_n43.n22 387.565
R580 w_n43_n43.n82 w_n43_n43.n22 387.565
R581 w_n43_n43.n82 w_n43_n43.n26 387.565
R582 w_n43_n43.n76 w_n43_n43.n26 387.565
R583 w_n43_n43.n76 w_n43_n43.n30 387.565
R584 w_n43_n43.n70 w_n43_n43.n30 387.565
R585 w_n43_n43.n70 w_n43_n43.n34 387.565
R586 w_n43_n43.n64 w_n43_n43.n34 387.565
R587 w_n43_n43.n64 w_n43_n43.n38 387.565
R588 w_n43_n43.n3 B 245.078
R589 w_n43_n43.n58 w_n43_n43.n41 218.815
R590 w_n43_n43.n55 w_n43_n43.n41 218.815
R591 w_n43_n43.n49 w_n43_n43.n41 218.815
R592 w_n43_n43.n47 w_n43_n43.n41 218.815
R593 w_n43_n43.n109 w_n43_n43.n3 218.815
R594 w_n43_n43.n106 w_n43_n43.n3 218.815
R595 w_n43_n43.n124 w_n43_n43.n3 218.815
R596 w_n43_n43.n121 w_n43_n43.n3 218.815
R597 w_n43_n43.n59 w_n43_n43.n58 147.374
R598 w_n43_n43.n56 w_n43_n43.n55 147.374
R599 w_n43_n43.n49 w_n43_n43.n43 147.374
R600 w_n43_n43.n48 w_n43_n43.n47 147.374
R601 w_n43_n43.n110 w_n43_n43.n109 147.374
R602 w_n43_n43.n107 w_n43_n43.n106 147.374
R603 w_n43_n43.n125 w_n43_n43.n124 147.374
R604 w_n43_n43.n122 w_n43_n43.n121 147.374
R605 w_n43_n43.n121 w_n43_n43.n120 147.374
R606 w_n43_n43.n124 w_n43_n43.n123 147.374
R607 w_n43_n43.n106 w_n43_n43.n2 147.374
R608 w_n43_n43.n109 w_n43_n43.n108 147.374
R609 w_n43_n43.n58 w_n43_n43.n57 147.374
R610 w_n43_n43.n55 w_n43_n43.n54 147.374
R611 w_n43_n43.n50 w_n43_n43.n49 147.374
R612 w_n43_n43.n47 w_n43_n43.n46 147.374
R613 w_n43_n43.n119 w_n43_n43.n118 75.6711
R614 w_n43_n43.n112 w_n43_n43.n111 75.6711
R615 w_n43_n43.n61 w_n43_n43.n60 75.6711
R616 w_n43_n43.n45 w_n43_n43.n36 75.6711
R617 w_n43_n43.n118 w_n43_n43.n117 25.6005
R618 w_n43_n43.n117 w_n43_n43.n6 25.6005
R619 w_n43_n43.n98 w_n43_n43.n6 25.6005
R620 w_n43_n43.n98 w_n43_n43.n97 25.6005
R621 w_n43_n43.n97 w_n43_n43.n96 25.6005
R622 w_n43_n43.n96 w_n43_n43.n16 25.6005
R623 w_n43_n43.n86 w_n43_n43.n16 25.6005
R624 w_n43_n43.n86 w_n43_n43.n85 25.6005
R625 w_n43_n43.n85 w_n43_n43.n84 25.6005
R626 w_n43_n43.n84 w_n43_n43.n24 25.6005
R627 w_n43_n43.n74 w_n43_n43.n24 25.6005
R628 w_n43_n43.n74 w_n43_n43.n73 25.6005
R629 w_n43_n43.n73 w_n43_n43.n72 25.6005
R630 w_n43_n43.n72 w_n43_n43.n32 25.6005
R631 w_n43_n43.n62 w_n43_n43.n32 25.6005
R632 w_n43_n43.n62 w_n43_n43.n61 25.6005
R633 w_n43_n43.n119 w_n43_n43.n4 25.6005
R634 w_n43_n43.n4 w_n43_n43.n1 25.6005
R635 w_n43_n43.n126 w_n43_n43.n1 25.6005
R636 w_n43_n43.n105 w_n43_n43.n0 25.6005
R637 w_n43_n43.n105 w_n43_n43.n104 25.6005
R638 w_n43_n43.n111 w_n43_n43.n104 25.6005
R639 w_n43_n43.n113 w_n43_n43.n112 25.6005
R640 w_n43_n43.n113 w_n43_n43.n103 25.6005
R641 w_n43_n43.n103 w_n43_n43.n102 25.6005
R642 w_n43_n43.n102 w_n43_n43.n12 25.6005
R643 w_n43_n43.n92 w_n43_n43.n12 25.6005
R644 w_n43_n43.n92 w_n43_n43.n91 25.6005
R645 w_n43_n43.n91 w_n43_n43.n90 25.6005
R646 w_n43_n43.n90 w_n43_n43.n20 25.6005
R647 w_n43_n43.n80 w_n43_n43.n20 25.6005
R648 w_n43_n43.n80 w_n43_n43.n79 25.6005
R649 w_n43_n43.n79 w_n43_n43.n78 25.6005
R650 w_n43_n43.n78 w_n43_n43.n28 25.6005
R651 w_n43_n43.n68 w_n43_n43.n28 25.6005
R652 w_n43_n43.n68 w_n43_n43.n67 25.6005
R653 w_n43_n43.n67 w_n43_n43.n66 25.6005
R654 w_n43_n43.n66 w_n43_n43.n36 25.6005
R655 w_n43_n43.n60 w_n43_n43.n40 25.6005
R656 w_n43_n43.n42 w_n43_n43.n40 25.6005
R657 w_n43_n43.n53 w_n43_n43.n42 25.6005
R658 w_n43_n43.n53 w_n43_n43.n52 25.6005
R659 w_n43_n43.n52 w_n43_n43.n51 25.6005
R660 w_n43_n43.n51 w_n43_n43.n44 25.6005
R661 w_n43_n43.n45 w_n43_n43.n44 25.6005
R662 B w_n43_n43.n0 19.2005
R663 B w_n43_n43.n126 6.4005
C3 B.n0 B 0 ; **FLOATING
C4 B.n1 B 0 ; **FLOATING
C5 B.n2 B 0 ; **FLOATING
C6 B.n3 B 0 ; **FLOATING
C7 B.n4 B 0 ; **FLOATING
C8 B.n5 B 0 ; **FLOATING
C9 B.n6 B 0 ; **FLOATING
C10 B.n7 B 0 ; **FLOATING
C11 B.n8 B 0 ; **FLOATING
C12 B.n9 B 0 ; **FLOATING
C13 B.n10 B 0 ; **FLOATING
C14 B.n11 B 0 ; **FLOATING
C15 B.n12 B 0 ; **FLOATING
C16 B.n13 B 0 ; **FLOATING
C17 B.n14 B 0 ; **FLOATING
C18 B.n15 B 0 ; **FLOATING
C19 B.n16 B 0 ; **FLOATING
C20 B.n17 B 0 ; **FLOATING
C21 B.n18 B 0 ; **FLOATING
C22 B.n19 B 0 ; **FLOATING
C23 B.n20 B 0 ; **FLOATING
C24 B.n21 B 0 ; **FLOATING
C25 B.n22 B 0 ; **FLOATING
C26 B.n23 B 0 ; **FLOATING
C27 B.n24 B 0 ; **FLOATING
C28 B.n25 B 0 ; **FLOATING
C29 B.n26 B 0 ; **FLOATING
C30 B.n27 B 0 ; **FLOATING
C31 B.n28 B 0 ; **FLOATING
C32 B.n29 B 0 ; **FLOATING
C33 B.n30 B 0 ; **FLOATING
C34 B.n31 B 0 ; **FLOATING
C35 B.n32 B 0 ; **FLOATING
C36 B.n33 B 0 ; **FLOATING
C37 B.n34 B 0 ; **FLOATING
C38 B.n35 B 0 ; **FLOATING
C39 B.n36 B 0 ; **FLOATING
C40 B.n37 B 0 ; **FLOATING
C41 B.n38 B 0 ; **FLOATING
C42 B.n39 B 0 ; **FLOATING
C43 B.n40 B 0 ; **FLOATING
C44 B.n41 B 0 ; **FLOATING
C45 B.n42 B 0 ; **FLOATING
C46 B.n43 B 0 ; **FLOATING
C47 B.n44 B 0 ; **FLOATING
C48 B.n46 B 0 ; **FLOATING
C49 B.n48 B 0 ; **FLOATING
C50 B.n49 B 0 ; **FLOATING
C51 B.n50 B 0 ; **FLOATING
C52 B.n51 B 0 ; **FLOATING
C53 B.n52 B 0 ; **FLOATING
C54 B.n54 B 0 ; **FLOATING
C55 B.n55 B 0 ; **FLOATING
C56 B.n57 B 0 ; **FLOATING
C57 B.n58 B 0 ; **FLOATING
C58 B.n59 B 0 ; **FLOATING
C59 B.n60 B 0 ; **FLOATING
C60 B.n61 B 0 ; **FLOATING
C61 B.n62 B 0 ; **FLOATING
C62 B.n63 B 0 ; **FLOATING
C63 B.n64 B 0 ; **FLOATING
C64 B.n65 B 0 ; **FLOATING
C65 B.n66 B 0 ; **FLOATING
C66 B.n67 B 0 ; **FLOATING
C67 B.n68 B 0 ; **FLOATING
C68 B.n69 B 0 ; **FLOATING
C69 B.n70 B 0 ; **FLOATING
C70 B.n71 B 0 ; **FLOATING
C71 B.n72 B 0 ; **FLOATING
C72 B.n73 B 0 ; **FLOATING
C73 B.n74 B 0 ; **FLOATING
C74 B.n75 B 0 ; **FLOATING
C75 B.n76 B 0 ; **FLOATING
C76 B.n77 B 0 ; **FLOATING
C77 B.n78 B 0 ; **FLOATING
C78 B.n79 B 0 ; **FLOATING
C79 B.n80 B 0 ; **FLOATING
C80 B.n81 B 0 ; **FLOATING
C81 B.n82 B 0 ; **FLOATING
C82 B.n83 B 0 ; **FLOATING
C83 B.n84 B 0 ; **FLOATING
C84 B.n85 B 0 ; **FLOATING
C85 B.n86 B 0 ; **FLOATING
C86 B.n87 B 0 ; **FLOATING
C87 B.n88 B 0 ; **FLOATING
C88 B.n89 B 0 ; **FLOATING
C89 B.n90 B 0 ; **FLOATING
C90 B.n91 B 0 ; **FLOATING
C91 B.n92 B 0 ; **FLOATING
C92 B.n93 B 0 ; **FLOATING
C93 B.n94 B 0 ; **FLOATING
C94 B.n95 B 0 ; **FLOATING
C95 B.n96 B 0 ; **FLOATING
C96 B.n97 B 0 ; **FLOATING
C97 B.n98 B 0 ; **FLOATING
C98 B.n99 B 0 ; **FLOATING
C99 B.n100 B 0 ; **FLOATING
C100 B.n101 B 0 ; **FLOATING
C101 B.n102 B 0 ; **FLOATING
C102 B.n103 B 0 ; **FLOATING
C103 B.n104 B 0 ; **FLOATING
C104 B.n105 B 0 ; **FLOATING
C105 B.n108 B 0 ; **FLOATING
C106 B.n109 B 0 ; **FLOATING
C107 B.n110 B 0 ; **FLOATING
C108 B.n111 B 0 ; **FLOATING
C109 B.n112 B 0 ; **FLOATING
C110 B.n113 B 0 ; **FLOATING
C111 B.n114 B 0 ; **FLOATING
C112 B.n115 B 0 ; **FLOATING
C113 B.n116 B 0 ; **FLOATING
C114 B.n117 B 0 ; **FLOATING
C115 B.n118 B 0 ; **FLOATING
C116 B.n119 B 0 ; **FLOATING
C117 B.n120 B 0 ; **FLOATING
C118 B.n122 B 0 ; **FLOATING
C119 B.n123 B 0 ; **FLOATING
C120 B.n125 B 0 ; **FLOATING
C121 B.n126 B 0 ; **FLOATING
C122 S B 0.84953f
C123 D B 0.84953f
C124 G B 0.98062f
C125 nfet_01v8_lvt_W5_L2_m2__nf1_gboth_sdfull_pc/D.n0 B 0.02247f ; **FLOATING
C126 nfet_01v8_lvt_W5_L2_m2__nf1_gboth_sdfull_pc/D.t0 B 0.02957f ; **FLOATING
C127 nfet_01v8_lvt_W5_L2_m2__nf1_gboth_sdfull_pc/D.n1 B 0.02595f ; **FLOATING
C128 nfet_01v8_lvt_W5_L2_m2__nf1_gboth_sdfull_pc/S.n0 B 0.02247f ; **FLOATING
C129 nfet_01v8_lvt_W5_L2_m2__nf1_gboth_sdfull_pc/S.t0 B 0.02957f ; **FLOATING
C130 nfet_01v8_lvt_W5_L2_m2__nf1_gboth_sdfull_pc/S.n1 B 0.02595f ; **FLOATING
