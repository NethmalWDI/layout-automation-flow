.subckt pfet_01v8_lvt_W37p3_L0p74_m1__nf4_gtop_sdhalf_outS D G S B
Xpfet_01v8_lvt_W37p3_L0p74_m1__nf4_gtop_sdhalf_outS D G S B sky130_fd_pr__pfet_01v8_lvt L=0.74 W=37.3 nf=4
.ends
