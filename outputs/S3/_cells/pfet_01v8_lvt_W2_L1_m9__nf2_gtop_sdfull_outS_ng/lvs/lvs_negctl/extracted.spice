* NGSPICE file created from pfet_01v8_lvt_W2_L1_m9__nf2_gtop_sdfull_outS_ng.ext - technology: sky130A

.subckt sky130_fd_pr__pfet_01v8_lvt_XJP8NB G D0 a_229_n136# w_n323_n198# S1
X0 S1 G D0 w_n323_n198# sky130_fd_pr__pfet_01v8_lvt ad=0.145 pd=1.29 as=0.29 ps=2.58 w=1 l=1
X1 a_229_n136# G S1 w_n323_n198# sky130_fd_pr__pfet_01v8_lvt ad=0.29 pd=2.58 as=0.145 ps=1.29 w=1 l=1
.ends

.subckt pfet_01v8_lvt_W2_L1_m9__nf2_gtop_sdfull_outS_ng S D G B
Xpfet_01v8_lvt_W2_L1_m9__nf2_gtop_sdfull_outS_ng_pc G S S B D sky130_fd_pr__pfet_01v8_lvt_XJP8NB
.ends
