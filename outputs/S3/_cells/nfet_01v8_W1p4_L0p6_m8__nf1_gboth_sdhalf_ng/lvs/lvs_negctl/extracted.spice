* NGSPICE file created from nfet_01v8_W1p4_L0p6_m8__nf1_gboth_sdhalf_ng.ext - technology: sky130A

.subckt sky130_fd_pr__nfet_01v8_C4GTDY G D S VSUBS
X0 S G D VSUBS sky130_fd_pr__nfet_01v8 ad=0.406 pd=3.38 as=0.406 ps=3.38 w=1.4 l=0.6
.ends

.subckt nfet_01v8_W1p4_L0p6_m8__nf1_gboth_sdhalf_ng D S G B
Xnfet_01v8_W1p4_L0p6_m8__nf1_gboth_sdhalf_ng_pc G D S B sky130_fd_pr__nfet_01v8_C4GTDY
.ends
