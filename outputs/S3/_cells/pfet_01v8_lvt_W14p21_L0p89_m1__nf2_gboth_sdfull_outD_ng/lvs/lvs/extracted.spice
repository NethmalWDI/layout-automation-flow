* NGSPICE file created from pfet_01v8_lvt_W14p21_L0p89_m1__nf2_gboth_sdfull_outD_ng.ext - technology: sky130A

.subckt sky130_fd_pr__pfet_01v8_lvt_ZLA3LR G w_n301_n811# D0 a_207_n711# S1
X0 a_207_n711# G S1 w_n301_n811# sky130_fd_pr__pfet_01v8_lvt ad=2.0619 pd=14.8 as=1.03095 ps=7.4 w=7.11 l=0.89
X1 S1 G D0 w_n301_n811# sky130_fd_pr__pfet_01v8_lvt ad=1.03095 pd=7.4 as=2.0619 ps=14.8 w=7.11 l=0.89
.ends

.subckt pfet_01v8_lvt_W14p21_L0p89_m1__nf2_gboth_sdfull_outD_ng S D G B
Xpfet_01v8_lvt_W14p21_L0p89_m1__nf2_gboth_sdfull_outD_ng_pc G B D D S sky130_fd_pr__pfet_01v8_lvt_ZLA3LR
.ends
