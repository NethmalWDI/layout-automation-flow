* NGSPICE file created from pfet_01v8_lvt_W1_L10_m2__nf1_gboth_sdfull.ext - technology: sky130A

X0 S G D pfet_01v8_lvt_W1_L10_m2__nf1_gboth_sdfull_pc/B.t0 sky130_fd_pr__pfet_01v8_lvt ad=0.29 pd=2.58 as=0.29 ps=2.58 w=1 l=10
C0 G D 0.08977f
C1 B G 3.22912f
C2 B D 0.09825f
C3 G S 0.08977f
C4 B S 0.09825f
R0 pfet_01v8_lvt_W1_L10_m2__nf1_gboth_sdfull_pc/B.n148 pfet_01v8_lvt_W1_L10_m2__nf1_gboth_sdfull_pc/B.n19 712.942
R1 pfet_01v8_lvt_W1_L10_m2__nf1_gboth_sdfull_pc/B.n158 pfet_01v8_lvt_W1_L10_m2__nf1_gboth_sdfull_pc/B.n13 712.942
R2 pfet_01v8_lvt_W1_L10_m2__nf1_gboth_sdfull_pc/B.n103 pfet_01v8_lvt_W1_L10_m2__nf1_gboth_sdfull_pc/B.n25 712.942
R3 pfet_01v8_lvt_W1_L10_m2__nf1_gboth_sdfull_pc/B.n101 pfet_01v8_lvt_W1_L10_m2__nf1_gboth_sdfull_pc/B.n27 712.942
R4 pfet_01v8_lvt_W1_L10_m2__nf1_gboth_sdfull_pc/B.n152 pfet_01v8_lvt_W1_L10_m2__nf1_gboth_sdfull_pc/B.n19 240
R5 pfet_01v8_lvt_W1_L10_m2__nf1_gboth_sdfull_pc/B.n152 pfet_01v8_lvt_W1_L10_m2__nf1_gboth_sdfull_pc/B.n18 240
R6 pfet_01v8_lvt_W1_L10_m2__nf1_gboth_sdfull_pc/B.n109 pfet_01v8_lvt_W1_L10_m2__nf1_gboth_sdfull_pc/B.n18 240
R7 pfet_01v8_lvt_W1_L10_m2__nf1_gboth_sdfull_pc/B.n109 pfet_01v8_lvt_W1_L10_m2__nf1_gboth_sdfull_pc/B.n21 240
R8 pfet_01v8_lvt_W1_L10_m2__nf1_gboth_sdfull_pc/B.n101 pfet_01v8_lvt_W1_L10_m2__nf1_gboth_sdfull_pc/B.n21 240
R9 pfet_01v8_lvt_W1_L10_m2__nf1_gboth_sdfull_pc/B.n161 pfet_01v8_lvt_W1_L10_m2__nf1_gboth_sdfull_pc/B.n160 240
R10 pfet_01v8_lvt_W1_L10_m2__nf1_gboth_sdfull_pc/B.n165 pfet_01v8_lvt_W1_L10_m2__nf1_gboth_sdfull_pc/B.n10 240
R11 pfet_01v8_lvt_W1_L10_m2__nf1_gboth_sdfull_pc/B.n168 pfet_01v8_lvt_W1_L10_m2__nf1_gboth_sdfull_pc/B.n167 240
R12 pfet_01v8_lvt_W1_L10_m2__nf1_gboth_sdfull_pc/B.n172 pfet_01v8_lvt_W1_L10_m2__nf1_gboth_sdfull_pc/B.n7 240
R13 pfet_01v8_lvt_W1_L10_m2__nf1_gboth_sdfull_pc/B.n175 pfet_01v8_lvt_W1_L10_m2__nf1_gboth_sdfull_pc/B.n174 240
R14 pfet_01v8_lvt_W1_L10_m2__nf1_gboth_sdfull_pc/B.n179 pfet_01v8_lvt_W1_L10_m2__nf1_gboth_sdfull_pc/B.n4 240
R15 pfet_01v8_lvt_W1_L10_m2__nf1_gboth_sdfull_pc/B.n182 pfet_01v8_lvt_W1_L10_m2__nf1_gboth_sdfull_pc/B.n181 240
R16 pfet_01v8_lvt_W1_L10_m2__nf1_gboth_sdfull_pc/B.n124 pfet_01v8_lvt_W1_L10_m2__nf1_gboth_sdfull_pc/B.n122 240
R17 pfet_01v8_lvt_W1_L10_m2__nf1_gboth_sdfull_pc/B.n127 pfet_01v8_lvt_W1_L10_m2__nf1_gboth_sdfull_pc/B.n126 240
R18 pfet_01v8_lvt_W1_L10_m2__nf1_gboth_sdfull_pc/B.n131 pfet_01v8_lvt_W1_L10_m2__nf1_gboth_sdfull_pc/B.n119 240
R19 pfet_01v8_lvt_W1_L10_m2__nf1_gboth_sdfull_pc/B.n134 pfet_01v8_lvt_W1_L10_m2__nf1_gboth_sdfull_pc/B.n133 240
R20 pfet_01v8_lvt_W1_L10_m2__nf1_gboth_sdfull_pc/B.n138 pfet_01v8_lvt_W1_L10_m2__nf1_gboth_sdfull_pc/B.n116 240
R21 pfet_01v8_lvt_W1_L10_m2__nf1_gboth_sdfull_pc/B.n141 pfet_01v8_lvt_W1_L10_m2__nf1_gboth_sdfull_pc/B.n140 240
R22 pfet_01v8_lvt_W1_L10_m2__nf1_gboth_sdfull_pc/B.n145 pfet_01v8_lvt_W1_L10_m2__nf1_gboth_sdfull_pc/B.n113 240
R23 pfet_01v8_lvt_W1_L10_m2__nf1_gboth_sdfull_pc/B.n148 pfet_01v8_lvt_W1_L10_m2__nf1_gboth_sdfull_pc/B.n147 240
R24 pfet_01v8_lvt_W1_L10_m2__nf1_gboth_sdfull_pc/B.n154 pfet_01v8_lvt_W1_L10_m2__nf1_gboth_sdfull_pc/B.n13 240
R25 pfet_01v8_lvt_W1_L10_m2__nf1_gboth_sdfull_pc/B.n154 pfet_01v8_lvt_W1_L10_m2__nf1_gboth_sdfull_pc/B.n15 240
R26 pfet_01v8_lvt_W1_L10_m2__nf1_gboth_sdfull_pc/B.n107 pfet_01v8_lvt_W1_L10_m2__nf1_gboth_sdfull_pc/B.n15 240
R27 pfet_01v8_lvt_W1_L10_m2__nf1_gboth_sdfull_pc/B.n107 pfet_01v8_lvt_W1_L10_m2__nf1_gboth_sdfull_pc/B.n23 240
R28 pfet_01v8_lvt_W1_L10_m2__nf1_gboth_sdfull_pc/B.n103 pfet_01v8_lvt_W1_L10_m2__nf1_gboth_sdfull_pc/B.n23 240
R29 pfet_01v8_lvt_W1_L10_m2__nf1_gboth_sdfull_pc/B.n47 pfet_01v8_lvt_W1_L10_m2__nf1_gboth_sdfull_pc/B.n25 240
R30 pfet_01v8_lvt_W1_L10_m2__nf1_gboth_sdfull_pc/B.n51 pfet_01v8_lvt_W1_L10_m2__nf1_gboth_sdfull_pc/B.n45 240
R31 pfet_01v8_lvt_W1_L10_m2__nf1_gboth_sdfull_pc/B.n54 pfet_01v8_lvt_W1_L10_m2__nf1_gboth_sdfull_pc/B.n53 240
R32 pfet_01v8_lvt_W1_L10_m2__nf1_gboth_sdfull_pc/B.n58 pfet_01v8_lvt_W1_L10_m2__nf1_gboth_sdfull_pc/B.n42 240
R33 pfet_01v8_lvt_W1_L10_m2__nf1_gboth_sdfull_pc/B.n61 pfet_01v8_lvt_W1_L10_m2__nf1_gboth_sdfull_pc/B.n60 240
R34 pfet_01v8_lvt_W1_L10_m2__nf1_gboth_sdfull_pc/B.n65 pfet_01v8_lvt_W1_L10_m2__nf1_gboth_sdfull_pc/B.n64 240
R35 pfet_01v8_lvt_W1_L10_m2__nf1_gboth_sdfull_pc/B.n67 pfet_01v8_lvt_W1_L10_m2__nf1_gboth_sdfull_pc/B.n38 240
R36 pfet_01v8_lvt_W1_L10_m2__nf1_gboth_sdfull_pc/B.n71 pfet_01v8_lvt_W1_L10_m2__nf1_gboth_sdfull_pc/B.n38 240
R37 pfet_01v8_lvt_W1_L10_m2__nf1_gboth_sdfull_pc/B.n74 pfet_01v8_lvt_W1_L10_m2__nf1_gboth_sdfull_pc/B.n73 240
R38 pfet_01v8_lvt_W1_L10_m2__nf1_gboth_sdfull_pc/B.n78 pfet_01v8_lvt_W1_L10_m2__nf1_gboth_sdfull_pc/B.n35 240
R39 pfet_01v8_lvt_W1_L10_m2__nf1_gboth_sdfull_pc/B.n81 pfet_01v8_lvt_W1_L10_m2__nf1_gboth_sdfull_pc/B.n80 240
R40 pfet_01v8_lvt_W1_L10_m2__nf1_gboth_sdfull_pc/B.n82 pfet_01v8_lvt_W1_L10_m2__nf1_gboth_sdfull_pc/B.n81 240
R41 pfet_01v8_lvt_W1_L10_m2__nf1_gboth_sdfull_pc/B.n86 pfet_01v8_lvt_W1_L10_m2__nf1_gboth_sdfull_pc/B.n31 240
R42 pfet_01v8_lvt_W1_L10_m2__nf1_gboth_sdfull_pc/B.n87 pfet_01v8_lvt_W1_L10_m2__nf1_gboth_sdfull_pc/B.n86 240
R43 pfet_01v8_lvt_W1_L10_m2__nf1_gboth_sdfull_pc/B.n89 pfet_01v8_lvt_W1_L10_m2__nf1_gboth_sdfull_pc/B.n29 240
R44 pfet_01v8_lvt_W1_L10_m2__nf1_gboth_sdfull_pc/B.n93 pfet_01v8_lvt_W1_L10_m2__nf1_gboth_sdfull_pc/B.n29 240
R45 pfet_01v8_lvt_W1_L10_m2__nf1_gboth_sdfull_pc/B.n97 pfet_01v8_lvt_W1_L10_m2__nf1_gboth_sdfull_pc/B.n95 240
R46 pfet_01v8_lvt_W1_L10_m2__nf1_gboth_sdfull_pc/B.n148 pfet_01v8_lvt_W1_L10_m2__nf1_gboth_sdfull_pc/B.n3 185
R47 pfet_01v8_lvt_W1_L10_m2__nf1_gboth_sdfull_pc/B.n149 pfet_01v8_lvt_W1_L10_m2__nf1_gboth_sdfull_pc/B.n148 185
R48 pfet_01v8_lvt_W1_L10_m2__nf1_gboth_sdfull_pc/B.n147 pfet_01v8_lvt_W1_L10_m2__nf1_gboth_sdfull_pc/B.n112 185
R49 pfet_01v8_lvt_W1_L10_m2__nf1_gboth_sdfull_pc/B.n145 pfet_01v8_lvt_W1_L10_m2__nf1_gboth_sdfull_pc/B.n144 185
R50 pfet_01v8_lvt_W1_L10_m2__nf1_gboth_sdfull_pc/B.n143 pfet_01v8_lvt_W1_L10_m2__nf1_gboth_sdfull_pc/B.n113 185
R51 pfet_01v8_lvt_W1_L10_m2__nf1_gboth_sdfull_pc/B.n142 pfet_01v8_lvt_W1_L10_m2__nf1_gboth_sdfull_pc/B.n141 185
R52 pfet_01v8_lvt_W1_L10_m2__nf1_gboth_sdfull_pc/B.n140 pfet_01v8_lvt_W1_L10_m2__nf1_gboth_sdfull_pc/B.n114 185
R53 pfet_01v8_lvt_W1_L10_m2__nf1_gboth_sdfull_pc/B.n138 pfet_01v8_lvt_W1_L10_m2__nf1_gboth_sdfull_pc/B.n137 185
R54 pfet_01v8_lvt_W1_L10_m2__nf1_gboth_sdfull_pc/B.n136 pfet_01v8_lvt_W1_L10_m2__nf1_gboth_sdfull_pc/B.n116 185
R55 pfet_01v8_lvt_W1_L10_m2__nf1_gboth_sdfull_pc/B.n135 pfet_01v8_lvt_W1_L10_m2__nf1_gboth_sdfull_pc/B.n134 185
R56 pfet_01v8_lvt_W1_L10_m2__nf1_gboth_sdfull_pc/B.n133 pfet_01v8_lvt_W1_L10_m2__nf1_gboth_sdfull_pc/B.n117 185
R57 pfet_01v8_lvt_W1_L10_m2__nf1_gboth_sdfull_pc/B.n131 pfet_01v8_lvt_W1_L10_m2__nf1_gboth_sdfull_pc/B.n130 185
R58 pfet_01v8_lvt_W1_L10_m2__nf1_gboth_sdfull_pc/B.n129 pfet_01v8_lvt_W1_L10_m2__nf1_gboth_sdfull_pc/B.n119 185
R59 pfet_01v8_lvt_W1_L10_m2__nf1_gboth_sdfull_pc/B.n128 pfet_01v8_lvt_W1_L10_m2__nf1_gboth_sdfull_pc/B.n127 185
R60 pfet_01v8_lvt_W1_L10_m2__nf1_gboth_sdfull_pc/B.n126 pfet_01v8_lvt_W1_L10_m2__nf1_gboth_sdfull_pc/B.n120 185
R61 pfet_01v8_lvt_W1_L10_m2__nf1_gboth_sdfull_pc/B.n124 pfet_01v8_lvt_W1_L10_m2__nf1_gboth_sdfull_pc/B.n123 185
R62 pfet_01v8_lvt_W1_L10_m2__nf1_gboth_sdfull_pc/B.n122 pfet_01v8_lvt_W1_L10_m2__nf1_gboth_sdfull_pc/B.n0 185
R63 pfet_01v8_lvt_W1_L10_m2__nf1_gboth_sdfull_pc/B.n183 pfet_01v8_lvt_W1_L10_m2__nf1_gboth_sdfull_pc/B.n182 185
R64 pfet_01v8_lvt_W1_L10_m2__nf1_gboth_sdfull_pc/B.n181 pfet_01v8_lvt_W1_L10_m2__nf1_gboth_sdfull_pc/B.n1 185
R65 pfet_01v8_lvt_W1_L10_m2__nf1_gboth_sdfull_pc/B.n179 pfet_01v8_lvt_W1_L10_m2__nf1_gboth_sdfull_pc/B.n178 185
R66 pfet_01v8_lvt_W1_L10_m2__nf1_gboth_sdfull_pc/B.n177 pfet_01v8_lvt_W1_L10_m2__nf1_gboth_sdfull_pc/B.n4 185
R67 pfet_01v8_lvt_W1_L10_m2__nf1_gboth_sdfull_pc/B.n176 pfet_01v8_lvt_W1_L10_m2__nf1_gboth_sdfull_pc/B.n175 185
R68 pfet_01v8_lvt_W1_L10_m2__nf1_gboth_sdfull_pc/B.n174 pfet_01v8_lvt_W1_L10_m2__nf1_gboth_sdfull_pc/B.n5 185
R69 pfet_01v8_lvt_W1_L10_m2__nf1_gboth_sdfull_pc/B.n172 pfet_01v8_lvt_W1_L10_m2__nf1_gboth_sdfull_pc/B.n171 185
R70 pfet_01v8_lvt_W1_L10_m2__nf1_gboth_sdfull_pc/B.n170 pfet_01v8_lvt_W1_L10_m2__nf1_gboth_sdfull_pc/B.n7 185
R71 pfet_01v8_lvt_W1_L10_m2__nf1_gboth_sdfull_pc/B.n169 pfet_01v8_lvt_W1_L10_m2__nf1_gboth_sdfull_pc/B.n168 185
R72 pfet_01v8_lvt_W1_L10_m2__nf1_gboth_sdfull_pc/B.n167 pfet_01v8_lvt_W1_L10_m2__nf1_gboth_sdfull_pc/B.n8 185
R73 pfet_01v8_lvt_W1_L10_m2__nf1_gboth_sdfull_pc/B.n165 pfet_01v8_lvt_W1_L10_m2__nf1_gboth_sdfull_pc/B.n164 185
R74 pfet_01v8_lvt_W1_L10_m2__nf1_gboth_sdfull_pc/B.n163 pfet_01v8_lvt_W1_L10_m2__nf1_gboth_sdfull_pc/B.n10 185
R75 pfet_01v8_lvt_W1_L10_m2__nf1_gboth_sdfull_pc/B.n162 pfet_01v8_lvt_W1_L10_m2__nf1_gboth_sdfull_pc/B.n161 185
R76 pfet_01v8_lvt_W1_L10_m2__nf1_gboth_sdfull_pc/B.n160 pfet_01v8_lvt_W1_L10_m2__nf1_gboth_sdfull_pc/B.n11 185
R77 pfet_01v8_lvt_W1_L10_m2__nf1_gboth_sdfull_pc/B.n158 pfet_01v8_lvt_W1_L10_m2__nf1_gboth_sdfull_pc/B.n157 185
R78 pfet_01v8_lvt_W1_L10_m2__nf1_gboth_sdfull_pc/B.n17 pfet_01v8_lvt_W1_L10_m2__nf1_gboth_sdfull_pc/B.n13 185
R79 pfet_01v8_lvt_W1_L10_m2__nf1_gboth_sdfull_pc/B.n156 pfet_01v8_lvt_W1_L10_m2__nf1_gboth_sdfull_pc/B.n13 185
R80 pfet_01v8_lvt_W1_L10_m2__nf1_gboth_sdfull_pc/B.n154 pfet_01v8_lvt_W1_L10_m2__nf1_gboth_sdfull_pc/B.n153 185
R81 pfet_01v8_lvt_W1_L10_m2__nf1_gboth_sdfull_pc/B.n155 pfet_01v8_lvt_W1_L10_m2__nf1_gboth_sdfull_pc/B.n154 185
R82 pfet_01v8_lvt_W1_L10_m2__nf1_gboth_sdfull_pc/B.n16 pfet_01v8_lvt_W1_L10_m2__nf1_gboth_sdfull_pc/B.n15 185
R83 pfet_01v8_lvt_W1_L10_m2__nf1_gboth_sdfull_pc/B.n15 pfet_01v8_lvt_W1_L10_m2__nf1_gboth_sdfull_pc/B.n14 185
R84 pfet_01v8_lvt_W1_L10_m2__nf1_gboth_sdfull_pc/B.n108 pfet_01v8_lvt_W1_L10_m2__nf1_gboth_sdfull_pc/B.n107 185
R85 pfet_01v8_lvt_W1_L10_m2__nf1_gboth_sdfull_pc/B.n107 pfet_01v8_lvt_W1_L10_m2__nf1_gboth_sdfull_pc/B.n106 185
R86 pfet_01v8_lvt_W1_L10_m2__nf1_gboth_sdfull_pc/B.n23 pfet_01v8_lvt_W1_L10_m2__nf1_gboth_sdfull_pc/B.n22 185
R87 pfet_01v8_lvt_W1_L10_m2__nf1_gboth_sdfull_pc/B.n105 pfet_01v8_lvt_W1_L10_m2__nf1_gboth_sdfull_pc/B.n23 185
R88 pfet_01v8_lvt_W1_L10_m2__nf1_gboth_sdfull_pc/B.n103 pfet_01v8_lvt_W1_L10_m2__nf1_gboth_sdfull_pc/B.n102 185
R89 pfet_01v8_lvt_W1_L10_m2__nf1_gboth_sdfull_pc/B.n104 pfet_01v8_lvt_W1_L10_m2__nf1_gboth_sdfull_pc/B.n103 185
R90 pfet_01v8_lvt_W1_L10_m2__nf1_gboth_sdfull_pc/B.n26 pfet_01v8_lvt_W1_L10_m2__nf1_gboth_sdfull_pc/B.n25 185
R91 pfet_01v8_lvt_W1_L10_m2__nf1_gboth_sdfull_pc/B.n25 pfet_01v8_lvt_W1_L10_m2__nf1_gboth_sdfull_pc/B.n24 185
R92 pfet_01v8_lvt_W1_L10_m2__nf1_gboth_sdfull_pc/B.n48 pfet_01v8_lvt_W1_L10_m2__nf1_gboth_sdfull_pc/B.n47 185
R93 pfet_01v8_lvt_W1_L10_m2__nf1_gboth_sdfull_pc/B.n49 pfet_01v8_lvt_W1_L10_m2__nf1_gboth_sdfull_pc/B.n45 185
R94 pfet_01v8_lvt_W1_L10_m2__nf1_gboth_sdfull_pc/B.n51 pfet_01v8_lvt_W1_L10_m2__nf1_gboth_sdfull_pc/B.n50 185
R95 pfet_01v8_lvt_W1_L10_m2__nf1_gboth_sdfull_pc/B.n53 pfet_01v8_lvt_W1_L10_m2__nf1_gboth_sdfull_pc/B.n43 185
R96 pfet_01v8_lvt_W1_L10_m2__nf1_gboth_sdfull_pc/B.n55 pfet_01v8_lvt_W1_L10_m2__nf1_gboth_sdfull_pc/B.n54 185
R97 pfet_01v8_lvt_W1_L10_m2__nf1_gboth_sdfull_pc/B.n56 pfet_01v8_lvt_W1_L10_m2__nf1_gboth_sdfull_pc/B.n42 185
R98 pfet_01v8_lvt_W1_L10_m2__nf1_gboth_sdfull_pc/B.n58 pfet_01v8_lvt_W1_L10_m2__nf1_gboth_sdfull_pc/B.n57 185
R99 pfet_01v8_lvt_W1_L10_m2__nf1_gboth_sdfull_pc/B.n60 pfet_01v8_lvt_W1_L10_m2__nf1_gboth_sdfull_pc/B.n41 185
R100 pfet_01v8_lvt_W1_L10_m2__nf1_gboth_sdfull_pc/B.n62 pfet_01v8_lvt_W1_L10_m2__nf1_gboth_sdfull_pc/B.n61 185
R101 pfet_01v8_lvt_W1_L10_m2__nf1_gboth_sdfull_pc/B.n64 pfet_01v8_lvt_W1_L10_m2__nf1_gboth_sdfull_pc/B.n63 185
R102 pfet_01v8_lvt_W1_L10_m2__nf1_gboth_sdfull_pc/B.n65 pfet_01v8_lvt_W1_L10_m2__nf1_gboth_sdfull_pc/B.n39 185
R103 pfet_01v8_lvt_W1_L10_m2__nf1_gboth_sdfull_pc/B.n68 pfet_01v8_lvt_W1_L10_m2__nf1_gboth_sdfull_pc/B.n67 185
R104 pfet_01v8_lvt_W1_L10_m2__nf1_gboth_sdfull_pc/B.n38 pfet_01v8_lvt_W1_L10_m2__nf1_gboth_sdfull_pc/B.n26 185
R105 pfet_01v8_lvt_W1_L10_m2__nf1_gboth_sdfull_pc/B.n69 pfet_01v8_lvt_W1_L10_m2__nf1_gboth_sdfull_pc/B.n38 185
R106 pfet_01v8_lvt_W1_L10_m2__nf1_gboth_sdfull_pc/B.n71 pfet_01v8_lvt_W1_L10_m2__nf1_gboth_sdfull_pc/B.n70 185
R107 pfet_01v8_lvt_W1_L10_m2__nf1_gboth_sdfull_pc/B.n73 pfet_01v8_lvt_W1_L10_m2__nf1_gboth_sdfull_pc/B.n36 185
R108 pfet_01v8_lvt_W1_L10_m2__nf1_gboth_sdfull_pc/B.n75 pfet_01v8_lvt_W1_L10_m2__nf1_gboth_sdfull_pc/B.n74 185
R109 pfet_01v8_lvt_W1_L10_m2__nf1_gboth_sdfull_pc/B.n76 pfet_01v8_lvt_W1_L10_m2__nf1_gboth_sdfull_pc/B.n35 185
R110 pfet_01v8_lvt_W1_L10_m2__nf1_gboth_sdfull_pc/B.n78 pfet_01v8_lvt_W1_L10_m2__nf1_gboth_sdfull_pc/B.n77 185
R111 pfet_01v8_lvt_W1_L10_m2__nf1_gboth_sdfull_pc/B.n80 pfet_01v8_lvt_W1_L10_m2__nf1_gboth_sdfull_pc/B.n34 185
R112 pfet_01v8_lvt_W1_L10_m2__nf1_gboth_sdfull_pc/B.n81 pfet_01v8_lvt_W1_L10_m2__nf1_gboth_sdfull_pc/B.n26 185
R113 pfet_01v8_lvt_W1_L10_m2__nf1_gboth_sdfull_pc/B.n81 pfet_01v8_lvt_W1_L10_m2__nf1_gboth_sdfull_pc/B.n32 185
R114 pfet_01v8_lvt_W1_L10_m2__nf1_gboth_sdfull_pc/B.n83 pfet_01v8_lvt_W1_L10_m2__nf1_gboth_sdfull_pc/B.n82 185
R115 pfet_01v8_lvt_W1_L10_m2__nf1_gboth_sdfull_pc/B.n84 pfet_01v8_lvt_W1_L10_m2__nf1_gboth_sdfull_pc/B.n31 185
R116 pfet_01v8_lvt_W1_L10_m2__nf1_gboth_sdfull_pc/B.n86 pfet_01v8_lvt_W1_L10_m2__nf1_gboth_sdfull_pc/B.n26 185
R117 pfet_01v8_lvt_W1_L10_m2__nf1_gboth_sdfull_pc/B.n86 pfet_01v8_lvt_W1_L10_m2__nf1_gboth_sdfull_pc/B.n85 185
R118 pfet_01v8_lvt_W1_L10_m2__nf1_gboth_sdfull_pc/B.n87 pfet_01v8_lvt_W1_L10_m2__nf1_gboth_sdfull_pc/B.n30 185
R119 pfet_01v8_lvt_W1_L10_m2__nf1_gboth_sdfull_pc/B.n90 pfet_01v8_lvt_W1_L10_m2__nf1_gboth_sdfull_pc/B.n89 185
R120 pfet_01v8_lvt_W1_L10_m2__nf1_gboth_sdfull_pc/B.n29 pfet_01v8_lvt_W1_L10_m2__nf1_gboth_sdfull_pc/B.n26 185
R121 pfet_01v8_lvt_W1_L10_m2__nf1_gboth_sdfull_pc/B.n91 pfet_01v8_lvt_W1_L10_m2__nf1_gboth_sdfull_pc/B.n29 185
R122 pfet_01v8_lvt_W1_L10_m2__nf1_gboth_sdfull_pc/B.n93 pfet_01v8_lvt_W1_L10_m2__nf1_gboth_sdfull_pc/B.n92 185
R123 pfet_01v8_lvt_W1_L10_m2__nf1_gboth_sdfull_pc/B.n95 pfet_01v8_lvt_W1_L10_m2__nf1_gboth_sdfull_pc/B.n28 185
R124 pfet_01v8_lvt_W1_L10_m2__nf1_gboth_sdfull_pc/B.n98 pfet_01v8_lvt_W1_L10_m2__nf1_gboth_sdfull_pc/B.n97 185
R125 pfet_01v8_lvt_W1_L10_m2__nf1_gboth_sdfull_pc/B.n99 pfet_01v8_lvt_W1_L10_m2__nf1_gboth_sdfull_pc/B.n27 185
R126 pfet_01v8_lvt_W1_L10_m2__nf1_gboth_sdfull_pc/B.n102 pfet_01v8_lvt_W1_L10_m2__nf1_gboth_sdfull_pc/B.n101 185
R127 pfet_01v8_lvt_W1_L10_m2__nf1_gboth_sdfull_pc/B.n101 pfet_01v8_lvt_W1_L10_m2__nf1_gboth_sdfull_pc/B.n100 185
R128 pfet_01v8_lvt_W1_L10_m2__nf1_gboth_sdfull_pc/B.n22 pfet_01v8_lvt_W1_L10_m2__nf1_gboth_sdfull_pc/B.n21 185
R129 pfet_01v8_lvt_W1_L10_m2__nf1_gboth_sdfull_pc/B.n21 pfet_01v8_lvt_W1_L10_m2__nf1_gboth_sdfull_pc/B.n20 185
R130 pfet_01v8_lvt_W1_L10_m2__nf1_gboth_sdfull_pc/B.n109 pfet_01v8_lvt_W1_L10_m2__nf1_gboth_sdfull_pc/B.n108 185
R131 pfet_01v8_lvt_W1_L10_m2__nf1_gboth_sdfull_pc/B.n110 pfet_01v8_lvt_W1_L10_m2__nf1_gboth_sdfull_pc/B.n109 185
R132 pfet_01v8_lvt_W1_L10_m2__nf1_gboth_sdfull_pc/B.n18 pfet_01v8_lvt_W1_L10_m2__nf1_gboth_sdfull_pc/B.n16 185
R133 pfet_01v8_lvt_W1_L10_m2__nf1_gboth_sdfull_pc/B.n111 pfet_01v8_lvt_W1_L10_m2__nf1_gboth_sdfull_pc/B.n18 185
R134 pfet_01v8_lvt_W1_L10_m2__nf1_gboth_sdfull_pc/B.n153 pfet_01v8_lvt_W1_L10_m2__nf1_gboth_sdfull_pc/B.n152 185
R135 pfet_01v8_lvt_W1_L10_m2__nf1_gboth_sdfull_pc/B.n152 pfet_01v8_lvt_W1_L10_m2__nf1_gboth_sdfull_pc/B.n151 185
R136 pfet_01v8_lvt_W1_L10_m2__nf1_gboth_sdfull_pc/B.n19 pfet_01v8_lvt_W1_L10_m2__nf1_gboth_sdfull_pc/B.n17 185
R137 pfet_01v8_lvt_W1_L10_m2__nf1_gboth_sdfull_pc/B.n150 pfet_01v8_lvt_W1_L10_m2__nf1_gboth_sdfull_pc/B.n19 185
R138 pfet_01v8_lvt_W1_L10_m2__nf1_gboth_sdfull_pc/B.n157 pfet_01v8_lvt_W1_L10_m2__nf1_gboth_sdfull_pc/B.n156 76.0476
R139 pfet_01v8_lvt_W1_L10_m2__nf1_gboth_sdfull_pc/B.n104 pfet_01v8_lvt_W1_L10_m2__nf1_gboth_sdfull_pc/B.n24 76.0476
R140 pfet_01v8_lvt_W1_L10_m2__nf1_gboth_sdfull_pc/B.n150 pfet_01v8_lvt_W1_L10_m2__nf1_gboth_sdfull_pc/B.n149 76.0476
R141 pfet_01v8_lvt_W1_L10_m2__nf1_gboth_sdfull_pc/B.n100 pfet_01v8_lvt_W1_L10_m2__nf1_gboth_sdfull_pc/B.n99 76.0476
R142 pfet_01v8_lvt_W1_L10_m2__nf1_gboth_sdfull_pc/B.n147 pfet_01v8_lvt_W1_L10_m2__nf1_gboth_sdfull_pc/B.n146 72.7879
R143 pfet_01v8_lvt_W1_L10_m2__nf1_gboth_sdfull_pc/B.n115 pfet_01v8_lvt_W1_L10_m2__nf1_gboth_sdfull_pc/B.n113 72.7879
R144 pfet_01v8_lvt_W1_L10_m2__nf1_gboth_sdfull_pc/B.n140 pfet_01v8_lvt_W1_L10_m2__nf1_gboth_sdfull_pc/B.n139 72.7879
R145 pfet_01v8_lvt_W1_L10_m2__nf1_gboth_sdfull_pc/B.n118 pfet_01v8_lvt_W1_L10_m2__nf1_gboth_sdfull_pc/B.n116 72.7879
R146 pfet_01v8_lvt_W1_L10_m2__nf1_gboth_sdfull_pc/B.n133 pfet_01v8_lvt_W1_L10_m2__nf1_gboth_sdfull_pc/B.n132 72.7879
R147 pfet_01v8_lvt_W1_L10_m2__nf1_gboth_sdfull_pc/B.n121 pfet_01v8_lvt_W1_L10_m2__nf1_gboth_sdfull_pc/B.n119 72.7879
R148 pfet_01v8_lvt_W1_L10_m2__nf1_gboth_sdfull_pc/B.n126 pfet_01v8_lvt_W1_L10_m2__nf1_gboth_sdfull_pc/B.n125 72.7879
R149 pfet_01v8_lvt_W1_L10_m2__nf1_gboth_sdfull_pc/B.n122 pfet_01v8_lvt_W1_L10_m2__nf1_gboth_sdfull_pc/B.n2 72.7879
R150 pfet_01v8_lvt_W1_L10_m2__nf1_gboth_sdfull_pc/B.n181 pfet_01v8_lvt_W1_L10_m2__nf1_gboth_sdfull_pc/B.n180 72.7879
R151 pfet_01v8_lvt_W1_L10_m2__nf1_gboth_sdfull_pc/B.n6 pfet_01v8_lvt_W1_L10_m2__nf1_gboth_sdfull_pc/B.n4 72.7879
R152 pfet_01v8_lvt_W1_L10_m2__nf1_gboth_sdfull_pc/B.n174 pfet_01v8_lvt_W1_L10_m2__nf1_gboth_sdfull_pc/B.n173 72.7879
R153 pfet_01v8_lvt_W1_L10_m2__nf1_gboth_sdfull_pc/B.n9 pfet_01v8_lvt_W1_L10_m2__nf1_gboth_sdfull_pc/B.n7 72.7879
R154 pfet_01v8_lvt_W1_L10_m2__nf1_gboth_sdfull_pc/B.n167 pfet_01v8_lvt_W1_L10_m2__nf1_gboth_sdfull_pc/B.n166 72.7879
R155 pfet_01v8_lvt_W1_L10_m2__nf1_gboth_sdfull_pc/B.n12 pfet_01v8_lvt_W1_L10_m2__nf1_gboth_sdfull_pc/B.n10 72.7879
R156 pfet_01v8_lvt_W1_L10_m2__nf1_gboth_sdfull_pc/B.n160 pfet_01v8_lvt_W1_L10_m2__nf1_gboth_sdfull_pc/B.n159 72.7879
R157 pfet_01v8_lvt_W1_L10_m2__nf1_gboth_sdfull_pc/B.n46 pfet_01v8_lvt_W1_L10_m2__nf1_gboth_sdfull_pc/B.n45 72.7879
R158 pfet_01v8_lvt_W1_L10_m2__nf1_gboth_sdfull_pc/B.n52 pfet_01v8_lvt_W1_L10_m2__nf1_gboth_sdfull_pc/B.n51 72.7879
R159 pfet_01v8_lvt_W1_L10_m2__nf1_gboth_sdfull_pc/B.n44 pfet_01v8_lvt_W1_L10_m2__nf1_gboth_sdfull_pc/B.n42 72.7879
R160 pfet_01v8_lvt_W1_L10_m2__nf1_gboth_sdfull_pc/B.n60 pfet_01v8_lvt_W1_L10_m2__nf1_gboth_sdfull_pc/B.n59 72.7879
R161 pfet_01v8_lvt_W1_L10_m2__nf1_gboth_sdfull_pc/B.n61 pfet_01v8_lvt_W1_L10_m2__nf1_gboth_sdfull_pc/B.n40 72.7879
R162 pfet_01v8_lvt_W1_L10_m2__nf1_gboth_sdfull_pc/B.n67 pfet_01v8_lvt_W1_L10_m2__nf1_gboth_sdfull_pc/B.n66 72.7879
R163 pfet_01v8_lvt_W1_L10_m2__nf1_gboth_sdfull_pc/B.n73 pfet_01v8_lvt_W1_L10_m2__nf1_gboth_sdfull_pc/B.n72 72.7879
R164 pfet_01v8_lvt_W1_L10_m2__nf1_gboth_sdfull_pc/B.n37 pfet_01v8_lvt_W1_L10_m2__nf1_gboth_sdfull_pc/B.n35 72.7879
R165 pfet_01v8_lvt_W1_L10_m2__nf1_gboth_sdfull_pc/B.n80 pfet_01v8_lvt_W1_L10_m2__nf1_gboth_sdfull_pc/B.n79 72.7879
R166 pfet_01v8_lvt_W1_L10_m2__nf1_gboth_sdfull_pc/B.n33 pfet_01v8_lvt_W1_L10_m2__nf1_gboth_sdfull_pc/B.n31 72.7879
R167 pfet_01v8_lvt_W1_L10_m2__nf1_gboth_sdfull_pc/B.n89 pfet_01v8_lvt_W1_L10_m2__nf1_gboth_sdfull_pc/B.n88 72.7879
R168 pfet_01v8_lvt_W1_L10_m2__nf1_gboth_sdfull_pc/B.n94 pfet_01v8_lvt_W1_L10_m2__nf1_gboth_sdfull_pc/B.n93 72.7879
R169 pfet_01v8_lvt_W1_L10_m2__nf1_gboth_sdfull_pc/B.n97 pfet_01v8_lvt_W1_L10_m2__nf1_gboth_sdfull_pc/B.n96 72.7879
R170 pfet_01v8_lvt_W1_L10_m2__nf1_gboth_sdfull_pc/B.n159 pfet_01v8_lvt_W1_L10_m2__nf1_gboth_sdfull_pc/B.n158 72.7879
R171 pfet_01v8_lvt_W1_L10_m2__nf1_gboth_sdfull_pc/B.n161 pfet_01v8_lvt_W1_L10_m2__nf1_gboth_sdfull_pc/B.n12 72.7879
R172 pfet_01v8_lvt_W1_L10_m2__nf1_gboth_sdfull_pc/B.n166 pfet_01v8_lvt_W1_L10_m2__nf1_gboth_sdfull_pc/B.n165 72.7879
R173 pfet_01v8_lvt_W1_L10_m2__nf1_gboth_sdfull_pc/B.n168 pfet_01v8_lvt_W1_L10_m2__nf1_gboth_sdfull_pc/B.n9 72.7879
R174 pfet_01v8_lvt_W1_L10_m2__nf1_gboth_sdfull_pc/B.n173 pfet_01v8_lvt_W1_L10_m2__nf1_gboth_sdfull_pc/B.n172 72.7879
R175 pfet_01v8_lvt_W1_L10_m2__nf1_gboth_sdfull_pc/B.n175 pfet_01v8_lvt_W1_L10_m2__nf1_gboth_sdfull_pc/B.n6 72.7879
R176 pfet_01v8_lvt_W1_L10_m2__nf1_gboth_sdfull_pc/B.n180 pfet_01v8_lvt_W1_L10_m2__nf1_gboth_sdfull_pc/B.n179 72.7879
R177 pfet_01v8_lvt_W1_L10_m2__nf1_gboth_sdfull_pc/B.n182 pfet_01v8_lvt_W1_L10_m2__nf1_gboth_sdfull_pc/B.n2 72.7879
R178 pfet_01v8_lvt_W1_L10_m2__nf1_gboth_sdfull_pc/B.n125 pfet_01v8_lvt_W1_L10_m2__nf1_gboth_sdfull_pc/B.n124 72.7879
R179 pfet_01v8_lvt_W1_L10_m2__nf1_gboth_sdfull_pc/B.n127 pfet_01v8_lvt_W1_L10_m2__nf1_gboth_sdfull_pc/B.n121 72.7879
R180 pfet_01v8_lvt_W1_L10_m2__nf1_gboth_sdfull_pc/B.n132 pfet_01v8_lvt_W1_L10_m2__nf1_gboth_sdfull_pc/B.n131 72.7879
R181 pfet_01v8_lvt_W1_L10_m2__nf1_gboth_sdfull_pc/B.n134 pfet_01v8_lvt_W1_L10_m2__nf1_gboth_sdfull_pc/B.n118 72.7879
R182 pfet_01v8_lvt_W1_L10_m2__nf1_gboth_sdfull_pc/B.n139 pfet_01v8_lvt_W1_L10_m2__nf1_gboth_sdfull_pc/B.n138 72.7879
R183 pfet_01v8_lvt_W1_L10_m2__nf1_gboth_sdfull_pc/B.n141 pfet_01v8_lvt_W1_L10_m2__nf1_gboth_sdfull_pc/B.n115 72.7879
R184 pfet_01v8_lvt_W1_L10_m2__nf1_gboth_sdfull_pc/B.n146 pfet_01v8_lvt_W1_L10_m2__nf1_gboth_sdfull_pc/B.n145 72.7879
R185 pfet_01v8_lvt_W1_L10_m2__nf1_gboth_sdfull_pc/B.n47 pfet_01v8_lvt_W1_L10_m2__nf1_gboth_sdfull_pc/B.n46 72.7879
R186 pfet_01v8_lvt_W1_L10_m2__nf1_gboth_sdfull_pc/B.n53 pfet_01v8_lvt_W1_L10_m2__nf1_gboth_sdfull_pc/B.n52 72.7879
R187 pfet_01v8_lvt_W1_L10_m2__nf1_gboth_sdfull_pc/B.n54 pfet_01v8_lvt_W1_L10_m2__nf1_gboth_sdfull_pc/B.n44 72.7879
R188 pfet_01v8_lvt_W1_L10_m2__nf1_gboth_sdfull_pc/B.n59 pfet_01v8_lvt_W1_L10_m2__nf1_gboth_sdfull_pc/B.n58 72.7879
R189 pfet_01v8_lvt_W1_L10_m2__nf1_gboth_sdfull_pc/B.n64 pfet_01v8_lvt_W1_L10_m2__nf1_gboth_sdfull_pc/B.n40 72.7879
R190 pfet_01v8_lvt_W1_L10_m2__nf1_gboth_sdfull_pc/B.n66 pfet_01v8_lvt_W1_L10_m2__nf1_gboth_sdfull_pc/B.n65 72.7879
R191 pfet_01v8_lvt_W1_L10_m2__nf1_gboth_sdfull_pc/B.n72 pfet_01v8_lvt_W1_L10_m2__nf1_gboth_sdfull_pc/B.n71 72.7879
R192 pfet_01v8_lvt_W1_L10_m2__nf1_gboth_sdfull_pc/B.n74 pfet_01v8_lvt_W1_L10_m2__nf1_gboth_sdfull_pc/B.n37 72.7879
R193 pfet_01v8_lvt_W1_L10_m2__nf1_gboth_sdfull_pc/B.n79 pfet_01v8_lvt_W1_L10_m2__nf1_gboth_sdfull_pc/B.n78 72.7879
R194 pfet_01v8_lvt_W1_L10_m2__nf1_gboth_sdfull_pc/B.n82 pfet_01v8_lvt_W1_L10_m2__nf1_gboth_sdfull_pc/B.n33 72.7879
R195 pfet_01v8_lvt_W1_L10_m2__nf1_gboth_sdfull_pc/B.n88 pfet_01v8_lvt_W1_L10_m2__nf1_gboth_sdfull_pc/B.n87 72.7879
R196 pfet_01v8_lvt_W1_L10_m2__nf1_gboth_sdfull_pc/B.n95 pfet_01v8_lvt_W1_L10_m2__nf1_gboth_sdfull_pc/B.n94 72.7879
R197 pfet_01v8_lvt_W1_L10_m2__nf1_gboth_sdfull_pc/B.n96 pfet_01v8_lvt_W1_L10_m2__nf1_gboth_sdfull_pc/B.n27 72.7879
R198 pfet_01v8_lvt_W1_L10_m2__nf1_gboth_sdfull_pc/B.n146 pfet_01v8_lvt_W1_L10_m2__nf1_gboth_sdfull_pc/B.n3 56.1076
R199 pfet_01v8_lvt_W1_L10_m2__nf1_gboth_sdfull_pc/B.n115 pfet_01v8_lvt_W1_L10_m2__nf1_gboth_sdfull_pc/B.n3 56.1076
R200 pfet_01v8_lvt_W1_L10_m2__nf1_gboth_sdfull_pc/B.n139 pfet_01v8_lvt_W1_L10_m2__nf1_gboth_sdfull_pc/B.n3 56.1076
R201 pfet_01v8_lvt_W1_L10_m2__nf1_gboth_sdfull_pc/B.n118 pfet_01v8_lvt_W1_L10_m2__nf1_gboth_sdfull_pc/B.n3 56.1076
R202 pfet_01v8_lvt_W1_L10_m2__nf1_gboth_sdfull_pc/B.n132 pfet_01v8_lvt_W1_L10_m2__nf1_gboth_sdfull_pc/B.n3 56.1076
R203 pfet_01v8_lvt_W1_L10_m2__nf1_gboth_sdfull_pc/B.n121 pfet_01v8_lvt_W1_L10_m2__nf1_gboth_sdfull_pc/B.n3 56.1076
R204 pfet_01v8_lvt_W1_L10_m2__nf1_gboth_sdfull_pc/B.n125 pfet_01v8_lvt_W1_L10_m2__nf1_gboth_sdfull_pc/B.n3 56.1076
R205 pfet_01v8_lvt_W1_L10_m2__nf1_gboth_sdfull_pc/B.n3 pfet_01v8_lvt_W1_L10_m2__nf1_gboth_sdfull_pc/B.n2 56.1076
R206 pfet_01v8_lvt_W1_L10_m2__nf1_gboth_sdfull_pc/B.n180 pfet_01v8_lvt_W1_L10_m2__nf1_gboth_sdfull_pc/B.n3 56.1076
R207 pfet_01v8_lvt_W1_L10_m2__nf1_gboth_sdfull_pc/B.n6 pfet_01v8_lvt_W1_L10_m2__nf1_gboth_sdfull_pc/B.n3 56.1076
R208 pfet_01v8_lvt_W1_L10_m2__nf1_gboth_sdfull_pc/B.n173 pfet_01v8_lvt_W1_L10_m2__nf1_gboth_sdfull_pc/B.n3 56.1076
R209 pfet_01v8_lvt_W1_L10_m2__nf1_gboth_sdfull_pc/B.n9 pfet_01v8_lvt_W1_L10_m2__nf1_gboth_sdfull_pc/B.n3 56.1076
R210 pfet_01v8_lvt_W1_L10_m2__nf1_gboth_sdfull_pc/B.n166 pfet_01v8_lvt_W1_L10_m2__nf1_gboth_sdfull_pc/B.n3 56.1076
R211 pfet_01v8_lvt_W1_L10_m2__nf1_gboth_sdfull_pc/B.n12 pfet_01v8_lvt_W1_L10_m2__nf1_gboth_sdfull_pc/B.n3 56.1076
R212 pfet_01v8_lvt_W1_L10_m2__nf1_gboth_sdfull_pc/B.n159 pfet_01v8_lvt_W1_L10_m2__nf1_gboth_sdfull_pc/B.n3 56.1076
R213 pfet_01v8_lvt_W1_L10_m2__nf1_gboth_sdfull_pc/B.n46 pfet_01v8_lvt_W1_L10_m2__nf1_gboth_sdfull_pc/B.n26 56.1076
R214 pfet_01v8_lvt_W1_L10_m2__nf1_gboth_sdfull_pc/B.n52 pfet_01v8_lvt_W1_L10_m2__nf1_gboth_sdfull_pc/B.n26 56.1076
R215 pfet_01v8_lvt_W1_L10_m2__nf1_gboth_sdfull_pc/B.n44 pfet_01v8_lvt_W1_L10_m2__nf1_gboth_sdfull_pc/B.n26 56.1076
R216 pfet_01v8_lvt_W1_L10_m2__nf1_gboth_sdfull_pc/B.n59 pfet_01v8_lvt_W1_L10_m2__nf1_gboth_sdfull_pc/B.n26 56.1076
R217 pfet_01v8_lvt_W1_L10_m2__nf1_gboth_sdfull_pc/B.n40 pfet_01v8_lvt_W1_L10_m2__nf1_gboth_sdfull_pc/B.n26 56.1076
R218 pfet_01v8_lvt_W1_L10_m2__nf1_gboth_sdfull_pc/B.n66 pfet_01v8_lvt_W1_L10_m2__nf1_gboth_sdfull_pc/B.n26 56.1076
R219 pfet_01v8_lvt_W1_L10_m2__nf1_gboth_sdfull_pc/B.n72 pfet_01v8_lvt_W1_L10_m2__nf1_gboth_sdfull_pc/B.n26 56.1076
R220 pfet_01v8_lvt_W1_L10_m2__nf1_gboth_sdfull_pc/B.n37 pfet_01v8_lvt_W1_L10_m2__nf1_gboth_sdfull_pc/B.n26 56.1076
R221 pfet_01v8_lvt_W1_L10_m2__nf1_gboth_sdfull_pc/B.n79 pfet_01v8_lvt_W1_L10_m2__nf1_gboth_sdfull_pc/B.n26 56.1076
R222 pfet_01v8_lvt_W1_L10_m2__nf1_gboth_sdfull_pc/B.n33 pfet_01v8_lvt_W1_L10_m2__nf1_gboth_sdfull_pc/B.n26 56.1076
R223 pfet_01v8_lvt_W1_L10_m2__nf1_gboth_sdfull_pc/B.n88 pfet_01v8_lvt_W1_L10_m2__nf1_gboth_sdfull_pc/B.n26 56.1076
R224 pfet_01v8_lvt_W1_L10_m2__nf1_gboth_sdfull_pc/B.n94 pfet_01v8_lvt_W1_L10_m2__nf1_gboth_sdfull_pc/B.n26 56.1076
R225 pfet_01v8_lvt_W1_L10_m2__nf1_gboth_sdfull_pc/B.n96 pfet_01v8_lvt_W1_L10_m2__nf1_gboth_sdfull_pc/B.n26 56.1076
R226 pfet_01v8_lvt_W1_L10_m2__nf1_gboth_sdfull_pc/B.n17 pfet_01v8_lvt_W1_L10_m2__nf1_gboth_sdfull_pc/B.n3 38.1276
R227 pfet_01v8_lvt_W1_L10_m2__nf1_gboth_sdfull_pc/B.n102 pfet_01v8_lvt_W1_L10_m2__nf1_gboth_sdfull_pc/B.n26 38.1276
R228 pfet_01v8_lvt_W1_L10_m2__nf1_gboth_sdfull_pc/B.n153 pfet_01v8_lvt_W1_L10_m2__nf1_gboth_sdfull_pc/B.n17 27.0072
R229 pfet_01v8_lvt_W1_L10_m2__nf1_gboth_sdfull_pc/B.n153 pfet_01v8_lvt_W1_L10_m2__nf1_gboth_sdfull_pc/B.n16 27.0072
R230 pfet_01v8_lvt_W1_L10_m2__nf1_gboth_sdfull_pc/B.n108 pfet_01v8_lvt_W1_L10_m2__nf1_gboth_sdfull_pc/B.n22 27.0072
R231 pfet_01v8_lvt_W1_L10_m2__nf1_gboth_sdfull_pc/B.n102 pfet_01v8_lvt_W1_L10_m2__nf1_gboth_sdfull_pc/B.n22 27.0072
R232 pfet_01v8_lvt_W1_L10_m2__nf1_gboth_sdfull_pc/B.n157 pfet_01v8_lvt_W1_L10_m2__nf1_gboth_sdfull_pc/B.n11 25.6005
R233 pfet_01v8_lvt_W1_L10_m2__nf1_gboth_sdfull_pc/B.n162 pfet_01v8_lvt_W1_L10_m2__nf1_gboth_sdfull_pc/B.n11 25.6005
R234 pfet_01v8_lvt_W1_L10_m2__nf1_gboth_sdfull_pc/B.n163 pfet_01v8_lvt_W1_L10_m2__nf1_gboth_sdfull_pc/B.n162 25.6005
R235 pfet_01v8_lvt_W1_L10_m2__nf1_gboth_sdfull_pc/B.n164 pfet_01v8_lvt_W1_L10_m2__nf1_gboth_sdfull_pc/B.n163 25.6005
R236 pfet_01v8_lvt_W1_L10_m2__nf1_gboth_sdfull_pc/B.n164 pfet_01v8_lvt_W1_L10_m2__nf1_gboth_sdfull_pc/B.n8 25.6005
R237 pfet_01v8_lvt_W1_L10_m2__nf1_gboth_sdfull_pc/B.n169 pfet_01v8_lvt_W1_L10_m2__nf1_gboth_sdfull_pc/B.n8 25.6005
R238 pfet_01v8_lvt_W1_L10_m2__nf1_gboth_sdfull_pc/B.n170 pfet_01v8_lvt_W1_L10_m2__nf1_gboth_sdfull_pc/B.n169 25.6005
R239 pfet_01v8_lvt_W1_L10_m2__nf1_gboth_sdfull_pc/B.n171 pfet_01v8_lvt_W1_L10_m2__nf1_gboth_sdfull_pc/B.n170 25.6005
R240 pfet_01v8_lvt_W1_L10_m2__nf1_gboth_sdfull_pc/B.n171 pfet_01v8_lvt_W1_L10_m2__nf1_gboth_sdfull_pc/B.n5 25.6005
R241 pfet_01v8_lvt_W1_L10_m2__nf1_gboth_sdfull_pc/B.n176 pfet_01v8_lvt_W1_L10_m2__nf1_gboth_sdfull_pc/B.n5 25.6005
R242 pfet_01v8_lvt_W1_L10_m2__nf1_gboth_sdfull_pc/B.n177 pfet_01v8_lvt_W1_L10_m2__nf1_gboth_sdfull_pc/B.n176 25.6005
R243 pfet_01v8_lvt_W1_L10_m2__nf1_gboth_sdfull_pc/B.n178 pfet_01v8_lvt_W1_L10_m2__nf1_gboth_sdfull_pc/B.n177 25.6005
R244 pfet_01v8_lvt_W1_L10_m2__nf1_gboth_sdfull_pc/B.n178 pfet_01v8_lvt_W1_L10_m2__nf1_gboth_sdfull_pc/B.n1 25.6005
R245 pfet_01v8_lvt_W1_L10_m2__nf1_gboth_sdfull_pc/B.n183 pfet_01v8_lvt_W1_L10_m2__nf1_gboth_sdfull_pc/B.n1 25.6005
R246 pfet_01v8_lvt_W1_L10_m2__nf1_gboth_sdfull_pc/B.n123 pfet_01v8_lvt_W1_L10_m2__nf1_gboth_sdfull_pc/B.n0 25.6005
R247 pfet_01v8_lvt_W1_L10_m2__nf1_gboth_sdfull_pc/B.n123 pfet_01v8_lvt_W1_L10_m2__nf1_gboth_sdfull_pc/B.n120 25.6005
R248 pfet_01v8_lvt_W1_L10_m2__nf1_gboth_sdfull_pc/B.n128 pfet_01v8_lvt_W1_L10_m2__nf1_gboth_sdfull_pc/B.n120 25.6005
R249 pfet_01v8_lvt_W1_L10_m2__nf1_gboth_sdfull_pc/B.n129 pfet_01v8_lvt_W1_L10_m2__nf1_gboth_sdfull_pc/B.n128 25.6005
R250 pfet_01v8_lvt_W1_L10_m2__nf1_gboth_sdfull_pc/B.n130 pfet_01v8_lvt_W1_L10_m2__nf1_gboth_sdfull_pc/B.n129 25.6005
R251 pfet_01v8_lvt_W1_L10_m2__nf1_gboth_sdfull_pc/B.n130 pfet_01v8_lvt_W1_L10_m2__nf1_gboth_sdfull_pc/B.n117 25.6005
R252 pfet_01v8_lvt_W1_L10_m2__nf1_gboth_sdfull_pc/B.n135 pfet_01v8_lvt_W1_L10_m2__nf1_gboth_sdfull_pc/B.n117 25.6005
R253 pfet_01v8_lvt_W1_L10_m2__nf1_gboth_sdfull_pc/B.n136 pfet_01v8_lvt_W1_L10_m2__nf1_gboth_sdfull_pc/B.n135 25.6005
R254 pfet_01v8_lvt_W1_L10_m2__nf1_gboth_sdfull_pc/B.n137 pfet_01v8_lvt_W1_L10_m2__nf1_gboth_sdfull_pc/B.n136 25.6005
R255 pfet_01v8_lvt_W1_L10_m2__nf1_gboth_sdfull_pc/B.n137 pfet_01v8_lvt_W1_L10_m2__nf1_gboth_sdfull_pc/B.n114 25.6005
R256 pfet_01v8_lvt_W1_L10_m2__nf1_gboth_sdfull_pc/B.n142 pfet_01v8_lvt_W1_L10_m2__nf1_gboth_sdfull_pc/B.n114 25.6005
R257 pfet_01v8_lvt_W1_L10_m2__nf1_gboth_sdfull_pc/B.n143 pfet_01v8_lvt_W1_L10_m2__nf1_gboth_sdfull_pc/B.n142 25.6005
R258 pfet_01v8_lvt_W1_L10_m2__nf1_gboth_sdfull_pc/B.n144 pfet_01v8_lvt_W1_L10_m2__nf1_gboth_sdfull_pc/B.n143 25.6005
R259 pfet_01v8_lvt_W1_L10_m2__nf1_gboth_sdfull_pc/B.n144 pfet_01v8_lvt_W1_L10_m2__nf1_gboth_sdfull_pc/B.n112 25.6005
R260 pfet_01v8_lvt_W1_L10_m2__nf1_gboth_sdfull_pc/B.n149 pfet_01v8_lvt_W1_L10_m2__nf1_gboth_sdfull_pc/B.n112 25.6005
R261 pfet_01v8_lvt_W1_L10_m2__nf1_gboth_sdfull_pc/B.n156 pfet_01v8_lvt_W1_L10_m2__nf1_gboth_sdfull_pc/B.n155 25.6005
R262 pfet_01v8_lvt_W1_L10_m2__nf1_gboth_sdfull_pc/B.n155 pfet_01v8_lvt_W1_L10_m2__nf1_gboth_sdfull_pc/B.n14 25.6005
R263 pfet_01v8_lvt_W1_L10_m2__nf1_gboth_sdfull_pc/B.n106 pfet_01v8_lvt_W1_L10_m2__nf1_gboth_sdfull_pc/B.n14 25.6005
R264 pfet_01v8_lvt_W1_L10_m2__nf1_gboth_sdfull_pc/B.n106 pfet_01v8_lvt_W1_L10_m2__nf1_gboth_sdfull_pc/B.n105 25.6005
R265 pfet_01v8_lvt_W1_L10_m2__nf1_gboth_sdfull_pc/B.n105 pfet_01v8_lvt_W1_L10_m2__nf1_gboth_sdfull_pc/B.n104 25.6005
R266 pfet_01v8_lvt_W1_L10_m2__nf1_gboth_sdfull_pc/B.n48 pfet_01v8_lvt_W1_L10_m2__nf1_gboth_sdfull_pc/B.n24 25.6005
R267 pfet_01v8_lvt_W1_L10_m2__nf1_gboth_sdfull_pc/B.n49 pfet_01v8_lvt_W1_L10_m2__nf1_gboth_sdfull_pc/B.n48 25.6005
R268 pfet_01v8_lvt_W1_L10_m2__nf1_gboth_sdfull_pc/B.n50 pfet_01v8_lvt_W1_L10_m2__nf1_gboth_sdfull_pc/B.n49 25.6005
R269 pfet_01v8_lvt_W1_L10_m2__nf1_gboth_sdfull_pc/B.n50 pfet_01v8_lvt_W1_L10_m2__nf1_gboth_sdfull_pc/B.n43 25.6005
R270 pfet_01v8_lvt_W1_L10_m2__nf1_gboth_sdfull_pc/B.n55 pfet_01v8_lvt_W1_L10_m2__nf1_gboth_sdfull_pc/B.n43 25.6005
R271 pfet_01v8_lvt_W1_L10_m2__nf1_gboth_sdfull_pc/B.n56 pfet_01v8_lvt_W1_L10_m2__nf1_gboth_sdfull_pc/B.n55 25.6005
R272 pfet_01v8_lvt_W1_L10_m2__nf1_gboth_sdfull_pc/B.n57 pfet_01v8_lvt_W1_L10_m2__nf1_gboth_sdfull_pc/B.n56 25.6005
R273 pfet_01v8_lvt_W1_L10_m2__nf1_gboth_sdfull_pc/B.n57 pfet_01v8_lvt_W1_L10_m2__nf1_gboth_sdfull_pc/B.n41 25.6005
R274 pfet_01v8_lvt_W1_L10_m2__nf1_gboth_sdfull_pc/B.n62 pfet_01v8_lvt_W1_L10_m2__nf1_gboth_sdfull_pc/B.n41 25.6005
R275 pfet_01v8_lvt_W1_L10_m2__nf1_gboth_sdfull_pc/B.n63 pfet_01v8_lvt_W1_L10_m2__nf1_gboth_sdfull_pc/B.n62 25.6005
R276 pfet_01v8_lvt_W1_L10_m2__nf1_gboth_sdfull_pc/B.n63 pfet_01v8_lvt_W1_L10_m2__nf1_gboth_sdfull_pc/B.n39 25.6005
R277 pfet_01v8_lvt_W1_L10_m2__nf1_gboth_sdfull_pc/B.n68 pfet_01v8_lvt_W1_L10_m2__nf1_gboth_sdfull_pc/B.n39 25.6005
R278 pfet_01v8_lvt_W1_L10_m2__nf1_gboth_sdfull_pc/B.n69 pfet_01v8_lvt_W1_L10_m2__nf1_gboth_sdfull_pc/B.n68 25.6005
R279 pfet_01v8_lvt_W1_L10_m2__nf1_gboth_sdfull_pc/B.n70 pfet_01v8_lvt_W1_L10_m2__nf1_gboth_sdfull_pc/B.n69 25.6005
R280 pfet_01v8_lvt_W1_L10_m2__nf1_gboth_sdfull_pc/B.n70 pfet_01v8_lvt_W1_L10_m2__nf1_gboth_sdfull_pc/B.n36 25.6005
R281 pfet_01v8_lvt_W1_L10_m2__nf1_gboth_sdfull_pc/B.n75 pfet_01v8_lvt_W1_L10_m2__nf1_gboth_sdfull_pc/B.n36 25.6005
R282 pfet_01v8_lvt_W1_L10_m2__nf1_gboth_sdfull_pc/B.n76 pfet_01v8_lvt_W1_L10_m2__nf1_gboth_sdfull_pc/B.n75 25.6005
R283 pfet_01v8_lvt_W1_L10_m2__nf1_gboth_sdfull_pc/B.n77 pfet_01v8_lvt_W1_L10_m2__nf1_gboth_sdfull_pc/B.n76 25.6005
R284 pfet_01v8_lvt_W1_L10_m2__nf1_gboth_sdfull_pc/B.n77 pfet_01v8_lvt_W1_L10_m2__nf1_gboth_sdfull_pc/B.n34 25.6005
R285 pfet_01v8_lvt_W1_L10_m2__nf1_gboth_sdfull_pc/B.n34 pfet_01v8_lvt_W1_L10_m2__nf1_gboth_sdfull_pc/B.n32 25.6005
R286 pfet_01v8_lvt_W1_L10_m2__nf1_gboth_sdfull_pc/B.n83 pfet_01v8_lvt_W1_L10_m2__nf1_gboth_sdfull_pc/B.n32 25.6005
R287 pfet_01v8_lvt_W1_L10_m2__nf1_gboth_sdfull_pc/B.n84 pfet_01v8_lvt_W1_L10_m2__nf1_gboth_sdfull_pc/B.n83 25.6005
R288 pfet_01v8_lvt_W1_L10_m2__nf1_gboth_sdfull_pc/B.n85 pfet_01v8_lvt_W1_L10_m2__nf1_gboth_sdfull_pc/B.n84 25.6005
R289 pfet_01v8_lvt_W1_L10_m2__nf1_gboth_sdfull_pc/B.n85 pfet_01v8_lvt_W1_L10_m2__nf1_gboth_sdfull_pc/B.n30 25.6005
R290 pfet_01v8_lvt_W1_L10_m2__nf1_gboth_sdfull_pc/B.n90 pfet_01v8_lvt_W1_L10_m2__nf1_gboth_sdfull_pc/B.n30 25.6005
R291 pfet_01v8_lvt_W1_L10_m2__nf1_gboth_sdfull_pc/B.n91 pfet_01v8_lvt_W1_L10_m2__nf1_gboth_sdfull_pc/B.n90 25.6005
R292 pfet_01v8_lvt_W1_L10_m2__nf1_gboth_sdfull_pc/B.n92 pfet_01v8_lvt_W1_L10_m2__nf1_gboth_sdfull_pc/B.n91 25.6005
R293 pfet_01v8_lvt_W1_L10_m2__nf1_gboth_sdfull_pc/B.n92 pfet_01v8_lvt_W1_L10_m2__nf1_gboth_sdfull_pc/B.n28 25.6005
R294 pfet_01v8_lvt_W1_L10_m2__nf1_gboth_sdfull_pc/B.n98 pfet_01v8_lvt_W1_L10_m2__nf1_gboth_sdfull_pc/B.n28 25.6005
R295 pfet_01v8_lvt_W1_L10_m2__nf1_gboth_sdfull_pc/B.n99 pfet_01v8_lvt_W1_L10_m2__nf1_gboth_sdfull_pc/B.n98 25.6005
R296 pfet_01v8_lvt_W1_L10_m2__nf1_gboth_sdfull_pc/B.n151 pfet_01v8_lvt_W1_L10_m2__nf1_gboth_sdfull_pc/B.n150 25.6005
R297 pfet_01v8_lvt_W1_L10_m2__nf1_gboth_sdfull_pc/B.n151 pfet_01v8_lvt_W1_L10_m2__nf1_gboth_sdfull_pc/B.n111 25.6005
R298 pfet_01v8_lvt_W1_L10_m2__nf1_gboth_sdfull_pc/B.n111 pfet_01v8_lvt_W1_L10_m2__nf1_gboth_sdfull_pc/B.n110 25.6005
R299 pfet_01v8_lvt_W1_L10_m2__nf1_gboth_sdfull_pc/B.n110 pfet_01v8_lvt_W1_L10_m2__nf1_gboth_sdfull_pc/B.n20 25.6005
R300 pfet_01v8_lvt_W1_L10_m2__nf1_gboth_sdfull_pc/B.n100 pfet_01v8_lvt_W1_L10_m2__nf1_gboth_sdfull_pc/B.n20 25.6005
R301 B pfet_01v8_lvt_W1_L10_m2__nf1_gboth_sdfull_pc/B.n183 19.2005
R302 pfet_01v8_lvt_W1_L10_m2__nf1_gboth_sdfull_pc/B.t0 pfet_01v8_lvt_W1_L10_m2__nf1_gboth_sdfull_pc/B.n16 13.5038
R303 pfet_01v8_lvt_W1_L10_m2__nf1_gboth_sdfull_pc/B.n108 pfet_01v8_lvt_W1_L10_m2__nf1_gboth_sdfull_pc/B.t0 13.5038
R304 B pfet_01v8_lvt_W1_L10_m2__nf1_gboth_sdfull_pc/B.n0 6.4005
C5 S VSUBS 0.05316f
C6 D VSUBS 0.05316f
C7 G VSUBS 1.05379f
C8 B VSUBS 5.59959f
C9 pfet_01v8_lvt_W1_L10_m2__nf1_gboth_sdfull_pc/B.n0 VSUBS 0.00259f ; **FLOATING
C10 pfet_01v8_lvt_W1_L10_m2__nf1_gboth_sdfull_pc/B.n1 VSUBS 0.00415f ; **FLOATING
C11 pfet_01v8_lvt_W1_L10_m2__nf1_gboth_sdfull_pc/B.n3 VSUBS 0.43345f ; **FLOATING
C12 pfet_01v8_lvt_W1_L10_m2__nf1_gboth_sdfull_pc/B.n4 VSUBS 0.00415f ; **FLOATING
C13 pfet_01v8_lvt_W1_L10_m2__nf1_gboth_sdfull_pc/B.n5 VSUBS 0.00415f ; **FLOATING
C14 pfet_01v8_lvt_W1_L10_m2__nf1_gboth_sdfull_pc/B.n7 VSUBS 0.00415f ; **FLOATING
C15 pfet_01v8_lvt_W1_L10_m2__nf1_gboth_sdfull_pc/B.n8 VSUBS 0.00415f ; **FLOATING
C16 pfet_01v8_lvt_W1_L10_m2__nf1_gboth_sdfull_pc/B.n10 VSUBS 0.00415f ; **FLOATING
C17 pfet_01v8_lvt_W1_L10_m2__nf1_gboth_sdfull_pc/B.n11 VSUBS 0.00415f ; **FLOATING
C18 pfet_01v8_lvt_W1_L10_m2__nf1_gboth_sdfull_pc/B.n13 VSUBS 0.00887f ; **FLOATING
C19 pfet_01v8_lvt_W1_L10_m2__nf1_gboth_sdfull_pc/B.n14 VSUBS 0.00415f ; **FLOATING
C20 pfet_01v8_lvt_W1_L10_m2__nf1_gboth_sdfull_pc/B.n15 VSUBS 0.00415f ; **FLOATING
C21 pfet_01v8_lvt_W1_L10_m2__nf1_gboth_sdfull_pc/B.n16 VSUBS 0.21887f ; **FLOATING
C22 pfet_01v8_lvt_W1_L10_m2__nf1_gboth_sdfull_pc/B.n17 VSUBS 0.35191f ; **FLOATING
C23 pfet_01v8_lvt_W1_L10_m2__nf1_gboth_sdfull_pc/B.n18 VSUBS 0.00415f ; **FLOATING
C24 pfet_01v8_lvt_W1_L10_m2__nf1_gboth_sdfull_pc/B.n19 VSUBS 0.00887f ; **FLOATING
C25 pfet_01v8_lvt_W1_L10_m2__nf1_gboth_sdfull_pc/B.n20 VSUBS 0.00415f ; **FLOATING
C26 pfet_01v8_lvt_W1_L10_m2__nf1_gboth_sdfull_pc/B.n21 VSUBS 0.00415f ; **FLOATING
C27 pfet_01v8_lvt_W1_L10_m2__nf1_gboth_sdfull_pc/B.n22 VSUBS 0.29183f ; **FLOATING
C28 pfet_01v8_lvt_W1_L10_m2__nf1_gboth_sdfull_pc/B.n23 VSUBS 0.00415f ; **FLOATING
C29 pfet_01v8_lvt_W1_L10_m2__nf1_gboth_sdfull_pc/B.n24 VSUBS 0.00864f ; **FLOATING
C30 pfet_01v8_lvt_W1_L10_m2__nf1_gboth_sdfull_pc/B.n25 VSUBS 0.00864f ; **FLOATING
C31 pfet_01v8_lvt_W1_L10_m2__nf1_gboth_sdfull_pc/B.n26 VSUBS 0.43345f ; **FLOATING
C32 pfet_01v8_lvt_W1_L10_m2__nf1_gboth_sdfull_pc/B.n27 VSUBS 0.00864f ; **FLOATING
C33 pfet_01v8_lvt_W1_L10_m2__nf1_gboth_sdfull_pc/B.n28 VSUBS 0.00415f ; **FLOATING
C34 pfet_01v8_lvt_W1_L10_m2__nf1_gboth_sdfull_pc/B.n29 VSUBS 0.00415f ; **FLOATING
C35 pfet_01v8_lvt_W1_L10_m2__nf1_gboth_sdfull_pc/B.n30 VSUBS 0.00415f ; **FLOATING
C36 pfet_01v8_lvt_W1_L10_m2__nf1_gboth_sdfull_pc/B.n31 VSUBS 0.00415f ; **FLOATING
C37 pfet_01v8_lvt_W1_L10_m2__nf1_gboth_sdfull_pc/B.n32 VSUBS 0.00415f ; **FLOATING
C38 pfet_01v8_lvt_W1_L10_m2__nf1_gboth_sdfull_pc/B.n34 VSUBS 0.00415f ; **FLOATING
C39 pfet_01v8_lvt_W1_L10_m2__nf1_gboth_sdfull_pc/B.n35 VSUBS 0.00415f ; **FLOATING
C40 pfet_01v8_lvt_W1_L10_m2__nf1_gboth_sdfull_pc/B.n36 VSUBS 0.00415f ; **FLOATING
C41 pfet_01v8_lvt_W1_L10_m2__nf1_gboth_sdfull_pc/B.n38 VSUBS 0.00415f ; **FLOATING
C42 pfet_01v8_lvt_W1_L10_m2__nf1_gboth_sdfull_pc/B.n39 VSUBS 0.00415f ; **FLOATING
C43 pfet_01v8_lvt_W1_L10_m2__nf1_gboth_sdfull_pc/B.n41 VSUBS 0.00415f ; **FLOATING
C44 pfet_01v8_lvt_W1_L10_m2__nf1_gboth_sdfull_pc/B.n42 VSUBS 0.00415f ; **FLOATING
C45 pfet_01v8_lvt_W1_L10_m2__nf1_gboth_sdfull_pc/B.n43 VSUBS 0.00415f ; **FLOATING
C46 pfet_01v8_lvt_W1_L10_m2__nf1_gboth_sdfull_pc/B.n45 VSUBS 0.00415f ; **FLOATING
C47 pfet_01v8_lvt_W1_L10_m2__nf1_gboth_sdfull_pc/B.n47 VSUBS 0.00415f ; **FLOATING
C48 pfet_01v8_lvt_W1_L10_m2__nf1_gboth_sdfull_pc/B.n48 VSUBS 0.00415f ; **FLOATING
C49 pfet_01v8_lvt_W1_L10_m2__nf1_gboth_sdfull_pc/B.n49 VSUBS 0.00415f ; **FLOATING
C50 pfet_01v8_lvt_W1_L10_m2__nf1_gboth_sdfull_pc/B.n50 VSUBS 0.00415f ; **FLOATING
C51 pfet_01v8_lvt_W1_L10_m2__nf1_gboth_sdfull_pc/B.n51 VSUBS 0.00415f ; **FLOATING
C52 pfet_01v8_lvt_W1_L10_m2__nf1_gboth_sdfull_pc/B.n53 VSUBS 0.00415f ; **FLOATING
C53 pfet_01v8_lvt_W1_L10_m2__nf1_gboth_sdfull_pc/B.n54 VSUBS 0.00415f ; **FLOATING
C54 pfet_01v8_lvt_W1_L10_m2__nf1_gboth_sdfull_pc/B.n55 VSUBS 0.00415f ; **FLOATING
C55 pfet_01v8_lvt_W1_L10_m2__nf1_gboth_sdfull_pc/B.n56 VSUBS 0.00415f ; **FLOATING
C56 pfet_01v8_lvt_W1_L10_m2__nf1_gboth_sdfull_pc/B.n57 VSUBS 0.00415f ; **FLOATING
C57 pfet_01v8_lvt_W1_L10_m2__nf1_gboth_sdfull_pc/B.n58 VSUBS 0.00415f ; **FLOATING
C58 pfet_01v8_lvt_W1_L10_m2__nf1_gboth_sdfull_pc/B.n60 VSUBS 0.00415f ; **FLOATING
C59 pfet_01v8_lvt_W1_L10_m2__nf1_gboth_sdfull_pc/B.n61 VSUBS 0.00415f ; **FLOATING
C60 pfet_01v8_lvt_W1_L10_m2__nf1_gboth_sdfull_pc/B.n62 VSUBS 0.00415f ; **FLOATING
C61 pfet_01v8_lvt_W1_L10_m2__nf1_gboth_sdfull_pc/B.n63 VSUBS 0.00415f ; **FLOATING
C62 pfet_01v8_lvt_W1_L10_m2__nf1_gboth_sdfull_pc/B.n64 VSUBS 0.00415f ; **FLOATING
C63 pfet_01v8_lvt_W1_L10_m2__nf1_gboth_sdfull_pc/B.n65 VSUBS 0.00415f ; **FLOATING
C64 pfet_01v8_lvt_W1_L10_m2__nf1_gboth_sdfull_pc/B.n67 VSUBS 0.00415f ; **FLOATING
C65 pfet_01v8_lvt_W1_L10_m2__nf1_gboth_sdfull_pc/B.n68 VSUBS 0.00415f ; **FLOATING
C66 pfet_01v8_lvt_W1_L10_m2__nf1_gboth_sdfull_pc/B.n69 VSUBS 0.00415f ; **FLOATING
C67 pfet_01v8_lvt_W1_L10_m2__nf1_gboth_sdfull_pc/B.n70 VSUBS 0.00415f ; **FLOATING
C68 pfet_01v8_lvt_W1_L10_m2__nf1_gboth_sdfull_pc/B.n71 VSUBS 0.00415f ; **FLOATING
C69 pfet_01v8_lvt_W1_L10_m2__nf1_gboth_sdfull_pc/B.n73 VSUBS 0.00415f ; **FLOATING
C70 pfet_01v8_lvt_W1_L10_m2__nf1_gboth_sdfull_pc/B.n74 VSUBS 0.00415f ; **FLOATING
C71 pfet_01v8_lvt_W1_L10_m2__nf1_gboth_sdfull_pc/B.n75 VSUBS 0.00415f ; **FLOATING
C72 pfet_01v8_lvt_W1_L10_m2__nf1_gboth_sdfull_pc/B.n76 VSUBS 0.00415f ; **FLOATING
C73 pfet_01v8_lvt_W1_L10_m2__nf1_gboth_sdfull_pc/B.n77 VSUBS 0.00415f ; **FLOATING
C74 pfet_01v8_lvt_W1_L10_m2__nf1_gboth_sdfull_pc/B.n78 VSUBS 0.00415f ; **FLOATING
C75 pfet_01v8_lvt_W1_L10_m2__nf1_gboth_sdfull_pc/B.n80 VSUBS 0.00415f ; **FLOATING
C76 pfet_01v8_lvt_W1_L10_m2__nf1_gboth_sdfull_pc/B.n81 VSUBS 0.00415f ; **FLOATING
C77 pfet_01v8_lvt_W1_L10_m2__nf1_gboth_sdfull_pc/B.n82 VSUBS 0.00415f ; **FLOATING
C78 pfet_01v8_lvt_W1_L10_m2__nf1_gboth_sdfull_pc/B.n83 VSUBS 0.00415f ; **FLOATING
C79 pfet_01v8_lvt_W1_L10_m2__nf1_gboth_sdfull_pc/B.n84 VSUBS 0.00415f ; **FLOATING
C80 pfet_01v8_lvt_W1_L10_m2__nf1_gboth_sdfull_pc/B.n85 VSUBS 0.00415f ; **FLOATING
C81 pfet_01v8_lvt_W1_L10_m2__nf1_gboth_sdfull_pc/B.n86 VSUBS 0.00415f ; **FLOATING
C82 pfet_01v8_lvt_W1_L10_m2__nf1_gboth_sdfull_pc/B.n87 VSUBS 0.00415f ; **FLOATING
C83 pfet_01v8_lvt_W1_L10_m2__nf1_gboth_sdfull_pc/B.n89 VSUBS 0.00415f ; **FLOATING
C84 pfet_01v8_lvt_W1_L10_m2__nf1_gboth_sdfull_pc/B.n90 VSUBS 0.00415f ; **FLOATING
C85 pfet_01v8_lvt_W1_L10_m2__nf1_gboth_sdfull_pc/B.n91 VSUBS 0.00415f ; **FLOATING
C86 pfet_01v8_lvt_W1_L10_m2__nf1_gboth_sdfull_pc/B.n92 VSUBS 0.00415f ; **FLOATING
C87 pfet_01v8_lvt_W1_L10_m2__nf1_gboth_sdfull_pc/B.n93 VSUBS 0.00415f ; **FLOATING
C88 pfet_01v8_lvt_W1_L10_m2__nf1_gboth_sdfull_pc/B.n95 VSUBS 0.00415f ; **FLOATING
C89 pfet_01v8_lvt_W1_L10_m2__nf1_gboth_sdfull_pc/B.n97 VSUBS 0.00415f ; **FLOATING
C90 pfet_01v8_lvt_W1_L10_m2__nf1_gboth_sdfull_pc/B.n98 VSUBS 0.00415f ; **FLOATING
C91 pfet_01v8_lvt_W1_L10_m2__nf1_gboth_sdfull_pc/B.n99 VSUBS 0.00864f ; **FLOATING
C92 pfet_01v8_lvt_W1_L10_m2__nf1_gboth_sdfull_pc/B.n100 VSUBS 0.00887f ; **FLOATING
C93 pfet_01v8_lvt_W1_L10_m2__nf1_gboth_sdfull_pc/B.n101 VSUBS 0.00887f ; **FLOATING
C94 pfet_01v8_lvt_W1_L10_m2__nf1_gboth_sdfull_pc/B.n102 VSUBS 0.35191f ; **FLOATING
C95 pfet_01v8_lvt_W1_L10_m2__nf1_gboth_sdfull_pc/B.n103 VSUBS 0.00887f ; **FLOATING
C96 pfet_01v8_lvt_W1_L10_m2__nf1_gboth_sdfull_pc/B.n104 VSUBS 0.00887f ; **FLOATING
C97 pfet_01v8_lvt_W1_L10_m2__nf1_gboth_sdfull_pc/B.n105 VSUBS 0.00415f ; **FLOATING
C98 pfet_01v8_lvt_W1_L10_m2__nf1_gboth_sdfull_pc/B.n106 VSUBS 0.00415f ; **FLOATING
C99 pfet_01v8_lvt_W1_L10_m2__nf1_gboth_sdfull_pc/B.n107 VSUBS 0.00415f ; **FLOATING
C100 pfet_01v8_lvt_W1_L10_m2__nf1_gboth_sdfull_pc/B.t0 VSUBS 0.14591f ; **FLOATING
C101 pfet_01v8_lvt_W1_L10_m2__nf1_gboth_sdfull_pc/B.n108 VSUBS 0.21887f ; **FLOATING
C102 pfet_01v8_lvt_W1_L10_m2__nf1_gboth_sdfull_pc/B.n109 VSUBS 0.00415f ; **FLOATING
C103 pfet_01v8_lvt_W1_L10_m2__nf1_gboth_sdfull_pc/B.n110 VSUBS 0.00415f ; **FLOATING
C104 pfet_01v8_lvt_W1_L10_m2__nf1_gboth_sdfull_pc/B.n111 VSUBS 0.00415f ; **FLOATING
C105 pfet_01v8_lvt_W1_L10_m2__nf1_gboth_sdfull_pc/B.n112 VSUBS 0.00415f ; **FLOATING
C106 pfet_01v8_lvt_W1_L10_m2__nf1_gboth_sdfull_pc/B.n113 VSUBS 0.00415f ; **FLOATING
C107 pfet_01v8_lvt_W1_L10_m2__nf1_gboth_sdfull_pc/B.n114 VSUBS 0.00415f ; **FLOATING
C108 pfet_01v8_lvt_W1_L10_m2__nf1_gboth_sdfull_pc/B.n116 VSUBS 0.00415f ; **FLOATING
C109 pfet_01v8_lvt_W1_L10_m2__nf1_gboth_sdfull_pc/B.n117 VSUBS 0.00415f ; **FLOATING
C110 pfet_01v8_lvt_W1_L10_m2__nf1_gboth_sdfull_pc/B.n119 VSUBS 0.00415f ; **FLOATING
C111 pfet_01v8_lvt_W1_L10_m2__nf1_gboth_sdfull_pc/B.n120 VSUBS 0.00415f ; **FLOATING
C112 pfet_01v8_lvt_W1_L10_m2__nf1_gboth_sdfull_pc/B.n122 VSUBS 0.00415f ; **FLOATING
C113 pfet_01v8_lvt_W1_L10_m2__nf1_gboth_sdfull_pc/B.n123 VSUBS 0.00415f ; **FLOATING
C114 pfet_01v8_lvt_W1_L10_m2__nf1_gboth_sdfull_pc/B.n124 VSUBS 0.00415f ; **FLOATING
C115 pfet_01v8_lvt_W1_L10_m2__nf1_gboth_sdfull_pc/B.n126 VSUBS 0.00415f ; **FLOATING
C116 pfet_01v8_lvt_W1_L10_m2__nf1_gboth_sdfull_pc/B.n127 VSUBS 0.00415f ; **FLOATING
C117 pfet_01v8_lvt_W1_L10_m2__nf1_gboth_sdfull_pc/B.n128 VSUBS 0.00415f ; **FLOATING
C118 pfet_01v8_lvt_W1_L10_m2__nf1_gboth_sdfull_pc/B.n129 VSUBS 0.00415f ; **FLOATING
C119 pfet_01v8_lvt_W1_L10_m2__nf1_gboth_sdfull_pc/B.n130 VSUBS 0.00415f ; **FLOATING
C120 pfet_01v8_lvt_W1_L10_m2__nf1_gboth_sdfull_pc/B.n131 VSUBS 0.00415f ; **FLOATING
C121 pfet_01v8_lvt_W1_L10_m2__nf1_gboth_sdfull_pc/B.n133 VSUBS 0.00415f ; **FLOATING
C122 pfet_01v8_lvt_W1_L10_m2__nf1_gboth_sdfull_pc/B.n134 VSUBS 0.00415f ; **FLOATING
C123 pfet_01v8_lvt_W1_L10_m2__nf1_gboth_sdfull_pc/B.n135 VSUBS 0.00415f ; **FLOATING
C124 pfet_01v8_lvt_W1_L10_m2__nf1_gboth_sdfull_pc/B.n136 VSUBS 0.00415f ; **FLOATING
C125 pfet_01v8_lvt_W1_L10_m2__nf1_gboth_sdfull_pc/B.n137 VSUBS 0.00415f ; **FLOATING
C126 pfet_01v8_lvt_W1_L10_m2__nf1_gboth_sdfull_pc/B.n138 VSUBS 0.00415f ; **FLOATING
C127 pfet_01v8_lvt_W1_L10_m2__nf1_gboth_sdfull_pc/B.n140 VSUBS 0.00415f ; **FLOATING
C128 pfet_01v8_lvt_W1_L10_m2__nf1_gboth_sdfull_pc/B.n141 VSUBS 0.00415f ; **FLOATING
C129 pfet_01v8_lvt_W1_L10_m2__nf1_gboth_sdfull_pc/B.n142 VSUBS 0.00415f ; **FLOATING
C130 pfet_01v8_lvt_W1_L10_m2__nf1_gboth_sdfull_pc/B.n143 VSUBS 0.00415f ; **FLOATING
C131 pfet_01v8_lvt_W1_L10_m2__nf1_gboth_sdfull_pc/B.n144 VSUBS 0.00415f ; **FLOATING
C132 pfet_01v8_lvt_W1_L10_m2__nf1_gboth_sdfull_pc/B.n145 VSUBS 0.00415f ; **FLOATING
C133 pfet_01v8_lvt_W1_L10_m2__nf1_gboth_sdfull_pc/B.n147 VSUBS 0.00415f ; **FLOATING
C134 pfet_01v8_lvt_W1_L10_m2__nf1_gboth_sdfull_pc/B.n148 VSUBS 0.00864f ; **FLOATING
C135 pfet_01v8_lvt_W1_L10_m2__nf1_gboth_sdfull_pc/B.n149 VSUBS 0.00864f ; **FLOATING
C136 pfet_01v8_lvt_W1_L10_m2__nf1_gboth_sdfull_pc/B.n150 VSUBS 0.00887f ; **FLOATING
C137 pfet_01v8_lvt_W1_L10_m2__nf1_gboth_sdfull_pc/B.n151 VSUBS 0.00415f ; **FLOATING
C138 pfet_01v8_lvt_W1_L10_m2__nf1_gboth_sdfull_pc/B.n152 VSUBS 0.00415f ; **FLOATING
C139 pfet_01v8_lvt_W1_L10_m2__nf1_gboth_sdfull_pc/B.n153 VSUBS 0.29183f ; **FLOATING
C140 pfet_01v8_lvt_W1_L10_m2__nf1_gboth_sdfull_pc/B.n154 VSUBS 0.00415f ; **FLOATING
C141 pfet_01v8_lvt_W1_L10_m2__nf1_gboth_sdfull_pc/B.n155 VSUBS 0.00415f ; **FLOATING
C142 pfet_01v8_lvt_W1_L10_m2__nf1_gboth_sdfull_pc/B.n156 VSUBS 0.00887f ; **FLOATING
C143 pfet_01v8_lvt_W1_L10_m2__nf1_gboth_sdfull_pc/B.n157 VSUBS 0.00864f ; **FLOATING
C144 pfet_01v8_lvt_W1_L10_m2__nf1_gboth_sdfull_pc/B.n158 VSUBS 0.00864f ; **FLOATING
C145 pfet_01v8_lvt_W1_L10_m2__nf1_gboth_sdfull_pc/B.n160 VSUBS 0.00415f ; **FLOATING
C146 pfet_01v8_lvt_W1_L10_m2__nf1_gboth_sdfull_pc/B.n161 VSUBS 0.00415f ; **FLOATING
C147 pfet_01v8_lvt_W1_L10_m2__nf1_gboth_sdfull_pc/B.n162 VSUBS 0.00415f ; **FLOATING
C148 pfet_01v8_lvt_W1_L10_m2__nf1_gboth_sdfull_pc/B.n163 VSUBS 0.00415f ; **FLOATING
C149 pfet_01v8_lvt_W1_L10_m2__nf1_gboth_sdfull_pc/B.n164 VSUBS 0.00415f ; **FLOATING
C150 pfet_01v8_lvt_W1_L10_m2__nf1_gboth_sdfull_pc/B.n165 VSUBS 0.00415f ; **FLOATING
C151 pfet_01v8_lvt_W1_L10_m2__nf1_gboth_sdfull_pc/B.n167 VSUBS 0.00415f ; **FLOATING
C152 pfet_01v8_lvt_W1_L10_m2__nf1_gboth_sdfull_pc/B.n168 VSUBS 0.00415f ; **FLOATING
C153 pfet_01v8_lvt_W1_L10_m2__nf1_gboth_sdfull_pc/B.n169 VSUBS 0.00415f ; **FLOATING
C154 pfet_01v8_lvt_W1_L10_m2__nf1_gboth_sdfull_pc/B.n170 VSUBS 0.00415f ; **FLOATING
C155 pfet_01v8_lvt_W1_L10_m2__nf1_gboth_sdfull_pc/B.n171 VSUBS 0.00415f ; **FLOATING
C156 pfet_01v8_lvt_W1_L10_m2__nf1_gboth_sdfull_pc/B.n172 VSUBS 0.00415f ; **FLOATING
C157 pfet_01v8_lvt_W1_L10_m2__nf1_gboth_sdfull_pc/B.n174 VSUBS 0.00415f ; **FLOATING
C158 pfet_01v8_lvt_W1_L10_m2__nf1_gboth_sdfull_pc/B.n175 VSUBS 0.00415f ; **FLOATING
C159 pfet_01v8_lvt_W1_L10_m2__nf1_gboth_sdfull_pc/B.n176 VSUBS 0.00415f ; **FLOATING
C160 pfet_01v8_lvt_W1_L10_m2__nf1_gboth_sdfull_pc/B.n177 VSUBS 0.00415f ; **FLOATING
C161 pfet_01v8_lvt_W1_L10_m2__nf1_gboth_sdfull_pc/B.n178 VSUBS 0.00415f ; **FLOATING
C162 pfet_01v8_lvt_W1_L10_m2__nf1_gboth_sdfull_pc/B.n179 VSUBS 0.00415f ; **FLOATING
C163 pfet_01v8_lvt_W1_L10_m2__nf1_gboth_sdfull_pc/B.n181 VSUBS 0.00415f ; **FLOATING
C164 pfet_01v8_lvt_W1_L10_m2__nf1_gboth_sdfull_pc/B.n182 VSUBS 0.00415f ; **FLOATING
C165 pfet_01v8_lvt_W1_L10_m2__nf1_gboth_sdfull_pc/B.n183 VSUBS 0.00363f ; **FLOATING
