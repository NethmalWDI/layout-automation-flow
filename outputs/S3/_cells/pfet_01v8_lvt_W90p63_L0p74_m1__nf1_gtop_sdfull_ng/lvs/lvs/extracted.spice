* NGSPICE file created from pfet_01v8_lvt_W90p63_L0p74_m1__nf1_gtop_sdfull_ng.ext - technology: sky130A

.subckt sky130_fd_pr__pfet_01v8_lvt_XUBZ8A G D w_n168_n9161# S
X0 S G D w_n168_n9161# sky130_fd_pr__pfet_01v8_lvt ad=26.2827 pd=181.84 as=26.2827 ps=181.84 w=90.63 l=0.74
.ends

.subckt pfet_01v8_lvt_W90p63_L0p74_m1__nf1_gtop_sdfull_ng D S G B
Xpfet_01v8_lvt_W90p63_L0p74_m1__nf1_gtop_sdfull_ng_pc G D B S sky130_fd_pr__pfet_01v8_lvt_XUBZ8A
.ends
