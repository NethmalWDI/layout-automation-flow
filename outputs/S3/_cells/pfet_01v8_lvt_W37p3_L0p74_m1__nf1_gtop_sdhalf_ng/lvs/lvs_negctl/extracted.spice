* NGSPICE file created from pfet_01v8_lvt_W37p3_L0p74_m1__nf1_gtop_sdhalf_ng.ext - technology: sky130A

.subckt sky130_fd_pr__pfet_01v8_lvt_D4PWVM G D w_n168_n3828# S
X0 S G D w_n168_n3828# sky130_fd_pr__pfet_01v8_lvt ad=10.817 pd=75.18 as=10.817 ps=75.18 w=37.3 l=0.74
.ends

.subckt pfet_01v8_lvt_W37p3_L0p74_m1__nf1_gtop_sdhalf_ng D S G B
Xpfet_01v8_lvt_W37p3_L0p74_m1__nf1_gtop_sdhalf_ng_pc G D B S sky130_fd_pr__pfet_01v8_lvt_D4PWVM
.ends
