* NGSPICE file created from nfet_01v8_W24_L0p5_m1__nf4_gboth_sdhalf_outS.ext - technology: sky130A

.subckt nfet_01v8_W24_L0p5_m1__nf4_gboth_sdhalf_outS S D G B
X0 D G S B sky130_fd_pr__nfet_01v8 ad=0.87 pd=6.29 as=1.74 ps=12.58 w=6 l=0.5
X1 S G D B sky130_fd_pr__nfet_01v8 ad=1.74 pd=12.58 as=0.87 ps=6.29 w=6 l=0.5
X2 D G S B sky130_fd_pr__nfet_01v8 ad=0.87 pd=6.29 as=0.87 ps=6.29 w=6 l=0.5
X3 S G D B sky130_fd_pr__nfet_01v8 ad=0.87 pd=6.29 as=0.87 ps=6.29 w=6 l=0.5
C0 S D 0.87688f
C1 S G 0.61986f
C2 G D 0.61955f
C3 D B 0.10353f
C4 S B 0.62446f
C5 G B 1.32165f
.ends
