* NGSPICE file created from pfet_01v8_lvt_W887p03_L0p74_m1__nf1_gboth_sdhalf.ext - technology: sky130A

.subckt sky130_fd_pr__pfet_01v8_lvt_TSGEX8 G D B S
X0 S G D B sky130_fd_pr__pfet_01v8_lvt ad=257.23871 pd=1.77464k as=257.23871 ps=1.77464k w=887.03003 l=0.74
.ends

.subckt pfet_01v8_lvt_W887p03_L0p74_m1__nf1_gboth_sdhalf D S G B
Xpfet_01v8_lvt_W887p03_L0p74_m1__nf1_gboth_sdhalf_pc G D B S sky130_fd_pr__pfet_01v8_lvt_TSGEX8
.ends
