* NGSPICE file created from nfet_01v8_lvt_W484p2_L0p24_m1__nf16_gboth_sdfull_outS.ext - technology: sky130A

.subckt sky130_fd_pr__nfet_01v8_lvt_BC2H8C D10 S15 G S13 S11 B D8 D6 a_819_n3026#
+ D4 D2 D0 S9 S7 S5 S3 D14 S1 D12
X0 S1 G D0 B sky130_fd_pr__nfet_01v8_lvt ad=4.3877 pd=30.55 as=8.7754 ps=61.1 w=30.26 l=0.24
X1 S3 G D2 B sky130_fd_pr__nfet_01v8_lvt ad=4.3877 pd=30.55 as=4.3877 ps=30.55 w=30.26 l=0.24
X2 D14 G S13 B sky130_fd_pr__nfet_01v8_lvt ad=4.3877 pd=30.55 as=4.3877 ps=30.55 w=30.26 l=0.24
X3 D10 G S9 B sky130_fd_pr__nfet_01v8_lvt ad=4.3877 pd=30.55 as=4.3877 ps=30.55 w=30.26 l=0.24
X4 D12 G S11 B sky130_fd_pr__nfet_01v8_lvt ad=4.3877 pd=30.55 as=4.3877 ps=30.55 w=30.26 l=0.24
X5 D8 G S7 B sky130_fd_pr__nfet_01v8_lvt ad=4.3877 pd=30.55 as=4.3877 ps=30.55 w=30.26 l=0.24
X6 S9 G D8 B sky130_fd_pr__nfet_01v8_lvt ad=4.3877 pd=30.55 as=4.3877 ps=30.55 w=30.26 l=0.24
X7 S5 G D4 B sky130_fd_pr__nfet_01v8_lvt ad=4.3877 pd=30.55 as=4.3877 ps=30.55 w=30.26 l=0.24
X8 S7 G D6 B sky130_fd_pr__nfet_01v8_lvt ad=4.3877 pd=30.55 as=4.3877 ps=30.55 w=30.26 l=0.24
X9 a_819_n3026# G S15 B sky130_fd_pr__nfet_01v8_lvt ad=8.7754 pd=61.1 as=4.3877 ps=30.55 w=30.26 l=0.24
X10 D6 G S5 B sky130_fd_pr__nfet_01v8_lvt ad=4.3877 pd=30.55 as=4.3877 ps=30.55 w=30.26 l=0.24
X11 D2 G S1 B sky130_fd_pr__nfet_01v8_lvt ad=4.3877 pd=30.55 as=4.3877 ps=30.55 w=30.26 l=0.24
X12 S13 G D12 B sky130_fd_pr__nfet_01v8_lvt ad=4.3877 pd=30.55 as=4.3877 ps=30.55 w=30.26 l=0.24
X13 S15 G D14 B sky130_fd_pr__nfet_01v8_lvt ad=4.3877 pd=30.55 as=4.3877 ps=30.55 w=30.26 l=0.24
X14 D4 G S3 B sky130_fd_pr__nfet_01v8_lvt ad=4.3877 pd=30.55 as=4.3877 ps=30.55 w=30.26 l=0.24
X15 S11 G D10 B sky130_fd_pr__nfet_01v8_lvt ad=4.3877 pd=30.55 as=4.3877 ps=30.55 w=30.26 l=0.24
.ends

.subckt nfet_01v8_lvt_W484p2_L0p24_m1__nf16_gboth_sdfull_outS S D G B
Xnfet_01v8_lvt_W484p2_L0p24_m1__nf16_gboth_sdfull_outS_pc S D G D D B S S S S S S
+ D D D D S D S sky130_fd_pr__nfet_01v8_lvt_BC2H8C
.ends
