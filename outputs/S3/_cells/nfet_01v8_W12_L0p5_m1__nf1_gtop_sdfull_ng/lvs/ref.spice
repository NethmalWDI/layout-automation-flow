.subckt nfet_01v8_W12_L0p5_m1__nf1_gtop_sdfull_ng D G S B
Xnfet_01v8_W12_L0p5_m1__nf1_gtop_sdfull_ng D G S B sky130_fd_pr__nfet_01v8 L=0.5 W=12 nf=1
.ends
