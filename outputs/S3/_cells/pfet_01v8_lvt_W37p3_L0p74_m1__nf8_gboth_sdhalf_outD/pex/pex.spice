* NGSPICE file created from pfet_01v8_lvt_W37p3_L0p74_m1__nf8_gboth_sdhalf_outD.ext - technology: sky130A

.subckt pfet_01v8_lvt_W37p3_L0p74_m1__nf8_gboth_sdhalf_outD S D G B
X0 D G S B sky130_fd_pr__pfet_01v8_lvt ad=0.6757 pd=4.95 as=0.6757 ps=4.95 w=4.66 l=0.74
X1 D G S B sky130_fd_pr__pfet_01v8_lvt ad=0.6757 pd=4.95 as=0.6757 ps=4.95 w=4.66 l=0.74
X2 S G D B sky130_fd_pr__pfet_01v8_lvt ad=0.6757 pd=4.95 as=0.6757 ps=4.95 w=4.66 l=0.74
X3 D G S B sky130_fd_pr__pfet_01v8_lvt ad=0.6757 pd=4.95 as=0.6757 ps=4.95 w=4.66 l=0.74
X4 S G D B sky130_fd_pr__pfet_01v8_lvt ad=0.6757 pd=4.95 as=1.3514 ps=9.9 w=4.66 l=0.74
X5 D G S B sky130_fd_pr__pfet_01v8_lvt ad=1.3514 pd=9.9 as=0.6757 ps=4.95 w=4.66 l=0.74
X6 S G D B sky130_fd_pr__pfet_01v8_lvt ad=0.6757 pd=4.95 as=0.6757 ps=4.95 w=4.66 l=0.74
X7 S G D B sky130_fd_pr__pfet_01v8_lvt ad=0.6757 pd=4.95 as=0.6757 ps=4.95 w=4.66 l=0.74
C0 G B 2.59892f
C1 B D 0.59531f
C2 G D 1.31201f
C3 B S 0.3225f
C4 G S 1.31294f
C5 D S 1.30609f
C6 S VSUBS 0.17544f
C7 D VSUBS 0.30833f
C8 G VSUBS 0.8188f
C9 B VSUBS 9.18117f
.ends
