* NGSPICE file created from pfet_01v8_lvt_W14p21_L0p89_m1__nf8_gboth_sdfull_outS_ng.ext - technology: sky130A

.subckt pfet_01v8_lvt_W14p21_L0p89_m1__nf8_gboth_sdfull_outS_ng S D G B
X0 D G S B sky130_fd_pr__pfet_01v8_lvt ad=0.2581 pd=2.07 as=0.2581 ps=2.07 w=1.78 l=0.89
X1 S G D B sky130_fd_pr__pfet_01v8_lvt ad=0.5162 pd=4.14 as=0.2581 ps=2.07 w=1.78 l=0.89
X2 D G S B sky130_fd_pr__pfet_01v8_lvt ad=0.2581 pd=2.07 as=0.2581 ps=2.07 w=1.78 l=0.89
X3 S G D B sky130_fd_pr__pfet_01v8_lvt ad=0.2581 pd=2.07 as=0.2581 ps=2.07 w=1.78 l=0.89
X4 D G S B sky130_fd_pr__pfet_01v8_lvt ad=0.2581 pd=2.07 as=0.2581 ps=2.07 w=1.78 l=0.89
X5 S G D B sky130_fd_pr__pfet_01v8_lvt ad=0.2581 pd=2.07 as=0.2581 ps=2.07 w=1.78 l=0.89
X6 D G S B sky130_fd_pr__pfet_01v8_lvt ad=0.2581 pd=2.07 as=0.5162 ps=4.14 w=1.78 l=0.89
X7 S G D B sky130_fd_pr__pfet_01v8_lvt ad=0.2581 pd=2.07 as=0.2581 ps=2.07 w=1.78 l=0.89
C0 G B 1.32884f
C1 B S 0.20359f
C2 G S 1.35355f
C3 B D 0.17497f
C4 G D 1.3435f
C5 S D 1.09974f
C6 D VSUBS 0.32169f
C7 S VSUBS 0.59779f
C8 G VSUBS 2.31386f
C9 B VSUBS 3.36602f
.ends
