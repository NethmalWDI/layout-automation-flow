* NGSPICE file created from pfet_01v8_lvt_W14p21_L0p89_m1__nf8_gboth_sdfull_outS_ng.ext - technology: sky130A

.subckt sky130_fd_pr__pfet_01v8_lvt_AWRWC9 G w_n1009_n278# D6 D4 D2 D0 a_915_n178#
+ S7 S5 S3 S1
X0 S7 G D6 w_n1009_n278# sky130_fd_pr__pfet_01v8_lvt ad=0.2581 pd=2.07 as=0.2581 ps=2.07 w=1.78 l=0.89
X1 a_915_n178# G S7 w_n1009_n278# sky130_fd_pr__pfet_01v8_lvt ad=0.5162 pd=4.14 as=0.2581 ps=2.07 w=1.78 l=0.89
X2 S5 G D4 w_n1009_n278# sky130_fd_pr__pfet_01v8_lvt ad=0.2581 pd=2.07 as=0.2581 ps=2.07 w=1.78 l=0.89
X3 D4 G S3 w_n1009_n278# sky130_fd_pr__pfet_01v8_lvt ad=0.2581 pd=2.07 as=0.2581 ps=2.07 w=1.78 l=0.89
X4 S3 G D2 w_n1009_n278# sky130_fd_pr__pfet_01v8_lvt ad=0.2581 pd=2.07 as=0.2581 ps=2.07 w=1.78 l=0.89
X5 D2 G S1 w_n1009_n278# sky130_fd_pr__pfet_01v8_lvt ad=0.2581 pd=2.07 as=0.2581 ps=2.07 w=1.78 l=0.89
X6 S1 G D0 w_n1009_n278# sky130_fd_pr__pfet_01v8_lvt ad=0.2581 pd=2.07 as=0.5162 ps=4.14 w=1.78 l=0.89
X7 D6 G S5 w_n1009_n278# sky130_fd_pr__pfet_01v8_lvt ad=0.2581 pd=2.07 as=0.2581 ps=2.07 w=1.78 l=0.89
.ends

.subckt pfet_01v8_lvt_W14p21_L0p89_m1__nf8_gboth_sdfull_outS_ng S D G B
Xpfet_01v8_lvt_W14p21_L0p89_m1__nf8_gboth_sdfull_outS_ng_pc G B S S S S S D D D D
+ sky130_fd_pr__pfet_01v8_lvt_AWRWC9
.ends
