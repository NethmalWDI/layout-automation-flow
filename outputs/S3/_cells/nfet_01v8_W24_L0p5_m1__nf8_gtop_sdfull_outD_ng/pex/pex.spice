* NGSPICE file created from nfet_01v8_W24_L0p5_m1__nf8_gtop_sdfull_outD_ng.ext - technology: sky130A

.subckt nfet_01v8_W24_L0p5_m1__nf8_gtop_sdfull_outD_ng S D G B
X0 S G D B sky130_fd_pr__nfet_01v8 ad=0.435 pd=3.29 as=0.435 ps=3.29 w=3 l=0.5
X1 D G S B sky130_fd_pr__nfet_01v8 ad=0.435 pd=3.29 as=0.435 ps=3.29 w=3 l=0.5
X2 D G S B sky130_fd_pr__nfet_01v8 ad=0.435 pd=3.29 as=0.435 ps=3.29 w=3 l=0.5
X3 S G D B sky130_fd_pr__nfet_01v8 ad=0.435 pd=3.29 as=0.435 ps=3.29 w=3 l=0.5
X4 S G D B sky130_fd_pr__nfet_01v8 ad=0.435 pd=3.29 as=0.435 ps=3.29 w=3 l=0.5
X5 S G D B sky130_fd_pr__nfet_01v8 ad=0.435 pd=3.29 as=0.87 ps=6.58 w=3 l=0.5
X6 D G S B sky130_fd_pr__nfet_01v8 ad=0.435 pd=3.29 as=0.435 ps=3.29 w=3 l=0.5
X7 D G S B sky130_fd_pr__nfet_01v8 ad=0.87 pd=6.58 as=0.435 ps=3.29 w=3 l=0.5
C0 D S 1.66099f
C1 G S 1.27106f
C2 G D 1.10001f
C3 S B 0.26482f
C4 D B 0.79164f
C5 G B 1.57854f
.ends
