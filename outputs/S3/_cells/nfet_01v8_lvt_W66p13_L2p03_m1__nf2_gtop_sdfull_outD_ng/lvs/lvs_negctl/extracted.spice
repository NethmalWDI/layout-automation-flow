* NGSPICE file created from nfet_01v8_lvt_W66p13_L2p03_m1__nf2_gtop_sdfull_outD_ng.ext - technology: sky130A

.subckt sky130_fd_pr__nfet_01v8_lvt_2AK5SA a_435_n3338# G D0 S1 VSUBS
X0 a_435_n3338# G S1 VSUBS sky130_fd_pr__nfet_01v8_lvt ad=9.5903 pd=66.72 as=4.79515 ps=33.36 w=33.07 l=2.03
X1 S1 G D0 VSUBS sky130_fd_pr__nfet_01v8_lvt ad=4.79515 pd=33.36 as=9.5903 ps=66.72 w=33.07 l=2.03
.ends

.subckt nfet_01v8_lvt_W66p13_L2p03_m1__nf2_gtop_sdfull_outD_ng S D G B
Xnfet_01v8_lvt_W66p13_L2p03_m1__nf2_gtop_sdfull_outD_ng_pc D G D S B sky130_fd_pr__nfet_01v8_lvt_2AK5SA
.ends
