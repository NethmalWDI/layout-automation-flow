* NGSPICE file created from nfet_01v8_lvt_W5_L20_m2__nf2_gtop_sdhalf_outS_ng.ext - technology: sky130A

.subckt sky130_fd_pr__nfet_01v8_lvt_HAP7TR G D0 a_4029_n281# S1 VSUBS
X0 S1 G D0 VSUBS sky130_fd_pr__nfet_01v8_lvt ad=0.3625 pd=2.79 as=0.725 ps=5.58 w=2.5 l=20
X1 a_4029_n281# G S1 VSUBS sky130_fd_pr__nfet_01v8_lvt ad=0.725 pd=5.58 as=0.3625 ps=2.79 w=2.5 l=20
.ends

.subckt nfet_01v8_lvt_W5_L20_m2__nf2_gtop_sdhalf_outS_ng S D G B
Xnfet_01v8_lvt_W5_L20_m2__nf2_gtop_sdhalf_outS_ng_pc G S S D B sky130_fd_pr__nfet_01v8_lvt_HAP7TR
.ends
