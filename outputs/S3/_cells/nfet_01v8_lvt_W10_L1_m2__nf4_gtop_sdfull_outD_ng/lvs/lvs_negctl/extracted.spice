* NGSPICE file created from nfet_01v8_lvt_W10_L1_m2__nf4_gtop_sdfull_outD_ng.ext - technology: sky130A

.subckt sky130_fd_pr__nfet_01v8_lvt_8VBVAJ G a_487_n281# D2 D0 S3 S1 VSUBS
X0 S3 G D2 VSUBS sky130_fd_pr__nfet_01v8_lvt ad=0.3625 pd=2.79 as=0.3625 ps=2.79 w=2.5 l=1
X1 D2 G S1 VSUBS sky130_fd_pr__nfet_01v8_lvt ad=0.3625 pd=2.79 as=0.3625 ps=2.79 w=2.5 l=1
X2 S1 G D0 VSUBS sky130_fd_pr__nfet_01v8_lvt ad=0.3625 pd=2.79 as=0.725 ps=5.58 w=2.5 l=1
X3 a_487_n281# G S3 VSUBS sky130_fd_pr__nfet_01v8_lvt ad=0.725 pd=5.58 as=0.3625 ps=2.79 w=2.5 l=1
.ends

.subckt nfet_01v8_lvt_W10_L1_m2__nf4_gtop_sdfull_outD_ng S D G B
Xnfet_01v8_lvt_W10_L1_m2__nf4_gtop_sdfull_outD_ng_pc G D D D S S B sky130_fd_pr__nfet_01v8_lvt_8VBVAJ
.ends
