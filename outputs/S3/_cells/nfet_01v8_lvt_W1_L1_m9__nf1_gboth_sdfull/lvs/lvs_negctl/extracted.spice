* NGSPICE file created from nfet_01v8_lvt_W1_L1_m9__nf1_gboth_sdfull.ext - technology: sky130A

.subckt sky130_fd_pr__nfet_01v8_lvt_G6PFY8 G D B S
X0 S G D B sky130_fd_pr__nfet_01v8_lvt ad=0.29 pd=2.58 as=0.29 ps=2.58 w=1 l=1
.ends

.subckt nfet_01v8_lvt_W1_L1_m9__nf1_gboth_sdfull D S G B
Xnfet_01v8_lvt_W1_L1_m9__nf1_gboth_sdfull_pc G D B S sky130_fd_pr__nfet_01v8_lvt_G6PFY8
.ends
