.subckt pfet_01v8_lvt_W90p63_L0p74_m1__nf8_gtop_sdfull_outS D G S B
Xpfet_01v8_lvt_W90p63_L0p74_m1__nf8_gtop_sdfull_outS D G S B sky130_fd_pr__pfet_01v8_lvt L=0.74 W=90.63 nf=8
.ends
