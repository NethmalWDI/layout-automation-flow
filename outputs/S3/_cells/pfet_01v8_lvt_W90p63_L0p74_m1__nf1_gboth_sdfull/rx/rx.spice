* NGSPICE file created from pfet_01v8_lvt_W90p63_L0p74_m1__nf1_gboth_sdfull.ext - technology: sky130A

X0 S pfet_01v8_lvt_W90p63_L0p74_m1__nf1_gboth_sdfull_pc/G.t0 D pfet_01v8_lvt_W90p63_L0p74_m1__nf1_gboth_sdfull_pc/B.t0 sky130_fd_pr__pfet_01v8_lvt ad=26.2827 pd=181.84 as=26.2827 ps=181.84 w=90.63 l=0.74
C0 G B 0.35539f
C1 D B 5.26317f
C2 S B 5.26317f
C3 G D 4.16652f
C4 S G 4.16652f
C5 S D 3.37546f
R0 pfet_01v8_lvt_W90p63_L0p74_m1__nf1_gboth_sdfull_pc/G.n1 pfet_01v8_lvt_W90p63_L0p74_m1__nf1_gboth_sdfull_pc/G.t0 2951.6
R1 pfet_01v8_lvt_W90p63_L0p74_m1__nf1_gboth_sdfull_pc/G.n1 pfet_01v8_lvt_W90p63_L0p74_m1__nf1_gboth_sdfull_pc/G.n0 168.895
R2 pfet_01v8_lvt_W90p63_L0p74_m1__nf1_gboth_sdfull_pc/G.n2 pfet_01v8_lvt_W90p63_L0p74_m1__nf1_gboth_sdfull_pc/G.n1 168.895
R3 G pfet_01v8_lvt_W90p63_L0p74_m1__nf1_gboth_sdfull_pc/G.n0 12.8005
R4 G pfet_01v8_lvt_W90p63_L0p74_m1__nf1_gboth_sdfull_pc/G.n2 12.8005
R5 G pfet_01v8_lvt_W90p63_L0p74_m1__nf1_gboth_sdfull_pc/G.n0 10.2491
R6 pfet_01v8_lvt_W90p63_L0p74_m1__nf1_gboth_sdfull_pc/G.n2 G 10.0534
R7 pfet_01v8_lvt_W90p63_L0p74_m1__nf1_gboth_sdfull_pc/B.n667 pfet_01v8_lvt_W90p63_L0p74_m1__nf1_gboth_sdfull_pc/B.n10 758.823
R8 pfet_01v8_lvt_W90p63_L0p74_m1__nf1_gboth_sdfull_pc/B.n756 pfet_01v8_lvt_W90p63_L0p74_m1__nf1_gboth_sdfull_pc/B.n3 758.823
R9 pfet_01v8_lvt_W90p63_L0p74_m1__nf1_gboth_sdfull_pc/B.n1327 pfet_01v8_lvt_W90p63_L0p74_m1__nf1_gboth_sdfull_pc/B.n6 758.823
R10 pfet_01v8_lvt_W90p63_L0p74_m1__nf1_gboth_sdfull_pc/B.n670 pfet_01v8_lvt_W90p63_L0p74_m1__nf1_gboth_sdfull_pc/B.n8 758.823
R11 pfet_01v8_lvt_W90p63_L0p74_m1__nf1_gboth_sdfull_pc/B.n663 pfet_01v8_lvt_W90p63_L0p74_m1__nf1_gboth_sdfull_pc/B.n661 240
R12 pfet_01v8_lvt_W90p63_L0p74_m1__nf1_gboth_sdfull_pc/B.n659 pfet_01v8_lvt_W90p63_L0p74_m1__nf1_gboth_sdfull_pc/B.n12 240
R13 pfet_01v8_lvt_W90p63_L0p74_m1__nf1_gboth_sdfull_pc/B.n655 pfet_01v8_lvt_W90p63_L0p74_m1__nf1_gboth_sdfull_pc/B.n653 240
R14 pfet_01v8_lvt_W90p63_L0p74_m1__nf1_gboth_sdfull_pc/B.n653 pfet_01v8_lvt_W90p63_L0p74_m1__nf1_gboth_sdfull_pc/B.n652 240
R15 pfet_01v8_lvt_W90p63_L0p74_m1__nf1_gboth_sdfull_pc/B.n649 pfet_01v8_lvt_W90p63_L0p74_m1__nf1_gboth_sdfull_pc/B.n648 240
R16 pfet_01v8_lvt_W90p63_L0p74_m1__nf1_gboth_sdfull_pc/B.n648 pfet_01v8_lvt_W90p63_L0p74_m1__nf1_gboth_sdfull_pc/B.n647 240
R17 pfet_01v8_lvt_W90p63_L0p74_m1__nf1_gboth_sdfull_pc/B.n644 pfet_01v8_lvt_W90p63_L0p74_m1__nf1_gboth_sdfull_pc/B.n643 240
R18 pfet_01v8_lvt_W90p63_L0p74_m1__nf1_gboth_sdfull_pc/B.n643 pfet_01v8_lvt_W90p63_L0p74_m1__nf1_gboth_sdfull_pc/B.n642 240
R19 pfet_01v8_lvt_W90p63_L0p74_m1__nf1_gboth_sdfull_pc/B.n639 pfet_01v8_lvt_W90p63_L0p74_m1__nf1_gboth_sdfull_pc/B.n638 240
R20 pfet_01v8_lvt_W90p63_L0p74_m1__nf1_gboth_sdfull_pc/B.n638 pfet_01v8_lvt_W90p63_L0p74_m1__nf1_gboth_sdfull_pc/B.n637 240
R21 pfet_01v8_lvt_W90p63_L0p74_m1__nf1_gboth_sdfull_pc/B.n634 pfet_01v8_lvt_W90p63_L0p74_m1__nf1_gboth_sdfull_pc/B.n633 240
R22 pfet_01v8_lvt_W90p63_L0p74_m1__nf1_gboth_sdfull_pc/B.n631 pfet_01v8_lvt_W90p63_L0p74_m1__nf1_gboth_sdfull_pc/B.n22 240
R23 pfet_01v8_lvt_W90p63_L0p74_m1__nf1_gboth_sdfull_pc/B.n627 pfet_01v8_lvt_W90p63_L0p74_m1__nf1_gboth_sdfull_pc/B.n625 240
R24 pfet_01v8_lvt_W90p63_L0p74_m1__nf1_gboth_sdfull_pc/B.n625 pfet_01v8_lvt_W90p63_L0p74_m1__nf1_gboth_sdfull_pc/B.n624 240
R25 pfet_01v8_lvt_W90p63_L0p74_m1__nf1_gboth_sdfull_pc/B.n622 pfet_01v8_lvt_W90p63_L0p74_m1__nf1_gboth_sdfull_pc/B.n25 240
R26 pfet_01v8_lvt_W90p63_L0p74_m1__nf1_gboth_sdfull_pc/B.n618 pfet_01v8_lvt_W90p63_L0p74_m1__nf1_gboth_sdfull_pc/B.n616 240
R27 pfet_01v8_lvt_W90p63_L0p74_m1__nf1_gboth_sdfull_pc/B.n614 pfet_01v8_lvt_W90p63_L0p74_m1__nf1_gboth_sdfull_pc/B.n27 240
R28 pfet_01v8_lvt_W90p63_L0p74_m1__nf1_gboth_sdfull_pc/B.n610 pfet_01v8_lvt_W90p63_L0p74_m1__nf1_gboth_sdfull_pc/B.n608 240
R29 pfet_01v8_lvt_W90p63_L0p74_m1__nf1_gboth_sdfull_pc/B.n606 pfet_01v8_lvt_W90p63_L0p74_m1__nf1_gboth_sdfull_pc/B.n29 240
R30 pfet_01v8_lvt_W90p63_L0p74_m1__nf1_gboth_sdfull_pc/B.n602 pfet_01v8_lvt_W90p63_L0p74_m1__nf1_gboth_sdfull_pc/B.n600 240
R31 pfet_01v8_lvt_W90p63_L0p74_m1__nf1_gboth_sdfull_pc/B.n598 pfet_01v8_lvt_W90p63_L0p74_m1__nf1_gboth_sdfull_pc/B.n31 240
R32 pfet_01v8_lvt_W90p63_L0p74_m1__nf1_gboth_sdfull_pc/B.n594 pfet_01v8_lvt_W90p63_L0p74_m1__nf1_gboth_sdfull_pc/B.n31 240
R33 pfet_01v8_lvt_W90p63_L0p74_m1__nf1_gboth_sdfull_pc/B.n592 pfet_01v8_lvt_W90p63_L0p74_m1__nf1_gboth_sdfull_pc/B.n591 240
R34 pfet_01v8_lvt_W90p63_L0p74_m1__nf1_gboth_sdfull_pc/B.n588 pfet_01v8_lvt_W90p63_L0p74_m1__nf1_gboth_sdfull_pc/B.n587 240
R35 pfet_01v8_lvt_W90p63_L0p74_m1__nf1_gboth_sdfull_pc/B.n585 pfet_01v8_lvt_W90p63_L0p74_m1__nf1_gboth_sdfull_pc/B.n35 240
R36 pfet_01v8_lvt_W90p63_L0p74_m1__nf1_gboth_sdfull_pc/B.n581 pfet_01v8_lvt_W90p63_L0p74_m1__nf1_gboth_sdfull_pc/B.n579 240
R37 pfet_01v8_lvt_W90p63_L0p74_m1__nf1_gboth_sdfull_pc/B.n577 pfet_01v8_lvt_W90p63_L0p74_m1__nf1_gboth_sdfull_pc/B.n37 240
R38 pfet_01v8_lvt_W90p63_L0p74_m1__nf1_gboth_sdfull_pc/B.n573 pfet_01v8_lvt_W90p63_L0p74_m1__nf1_gboth_sdfull_pc/B.n571 240
R39 pfet_01v8_lvt_W90p63_L0p74_m1__nf1_gboth_sdfull_pc/B.n571 pfet_01v8_lvt_W90p63_L0p74_m1__nf1_gboth_sdfull_pc/B.n570 240
R40 pfet_01v8_lvt_W90p63_L0p74_m1__nf1_gboth_sdfull_pc/B.n567 pfet_01v8_lvt_W90p63_L0p74_m1__nf1_gboth_sdfull_pc/B.n566 240
R41 pfet_01v8_lvt_W90p63_L0p74_m1__nf1_gboth_sdfull_pc/B.n564 pfet_01v8_lvt_W90p63_L0p74_m1__nf1_gboth_sdfull_pc/B.n41 240
R42 pfet_01v8_lvt_W90p63_L0p74_m1__nf1_gboth_sdfull_pc/B.n560 pfet_01v8_lvt_W90p63_L0p74_m1__nf1_gboth_sdfull_pc/B.n41 240
R43 pfet_01v8_lvt_W90p63_L0p74_m1__nf1_gboth_sdfull_pc/B.n558 pfet_01v8_lvt_W90p63_L0p74_m1__nf1_gboth_sdfull_pc/B.n557 240
R44 pfet_01v8_lvt_W90p63_L0p74_m1__nf1_gboth_sdfull_pc/B.n554 pfet_01v8_lvt_W90p63_L0p74_m1__nf1_gboth_sdfull_pc/B.n553 240
R45 pfet_01v8_lvt_W90p63_L0p74_m1__nf1_gboth_sdfull_pc/B.n553 pfet_01v8_lvt_W90p63_L0p74_m1__nf1_gboth_sdfull_pc/B.n552 240
R46 pfet_01v8_lvt_W90p63_L0p74_m1__nf1_gboth_sdfull_pc/B.n550 pfet_01v8_lvt_W90p63_L0p74_m1__nf1_gboth_sdfull_pc/B.n46 240
R47 pfet_01v8_lvt_W90p63_L0p74_m1__nf1_gboth_sdfull_pc/B.n546 pfet_01v8_lvt_W90p63_L0p74_m1__nf1_gboth_sdfull_pc/B.n544 240
R48 pfet_01v8_lvt_W90p63_L0p74_m1__nf1_gboth_sdfull_pc/B.n544 pfet_01v8_lvt_W90p63_L0p74_m1__nf1_gboth_sdfull_pc/B.n543 240
R49 pfet_01v8_lvt_W90p63_L0p74_m1__nf1_gboth_sdfull_pc/B.n541 pfet_01v8_lvt_W90p63_L0p74_m1__nf1_gboth_sdfull_pc/B.n49 240
R50 pfet_01v8_lvt_W90p63_L0p74_m1__nf1_gboth_sdfull_pc/B.n537 pfet_01v8_lvt_W90p63_L0p74_m1__nf1_gboth_sdfull_pc/B.n535 240
R51 pfet_01v8_lvt_W90p63_L0p74_m1__nf1_gboth_sdfull_pc/B.n535 pfet_01v8_lvt_W90p63_L0p74_m1__nf1_gboth_sdfull_pc/B.n534 240
R52 pfet_01v8_lvt_W90p63_L0p74_m1__nf1_gboth_sdfull_pc/B.n531 pfet_01v8_lvt_W90p63_L0p74_m1__nf1_gboth_sdfull_pc/B.n530 240
R53 pfet_01v8_lvt_W90p63_L0p74_m1__nf1_gboth_sdfull_pc/B.n528 pfet_01v8_lvt_W90p63_L0p74_m1__nf1_gboth_sdfull_pc/B.n53 240
R54 pfet_01v8_lvt_W90p63_L0p74_m1__nf1_gboth_sdfull_pc/B.n524 pfet_01v8_lvt_W90p63_L0p74_m1__nf1_gboth_sdfull_pc/B.n522 240
R55 pfet_01v8_lvt_W90p63_L0p74_m1__nf1_gboth_sdfull_pc/B.n522 pfet_01v8_lvt_W90p63_L0p74_m1__nf1_gboth_sdfull_pc/B.n521 240
R56 pfet_01v8_lvt_W90p63_L0p74_m1__nf1_gboth_sdfull_pc/B.n518 pfet_01v8_lvt_W90p63_L0p74_m1__nf1_gboth_sdfull_pc/B.n517 240
R57 pfet_01v8_lvt_W90p63_L0p74_m1__nf1_gboth_sdfull_pc/B.n517 pfet_01v8_lvt_W90p63_L0p74_m1__nf1_gboth_sdfull_pc/B.n516 240
R58 pfet_01v8_lvt_W90p63_L0p74_m1__nf1_gboth_sdfull_pc/B.n513 pfet_01v8_lvt_W90p63_L0p74_m1__nf1_gboth_sdfull_pc/B.n512 240
R59 pfet_01v8_lvt_W90p63_L0p74_m1__nf1_gboth_sdfull_pc/B.n512 pfet_01v8_lvt_W90p63_L0p74_m1__nf1_gboth_sdfull_pc/B.n511 240
R60 pfet_01v8_lvt_W90p63_L0p74_m1__nf1_gboth_sdfull_pc/B.n508 pfet_01v8_lvt_W90p63_L0p74_m1__nf1_gboth_sdfull_pc/B.n507 240
R61 pfet_01v8_lvt_W90p63_L0p74_m1__nf1_gboth_sdfull_pc/B.n507 pfet_01v8_lvt_W90p63_L0p74_m1__nf1_gboth_sdfull_pc/B.n506 240
R62 pfet_01v8_lvt_W90p63_L0p74_m1__nf1_gboth_sdfull_pc/B.n504 pfet_01v8_lvt_W90p63_L0p74_m1__nf1_gboth_sdfull_pc/B.n62 240
R63 pfet_01v8_lvt_W90p63_L0p74_m1__nf1_gboth_sdfull_pc/B.n500 pfet_01v8_lvt_W90p63_L0p74_m1__nf1_gboth_sdfull_pc/B.n498 240
R64 pfet_01v8_lvt_W90p63_L0p74_m1__nf1_gboth_sdfull_pc/B.n496 pfet_01v8_lvt_W90p63_L0p74_m1__nf1_gboth_sdfull_pc/B.n64 240
R65 pfet_01v8_lvt_W90p63_L0p74_m1__nf1_gboth_sdfull_pc/B.n492 pfet_01v8_lvt_W90p63_L0p74_m1__nf1_gboth_sdfull_pc/B.n490 240
R66 pfet_01v8_lvt_W90p63_L0p74_m1__nf1_gboth_sdfull_pc/B.n488 pfet_01v8_lvt_W90p63_L0p74_m1__nf1_gboth_sdfull_pc/B.n66 240
R67 pfet_01v8_lvt_W90p63_L0p74_m1__nf1_gboth_sdfull_pc/B.n484 pfet_01v8_lvt_W90p63_L0p74_m1__nf1_gboth_sdfull_pc/B.n482 240
R68 pfet_01v8_lvt_W90p63_L0p74_m1__nf1_gboth_sdfull_pc/B.n482 pfet_01v8_lvt_W90p63_L0p74_m1__nf1_gboth_sdfull_pc/B.n481 240
R69 pfet_01v8_lvt_W90p63_L0p74_m1__nf1_gboth_sdfull_pc/B.n478 pfet_01v8_lvt_W90p63_L0p74_m1__nf1_gboth_sdfull_pc/B.n477 240
R70 pfet_01v8_lvt_W90p63_L0p74_m1__nf1_gboth_sdfull_pc/B.n475 pfet_01v8_lvt_W90p63_L0p74_m1__nf1_gboth_sdfull_pc/B.n70 240
R71 pfet_01v8_lvt_W90p63_L0p74_m1__nf1_gboth_sdfull_pc/B.n471 pfet_01v8_lvt_W90p63_L0p74_m1__nf1_gboth_sdfull_pc/B.n70 240
R72 pfet_01v8_lvt_W90p63_L0p74_m1__nf1_gboth_sdfull_pc/B.n469 pfet_01v8_lvt_W90p63_L0p74_m1__nf1_gboth_sdfull_pc/B.n468 240
R73 pfet_01v8_lvt_W90p63_L0p74_m1__nf1_gboth_sdfull_pc/B.n465 pfet_01v8_lvt_W90p63_L0p74_m1__nf1_gboth_sdfull_pc/B.n464 240
R74 pfet_01v8_lvt_W90p63_L0p74_m1__nf1_gboth_sdfull_pc/B.n462 pfet_01v8_lvt_W90p63_L0p74_m1__nf1_gboth_sdfull_pc/B.n74 240
R75 pfet_01v8_lvt_W90p63_L0p74_m1__nf1_gboth_sdfull_pc/B.n458 pfet_01v8_lvt_W90p63_L0p74_m1__nf1_gboth_sdfull_pc/B.n456 240
R76 pfet_01v8_lvt_W90p63_L0p74_m1__nf1_gboth_sdfull_pc/B.n454 pfet_01v8_lvt_W90p63_L0p74_m1__nf1_gboth_sdfull_pc/B.n76 240
R77 pfet_01v8_lvt_W90p63_L0p74_m1__nf1_gboth_sdfull_pc/B.n450 pfet_01v8_lvt_W90p63_L0p74_m1__nf1_gboth_sdfull_pc/B.n76 240
R78 pfet_01v8_lvt_W90p63_L0p74_m1__nf1_gboth_sdfull_pc/B.n448 pfet_01v8_lvt_W90p63_L0p74_m1__nf1_gboth_sdfull_pc/B.n447 240
R79 pfet_01v8_lvt_W90p63_L0p74_m1__nf1_gboth_sdfull_pc/B.n445 pfet_01v8_lvt_W90p63_L0p74_m1__nf1_gboth_sdfull_pc/B.n79 240
R80 pfet_01v8_lvt_W90p63_L0p74_m1__nf1_gboth_sdfull_pc/B.n441 pfet_01v8_lvt_W90p63_L0p74_m1__nf1_gboth_sdfull_pc/B.n439 240
R81 pfet_01v8_lvt_W90p63_L0p74_m1__nf1_gboth_sdfull_pc/B.n437 pfet_01v8_lvt_W90p63_L0p74_m1__nf1_gboth_sdfull_pc/B.n81 240
R82 pfet_01v8_lvt_W90p63_L0p74_m1__nf1_gboth_sdfull_pc/B.n433 pfet_01v8_lvt_W90p63_L0p74_m1__nf1_gboth_sdfull_pc/B.n431 240
R83 pfet_01v8_lvt_W90p63_L0p74_m1__nf1_gboth_sdfull_pc/B.n429 pfet_01v8_lvt_W90p63_L0p74_m1__nf1_gboth_sdfull_pc/B.n83 240
R84 pfet_01v8_lvt_W90p63_L0p74_m1__nf1_gboth_sdfull_pc/B.n425 pfet_01v8_lvt_W90p63_L0p74_m1__nf1_gboth_sdfull_pc/B.n83 240
R85 pfet_01v8_lvt_W90p63_L0p74_m1__nf1_gboth_sdfull_pc/B.n423 pfet_01v8_lvt_W90p63_L0p74_m1__nf1_gboth_sdfull_pc/B.n422 240
R86 pfet_01v8_lvt_W90p63_L0p74_m1__nf1_gboth_sdfull_pc/B.n419 pfet_01v8_lvt_W90p63_L0p74_m1__nf1_gboth_sdfull_pc/B.n418 240
R87 pfet_01v8_lvt_W90p63_L0p74_m1__nf1_gboth_sdfull_pc/B.n418 pfet_01v8_lvt_W90p63_L0p74_m1__nf1_gboth_sdfull_pc/B.n417 240
R88 pfet_01v8_lvt_W90p63_L0p74_m1__nf1_gboth_sdfull_pc/B.n414 pfet_01v8_lvt_W90p63_L0p74_m1__nf1_gboth_sdfull_pc/B.n413 240
R89 pfet_01v8_lvt_W90p63_L0p74_m1__nf1_gboth_sdfull_pc/B.n411 pfet_01v8_lvt_W90p63_L0p74_m1__nf1_gboth_sdfull_pc/B.n89 240
R90 pfet_01v8_lvt_W90p63_L0p74_m1__nf1_gboth_sdfull_pc/B.n407 pfet_01v8_lvt_W90p63_L0p74_m1__nf1_gboth_sdfull_pc/B.n405 240
R91 pfet_01v8_lvt_W90p63_L0p74_m1__nf1_gboth_sdfull_pc/B.n403 pfet_01v8_lvt_W90p63_L0p74_m1__nf1_gboth_sdfull_pc/B.n91 240
R92 pfet_01v8_lvt_W90p63_L0p74_m1__nf1_gboth_sdfull_pc/B.n399 pfet_01v8_lvt_W90p63_L0p74_m1__nf1_gboth_sdfull_pc/B.n397 240
R93 pfet_01v8_lvt_W90p63_L0p74_m1__nf1_gboth_sdfull_pc/B.n395 pfet_01v8_lvt_W90p63_L0p74_m1__nf1_gboth_sdfull_pc/B.n93 240
R94 pfet_01v8_lvt_W90p63_L0p74_m1__nf1_gboth_sdfull_pc/B.n391 pfet_01v8_lvt_W90p63_L0p74_m1__nf1_gboth_sdfull_pc/B.n389 240
R95 pfet_01v8_lvt_W90p63_L0p74_m1__nf1_gboth_sdfull_pc/B.n389 pfet_01v8_lvt_W90p63_L0p74_m1__nf1_gboth_sdfull_pc/B.n388 240
R96 pfet_01v8_lvt_W90p63_L0p74_m1__nf1_gboth_sdfull_pc/B.n385 pfet_01v8_lvt_W90p63_L0p74_m1__nf1_gboth_sdfull_pc/B.n384 240
R97 pfet_01v8_lvt_W90p63_L0p74_m1__nf1_gboth_sdfull_pc/B.n382 pfet_01v8_lvt_W90p63_L0p74_m1__nf1_gboth_sdfull_pc/B.n97 240
R98 pfet_01v8_lvt_W90p63_L0p74_m1__nf1_gboth_sdfull_pc/B.n378 pfet_01v8_lvt_W90p63_L0p74_m1__nf1_gboth_sdfull_pc/B.n376 240
R99 pfet_01v8_lvt_W90p63_L0p74_m1__nf1_gboth_sdfull_pc/B.n374 pfet_01v8_lvt_W90p63_L0p74_m1__nf1_gboth_sdfull_pc/B.n99 240
R100 pfet_01v8_lvt_W90p63_L0p74_m1__nf1_gboth_sdfull_pc/B.n370 pfet_01v8_lvt_W90p63_L0p74_m1__nf1_gboth_sdfull_pc/B.n368 240
R101 pfet_01v8_lvt_W90p63_L0p74_m1__nf1_gboth_sdfull_pc/B.n366 pfet_01v8_lvt_W90p63_L0p74_m1__nf1_gboth_sdfull_pc/B.n101 240
R102 pfet_01v8_lvt_W90p63_L0p74_m1__nf1_gboth_sdfull_pc/B.n362 pfet_01v8_lvt_W90p63_L0p74_m1__nf1_gboth_sdfull_pc/B.n360 240
R103 pfet_01v8_lvt_W90p63_L0p74_m1__nf1_gboth_sdfull_pc/B.n358 pfet_01v8_lvt_W90p63_L0p74_m1__nf1_gboth_sdfull_pc/B.n103 240
R104 pfet_01v8_lvt_W90p63_L0p74_m1__nf1_gboth_sdfull_pc/B.n354 pfet_01v8_lvt_W90p63_L0p74_m1__nf1_gboth_sdfull_pc/B.n352 240
R105 pfet_01v8_lvt_W90p63_L0p74_m1__nf1_gboth_sdfull_pc/B.n350 pfet_01v8_lvt_W90p63_L0p74_m1__nf1_gboth_sdfull_pc/B.n105 240
R106 pfet_01v8_lvt_W90p63_L0p74_m1__nf1_gboth_sdfull_pc/B.n346 pfet_01v8_lvt_W90p63_L0p74_m1__nf1_gboth_sdfull_pc/B.n344 240
R107 pfet_01v8_lvt_W90p63_L0p74_m1__nf1_gboth_sdfull_pc/B.n342 pfet_01v8_lvt_W90p63_L0p74_m1__nf1_gboth_sdfull_pc/B.n107 240
R108 pfet_01v8_lvt_W90p63_L0p74_m1__nf1_gboth_sdfull_pc/B.n338 pfet_01v8_lvt_W90p63_L0p74_m1__nf1_gboth_sdfull_pc/B.n336 240
R109 pfet_01v8_lvt_W90p63_L0p74_m1__nf1_gboth_sdfull_pc/B.n334 pfet_01v8_lvt_W90p63_L0p74_m1__nf1_gboth_sdfull_pc/B.n109 240
R110 pfet_01v8_lvt_W90p63_L0p74_m1__nf1_gboth_sdfull_pc/B.n330 pfet_01v8_lvt_W90p63_L0p74_m1__nf1_gboth_sdfull_pc/B.n109 240
R111 pfet_01v8_lvt_W90p63_L0p74_m1__nf1_gboth_sdfull_pc/B.n328 pfet_01v8_lvt_W90p63_L0p74_m1__nf1_gboth_sdfull_pc/B.n327 240
R112 pfet_01v8_lvt_W90p63_L0p74_m1__nf1_gboth_sdfull_pc/B.n324 pfet_01v8_lvt_W90p63_L0p74_m1__nf1_gboth_sdfull_pc/B.n323 240
R113 pfet_01v8_lvt_W90p63_L0p74_m1__nf1_gboth_sdfull_pc/B.n321 pfet_01v8_lvt_W90p63_L0p74_m1__nf1_gboth_sdfull_pc/B.n113 240
R114 pfet_01v8_lvt_W90p63_L0p74_m1__nf1_gboth_sdfull_pc/B.n317 pfet_01v8_lvt_W90p63_L0p74_m1__nf1_gboth_sdfull_pc/B.n315 240
R115 pfet_01v8_lvt_W90p63_L0p74_m1__nf1_gboth_sdfull_pc/B.n315 pfet_01v8_lvt_W90p63_L0p74_m1__nf1_gboth_sdfull_pc/B.n314 240
R116 pfet_01v8_lvt_W90p63_L0p74_m1__nf1_gboth_sdfull_pc/B.n311 pfet_01v8_lvt_W90p63_L0p74_m1__nf1_gboth_sdfull_pc/B.n310 240
R117 pfet_01v8_lvt_W90p63_L0p74_m1__nf1_gboth_sdfull_pc/B.n308 pfet_01v8_lvt_W90p63_L0p74_m1__nf1_gboth_sdfull_pc/B.n117 240
R118 pfet_01v8_lvt_W90p63_L0p74_m1__nf1_gboth_sdfull_pc/B.n304 pfet_01v8_lvt_W90p63_L0p74_m1__nf1_gboth_sdfull_pc/B.n302 240
R119 pfet_01v8_lvt_W90p63_L0p74_m1__nf1_gboth_sdfull_pc/B.n300 pfet_01v8_lvt_W90p63_L0p74_m1__nf1_gboth_sdfull_pc/B.n119 240
R120 pfet_01v8_lvt_W90p63_L0p74_m1__nf1_gboth_sdfull_pc/B.n296 pfet_01v8_lvt_W90p63_L0p74_m1__nf1_gboth_sdfull_pc/B.n119 240
R121 pfet_01v8_lvt_W90p63_L0p74_m1__nf1_gboth_sdfull_pc/B.n294 pfet_01v8_lvt_W90p63_L0p74_m1__nf1_gboth_sdfull_pc/B.n293 240
R122 pfet_01v8_lvt_W90p63_L0p74_m1__nf1_gboth_sdfull_pc/B.n290 pfet_01v8_lvt_W90p63_L0p74_m1__nf1_gboth_sdfull_pc/B.n289 240
R123 pfet_01v8_lvt_W90p63_L0p74_m1__nf1_gboth_sdfull_pc/B.n289 pfet_01v8_lvt_W90p63_L0p74_m1__nf1_gboth_sdfull_pc/B.n288 240
R124 pfet_01v8_lvt_W90p63_L0p74_m1__nf1_gboth_sdfull_pc/B.n286 pfet_01v8_lvt_W90p63_L0p74_m1__nf1_gboth_sdfull_pc/B.n124 240
R125 pfet_01v8_lvt_W90p63_L0p74_m1__nf1_gboth_sdfull_pc/B.n282 pfet_01v8_lvt_W90p63_L0p74_m1__nf1_gboth_sdfull_pc/B.n280 240
R126 pfet_01v8_lvt_W90p63_L0p74_m1__nf1_gboth_sdfull_pc/B.n278 pfet_01v8_lvt_W90p63_L0p74_m1__nf1_gboth_sdfull_pc/B.n126 240
R127 pfet_01v8_lvt_W90p63_L0p74_m1__nf1_gboth_sdfull_pc/B.n274 pfet_01v8_lvt_W90p63_L0p74_m1__nf1_gboth_sdfull_pc/B.n272 240
R128 pfet_01v8_lvt_W90p63_L0p74_m1__nf1_gboth_sdfull_pc/B.n270 pfet_01v8_lvt_W90p63_L0p74_m1__nf1_gboth_sdfull_pc/B.n128 240
R129 pfet_01v8_lvt_W90p63_L0p74_m1__nf1_gboth_sdfull_pc/B.n266 pfet_01v8_lvt_W90p63_L0p74_m1__nf1_gboth_sdfull_pc/B.n264 240
R130 pfet_01v8_lvt_W90p63_L0p74_m1__nf1_gboth_sdfull_pc/B.n262 pfet_01v8_lvt_W90p63_L0p74_m1__nf1_gboth_sdfull_pc/B.n130 240
R131 pfet_01v8_lvt_W90p63_L0p74_m1__nf1_gboth_sdfull_pc/B.n258 pfet_01v8_lvt_W90p63_L0p74_m1__nf1_gboth_sdfull_pc/B.n256 240
R132 pfet_01v8_lvt_W90p63_L0p74_m1__nf1_gboth_sdfull_pc/B.n254 pfet_01v8_lvt_W90p63_L0p74_m1__nf1_gboth_sdfull_pc/B.n132 240
R133 pfet_01v8_lvt_W90p63_L0p74_m1__nf1_gboth_sdfull_pc/B.n250 pfet_01v8_lvt_W90p63_L0p74_m1__nf1_gboth_sdfull_pc/B.n248 240
R134 pfet_01v8_lvt_W90p63_L0p74_m1__nf1_gboth_sdfull_pc/B.n246 pfet_01v8_lvt_W90p63_L0p74_m1__nf1_gboth_sdfull_pc/B.n134 240
R135 pfet_01v8_lvt_W90p63_L0p74_m1__nf1_gboth_sdfull_pc/B.n242 pfet_01v8_lvt_W90p63_L0p74_m1__nf1_gboth_sdfull_pc/B.n240 240
R136 pfet_01v8_lvt_W90p63_L0p74_m1__nf1_gboth_sdfull_pc/B.n238 pfet_01v8_lvt_W90p63_L0p74_m1__nf1_gboth_sdfull_pc/B.n136 240
R137 pfet_01v8_lvt_W90p63_L0p74_m1__nf1_gboth_sdfull_pc/B.n234 pfet_01v8_lvt_W90p63_L0p74_m1__nf1_gboth_sdfull_pc/B.n232 240
R138 pfet_01v8_lvt_W90p63_L0p74_m1__nf1_gboth_sdfull_pc/B.n230 pfet_01v8_lvt_W90p63_L0p74_m1__nf1_gboth_sdfull_pc/B.n138 240
R139 pfet_01v8_lvt_W90p63_L0p74_m1__nf1_gboth_sdfull_pc/B.n226 pfet_01v8_lvt_W90p63_L0p74_m1__nf1_gboth_sdfull_pc/B.n224 240
R140 pfet_01v8_lvt_W90p63_L0p74_m1__nf1_gboth_sdfull_pc/B.n222 pfet_01v8_lvt_W90p63_L0p74_m1__nf1_gboth_sdfull_pc/B.n140 240
R141 pfet_01v8_lvt_W90p63_L0p74_m1__nf1_gboth_sdfull_pc/B.n218 pfet_01v8_lvt_W90p63_L0p74_m1__nf1_gboth_sdfull_pc/B.n216 240
R142 pfet_01v8_lvt_W90p63_L0p74_m1__nf1_gboth_sdfull_pc/B.n214 pfet_01v8_lvt_W90p63_L0p74_m1__nf1_gboth_sdfull_pc/B.n142 240
R143 pfet_01v8_lvt_W90p63_L0p74_m1__nf1_gboth_sdfull_pc/B.n210 pfet_01v8_lvt_W90p63_L0p74_m1__nf1_gboth_sdfull_pc/B.n208 240
R144 pfet_01v8_lvt_W90p63_L0p74_m1__nf1_gboth_sdfull_pc/B.n208 pfet_01v8_lvt_W90p63_L0p74_m1__nf1_gboth_sdfull_pc/B.n207 240
R145 pfet_01v8_lvt_W90p63_L0p74_m1__nf1_gboth_sdfull_pc/B.n204 pfet_01v8_lvt_W90p63_L0p74_m1__nf1_gboth_sdfull_pc/B.n203 240
R146 pfet_01v8_lvt_W90p63_L0p74_m1__nf1_gboth_sdfull_pc/B.n201 pfet_01v8_lvt_W90p63_L0p74_m1__nf1_gboth_sdfull_pc/B.n146 240
R147 pfet_01v8_lvt_W90p63_L0p74_m1__nf1_gboth_sdfull_pc/B.n197 pfet_01v8_lvt_W90p63_L0p74_m1__nf1_gboth_sdfull_pc/B.n195 240
R148 pfet_01v8_lvt_W90p63_L0p74_m1__nf1_gboth_sdfull_pc/B.n193 pfet_01v8_lvt_W90p63_L0p74_m1__nf1_gboth_sdfull_pc/B.n148 240
R149 pfet_01v8_lvt_W90p63_L0p74_m1__nf1_gboth_sdfull_pc/B.n189 pfet_01v8_lvt_W90p63_L0p74_m1__nf1_gboth_sdfull_pc/B.n187 240
R150 pfet_01v8_lvt_W90p63_L0p74_m1__nf1_gboth_sdfull_pc/B.n185 pfet_01v8_lvt_W90p63_L0p74_m1__nf1_gboth_sdfull_pc/B.n150 240
R151 pfet_01v8_lvt_W90p63_L0p74_m1__nf1_gboth_sdfull_pc/B.n181 pfet_01v8_lvt_W90p63_L0p74_m1__nf1_gboth_sdfull_pc/B.n150 240
R152 pfet_01v8_lvt_W90p63_L0p74_m1__nf1_gboth_sdfull_pc/B.n179 pfet_01v8_lvt_W90p63_L0p74_m1__nf1_gboth_sdfull_pc/B.n178 240
R153 pfet_01v8_lvt_W90p63_L0p74_m1__nf1_gboth_sdfull_pc/B.n175 pfet_01v8_lvt_W90p63_L0p74_m1__nf1_gboth_sdfull_pc/B.n174 240
R154 pfet_01v8_lvt_W90p63_L0p74_m1__nf1_gboth_sdfull_pc/B.n174 pfet_01v8_lvt_W90p63_L0p74_m1__nf1_gboth_sdfull_pc/B.n173 240
R155 pfet_01v8_lvt_W90p63_L0p74_m1__nf1_gboth_sdfull_pc/B.n170 pfet_01v8_lvt_W90p63_L0p74_m1__nf1_gboth_sdfull_pc/B.n169 240
R156 pfet_01v8_lvt_W90p63_L0p74_m1__nf1_gboth_sdfull_pc/B.n169 pfet_01v8_lvt_W90p63_L0p74_m1__nf1_gboth_sdfull_pc/B.n168 240
R157 pfet_01v8_lvt_W90p63_L0p74_m1__nf1_gboth_sdfull_pc/B.n165 pfet_01v8_lvt_W90p63_L0p74_m1__nf1_gboth_sdfull_pc/B.n164 240
R158 pfet_01v8_lvt_W90p63_L0p74_m1__nf1_gboth_sdfull_pc/B.n162 pfet_01v8_lvt_W90p63_L0p74_m1__nf1_gboth_sdfull_pc/B.n159 240
R159 pfet_01v8_lvt_W90p63_L0p74_m1__nf1_gboth_sdfull_pc/B.n1333 pfet_01v8_lvt_W90p63_L0p74_m1__nf1_gboth_sdfull_pc/B.n3 240
R160 pfet_01v8_lvt_W90p63_L0p74_m1__nf1_gboth_sdfull_pc/B.n1333 pfet_01v8_lvt_W90p63_L0p74_m1__nf1_gboth_sdfull_pc/B.n2 240
R161 pfet_01v8_lvt_W90p63_L0p74_m1__nf1_gboth_sdfull_pc/B.n667 pfet_01v8_lvt_W90p63_L0p74_m1__nf1_gboth_sdfull_pc/B.n2 240
R162 pfet_01v8_lvt_W90p63_L0p74_m1__nf1_gboth_sdfull_pc/B.n828 pfet_01v8_lvt_W90p63_L0p74_m1__nf1_gboth_sdfull_pc/B.n756 240
R163 pfet_01v8_lvt_W90p63_L0p74_m1__nf1_gboth_sdfull_pc/B.n832 pfet_01v8_lvt_W90p63_L0p74_m1__nf1_gboth_sdfull_pc/B.n831 240
R164 pfet_01v8_lvt_W90p63_L0p74_m1__nf1_gboth_sdfull_pc/B.n836 pfet_01v8_lvt_W90p63_L0p74_m1__nf1_gboth_sdfull_pc/B.n835 240
R165 pfet_01v8_lvt_W90p63_L0p74_m1__nf1_gboth_sdfull_pc/B.n840 pfet_01v8_lvt_W90p63_L0p74_m1__nf1_gboth_sdfull_pc/B.n839 240
R166 pfet_01v8_lvt_W90p63_L0p74_m1__nf1_gboth_sdfull_pc/B.n844 pfet_01v8_lvt_W90p63_L0p74_m1__nf1_gboth_sdfull_pc/B.n843 240
R167 pfet_01v8_lvt_W90p63_L0p74_m1__nf1_gboth_sdfull_pc/B.n848 pfet_01v8_lvt_W90p63_L0p74_m1__nf1_gboth_sdfull_pc/B.n847 240
R168 pfet_01v8_lvt_W90p63_L0p74_m1__nf1_gboth_sdfull_pc/B.n850 pfet_01v8_lvt_W90p63_L0p74_m1__nf1_gboth_sdfull_pc/B.n751 240
R169 pfet_01v8_lvt_W90p63_L0p74_m1__nf1_gboth_sdfull_pc/B.n853 pfet_01v8_lvt_W90p63_L0p74_m1__nf1_gboth_sdfull_pc/B.n751 240
R170 pfet_01v8_lvt_W90p63_L0p74_m1__nf1_gboth_sdfull_pc/B.n855 pfet_01v8_lvt_W90p63_L0p74_m1__nf1_gboth_sdfull_pc/B.n760 240
R171 pfet_01v8_lvt_W90p63_L0p74_m1__nf1_gboth_sdfull_pc/B.n858 pfet_01v8_lvt_W90p63_L0p74_m1__nf1_gboth_sdfull_pc/B.n760 240
R172 pfet_01v8_lvt_W90p63_L0p74_m1__nf1_gboth_sdfull_pc/B.n862 pfet_01v8_lvt_W90p63_L0p74_m1__nf1_gboth_sdfull_pc/B.n861 240
R173 pfet_01v8_lvt_W90p63_L0p74_m1__nf1_gboth_sdfull_pc/B.n864 pfet_01v8_lvt_W90p63_L0p74_m1__nf1_gboth_sdfull_pc/B.n748 240
R174 pfet_01v8_lvt_W90p63_L0p74_m1__nf1_gboth_sdfull_pc/B.n867 pfet_01v8_lvt_W90p63_L0p74_m1__nf1_gboth_sdfull_pc/B.n748 240
R175 pfet_01v8_lvt_W90p63_L0p74_m1__nf1_gboth_sdfull_pc/B.n871 pfet_01v8_lvt_W90p63_L0p74_m1__nf1_gboth_sdfull_pc/B.n870 240
R176 pfet_01v8_lvt_W90p63_L0p74_m1__nf1_gboth_sdfull_pc/B.n875 pfet_01v8_lvt_W90p63_L0p74_m1__nf1_gboth_sdfull_pc/B.n874 240
R177 pfet_01v8_lvt_W90p63_L0p74_m1__nf1_gboth_sdfull_pc/B.n879 pfet_01v8_lvt_W90p63_L0p74_m1__nf1_gboth_sdfull_pc/B.n878 240
R178 pfet_01v8_lvt_W90p63_L0p74_m1__nf1_gboth_sdfull_pc/B.n883 pfet_01v8_lvt_W90p63_L0p74_m1__nf1_gboth_sdfull_pc/B.n882 240
R179 pfet_01v8_lvt_W90p63_L0p74_m1__nf1_gboth_sdfull_pc/B.n887 pfet_01v8_lvt_W90p63_L0p74_m1__nf1_gboth_sdfull_pc/B.n886 240
R180 pfet_01v8_lvt_W90p63_L0p74_m1__nf1_gboth_sdfull_pc/B.n889 pfet_01v8_lvt_W90p63_L0p74_m1__nf1_gboth_sdfull_pc/B.n765 240
R181 pfet_01v8_lvt_W90p63_L0p74_m1__nf1_gboth_sdfull_pc/B.n892 pfet_01v8_lvt_W90p63_L0p74_m1__nf1_gboth_sdfull_pc/B.n765 240
R182 pfet_01v8_lvt_W90p63_L0p74_m1__nf1_gboth_sdfull_pc/B.n896 pfet_01v8_lvt_W90p63_L0p74_m1__nf1_gboth_sdfull_pc/B.n895 240
R183 pfet_01v8_lvt_W90p63_L0p74_m1__nf1_gboth_sdfull_pc/B.n898 pfet_01v8_lvt_W90p63_L0p74_m1__nf1_gboth_sdfull_pc/B.n744 240
R184 pfet_01v8_lvt_W90p63_L0p74_m1__nf1_gboth_sdfull_pc/B.n901 pfet_01v8_lvt_W90p63_L0p74_m1__nf1_gboth_sdfull_pc/B.n744 240
R185 pfet_01v8_lvt_W90p63_L0p74_m1__nf1_gboth_sdfull_pc/B.n903 pfet_01v8_lvt_W90p63_L0p74_m1__nf1_gboth_sdfull_pc/B.n768 240
R186 pfet_01v8_lvt_W90p63_L0p74_m1__nf1_gboth_sdfull_pc/B.n906 pfet_01v8_lvt_W90p63_L0p74_m1__nf1_gboth_sdfull_pc/B.n768 240
R187 pfet_01v8_lvt_W90p63_L0p74_m1__nf1_gboth_sdfull_pc/B.n910 pfet_01v8_lvt_W90p63_L0p74_m1__nf1_gboth_sdfull_pc/B.n909 240
R188 pfet_01v8_lvt_W90p63_L0p74_m1__nf1_gboth_sdfull_pc/B.n912 pfet_01v8_lvt_W90p63_L0p74_m1__nf1_gboth_sdfull_pc/B.n741 240
R189 pfet_01v8_lvt_W90p63_L0p74_m1__nf1_gboth_sdfull_pc/B.n915 pfet_01v8_lvt_W90p63_L0p74_m1__nf1_gboth_sdfull_pc/B.n741 240
R190 pfet_01v8_lvt_W90p63_L0p74_m1__nf1_gboth_sdfull_pc/B.n917 pfet_01v8_lvt_W90p63_L0p74_m1__nf1_gboth_sdfull_pc/B.n770 240
R191 pfet_01v8_lvt_W90p63_L0p74_m1__nf1_gboth_sdfull_pc/B.n920 pfet_01v8_lvt_W90p63_L0p74_m1__nf1_gboth_sdfull_pc/B.n770 240
R192 pfet_01v8_lvt_W90p63_L0p74_m1__nf1_gboth_sdfull_pc/B.n922 pfet_01v8_lvt_W90p63_L0p74_m1__nf1_gboth_sdfull_pc/B.n739 240
R193 pfet_01v8_lvt_W90p63_L0p74_m1__nf1_gboth_sdfull_pc/B.n925 pfet_01v8_lvt_W90p63_L0p74_m1__nf1_gboth_sdfull_pc/B.n739 240
R194 pfet_01v8_lvt_W90p63_L0p74_m1__nf1_gboth_sdfull_pc/B.n927 pfet_01v8_lvt_W90p63_L0p74_m1__nf1_gboth_sdfull_pc/B.n772 240
R195 pfet_01v8_lvt_W90p63_L0p74_m1__nf1_gboth_sdfull_pc/B.n930 pfet_01v8_lvt_W90p63_L0p74_m1__nf1_gboth_sdfull_pc/B.n772 240
R196 pfet_01v8_lvt_W90p63_L0p74_m1__nf1_gboth_sdfull_pc/B.n934 pfet_01v8_lvt_W90p63_L0p74_m1__nf1_gboth_sdfull_pc/B.n933 240
R197 pfet_01v8_lvt_W90p63_L0p74_m1__nf1_gboth_sdfull_pc/B.n936 pfet_01v8_lvt_W90p63_L0p74_m1__nf1_gboth_sdfull_pc/B.n736 240
R198 pfet_01v8_lvt_W90p63_L0p74_m1__nf1_gboth_sdfull_pc/B.n939 pfet_01v8_lvt_W90p63_L0p74_m1__nf1_gboth_sdfull_pc/B.n736 240
R199 pfet_01v8_lvt_W90p63_L0p74_m1__nf1_gboth_sdfull_pc/B.n943 pfet_01v8_lvt_W90p63_L0p74_m1__nf1_gboth_sdfull_pc/B.n942 240
R200 pfet_01v8_lvt_W90p63_L0p74_m1__nf1_gboth_sdfull_pc/B.n945 pfet_01v8_lvt_W90p63_L0p74_m1__nf1_gboth_sdfull_pc/B.n774 240
R201 pfet_01v8_lvt_W90p63_L0p74_m1__nf1_gboth_sdfull_pc/B.n948 pfet_01v8_lvt_W90p63_L0p74_m1__nf1_gboth_sdfull_pc/B.n774 240
R202 pfet_01v8_lvt_W90p63_L0p74_m1__nf1_gboth_sdfull_pc/B.n950 pfet_01v8_lvt_W90p63_L0p74_m1__nf1_gboth_sdfull_pc/B.n733 240
R203 pfet_01v8_lvt_W90p63_L0p74_m1__nf1_gboth_sdfull_pc/B.n953 pfet_01v8_lvt_W90p63_L0p74_m1__nf1_gboth_sdfull_pc/B.n733 240
R204 pfet_01v8_lvt_W90p63_L0p74_m1__nf1_gboth_sdfull_pc/B.n957 pfet_01v8_lvt_W90p63_L0p74_m1__nf1_gboth_sdfull_pc/B.n956 240
R205 pfet_01v8_lvt_W90p63_L0p74_m1__nf1_gboth_sdfull_pc/B.n959 pfet_01v8_lvt_W90p63_L0p74_m1__nf1_gboth_sdfull_pc/B.n777 240
R206 pfet_01v8_lvt_W90p63_L0p74_m1__nf1_gboth_sdfull_pc/B.n962 pfet_01v8_lvt_W90p63_L0p74_m1__nf1_gboth_sdfull_pc/B.n777 240
R207 pfet_01v8_lvt_W90p63_L0p74_m1__nf1_gboth_sdfull_pc/B.n966 pfet_01v8_lvt_W90p63_L0p74_m1__nf1_gboth_sdfull_pc/B.n965 240
R208 pfet_01v8_lvt_W90p63_L0p74_m1__nf1_gboth_sdfull_pc/B.n970 pfet_01v8_lvt_W90p63_L0p74_m1__nf1_gboth_sdfull_pc/B.n969 240
R209 pfet_01v8_lvt_W90p63_L0p74_m1__nf1_gboth_sdfull_pc/B.n974 pfet_01v8_lvt_W90p63_L0p74_m1__nf1_gboth_sdfull_pc/B.n973 240
R210 pfet_01v8_lvt_W90p63_L0p74_m1__nf1_gboth_sdfull_pc/B.n978 pfet_01v8_lvt_W90p63_L0p74_m1__nf1_gboth_sdfull_pc/B.n977 240
R211 pfet_01v8_lvt_W90p63_L0p74_m1__nf1_gboth_sdfull_pc/B.n982 pfet_01v8_lvt_W90p63_L0p74_m1__nf1_gboth_sdfull_pc/B.n981 240
R212 pfet_01v8_lvt_W90p63_L0p74_m1__nf1_gboth_sdfull_pc/B.n986 pfet_01v8_lvt_W90p63_L0p74_m1__nf1_gboth_sdfull_pc/B.n985 240
R213 pfet_01v8_lvt_W90p63_L0p74_m1__nf1_gboth_sdfull_pc/B.n990 pfet_01v8_lvt_W90p63_L0p74_m1__nf1_gboth_sdfull_pc/B.n989 240
R214 pfet_01v8_lvt_W90p63_L0p74_m1__nf1_gboth_sdfull_pc/B.n994 pfet_01v8_lvt_W90p63_L0p74_m1__nf1_gboth_sdfull_pc/B.n993 240
R215 pfet_01v8_lvt_W90p63_L0p74_m1__nf1_gboth_sdfull_pc/B.n996 pfet_01v8_lvt_W90p63_L0p74_m1__nf1_gboth_sdfull_pc/B.n725 240
R216 pfet_01v8_lvt_W90p63_L0p74_m1__nf1_gboth_sdfull_pc/B.n999 pfet_01v8_lvt_W90p63_L0p74_m1__nf1_gboth_sdfull_pc/B.n725 240
R217 pfet_01v8_lvt_W90p63_L0p74_m1__nf1_gboth_sdfull_pc/B.n1001 pfet_01v8_lvt_W90p63_L0p74_m1__nf1_gboth_sdfull_pc/B.n781 240
R218 pfet_01v8_lvt_W90p63_L0p74_m1__nf1_gboth_sdfull_pc/B.n1004 pfet_01v8_lvt_W90p63_L0p74_m1__nf1_gboth_sdfull_pc/B.n781 240
R219 pfet_01v8_lvt_W90p63_L0p74_m1__nf1_gboth_sdfull_pc/B.n1006 pfet_01v8_lvt_W90p63_L0p74_m1__nf1_gboth_sdfull_pc/B.n723 240
R220 pfet_01v8_lvt_W90p63_L0p74_m1__nf1_gboth_sdfull_pc/B.n1009 pfet_01v8_lvt_W90p63_L0p74_m1__nf1_gboth_sdfull_pc/B.n723 240
R221 pfet_01v8_lvt_W90p63_L0p74_m1__nf1_gboth_sdfull_pc/B.n1011 pfet_01v8_lvt_W90p63_L0p74_m1__nf1_gboth_sdfull_pc/B.n783 240
R222 pfet_01v8_lvt_W90p63_L0p74_m1__nf1_gboth_sdfull_pc/B.n1014 pfet_01v8_lvt_W90p63_L0p74_m1__nf1_gboth_sdfull_pc/B.n783 240
R223 pfet_01v8_lvt_W90p63_L0p74_m1__nf1_gboth_sdfull_pc/B.n1016 pfet_01v8_lvt_W90p63_L0p74_m1__nf1_gboth_sdfull_pc/B.n721 240
R224 pfet_01v8_lvt_W90p63_L0p74_m1__nf1_gboth_sdfull_pc/B.n1019 pfet_01v8_lvt_W90p63_L0p74_m1__nf1_gboth_sdfull_pc/B.n721 240
R225 pfet_01v8_lvt_W90p63_L0p74_m1__nf1_gboth_sdfull_pc/B.n1023 pfet_01v8_lvt_W90p63_L0p74_m1__nf1_gboth_sdfull_pc/B.n1022 240
R226 pfet_01v8_lvt_W90p63_L0p74_m1__nf1_gboth_sdfull_pc/B.n1027 pfet_01v8_lvt_W90p63_L0p74_m1__nf1_gboth_sdfull_pc/B.n1026 240
R227 pfet_01v8_lvt_W90p63_L0p74_m1__nf1_gboth_sdfull_pc/B.n1031 pfet_01v8_lvt_W90p63_L0p74_m1__nf1_gboth_sdfull_pc/B.n1030 240
R228 pfet_01v8_lvt_W90p63_L0p74_m1__nf1_gboth_sdfull_pc/B.n1033 pfet_01v8_lvt_W90p63_L0p74_m1__nf1_gboth_sdfull_pc/B.n787 240
R229 pfet_01v8_lvt_W90p63_L0p74_m1__nf1_gboth_sdfull_pc/B.n1036 pfet_01v8_lvt_W90p63_L0p74_m1__nf1_gboth_sdfull_pc/B.n787 240
R230 pfet_01v8_lvt_W90p63_L0p74_m1__nf1_gboth_sdfull_pc/B.n1040 pfet_01v8_lvt_W90p63_L0p74_m1__nf1_gboth_sdfull_pc/B.n1039 240
R231 pfet_01v8_lvt_W90p63_L0p74_m1__nf1_gboth_sdfull_pc/B.n1044 pfet_01v8_lvt_W90p63_L0p74_m1__nf1_gboth_sdfull_pc/B.n1043 240
R232 pfet_01v8_lvt_W90p63_L0p74_m1__nf1_gboth_sdfull_pc/B.n1048 pfet_01v8_lvt_W90p63_L0p74_m1__nf1_gboth_sdfull_pc/B.n1047 240
R233 pfet_01v8_lvt_W90p63_L0p74_m1__nf1_gboth_sdfull_pc/B.n1052 pfet_01v8_lvt_W90p63_L0p74_m1__nf1_gboth_sdfull_pc/B.n1051 240
R234 pfet_01v8_lvt_W90p63_L0p74_m1__nf1_gboth_sdfull_pc/B.n1056 pfet_01v8_lvt_W90p63_L0p74_m1__nf1_gboth_sdfull_pc/B.n1055 240
R235 pfet_01v8_lvt_W90p63_L0p74_m1__nf1_gboth_sdfull_pc/B.n1058 pfet_01v8_lvt_W90p63_L0p74_m1__nf1_gboth_sdfull_pc/B.n714 240
R236 pfet_01v8_lvt_W90p63_L0p74_m1__nf1_gboth_sdfull_pc/B.n1061 pfet_01v8_lvt_W90p63_L0p74_m1__nf1_gboth_sdfull_pc/B.n714 240
R237 pfet_01v8_lvt_W90p63_L0p74_m1__nf1_gboth_sdfull_pc/B.n1065 pfet_01v8_lvt_W90p63_L0p74_m1__nf1_gboth_sdfull_pc/B.n1064 240
R238 pfet_01v8_lvt_W90p63_L0p74_m1__nf1_gboth_sdfull_pc/B.n1069 pfet_01v8_lvt_W90p63_L0p74_m1__nf1_gboth_sdfull_pc/B.n1068 240
R239 pfet_01v8_lvt_W90p63_L0p74_m1__nf1_gboth_sdfull_pc/B.n1073 pfet_01v8_lvt_W90p63_L0p74_m1__nf1_gboth_sdfull_pc/B.n1072 240
R240 pfet_01v8_lvt_W90p63_L0p74_m1__nf1_gboth_sdfull_pc/B.n1075 pfet_01v8_lvt_W90p63_L0p74_m1__nf1_gboth_sdfull_pc/B.n793 240
R241 pfet_01v8_lvt_W90p63_L0p74_m1__nf1_gboth_sdfull_pc/B.n1078 pfet_01v8_lvt_W90p63_L0p74_m1__nf1_gboth_sdfull_pc/B.n793 240
R242 pfet_01v8_lvt_W90p63_L0p74_m1__nf1_gboth_sdfull_pc/B.n1080 pfet_01v8_lvt_W90p63_L0p74_m1__nf1_gboth_sdfull_pc/B.n712 240
R243 pfet_01v8_lvt_W90p63_L0p74_m1__nf1_gboth_sdfull_pc/B.n1083 pfet_01v8_lvt_W90p63_L0p74_m1__nf1_gboth_sdfull_pc/B.n712 240
R244 pfet_01v8_lvt_W90p63_L0p74_m1__nf1_gboth_sdfull_pc/B.n1085 pfet_01v8_lvt_W90p63_L0p74_m1__nf1_gboth_sdfull_pc/B.n795 240
R245 pfet_01v8_lvt_W90p63_L0p74_m1__nf1_gboth_sdfull_pc/B.n1088 pfet_01v8_lvt_W90p63_L0p74_m1__nf1_gboth_sdfull_pc/B.n795 240
R246 pfet_01v8_lvt_W90p63_L0p74_m1__nf1_gboth_sdfull_pc/B.n1092 pfet_01v8_lvt_W90p63_L0p74_m1__nf1_gboth_sdfull_pc/B.n1091 240
R247 pfet_01v8_lvt_W90p63_L0p74_m1__nf1_gboth_sdfull_pc/B.n1094 pfet_01v8_lvt_W90p63_L0p74_m1__nf1_gboth_sdfull_pc/B.n710 240
R248 pfet_01v8_lvt_W90p63_L0p74_m1__nf1_gboth_sdfull_pc/B.n1097 pfet_01v8_lvt_W90p63_L0p74_m1__nf1_gboth_sdfull_pc/B.n710 240
R249 pfet_01v8_lvt_W90p63_L0p74_m1__nf1_gboth_sdfull_pc/B.n1101 pfet_01v8_lvt_W90p63_L0p74_m1__nf1_gboth_sdfull_pc/B.n1100 240
R250 pfet_01v8_lvt_W90p63_L0p74_m1__nf1_gboth_sdfull_pc/B.n1105 pfet_01v8_lvt_W90p63_L0p74_m1__nf1_gboth_sdfull_pc/B.n1104 240
R251 pfet_01v8_lvt_W90p63_L0p74_m1__nf1_gboth_sdfull_pc/B.n1107 pfet_01v8_lvt_W90p63_L0p74_m1__nf1_gboth_sdfull_pc/B.n800 240
R252 pfet_01v8_lvt_W90p63_L0p74_m1__nf1_gboth_sdfull_pc/B.n1110 pfet_01v8_lvt_W90p63_L0p74_m1__nf1_gboth_sdfull_pc/B.n800 240
R253 pfet_01v8_lvt_W90p63_L0p74_m1__nf1_gboth_sdfull_pc/B.n1114 pfet_01v8_lvt_W90p63_L0p74_m1__nf1_gboth_sdfull_pc/B.n1113 240
R254 pfet_01v8_lvt_W90p63_L0p74_m1__nf1_gboth_sdfull_pc/B.n1118 pfet_01v8_lvt_W90p63_L0p74_m1__nf1_gboth_sdfull_pc/B.n1117 240
R255 pfet_01v8_lvt_W90p63_L0p74_m1__nf1_gboth_sdfull_pc/B.n1120 pfet_01v8_lvt_W90p63_L0p74_m1__nf1_gboth_sdfull_pc/B.n707 240
R256 pfet_01v8_lvt_W90p63_L0p74_m1__nf1_gboth_sdfull_pc/B.n1123 pfet_01v8_lvt_W90p63_L0p74_m1__nf1_gboth_sdfull_pc/B.n707 240
R257 pfet_01v8_lvt_W90p63_L0p74_m1__nf1_gboth_sdfull_pc/B.n1127 pfet_01v8_lvt_W90p63_L0p74_m1__nf1_gboth_sdfull_pc/B.n1126 240
R258 pfet_01v8_lvt_W90p63_L0p74_m1__nf1_gboth_sdfull_pc/B.n1131 pfet_01v8_lvt_W90p63_L0p74_m1__nf1_gboth_sdfull_pc/B.n1130 240
R259 pfet_01v8_lvt_W90p63_L0p74_m1__nf1_gboth_sdfull_pc/B.n1133 pfet_01v8_lvt_W90p63_L0p74_m1__nf1_gboth_sdfull_pc/B.n804 240
R260 pfet_01v8_lvt_W90p63_L0p74_m1__nf1_gboth_sdfull_pc/B.n1136 pfet_01v8_lvt_W90p63_L0p74_m1__nf1_gboth_sdfull_pc/B.n804 240
R261 pfet_01v8_lvt_W90p63_L0p74_m1__nf1_gboth_sdfull_pc/B.n1138 pfet_01v8_lvt_W90p63_L0p74_m1__nf1_gboth_sdfull_pc/B.n704 240
R262 pfet_01v8_lvt_W90p63_L0p74_m1__nf1_gboth_sdfull_pc/B.n1141 pfet_01v8_lvt_W90p63_L0p74_m1__nf1_gboth_sdfull_pc/B.n704 240
R263 pfet_01v8_lvt_W90p63_L0p74_m1__nf1_gboth_sdfull_pc/B.n1145 pfet_01v8_lvt_W90p63_L0p74_m1__nf1_gboth_sdfull_pc/B.n1144 240
R264 pfet_01v8_lvt_W90p63_L0p74_m1__nf1_gboth_sdfull_pc/B.n1149 pfet_01v8_lvt_W90p63_L0p74_m1__nf1_gboth_sdfull_pc/B.n1148 240
R265 pfet_01v8_lvt_W90p63_L0p74_m1__nf1_gboth_sdfull_pc/B.n1153 pfet_01v8_lvt_W90p63_L0p74_m1__nf1_gboth_sdfull_pc/B.n1152 240
R266 pfet_01v8_lvt_W90p63_L0p74_m1__nf1_gboth_sdfull_pc/B.n1155 pfet_01v8_lvt_W90p63_L0p74_m1__nf1_gboth_sdfull_pc/B.n808 240
R267 pfet_01v8_lvt_W90p63_L0p74_m1__nf1_gboth_sdfull_pc/B.n1158 pfet_01v8_lvt_W90p63_L0p74_m1__nf1_gboth_sdfull_pc/B.n808 240
R268 pfet_01v8_lvt_W90p63_L0p74_m1__nf1_gboth_sdfull_pc/B.n1162 pfet_01v8_lvt_W90p63_L0p74_m1__nf1_gboth_sdfull_pc/B.n1161 240
R269 pfet_01v8_lvt_W90p63_L0p74_m1__nf1_gboth_sdfull_pc/B.n1166 pfet_01v8_lvt_W90p63_L0p74_m1__nf1_gboth_sdfull_pc/B.n1165 240
R270 pfet_01v8_lvt_W90p63_L0p74_m1__nf1_gboth_sdfull_pc/B.n1170 pfet_01v8_lvt_W90p63_L0p74_m1__nf1_gboth_sdfull_pc/B.n1169 240
R271 pfet_01v8_lvt_W90p63_L0p74_m1__nf1_gboth_sdfull_pc/B.n1174 pfet_01v8_lvt_W90p63_L0p74_m1__nf1_gboth_sdfull_pc/B.n1173 240
R272 pfet_01v8_lvt_W90p63_L0p74_m1__nf1_gboth_sdfull_pc/B.n1176 pfet_01v8_lvt_W90p63_L0p74_m1__nf1_gboth_sdfull_pc/B.n699 240
R273 pfet_01v8_lvt_W90p63_L0p74_m1__nf1_gboth_sdfull_pc/B.n1179 pfet_01v8_lvt_W90p63_L0p74_m1__nf1_gboth_sdfull_pc/B.n699 240
R274 pfet_01v8_lvt_W90p63_L0p74_m1__nf1_gboth_sdfull_pc/B.n1183 pfet_01v8_lvt_W90p63_L0p74_m1__nf1_gboth_sdfull_pc/B.n1182 240
R275 pfet_01v8_lvt_W90p63_L0p74_m1__nf1_gboth_sdfull_pc/B.n1187 pfet_01v8_lvt_W90p63_L0p74_m1__nf1_gboth_sdfull_pc/B.n1186 240
R276 pfet_01v8_lvt_W90p63_L0p74_m1__nf1_gboth_sdfull_pc/B.n1191 pfet_01v8_lvt_W90p63_L0p74_m1__nf1_gboth_sdfull_pc/B.n1190 240
R277 pfet_01v8_lvt_W90p63_L0p74_m1__nf1_gboth_sdfull_pc/B.n1195 pfet_01v8_lvt_W90p63_L0p74_m1__nf1_gboth_sdfull_pc/B.n1194 240
R278 pfet_01v8_lvt_W90p63_L0p74_m1__nf1_gboth_sdfull_pc/B.n1199 pfet_01v8_lvt_W90p63_L0p74_m1__nf1_gboth_sdfull_pc/B.n1198 240
R279 pfet_01v8_lvt_W90p63_L0p74_m1__nf1_gboth_sdfull_pc/B.n1203 pfet_01v8_lvt_W90p63_L0p74_m1__nf1_gboth_sdfull_pc/B.n1202 240
R280 pfet_01v8_lvt_W90p63_L0p74_m1__nf1_gboth_sdfull_pc/B.n1207 pfet_01v8_lvt_W90p63_L0p74_m1__nf1_gboth_sdfull_pc/B.n1206 240
R281 pfet_01v8_lvt_W90p63_L0p74_m1__nf1_gboth_sdfull_pc/B.n1209 pfet_01v8_lvt_W90p63_L0p74_m1__nf1_gboth_sdfull_pc/B.n816 240
R282 pfet_01v8_lvt_W90p63_L0p74_m1__nf1_gboth_sdfull_pc/B.n1212 pfet_01v8_lvt_W90p63_L0p74_m1__nf1_gboth_sdfull_pc/B.n816 240
R283 pfet_01v8_lvt_W90p63_L0p74_m1__nf1_gboth_sdfull_pc/B.n1216 pfet_01v8_lvt_W90p63_L0p74_m1__nf1_gboth_sdfull_pc/B.n1215 240
R284 pfet_01v8_lvt_W90p63_L0p74_m1__nf1_gboth_sdfull_pc/B.n1220 pfet_01v8_lvt_W90p63_L0p74_m1__nf1_gboth_sdfull_pc/B.n1219 240
R285 pfet_01v8_lvt_W90p63_L0p74_m1__nf1_gboth_sdfull_pc/B.n1224 pfet_01v8_lvt_W90p63_L0p74_m1__nf1_gboth_sdfull_pc/B.n1223 240
R286 pfet_01v8_lvt_W90p63_L0p74_m1__nf1_gboth_sdfull_pc/B.n1228 pfet_01v8_lvt_W90p63_L0p74_m1__nf1_gboth_sdfull_pc/B.n1227 240
R287 pfet_01v8_lvt_W90p63_L0p74_m1__nf1_gboth_sdfull_pc/B.n1232 pfet_01v8_lvt_W90p63_L0p74_m1__nf1_gboth_sdfull_pc/B.n1231 240
R288 pfet_01v8_lvt_W90p63_L0p74_m1__nf1_gboth_sdfull_pc/B.n1236 pfet_01v8_lvt_W90p63_L0p74_m1__nf1_gboth_sdfull_pc/B.n1235 240
R289 pfet_01v8_lvt_W90p63_L0p74_m1__nf1_gboth_sdfull_pc/B.n1240 pfet_01v8_lvt_W90p63_L0p74_m1__nf1_gboth_sdfull_pc/B.n1239 240
R290 pfet_01v8_lvt_W90p63_L0p74_m1__nf1_gboth_sdfull_pc/B.n1244 pfet_01v8_lvt_W90p63_L0p74_m1__nf1_gboth_sdfull_pc/B.n1243 240
R291 pfet_01v8_lvt_W90p63_L0p74_m1__nf1_gboth_sdfull_pc/B.n1248 pfet_01v8_lvt_W90p63_L0p74_m1__nf1_gboth_sdfull_pc/B.n1247 240
R292 pfet_01v8_lvt_W90p63_L0p74_m1__nf1_gboth_sdfull_pc/B.n1252 pfet_01v8_lvt_W90p63_L0p74_m1__nf1_gboth_sdfull_pc/B.n1251 240
R293 pfet_01v8_lvt_W90p63_L0p74_m1__nf1_gboth_sdfull_pc/B.n1256 pfet_01v8_lvt_W90p63_L0p74_m1__nf1_gboth_sdfull_pc/B.n1255 240
R294 pfet_01v8_lvt_W90p63_L0p74_m1__nf1_gboth_sdfull_pc/B.n1260 pfet_01v8_lvt_W90p63_L0p74_m1__nf1_gboth_sdfull_pc/B.n1259 240
R295 pfet_01v8_lvt_W90p63_L0p74_m1__nf1_gboth_sdfull_pc/B.n1264 pfet_01v8_lvt_W90p63_L0p74_m1__nf1_gboth_sdfull_pc/B.n1263 240
R296 pfet_01v8_lvt_W90p63_L0p74_m1__nf1_gboth_sdfull_pc/B.n1268 pfet_01v8_lvt_W90p63_L0p74_m1__nf1_gboth_sdfull_pc/B.n1267 240
R297 pfet_01v8_lvt_W90p63_L0p74_m1__nf1_gboth_sdfull_pc/B.n1272 pfet_01v8_lvt_W90p63_L0p74_m1__nf1_gboth_sdfull_pc/B.n1271 240
R298 pfet_01v8_lvt_W90p63_L0p74_m1__nf1_gboth_sdfull_pc/B.n1276 pfet_01v8_lvt_W90p63_L0p74_m1__nf1_gboth_sdfull_pc/B.n1275 240
R299 pfet_01v8_lvt_W90p63_L0p74_m1__nf1_gboth_sdfull_pc/B.n1280 pfet_01v8_lvt_W90p63_L0p74_m1__nf1_gboth_sdfull_pc/B.n1279 240
R300 pfet_01v8_lvt_W90p63_L0p74_m1__nf1_gboth_sdfull_pc/B.n1284 pfet_01v8_lvt_W90p63_L0p74_m1__nf1_gboth_sdfull_pc/B.n1283 240
R301 pfet_01v8_lvt_W90p63_L0p74_m1__nf1_gboth_sdfull_pc/B.n1288 pfet_01v8_lvt_W90p63_L0p74_m1__nf1_gboth_sdfull_pc/B.n1287 240
R302 pfet_01v8_lvt_W90p63_L0p74_m1__nf1_gboth_sdfull_pc/B.n1292 pfet_01v8_lvt_W90p63_L0p74_m1__nf1_gboth_sdfull_pc/B.n1291 240
R303 pfet_01v8_lvt_W90p63_L0p74_m1__nf1_gboth_sdfull_pc/B.n1296 pfet_01v8_lvt_W90p63_L0p74_m1__nf1_gboth_sdfull_pc/B.n1295 240
R304 pfet_01v8_lvt_W90p63_L0p74_m1__nf1_gboth_sdfull_pc/B.n1300 pfet_01v8_lvt_W90p63_L0p74_m1__nf1_gboth_sdfull_pc/B.n1299 240
R305 pfet_01v8_lvt_W90p63_L0p74_m1__nf1_gboth_sdfull_pc/B.n1304 pfet_01v8_lvt_W90p63_L0p74_m1__nf1_gboth_sdfull_pc/B.n1303 240
R306 pfet_01v8_lvt_W90p63_L0p74_m1__nf1_gboth_sdfull_pc/B.n1308 pfet_01v8_lvt_W90p63_L0p74_m1__nf1_gboth_sdfull_pc/B.n1307 240
R307 pfet_01v8_lvt_W90p63_L0p74_m1__nf1_gboth_sdfull_pc/B.n1312 pfet_01v8_lvt_W90p63_L0p74_m1__nf1_gboth_sdfull_pc/B.n1311 240
R308 pfet_01v8_lvt_W90p63_L0p74_m1__nf1_gboth_sdfull_pc/B.n1314 pfet_01v8_lvt_W90p63_L0p74_m1__nf1_gboth_sdfull_pc/B.n675 240
R309 pfet_01v8_lvt_W90p63_L0p74_m1__nf1_gboth_sdfull_pc/B.n1317 pfet_01v8_lvt_W90p63_L0p74_m1__nf1_gboth_sdfull_pc/B.n675 240
R310 pfet_01v8_lvt_W90p63_L0p74_m1__nf1_gboth_sdfull_pc/B.n1319 pfet_01v8_lvt_W90p63_L0p74_m1__nf1_gboth_sdfull_pc/B.n824 240
R311 pfet_01v8_lvt_W90p63_L0p74_m1__nf1_gboth_sdfull_pc/B.n1323 pfet_01v8_lvt_W90p63_L0p74_m1__nf1_gboth_sdfull_pc/B.n824 240
R312 pfet_01v8_lvt_W90p63_L0p74_m1__nf1_gboth_sdfull_pc/B.n825 pfet_01v8_lvt_W90p63_L0p74_m1__nf1_gboth_sdfull_pc/B.n674 240
R313 pfet_01v8_lvt_W90p63_L0p74_m1__nf1_gboth_sdfull_pc/B.n1331 pfet_01v8_lvt_W90p63_L0p74_m1__nf1_gboth_sdfull_pc/B.n6 240
R314 pfet_01v8_lvt_W90p63_L0p74_m1__nf1_gboth_sdfull_pc/B.n1331 pfet_01v8_lvt_W90p63_L0p74_m1__nf1_gboth_sdfull_pc/B.n5 240
R315 pfet_01v8_lvt_W90p63_L0p74_m1__nf1_gboth_sdfull_pc/B.n670 pfet_01v8_lvt_W90p63_L0p74_m1__nf1_gboth_sdfull_pc/B.n5 240
R316 pfet_01v8_lvt_W90p63_L0p74_m1__nf1_gboth_sdfull_pc/B.n669 pfet_01v8_lvt_W90p63_L0p74_m1__nf1_gboth_sdfull_pc/B.n667 185
R317 pfet_01v8_lvt_W90p63_L0p74_m1__nf1_gboth_sdfull_pc/B.n667 pfet_01v8_lvt_W90p63_L0p74_m1__nf1_gboth_sdfull_pc/B.n666 185
R318 pfet_01v8_lvt_W90p63_L0p74_m1__nf1_gboth_sdfull_pc/B.n668 pfet_01v8_lvt_W90p63_L0p74_m1__nf1_gboth_sdfull_pc/B.n2 185
R319 pfet_01v8_lvt_W90p63_L0p74_m1__nf1_gboth_sdfull_pc/B.n2 pfet_01v8_lvt_W90p63_L0p74_m1__nf1_gboth_sdfull_pc/B.n0 185
R320 pfet_01v8_lvt_W90p63_L0p74_m1__nf1_gboth_sdfull_pc/B.n1333 pfet_01v8_lvt_W90p63_L0p74_m1__nf1_gboth_sdfull_pc/B.n1332 185
R321 pfet_01v8_lvt_W90p63_L0p74_m1__nf1_gboth_sdfull_pc/B.n1334 pfet_01v8_lvt_W90p63_L0p74_m1__nf1_gboth_sdfull_pc/B.n1333 185
R322 pfet_01v8_lvt_W90p63_L0p74_m1__nf1_gboth_sdfull_pc/B.n4 pfet_01v8_lvt_W90p63_L0p74_m1__nf1_gboth_sdfull_pc/B.n3 185
R323 pfet_01v8_lvt_W90p63_L0p74_m1__nf1_gboth_sdfull_pc/B.n3 pfet_01v8_lvt_W90p63_L0p74_m1__nf1_gboth_sdfull_pc/B.n1 185
R324 pfet_01v8_lvt_W90p63_L0p74_m1__nf1_gboth_sdfull_pc/B.n1325 pfet_01v8_lvt_W90p63_L0p74_m1__nf1_gboth_sdfull_pc/B.n756 185
R325 pfet_01v8_lvt_W90p63_L0p74_m1__nf1_gboth_sdfull_pc/B.n827 pfet_01v8_lvt_W90p63_L0p74_m1__nf1_gboth_sdfull_pc/B.n756 185
R326 pfet_01v8_lvt_W90p63_L0p74_m1__nf1_gboth_sdfull_pc/B.n829 pfet_01v8_lvt_W90p63_L0p74_m1__nf1_gboth_sdfull_pc/B.n828 185
R327 pfet_01v8_lvt_W90p63_L0p74_m1__nf1_gboth_sdfull_pc/B.n831 pfet_01v8_lvt_W90p63_L0p74_m1__nf1_gboth_sdfull_pc/B.n830 185
R328 pfet_01v8_lvt_W90p63_L0p74_m1__nf1_gboth_sdfull_pc/B.n833 pfet_01v8_lvt_W90p63_L0p74_m1__nf1_gboth_sdfull_pc/B.n832 185
R329 pfet_01v8_lvt_W90p63_L0p74_m1__nf1_gboth_sdfull_pc/B.n835 pfet_01v8_lvt_W90p63_L0p74_m1__nf1_gboth_sdfull_pc/B.n834 185
R330 pfet_01v8_lvt_W90p63_L0p74_m1__nf1_gboth_sdfull_pc/B.n837 pfet_01v8_lvt_W90p63_L0p74_m1__nf1_gboth_sdfull_pc/B.n836 185
R331 pfet_01v8_lvt_W90p63_L0p74_m1__nf1_gboth_sdfull_pc/B.n839 pfet_01v8_lvt_W90p63_L0p74_m1__nf1_gboth_sdfull_pc/B.n838 185
R332 pfet_01v8_lvt_W90p63_L0p74_m1__nf1_gboth_sdfull_pc/B.n841 pfet_01v8_lvt_W90p63_L0p74_m1__nf1_gboth_sdfull_pc/B.n840 185
R333 pfet_01v8_lvt_W90p63_L0p74_m1__nf1_gboth_sdfull_pc/B.n843 pfet_01v8_lvt_W90p63_L0p74_m1__nf1_gboth_sdfull_pc/B.n842 185
R334 pfet_01v8_lvt_W90p63_L0p74_m1__nf1_gboth_sdfull_pc/B.n845 pfet_01v8_lvt_W90p63_L0p74_m1__nf1_gboth_sdfull_pc/B.n844 185
R335 pfet_01v8_lvt_W90p63_L0p74_m1__nf1_gboth_sdfull_pc/B.n847 pfet_01v8_lvt_W90p63_L0p74_m1__nf1_gboth_sdfull_pc/B.n846 185
R336 pfet_01v8_lvt_W90p63_L0p74_m1__nf1_gboth_sdfull_pc/B.n849 pfet_01v8_lvt_W90p63_L0p74_m1__nf1_gboth_sdfull_pc/B.n848 185
R337 pfet_01v8_lvt_W90p63_L0p74_m1__nf1_gboth_sdfull_pc/B.n851 pfet_01v8_lvt_W90p63_L0p74_m1__nf1_gboth_sdfull_pc/B.n850 185
R338 pfet_01v8_lvt_W90p63_L0p74_m1__nf1_gboth_sdfull_pc/B.n1325 pfet_01v8_lvt_W90p63_L0p74_m1__nf1_gboth_sdfull_pc/B.n751 185
R339 pfet_01v8_lvt_W90p63_L0p74_m1__nf1_gboth_sdfull_pc/B.n852 pfet_01v8_lvt_W90p63_L0p74_m1__nf1_gboth_sdfull_pc/B.n751 185
R340 pfet_01v8_lvt_W90p63_L0p74_m1__nf1_gboth_sdfull_pc/B.n854 pfet_01v8_lvt_W90p63_L0p74_m1__nf1_gboth_sdfull_pc/B.n853 185
R341 pfet_01v8_lvt_W90p63_L0p74_m1__nf1_gboth_sdfull_pc/B.n856 pfet_01v8_lvt_W90p63_L0p74_m1__nf1_gboth_sdfull_pc/B.n855 185
R342 pfet_01v8_lvt_W90p63_L0p74_m1__nf1_gboth_sdfull_pc/B.n1325 pfet_01v8_lvt_W90p63_L0p74_m1__nf1_gboth_sdfull_pc/B.n760 185
R343 pfet_01v8_lvt_W90p63_L0p74_m1__nf1_gboth_sdfull_pc/B.n857 pfet_01v8_lvt_W90p63_L0p74_m1__nf1_gboth_sdfull_pc/B.n760 185
R344 pfet_01v8_lvt_W90p63_L0p74_m1__nf1_gboth_sdfull_pc/B.n859 pfet_01v8_lvt_W90p63_L0p74_m1__nf1_gboth_sdfull_pc/B.n858 185
R345 pfet_01v8_lvt_W90p63_L0p74_m1__nf1_gboth_sdfull_pc/B.n861 pfet_01v8_lvt_W90p63_L0p74_m1__nf1_gboth_sdfull_pc/B.n860 185
R346 pfet_01v8_lvt_W90p63_L0p74_m1__nf1_gboth_sdfull_pc/B.n863 pfet_01v8_lvt_W90p63_L0p74_m1__nf1_gboth_sdfull_pc/B.n862 185
R347 pfet_01v8_lvt_W90p63_L0p74_m1__nf1_gboth_sdfull_pc/B.n865 pfet_01v8_lvt_W90p63_L0p74_m1__nf1_gboth_sdfull_pc/B.n864 185
R348 pfet_01v8_lvt_W90p63_L0p74_m1__nf1_gboth_sdfull_pc/B.n1325 pfet_01v8_lvt_W90p63_L0p74_m1__nf1_gboth_sdfull_pc/B.n748 185
R349 pfet_01v8_lvt_W90p63_L0p74_m1__nf1_gboth_sdfull_pc/B.n866 pfet_01v8_lvt_W90p63_L0p74_m1__nf1_gboth_sdfull_pc/B.n748 185
R350 pfet_01v8_lvt_W90p63_L0p74_m1__nf1_gboth_sdfull_pc/B.n868 pfet_01v8_lvt_W90p63_L0p74_m1__nf1_gboth_sdfull_pc/B.n867 185
R351 pfet_01v8_lvt_W90p63_L0p74_m1__nf1_gboth_sdfull_pc/B.n870 pfet_01v8_lvt_W90p63_L0p74_m1__nf1_gboth_sdfull_pc/B.n869 185
R352 pfet_01v8_lvt_W90p63_L0p74_m1__nf1_gboth_sdfull_pc/B.n872 pfet_01v8_lvt_W90p63_L0p74_m1__nf1_gboth_sdfull_pc/B.n871 185
R353 pfet_01v8_lvt_W90p63_L0p74_m1__nf1_gboth_sdfull_pc/B.n874 pfet_01v8_lvt_W90p63_L0p74_m1__nf1_gboth_sdfull_pc/B.n873 185
R354 pfet_01v8_lvt_W90p63_L0p74_m1__nf1_gboth_sdfull_pc/B.n876 pfet_01v8_lvt_W90p63_L0p74_m1__nf1_gboth_sdfull_pc/B.n875 185
R355 pfet_01v8_lvt_W90p63_L0p74_m1__nf1_gboth_sdfull_pc/B.n878 pfet_01v8_lvt_W90p63_L0p74_m1__nf1_gboth_sdfull_pc/B.n877 185
R356 pfet_01v8_lvt_W90p63_L0p74_m1__nf1_gboth_sdfull_pc/B.n880 pfet_01v8_lvt_W90p63_L0p74_m1__nf1_gboth_sdfull_pc/B.n879 185
R357 pfet_01v8_lvt_W90p63_L0p74_m1__nf1_gboth_sdfull_pc/B.n882 pfet_01v8_lvt_W90p63_L0p74_m1__nf1_gboth_sdfull_pc/B.n881 185
R358 pfet_01v8_lvt_W90p63_L0p74_m1__nf1_gboth_sdfull_pc/B.n884 pfet_01v8_lvt_W90p63_L0p74_m1__nf1_gboth_sdfull_pc/B.n883 185
R359 pfet_01v8_lvt_W90p63_L0p74_m1__nf1_gboth_sdfull_pc/B.n886 pfet_01v8_lvt_W90p63_L0p74_m1__nf1_gboth_sdfull_pc/B.n885 185
R360 pfet_01v8_lvt_W90p63_L0p74_m1__nf1_gboth_sdfull_pc/B.n888 pfet_01v8_lvt_W90p63_L0p74_m1__nf1_gboth_sdfull_pc/B.n887 185
R361 pfet_01v8_lvt_W90p63_L0p74_m1__nf1_gboth_sdfull_pc/B.n890 pfet_01v8_lvt_W90p63_L0p74_m1__nf1_gboth_sdfull_pc/B.n889 185
R362 pfet_01v8_lvt_W90p63_L0p74_m1__nf1_gboth_sdfull_pc/B.n1325 pfet_01v8_lvt_W90p63_L0p74_m1__nf1_gboth_sdfull_pc/B.n765 185
R363 pfet_01v8_lvt_W90p63_L0p74_m1__nf1_gboth_sdfull_pc/B.n891 pfet_01v8_lvt_W90p63_L0p74_m1__nf1_gboth_sdfull_pc/B.n765 185
R364 pfet_01v8_lvt_W90p63_L0p74_m1__nf1_gboth_sdfull_pc/B.n893 pfet_01v8_lvt_W90p63_L0p74_m1__nf1_gboth_sdfull_pc/B.n892 185
R365 pfet_01v8_lvt_W90p63_L0p74_m1__nf1_gboth_sdfull_pc/B.n895 pfet_01v8_lvt_W90p63_L0p74_m1__nf1_gboth_sdfull_pc/B.n894 185
R366 pfet_01v8_lvt_W90p63_L0p74_m1__nf1_gboth_sdfull_pc/B.n897 pfet_01v8_lvt_W90p63_L0p74_m1__nf1_gboth_sdfull_pc/B.n896 185
R367 pfet_01v8_lvt_W90p63_L0p74_m1__nf1_gboth_sdfull_pc/B.n899 pfet_01v8_lvt_W90p63_L0p74_m1__nf1_gboth_sdfull_pc/B.n898 185
R368 pfet_01v8_lvt_W90p63_L0p74_m1__nf1_gboth_sdfull_pc/B.n1325 pfet_01v8_lvt_W90p63_L0p74_m1__nf1_gboth_sdfull_pc/B.n744 185
R369 pfet_01v8_lvt_W90p63_L0p74_m1__nf1_gboth_sdfull_pc/B.n900 pfet_01v8_lvt_W90p63_L0p74_m1__nf1_gboth_sdfull_pc/B.n744 185
R370 pfet_01v8_lvt_W90p63_L0p74_m1__nf1_gboth_sdfull_pc/B.n902 pfet_01v8_lvt_W90p63_L0p74_m1__nf1_gboth_sdfull_pc/B.n901 185
R371 pfet_01v8_lvt_W90p63_L0p74_m1__nf1_gboth_sdfull_pc/B.n904 pfet_01v8_lvt_W90p63_L0p74_m1__nf1_gboth_sdfull_pc/B.n903 185
R372 pfet_01v8_lvt_W90p63_L0p74_m1__nf1_gboth_sdfull_pc/B.n1325 pfet_01v8_lvt_W90p63_L0p74_m1__nf1_gboth_sdfull_pc/B.n768 185
R373 pfet_01v8_lvt_W90p63_L0p74_m1__nf1_gboth_sdfull_pc/B.n905 pfet_01v8_lvt_W90p63_L0p74_m1__nf1_gboth_sdfull_pc/B.n768 185
R374 pfet_01v8_lvt_W90p63_L0p74_m1__nf1_gboth_sdfull_pc/B.n907 pfet_01v8_lvt_W90p63_L0p74_m1__nf1_gboth_sdfull_pc/B.n906 185
R375 pfet_01v8_lvt_W90p63_L0p74_m1__nf1_gboth_sdfull_pc/B.n909 pfet_01v8_lvt_W90p63_L0p74_m1__nf1_gboth_sdfull_pc/B.n908 185
R376 pfet_01v8_lvt_W90p63_L0p74_m1__nf1_gboth_sdfull_pc/B.n911 pfet_01v8_lvt_W90p63_L0p74_m1__nf1_gboth_sdfull_pc/B.n910 185
R377 pfet_01v8_lvt_W90p63_L0p74_m1__nf1_gboth_sdfull_pc/B.n913 pfet_01v8_lvt_W90p63_L0p74_m1__nf1_gboth_sdfull_pc/B.n912 185
R378 pfet_01v8_lvt_W90p63_L0p74_m1__nf1_gboth_sdfull_pc/B.n1325 pfet_01v8_lvt_W90p63_L0p74_m1__nf1_gboth_sdfull_pc/B.n741 185
R379 pfet_01v8_lvt_W90p63_L0p74_m1__nf1_gboth_sdfull_pc/B.n914 pfet_01v8_lvt_W90p63_L0p74_m1__nf1_gboth_sdfull_pc/B.n741 185
R380 pfet_01v8_lvt_W90p63_L0p74_m1__nf1_gboth_sdfull_pc/B.n916 pfet_01v8_lvt_W90p63_L0p74_m1__nf1_gboth_sdfull_pc/B.n915 185
R381 pfet_01v8_lvt_W90p63_L0p74_m1__nf1_gboth_sdfull_pc/B.n918 pfet_01v8_lvt_W90p63_L0p74_m1__nf1_gboth_sdfull_pc/B.n917 185
R382 pfet_01v8_lvt_W90p63_L0p74_m1__nf1_gboth_sdfull_pc/B.n1325 pfet_01v8_lvt_W90p63_L0p74_m1__nf1_gboth_sdfull_pc/B.n770 185
R383 pfet_01v8_lvt_W90p63_L0p74_m1__nf1_gboth_sdfull_pc/B.n919 pfet_01v8_lvt_W90p63_L0p74_m1__nf1_gboth_sdfull_pc/B.n770 185
R384 pfet_01v8_lvt_W90p63_L0p74_m1__nf1_gboth_sdfull_pc/B.n921 pfet_01v8_lvt_W90p63_L0p74_m1__nf1_gboth_sdfull_pc/B.n920 185
R385 pfet_01v8_lvt_W90p63_L0p74_m1__nf1_gboth_sdfull_pc/B.n923 pfet_01v8_lvt_W90p63_L0p74_m1__nf1_gboth_sdfull_pc/B.n922 185
R386 pfet_01v8_lvt_W90p63_L0p74_m1__nf1_gboth_sdfull_pc/B.n1325 pfet_01v8_lvt_W90p63_L0p74_m1__nf1_gboth_sdfull_pc/B.n739 185
R387 pfet_01v8_lvt_W90p63_L0p74_m1__nf1_gboth_sdfull_pc/B.n924 pfet_01v8_lvt_W90p63_L0p74_m1__nf1_gboth_sdfull_pc/B.n739 185
R388 pfet_01v8_lvt_W90p63_L0p74_m1__nf1_gboth_sdfull_pc/B.n926 pfet_01v8_lvt_W90p63_L0p74_m1__nf1_gboth_sdfull_pc/B.n925 185
R389 pfet_01v8_lvt_W90p63_L0p74_m1__nf1_gboth_sdfull_pc/B.n928 pfet_01v8_lvt_W90p63_L0p74_m1__nf1_gboth_sdfull_pc/B.n927 185
R390 pfet_01v8_lvt_W90p63_L0p74_m1__nf1_gboth_sdfull_pc/B.n1325 pfet_01v8_lvt_W90p63_L0p74_m1__nf1_gboth_sdfull_pc/B.n772 185
R391 pfet_01v8_lvt_W90p63_L0p74_m1__nf1_gboth_sdfull_pc/B.n929 pfet_01v8_lvt_W90p63_L0p74_m1__nf1_gboth_sdfull_pc/B.n772 185
R392 pfet_01v8_lvt_W90p63_L0p74_m1__nf1_gboth_sdfull_pc/B.n931 pfet_01v8_lvt_W90p63_L0p74_m1__nf1_gboth_sdfull_pc/B.n930 185
R393 pfet_01v8_lvt_W90p63_L0p74_m1__nf1_gboth_sdfull_pc/B.n933 pfet_01v8_lvt_W90p63_L0p74_m1__nf1_gboth_sdfull_pc/B.n932 185
R394 pfet_01v8_lvt_W90p63_L0p74_m1__nf1_gboth_sdfull_pc/B.n935 pfet_01v8_lvt_W90p63_L0p74_m1__nf1_gboth_sdfull_pc/B.n934 185
R395 pfet_01v8_lvt_W90p63_L0p74_m1__nf1_gboth_sdfull_pc/B.n937 pfet_01v8_lvt_W90p63_L0p74_m1__nf1_gboth_sdfull_pc/B.n936 185
R396 pfet_01v8_lvt_W90p63_L0p74_m1__nf1_gboth_sdfull_pc/B.n1325 pfet_01v8_lvt_W90p63_L0p74_m1__nf1_gboth_sdfull_pc/B.n736 185
R397 pfet_01v8_lvt_W90p63_L0p74_m1__nf1_gboth_sdfull_pc/B.n938 pfet_01v8_lvt_W90p63_L0p74_m1__nf1_gboth_sdfull_pc/B.n736 185
R398 pfet_01v8_lvt_W90p63_L0p74_m1__nf1_gboth_sdfull_pc/B.n940 pfet_01v8_lvt_W90p63_L0p74_m1__nf1_gboth_sdfull_pc/B.n939 185
R399 pfet_01v8_lvt_W90p63_L0p74_m1__nf1_gboth_sdfull_pc/B.n942 pfet_01v8_lvt_W90p63_L0p74_m1__nf1_gboth_sdfull_pc/B.n941 185
R400 pfet_01v8_lvt_W90p63_L0p74_m1__nf1_gboth_sdfull_pc/B.n944 pfet_01v8_lvt_W90p63_L0p74_m1__nf1_gboth_sdfull_pc/B.n943 185
R401 pfet_01v8_lvt_W90p63_L0p74_m1__nf1_gboth_sdfull_pc/B.n946 pfet_01v8_lvt_W90p63_L0p74_m1__nf1_gboth_sdfull_pc/B.n945 185
R402 pfet_01v8_lvt_W90p63_L0p74_m1__nf1_gboth_sdfull_pc/B.n1325 pfet_01v8_lvt_W90p63_L0p74_m1__nf1_gboth_sdfull_pc/B.n774 185
R403 pfet_01v8_lvt_W90p63_L0p74_m1__nf1_gboth_sdfull_pc/B.n947 pfet_01v8_lvt_W90p63_L0p74_m1__nf1_gboth_sdfull_pc/B.n774 185
R404 pfet_01v8_lvt_W90p63_L0p74_m1__nf1_gboth_sdfull_pc/B.n949 pfet_01v8_lvt_W90p63_L0p74_m1__nf1_gboth_sdfull_pc/B.n948 185
R405 pfet_01v8_lvt_W90p63_L0p74_m1__nf1_gboth_sdfull_pc/B.n951 pfet_01v8_lvt_W90p63_L0p74_m1__nf1_gboth_sdfull_pc/B.n950 185
R406 pfet_01v8_lvt_W90p63_L0p74_m1__nf1_gboth_sdfull_pc/B.n1325 pfet_01v8_lvt_W90p63_L0p74_m1__nf1_gboth_sdfull_pc/B.n733 185
R407 pfet_01v8_lvt_W90p63_L0p74_m1__nf1_gboth_sdfull_pc/B.n952 pfet_01v8_lvt_W90p63_L0p74_m1__nf1_gboth_sdfull_pc/B.n733 185
R408 pfet_01v8_lvt_W90p63_L0p74_m1__nf1_gboth_sdfull_pc/B.n954 pfet_01v8_lvt_W90p63_L0p74_m1__nf1_gboth_sdfull_pc/B.n953 185
R409 pfet_01v8_lvt_W90p63_L0p74_m1__nf1_gboth_sdfull_pc/B.n956 pfet_01v8_lvt_W90p63_L0p74_m1__nf1_gboth_sdfull_pc/B.n955 185
R410 pfet_01v8_lvt_W90p63_L0p74_m1__nf1_gboth_sdfull_pc/B.n958 pfet_01v8_lvt_W90p63_L0p74_m1__nf1_gboth_sdfull_pc/B.n957 185
R411 pfet_01v8_lvt_W90p63_L0p74_m1__nf1_gboth_sdfull_pc/B.n960 pfet_01v8_lvt_W90p63_L0p74_m1__nf1_gboth_sdfull_pc/B.n959 185
R412 pfet_01v8_lvt_W90p63_L0p74_m1__nf1_gboth_sdfull_pc/B.n1325 pfet_01v8_lvt_W90p63_L0p74_m1__nf1_gboth_sdfull_pc/B.n777 185
R413 pfet_01v8_lvt_W90p63_L0p74_m1__nf1_gboth_sdfull_pc/B.n961 pfet_01v8_lvt_W90p63_L0p74_m1__nf1_gboth_sdfull_pc/B.n777 185
R414 pfet_01v8_lvt_W90p63_L0p74_m1__nf1_gboth_sdfull_pc/B.n963 pfet_01v8_lvt_W90p63_L0p74_m1__nf1_gboth_sdfull_pc/B.n962 185
R415 pfet_01v8_lvt_W90p63_L0p74_m1__nf1_gboth_sdfull_pc/B.n965 pfet_01v8_lvt_W90p63_L0p74_m1__nf1_gboth_sdfull_pc/B.n964 185
R416 pfet_01v8_lvt_W90p63_L0p74_m1__nf1_gboth_sdfull_pc/B.n967 pfet_01v8_lvt_W90p63_L0p74_m1__nf1_gboth_sdfull_pc/B.n966 185
R417 pfet_01v8_lvt_W90p63_L0p74_m1__nf1_gboth_sdfull_pc/B.n969 pfet_01v8_lvt_W90p63_L0p74_m1__nf1_gboth_sdfull_pc/B.n968 185
R418 pfet_01v8_lvt_W90p63_L0p74_m1__nf1_gboth_sdfull_pc/B.n971 pfet_01v8_lvt_W90p63_L0p74_m1__nf1_gboth_sdfull_pc/B.n970 185
R419 pfet_01v8_lvt_W90p63_L0p74_m1__nf1_gboth_sdfull_pc/B.n973 pfet_01v8_lvt_W90p63_L0p74_m1__nf1_gboth_sdfull_pc/B.n972 185
R420 pfet_01v8_lvt_W90p63_L0p74_m1__nf1_gboth_sdfull_pc/B.n975 pfet_01v8_lvt_W90p63_L0p74_m1__nf1_gboth_sdfull_pc/B.n974 185
R421 pfet_01v8_lvt_W90p63_L0p74_m1__nf1_gboth_sdfull_pc/B.n977 pfet_01v8_lvt_W90p63_L0p74_m1__nf1_gboth_sdfull_pc/B.n976 185
R422 pfet_01v8_lvt_W90p63_L0p74_m1__nf1_gboth_sdfull_pc/B.n979 pfet_01v8_lvt_W90p63_L0p74_m1__nf1_gboth_sdfull_pc/B.n978 185
R423 pfet_01v8_lvt_W90p63_L0p74_m1__nf1_gboth_sdfull_pc/B.n981 pfet_01v8_lvt_W90p63_L0p74_m1__nf1_gboth_sdfull_pc/B.n980 185
R424 pfet_01v8_lvt_W90p63_L0p74_m1__nf1_gboth_sdfull_pc/B.n983 pfet_01v8_lvt_W90p63_L0p74_m1__nf1_gboth_sdfull_pc/B.n982 185
R425 pfet_01v8_lvt_W90p63_L0p74_m1__nf1_gboth_sdfull_pc/B.n985 pfet_01v8_lvt_W90p63_L0p74_m1__nf1_gboth_sdfull_pc/B.n984 185
R426 pfet_01v8_lvt_W90p63_L0p74_m1__nf1_gboth_sdfull_pc/B.n987 pfet_01v8_lvt_W90p63_L0p74_m1__nf1_gboth_sdfull_pc/B.n986 185
R427 pfet_01v8_lvt_W90p63_L0p74_m1__nf1_gboth_sdfull_pc/B.n989 pfet_01v8_lvt_W90p63_L0p74_m1__nf1_gboth_sdfull_pc/B.n988 185
R428 pfet_01v8_lvt_W90p63_L0p74_m1__nf1_gboth_sdfull_pc/B.n991 pfet_01v8_lvt_W90p63_L0p74_m1__nf1_gboth_sdfull_pc/B.n990 185
R429 pfet_01v8_lvt_W90p63_L0p74_m1__nf1_gboth_sdfull_pc/B.n993 pfet_01v8_lvt_W90p63_L0p74_m1__nf1_gboth_sdfull_pc/B.n992 185
R430 pfet_01v8_lvt_W90p63_L0p74_m1__nf1_gboth_sdfull_pc/B.n995 pfet_01v8_lvt_W90p63_L0p74_m1__nf1_gboth_sdfull_pc/B.n994 185
R431 pfet_01v8_lvt_W90p63_L0p74_m1__nf1_gboth_sdfull_pc/B.n997 pfet_01v8_lvt_W90p63_L0p74_m1__nf1_gboth_sdfull_pc/B.n996 185
R432 pfet_01v8_lvt_W90p63_L0p74_m1__nf1_gboth_sdfull_pc/B.n1325 pfet_01v8_lvt_W90p63_L0p74_m1__nf1_gboth_sdfull_pc/B.n725 185
R433 pfet_01v8_lvt_W90p63_L0p74_m1__nf1_gboth_sdfull_pc/B.n998 pfet_01v8_lvt_W90p63_L0p74_m1__nf1_gboth_sdfull_pc/B.n725 185
R434 pfet_01v8_lvt_W90p63_L0p74_m1__nf1_gboth_sdfull_pc/B.n1000 pfet_01v8_lvt_W90p63_L0p74_m1__nf1_gboth_sdfull_pc/B.n999 185
R435 pfet_01v8_lvt_W90p63_L0p74_m1__nf1_gboth_sdfull_pc/B.n1002 pfet_01v8_lvt_W90p63_L0p74_m1__nf1_gboth_sdfull_pc/B.n1001 185
R436 pfet_01v8_lvt_W90p63_L0p74_m1__nf1_gboth_sdfull_pc/B.n1325 pfet_01v8_lvt_W90p63_L0p74_m1__nf1_gboth_sdfull_pc/B.n781 185
R437 pfet_01v8_lvt_W90p63_L0p74_m1__nf1_gboth_sdfull_pc/B.n1003 pfet_01v8_lvt_W90p63_L0p74_m1__nf1_gboth_sdfull_pc/B.n781 185
R438 pfet_01v8_lvt_W90p63_L0p74_m1__nf1_gboth_sdfull_pc/B.n1005 pfet_01v8_lvt_W90p63_L0p74_m1__nf1_gboth_sdfull_pc/B.n1004 185
R439 pfet_01v8_lvt_W90p63_L0p74_m1__nf1_gboth_sdfull_pc/B.n1007 pfet_01v8_lvt_W90p63_L0p74_m1__nf1_gboth_sdfull_pc/B.n1006 185
R440 pfet_01v8_lvt_W90p63_L0p74_m1__nf1_gboth_sdfull_pc/B.n1325 pfet_01v8_lvt_W90p63_L0p74_m1__nf1_gboth_sdfull_pc/B.n723 185
R441 pfet_01v8_lvt_W90p63_L0p74_m1__nf1_gboth_sdfull_pc/B.n1008 pfet_01v8_lvt_W90p63_L0p74_m1__nf1_gboth_sdfull_pc/B.n723 185
R442 pfet_01v8_lvt_W90p63_L0p74_m1__nf1_gboth_sdfull_pc/B.n1010 pfet_01v8_lvt_W90p63_L0p74_m1__nf1_gboth_sdfull_pc/B.n1009 185
R443 pfet_01v8_lvt_W90p63_L0p74_m1__nf1_gboth_sdfull_pc/B.n1012 pfet_01v8_lvt_W90p63_L0p74_m1__nf1_gboth_sdfull_pc/B.n1011 185
R444 pfet_01v8_lvt_W90p63_L0p74_m1__nf1_gboth_sdfull_pc/B.n1325 pfet_01v8_lvt_W90p63_L0p74_m1__nf1_gboth_sdfull_pc/B.n783 185
R445 pfet_01v8_lvt_W90p63_L0p74_m1__nf1_gboth_sdfull_pc/B.n1013 pfet_01v8_lvt_W90p63_L0p74_m1__nf1_gboth_sdfull_pc/B.n783 185
R446 pfet_01v8_lvt_W90p63_L0p74_m1__nf1_gboth_sdfull_pc/B.n1015 pfet_01v8_lvt_W90p63_L0p74_m1__nf1_gboth_sdfull_pc/B.n1014 185
R447 pfet_01v8_lvt_W90p63_L0p74_m1__nf1_gboth_sdfull_pc/B.n1017 pfet_01v8_lvt_W90p63_L0p74_m1__nf1_gboth_sdfull_pc/B.n1016 185
R448 pfet_01v8_lvt_W90p63_L0p74_m1__nf1_gboth_sdfull_pc/B.n1325 pfet_01v8_lvt_W90p63_L0p74_m1__nf1_gboth_sdfull_pc/B.n721 185
R449 pfet_01v8_lvt_W90p63_L0p74_m1__nf1_gboth_sdfull_pc/B.n1018 pfet_01v8_lvt_W90p63_L0p74_m1__nf1_gboth_sdfull_pc/B.n721 185
R450 pfet_01v8_lvt_W90p63_L0p74_m1__nf1_gboth_sdfull_pc/B.n1020 pfet_01v8_lvt_W90p63_L0p74_m1__nf1_gboth_sdfull_pc/B.n1019 185
R451 pfet_01v8_lvt_W90p63_L0p74_m1__nf1_gboth_sdfull_pc/B.n1022 pfet_01v8_lvt_W90p63_L0p74_m1__nf1_gboth_sdfull_pc/B.n1021 185
R452 pfet_01v8_lvt_W90p63_L0p74_m1__nf1_gboth_sdfull_pc/B.n1024 pfet_01v8_lvt_W90p63_L0p74_m1__nf1_gboth_sdfull_pc/B.n1023 185
R453 pfet_01v8_lvt_W90p63_L0p74_m1__nf1_gboth_sdfull_pc/B.n1026 pfet_01v8_lvt_W90p63_L0p74_m1__nf1_gboth_sdfull_pc/B.n1025 185
R454 pfet_01v8_lvt_W90p63_L0p74_m1__nf1_gboth_sdfull_pc/B.n1028 pfet_01v8_lvt_W90p63_L0p74_m1__nf1_gboth_sdfull_pc/B.n1027 185
R455 pfet_01v8_lvt_W90p63_L0p74_m1__nf1_gboth_sdfull_pc/B.n1030 pfet_01v8_lvt_W90p63_L0p74_m1__nf1_gboth_sdfull_pc/B.n1029 185
R456 pfet_01v8_lvt_W90p63_L0p74_m1__nf1_gboth_sdfull_pc/B.n1032 pfet_01v8_lvt_W90p63_L0p74_m1__nf1_gboth_sdfull_pc/B.n1031 185
R457 pfet_01v8_lvt_W90p63_L0p74_m1__nf1_gboth_sdfull_pc/B.n1034 pfet_01v8_lvt_W90p63_L0p74_m1__nf1_gboth_sdfull_pc/B.n1033 185
R458 pfet_01v8_lvt_W90p63_L0p74_m1__nf1_gboth_sdfull_pc/B.n1325 pfet_01v8_lvt_W90p63_L0p74_m1__nf1_gboth_sdfull_pc/B.n787 185
R459 pfet_01v8_lvt_W90p63_L0p74_m1__nf1_gboth_sdfull_pc/B.n1035 pfet_01v8_lvt_W90p63_L0p74_m1__nf1_gboth_sdfull_pc/B.n787 185
R460 pfet_01v8_lvt_W90p63_L0p74_m1__nf1_gboth_sdfull_pc/B.n1037 pfet_01v8_lvt_W90p63_L0p74_m1__nf1_gboth_sdfull_pc/B.n1036 185
R461 pfet_01v8_lvt_W90p63_L0p74_m1__nf1_gboth_sdfull_pc/B.n1039 pfet_01v8_lvt_W90p63_L0p74_m1__nf1_gboth_sdfull_pc/B.n1038 185
R462 pfet_01v8_lvt_W90p63_L0p74_m1__nf1_gboth_sdfull_pc/B.n1041 pfet_01v8_lvt_W90p63_L0p74_m1__nf1_gboth_sdfull_pc/B.n1040 185
R463 pfet_01v8_lvt_W90p63_L0p74_m1__nf1_gboth_sdfull_pc/B.n1043 pfet_01v8_lvt_W90p63_L0p74_m1__nf1_gboth_sdfull_pc/B.n1042 185
R464 pfet_01v8_lvt_W90p63_L0p74_m1__nf1_gboth_sdfull_pc/B.n1045 pfet_01v8_lvt_W90p63_L0p74_m1__nf1_gboth_sdfull_pc/B.n1044 185
R465 pfet_01v8_lvt_W90p63_L0p74_m1__nf1_gboth_sdfull_pc/B.n1047 pfet_01v8_lvt_W90p63_L0p74_m1__nf1_gboth_sdfull_pc/B.n1046 185
R466 pfet_01v8_lvt_W90p63_L0p74_m1__nf1_gboth_sdfull_pc/B.n1049 pfet_01v8_lvt_W90p63_L0p74_m1__nf1_gboth_sdfull_pc/B.n1048 185
R467 pfet_01v8_lvt_W90p63_L0p74_m1__nf1_gboth_sdfull_pc/B.n1051 pfet_01v8_lvt_W90p63_L0p74_m1__nf1_gboth_sdfull_pc/B.n1050 185
R468 pfet_01v8_lvt_W90p63_L0p74_m1__nf1_gboth_sdfull_pc/B.n1053 pfet_01v8_lvt_W90p63_L0p74_m1__nf1_gboth_sdfull_pc/B.n1052 185
R469 pfet_01v8_lvt_W90p63_L0p74_m1__nf1_gboth_sdfull_pc/B.n1055 pfet_01v8_lvt_W90p63_L0p74_m1__nf1_gboth_sdfull_pc/B.n1054 185
R470 pfet_01v8_lvt_W90p63_L0p74_m1__nf1_gboth_sdfull_pc/B.n1057 pfet_01v8_lvt_W90p63_L0p74_m1__nf1_gboth_sdfull_pc/B.n1056 185
R471 pfet_01v8_lvt_W90p63_L0p74_m1__nf1_gboth_sdfull_pc/B.n1059 pfet_01v8_lvt_W90p63_L0p74_m1__nf1_gboth_sdfull_pc/B.n1058 185
R472 pfet_01v8_lvt_W90p63_L0p74_m1__nf1_gboth_sdfull_pc/B.n1325 pfet_01v8_lvt_W90p63_L0p74_m1__nf1_gboth_sdfull_pc/B.n714 185
R473 pfet_01v8_lvt_W90p63_L0p74_m1__nf1_gboth_sdfull_pc/B.n1060 pfet_01v8_lvt_W90p63_L0p74_m1__nf1_gboth_sdfull_pc/B.n714 185
R474 pfet_01v8_lvt_W90p63_L0p74_m1__nf1_gboth_sdfull_pc/B.n1062 pfet_01v8_lvt_W90p63_L0p74_m1__nf1_gboth_sdfull_pc/B.n1061 185
R475 pfet_01v8_lvt_W90p63_L0p74_m1__nf1_gboth_sdfull_pc/B.n1064 pfet_01v8_lvt_W90p63_L0p74_m1__nf1_gboth_sdfull_pc/B.n1063 185
R476 pfet_01v8_lvt_W90p63_L0p74_m1__nf1_gboth_sdfull_pc/B.n1066 pfet_01v8_lvt_W90p63_L0p74_m1__nf1_gboth_sdfull_pc/B.n1065 185
R477 pfet_01v8_lvt_W90p63_L0p74_m1__nf1_gboth_sdfull_pc/B.n1068 pfet_01v8_lvt_W90p63_L0p74_m1__nf1_gboth_sdfull_pc/B.n1067 185
R478 pfet_01v8_lvt_W90p63_L0p74_m1__nf1_gboth_sdfull_pc/B.n1070 pfet_01v8_lvt_W90p63_L0p74_m1__nf1_gboth_sdfull_pc/B.n1069 185
R479 pfet_01v8_lvt_W90p63_L0p74_m1__nf1_gboth_sdfull_pc/B.n1072 pfet_01v8_lvt_W90p63_L0p74_m1__nf1_gboth_sdfull_pc/B.n1071 185
R480 pfet_01v8_lvt_W90p63_L0p74_m1__nf1_gboth_sdfull_pc/B.n1074 pfet_01v8_lvt_W90p63_L0p74_m1__nf1_gboth_sdfull_pc/B.n1073 185
R481 pfet_01v8_lvt_W90p63_L0p74_m1__nf1_gboth_sdfull_pc/B.n1076 pfet_01v8_lvt_W90p63_L0p74_m1__nf1_gboth_sdfull_pc/B.n1075 185
R482 pfet_01v8_lvt_W90p63_L0p74_m1__nf1_gboth_sdfull_pc/B.n1325 pfet_01v8_lvt_W90p63_L0p74_m1__nf1_gboth_sdfull_pc/B.n793 185
R483 pfet_01v8_lvt_W90p63_L0p74_m1__nf1_gboth_sdfull_pc/B.n1077 pfet_01v8_lvt_W90p63_L0p74_m1__nf1_gboth_sdfull_pc/B.n793 185
R484 pfet_01v8_lvt_W90p63_L0p74_m1__nf1_gboth_sdfull_pc/B.n1079 pfet_01v8_lvt_W90p63_L0p74_m1__nf1_gboth_sdfull_pc/B.n1078 185
R485 pfet_01v8_lvt_W90p63_L0p74_m1__nf1_gboth_sdfull_pc/B.n1081 pfet_01v8_lvt_W90p63_L0p74_m1__nf1_gboth_sdfull_pc/B.n1080 185
R486 pfet_01v8_lvt_W90p63_L0p74_m1__nf1_gboth_sdfull_pc/B.n1325 pfet_01v8_lvt_W90p63_L0p74_m1__nf1_gboth_sdfull_pc/B.n712 185
R487 pfet_01v8_lvt_W90p63_L0p74_m1__nf1_gboth_sdfull_pc/B.n1082 pfet_01v8_lvt_W90p63_L0p74_m1__nf1_gboth_sdfull_pc/B.n712 185
R488 pfet_01v8_lvt_W90p63_L0p74_m1__nf1_gboth_sdfull_pc/B.n1084 pfet_01v8_lvt_W90p63_L0p74_m1__nf1_gboth_sdfull_pc/B.n1083 185
R489 pfet_01v8_lvt_W90p63_L0p74_m1__nf1_gboth_sdfull_pc/B.n1086 pfet_01v8_lvt_W90p63_L0p74_m1__nf1_gboth_sdfull_pc/B.n1085 185
R490 pfet_01v8_lvt_W90p63_L0p74_m1__nf1_gboth_sdfull_pc/B.n1325 pfet_01v8_lvt_W90p63_L0p74_m1__nf1_gboth_sdfull_pc/B.n795 185
R491 pfet_01v8_lvt_W90p63_L0p74_m1__nf1_gboth_sdfull_pc/B.n1087 pfet_01v8_lvt_W90p63_L0p74_m1__nf1_gboth_sdfull_pc/B.n795 185
R492 pfet_01v8_lvt_W90p63_L0p74_m1__nf1_gboth_sdfull_pc/B.n1089 pfet_01v8_lvt_W90p63_L0p74_m1__nf1_gboth_sdfull_pc/B.n1088 185
R493 pfet_01v8_lvt_W90p63_L0p74_m1__nf1_gboth_sdfull_pc/B.n1091 pfet_01v8_lvt_W90p63_L0p74_m1__nf1_gboth_sdfull_pc/B.n1090 185
R494 pfet_01v8_lvt_W90p63_L0p74_m1__nf1_gboth_sdfull_pc/B.n1093 pfet_01v8_lvt_W90p63_L0p74_m1__nf1_gboth_sdfull_pc/B.n1092 185
R495 pfet_01v8_lvt_W90p63_L0p74_m1__nf1_gboth_sdfull_pc/B.n1095 pfet_01v8_lvt_W90p63_L0p74_m1__nf1_gboth_sdfull_pc/B.n1094 185
R496 pfet_01v8_lvt_W90p63_L0p74_m1__nf1_gboth_sdfull_pc/B.n1325 pfet_01v8_lvt_W90p63_L0p74_m1__nf1_gboth_sdfull_pc/B.n710 185
R497 pfet_01v8_lvt_W90p63_L0p74_m1__nf1_gboth_sdfull_pc/B.n1096 pfet_01v8_lvt_W90p63_L0p74_m1__nf1_gboth_sdfull_pc/B.n710 185
R498 pfet_01v8_lvt_W90p63_L0p74_m1__nf1_gboth_sdfull_pc/B.n1098 pfet_01v8_lvt_W90p63_L0p74_m1__nf1_gboth_sdfull_pc/B.n1097 185
R499 pfet_01v8_lvt_W90p63_L0p74_m1__nf1_gboth_sdfull_pc/B.n1100 pfet_01v8_lvt_W90p63_L0p74_m1__nf1_gboth_sdfull_pc/B.n1099 185
R500 pfet_01v8_lvt_W90p63_L0p74_m1__nf1_gboth_sdfull_pc/B.n1102 pfet_01v8_lvt_W90p63_L0p74_m1__nf1_gboth_sdfull_pc/B.n1101 185
R501 pfet_01v8_lvt_W90p63_L0p74_m1__nf1_gboth_sdfull_pc/B.n1104 pfet_01v8_lvt_W90p63_L0p74_m1__nf1_gboth_sdfull_pc/B.n1103 185
R502 pfet_01v8_lvt_W90p63_L0p74_m1__nf1_gboth_sdfull_pc/B.n1106 pfet_01v8_lvt_W90p63_L0p74_m1__nf1_gboth_sdfull_pc/B.n1105 185
R503 pfet_01v8_lvt_W90p63_L0p74_m1__nf1_gboth_sdfull_pc/B.n1108 pfet_01v8_lvt_W90p63_L0p74_m1__nf1_gboth_sdfull_pc/B.n1107 185
R504 pfet_01v8_lvt_W90p63_L0p74_m1__nf1_gboth_sdfull_pc/B.n1325 pfet_01v8_lvt_W90p63_L0p74_m1__nf1_gboth_sdfull_pc/B.n800 185
R505 pfet_01v8_lvt_W90p63_L0p74_m1__nf1_gboth_sdfull_pc/B.n1109 pfet_01v8_lvt_W90p63_L0p74_m1__nf1_gboth_sdfull_pc/B.n800 185
R506 pfet_01v8_lvt_W90p63_L0p74_m1__nf1_gboth_sdfull_pc/B.n1111 pfet_01v8_lvt_W90p63_L0p74_m1__nf1_gboth_sdfull_pc/B.n1110 185
R507 pfet_01v8_lvt_W90p63_L0p74_m1__nf1_gboth_sdfull_pc/B.n1113 pfet_01v8_lvt_W90p63_L0p74_m1__nf1_gboth_sdfull_pc/B.n1112 185
R508 pfet_01v8_lvt_W90p63_L0p74_m1__nf1_gboth_sdfull_pc/B.n1115 pfet_01v8_lvt_W90p63_L0p74_m1__nf1_gboth_sdfull_pc/B.n1114 185
R509 pfet_01v8_lvt_W90p63_L0p74_m1__nf1_gboth_sdfull_pc/B.n1117 pfet_01v8_lvt_W90p63_L0p74_m1__nf1_gboth_sdfull_pc/B.n1116 185
R510 pfet_01v8_lvt_W90p63_L0p74_m1__nf1_gboth_sdfull_pc/B.n1119 pfet_01v8_lvt_W90p63_L0p74_m1__nf1_gboth_sdfull_pc/B.n1118 185
R511 pfet_01v8_lvt_W90p63_L0p74_m1__nf1_gboth_sdfull_pc/B.n1121 pfet_01v8_lvt_W90p63_L0p74_m1__nf1_gboth_sdfull_pc/B.n1120 185
R512 pfet_01v8_lvt_W90p63_L0p74_m1__nf1_gboth_sdfull_pc/B.n1325 pfet_01v8_lvt_W90p63_L0p74_m1__nf1_gboth_sdfull_pc/B.n707 185
R513 pfet_01v8_lvt_W90p63_L0p74_m1__nf1_gboth_sdfull_pc/B.n1122 pfet_01v8_lvt_W90p63_L0p74_m1__nf1_gboth_sdfull_pc/B.n707 185
R514 pfet_01v8_lvt_W90p63_L0p74_m1__nf1_gboth_sdfull_pc/B.n1124 pfet_01v8_lvt_W90p63_L0p74_m1__nf1_gboth_sdfull_pc/B.n1123 185
R515 pfet_01v8_lvt_W90p63_L0p74_m1__nf1_gboth_sdfull_pc/B.n1126 pfet_01v8_lvt_W90p63_L0p74_m1__nf1_gboth_sdfull_pc/B.n1125 185
R516 pfet_01v8_lvt_W90p63_L0p74_m1__nf1_gboth_sdfull_pc/B.n1128 pfet_01v8_lvt_W90p63_L0p74_m1__nf1_gboth_sdfull_pc/B.n1127 185
R517 pfet_01v8_lvt_W90p63_L0p74_m1__nf1_gboth_sdfull_pc/B.n1130 pfet_01v8_lvt_W90p63_L0p74_m1__nf1_gboth_sdfull_pc/B.n1129 185
R518 pfet_01v8_lvt_W90p63_L0p74_m1__nf1_gboth_sdfull_pc/B.n1132 pfet_01v8_lvt_W90p63_L0p74_m1__nf1_gboth_sdfull_pc/B.n1131 185
R519 pfet_01v8_lvt_W90p63_L0p74_m1__nf1_gboth_sdfull_pc/B.n1134 pfet_01v8_lvt_W90p63_L0p74_m1__nf1_gboth_sdfull_pc/B.n1133 185
R520 pfet_01v8_lvt_W90p63_L0p74_m1__nf1_gboth_sdfull_pc/B.n1325 pfet_01v8_lvt_W90p63_L0p74_m1__nf1_gboth_sdfull_pc/B.n804 185
R521 pfet_01v8_lvt_W90p63_L0p74_m1__nf1_gboth_sdfull_pc/B.n1135 pfet_01v8_lvt_W90p63_L0p74_m1__nf1_gboth_sdfull_pc/B.n804 185
R522 pfet_01v8_lvt_W90p63_L0p74_m1__nf1_gboth_sdfull_pc/B.n1137 pfet_01v8_lvt_W90p63_L0p74_m1__nf1_gboth_sdfull_pc/B.n1136 185
R523 pfet_01v8_lvt_W90p63_L0p74_m1__nf1_gboth_sdfull_pc/B.n1139 pfet_01v8_lvt_W90p63_L0p74_m1__nf1_gboth_sdfull_pc/B.n1138 185
R524 pfet_01v8_lvt_W90p63_L0p74_m1__nf1_gboth_sdfull_pc/B.n1325 pfet_01v8_lvt_W90p63_L0p74_m1__nf1_gboth_sdfull_pc/B.n704 185
R525 pfet_01v8_lvt_W90p63_L0p74_m1__nf1_gboth_sdfull_pc/B.n1140 pfet_01v8_lvt_W90p63_L0p74_m1__nf1_gboth_sdfull_pc/B.n704 185
R526 pfet_01v8_lvt_W90p63_L0p74_m1__nf1_gboth_sdfull_pc/B.n1142 pfet_01v8_lvt_W90p63_L0p74_m1__nf1_gboth_sdfull_pc/B.n1141 185
R527 pfet_01v8_lvt_W90p63_L0p74_m1__nf1_gboth_sdfull_pc/B.n1144 pfet_01v8_lvt_W90p63_L0p74_m1__nf1_gboth_sdfull_pc/B.n1143 185
R528 pfet_01v8_lvt_W90p63_L0p74_m1__nf1_gboth_sdfull_pc/B.n1146 pfet_01v8_lvt_W90p63_L0p74_m1__nf1_gboth_sdfull_pc/B.n1145 185
R529 pfet_01v8_lvt_W90p63_L0p74_m1__nf1_gboth_sdfull_pc/B.n1148 pfet_01v8_lvt_W90p63_L0p74_m1__nf1_gboth_sdfull_pc/B.n1147 185
R530 pfet_01v8_lvt_W90p63_L0p74_m1__nf1_gboth_sdfull_pc/B.n1150 pfet_01v8_lvt_W90p63_L0p74_m1__nf1_gboth_sdfull_pc/B.n1149 185
R531 pfet_01v8_lvt_W90p63_L0p74_m1__nf1_gboth_sdfull_pc/B.n1152 pfet_01v8_lvt_W90p63_L0p74_m1__nf1_gboth_sdfull_pc/B.n1151 185
R532 pfet_01v8_lvt_W90p63_L0p74_m1__nf1_gboth_sdfull_pc/B.n1154 pfet_01v8_lvt_W90p63_L0p74_m1__nf1_gboth_sdfull_pc/B.n1153 185
R533 pfet_01v8_lvt_W90p63_L0p74_m1__nf1_gboth_sdfull_pc/B.n1156 pfet_01v8_lvt_W90p63_L0p74_m1__nf1_gboth_sdfull_pc/B.n1155 185
R534 pfet_01v8_lvt_W90p63_L0p74_m1__nf1_gboth_sdfull_pc/B.n1325 pfet_01v8_lvt_W90p63_L0p74_m1__nf1_gboth_sdfull_pc/B.n808 185
R535 pfet_01v8_lvt_W90p63_L0p74_m1__nf1_gboth_sdfull_pc/B.n1157 pfet_01v8_lvt_W90p63_L0p74_m1__nf1_gboth_sdfull_pc/B.n808 185
R536 pfet_01v8_lvt_W90p63_L0p74_m1__nf1_gboth_sdfull_pc/B.n1159 pfet_01v8_lvt_W90p63_L0p74_m1__nf1_gboth_sdfull_pc/B.n1158 185
R537 pfet_01v8_lvt_W90p63_L0p74_m1__nf1_gboth_sdfull_pc/B.n1161 pfet_01v8_lvt_W90p63_L0p74_m1__nf1_gboth_sdfull_pc/B.n1160 185
R538 pfet_01v8_lvt_W90p63_L0p74_m1__nf1_gboth_sdfull_pc/B.n1163 pfet_01v8_lvt_W90p63_L0p74_m1__nf1_gboth_sdfull_pc/B.n1162 185
R539 pfet_01v8_lvt_W90p63_L0p74_m1__nf1_gboth_sdfull_pc/B.n1165 pfet_01v8_lvt_W90p63_L0p74_m1__nf1_gboth_sdfull_pc/B.n1164 185
R540 pfet_01v8_lvt_W90p63_L0p74_m1__nf1_gboth_sdfull_pc/B.n1167 pfet_01v8_lvt_W90p63_L0p74_m1__nf1_gboth_sdfull_pc/B.n1166 185
R541 pfet_01v8_lvt_W90p63_L0p74_m1__nf1_gboth_sdfull_pc/B.n1169 pfet_01v8_lvt_W90p63_L0p74_m1__nf1_gboth_sdfull_pc/B.n1168 185
R542 pfet_01v8_lvt_W90p63_L0p74_m1__nf1_gboth_sdfull_pc/B.n1171 pfet_01v8_lvt_W90p63_L0p74_m1__nf1_gboth_sdfull_pc/B.n1170 185
R543 pfet_01v8_lvt_W90p63_L0p74_m1__nf1_gboth_sdfull_pc/B.n1173 pfet_01v8_lvt_W90p63_L0p74_m1__nf1_gboth_sdfull_pc/B.n1172 185
R544 pfet_01v8_lvt_W90p63_L0p74_m1__nf1_gboth_sdfull_pc/B.n1175 pfet_01v8_lvt_W90p63_L0p74_m1__nf1_gboth_sdfull_pc/B.n1174 185
R545 pfet_01v8_lvt_W90p63_L0p74_m1__nf1_gboth_sdfull_pc/B.n1177 pfet_01v8_lvt_W90p63_L0p74_m1__nf1_gboth_sdfull_pc/B.n1176 185
R546 pfet_01v8_lvt_W90p63_L0p74_m1__nf1_gboth_sdfull_pc/B.n1325 pfet_01v8_lvt_W90p63_L0p74_m1__nf1_gboth_sdfull_pc/B.n699 185
R547 pfet_01v8_lvt_W90p63_L0p74_m1__nf1_gboth_sdfull_pc/B.n1178 pfet_01v8_lvt_W90p63_L0p74_m1__nf1_gboth_sdfull_pc/B.n699 185
R548 pfet_01v8_lvt_W90p63_L0p74_m1__nf1_gboth_sdfull_pc/B.n1180 pfet_01v8_lvt_W90p63_L0p74_m1__nf1_gboth_sdfull_pc/B.n1179 185
R549 pfet_01v8_lvt_W90p63_L0p74_m1__nf1_gboth_sdfull_pc/B.n1182 pfet_01v8_lvt_W90p63_L0p74_m1__nf1_gboth_sdfull_pc/B.n1181 185
R550 pfet_01v8_lvt_W90p63_L0p74_m1__nf1_gboth_sdfull_pc/B.n1184 pfet_01v8_lvt_W90p63_L0p74_m1__nf1_gboth_sdfull_pc/B.n1183 185
R551 pfet_01v8_lvt_W90p63_L0p74_m1__nf1_gboth_sdfull_pc/B.n1186 pfet_01v8_lvt_W90p63_L0p74_m1__nf1_gboth_sdfull_pc/B.n1185 185
R552 pfet_01v8_lvt_W90p63_L0p74_m1__nf1_gboth_sdfull_pc/B.n1188 pfet_01v8_lvt_W90p63_L0p74_m1__nf1_gboth_sdfull_pc/B.n1187 185
R553 pfet_01v8_lvt_W90p63_L0p74_m1__nf1_gboth_sdfull_pc/B.n1190 pfet_01v8_lvt_W90p63_L0p74_m1__nf1_gboth_sdfull_pc/B.n1189 185
R554 pfet_01v8_lvt_W90p63_L0p74_m1__nf1_gboth_sdfull_pc/B.n1192 pfet_01v8_lvt_W90p63_L0p74_m1__nf1_gboth_sdfull_pc/B.n1191 185
R555 pfet_01v8_lvt_W90p63_L0p74_m1__nf1_gboth_sdfull_pc/B.n1194 pfet_01v8_lvt_W90p63_L0p74_m1__nf1_gboth_sdfull_pc/B.n1193 185
R556 pfet_01v8_lvt_W90p63_L0p74_m1__nf1_gboth_sdfull_pc/B.n1196 pfet_01v8_lvt_W90p63_L0p74_m1__nf1_gboth_sdfull_pc/B.n1195 185
R557 pfet_01v8_lvt_W90p63_L0p74_m1__nf1_gboth_sdfull_pc/B.n1198 pfet_01v8_lvt_W90p63_L0p74_m1__nf1_gboth_sdfull_pc/B.n1197 185
R558 pfet_01v8_lvt_W90p63_L0p74_m1__nf1_gboth_sdfull_pc/B.n1200 pfet_01v8_lvt_W90p63_L0p74_m1__nf1_gboth_sdfull_pc/B.n1199 185
R559 pfet_01v8_lvt_W90p63_L0p74_m1__nf1_gboth_sdfull_pc/B.n1202 pfet_01v8_lvt_W90p63_L0p74_m1__nf1_gboth_sdfull_pc/B.n1201 185
R560 pfet_01v8_lvt_W90p63_L0p74_m1__nf1_gboth_sdfull_pc/B.n1204 pfet_01v8_lvt_W90p63_L0p74_m1__nf1_gboth_sdfull_pc/B.n1203 185
R561 pfet_01v8_lvt_W90p63_L0p74_m1__nf1_gboth_sdfull_pc/B.n1206 pfet_01v8_lvt_W90p63_L0p74_m1__nf1_gboth_sdfull_pc/B.n1205 185
R562 pfet_01v8_lvt_W90p63_L0p74_m1__nf1_gboth_sdfull_pc/B.n1208 pfet_01v8_lvt_W90p63_L0p74_m1__nf1_gboth_sdfull_pc/B.n1207 185
R563 pfet_01v8_lvt_W90p63_L0p74_m1__nf1_gboth_sdfull_pc/B.n1210 pfet_01v8_lvt_W90p63_L0p74_m1__nf1_gboth_sdfull_pc/B.n1209 185
R564 pfet_01v8_lvt_W90p63_L0p74_m1__nf1_gboth_sdfull_pc/B.n1325 pfet_01v8_lvt_W90p63_L0p74_m1__nf1_gboth_sdfull_pc/B.n816 185
R565 pfet_01v8_lvt_W90p63_L0p74_m1__nf1_gboth_sdfull_pc/B.n1211 pfet_01v8_lvt_W90p63_L0p74_m1__nf1_gboth_sdfull_pc/B.n816 185
R566 pfet_01v8_lvt_W90p63_L0p74_m1__nf1_gboth_sdfull_pc/B.n1213 pfet_01v8_lvt_W90p63_L0p74_m1__nf1_gboth_sdfull_pc/B.n1212 185
R567 pfet_01v8_lvt_W90p63_L0p74_m1__nf1_gboth_sdfull_pc/B.n1215 pfet_01v8_lvt_W90p63_L0p74_m1__nf1_gboth_sdfull_pc/B.n1214 185
R568 pfet_01v8_lvt_W90p63_L0p74_m1__nf1_gboth_sdfull_pc/B.n1217 pfet_01v8_lvt_W90p63_L0p74_m1__nf1_gboth_sdfull_pc/B.n1216 185
R569 pfet_01v8_lvt_W90p63_L0p74_m1__nf1_gboth_sdfull_pc/B.n1219 pfet_01v8_lvt_W90p63_L0p74_m1__nf1_gboth_sdfull_pc/B.n1218 185
R570 pfet_01v8_lvt_W90p63_L0p74_m1__nf1_gboth_sdfull_pc/B.n1221 pfet_01v8_lvt_W90p63_L0p74_m1__nf1_gboth_sdfull_pc/B.n1220 185
R571 pfet_01v8_lvt_W90p63_L0p74_m1__nf1_gboth_sdfull_pc/B.n1223 pfet_01v8_lvt_W90p63_L0p74_m1__nf1_gboth_sdfull_pc/B.n1222 185
R572 pfet_01v8_lvt_W90p63_L0p74_m1__nf1_gboth_sdfull_pc/B.n1225 pfet_01v8_lvt_W90p63_L0p74_m1__nf1_gboth_sdfull_pc/B.n1224 185
R573 pfet_01v8_lvt_W90p63_L0p74_m1__nf1_gboth_sdfull_pc/B.n1227 pfet_01v8_lvt_W90p63_L0p74_m1__nf1_gboth_sdfull_pc/B.n1226 185
R574 pfet_01v8_lvt_W90p63_L0p74_m1__nf1_gboth_sdfull_pc/B.n1229 pfet_01v8_lvt_W90p63_L0p74_m1__nf1_gboth_sdfull_pc/B.n1228 185
R575 pfet_01v8_lvt_W90p63_L0p74_m1__nf1_gboth_sdfull_pc/B.n1231 pfet_01v8_lvt_W90p63_L0p74_m1__nf1_gboth_sdfull_pc/B.n1230 185
R576 pfet_01v8_lvt_W90p63_L0p74_m1__nf1_gboth_sdfull_pc/B.n1233 pfet_01v8_lvt_W90p63_L0p74_m1__nf1_gboth_sdfull_pc/B.n1232 185
R577 pfet_01v8_lvt_W90p63_L0p74_m1__nf1_gboth_sdfull_pc/B.n1235 pfet_01v8_lvt_W90p63_L0p74_m1__nf1_gboth_sdfull_pc/B.n1234 185
R578 pfet_01v8_lvt_W90p63_L0p74_m1__nf1_gboth_sdfull_pc/B.n1237 pfet_01v8_lvt_W90p63_L0p74_m1__nf1_gboth_sdfull_pc/B.n1236 185
R579 pfet_01v8_lvt_W90p63_L0p74_m1__nf1_gboth_sdfull_pc/B.n1239 pfet_01v8_lvt_W90p63_L0p74_m1__nf1_gboth_sdfull_pc/B.n1238 185
R580 pfet_01v8_lvt_W90p63_L0p74_m1__nf1_gboth_sdfull_pc/B.n1241 pfet_01v8_lvt_W90p63_L0p74_m1__nf1_gboth_sdfull_pc/B.n1240 185
R581 pfet_01v8_lvt_W90p63_L0p74_m1__nf1_gboth_sdfull_pc/B.n1243 pfet_01v8_lvt_W90p63_L0p74_m1__nf1_gboth_sdfull_pc/B.n1242 185
R582 pfet_01v8_lvt_W90p63_L0p74_m1__nf1_gboth_sdfull_pc/B.n1245 pfet_01v8_lvt_W90p63_L0p74_m1__nf1_gboth_sdfull_pc/B.n1244 185
R583 pfet_01v8_lvt_W90p63_L0p74_m1__nf1_gboth_sdfull_pc/B.n1247 pfet_01v8_lvt_W90p63_L0p74_m1__nf1_gboth_sdfull_pc/B.n1246 185
R584 pfet_01v8_lvt_W90p63_L0p74_m1__nf1_gboth_sdfull_pc/B.n1249 pfet_01v8_lvt_W90p63_L0p74_m1__nf1_gboth_sdfull_pc/B.n1248 185
R585 pfet_01v8_lvt_W90p63_L0p74_m1__nf1_gboth_sdfull_pc/B.n1251 pfet_01v8_lvt_W90p63_L0p74_m1__nf1_gboth_sdfull_pc/B.n1250 185
R586 pfet_01v8_lvt_W90p63_L0p74_m1__nf1_gboth_sdfull_pc/B.n1253 pfet_01v8_lvt_W90p63_L0p74_m1__nf1_gboth_sdfull_pc/B.n1252 185
R587 pfet_01v8_lvt_W90p63_L0p74_m1__nf1_gboth_sdfull_pc/B.n1255 pfet_01v8_lvt_W90p63_L0p74_m1__nf1_gboth_sdfull_pc/B.n1254 185
R588 pfet_01v8_lvt_W90p63_L0p74_m1__nf1_gboth_sdfull_pc/B.n1257 pfet_01v8_lvt_W90p63_L0p74_m1__nf1_gboth_sdfull_pc/B.n1256 185
R589 pfet_01v8_lvt_W90p63_L0p74_m1__nf1_gboth_sdfull_pc/B.n1259 pfet_01v8_lvt_W90p63_L0p74_m1__nf1_gboth_sdfull_pc/B.n1258 185
R590 pfet_01v8_lvt_W90p63_L0p74_m1__nf1_gboth_sdfull_pc/B.n1261 pfet_01v8_lvt_W90p63_L0p74_m1__nf1_gboth_sdfull_pc/B.n1260 185
R591 pfet_01v8_lvt_W90p63_L0p74_m1__nf1_gboth_sdfull_pc/B.n1263 pfet_01v8_lvt_W90p63_L0p74_m1__nf1_gboth_sdfull_pc/B.n1262 185
R592 pfet_01v8_lvt_W90p63_L0p74_m1__nf1_gboth_sdfull_pc/B.n1265 pfet_01v8_lvt_W90p63_L0p74_m1__nf1_gboth_sdfull_pc/B.n1264 185
R593 pfet_01v8_lvt_W90p63_L0p74_m1__nf1_gboth_sdfull_pc/B.n1267 pfet_01v8_lvt_W90p63_L0p74_m1__nf1_gboth_sdfull_pc/B.n1266 185
R594 pfet_01v8_lvt_W90p63_L0p74_m1__nf1_gboth_sdfull_pc/B.n1269 pfet_01v8_lvt_W90p63_L0p74_m1__nf1_gboth_sdfull_pc/B.n1268 185
R595 pfet_01v8_lvt_W90p63_L0p74_m1__nf1_gboth_sdfull_pc/B.n1271 pfet_01v8_lvt_W90p63_L0p74_m1__nf1_gboth_sdfull_pc/B.n1270 185
R596 pfet_01v8_lvt_W90p63_L0p74_m1__nf1_gboth_sdfull_pc/B.n1273 pfet_01v8_lvt_W90p63_L0p74_m1__nf1_gboth_sdfull_pc/B.n1272 185
R597 pfet_01v8_lvt_W90p63_L0p74_m1__nf1_gboth_sdfull_pc/B.n1275 pfet_01v8_lvt_W90p63_L0p74_m1__nf1_gboth_sdfull_pc/B.n1274 185
R598 pfet_01v8_lvt_W90p63_L0p74_m1__nf1_gboth_sdfull_pc/B.n1277 pfet_01v8_lvt_W90p63_L0p74_m1__nf1_gboth_sdfull_pc/B.n1276 185
R599 pfet_01v8_lvt_W90p63_L0p74_m1__nf1_gboth_sdfull_pc/B.n1279 pfet_01v8_lvt_W90p63_L0p74_m1__nf1_gboth_sdfull_pc/B.n1278 185
R600 pfet_01v8_lvt_W90p63_L0p74_m1__nf1_gboth_sdfull_pc/B.n1281 pfet_01v8_lvt_W90p63_L0p74_m1__nf1_gboth_sdfull_pc/B.n1280 185
R601 pfet_01v8_lvt_W90p63_L0p74_m1__nf1_gboth_sdfull_pc/B.n1283 pfet_01v8_lvt_W90p63_L0p74_m1__nf1_gboth_sdfull_pc/B.n1282 185
R602 pfet_01v8_lvt_W90p63_L0p74_m1__nf1_gboth_sdfull_pc/B.n1285 pfet_01v8_lvt_W90p63_L0p74_m1__nf1_gboth_sdfull_pc/B.n1284 185
R603 pfet_01v8_lvt_W90p63_L0p74_m1__nf1_gboth_sdfull_pc/B.n1287 pfet_01v8_lvt_W90p63_L0p74_m1__nf1_gboth_sdfull_pc/B.n1286 185
R604 pfet_01v8_lvt_W90p63_L0p74_m1__nf1_gboth_sdfull_pc/B.n1289 pfet_01v8_lvt_W90p63_L0p74_m1__nf1_gboth_sdfull_pc/B.n1288 185
R605 pfet_01v8_lvt_W90p63_L0p74_m1__nf1_gboth_sdfull_pc/B.n1291 pfet_01v8_lvt_W90p63_L0p74_m1__nf1_gboth_sdfull_pc/B.n1290 185
R606 pfet_01v8_lvt_W90p63_L0p74_m1__nf1_gboth_sdfull_pc/B.n1293 pfet_01v8_lvt_W90p63_L0p74_m1__nf1_gboth_sdfull_pc/B.n1292 185
R607 pfet_01v8_lvt_W90p63_L0p74_m1__nf1_gboth_sdfull_pc/B.n1295 pfet_01v8_lvt_W90p63_L0p74_m1__nf1_gboth_sdfull_pc/B.n1294 185
R608 pfet_01v8_lvt_W90p63_L0p74_m1__nf1_gboth_sdfull_pc/B.n1297 pfet_01v8_lvt_W90p63_L0p74_m1__nf1_gboth_sdfull_pc/B.n1296 185
R609 pfet_01v8_lvt_W90p63_L0p74_m1__nf1_gboth_sdfull_pc/B.n1299 pfet_01v8_lvt_W90p63_L0p74_m1__nf1_gboth_sdfull_pc/B.n1298 185
R610 pfet_01v8_lvt_W90p63_L0p74_m1__nf1_gboth_sdfull_pc/B.n1301 pfet_01v8_lvt_W90p63_L0p74_m1__nf1_gboth_sdfull_pc/B.n1300 185
R611 pfet_01v8_lvt_W90p63_L0p74_m1__nf1_gboth_sdfull_pc/B.n1303 pfet_01v8_lvt_W90p63_L0p74_m1__nf1_gboth_sdfull_pc/B.n1302 185
R612 pfet_01v8_lvt_W90p63_L0p74_m1__nf1_gboth_sdfull_pc/B.n1305 pfet_01v8_lvt_W90p63_L0p74_m1__nf1_gboth_sdfull_pc/B.n1304 185
R613 pfet_01v8_lvt_W90p63_L0p74_m1__nf1_gboth_sdfull_pc/B.n1307 pfet_01v8_lvt_W90p63_L0p74_m1__nf1_gboth_sdfull_pc/B.n1306 185
R614 pfet_01v8_lvt_W90p63_L0p74_m1__nf1_gboth_sdfull_pc/B.n1309 pfet_01v8_lvt_W90p63_L0p74_m1__nf1_gboth_sdfull_pc/B.n1308 185
R615 pfet_01v8_lvt_W90p63_L0p74_m1__nf1_gboth_sdfull_pc/B.n1311 pfet_01v8_lvt_W90p63_L0p74_m1__nf1_gboth_sdfull_pc/B.n1310 185
R616 pfet_01v8_lvt_W90p63_L0p74_m1__nf1_gboth_sdfull_pc/B.n1313 pfet_01v8_lvt_W90p63_L0p74_m1__nf1_gboth_sdfull_pc/B.n1312 185
R617 pfet_01v8_lvt_W90p63_L0p74_m1__nf1_gboth_sdfull_pc/B.n1315 pfet_01v8_lvt_W90p63_L0p74_m1__nf1_gboth_sdfull_pc/B.n1314 185
R618 pfet_01v8_lvt_W90p63_L0p74_m1__nf1_gboth_sdfull_pc/B.n1325 pfet_01v8_lvt_W90p63_L0p74_m1__nf1_gboth_sdfull_pc/B.n675 185
R619 pfet_01v8_lvt_W90p63_L0p74_m1__nf1_gboth_sdfull_pc/B.n1316 pfet_01v8_lvt_W90p63_L0p74_m1__nf1_gboth_sdfull_pc/B.n675 185
R620 pfet_01v8_lvt_W90p63_L0p74_m1__nf1_gboth_sdfull_pc/B.n1318 pfet_01v8_lvt_W90p63_L0p74_m1__nf1_gboth_sdfull_pc/B.n1317 185
R621 pfet_01v8_lvt_W90p63_L0p74_m1__nf1_gboth_sdfull_pc/B.n1320 pfet_01v8_lvt_W90p63_L0p74_m1__nf1_gboth_sdfull_pc/B.n1319 185
R622 pfet_01v8_lvt_W90p63_L0p74_m1__nf1_gboth_sdfull_pc/B.n1325 pfet_01v8_lvt_W90p63_L0p74_m1__nf1_gboth_sdfull_pc/B.n824 185
R623 pfet_01v8_lvt_W90p63_L0p74_m1__nf1_gboth_sdfull_pc/B.n1321 pfet_01v8_lvt_W90p63_L0p74_m1__nf1_gboth_sdfull_pc/B.n824 185
R624 pfet_01v8_lvt_W90p63_L0p74_m1__nf1_gboth_sdfull_pc/B.n1323 pfet_01v8_lvt_W90p63_L0p74_m1__nf1_gboth_sdfull_pc/B.n1322 185
R625 pfet_01v8_lvt_W90p63_L0p74_m1__nf1_gboth_sdfull_pc/B.n826 pfet_01v8_lvt_W90p63_L0p74_m1__nf1_gboth_sdfull_pc/B.n825 185
R626 pfet_01v8_lvt_W90p63_L0p74_m1__nf1_gboth_sdfull_pc/B.n674 pfet_01v8_lvt_W90p63_L0p74_m1__nf1_gboth_sdfull_pc/B.n673 185
R627 pfet_01v8_lvt_W90p63_L0p74_m1__nf1_gboth_sdfull_pc/B.n1328 pfet_01v8_lvt_W90p63_L0p74_m1__nf1_gboth_sdfull_pc/B.n1327 185
R628 pfet_01v8_lvt_W90p63_L0p74_m1__nf1_gboth_sdfull_pc/B.n6 pfet_01v8_lvt_W90p63_L0p74_m1__nf1_gboth_sdfull_pc/B.n4 185
R629 pfet_01v8_lvt_W90p63_L0p74_m1__nf1_gboth_sdfull_pc/B.n1329 pfet_01v8_lvt_W90p63_L0p74_m1__nf1_gboth_sdfull_pc/B.n6 185
R630 pfet_01v8_lvt_W90p63_L0p74_m1__nf1_gboth_sdfull_pc/B.n1332 pfet_01v8_lvt_W90p63_L0p74_m1__nf1_gboth_sdfull_pc/B.n1331 185
R631 pfet_01v8_lvt_W90p63_L0p74_m1__nf1_gboth_sdfull_pc/B.n1331 pfet_01v8_lvt_W90p63_L0p74_m1__nf1_gboth_sdfull_pc/B.n1330 185
R632 pfet_01v8_lvt_W90p63_L0p74_m1__nf1_gboth_sdfull_pc/B.n668 pfet_01v8_lvt_W90p63_L0p74_m1__nf1_gboth_sdfull_pc/B.n5 185
R633 pfet_01v8_lvt_W90p63_L0p74_m1__nf1_gboth_sdfull_pc/B.n672 pfet_01v8_lvt_W90p63_L0p74_m1__nf1_gboth_sdfull_pc/B.n5 185
R634 pfet_01v8_lvt_W90p63_L0p74_m1__nf1_gboth_sdfull_pc/B.n670 pfet_01v8_lvt_W90p63_L0p74_m1__nf1_gboth_sdfull_pc/B.n669 185
R635 pfet_01v8_lvt_W90p63_L0p74_m1__nf1_gboth_sdfull_pc/B.n671 pfet_01v8_lvt_W90p63_L0p74_m1__nf1_gboth_sdfull_pc/B.n670 185
R636 pfet_01v8_lvt_W90p63_L0p74_m1__nf1_gboth_sdfull_pc/B.n8 pfet_01v8_lvt_W90p63_L0p74_m1__nf1_gboth_sdfull_pc/B.n7 185
R637 pfet_01v8_lvt_W90p63_L0p74_m1__nf1_gboth_sdfull_pc/B.n160 pfet_01v8_lvt_W90p63_L0p74_m1__nf1_gboth_sdfull_pc/B.n159 185
R638 pfet_01v8_lvt_W90p63_L0p74_m1__nf1_gboth_sdfull_pc/B.n162 pfet_01v8_lvt_W90p63_L0p74_m1__nf1_gboth_sdfull_pc/B.n161 185
R639 pfet_01v8_lvt_W90p63_L0p74_m1__nf1_gboth_sdfull_pc/B.n164 pfet_01v8_lvt_W90p63_L0p74_m1__nf1_gboth_sdfull_pc/B.n157 185
R640 pfet_01v8_lvt_W90p63_L0p74_m1__nf1_gboth_sdfull_pc/B.n166 pfet_01v8_lvt_W90p63_L0p74_m1__nf1_gboth_sdfull_pc/B.n165 185
R641 pfet_01v8_lvt_W90p63_L0p74_m1__nf1_gboth_sdfull_pc/B.n168 pfet_01v8_lvt_W90p63_L0p74_m1__nf1_gboth_sdfull_pc/B.n167 185
R642 pfet_01v8_lvt_W90p63_L0p74_m1__nf1_gboth_sdfull_pc/B.n169 pfet_01v8_lvt_W90p63_L0p74_m1__nf1_gboth_sdfull_pc/B.n9 185
R643 pfet_01v8_lvt_W90p63_L0p74_m1__nf1_gboth_sdfull_pc/B.n169 pfet_01v8_lvt_W90p63_L0p74_m1__nf1_gboth_sdfull_pc/B.n155 185
R644 pfet_01v8_lvt_W90p63_L0p74_m1__nf1_gboth_sdfull_pc/B.n171 pfet_01v8_lvt_W90p63_L0p74_m1__nf1_gboth_sdfull_pc/B.n170 185
R645 pfet_01v8_lvt_W90p63_L0p74_m1__nf1_gboth_sdfull_pc/B.n173 pfet_01v8_lvt_W90p63_L0p74_m1__nf1_gboth_sdfull_pc/B.n172 185
R646 pfet_01v8_lvt_W90p63_L0p74_m1__nf1_gboth_sdfull_pc/B.n174 pfet_01v8_lvt_W90p63_L0p74_m1__nf1_gboth_sdfull_pc/B.n9 185
R647 pfet_01v8_lvt_W90p63_L0p74_m1__nf1_gboth_sdfull_pc/B.n174 pfet_01v8_lvt_W90p63_L0p74_m1__nf1_gboth_sdfull_pc/B.n153 185
R648 pfet_01v8_lvt_W90p63_L0p74_m1__nf1_gboth_sdfull_pc/B.n176 pfet_01v8_lvt_W90p63_L0p74_m1__nf1_gboth_sdfull_pc/B.n175 185
R649 pfet_01v8_lvt_W90p63_L0p74_m1__nf1_gboth_sdfull_pc/B.n178 pfet_01v8_lvt_W90p63_L0p74_m1__nf1_gboth_sdfull_pc/B.n177 185
R650 pfet_01v8_lvt_W90p63_L0p74_m1__nf1_gboth_sdfull_pc/B.n179 pfet_01v8_lvt_W90p63_L0p74_m1__nf1_gboth_sdfull_pc/B.n151 185
R651 pfet_01v8_lvt_W90p63_L0p74_m1__nf1_gboth_sdfull_pc/B.n182 pfet_01v8_lvt_W90p63_L0p74_m1__nf1_gboth_sdfull_pc/B.n181 185
R652 pfet_01v8_lvt_W90p63_L0p74_m1__nf1_gboth_sdfull_pc/B.n150 pfet_01v8_lvt_W90p63_L0p74_m1__nf1_gboth_sdfull_pc/B.n9 185
R653 pfet_01v8_lvt_W90p63_L0p74_m1__nf1_gboth_sdfull_pc/B.n183 pfet_01v8_lvt_W90p63_L0p74_m1__nf1_gboth_sdfull_pc/B.n150 185
R654 pfet_01v8_lvt_W90p63_L0p74_m1__nf1_gboth_sdfull_pc/B.n185 pfet_01v8_lvt_W90p63_L0p74_m1__nf1_gboth_sdfull_pc/B.n184 185
R655 pfet_01v8_lvt_W90p63_L0p74_m1__nf1_gboth_sdfull_pc/B.n187 pfet_01v8_lvt_W90p63_L0p74_m1__nf1_gboth_sdfull_pc/B.n149 185
R656 pfet_01v8_lvt_W90p63_L0p74_m1__nf1_gboth_sdfull_pc/B.n190 pfet_01v8_lvt_W90p63_L0p74_m1__nf1_gboth_sdfull_pc/B.n189 185
R657 pfet_01v8_lvt_W90p63_L0p74_m1__nf1_gboth_sdfull_pc/B.n191 pfet_01v8_lvt_W90p63_L0p74_m1__nf1_gboth_sdfull_pc/B.n148 185
R658 pfet_01v8_lvt_W90p63_L0p74_m1__nf1_gboth_sdfull_pc/B.n193 pfet_01v8_lvt_W90p63_L0p74_m1__nf1_gboth_sdfull_pc/B.n192 185
R659 pfet_01v8_lvt_W90p63_L0p74_m1__nf1_gboth_sdfull_pc/B.n195 pfet_01v8_lvt_W90p63_L0p74_m1__nf1_gboth_sdfull_pc/B.n147 185
R660 pfet_01v8_lvt_W90p63_L0p74_m1__nf1_gboth_sdfull_pc/B.n198 pfet_01v8_lvt_W90p63_L0p74_m1__nf1_gboth_sdfull_pc/B.n197 185
R661 pfet_01v8_lvt_W90p63_L0p74_m1__nf1_gboth_sdfull_pc/B.n199 pfet_01v8_lvt_W90p63_L0p74_m1__nf1_gboth_sdfull_pc/B.n146 185
R662 pfet_01v8_lvt_W90p63_L0p74_m1__nf1_gboth_sdfull_pc/B.n201 pfet_01v8_lvt_W90p63_L0p74_m1__nf1_gboth_sdfull_pc/B.n200 185
R663 pfet_01v8_lvt_W90p63_L0p74_m1__nf1_gboth_sdfull_pc/B.n203 pfet_01v8_lvt_W90p63_L0p74_m1__nf1_gboth_sdfull_pc/B.n145 185
R664 pfet_01v8_lvt_W90p63_L0p74_m1__nf1_gboth_sdfull_pc/B.n205 pfet_01v8_lvt_W90p63_L0p74_m1__nf1_gboth_sdfull_pc/B.n204 185
R665 pfet_01v8_lvt_W90p63_L0p74_m1__nf1_gboth_sdfull_pc/B.n207 pfet_01v8_lvt_W90p63_L0p74_m1__nf1_gboth_sdfull_pc/B.n206 185
R666 pfet_01v8_lvt_W90p63_L0p74_m1__nf1_gboth_sdfull_pc/B.n208 pfet_01v8_lvt_W90p63_L0p74_m1__nf1_gboth_sdfull_pc/B.n9 185
R667 pfet_01v8_lvt_W90p63_L0p74_m1__nf1_gboth_sdfull_pc/B.n208 pfet_01v8_lvt_W90p63_L0p74_m1__nf1_gboth_sdfull_pc/B.n143 185
R668 pfet_01v8_lvt_W90p63_L0p74_m1__nf1_gboth_sdfull_pc/B.n211 pfet_01v8_lvt_W90p63_L0p74_m1__nf1_gboth_sdfull_pc/B.n210 185
R669 pfet_01v8_lvt_W90p63_L0p74_m1__nf1_gboth_sdfull_pc/B.n212 pfet_01v8_lvt_W90p63_L0p74_m1__nf1_gboth_sdfull_pc/B.n142 185
R670 pfet_01v8_lvt_W90p63_L0p74_m1__nf1_gboth_sdfull_pc/B.n214 pfet_01v8_lvt_W90p63_L0p74_m1__nf1_gboth_sdfull_pc/B.n213 185
R671 pfet_01v8_lvt_W90p63_L0p74_m1__nf1_gboth_sdfull_pc/B.n216 pfet_01v8_lvt_W90p63_L0p74_m1__nf1_gboth_sdfull_pc/B.n141 185
R672 pfet_01v8_lvt_W90p63_L0p74_m1__nf1_gboth_sdfull_pc/B.n219 pfet_01v8_lvt_W90p63_L0p74_m1__nf1_gboth_sdfull_pc/B.n218 185
R673 pfet_01v8_lvt_W90p63_L0p74_m1__nf1_gboth_sdfull_pc/B.n220 pfet_01v8_lvt_W90p63_L0p74_m1__nf1_gboth_sdfull_pc/B.n140 185
R674 pfet_01v8_lvt_W90p63_L0p74_m1__nf1_gboth_sdfull_pc/B.n222 pfet_01v8_lvt_W90p63_L0p74_m1__nf1_gboth_sdfull_pc/B.n221 185
R675 pfet_01v8_lvt_W90p63_L0p74_m1__nf1_gboth_sdfull_pc/B.n224 pfet_01v8_lvt_W90p63_L0p74_m1__nf1_gboth_sdfull_pc/B.n139 185
R676 pfet_01v8_lvt_W90p63_L0p74_m1__nf1_gboth_sdfull_pc/B.n227 pfet_01v8_lvt_W90p63_L0p74_m1__nf1_gboth_sdfull_pc/B.n226 185
R677 pfet_01v8_lvt_W90p63_L0p74_m1__nf1_gboth_sdfull_pc/B.n228 pfet_01v8_lvt_W90p63_L0p74_m1__nf1_gboth_sdfull_pc/B.n138 185
R678 pfet_01v8_lvt_W90p63_L0p74_m1__nf1_gboth_sdfull_pc/B.n230 pfet_01v8_lvt_W90p63_L0p74_m1__nf1_gboth_sdfull_pc/B.n229 185
R679 pfet_01v8_lvt_W90p63_L0p74_m1__nf1_gboth_sdfull_pc/B.n232 pfet_01v8_lvt_W90p63_L0p74_m1__nf1_gboth_sdfull_pc/B.n137 185
R680 pfet_01v8_lvt_W90p63_L0p74_m1__nf1_gboth_sdfull_pc/B.n235 pfet_01v8_lvt_W90p63_L0p74_m1__nf1_gboth_sdfull_pc/B.n234 185
R681 pfet_01v8_lvt_W90p63_L0p74_m1__nf1_gboth_sdfull_pc/B.n236 pfet_01v8_lvt_W90p63_L0p74_m1__nf1_gboth_sdfull_pc/B.n136 185
R682 pfet_01v8_lvt_W90p63_L0p74_m1__nf1_gboth_sdfull_pc/B.n238 pfet_01v8_lvt_W90p63_L0p74_m1__nf1_gboth_sdfull_pc/B.n237 185
R683 pfet_01v8_lvt_W90p63_L0p74_m1__nf1_gboth_sdfull_pc/B.n240 pfet_01v8_lvt_W90p63_L0p74_m1__nf1_gboth_sdfull_pc/B.n135 185
R684 pfet_01v8_lvt_W90p63_L0p74_m1__nf1_gboth_sdfull_pc/B.n243 pfet_01v8_lvt_W90p63_L0p74_m1__nf1_gboth_sdfull_pc/B.n242 185
R685 pfet_01v8_lvt_W90p63_L0p74_m1__nf1_gboth_sdfull_pc/B.n244 pfet_01v8_lvt_W90p63_L0p74_m1__nf1_gboth_sdfull_pc/B.n134 185
R686 pfet_01v8_lvt_W90p63_L0p74_m1__nf1_gboth_sdfull_pc/B.n246 pfet_01v8_lvt_W90p63_L0p74_m1__nf1_gboth_sdfull_pc/B.n245 185
R687 pfet_01v8_lvt_W90p63_L0p74_m1__nf1_gboth_sdfull_pc/B.n248 pfet_01v8_lvt_W90p63_L0p74_m1__nf1_gboth_sdfull_pc/B.n133 185
R688 pfet_01v8_lvt_W90p63_L0p74_m1__nf1_gboth_sdfull_pc/B.n251 pfet_01v8_lvt_W90p63_L0p74_m1__nf1_gboth_sdfull_pc/B.n250 185
R689 pfet_01v8_lvt_W90p63_L0p74_m1__nf1_gboth_sdfull_pc/B.n252 pfet_01v8_lvt_W90p63_L0p74_m1__nf1_gboth_sdfull_pc/B.n132 185
R690 pfet_01v8_lvt_W90p63_L0p74_m1__nf1_gboth_sdfull_pc/B.n254 pfet_01v8_lvt_W90p63_L0p74_m1__nf1_gboth_sdfull_pc/B.n253 185
R691 pfet_01v8_lvt_W90p63_L0p74_m1__nf1_gboth_sdfull_pc/B.n256 pfet_01v8_lvt_W90p63_L0p74_m1__nf1_gboth_sdfull_pc/B.n131 185
R692 pfet_01v8_lvt_W90p63_L0p74_m1__nf1_gboth_sdfull_pc/B.n259 pfet_01v8_lvt_W90p63_L0p74_m1__nf1_gboth_sdfull_pc/B.n258 185
R693 pfet_01v8_lvt_W90p63_L0p74_m1__nf1_gboth_sdfull_pc/B.n260 pfet_01v8_lvt_W90p63_L0p74_m1__nf1_gboth_sdfull_pc/B.n130 185
R694 pfet_01v8_lvt_W90p63_L0p74_m1__nf1_gboth_sdfull_pc/B.n262 pfet_01v8_lvt_W90p63_L0p74_m1__nf1_gboth_sdfull_pc/B.n261 185
R695 pfet_01v8_lvt_W90p63_L0p74_m1__nf1_gboth_sdfull_pc/B.n264 pfet_01v8_lvt_W90p63_L0p74_m1__nf1_gboth_sdfull_pc/B.n129 185
R696 pfet_01v8_lvt_W90p63_L0p74_m1__nf1_gboth_sdfull_pc/B.n267 pfet_01v8_lvt_W90p63_L0p74_m1__nf1_gboth_sdfull_pc/B.n266 185
R697 pfet_01v8_lvt_W90p63_L0p74_m1__nf1_gboth_sdfull_pc/B.n268 pfet_01v8_lvt_W90p63_L0p74_m1__nf1_gboth_sdfull_pc/B.n128 185
R698 pfet_01v8_lvt_W90p63_L0p74_m1__nf1_gboth_sdfull_pc/B.n270 pfet_01v8_lvt_W90p63_L0p74_m1__nf1_gboth_sdfull_pc/B.n269 185
R699 pfet_01v8_lvt_W90p63_L0p74_m1__nf1_gboth_sdfull_pc/B.n272 pfet_01v8_lvt_W90p63_L0p74_m1__nf1_gboth_sdfull_pc/B.n127 185
R700 pfet_01v8_lvt_W90p63_L0p74_m1__nf1_gboth_sdfull_pc/B.n275 pfet_01v8_lvt_W90p63_L0p74_m1__nf1_gboth_sdfull_pc/B.n274 185
R701 pfet_01v8_lvt_W90p63_L0p74_m1__nf1_gboth_sdfull_pc/B.n276 pfet_01v8_lvt_W90p63_L0p74_m1__nf1_gboth_sdfull_pc/B.n126 185
R702 pfet_01v8_lvt_W90p63_L0p74_m1__nf1_gboth_sdfull_pc/B.n278 pfet_01v8_lvt_W90p63_L0p74_m1__nf1_gboth_sdfull_pc/B.n277 185
R703 pfet_01v8_lvt_W90p63_L0p74_m1__nf1_gboth_sdfull_pc/B.n280 pfet_01v8_lvt_W90p63_L0p74_m1__nf1_gboth_sdfull_pc/B.n125 185
R704 pfet_01v8_lvt_W90p63_L0p74_m1__nf1_gboth_sdfull_pc/B.n283 pfet_01v8_lvt_W90p63_L0p74_m1__nf1_gboth_sdfull_pc/B.n282 185
R705 pfet_01v8_lvt_W90p63_L0p74_m1__nf1_gboth_sdfull_pc/B.n284 pfet_01v8_lvt_W90p63_L0p74_m1__nf1_gboth_sdfull_pc/B.n124 185
R706 pfet_01v8_lvt_W90p63_L0p74_m1__nf1_gboth_sdfull_pc/B.n286 pfet_01v8_lvt_W90p63_L0p74_m1__nf1_gboth_sdfull_pc/B.n285 185
R707 pfet_01v8_lvt_W90p63_L0p74_m1__nf1_gboth_sdfull_pc/B.n288 pfet_01v8_lvt_W90p63_L0p74_m1__nf1_gboth_sdfull_pc/B.n123 185
R708 pfet_01v8_lvt_W90p63_L0p74_m1__nf1_gboth_sdfull_pc/B.n289 pfet_01v8_lvt_W90p63_L0p74_m1__nf1_gboth_sdfull_pc/B.n9 185
R709 pfet_01v8_lvt_W90p63_L0p74_m1__nf1_gboth_sdfull_pc/B.n289 pfet_01v8_lvt_W90p63_L0p74_m1__nf1_gboth_sdfull_pc/B.n122 185
R710 pfet_01v8_lvt_W90p63_L0p74_m1__nf1_gboth_sdfull_pc/B.n291 pfet_01v8_lvt_W90p63_L0p74_m1__nf1_gboth_sdfull_pc/B.n290 185
R711 pfet_01v8_lvt_W90p63_L0p74_m1__nf1_gboth_sdfull_pc/B.n293 pfet_01v8_lvt_W90p63_L0p74_m1__nf1_gboth_sdfull_pc/B.n292 185
R712 pfet_01v8_lvt_W90p63_L0p74_m1__nf1_gboth_sdfull_pc/B.n294 pfet_01v8_lvt_W90p63_L0p74_m1__nf1_gboth_sdfull_pc/B.n120 185
R713 pfet_01v8_lvt_W90p63_L0p74_m1__nf1_gboth_sdfull_pc/B.n297 pfet_01v8_lvt_W90p63_L0p74_m1__nf1_gboth_sdfull_pc/B.n296 185
R714 pfet_01v8_lvt_W90p63_L0p74_m1__nf1_gboth_sdfull_pc/B.n119 pfet_01v8_lvt_W90p63_L0p74_m1__nf1_gboth_sdfull_pc/B.n9 185
R715 pfet_01v8_lvt_W90p63_L0p74_m1__nf1_gboth_sdfull_pc/B.n298 pfet_01v8_lvt_W90p63_L0p74_m1__nf1_gboth_sdfull_pc/B.n119 185
R716 pfet_01v8_lvt_W90p63_L0p74_m1__nf1_gboth_sdfull_pc/B.n300 pfet_01v8_lvt_W90p63_L0p74_m1__nf1_gboth_sdfull_pc/B.n299 185
R717 pfet_01v8_lvt_W90p63_L0p74_m1__nf1_gboth_sdfull_pc/B.n302 pfet_01v8_lvt_W90p63_L0p74_m1__nf1_gboth_sdfull_pc/B.n118 185
R718 pfet_01v8_lvt_W90p63_L0p74_m1__nf1_gboth_sdfull_pc/B.n305 pfet_01v8_lvt_W90p63_L0p74_m1__nf1_gboth_sdfull_pc/B.n304 185
R719 pfet_01v8_lvt_W90p63_L0p74_m1__nf1_gboth_sdfull_pc/B.n306 pfet_01v8_lvt_W90p63_L0p74_m1__nf1_gboth_sdfull_pc/B.n117 185
R720 pfet_01v8_lvt_W90p63_L0p74_m1__nf1_gboth_sdfull_pc/B.n308 pfet_01v8_lvt_W90p63_L0p74_m1__nf1_gboth_sdfull_pc/B.n307 185
R721 pfet_01v8_lvt_W90p63_L0p74_m1__nf1_gboth_sdfull_pc/B.n310 pfet_01v8_lvt_W90p63_L0p74_m1__nf1_gboth_sdfull_pc/B.n116 185
R722 pfet_01v8_lvt_W90p63_L0p74_m1__nf1_gboth_sdfull_pc/B.n312 pfet_01v8_lvt_W90p63_L0p74_m1__nf1_gboth_sdfull_pc/B.n311 185
R723 pfet_01v8_lvt_W90p63_L0p74_m1__nf1_gboth_sdfull_pc/B.n314 pfet_01v8_lvt_W90p63_L0p74_m1__nf1_gboth_sdfull_pc/B.n313 185
R724 pfet_01v8_lvt_W90p63_L0p74_m1__nf1_gboth_sdfull_pc/B.n315 pfet_01v8_lvt_W90p63_L0p74_m1__nf1_gboth_sdfull_pc/B.n9 185
R725 pfet_01v8_lvt_W90p63_L0p74_m1__nf1_gboth_sdfull_pc/B.n315 pfet_01v8_lvt_W90p63_L0p74_m1__nf1_gboth_sdfull_pc/B.n114 185
R726 pfet_01v8_lvt_W90p63_L0p74_m1__nf1_gboth_sdfull_pc/B.n318 pfet_01v8_lvt_W90p63_L0p74_m1__nf1_gboth_sdfull_pc/B.n317 185
R727 pfet_01v8_lvt_W90p63_L0p74_m1__nf1_gboth_sdfull_pc/B.n319 pfet_01v8_lvt_W90p63_L0p74_m1__nf1_gboth_sdfull_pc/B.n113 185
R728 pfet_01v8_lvt_W90p63_L0p74_m1__nf1_gboth_sdfull_pc/B.n321 pfet_01v8_lvt_W90p63_L0p74_m1__nf1_gboth_sdfull_pc/B.n320 185
R729 pfet_01v8_lvt_W90p63_L0p74_m1__nf1_gboth_sdfull_pc/B.n323 pfet_01v8_lvt_W90p63_L0p74_m1__nf1_gboth_sdfull_pc/B.n112 185
R730 pfet_01v8_lvt_W90p63_L0p74_m1__nf1_gboth_sdfull_pc/B.n325 pfet_01v8_lvt_W90p63_L0p74_m1__nf1_gboth_sdfull_pc/B.n324 185
R731 pfet_01v8_lvt_W90p63_L0p74_m1__nf1_gboth_sdfull_pc/B.n327 pfet_01v8_lvt_W90p63_L0p74_m1__nf1_gboth_sdfull_pc/B.n326 185
R732 pfet_01v8_lvt_W90p63_L0p74_m1__nf1_gboth_sdfull_pc/B.n328 pfet_01v8_lvt_W90p63_L0p74_m1__nf1_gboth_sdfull_pc/B.n110 185
R733 pfet_01v8_lvt_W90p63_L0p74_m1__nf1_gboth_sdfull_pc/B.n331 pfet_01v8_lvt_W90p63_L0p74_m1__nf1_gboth_sdfull_pc/B.n330 185
R734 pfet_01v8_lvt_W90p63_L0p74_m1__nf1_gboth_sdfull_pc/B.n109 pfet_01v8_lvt_W90p63_L0p74_m1__nf1_gboth_sdfull_pc/B.n9 185
R735 pfet_01v8_lvt_W90p63_L0p74_m1__nf1_gboth_sdfull_pc/B.n332 pfet_01v8_lvt_W90p63_L0p74_m1__nf1_gboth_sdfull_pc/B.n109 185
R736 pfet_01v8_lvt_W90p63_L0p74_m1__nf1_gboth_sdfull_pc/B.n334 pfet_01v8_lvt_W90p63_L0p74_m1__nf1_gboth_sdfull_pc/B.n333 185
R737 pfet_01v8_lvt_W90p63_L0p74_m1__nf1_gboth_sdfull_pc/B.n336 pfet_01v8_lvt_W90p63_L0p74_m1__nf1_gboth_sdfull_pc/B.n108 185
R738 pfet_01v8_lvt_W90p63_L0p74_m1__nf1_gboth_sdfull_pc/B.n339 pfet_01v8_lvt_W90p63_L0p74_m1__nf1_gboth_sdfull_pc/B.n338 185
R739 pfet_01v8_lvt_W90p63_L0p74_m1__nf1_gboth_sdfull_pc/B.n340 pfet_01v8_lvt_W90p63_L0p74_m1__nf1_gboth_sdfull_pc/B.n107 185
R740 pfet_01v8_lvt_W90p63_L0p74_m1__nf1_gboth_sdfull_pc/B.n342 pfet_01v8_lvt_W90p63_L0p74_m1__nf1_gboth_sdfull_pc/B.n341 185
R741 pfet_01v8_lvt_W90p63_L0p74_m1__nf1_gboth_sdfull_pc/B.n344 pfet_01v8_lvt_W90p63_L0p74_m1__nf1_gboth_sdfull_pc/B.n106 185
R742 pfet_01v8_lvt_W90p63_L0p74_m1__nf1_gboth_sdfull_pc/B.n347 pfet_01v8_lvt_W90p63_L0p74_m1__nf1_gboth_sdfull_pc/B.n346 185
R743 pfet_01v8_lvt_W90p63_L0p74_m1__nf1_gboth_sdfull_pc/B.n348 pfet_01v8_lvt_W90p63_L0p74_m1__nf1_gboth_sdfull_pc/B.n105 185
R744 pfet_01v8_lvt_W90p63_L0p74_m1__nf1_gboth_sdfull_pc/B.n350 pfet_01v8_lvt_W90p63_L0p74_m1__nf1_gboth_sdfull_pc/B.n349 185
R745 pfet_01v8_lvt_W90p63_L0p74_m1__nf1_gboth_sdfull_pc/B.n352 pfet_01v8_lvt_W90p63_L0p74_m1__nf1_gboth_sdfull_pc/B.n104 185
R746 pfet_01v8_lvt_W90p63_L0p74_m1__nf1_gboth_sdfull_pc/B.n355 pfet_01v8_lvt_W90p63_L0p74_m1__nf1_gboth_sdfull_pc/B.n354 185
R747 pfet_01v8_lvt_W90p63_L0p74_m1__nf1_gboth_sdfull_pc/B.n356 pfet_01v8_lvt_W90p63_L0p74_m1__nf1_gboth_sdfull_pc/B.n103 185
R748 pfet_01v8_lvt_W90p63_L0p74_m1__nf1_gboth_sdfull_pc/B.n358 pfet_01v8_lvt_W90p63_L0p74_m1__nf1_gboth_sdfull_pc/B.n357 185
R749 pfet_01v8_lvt_W90p63_L0p74_m1__nf1_gboth_sdfull_pc/B.n360 pfet_01v8_lvt_W90p63_L0p74_m1__nf1_gboth_sdfull_pc/B.n102 185
R750 pfet_01v8_lvt_W90p63_L0p74_m1__nf1_gboth_sdfull_pc/B.n363 pfet_01v8_lvt_W90p63_L0p74_m1__nf1_gboth_sdfull_pc/B.n362 185
R751 pfet_01v8_lvt_W90p63_L0p74_m1__nf1_gboth_sdfull_pc/B.n364 pfet_01v8_lvt_W90p63_L0p74_m1__nf1_gboth_sdfull_pc/B.n101 185
R752 pfet_01v8_lvt_W90p63_L0p74_m1__nf1_gboth_sdfull_pc/B.n366 pfet_01v8_lvt_W90p63_L0p74_m1__nf1_gboth_sdfull_pc/B.n365 185
R753 pfet_01v8_lvt_W90p63_L0p74_m1__nf1_gboth_sdfull_pc/B.n368 pfet_01v8_lvt_W90p63_L0p74_m1__nf1_gboth_sdfull_pc/B.n100 185
R754 pfet_01v8_lvt_W90p63_L0p74_m1__nf1_gboth_sdfull_pc/B.n371 pfet_01v8_lvt_W90p63_L0p74_m1__nf1_gboth_sdfull_pc/B.n370 185
R755 pfet_01v8_lvt_W90p63_L0p74_m1__nf1_gboth_sdfull_pc/B.n372 pfet_01v8_lvt_W90p63_L0p74_m1__nf1_gboth_sdfull_pc/B.n99 185
R756 pfet_01v8_lvt_W90p63_L0p74_m1__nf1_gboth_sdfull_pc/B.n374 pfet_01v8_lvt_W90p63_L0p74_m1__nf1_gboth_sdfull_pc/B.n373 185
R757 pfet_01v8_lvt_W90p63_L0p74_m1__nf1_gboth_sdfull_pc/B.n376 pfet_01v8_lvt_W90p63_L0p74_m1__nf1_gboth_sdfull_pc/B.n98 185
R758 pfet_01v8_lvt_W90p63_L0p74_m1__nf1_gboth_sdfull_pc/B.n379 pfet_01v8_lvt_W90p63_L0p74_m1__nf1_gboth_sdfull_pc/B.n378 185
R759 pfet_01v8_lvt_W90p63_L0p74_m1__nf1_gboth_sdfull_pc/B.n380 pfet_01v8_lvt_W90p63_L0p74_m1__nf1_gboth_sdfull_pc/B.n97 185
R760 pfet_01v8_lvt_W90p63_L0p74_m1__nf1_gboth_sdfull_pc/B.n382 pfet_01v8_lvt_W90p63_L0p74_m1__nf1_gboth_sdfull_pc/B.n381 185
R761 pfet_01v8_lvt_W90p63_L0p74_m1__nf1_gboth_sdfull_pc/B.n384 pfet_01v8_lvt_W90p63_L0p74_m1__nf1_gboth_sdfull_pc/B.n96 185
R762 pfet_01v8_lvt_W90p63_L0p74_m1__nf1_gboth_sdfull_pc/B.n386 pfet_01v8_lvt_W90p63_L0p74_m1__nf1_gboth_sdfull_pc/B.n385 185
R763 pfet_01v8_lvt_W90p63_L0p74_m1__nf1_gboth_sdfull_pc/B.n388 pfet_01v8_lvt_W90p63_L0p74_m1__nf1_gboth_sdfull_pc/B.n387 185
R764 pfet_01v8_lvt_W90p63_L0p74_m1__nf1_gboth_sdfull_pc/B.n389 pfet_01v8_lvt_W90p63_L0p74_m1__nf1_gboth_sdfull_pc/B.n9 185
R765 pfet_01v8_lvt_W90p63_L0p74_m1__nf1_gboth_sdfull_pc/B.n389 pfet_01v8_lvt_W90p63_L0p74_m1__nf1_gboth_sdfull_pc/B.n94 185
R766 pfet_01v8_lvt_W90p63_L0p74_m1__nf1_gboth_sdfull_pc/B.n392 pfet_01v8_lvt_W90p63_L0p74_m1__nf1_gboth_sdfull_pc/B.n391 185
R767 pfet_01v8_lvt_W90p63_L0p74_m1__nf1_gboth_sdfull_pc/B.n393 pfet_01v8_lvt_W90p63_L0p74_m1__nf1_gboth_sdfull_pc/B.n93 185
R768 pfet_01v8_lvt_W90p63_L0p74_m1__nf1_gboth_sdfull_pc/B.n395 pfet_01v8_lvt_W90p63_L0p74_m1__nf1_gboth_sdfull_pc/B.n394 185
R769 pfet_01v8_lvt_W90p63_L0p74_m1__nf1_gboth_sdfull_pc/B.n397 pfet_01v8_lvt_W90p63_L0p74_m1__nf1_gboth_sdfull_pc/B.n92 185
R770 pfet_01v8_lvt_W90p63_L0p74_m1__nf1_gboth_sdfull_pc/B.n400 pfet_01v8_lvt_W90p63_L0p74_m1__nf1_gboth_sdfull_pc/B.n399 185
R771 pfet_01v8_lvt_W90p63_L0p74_m1__nf1_gboth_sdfull_pc/B.n401 pfet_01v8_lvt_W90p63_L0p74_m1__nf1_gboth_sdfull_pc/B.n91 185
R772 pfet_01v8_lvt_W90p63_L0p74_m1__nf1_gboth_sdfull_pc/B.n403 pfet_01v8_lvt_W90p63_L0p74_m1__nf1_gboth_sdfull_pc/B.n402 185
R773 pfet_01v8_lvt_W90p63_L0p74_m1__nf1_gboth_sdfull_pc/B.n405 pfet_01v8_lvt_W90p63_L0p74_m1__nf1_gboth_sdfull_pc/B.n90 185
R774 pfet_01v8_lvt_W90p63_L0p74_m1__nf1_gboth_sdfull_pc/B.n408 pfet_01v8_lvt_W90p63_L0p74_m1__nf1_gboth_sdfull_pc/B.n407 185
R775 pfet_01v8_lvt_W90p63_L0p74_m1__nf1_gboth_sdfull_pc/B.n409 pfet_01v8_lvt_W90p63_L0p74_m1__nf1_gboth_sdfull_pc/B.n89 185
R776 pfet_01v8_lvt_W90p63_L0p74_m1__nf1_gboth_sdfull_pc/B.n411 pfet_01v8_lvt_W90p63_L0p74_m1__nf1_gboth_sdfull_pc/B.n410 185
R777 pfet_01v8_lvt_W90p63_L0p74_m1__nf1_gboth_sdfull_pc/B.n413 pfet_01v8_lvt_W90p63_L0p74_m1__nf1_gboth_sdfull_pc/B.n88 185
R778 pfet_01v8_lvt_W90p63_L0p74_m1__nf1_gboth_sdfull_pc/B.n415 pfet_01v8_lvt_W90p63_L0p74_m1__nf1_gboth_sdfull_pc/B.n414 185
R779 pfet_01v8_lvt_W90p63_L0p74_m1__nf1_gboth_sdfull_pc/B.n417 pfet_01v8_lvt_W90p63_L0p74_m1__nf1_gboth_sdfull_pc/B.n416 185
R780 pfet_01v8_lvt_W90p63_L0p74_m1__nf1_gboth_sdfull_pc/B.n418 pfet_01v8_lvt_W90p63_L0p74_m1__nf1_gboth_sdfull_pc/B.n9 185
R781 pfet_01v8_lvt_W90p63_L0p74_m1__nf1_gboth_sdfull_pc/B.n418 pfet_01v8_lvt_W90p63_L0p74_m1__nf1_gboth_sdfull_pc/B.n86 185
R782 pfet_01v8_lvt_W90p63_L0p74_m1__nf1_gboth_sdfull_pc/B.n420 pfet_01v8_lvt_W90p63_L0p74_m1__nf1_gboth_sdfull_pc/B.n419 185
R783 pfet_01v8_lvt_W90p63_L0p74_m1__nf1_gboth_sdfull_pc/B.n422 pfet_01v8_lvt_W90p63_L0p74_m1__nf1_gboth_sdfull_pc/B.n421 185
R784 pfet_01v8_lvt_W90p63_L0p74_m1__nf1_gboth_sdfull_pc/B.n423 pfet_01v8_lvt_W90p63_L0p74_m1__nf1_gboth_sdfull_pc/B.n84 185
R785 pfet_01v8_lvt_W90p63_L0p74_m1__nf1_gboth_sdfull_pc/B.n426 pfet_01v8_lvt_W90p63_L0p74_m1__nf1_gboth_sdfull_pc/B.n425 185
R786 pfet_01v8_lvt_W90p63_L0p74_m1__nf1_gboth_sdfull_pc/B.n83 pfet_01v8_lvt_W90p63_L0p74_m1__nf1_gboth_sdfull_pc/B.n9 185
R787 pfet_01v8_lvt_W90p63_L0p74_m1__nf1_gboth_sdfull_pc/B.n427 pfet_01v8_lvt_W90p63_L0p74_m1__nf1_gboth_sdfull_pc/B.n83 185
R788 pfet_01v8_lvt_W90p63_L0p74_m1__nf1_gboth_sdfull_pc/B.n429 pfet_01v8_lvt_W90p63_L0p74_m1__nf1_gboth_sdfull_pc/B.n428 185
R789 pfet_01v8_lvt_W90p63_L0p74_m1__nf1_gboth_sdfull_pc/B.n431 pfet_01v8_lvt_W90p63_L0p74_m1__nf1_gboth_sdfull_pc/B.n82 185
R790 pfet_01v8_lvt_W90p63_L0p74_m1__nf1_gboth_sdfull_pc/B.n434 pfet_01v8_lvt_W90p63_L0p74_m1__nf1_gboth_sdfull_pc/B.n433 185
R791 pfet_01v8_lvt_W90p63_L0p74_m1__nf1_gboth_sdfull_pc/B.n435 pfet_01v8_lvt_W90p63_L0p74_m1__nf1_gboth_sdfull_pc/B.n81 185
R792 pfet_01v8_lvt_W90p63_L0p74_m1__nf1_gboth_sdfull_pc/B.n437 pfet_01v8_lvt_W90p63_L0p74_m1__nf1_gboth_sdfull_pc/B.n436 185
R793 pfet_01v8_lvt_W90p63_L0p74_m1__nf1_gboth_sdfull_pc/B.n439 pfet_01v8_lvt_W90p63_L0p74_m1__nf1_gboth_sdfull_pc/B.n80 185
R794 pfet_01v8_lvt_W90p63_L0p74_m1__nf1_gboth_sdfull_pc/B.n442 pfet_01v8_lvt_W90p63_L0p74_m1__nf1_gboth_sdfull_pc/B.n441 185
R795 pfet_01v8_lvt_W90p63_L0p74_m1__nf1_gboth_sdfull_pc/B.n443 pfet_01v8_lvt_W90p63_L0p74_m1__nf1_gboth_sdfull_pc/B.n79 185
R796 pfet_01v8_lvt_W90p63_L0p74_m1__nf1_gboth_sdfull_pc/B.n445 pfet_01v8_lvt_W90p63_L0p74_m1__nf1_gboth_sdfull_pc/B.n444 185
R797 pfet_01v8_lvt_W90p63_L0p74_m1__nf1_gboth_sdfull_pc/B.n447 pfet_01v8_lvt_W90p63_L0p74_m1__nf1_gboth_sdfull_pc/B.n78 185
R798 pfet_01v8_lvt_W90p63_L0p74_m1__nf1_gboth_sdfull_pc/B.n448 pfet_01v8_lvt_W90p63_L0p74_m1__nf1_gboth_sdfull_pc/B.n77 185
R799 pfet_01v8_lvt_W90p63_L0p74_m1__nf1_gboth_sdfull_pc/B.n451 pfet_01v8_lvt_W90p63_L0p74_m1__nf1_gboth_sdfull_pc/B.n450 185
R800 pfet_01v8_lvt_W90p63_L0p74_m1__nf1_gboth_sdfull_pc/B.n76 pfet_01v8_lvt_W90p63_L0p74_m1__nf1_gboth_sdfull_pc/B.n9 185
R801 pfet_01v8_lvt_W90p63_L0p74_m1__nf1_gboth_sdfull_pc/B.n452 pfet_01v8_lvt_W90p63_L0p74_m1__nf1_gboth_sdfull_pc/B.n76 185
R802 pfet_01v8_lvt_W90p63_L0p74_m1__nf1_gboth_sdfull_pc/B.n454 pfet_01v8_lvt_W90p63_L0p74_m1__nf1_gboth_sdfull_pc/B.n453 185
R803 pfet_01v8_lvt_W90p63_L0p74_m1__nf1_gboth_sdfull_pc/B.n456 pfet_01v8_lvt_W90p63_L0p74_m1__nf1_gboth_sdfull_pc/B.n75 185
R804 pfet_01v8_lvt_W90p63_L0p74_m1__nf1_gboth_sdfull_pc/B.n459 pfet_01v8_lvt_W90p63_L0p74_m1__nf1_gboth_sdfull_pc/B.n458 185
R805 pfet_01v8_lvt_W90p63_L0p74_m1__nf1_gboth_sdfull_pc/B.n460 pfet_01v8_lvt_W90p63_L0p74_m1__nf1_gboth_sdfull_pc/B.n74 185
R806 pfet_01v8_lvt_W90p63_L0p74_m1__nf1_gboth_sdfull_pc/B.n462 pfet_01v8_lvt_W90p63_L0p74_m1__nf1_gboth_sdfull_pc/B.n461 185
R807 pfet_01v8_lvt_W90p63_L0p74_m1__nf1_gboth_sdfull_pc/B.n464 pfet_01v8_lvt_W90p63_L0p74_m1__nf1_gboth_sdfull_pc/B.n73 185
R808 pfet_01v8_lvt_W90p63_L0p74_m1__nf1_gboth_sdfull_pc/B.n466 pfet_01v8_lvt_W90p63_L0p74_m1__nf1_gboth_sdfull_pc/B.n465 185
R809 pfet_01v8_lvt_W90p63_L0p74_m1__nf1_gboth_sdfull_pc/B.n468 pfet_01v8_lvt_W90p63_L0p74_m1__nf1_gboth_sdfull_pc/B.n467 185
R810 pfet_01v8_lvt_W90p63_L0p74_m1__nf1_gboth_sdfull_pc/B.n469 pfet_01v8_lvt_W90p63_L0p74_m1__nf1_gboth_sdfull_pc/B.n71 185
R811 pfet_01v8_lvt_W90p63_L0p74_m1__nf1_gboth_sdfull_pc/B.n472 pfet_01v8_lvt_W90p63_L0p74_m1__nf1_gboth_sdfull_pc/B.n471 185
R812 pfet_01v8_lvt_W90p63_L0p74_m1__nf1_gboth_sdfull_pc/B.n70 pfet_01v8_lvt_W90p63_L0p74_m1__nf1_gboth_sdfull_pc/B.n9 185
R813 pfet_01v8_lvt_W90p63_L0p74_m1__nf1_gboth_sdfull_pc/B.n473 pfet_01v8_lvt_W90p63_L0p74_m1__nf1_gboth_sdfull_pc/B.n70 185
R814 pfet_01v8_lvt_W90p63_L0p74_m1__nf1_gboth_sdfull_pc/B.n475 pfet_01v8_lvt_W90p63_L0p74_m1__nf1_gboth_sdfull_pc/B.n474 185
R815 pfet_01v8_lvt_W90p63_L0p74_m1__nf1_gboth_sdfull_pc/B.n477 pfet_01v8_lvt_W90p63_L0p74_m1__nf1_gboth_sdfull_pc/B.n69 185
R816 pfet_01v8_lvt_W90p63_L0p74_m1__nf1_gboth_sdfull_pc/B.n479 pfet_01v8_lvt_W90p63_L0p74_m1__nf1_gboth_sdfull_pc/B.n478 185
R817 pfet_01v8_lvt_W90p63_L0p74_m1__nf1_gboth_sdfull_pc/B.n481 pfet_01v8_lvt_W90p63_L0p74_m1__nf1_gboth_sdfull_pc/B.n480 185
R818 pfet_01v8_lvt_W90p63_L0p74_m1__nf1_gboth_sdfull_pc/B.n482 pfet_01v8_lvt_W90p63_L0p74_m1__nf1_gboth_sdfull_pc/B.n9 185
R819 pfet_01v8_lvt_W90p63_L0p74_m1__nf1_gboth_sdfull_pc/B.n482 pfet_01v8_lvt_W90p63_L0p74_m1__nf1_gboth_sdfull_pc/B.n67 185
R820 pfet_01v8_lvt_W90p63_L0p74_m1__nf1_gboth_sdfull_pc/B.n485 pfet_01v8_lvt_W90p63_L0p74_m1__nf1_gboth_sdfull_pc/B.n484 185
R821 pfet_01v8_lvt_W90p63_L0p74_m1__nf1_gboth_sdfull_pc/B.n486 pfet_01v8_lvt_W90p63_L0p74_m1__nf1_gboth_sdfull_pc/B.n66 185
R822 pfet_01v8_lvt_W90p63_L0p74_m1__nf1_gboth_sdfull_pc/B.n488 pfet_01v8_lvt_W90p63_L0p74_m1__nf1_gboth_sdfull_pc/B.n487 185
R823 pfet_01v8_lvt_W90p63_L0p74_m1__nf1_gboth_sdfull_pc/B.n490 pfet_01v8_lvt_W90p63_L0p74_m1__nf1_gboth_sdfull_pc/B.n65 185
R824 pfet_01v8_lvt_W90p63_L0p74_m1__nf1_gboth_sdfull_pc/B.n493 pfet_01v8_lvt_W90p63_L0p74_m1__nf1_gboth_sdfull_pc/B.n492 185
R825 pfet_01v8_lvt_W90p63_L0p74_m1__nf1_gboth_sdfull_pc/B.n494 pfet_01v8_lvt_W90p63_L0p74_m1__nf1_gboth_sdfull_pc/B.n64 185
R826 pfet_01v8_lvt_W90p63_L0p74_m1__nf1_gboth_sdfull_pc/B.n496 pfet_01v8_lvt_W90p63_L0p74_m1__nf1_gboth_sdfull_pc/B.n495 185
R827 pfet_01v8_lvt_W90p63_L0p74_m1__nf1_gboth_sdfull_pc/B.n498 pfet_01v8_lvt_W90p63_L0p74_m1__nf1_gboth_sdfull_pc/B.n63 185
R828 pfet_01v8_lvt_W90p63_L0p74_m1__nf1_gboth_sdfull_pc/B.n501 pfet_01v8_lvt_W90p63_L0p74_m1__nf1_gboth_sdfull_pc/B.n500 185
R829 pfet_01v8_lvt_W90p63_L0p74_m1__nf1_gboth_sdfull_pc/B.n502 pfet_01v8_lvt_W90p63_L0p74_m1__nf1_gboth_sdfull_pc/B.n62 185
R830 pfet_01v8_lvt_W90p63_L0p74_m1__nf1_gboth_sdfull_pc/B.n504 pfet_01v8_lvt_W90p63_L0p74_m1__nf1_gboth_sdfull_pc/B.n503 185
R831 pfet_01v8_lvt_W90p63_L0p74_m1__nf1_gboth_sdfull_pc/B.n506 pfet_01v8_lvt_W90p63_L0p74_m1__nf1_gboth_sdfull_pc/B.n61 185
R832 pfet_01v8_lvt_W90p63_L0p74_m1__nf1_gboth_sdfull_pc/B.n507 pfet_01v8_lvt_W90p63_L0p74_m1__nf1_gboth_sdfull_pc/B.n9 185
R833 pfet_01v8_lvt_W90p63_L0p74_m1__nf1_gboth_sdfull_pc/B.n507 pfet_01v8_lvt_W90p63_L0p74_m1__nf1_gboth_sdfull_pc/B.n60 185
R834 pfet_01v8_lvt_W90p63_L0p74_m1__nf1_gboth_sdfull_pc/B.n509 pfet_01v8_lvt_W90p63_L0p74_m1__nf1_gboth_sdfull_pc/B.n508 185
R835 pfet_01v8_lvt_W90p63_L0p74_m1__nf1_gboth_sdfull_pc/B.n511 pfet_01v8_lvt_W90p63_L0p74_m1__nf1_gboth_sdfull_pc/B.n510 185
R836 pfet_01v8_lvt_W90p63_L0p74_m1__nf1_gboth_sdfull_pc/B.n512 pfet_01v8_lvt_W90p63_L0p74_m1__nf1_gboth_sdfull_pc/B.n9 185
R837 pfet_01v8_lvt_W90p63_L0p74_m1__nf1_gboth_sdfull_pc/B.n512 pfet_01v8_lvt_W90p63_L0p74_m1__nf1_gboth_sdfull_pc/B.n58 185
R838 pfet_01v8_lvt_W90p63_L0p74_m1__nf1_gboth_sdfull_pc/B.n514 pfet_01v8_lvt_W90p63_L0p74_m1__nf1_gboth_sdfull_pc/B.n513 185
R839 pfet_01v8_lvt_W90p63_L0p74_m1__nf1_gboth_sdfull_pc/B.n516 pfet_01v8_lvt_W90p63_L0p74_m1__nf1_gboth_sdfull_pc/B.n515 185
R840 pfet_01v8_lvt_W90p63_L0p74_m1__nf1_gboth_sdfull_pc/B.n517 pfet_01v8_lvt_W90p63_L0p74_m1__nf1_gboth_sdfull_pc/B.n9 185
R841 pfet_01v8_lvt_W90p63_L0p74_m1__nf1_gboth_sdfull_pc/B.n517 pfet_01v8_lvt_W90p63_L0p74_m1__nf1_gboth_sdfull_pc/B.n56 185
R842 pfet_01v8_lvt_W90p63_L0p74_m1__nf1_gboth_sdfull_pc/B.n519 pfet_01v8_lvt_W90p63_L0p74_m1__nf1_gboth_sdfull_pc/B.n518 185
R843 pfet_01v8_lvt_W90p63_L0p74_m1__nf1_gboth_sdfull_pc/B.n521 pfet_01v8_lvt_W90p63_L0p74_m1__nf1_gboth_sdfull_pc/B.n520 185
R844 pfet_01v8_lvt_W90p63_L0p74_m1__nf1_gboth_sdfull_pc/B.n522 pfet_01v8_lvt_W90p63_L0p74_m1__nf1_gboth_sdfull_pc/B.n9 185
R845 pfet_01v8_lvt_W90p63_L0p74_m1__nf1_gboth_sdfull_pc/B.n522 pfet_01v8_lvt_W90p63_L0p74_m1__nf1_gboth_sdfull_pc/B.n54 185
R846 pfet_01v8_lvt_W90p63_L0p74_m1__nf1_gboth_sdfull_pc/B.n525 pfet_01v8_lvt_W90p63_L0p74_m1__nf1_gboth_sdfull_pc/B.n524 185
R847 pfet_01v8_lvt_W90p63_L0p74_m1__nf1_gboth_sdfull_pc/B.n526 pfet_01v8_lvt_W90p63_L0p74_m1__nf1_gboth_sdfull_pc/B.n53 185
R848 pfet_01v8_lvt_W90p63_L0p74_m1__nf1_gboth_sdfull_pc/B.n528 pfet_01v8_lvt_W90p63_L0p74_m1__nf1_gboth_sdfull_pc/B.n527 185
R849 pfet_01v8_lvt_W90p63_L0p74_m1__nf1_gboth_sdfull_pc/B.n530 pfet_01v8_lvt_W90p63_L0p74_m1__nf1_gboth_sdfull_pc/B.n52 185
R850 pfet_01v8_lvt_W90p63_L0p74_m1__nf1_gboth_sdfull_pc/B.n532 pfet_01v8_lvt_W90p63_L0p74_m1__nf1_gboth_sdfull_pc/B.n531 185
R851 pfet_01v8_lvt_W90p63_L0p74_m1__nf1_gboth_sdfull_pc/B.n534 pfet_01v8_lvt_W90p63_L0p74_m1__nf1_gboth_sdfull_pc/B.n533 185
R852 pfet_01v8_lvt_W90p63_L0p74_m1__nf1_gboth_sdfull_pc/B.n535 pfet_01v8_lvt_W90p63_L0p74_m1__nf1_gboth_sdfull_pc/B.n9 185
R853 pfet_01v8_lvt_W90p63_L0p74_m1__nf1_gboth_sdfull_pc/B.n535 pfet_01v8_lvt_W90p63_L0p74_m1__nf1_gboth_sdfull_pc/B.n50 185
R854 pfet_01v8_lvt_W90p63_L0p74_m1__nf1_gboth_sdfull_pc/B.n538 pfet_01v8_lvt_W90p63_L0p74_m1__nf1_gboth_sdfull_pc/B.n537 185
R855 pfet_01v8_lvt_W90p63_L0p74_m1__nf1_gboth_sdfull_pc/B.n539 pfet_01v8_lvt_W90p63_L0p74_m1__nf1_gboth_sdfull_pc/B.n49 185
R856 pfet_01v8_lvt_W90p63_L0p74_m1__nf1_gboth_sdfull_pc/B.n541 pfet_01v8_lvt_W90p63_L0p74_m1__nf1_gboth_sdfull_pc/B.n540 185
R857 pfet_01v8_lvt_W90p63_L0p74_m1__nf1_gboth_sdfull_pc/B.n543 pfet_01v8_lvt_W90p63_L0p74_m1__nf1_gboth_sdfull_pc/B.n48 185
R858 pfet_01v8_lvt_W90p63_L0p74_m1__nf1_gboth_sdfull_pc/B.n544 pfet_01v8_lvt_W90p63_L0p74_m1__nf1_gboth_sdfull_pc/B.n9 185
R859 pfet_01v8_lvt_W90p63_L0p74_m1__nf1_gboth_sdfull_pc/B.n544 pfet_01v8_lvt_W90p63_L0p74_m1__nf1_gboth_sdfull_pc/B.n47 185
R860 pfet_01v8_lvt_W90p63_L0p74_m1__nf1_gboth_sdfull_pc/B.n547 pfet_01v8_lvt_W90p63_L0p74_m1__nf1_gboth_sdfull_pc/B.n546 185
R861 pfet_01v8_lvt_W90p63_L0p74_m1__nf1_gboth_sdfull_pc/B.n548 pfet_01v8_lvt_W90p63_L0p74_m1__nf1_gboth_sdfull_pc/B.n46 185
R862 pfet_01v8_lvt_W90p63_L0p74_m1__nf1_gboth_sdfull_pc/B.n550 pfet_01v8_lvt_W90p63_L0p74_m1__nf1_gboth_sdfull_pc/B.n549 185
R863 pfet_01v8_lvt_W90p63_L0p74_m1__nf1_gboth_sdfull_pc/B.n552 pfet_01v8_lvt_W90p63_L0p74_m1__nf1_gboth_sdfull_pc/B.n45 185
R864 pfet_01v8_lvt_W90p63_L0p74_m1__nf1_gboth_sdfull_pc/B.n553 pfet_01v8_lvt_W90p63_L0p74_m1__nf1_gboth_sdfull_pc/B.n9 185
R865 pfet_01v8_lvt_W90p63_L0p74_m1__nf1_gboth_sdfull_pc/B.n553 pfet_01v8_lvt_W90p63_L0p74_m1__nf1_gboth_sdfull_pc/B.n44 185
R866 pfet_01v8_lvt_W90p63_L0p74_m1__nf1_gboth_sdfull_pc/B.n555 pfet_01v8_lvt_W90p63_L0p74_m1__nf1_gboth_sdfull_pc/B.n554 185
R867 pfet_01v8_lvt_W90p63_L0p74_m1__nf1_gboth_sdfull_pc/B.n557 pfet_01v8_lvt_W90p63_L0p74_m1__nf1_gboth_sdfull_pc/B.n556 185
R868 pfet_01v8_lvt_W90p63_L0p74_m1__nf1_gboth_sdfull_pc/B.n558 pfet_01v8_lvt_W90p63_L0p74_m1__nf1_gboth_sdfull_pc/B.n42 185
R869 pfet_01v8_lvt_W90p63_L0p74_m1__nf1_gboth_sdfull_pc/B.n561 pfet_01v8_lvt_W90p63_L0p74_m1__nf1_gboth_sdfull_pc/B.n560 185
R870 pfet_01v8_lvt_W90p63_L0p74_m1__nf1_gboth_sdfull_pc/B.n41 pfet_01v8_lvt_W90p63_L0p74_m1__nf1_gboth_sdfull_pc/B.n9 185
R871 pfet_01v8_lvt_W90p63_L0p74_m1__nf1_gboth_sdfull_pc/B.n562 pfet_01v8_lvt_W90p63_L0p74_m1__nf1_gboth_sdfull_pc/B.n41 185
R872 pfet_01v8_lvt_W90p63_L0p74_m1__nf1_gboth_sdfull_pc/B.n564 pfet_01v8_lvt_W90p63_L0p74_m1__nf1_gboth_sdfull_pc/B.n563 185
R873 pfet_01v8_lvt_W90p63_L0p74_m1__nf1_gboth_sdfull_pc/B.n566 pfet_01v8_lvt_W90p63_L0p74_m1__nf1_gboth_sdfull_pc/B.n40 185
R874 pfet_01v8_lvt_W90p63_L0p74_m1__nf1_gboth_sdfull_pc/B.n568 pfet_01v8_lvt_W90p63_L0p74_m1__nf1_gboth_sdfull_pc/B.n567 185
R875 pfet_01v8_lvt_W90p63_L0p74_m1__nf1_gboth_sdfull_pc/B.n570 pfet_01v8_lvt_W90p63_L0p74_m1__nf1_gboth_sdfull_pc/B.n569 185
R876 pfet_01v8_lvt_W90p63_L0p74_m1__nf1_gboth_sdfull_pc/B.n571 pfet_01v8_lvt_W90p63_L0p74_m1__nf1_gboth_sdfull_pc/B.n9 185
R877 pfet_01v8_lvt_W90p63_L0p74_m1__nf1_gboth_sdfull_pc/B.n571 pfet_01v8_lvt_W90p63_L0p74_m1__nf1_gboth_sdfull_pc/B.n38 185
R878 pfet_01v8_lvt_W90p63_L0p74_m1__nf1_gboth_sdfull_pc/B.n574 pfet_01v8_lvt_W90p63_L0p74_m1__nf1_gboth_sdfull_pc/B.n573 185
R879 pfet_01v8_lvt_W90p63_L0p74_m1__nf1_gboth_sdfull_pc/B.n575 pfet_01v8_lvt_W90p63_L0p74_m1__nf1_gboth_sdfull_pc/B.n37 185
R880 pfet_01v8_lvt_W90p63_L0p74_m1__nf1_gboth_sdfull_pc/B.n577 pfet_01v8_lvt_W90p63_L0p74_m1__nf1_gboth_sdfull_pc/B.n576 185
R881 pfet_01v8_lvt_W90p63_L0p74_m1__nf1_gboth_sdfull_pc/B.n579 pfet_01v8_lvt_W90p63_L0p74_m1__nf1_gboth_sdfull_pc/B.n36 185
R882 pfet_01v8_lvt_W90p63_L0p74_m1__nf1_gboth_sdfull_pc/B.n582 pfet_01v8_lvt_W90p63_L0p74_m1__nf1_gboth_sdfull_pc/B.n581 185
R883 pfet_01v8_lvt_W90p63_L0p74_m1__nf1_gboth_sdfull_pc/B.n583 pfet_01v8_lvt_W90p63_L0p74_m1__nf1_gboth_sdfull_pc/B.n35 185
R884 pfet_01v8_lvt_W90p63_L0p74_m1__nf1_gboth_sdfull_pc/B.n585 pfet_01v8_lvt_W90p63_L0p74_m1__nf1_gboth_sdfull_pc/B.n584 185
R885 pfet_01v8_lvt_W90p63_L0p74_m1__nf1_gboth_sdfull_pc/B.n587 pfet_01v8_lvt_W90p63_L0p74_m1__nf1_gboth_sdfull_pc/B.n34 185
R886 pfet_01v8_lvt_W90p63_L0p74_m1__nf1_gboth_sdfull_pc/B.n589 pfet_01v8_lvt_W90p63_L0p74_m1__nf1_gboth_sdfull_pc/B.n588 185
R887 pfet_01v8_lvt_W90p63_L0p74_m1__nf1_gboth_sdfull_pc/B.n591 pfet_01v8_lvt_W90p63_L0p74_m1__nf1_gboth_sdfull_pc/B.n590 185
R888 pfet_01v8_lvt_W90p63_L0p74_m1__nf1_gboth_sdfull_pc/B.n592 pfet_01v8_lvt_W90p63_L0p74_m1__nf1_gboth_sdfull_pc/B.n32 185
R889 pfet_01v8_lvt_W90p63_L0p74_m1__nf1_gboth_sdfull_pc/B.n595 pfet_01v8_lvt_W90p63_L0p74_m1__nf1_gboth_sdfull_pc/B.n594 185
R890 pfet_01v8_lvt_W90p63_L0p74_m1__nf1_gboth_sdfull_pc/B.n31 pfet_01v8_lvt_W90p63_L0p74_m1__nf1_gboth_sdfull_pc/B.n9 185
R891 pfet_01v8_lvt_W90p63_L0p74_m1__nf1_gboth_sdfull_pc/B.n596 pfet_01v8_lvt_W90p63_L0p74_m1__nf1_gboth_sdfull_pc/B.n31 185
R892 pfet_01v8_lvt_W90p63_L0p74_m1__nf1_gboth_sdfull_pc/B.n598 pfet_01v8_lvt_W90p63_L0p74_m1__nf1_gboth_sdfull_pc/B.n597 185
R893 pfet_01v8_lvt_W90p63_L0p74_m1__nf1_gboth_sdfull_pc/B.n600 pfet_01v8_lvt_W90p63_L0p74_m1__nf1_gboth_sdfull_pc/B.n30 185
R894 pfet_01v8_lvt_W90p63_L0p74_m1__nf1_gboth_sdfull_pc/B.n603 pfet_01v8_lvt_W90p63_L0p74_m1__nf1_gboth_sdfull_pc/B.n602 185
R895 pfet_01v8_lvt_W90p63_L0p74_m1__nf1_gboth_sdfull_pc/B.n604 pfet_01v8_lvt_W90p63_L0p74_m1__nf1_gboth_sdfull_pc/B.n29 185
R896 pfet_01v8_lvt_W90p63_L0p74_m1__nf1_gboth_sdfull_pc/B.n606 pfet_01v8_lvt_W90p63_L0p74_m1__nf1_gboth_sdfull_pc/B.n605 185
R897 pfet_01v8_lvt_W90p63_L0p74_m1__nf1_gboth_sdfull_pc/B.n608 pfet_01v8_lvt_W90p63_L0p74_m1__nf1_gboth_sdfull_pc/B.n28 185
R898 pfet_01v8_lvt_W90p63_L0p74_m1__nf1_gboth_sdfull_pc/B.n611 pfet_01v8_lvt_W90p63_L0p74_m1__nf1_gboth_sdfull_pc/B.n610 185
R899 pfet_01v8_lvt_W90p63_L0p74_m1__nf1_gboth_sdfull_pc/B.n612 pfet_01v8_lvt_W90p63_L0p74_m1__nf1_gboth_sdfull_pc/B.n27 185
R900 pfet_01v8_lvt_W90p63_L0p74_m1__nf1_gboth_sdfull_pc/B.n614 pfet_01v8_lvt_W90p63_L0p74_m1__nf1_gboth_sdfull_pc/B.n613 185
R901 pfet_01v8_lvt_W90p63_L0p74_m1__nf1_gboth_sdfull_pc/B.n616 pfet_01v8_lvt_W90p63_L0p74_m1__nf1_gboth_sdfull_pc/B.n26 185
R902 pfet_01v8_lvt_W90p63_L0p74_m1__nf1_gboth_sdfull_pc/B.n619 pfet_01v8_lvt_W90p63_L0p74_m1__nf1_gboth_sdfull_pc/B.n618 185
R903 pfet_01v8_lvt_W90p63_L0p74_m1__nf1_gboth_sdfull_pc/B.n620 pfet_01v8_lvt_W90p63_L0p74_m1__nf1_gboth_sdfull_pc/B.n25 185
R904 pfet_01v8_lvt_W90p63_L0p74_m1__nf1_gboth_sdfull_pc/B.n622 pfet_01v8_lvt_W90p63_L0p74_m1__nf1_gboth_sdfull_pc/B.n621 185
R905 pfet_01v8_lvt_W90p63_L0p74_m1__nf1_gboth_sdfull_pc/B.n624 pfet_01v8_lvt_W90p63_L0p74_m1__nf1_gboth_sdfull_pc/B.n24 185
R906 pfet_01v8_lvt_W90p63_L0p74_m1__nf1_gboth_sdfull_pc/B.n625 pfet_01v8_lvt_W90p63_L0p74_m1__nf1_gboth_sdfull_pc/B.n9 185
R907 pfet_01v8_lvt_W90p63_L0p74_m1__nf1_gboth_sdfull_pc/B.n625 pfet_01v8_lvt_W90p63_L0p74_m1__nf1_gboth_sdfull_pc/B.n23 185
R908 pfet_01v8_lvt_W90p63_L0p74_m1__nf1_gboth_sdfull_pc/B.n628 pfet_01v8_lvt_W90p63_L0p74_m1__nf1_gboth_sdfull_pc/B.n627 185
R909 pfet_01v8_lvt_W90p63_L0p74_m1__nf1_gboth_sdfull_pc/B.n629 pfet_01v8_lvt_W90p63_L0p74_m1__nf1_gboth_sdfull_pc/B.n22 185
R910 pfet_01v8_lvt_W90p63_L0p74_m1__nf1_gboth_sdfull_pc/B.n631 pfet_01v8_lvt_W90p63_L0p74_m1__nf1_gboth_sdfull_pc/B.n630 185
R911 pfet_01v8_lvt_W90p63_L0p74_m1__nf1_gboth_sdfull_pc/B.n633 pfet_01v8_lvt_W90p63_L0p74_m1__nf1_gboth_sdfull_pc/B.n21 185
R912 pfet_01v8_lvt_W90p63_L0p74_m1__nf1_gboth_sdfull_pc/B.n635 pfet_01v8_lvt_W90p63_L0p74_m1__nf1_gboth_sdfull_pc/B.n634 185
R913 pfet_01v8_lvt_W90p63_L0p74_m1__nf1_gboth_sdfull_pc/B.n637 pfet_01v8_lvt_W90p63_L0p74_m1__nf1_gboth_sdfull_pc/B.n636 185
R914 pfet_01v8_lvt_W90p63_L0p74_m1__nf1_gboth_sdfull_pc/B.n638 pfet_01v8_lvt_W90p63_L0p74_m1__nf1_gboth_sdfull_pc/B.n9 185
R915 pfet_01v8_lvt_W90p63_L0p74_m1__nf1_gboth_sdfull_pc/B.n638 pfet_01v8_lvt_W90p63_L0p74_m1__nf1_gboth_sdfull_pc/B.n19 185
R916 pfet_01v8_lvt_W90p63_L0p74_m1__nf1_gboth_sdfull_pc/B.n640 pfet_01v8_lvt_W90p63_L0p74_m1__nf1_gboth_sdfull_pc/B.n639 185
R917 pfet_01v8_lvt_W90p63_L0p74_m1__nf1_gboth_sdfull_pc/B.n642 pfet_01v8_lvt_W90p63_L0p74_m1__nf1_gboth_sdfull_pc/B.n641 185
R918 pfet_01v8_lvt_W90p63_L0p74_m1__nf1_gboth_sdfull_pc/B.n643 pfet_01v8_lvt_W90p63_L0p74_m1__nf1_gboth_sdfull_pc/B.n9 185
R919 pfet_01v8_lvt_W90p63_L0p74_m1__nf1_gboth_sdfull_pc/B.n643 pfet_01v8_lvt_W90p63_L0p74_m1__nf1_gboth_sdfull_pc/B.n17 185
R920 pfet_01v8_lvt_W90p63_L0p74_m1__nf1_gboth_sdfull_pc/B.n645 pfet_01v8_lvt_W90p63_L0p74_m1__nf1_gboth_sdfull_pc/B.n644 185
R921 pfet_01v8_lvt_W90p63_L0p74_m1__nf1_gboth_sdfull_pc/B.n647 pfet_01v8_lvt_W90p63_L0p74_m1__nf1_gboth_sdfull_pc/B.n646 185
R922 pfet_01v8_lvt_W90p63_L0p74_m1__nf1_gboth_sdfull_pc/B.n648 pfet_01v8_lvt_W90p63_L0p74_m1__nf1_gboth_sdfull_pc/B.n9 185
R923 pfet_01v8_lvt_W90p63_L0p74_m1__nf1_gboth_sdfull_pc/B.n648 pfet_01v8_lvt_W90p63_L0p74_m1__nf1_gboth_sdfull_pc/B.n15 185
R924 pfet_01v8_lvt_W90p63_L0p74_m1__nf1_gboth_sdfull_pc/B.n650 pfet_01v8_lvt_W90p63_L0p74_m1__nf1_gboth_sdfull_pc/B.n649 185
R925 pfet_01v8_lvt_W90p63_L0p74_m1__nf1_gboth_sdfull_pc/B.n652 pfet_01v8_lvt_W90p63_L0p74_m1__nf1_gboth_sdfull_pc/B.n651 185
R926 pfet_01v8_lvt_W90p63_L0p74_m1__nf1_gboth_sdfull_pc/B.n653 pfet_01v8_lvt_W90p63_L0p74_m1__nf1_gboth_sdfull_pc/B.n9 185
R927 pfet_01v8_lvt_W90p63_L0p74_m1__nf1_gboth_sdfull_pc/B.n653 pfet_01v8_lvt_W90p63_L0p74_m1__nf1_gboth_sdfull_pc/B.n13 185
R928 pfet_01v8_lvt_W90p63_L0p74_m1__nf1_gboth_sdfull_pc/B.n656 pfet_01v8_lvt_W90p63_L0p74_m1__nf1_gboth_sdfull_pc/B.n655 185
R929 pfet_01v8_lvt_W90p63_L0p74_m1__nf1_gboth_sdfull_pc/B.n657 pfet_01v8_lvt_W90p63_L0p74_m1__nf1_gboth_sdfull_pc/B.n12 185
R930 pfet_01v8_lvt_W90p63_L0p74_m1__nf1_gboth_sdfull_pc/B.n659 pfet_01v8_lvt_W90p63_L0p74_m1__nf1_gboth_sdfull_pc/B.n658 185
R931 pfet_01v8_lvt_W90p63_L0p74_m1__nf1_gboth_sdfull_pc/B.n661 pfet_01v8_lvt_W90p63_L0p74_m1__nf1_gboth_sdfull_pc/B.n11 185
R932 pfet_01v8_lvt_W90p63_L0p74_m1__nf1_gboth_sdfull_pc/B.n664 pfet_01v8_lvt_W90p63_L0p74_m1__nf1_gboth_sdfull_pc/B.n663 185
R933 pfet_01v8_lvt_W90p63_L0p74_m1__nf1_gboth_sdfull_pc/B.n665 pfet_01v8_lvt_W90p63_L0p74_m1__nf1_gboth_sdfull_pc/B.n10 185
R934 pfet_01v8_lvt_W90p63_L0p74_m1__nf1_gboth_sdfull_pc/B.n827 pfet_01v8_lvt_W90p63_L0p74_m1__nf1_gboth_sdfull_pc/B.n1 80.9417
R935 pfet_01v8_lvt_W90p63_L0p74_m1__nf1_gboth_sdfull_pc/B.n1329 pfet_01v8_lvt_W90p63_L0p74_m1__nf1_gboth_sdfull_pc/B.n1328 80.9417
R936 pfet_01v8_lvt_W90p63_L0p74_m1__nf1_gboth_sdfull_pc/B.n666 pfet_01v8_lvt_W90p63_L0p74_m1__nf1_gboth_sdfull_pc/B.n665 80.9417
R937 pfet_01v8_lvt_W90p63_L0p74_m1__nf1_gboth_sdfull_pc/B.n671 pfet_01v8_lvt_W90p63_L0p74_m1__nf1_gboth_sdfull_pc/B.n7 80.9417
R938 pfet_01v8_lvt_W90p63_L0p74_m1__nf1_gboth_sdfull_pc/B.n831 pfet_01v8_lvt_W90p63_L0p74_m1__nf1_gboth_sdfull_pc/B.n755 72.7879
R939 pfet_01v8_lvt_W90p63_L0p74_m1__nf1_gboth_sdfull_pc/B.n835 pfet_01v8_lvt_W90p63_L0p74_m1__nf1_gboth_sdfull_pc/B.n754 72.7879
R940 pfet_01v8_lvt_W90p63_L0p74_m1__nf1_gboth_sdfull_pc/B.n836 pfet_01v8_lvt_W90p63_L0p74_m1__nf1_gboth_sdfull_pc/B.n757 72.7879
R941 pfet_01v8_lvt_W90p63_L0p74_m1__nf1_gboth_sdfull_pc/B.n840 pfet_01v8_lvt_W90p63_L0p74_m1__nf1_gboth_sdfull_pc/B.n758 72.7879
R942 pfet_01v8_lvt_W90p63_L0p74_m1__nf1_gboth_sdfull_pc/B.n847 pfet_01v8_lvt_W90p63_L0p74_m1__nf1_gboth_sdfull_pc/B.n753 72.7879
R943 pfet_01v8_lvt_W90p63_L0p74_m1__nf1_gboth_sdfull_pc/B.n850 pfet_01v8_lvt_W90p63_L0p74_m1__nf1_gboth_sdfull_pc/B.n752 72.7879
R944 pfet_01v8_lvt_W90p63_L0p74_m1__nf1_gboth_sdfull_pc/B.n855 pfet_01v8_lvt_W90p63_L0p74_m1__nf1_gboth_sdfull_pc/B.n759 72.7879
R945 pfet_01v8_lvt_W90p63_L0p74_m1__nf1_gboth_sdfull_pc/B.n861 pfet_01v8_lvt_W90p63_L0p74_m1__nf1_gboth_sdfull_pc/B.n750 72.7879
R946 pfet_01v8_lvt_W90p63_L0p74_m1__nf1_gboth_sdfull_pc/B.n864 pfet_01v8_lvt_W90p63_L0p74_m1__nf1_gboth_sdfull_pc/B.n749 72.7879
R947 pfet_01v8_lvt_W90p63_L0p74_m1__nf1_gboth_sdfull_pc/B.n870 pfet_01v8_lvt_W90p63_L0p74_m1__nf1_gboth_sdfull_pc/B.n761 72.7879
R948 pfet_01v8_lvt_W90p63_L0p74_m1__nf1_gboth_sdfull_pc/B.n871 pfet_01v8_lvt_W90p63_L0p74_m1__nf1_gboth_sdfull_pc/B.n747 72.7879
R949 pfet_01v8_lvt_W90p63_L0p74_m1__nf1_gboth_sdfull_pc/B.n878 pfet_01v8_lvt_W90p63_L0p74_m1__nf1_gboth_sdfull_pc/B.n762 72.7879
R950 pfet_01v8_lvt_W90p63_L0p74_m1__nf1_gboth_sdfull_pc/B.n882 pfet_01v8_lvt_W90p63_L0p74_m1__nf1_gboth_sdfull_pc/B.n763 72.7879
R951 pfet_01v8_lvt_W90p63_L0p74_m1__nf1_gboth_sdfull_pc/B.n883 pfet_01v8_lvt_W90p63_L0p74_m1__nf1_gboth_sdfull_pc/B.n746 72.7879
R952 pfet_01v8_lvt_W90p63_L0p74_m1__nf1_gboth_sdfull_pc/B.n889 pfet_01v8_lvt_W90p63_L0p74_m1__nf1_gboth_sdfull_pc/B.n764 72.7879
R953 pfet_01v8_lvt_W90p63_L0p74_m1__nf1_gboth_sdfull_pc/B.n892 pfet_01v8_lvt_W90p63_L0p74_m1__nf1_gboth_sdfull_pc/B.n766 72.7879
R954 pfet_01v8_lvt_W90p63_L0p74_m1__nf1_gboth_sdfull_pc/B.n898 pfet_01v8_lvt_W90p63_L0p74_m1__nf1_gboth_sdfull_pc/B.n745 72.7879
R955 pfet_01v8_lvt_W90p63_L0p74_m1__nf1_gboth_sdfull_pc/B.n903 pfet_01v8_lvt_W90p63_L0p74_m1__nf1_gboth_sdfull_pc/B.n767 72.7879
R956 pfet_01v8_lvt_W90p63_L0p74_m1__nf1_gboth_sdfull_pc/B.n909 pfet_01v8_lvt_W90p63_L0p74_m1__nf1_gboth_sdfull_pc/B.n743 72.7879
R957 pfet_01v8_lvt_W90p63_L0p74_m1__nf1_gboth_sdfull_pc/B.n912 pfet_01v8_lvt_W90p63_L0p74_m1__nf1_gboth_sdfull_pc/B.n742 72.7879
R958 pfet_01v8_lvt_W90p63_L0p74_m1__nf1_gboth_sdfull_pc/B.n917 pfet_01v8_lvt_W90p63_L0p74_m1__nf1_gboth_sdfull_pc/B.n769 72.7879
R959 pfet_01v8_lvt_W90p63_L0p74_m1__nf1_gboth_sdfull_pc/B.n922 pfet_01v8_lvt_W90p63_L0p74_m1__nf1_gboth_sdfull_pc/B.n740 72.7879
R960 pfet_01v8_lvt_W90p63_L0p74_m1__nf1_gboth_sdfull_pc/B.n927 pfet_01v8_lvt_W90p63_L0p74_m1__nf1_gboth_sdfull_pc/B.n771 72.7879
R961 pfet_01v8_lvt_W90p63_L0p74_m1__nf1_gboth_sdfull_pc/B.n933 pfet_01v8_lvt_W90p63_L0p74_m1__nf1_gboth_sdfull_pc/B.n738 72.7879
R962 pfet_01v8_lvt_W90p63_L0p74_m1__nf1_gboth_sdfull_pc/B.n936 pfet_01v8_lvt_W90p63_L0p74_m1__nf1_gboth_sdfull_pc/B.n737 72.7879
R963 pfet_01v8_lvt_W90p63_L0p74_m1__nf1_gboth_sdfull_pc/B.n939 pfet_01v8_lvt_W90p63_L0p74_m1__nf1_gboth_sdfull_pc/B.n735 72.7879
R964 pfet_01v8_lvt_W90p63_L0p74_m1__nf1_gboth_sdfull_pc/B.n945 pfet_01v8_lvt_W90p63_L0p74_m1__nf1_gboth_sdfull_pc/B.n773 72.7879
R965 pfet_01v8_lvt_W90p63_L0p74_m1__nf1_gboth_sdfull_pc/B.n950 pfet_01v8_lvt_W90p63_L0p74_m1__nf1_gboth_sdfull_pc/B.n734 72.7879
R966 pfet_01v8_lvt_W90p63_L0p74_m1__nf1_gboth_sdfull_pc/B.n956 pfet_01v8_lvt_W90p63_L0p74_m1__nf1_gboth_sdfull_pc/B.n775 72.7879
R967 pfet_01v8_lvt_W90p63_L0p74_m1__nf1_gboth_sdfull_pc/B.n959 pfet_01v8_lvt_W90p63_L0p74_m1__nf1_gboth_sdfull_pc/B.n776 72.7879
R968 pfet_01v8_lvt_W90p63_L0p74_m1__nf1_gboth_sdfull_pc/B.n965 pfet_01v8_lvt_W90p63_L0p74_m1__nf1_gboth_sdfull_pc/B.n732 72.7879
R969 pfet_01v8_lvt_W90p63_L0p74_m1__nf1_gboth_sdfull_pc/B.n969 pfet_01v8_lvt_W90p63_L0p74_m1__nf1_gboth_sdfull_pc/B.n731 72.7879
R970 pfet_01v8_lvt_W90p63_L0p74_m1__nf1_gboth_sdfull_pc/B.n970 pfet_01v8_lvt_W90p63_L0p74_m1__nf1_gboth_sdfull_pc/B.n778 72.7879
R971 pfet_01v8_lvt_W90p63_L0p74_m1__nf1_gboth_sdfull_pc/B.n977 pfet_01v8_lvt_W90p63_L0p74_m1__nf1_gboth_sdfull_pc/B.n730 72.7879
R972 pfet_01v8_lvt_W90p63_L0p74_m1__nf1_gboth_sdfull_pc/B.n981 pfet_01v8_lvt_W90p63_L0p74_m1__nf1_gboth_sdfull_pc/B.n729 72.7879
R973 pfet_01v8_lvt_W90p63_L0p74_m1__nf1_gboth_sdfull_pc/B.n985 pfet_01v8_lvt_W90p63_L0p74_m1__nf1_gboth_sdfull_pc/B.n728 72.7879
R974 pfet_01v8_lvt_W90p63_L0p74_m1__nf1_gboth_sdfull_pc/B.n986 pfet_01v8_lvt_W90p63_L0p74_m1__nf1_gboth_sdfull_pc/B.n779 72.7879
R975 pfet_01v8_lvt_W90p63_L0p74_m1__nf1_gboth_sdfull_pc/B.n993 pfet_01v8_lvt_W90p63_L0p74_m1__nf1_gboth_sdfull_pc/B.n727 72.7879
R976 pfet_01v8_lvt_W90p63_L0p74_m1__nf1_gboth_sdfull_pc/B.n996 pfet_01v8_lvt_W90p63_L0p74_m1__nf1_gboth_sdfull_pc/B.n726 72.7879
R977 pfet_01v8_lvt_W90p63_L0p74_m1__nf1_gboth_sdfull_pc/B.n1001 pfet_01v8_lvt_W90p63_L0p74_m1__nf1_gboth_sdfull_pc/B.n780 72.7879
R978 pfet_01v8_lvt_W90p63_L0p74_m1__nf1_gboth_sdfull_pc/B.n1006 pfet_01v8_lvt_W90p63_L0p74_m1__nf1_gboth_sdfull_pc/B.n724 72.7879
R979 pfet_01v8_lvt_W90p63_L0p74_m1__nf1_gboth_sdfull_pc/B.n1011 pfet_01v8_lvt_W90p63_L0p74_m1__nf1_gboth_sdfull_pc/B.n782 72.7879
R980 pfet_01v8_lvt_W90p63_L0p74_m1__nf1_gboth_sdfull_pc/B.n1016 pfet_01v8_lvt_W90p63_L0p74_m1__nf1_gboth_sdfull_pc/B.n722 72.7879
R981 pfet_01v8_lvt_W90p63_L0p74_m1__nf1_gboth_sdfull_pc/B.n1022 pfet_01v8_lvt_W90p63_L0p74_m1__nf1_gboth_sdfull_pc/B.n784 72.7879
R982 pfet_01v8_lvt_W90p63_L0p74_m1__nf1_gboth_sdfull_pc/B.n1026 pfet_01v8_lvt_W90p63_L0p74_m1__nf1_gboth_sdfull_pc/B.n785 72.7879
R983 pfet_01v8_lvt_W90p63_L0p74_m1__nf1_gboth_sdfull_pc/B.n1027 pfet_01v8_lvt_W90p63_L0p74_m1__nf1_gboth_sdfull_pc/B.n720 72.7879
R984 pfet_01v8_lvt_W90p63_L0p74_m1__nf1_gboth_sdfull_pc/B.n1033 pfet_01v8_lvt_W90p63_L0p74_m1__nf1_gboth_sdfull_pc/B.n786 72.7879
R985 pfet_01v8_lvt_W90p63_L0p74_m1__nf1_gboth_sdfull_pc/B.n1039 pfet_01v8_lvt_W90p63_L0p74_m1__nf1_gboth_sdfull_pc/B.n719 72.7879
R986 pfet_01v8_lvt_W90p63_L0p74_m1__nf1_gboth_sdfull_pc/B.n1043 pfet_01v8_lvt_W90p63_L0p74_m1__nf1_gboth_sdfull_pc/B.n718 72.7879
R987 pfet_01v8_lvt_W90p63_L0p74_m1__nf1_gboth_sdfull_pc/B.n1047 pfet_01v8_lvt_W90p63_L0p74_m1__nf1_gboth_sdfull_pc/B.n717 72.7879
R988 pfet_01v8_lvt_W90p63_L0p74_m1__nf1_gboth_sdfull_pc/B.n1051 pfet_01v8_lvt_W90p63_L0p74_m1__nf1_gboth_sdfull_pc/B.n716 72.7879
R989 pfet_01v8_lvt_W90p63_L0p74_m1__nf1_gboth_sdfull_pc/B.n1052 pfet_01v8_lvt_W90p63_L0p74_m1__nf1_gboth_sdfull_pc/B.n788 72.7879
R990 pfet_01v8_lvt_W90p63_L0p74_m1__nf1_gboth_sdfull_pc/B.n1058 pfet_01v8_lvt_W90p63_L0p74_m1__nf1_gboth_sdfull_pc/B.n715 72.7879
R991 pfet_01v8_lvt_W90p63_L0p74_m1__nf1_gboth_sdfull_pc/B.n1064 pfet_01v8_lvt_W90p63_L0p74_m1__nf1_gboth_sdfull_pc/B.n789 72.7879
R992 pfet_01v8_lvt_W90p63_L0p74_m1__nf1_gboth_sdfull_pc/B.n1068 pfet_01v8_lvt_W90p63_L0p74_m1__nf1_gboth_sdfull_pc/B.n790 72.7879
R993 pfet_01v8_lvt_W90p63_L0p74_m1__nf1_gboth_sdfull_pc/B.n1072 pfet_01v8_lvt_W90p63_L0p74_m1__nf1_gboth_sdfull_pc/B.n791 72.7879
R994 pfet_01v8_lvt_W90p63_L0p74_m1__nf1_gboth_sdfull_pc/B.n1075 pfet_01v8_lvt_W90p63_L0p74_m1__nf1_gboth_sdfull_pc/B.n792 72.7879
R995 pfet_01v8_lvt_W90p63_L0p74_m1__nf1_gboth_sdfull_pc/B.n1080 pfet_01v8_lvt_W90p63_L0p74_m1__nf1_gboth_sdfull_pc/B.n713 72.7879
R996 pfet_01v8_lvt_W90p63_L0p74_m1__nf1_gboth_sdfull_pc/B.n1085 pfet_01v8_lvt_W90p63_L0p74_m1__nf1_gboth_sdfull_pc/B.n794 72.7879
R997 pfet_01v8_lvt_W90p63_L0p74_m1__nf1_gboth_sdfull_pc/B.n1088 pfet_01v8_lvt_W90p63_L0p74_m1__nf1_gboth_sdfull_pc/B.n796 72.7879
R998 pfet_01v8_lvt_W90p63_L0p74_m1__nf1_gboth_sdfull_pc/B.n1094 pfet_01v8_lvt_W90p63_L0p74_m1__nf1_gboth_sdfull_pc/B.n711 72.7879
R999 pfet_01v8_lvt_W90p63_L0p74_m1__nf1_gboth_sdfull_pc/B.n1100 pfet_01v8_lvt_W90p63_L0p74_m1__nf1_gboth_sdfull_pc/B.n797 72.7879
R1000 pfet_01v8_lvt_W90p63_L0p74_m1__nf1_gboth_sdfull_pc/B.n1104 pfet_01v8_lvt_W90p63_L0p74_m1__nf1_gboth_sdfull_pc/B.n798 72.7879
R1001 pfet_01v8_lvt_W90p63_L0p74_m1__nf1_gboth_sdfull_pc/B.n1107 pfet_01v8_lvt_W90p63_L0p74_m1__nf1_gboth_sdfull_pc/B.n799 72.7879
R1002 pfet_01v8_lvt_W90p63_L0p74_m1__nf1_gboth_sdfull_pc/B.n1110 pfet_01v8_lvt_W90p63_L0p74_m1__nf1_gboth_sdfull_pc/B.n801 72.7879
R1003 pfet_01v8_lvt_W90p63_L0p74_m1__nf1_gboth_sdfull_pc/B.n1117 pfet_01v8_lvt_W90p63_L0p74_m1__nf1_gboth_sdfull_pc/B.n709 72.7879
R1004 pfet_01v8_lvt_W90p63_L0p74_m1__nf1_gboth_sdfull_pc/B.n1120 pfet_01v8_lvt_W90p63_L0p74_m1__nf1_gboth_sdfull_pc/B.n708 72.7879
R1005 pfet_01v8_lvt_W90p63_L0p74_m1__nf1_gboth_sdfull_pc/B.n1126 pfet_01v8_lvt_W90p63_L0p74_m1__nf1_gboth_sdfull_pc/B.n802 72.7879
R1006 pfet_01v8_lvt_W90p63_L0p74_m1__nf1_gboth_sdfull_pc/B.n1127 pfet_01v8_lvt_W90p63_L0p74_m1__nf1_gboth_sdfull_pc/B.n706 72.7879
R1007 pfet_01v8_lvt_W90p63_L0p74_m1__nf1_gboth_sdfull_pc/B.n1133 pfet_01v8_lvt_W90p63_L0p74_m1__nf1_gboth_sdfull_pc/B.n803 72.7879
R1008 pfet_01v8_lvt_W90p63_L0p74_m1__nf1_gboth_sdfull_pc/B.n1138 pfet_01v8_lvt_W90p63_L0p74_m1__nf1_gboth_sdfull_pc/B.n705 72.7879
R1009 pfet_01v8_lvt_W90p63_L0p74_m1__nf1_gboth_sdfull_pc/B.n1144 pfet_01v8_lvt_W90p63_L0p74_m1__nf1_gboth_sdfull_pc/B.n805 72.7879
R1010 pfet_01v8_lvt_W90p63_L0p74_m1__nf1_gboth_sdfull_pc/B.n1148 pfet_01v8_lvt_W90p63_L0p74_m1__nf1_gboth_sdfull_pc/B.n806 72.7879
R1011 pfet_01v8_lvt_W90p63_L0p74_m1__nf1_gboth_sdfull_pc/B.n1149 pfet_01v8_lvt_W90p63_L0p74_m1__nf1_gboth_sdfull_pc/B.n703 72.7879
R1012 pfet_01v8_lvt_W90p63_L0p74_m1__nf1_gboth_sdfull_pc/B.n1155 pfet_01v8_lvt_W90p63_L0p74_m1__nf1_gboth_sdfull_pc/B.n807 72.7879
R1013 pfet_01v8_lvt_W90p63_L0p74_m1__nf1_gboth_sdfull_pc/B.n1158 pfet_01v8_lvt_W90p63_L0p74_m1__nf1_gboth_sdfull_pc/B.n809 72.7879
R1014 pfet_01v8_lvt_W90p63_L0p74_m1__nf1_gboth_sdfull_pc/B.n1165 pfet_01v8_lvt_W90p63_L0p74_m1__nf1_gboth_sdfull_pc/B.n702 72.7879
R1015 pfet_01v8_lvt_W90p63_L0p74_m1__nf1_gboth_sdfull_pc/B.n1166 pfet_01v8_lvt_W90p63_L0p74_m1__nf1_gboth_sdfull_pc/B.n810 72.7879
R1016 pfet_01v8_lvt_W90p63_L0p74_m1__nf1_gboth_sdfull_pc/B.n1173 pfet_01v8_lvt_W90p63_L0p74_m1__nf1_gboth_sdfull_pc/B.n701 72.7879
R1017 pfet_01v8_lvt_W90p63_L0p74_m1__nf1_gboth_sdfull_pc/B.n1176 pfet_01v8_lvt_W90p63_L0p74_m1__nf1_gboth_sdfull_pc/B.n700 72.7879
R1018 pfet_01v8_lvt_W90p63_L0p74_m1__nf1_gboth_sdfull_pc/B.n1182 pfet_01v8_lvt_W90p63_L0p74_m1__nf1_gboth_sdfull_pc/B.n811 72.7879
R1019 pfet_01v8_lvt_W90p63_L0p74_m1__nf1_gboth_sdfull_pc/B.n1183 pfet_01v8_lvt_W90p63_L0p74_m1__nf1_gboth_sdfull_pc/B.n698 72.7879
R1020 pfet_01v8_lvt_W90p63_L0p74_m1__nf1_gboth_sdfull_pc/B.n1190 pfet_01v8_lvt_W90p63_L0p74_m1__nf1_gboth_sdfull_pc/B.n812 72.7879
R1021 pfet_01v8_lvt_W90p63_L0p74_m1__nf1_gboth_sdfull_pc/B.n1191 pfet_01v8_lvt_W90p63_L0p74_m1__nf1_gboth_sdfull_pc/B.n697 72.7879
R1022 pfet_01v8_lvt_W90p63_L0p74_m1__nf1_gboth_sdfull_pc/B.n1198 pfet_01v8_lvt_W90p63_L0p74_m1__nf1_gboth_sdfull_pc/B.n813 72.7879
R1023 pfet_01v8_lvt_W90p63_L0p74_m1__nf1_gboth_sdfull_pc/B.n1202 pfet_01v8_lvt_W90p63_L0p74_m1__nf1_gboth_sdfull_pc/B.n814 72.7879
R1024 pfet_01v8_lvt_W90p63_L0p74_m1__nf1_gboth_sdfull_pc/B.n1203 pfet_01v8_lvt_W90p63_L0p74_m1__nf1_gboth_sdfull_pc/B.n696 72.7879
R1025 pfet_01v8_lvt_W90p63_L0p74_m1__nf1_gboth_sdfull_pc/B.n1209 pfet_01v8_lvt_W90p63_L0p74_m1__nf1_gboth_sdfull_pc/B.n815 72.7879
R1026 pfet_01v8_lvt_W90p63_L0p74_m1__nf1_gboth_sdfull_pc/B.n1215 pfet_01v8_lvt_W90p63_L0p74_m1__nf1_gboth_sdfull_pc/B.n695 72.7879
R1027 pfet_01v8_lvt_W90p63_L0p74_m1__nf1_gboth_sdfull_pc/B.n1219 pfet_01v8_lvt_W90p63_L0p74_m1__nf1_gboth_sdfull_pc/B.n694 72.7879
R1028 pfet_01v8_lvt_W90p63_L0p74_m1__nf1_gboth_sdfull_pc/B.n1223 pfet_01v8_lvt_W90p63_L0p74_m1__nf1_gboth_sdfull_pc/B.n693 72.7879
R1029 pfet_01v8_lvt_W90p63_L0p74_m1__nf1_gboth_sdfull_pc/B.n1224 pfet_01v8_lvt_W90p63_L0p74_m1__nf1_gboth_sdfull_pc/B.n817 72.7879
R1030 pfet_01v8_lvt_W90p63_L0p74_m1__nf1_gboth_sdfull_pc/B.n1231 pfet_01v8_lvt_W90p63_L0p74_m1__nf1_gboth_sdfull_pc/B.n692 72.7879
R1031 pfet_01v8_lvt_W90p63_L0p74_m1__nf1_gboth_sdfull_pc/B.n1235 pfet_01v8_lvt_W90p63_L0p74_m1__nf1_gboth_sdfull_pc/B.n691 72.7879
R1032 pfet_01v8_lvt_W90p63_L0p74_m1__nf1_gboth_sdfull_pc/B.n1236 pfet_01v8_lvt_W90p63_L0p74_m1__nf1_gboth_sdfull_pc/B.n818 72.7879
R1033 pfet_01v8_lvt_W90p63_L0p74_m1__nf1_gboth_sdfull_pc/B.n1243 pfet_01v8_lvt_W90p63_L0p74_m1__nf1_gboth_sdfull_pc/B.n690 72.7879
R1034 pfet_01v8_lvt_W90p63_L0p74_m1__nf1_gboth_sdfull_pc/B.n1247 pfet_01v8_lvt_W90p63_L0p74_m1__nf1_gboth_sdfull_pc/B.n689 72.7879
R1035 pfet_01v8_lvt_W90p63_L0p74_m1__nf1_gboth_sdfull_pc/B.n1251 pfet_01v8_lvt_W90p63_L0p74_m1__nf1_gboth_sdfull_pc/B.n688 72.7879
R1036 pfet_01v8_lvt_W90p63_L0p74_m1__nf1_gboth_sdfull_pc/B.n1255 pfet_01v8_lvt_W90p63_L0p74_m1__nf1_gboth_sdfull_pc/B.n687 72.7879
R1037 pfet_01v8_lvt_W90p63_L0p74_m1__nf1_gboth_sdfull_pc/B.n1259 pfet_01v8_lvt_W90p63_L0p74_m1__nf1_gboth_sdfull_pc/B.n686 72.7879
R1038 pfet_01v8_lvt_W90p63_L0p74_m1__nf1_gboth_sdfull_pc/B.n1263 pfet_01v8_lvt_W90p63_L0p74_m1__nf1_gboth_sdfull_pc/B.n685 72.7879
R1039 pfet_01v8_lvt_W90p63_L0p74_m1__nf1_gboth_sdfull_pc/B.n1267 pfet_01v8_lvt_W90p63_L0p74_m1__nf1_gboth_sdfull_pc/B.n684 72.7879
R1040 pfet_01v8_lvt_W90p63_L0p74_m1__nf1_gboth_sdfull_pc/B.n1271 pfet_01v8_lvt_W90p63_L0p74_m1__nf1_gboth_sdfull_pc/B.n683 72.7879
R1041 pfet_01v8_lvt_W90p63_L0p74_m1__nf1_gboth_sdfull_pc/B.n1275 pfet_01v8_lvt_W90p63_L0p74_m1__nf1_gboth_sdfull_pc/B.n682 72.7879
R1042 pfet_01v8_lvt_W90p63_L0p74_m1__nf1_gboth_sdfull_pc/B.n1279 pfet_01v8_lvt_W90p63_L0p74_m1__nf1_gboth_sdfull_pc/B.n681 72.7879
R1043 pfet_01v8_lvt_W90p63_L0p74_m1__nf1_gboth_sdfull_pc/B.n1280 pfet_01v8_lvt_W90p63_L0p74_m1__nf1_gboth_sdfull_pc/B.n819 72.7879
R1044 pfet_01v8_lvt_W90p63_L0p74_m1__nf1_gboth_sdfull_pc/B.n1287 pfet_01v8_lvt_W90p63_L0p74_m1__nf1_gboth_sdfull_pc/B.n680 72.7879
R1045 pfet_01v8_lvt_W90p63_L0p74_m1__nf1_gboth_sdfull_pc/B.n1291 pfet_01v8_lvt_W90p63_L0p74_m1__nf1_gboth_sdfull_pc/B.n679 72.7879
R1046 pfet_01v8_lvt_W90p63_L0p74_m1__nf1_gboth_sdfull_pc/B.n1292 pfet_01v8_lvt_W90p63_L0p74_m1__nf1_gboth_sdfull_pc/B.n820 72.7879
R1047 pfet_01v8_lvt_W90p63_L0p74_m1__nf1_gboth_sdfull_pc/B.n1299 pfet_01v8_lvt_W90p63_L0p74_m1__nf1_gboth_sdfull_pc/B.n678 72.7879
R1048 pfet_01v8_lvt_W90p63_L0p74_m1__nf1_gboth_sdfull_pc/B.n1300 pfet_01v8_lvt_W90p63_L0p74_m1__nf1_gboth_sdfull_pc/B.n821 72.7879
R1049 pfet_01v8_lvt_W90p63_L0p74_m1__nf1_gboth_sdfull_pc/B.n1307 pfet_01v8_lvt_W90p63_L0p74_m1__nf1_gboth_sdfull_pc/B.n677 72.7879
R1050 pfet_01v8_lvt_W90p63_L0p74_m1__nf1_gboth_sdfull_pc/B.n1308 pfet_01v8_lvt_W90p63_L0p74_m1__nf1_gboth_sdfull_pc/B.n822 72.7879
R1051 pfet_01v8_lvt_W90p63_L0p74_m1__nf1_gboth_sdfull_pc/B.n1314 pfet_01v8_lvt_W90p63_L0p74_m1__nf1_gboth_sdfull_pc/B.n676 72.7879
R1052 pfet_01v8_lvt_W90p63_L0p74_m1__nf1_gboth_sdfull_pc/B.n1319 pfet_01v8_lvt_W90p63_L0p74_m1__nf1_gboth_sdfull_pc/B.n823 72.7879
R1053 pfet_01v8_lvt_W90p63_L0p74_m1__nf1_gboth_sdfull_pc/B.n1324 pfet_01v8_lvt_W90p63_L0p74_m1__nf1_gboth_sdfull_pc/B.n1323 72.7879
R1054 pfet_01v8_lvt_W90p63_L0p74_m1__nf1_gboth_sdfull_pc/B.n1326 pfet_01v8_lvt_W90p63_L0p74_m1__nf1_gboth_sdfull_pc/B.n674 72.7879
R1055 pfet_01v8_lvt_W90p63_L0p74_m1__nf1_gboth_sdfull_pc/B.n159 pfet_01v8_lvt_W90p63_L0p74_m1__nf1_gboth_sdfull_pc/B.n158 72.7879
R1056 pfet_01v8_lvt_W90p63_L0p74_m1__nf1_gboth_sdfull_pc/B.n163 pfet_01v8_lvt_W90p63_L0p74_m1__nf1_gboth_sdfull_pc/B.n162 72.7879
R1057 pfet_01v8_lvt_W90p63_L0p74_m1__nf1_gboth_sdfull_pc/B.n165 pfet_01v8_lvt_W90p63_L0p74_m1__nf1_gboth_sdfull_pc/B.n156 72.7879
R1058 pfet_01v8_lvt_W90p63_L0p74_m1__nf1_gboth_sdfull_pc/B.n170 pfet_01v8_lvt_W90p63_L0p74_m1__nf1_gboth_sdfull_pc/B.n154 72.7879
R1059 pfet_01v8_lvt_W90p63_L0p74_m1__nf1_gboth_sdfull_pc/B.n175 pfet_01v8_lvt_W90p63_L0p74_m1__nf1_gboth_sdfull_pc/B.n152 72.7879
R1060 pfet_01v8_lvt_W90p63_L0p74_m1__nf1_gboth_sdfull_pc/B.n181 pfet_01v8_lvt_W90p63_L0p74_m1__nf1_gboth_sdfull_pc/B.n180 72.7879
R1061 pfet_01v8_lvt_W90p63_L0p74_m1__nf1_gboth_sdfull_pc/B.n186 pfet_01v8_lvt_W90p63_L0p74_m1__nf1_gboth_sdfull_pc/B.n185 72.7879
R1062 pfet_01v8_lvt_W90p63_L0p74_m1__nf1_gboth_sdfull_pc/B.n189 pfet_01v8_lvt_W90p63_L0p74_m1__nf1_gboth_sdfull_pc/B.n188 72.7879
R1063 pfet_01v8_lvt_W90p63_L0p74_m1__nf1_gboth_sdfull_pc/B.n194 pfet_01v8_lvt_W90p63_L0p74_m1__nf1_gboth_sdfull_pc/B.n193 72.7879
R1064 pfet_01v8_lvt_W90p63_L0p74_m1__nf1_gboth_sdfull_pc/B.n196 pfet_01v8_lvt_W90p63_L0p74_m1__nf1_gboth_sdfull_pc/B.n146 72.7879
R1065 pfet_01v8_lvt_W90p63_L0p74_m1__nf1_gboth_sdfull_pc/B.n202 pfet_01v8_lvt_W90p63_L0p74_m1__nf1_gboth_sdfull_pc/B.n201 72.7879
R1066 pfet_01v8_lvt_W90p63_L0p74_m1__nf1_gboth_sdfull_pc/B.n204 pfet_01v8_lvt_W90p63_L0p74_m1__nf1_gboth_sdfull_pc/B.n144 72.7879
R1067 pfet_01v8_lvt_W90p63_L0p74_m1__nf1_gboth_sdfull_pc/B.n210 pfet_01v8_lvt_W90p63_L0p74_m1__nf1_gboth_sdfull_pc/B.n209 72.7879
R1068 pfet_01v8_lvt_W90p63_L0p74_m1__nf1_gboth_sdfull_pc/B.n215 pfet_01v8_lvt_W90p63_L0p74_m1__nf1_gboth_sdfull_pc/B.n214 72.7879
R1069 pfet_01v8_lvt_W90p63_L0p74_m1__nf1_gboth_sdfull_pc/B.n218 pfet_01v8_lvt_W90p63_L0p74_m1__nf1_gboth_sdfull_pc/B.n217 72.7879
R1070 pfet_01v8_lvt_W90p63_L0p74_m1__nf1_gboth_sdfull_pc/B.n224 pfet_01v8_lvt_W90p63_L0p74_m1__nf1_gboth_sdfull_pc/B.n223 72.7879
R1071 pfet_01v8_lvt_W90p63_L0p74_m1__nf1_gboth_sdfull_pc/B.n226 pfet_01v8_lvt_W90p63_L0p74_m1__nf1_gboth_sdfull_pc/B.n225 72.7879
R1072 pfet_01v8_lvt_W90p63_L0p74_m1__nf1_gboth_sdfull_pc/B.n232 pfet_01v8_lvt_W90p63_L0p74_m1__nf1_gboth_sdfull_pc/B.n231 72.7879
R1073 pfet_01v8_lvt_W90p63_L0p74_m1__nf1_gboth_sdfull_pc/B.n233 pfet_01v8_lvt_W90p63_L0p74_m1__nf1_gboth_sdfull_pc/B.n136 72.7879
R1074 pfet_01v8_lvt_W90p63_L0p74_m1__nf1_gboth_sdfull_pc/B.n239 pfet_01v8_lvt_W90p63_L0p74_m1__nf1_gboth_sdfull_pc/B.n238 72.7879
R1075 pfet_01v8_lvt_W90p63_L0p74_m1__nf1_gboth_sdfull_pc/B.n241 pfet_01v8_lvt_W90p63_L0p74_m1__nf1_gboth_sdfull_pc/B.n134 72.7879
R1076 pfet_01v8_lvt_W90p63_L0p74_m1__nf1_gboth_sdfull_pc/B.n248 pfet_01v8_lvt_W90p63_L0p74_m1__nf1_gboth_sdfull_pc/B.n247 72.7879
R1077 pfet_01v8_lvt_W90p63_L0p74_m1__nf1_gboth_sdfull_pc/B.n250 pfet_01v8_lvt_W90p63_L0p74_m1__nf1_gboth_sdfull_pc/B.n249 72.7879
R1078 pfet_01v8_lvt_W90p63_L0p74_m1__nf1_gboth_sdfull_pc/B.n256 pfet_01v8_lvt_W90p63_L0p74_m1__nf1_gboth_sdfull_pc/B.n255 72.7879
R1079 pfet_01v8_lvt_W90p63_L0p74_m1__nf1_gboth_sdfull_pc/B.n257 pfet_01v8_lvt_W90p63_L0p74_m1__nf1_gboth_sdfull_pc/B.n130 72.7879
R1080 pfet_01v8_lvt_W90p63_L0p74_m1__nf1_gboth_sdfull_pc/B.n264 pfet_01v8_lvt_W90p63_L0p74_m1__nf1_gboth_sdfull_pc/B.n263 72.7879
R1081 pfet_01v8_lvt_W90p63_L0p74_m1__nf1_gboth_sdfull_pc/B.n266 pfet_01v8_lvt_W90p63_L0p74_m1__nf1_gboth_sdfull_pc/B.n265 72.7879
R1082 pfet_01v8_lvt_W90p63_L0p74_m1__nf1_gboth_sdfull_pc/B.n271 pfet_01v8_lvt_W90p63_L0p74_m1__nf1_gboth_sdfull_pc/B.n270 72.7879
R1083 pfet_01v8_lvt_W90p63_L0p74_m1__nf1_gboth_sdfull_pc/B.n274 pfet_01v8_lvt_W90p63_L0p74_m1__nf1_gboth_sdfull_pc/B.n273 72.7879
R1084 pfet_01v8_lvt_W90p63_L0p74_m1__nf1_gboth_sdfull_pc/B.n279 pfet_01v8_lvt_W90p63_L0p74_m1__nf1_gboth_sdfull_pc/B.n278 72.7879
R1085 pfet_01v8_lvt_W90p63_L0p74_m1__nf1_gboth_sdfull_pc/B.n282 pfet_01v8_lvt_W90p63_L0p74_m1__nf1_gboth_sdfull_pc/B.n281 72.7879
R1086 pfet_01v8_lvt_W90p63_L0p74_m1__nf1_gboth_sdfull_pc/B.n288 pfet_01v8_lvt_W90p63_L0p74_m1__nf1_gboth_sdfull_pc/B.n287 72.7879
R1087 pfet_01v8_lvt_W90p63_L0p74_m1__nf1_gboth_sdfull_pc/B.n290 pfet_01v8_lvt_W90p63_L0p74_m1__nf1_gboth_sdfull_pc/B.n121 72.7879
R1088 pfet_01v8_lvt_W90p63_L0p74_m1__nf1_gboth_sdfull_pc/B.n295 pfet_01v8_lvt_W90p63_L0p74_m1__nf1_gboth_sdfull_pc/B.n294 72.7879
R1089 pfet_01v8_lvt_W90p63_L0p74_m1__nf1_gboth_sdfull_pc/B.n301 pfet_01v8_lvt_W90p63_L0p74_m1__nf1_gboth_sdfull_pc/B.n300 72.7879
R1090 pfet_01v8_lvt_W90p63_L0p74_m1__nf1_gboth_sdfull_pc/B.n303 pfet_01v8_lvt_W90p63_L0p74_m1__nf1_gboth_sdfull_pc/B.n117 72.7879
R1091 pfet_01v8_lvt_W90p63_L0p74_m1__nf1_gboth_sdfull_pc/B.n309 pfet_01v8_lvt_W90p63_L0p74_m1__nf1_gboth_sdfull_pc/B.n308 72.7879
R1092 pfet_01v8_lvt_W90p63_L0p74_m1__nf1_gboth_sdfull_pc/B.n311 pfet_01v8_lvt_W90p63_L0p74_m1__nf1_gboth_sdfull_pc/B.n115 72.7879
R1093 pfet_01v8_lvt_W90p63_L0p74_m1__nf1_gboth_sdfull_pc/B.n317 pfet_01v8_lvt_W90p63_L0p74_m1__nf1_gboth_sdfull_pc/B.n316 72.7879
R1094 pfet_01v8_lvt_W90p63_L0p74_m1__nf1_gboth_sdfull_pc/B.n323 pfet_01v8_lvt_W90p63_L0p74_m1__nf1_gboth_sdfull_pc/B.n322 72.7879
R1095 pfet_01v8_lvt_W90p63_L0p74_m1__nf1_gboth_sdfull_pc/B.n324 pfet_01v8_lvt_W90p63_L0p74_m1__nf1_gboth_sdfull_pc/B.n111 72.7879
R1096 pfet_01v8_lvt_W90p63_L0p74_m1__nf1_gboth_sdfull_pc/B.n330 pfet_01v8_lvt_W90p63_L0p74_m1__nf1_gboth_sdfull_pc/B.n329 72.7879
R1097 pfet_01v8_lvt_W90p63_L0p74_m1__nf1_gboth_sdfull_pc/B.n335 pfet_01v8_lvt_W90p63_L0p74_m1__nf1_gboth_sdfull_pc/B.n334 72.7879
R1098 pfet_01v8_lvt_W90p63_L0p74_m1__nf1_gboth_sdfull_pc/B.n338 pfet_01v8_lvt_W90p63_L0p74_m1__nf1_gboth_sdfull_pc/B.n337 72.7879
R1099 pfet_01v8_lvt_W90p63_L0p74_m1__nf1_gboth_sdfull_pc/B.n343 pfet_01v8_lvt_W90p63_L0p74_m1__nf1_gboth_sdfull_pc/B.n342 72.7879
R1100 pfet_01v8_lvt_W90p63_L0p74_m1__nf1_gboth_sdfull_pc/B.n346 pfet_01v8_lvt_W90p63_L0p74_m1__nf1_gboth_sdfull_pc/B.n345 72.7879
R1101 pfet_01v8_lvt_W90p63_L0p74_m1__nf1_gboth_sdfull_pc/B.n352 pfet_01v8_lvt_W90p63_L0p74_m1__nf1_gboth_sdfull_pc/B.n351 72.7879
R1102 pfet_01v8_lvt_W90p63_L0p74_m1__nf1_gboth_sdfull_pc/B.n354 pfet_01v8_lvt_W90p63_L0p74_m1__nf1_gboth_sdfull_pc/B.n353 72.7879
R1103 pfet_01v8_lvt_W90p63_L0p74_m1__nf1_gboth_sdfull_pc/B.n359 pfet_01v8_lvt_W90p63_L0p74_m1__nf1_gboth_sdfull_pc/B.n358 72.7879
R1104 pfet_01v8_lvt_W90p63_L0p74_m1__nf1_gboth_sdfull_pc/B.n361 pfet_01v8_lvt_W90p63_L0p74_m1__nf1_gboth_sdfull_pc/B.n101 72.7879
R1105 pfet_01v8_lvt_W90p63_L0p74_m1__nf1_gboth_sdfull_pc/B.n367 pfet_01v8_lvt_W90p63_L0p74_m1__nf1_gboth_sdfull_pc/B.n366 72.7879
R1106 pfet_01v8_lvt_W90p63_L0p74_m1__nf1_gboth_sdfull_pc/B.n369 pfet_01v8_lvt_W90p63_L0p74_m1__nf1_gboth_sdfull_pc/B.n99 72.7879
R1107 pfet_01v8_lvt_W90p63_L0p74_m1__nf1_gboth_sdfull_pc/B.n375 pfet_01v8_lvt_W90p63_L0p74_m1__nf1_gboth_sdfull_pc/B.n374 72.7879
R1108 pfet_01v8_lvt_W90p63_L0p74_m1__nf1_gboth_sdfull_pc/B.n378 pfet_01v8_lvt_W90p63_L0p74_m1__nf1_gboth_sdfull_pc/B.n377 72.7879
R1109 pfet_01v8_lvt_W90p63_L0p74_m1__nf1_gboth_sdfull_pc/B.n384 pfet_01v8_lvt_W90p63_L0p74_m1__nf1_gboth_sdfull_pc/B.n383 72.7879
R1110 pfet_01v8_lvt_W90p63_L0p74_m1__nf1_gboth_sdfull_pc/B.n385 pfet_01v8_lvt_W90p63_L0p74_m1__nf1_gboth_sdfull_pc/B.n95 72.7879
R1111 pfet_01v8_lvt_W90p63_L0p74_m1__nf1_gboth_sdfull_pc/B.n391 pfet_01v8_lvt_W90p63_L0p74_m1__nf1_gboth_sdfull_pc/B.n390 72.7879
R1112 pfet_01v8_lvt_W90p63_L0p74_m1__nf1_gboth_sdfull_pc/B.n396 pfet_01v8_lvt_W90p63_L0p74_m1__nf1_gboth_sdfull_pc/B.n395 72.7879
R1113 pfet_01v8_lvt_W90p63_L0p74_m1__nf1_gboth_sdfull_pc/B.n399 pfet_01v8_lvt_W90p63_L0p74_m1__nf1_gboth_sdfull_pc/B.n398 72.7879
R1114 pfet_01v8_lvt_W90p63_L0p74_m1__nf1_gboth_sdfull_pc/B.n404 pfet_01v8_lvt_W90p63_L0p74_m1__nf1_gboth_sdfull_pc/B.n403 72.7879
R1115 pfet_01v8_lvt_W90p63_L0p74_m1__nf1_gboth_sdfull_pc/B.n406 pfet_01v8_lvt_W90p63_L0p74_m1__nf1_gboth_sdfull_pc/B.n89 72.7879
R1116 pfet_01v8_lvt_W90p63_L0p74_m1__nf1_gboth_sdfull_pc/B.n413 pfet_01v8_lvt_W90p63_L0p74_m1__nf1_gboth_sdfull_pc/B.n412 72.7879
R1117 pfet_01v8_lvt_W90p63_L0p74_m1__nf1_gboth_sdfull_pc/B.n414 pfet_01v8_lvt_W90p63_L0p74_m1__nf1_gboth_sdfull_pc/B.n87 72.7879
R1118 pfet_01v8_lvt_W90p63_L0p74_m1__nf1_gboth_sdfull_pc/B.n419 pfet_01v8_lvt_W90p63_L0p74_m1__nf1_gboth_sdfull_pc/B.n85 72.7879
R1119 pfet_01v8_lvt_W90p63_L0p74_m1__nf1_gboth_sdfull_pc/B.n425 pfet_01v8_lvt_W90p63_L0p74_m1__nf1_gboth_sdfull_pc/B.n424 72.7879
R1120 pfet_01v8_lvt_W90p63_L0p74_m1__nf1_gboth_sdfull_pc/B.n430 pfet_01v8_lvt_W90p63_L0p74_m1__nf1_gboth_sdfull_pc/B.n429 72.7879
R1121 pfet_01v8_lvt_W90p63_L0p74_m1__nf1_gboth_sdfull_pc/B.n432 pfet_01v8_lvt_W90p63_L0p74_m1__nf1_gboth_sdfull_pc/B.n81 72.7879
R1122 pfet_01v8_lvt_W90p63_L0p74_m1__nf1_gboth_sdfull_pc/B.n439 pfet_01v8_lvt_W90p63_L0p74_m1__nf1_gboth_sdfull_pc/B.n438 72.7879
R1123 pfet_01v8_lvt_W90p63_L0p74_m1__nf1_gboth_sdfull_pc/B.n441 pfet_01v8_lvt_W90p63_L0p74_m1__nf1_gboth_sdfull_pc/B.n440 72.7879
R1124 pfet_01v8_lvt_W90p63_L0p74_m1__nf1_gboth_sdfull_pc/B.n447 pfet_01v8_lvt_W90p63_L0p74_m1__nf1_gboth_sdfull_pc/B.n446 72.7879
R1125 pfet_01v8_lvt_W90p63_L0p74_m1__nf1_gboth_sdfull_pc/B.n449 pfet_01v8_lvt_W90p63_L0p74_m1__nf1_gboth_sdfull_pc/B.n448 72.7879
R1126 pfet_01v8_lvt_W90p63_L0p74_m1__nf1_gboth_sdfull_pc/B.n455 pfet_01v8_lvt_W90p63_L0p74_m1__nf1_gboth_sdfull_pc/B.n454 72.7879
R1127 pfet_01v8_lvt_W90p63_L0p74_m1__nf1_gboth_sdfull_pc/B.n457 pfet_01v8_lvt_W90p63_L0p74_m1__nf1_gboth_sdfull_pc/B.n74 72.7879
R1128 pfet_01v8_lvt_W90p63_L0p74_m1__nf1_gboth_sdfull_pc/B.n463 pfet_01v8_lvt_W90p63_L0p74_m1__nf1_gboth_sdfull_pc/B.n462 72.7879
R1129 pfet_01v8_lvt_W90p63_L0p74_m1__nf1_gboth_sdfull_pc/B.n465 pfet_01v8_lvt_W90p63_L0p74_m1__nf1_gboth_sdfull_pc/B.n72 72.7879
R1130 pfet_01v8_lvt_W90p63_L0p74_m1__nf1_gboth_sdfull_pc/B.n471 pfet_01v8_lvt_W90p63_L0p74_m1__nf1_gboth_sdfull_pc/B.n470 72.7879
R1131 pfet_01v8_lvt_W90p63_L0p74_m1__nf1_gboth_sdfull_pc/B.n476 pfet_01v8_lvt_W90p63_L0p74_m1__nf1_gboth_sdfull_pc/B.n475 72.7879
R1132 pfet_01v8_lvt_W90p63_L0p74_m1__nf1_gboth_sdfull_pc/B.n478 pfet_01v8_lvt_W90p63_L0p74_m1__nf1_gboth_sdfull_pc/B.n68 72.7879
R1133 pfet_01v8_lvt_W90p63_L0p74_m1__nf1_gboth_sdfull_pc/B.n484 pfet_01v8_lvt_W90p63_L0p74_m1__nf1_gboth_sdfull_pc/B.n483 72.7879
R1134 pfet_01v8_lvt_W90p63_L0p74_m1__nf1_gboth_sdfull_pc/B.n490 pfet_01v8_lvt_W90p63_L0p74_m1__nf1_gboth_sdfull_pc/B.n489 72.7879
R1135 pfet_01v8_lvt_W90p63_L0p74_m1__nf1_gboth_sdfull_pc/B.n491 pfet_01v8_lvt_W90p63_L0p74_m1__nf1_gboth_sdfull_pc/B.n64 72.7879
R1136 pfet_01v8_lvt_W90p63_L0p74_m1__nf1_gboth_sdfull_pc/B.n497 pfet_01v8_lvt_W90p63_L0p74_m1__nf1_gboth_sdfull_pc/B.n496 72.7879
R1137 pfet_01v8_lvt_W90p63_L0p74_m1__nf1_gboth_sdfull_pc/B.n499 pfet_01v8_lvt_W90p63_L0p74_m1__nf1_gboth_sdfull_pc/B.n62 72.7879
R1138 pfet_01v8_lvt_W90p63_L0p74_m1__nf1_gboth_sdfull_pc/B.n506 pfet_01v8_lvt_W90p63_L0p74_m1__nf1_gboth_sdfull_pc/B.n505 72.7879
R1139 pfet_01v8_lvt_W90p63_L0p74_m1__nf1_gboth_sdfull_pc/B.n508 pfet_01v8_lvt_W90p63_L0p74_m1__nf1_gboth_sdfull_pc/B.n59 72.7879
R1140 pfet_01v8_lvt_W90p63_L0p74_m1__nf1_gboth_sdfull_pc/B.n513 pfet_01v8_lvt_W90p63_L0p74_m1__nf1_gboth_sdfull_pc/B.n57 72.7879
R1141 pfet_01v8_lvt_W90p63_L0p74_m1__nf1_gboth_sdfull_pc/B.n518 pfet_01v8_lvt_W90p63_L0p74_m1__nf1_gboth_sdfull_pc/B.n55 72.7879
R1142 pfet_01v8_lvt_W90p63_L0p74_m1__nf1_gboth_sdfull_pc/B.n524 pfet_01v8_lvt_W90p63_L0p74_m1__nf1_gboth_sdfull_pc/B.n523 72.7879
R1143 pfet_01v8_lvt_W90p63_L0p74_m1__nf1_gboth_sdfull_pc/B.n529 pfet_01v8_lvt_W90p63_L0p74_m1__nf1_gboth_sdfull_pc/B.n528 72.7879
R1144 pfet_01v8_lvt_W90p63_L0p74_m1__nf1_gboth_sdfull_pc/B.n531 pfet_01v8_lvt_W90p63_L0p74_m1__nf1_gboth_sdfull_pc/B.n51 72.7879
R1145 pfet_01v8_lvt_W90p63_L0p74_m1__nf1_gboth_sdfull_pc/B.n537 pfet_01v8_lvt_W90p63_L0p74_m1__nf1_gboth_sdfull_pc/B.n536 72.7879
R1146 pfet_01v8_lvt_W90p63_L0p74_m1__nf1_gboth_sdfull_pc/B.n543 pfet_01v8_lvt_W90p63_L0p74_m1__nf1_gboth_sdfull_pc/B.n542 72.7879
R1147 pfet_01v8_lvt_W90p63_L0p74_m1__nf1_gboth_sdfull_pc/B.n546 pfet_01v8_lvt_W90p63_L0p74_m1__nf1_gboth_sdfull_pc/B.n545 72.7879
R1148 pfet_01v8_lvt_W90p63_L0p74_m1__nf1_gboth_sdfull_pc/B.n552 pfet_01v8_lvt_W90p63_L0p74_m1__nf1_gboth_sdfull_pc/B.n551 72.7879
R1149 pfet_01v8_lvt_W90p63_L0p74_m1__nf1_gboth_sdfull_pc/B.n554 pfet_01v8_lvt_W90p63_L0p74_m1__nf1_gboth_sdfull_pc/B.n43 72.7879
R1150 pfet_01v8_lvt_W90p63_L0p74_m1__nf1_gboth_sdfull_pc/B.n559 pfet_01v8_lvt_W90p63_L0p74_m1__nf1_gboth_sdfull_pc/B.n558 72.7879
R1151 pfet_01v8_lvt_W90p63_L0p74_m1__nf1_gboth_sdfull_pc/B.n565 pfet_01v8_lvt_W90p63_L0p74_m1__nf1_gboth_sdfull_pc/B.n564 72.7879
R1152 pfet_01v8_lvt_W90p63_L0p74_m1__nf1_gboth_sdfull_pc/B.n567 pfet_01v8_lvt_W90p63_L0p74_m1__nf1_gboth_sdfull_pc/B.n39 72.7879
R1153 pfet_01v8_lvt_W90p63_L0p74_m1__nf1_gboth_sdfull_pc/B.n573 pfet_01v8_lvt_W90p63_L0p74_m1__nf1_gboth_sdfull_pc/B.n572 72.7879
R1154 pfet_01v8_lvt_W90p63_L0p74_m1__nf1_gboth_sdfull_pc/B.n578 pfet_01v8_lvt_W90p63_L0p74_m1__nf1_gboth_sdfull_pc/B.n577 72.7879
R1155 pfet_01v8_lvt_W90p63_L0p74_m1__nf1_gboth_sdfull_pc/B.n581 pfet_01v8_lvt_W90p63_L0p74_m1__nf1_gboth_sdfull_pc/B.n580 72.7879
R1156 pfet_01v8_lvt_W90p63_L0p74_m1__nf1_gboth_sdfull_pc/B.n586 pfet_01v8_lvt_W90p63_L0p74_m1__nf1_gboth_sdfull_pc/B.n585 72.7879
R1157 pfet_01v8_lvt_W90p63_L0p74_m1__nf1_gboth_sdfull_pc/B.n588 pfet_01v8_lvt_W90p63_L0p74_m1__nf1_gboth_sdfull_pc/B.n33 72.7879
R1158 pfet_01v8_lvt_W90p63_L0p74_m1__nf1_gboth_sdfull_pc/B.n593 pfet_01v8_lvt_W90p63_L0p74_m1__nf1_gboth_sdfull_pc/B.n592 72.7879
R1159 pfet_01v8_lvt_W90p63_L0p74_m1__nf1_gboth_sdfull_pc/B.n599 pfet_01v8_lvt_W90p63_L0p74_m1__nf1_gboth_sdfull_pc/B.n598 72.7879
R1160 pfet_01v8_lvt_W90p63_L0p74_m1__nf1_gboth_sdfull_pc/B.n602 pfet_01v8_lvt_W90p63_L0p74_m1__nf1_gboth_sdfull_pc/B.n601 72.7879
R1161 pfet_01v8_lvt_W90p63_L0p74_m1__nf1_gboth_sdfull_pc/B.n608 pfet_01v8_lvt_W90p63_L0p74_m1__nf1_gboth_sdfull_pc/B.n607 72.7879
R1162 pfet_01v8_lvt_W90p63_L0p74_m1__nf1_gboth_sdfull_pc/B.n610 pfet_01v8_lvt_W90p63_L0p74_m1__nf1_gboth_sdfull_pc/B.n609 72.7879
R1163 pfet_01v8_lvt_W90p63_L0p74_m1__nf1_gboth_sdfull_pc/B.n616 pfet_01v8_lvt_W90p63_L0p74_m1__nf1_gboth_sdfull_pc/B.n615 72.7879
R1164 pfet_01v8_lvt_W90p63_L0p74_m1__nf1_gboth_sdfull_pc/B.n617 pfet_01v8_lvt_W90p63_L0p74_m1__nf1_gboth_sdfull_pc/B.n25 72.7879
R1165 pfet_01v8_lvt_W90p63_L0p74_m1__nf1_gboth_sdfull_pc/B.n624 pfet_01v8_lvt_W90p63_L0p74_m1__nf1_gboth_sdfull_pc/B.n623 72.7879
R1166 pfet_01v8_lvt_W90p63_L0p74_m1__nf1_gboth_sdfull_pc/B.n627 pfet_01v8_lvt_W90p63_L0p74_m1__nf1_gboth_sdfull_pc/B.n626 72.7879
R1167 pfet_01v8_lvt_W90p63_L0p74_m1__nf1_gboth_sdfull_pc/B.n633 pfet_01v8_lvt_W90p63_L0p74_m1__nf1_gboth_sdfull_pc/B.n632 72.7879
R1168 pfet_01v8_lvt_W90p63_L0p74_m1__nf1_gboth_sdfull_pc/B.n634 pfet_01v8_lvt_W90p63_L0p74_m1__nf1_gboth_sdfull_pc/B.n20 72.7879
R1169 pfet_01v8_lvt_W90p63_L0p74_m1__nf1_gboth_sdfull_pc/B.n639 pfet_01v8_lvt_W90p63_L0p74_m1__nf1_gboth_sdfull_pc/B.n18 72.7879
R1170 pfet_01v8_lvt_W90p63_L0p74_m1__nf1_gboth_sdfull_pc/B.n644 pfet_01v8_lvt_W90p63_L0p74_m1__nf1_gboth_sdfull_pc/B.n16 72.7879
R1171 pfet_01v8_lvt_W90p63_L0p74_m1__nf1_gboth_sdfull_pc/B.n649 pfet_01v8_lvt_W90p63_L0p74_m1__nf1_gboth_sdfull_pc/B.n14 72.7879
R1172 pfet_01v8_lvt_W90p63_L0p74_m1__nf1_gboth_sdfull_pc/B.n655 pfet_01v8_lvt_W90p63_L0p74_m1__nf1_gboth_sdfull_pc/B.n654 72.7879
R1173 pfet_01v8_lvt_W90p63_L0p74_m1__nf1_gboth_sdfull_pc/B.n660 pfet_01v8_lvt_W90p63_L0p74_m1__nf1_gboth_sdfull_pc/B.n659 72.7879
R1174 pfet_01v8_lvt_W90p63_L0p74_m1__nf1_gboth_sdfull_pc/B.n663 pfet_01v8_lvt_W90p63_L0p74_m1__nf1_gboth_sdfull_pc/B.n662 72.7879
R1175 pfet_01v8_lvt_W90p63_L0p74_m1__nf1_gboth_sdfull_pc/B.n662 pfet_01v8_lvt_W90p63_L0p74_m1__nf1_gboth_sdfull_pc/B.n10 72.7879
R1176 pfet_01v8_lvt_W90p63_L0p74_m1__nf1_gboth_sdfull_pc/B.n661 pfet_01v8_lvt_W90p63_L0p74_m1__nf1_gboth_sdfull_pc/B.n660 72.7879
R1177 pfet_01v8_lvt_W90p63_L0p74_m1__nf1_gboth_sdfull_pc/B.n654 pfet_01v8_lvt_W90p63_L0p74_m1__nf1_gboth_sdfull_pc/B.n12 72.7879
R1178 pfet_01v8_lvt_W90p63_L0p74_m1__nf1_gboth_sdfull_pc/B.n652 pfet_01v8_lvt_W90p63_L0p74_m1__nf1_gboth_sdfull_pc/B.n14 72.7879
R1179 pfet_01v8_lvt_W90p63_L0p74_m1__nf1_gboth_sdfull_pc/B.n647 pfet_01v8_lvt_W90p63_L0p74_m1__nf1_gboth_sdfull_pc/B.n16 72.7879
R1180 pfet_01v8_lvt_W90p63_L0p74_m1__nf1_gboth_sdfull_pc/B.n642 pfet_01v8_lvt_W90p63_L0p74_m1__nf1_gboth_sdfull_pc/B.n18 72.7879
R1181 pfet_01v8_lvt_W90p63_L0p74_m1__nf1_gboth_sdfull_pc/B.n637 pfet_01v8_lvt_W90p63_L0p74_m1__nf1_gboth_sdfull_pc/B.n20 72.7879
R1182 pfet_01v8_lvt_W90p63_L0p74_m1__nf1_gboth_sdfull_pc/B.n632 pfet_01v8_lvt_W90p63_L0p74_m1__nf1_gboth_sdfull_pc/B.n631 72.7879
R1183 pfet_01v8_lvt_W90p63_L0p74_m1__nf1_gboth_sdfull_pc/B.n626 pfet_01v8_lvt_W90p63_L0p74_m1__nf1_gboth_sdfull_pc/B.n22 72.7879
R1184 pfet_01v8_lvt_W90p63_L0p74_m1__nf1_gboth_sdfull_pc/B.n623 pfet_01v8_lvt_W90p63_L0p74_m1__nf1_gboth_sdfull_pc/B.n622 72.7879
R1185 pfet_01v8_lvt_W90p63_L0p74_m1__nf1_gboth_sdfull_pc/B.n618 pfet_01v8_lvt_W90p63_L0p74_m1__nf1_gboth_sdfull_pc/B.n617 72.7879
R1186 pfet_01v8_lvt_W90p63_L0p74_m1__nf1_gboth_sdfull_pc/B.n615 pfet_01v8_lvt_W90p63_L0p74_m1__nf1_gboth_sdfull_pc/B.n614 72.7879
R1187 pfet_01v8_lvt_W90p63_L0p74_m1__nf1_gboth_sdfull_pc/B.n609 pfet_01v8_lvt_W90p63_L0p74_m1__nf1_gboth_sdfull_pc/B.n27 72.7879
R1188 pfet_01v8_lvt_W90p63_L0p74_m1__nf1_gboth_sdfull_pc/B.n607 pfet_01v8_lvt_W90p63_L0p74_m1__nf1_gboth_sdfull_pc/B.n606 72.7879
R1189 pfet_01v8_lvt_W90p63_L0p74_m1__nf1_gboth_sdfull_pc/B.n601 pfet_01v8_lvt_W90p63_L0p74_m1__nf1_gboth_sdfull_pc/B.n29 72.7879
R1190 pfet_01v8_lvt_W90p63_L0p74_m1__nf1_gboth_sdfull_pc/B.n600 pfet_01v8_lvt_W90p63_L0p74_m1__nf1_gboth_sdfull_pc/B.n599 72.7879
R1191 pfet_01v8_lvt_W90p63_L0p74_m1__nf1_gboth_sdfull_pc/B.n594 pfet_01v8_lvt_W90p63_L0p74_m1__nf1_gboth_sdfull_pc/B.n593 72.7879
R1192 pfet_01v8_lvt_W90p63_L0p74_m1__nf1_gboth_sdfull_pc/B.n591 pfet_01v8_lvt_W90p63_L0p74_m1__nf1_gboth_sdfull_pc/B.n33 72.7879
R1193 pfet_01v8_lvt_W90p63_L0p74_m1__nf1_gboth_sdfull_pc/B.n587 pfet_01v8_lvt_W90p63_L0p74_m1__nf1_gboth_sdfull_pc/B.n586 72.7879
R1194 pfet_01v8_lvt_W90p63_L0p74_m1__nf1_gboth_sdfull_pc/B.n580 pfet_01v8_lvt_W90p63_L0p74_m1__nf1_gboth_sdfull_pc/B.n35 72.7879
R1195 pfet_01v8_lvt_W90p63_L0p74_m1__nf1_gboth_sdfull_pc/B.n579 pfet_01v8_lvt_W90p63_L0p74_m1__nf1_gboth_sdfull_pc/B.n578 72.7879
R1196 pfet_01v8_lvt_W90p63_L0p74_m1__nf1_gboth_sdfull_pc/B.n572 pfet_01v8_lvt_W90p63_L0p74_m1__nf1_gboth_sdfull_pc/B.n37 72.7879
R1197 pfet_01v8_lvt_W90p63_L0p74_m1__nf1_gboth_sdfull_pc/B.n570 pfet_01v8_lvt_W90p63_L0p74_m1__nf1_gboth_sdfull_pc/B.n39 72.7879
R1198 pfet_01v8_lvt_W90p63_L0p74_m1__nf1_gboth_sdfull_pc/B.n566 pfet_01v8_lvt_W90p63_L0p74_m1__nf1_gboth_sdfull_pc/B.n565 72.7879
R1199 pfet_01v8_lvt_W90p63_L0p74_m1__nf1_gboth_sdfull_pc/B.n560 pfet_01v8_lvt_W90p63_L0p74_m1__nf1_gboth_sdfull_pc/B.n559 72.7879
R1200 pfet_01v8_lvt_W90p63_L0p74_m1__nf1_gboth_sdfull_pc/B.n557 pfet_01v8_lvt_W90p63_L0p74_m1__nf1_gboth_sdfull_pc/B.n43 72.7879
R1201 pfet_01v8_lvt_W90p63_L0p74_m1__nf1_gboth_sdfull_pc/B.n551 pfet_01v8_lvt_W90p63_L0p74_m1__nf1_gboth_sdfull_pc/B.n550 72.7879
R1202 pfet_01v8_lvt_W90p63_L0p74_m1__nf1_gboth_sdfull_pc/B.n545 pfet_01v8_lvt_W90p63_L0p74_m1__nf1_gboth_sdfull_pc/B.n46 72.7879
R1203 pfet_01v8_lvt_W90p63_L0p74_m1__nf1_gboth_sdfull_pc/B.n542 pfet_01v8_lvt_W90p63_L0p74_m1__nf1_gboth_sdfull_pc/B.n541 72.7879
R1204 pfet_01v8_lvt_W90p63_L0p74_m1__nf1_gboth_sdfull_pc/B.n536 pfet_01v8_lvt_W90p63_L0p74_m1__nf1_gboth_sdfull_pc/B.n49 72.7879
R1205 pfet_01v8_lvt_W90p63_L0p74_m1__nf1_gboth_sdfull_pc/B.n534 pfet_01v8_lvt_W90p63_L0p74_m1__nf1_gboth_sdfull_pc/B.n51 72.7879
R1206 pfet_01v8_lvt_W90p63_L0p74_m1__nf1_gboth_sdfull_pc/B.n530 pfet_01v8_lvt_W90p63_L0p74_m1__nf1_gboth_sdfull_pc/B.n529 72.7879
R1207 pfet_01v8_lvt_W90p63_L0p74_m1__nf1_gboth_sdfull_pc/B.n523 pfet_01v8_lvt_W90p63_L0p74_m1__nf1_gboth_sdfull_pc/B.n53 72.7879
R1208 pfet_01v8_lvt_W90p63_L0p74_m1__nf1_gboth_sdfull_pc/B.n521 pfet_01v8_lvt_W90p63_L0p74_m1__nf1_gboth_sdfull_pc/B.n55 72.7879
R1209 pfet_01v8_lvt_W90p63_L0p74_m1__nf1_gboth_sdfull_pc/B.n516 pfet_01v8_lvt_W90p63_L0p74_m1__nf1_gboth_sdfull_pc/B.n57 72.7879
R1210 pfet_01v8_lvt_W90p63_L0p74_m1__nf1_gboth_sdfull_pc/B.n511 pfet_01v8_lvt_W90p63_L0p74_m1__nf1_gboth_sdfull_pc/B.n59 72.7879
R1211 pfet_01v8_lvt_W90p63_L0p74_m1__nf1_gboth_sdfull_pc/B.n505 pfet_01v8_lvt_W90p63_L0p74_m1__nf1_gboth_sdfull_pc/B.n504 72.7879
R1212 pfet_01v8_lvt_W90p63_L0p74_m1__nf1_gboth_sdfull_pc/B.n500 pfet_01v8_lvt_W90p63_L0p74_m1__nf1_gboth_sdfull_pc/B.n499 72.7879
R1213 pfet_01v8_lvt_W90p63_L0p74_m1__nf1_gboth_sdfull_pc/B.n498 pfet_01v8_lvt_W90p63_L0p74_m1__nf1_gboth_sdfull_pc/B.n497 72.7879
R1214 pfet_01v8_lvt_W90p63_L0p74_m1__nf1_gboth_sdfull_pc/B.n492 pfet_01v8_lvt_W90p63_L0p74_m1__nf1_gboth_sdfull_pc/B.n491 72.7879
R1215 pfet_01v8_lvt_W90p63_L0p74_m1__nf1_gboth_sdfull_pc/B.n489 pfet_01v8_lvt_W90p63_L0p74_m1__nf1_gboth_sdfull_pc/B.n488 72.7879
R1216 pfet_01v8_lvt_W90p63_L0p74_m1__nf1_gboth_sdfull_pc/B.n483 pfet_01v8_lvt_W90p63_L0p74_m1__nf1_gboth_sdfull_pc/B.n66 72.7879
R1217 pfet_01v8_lvt_W90p63_L0p74_m1__nf1_gboth_sdfull_pc/B.n481 pfet_01v8_lvt_W90p63_L0p74_m1__nf1_gboth_sdfull_pc/B.n68 72.7879
R1218 pfet_01v8_lvt_W90p63_L0p74_m1__nf1_gboth_sdfull_pc/B.n477 pfet_01v8_lvt_W90p63_L0p74_m1__nf1_gboth_sdfull_pc/B.n476 72.7879
R1219 pfet_01v8_lvt_W90p63_L0p74_m1__nf1_gboth_sdfull_pc/B.n470 pfet_01v8_lvt_W90p63_L0p74_m1__nf1_gboth_sdfull_pc/B.n469 72.7879
R1220 pfet_01v8_lvt_W90p63_L0p74_m1__nf1_gboth_sdfull_pc/B.n468 pfet_01v8_lvt_W90p63_L0p74_m1__nf1_gboth_sdfull_pc/B.n72 72.7879
R1221 pfet_01v8_lvt_W90p63_L0p74_m1__nf1_gboth_sdfull_pc/B.n464 pfet_01v8_lvt_W90p63_L0p74_m1__nf1_gboth_sdfull_pc/B.n463 72.7879
R1222 pfet_01v8_lvt_W90p63_L0p74_m1__nf1_gboth_sdfull_pc/B.n458 pfet_01v8_lvt_W90p63_L0p74_m1__nf1_gboth_sdfull_pc/B.n457 72.7879
R1223 pfet_01v8_lvt_W90p63_L0p74_m1__nf1_gboth_sdfull_pc/B.n456 pfet_01v8_lvt_W90p63_L0p74_m1__nf1_gboth_sdfull_pc/B.n455 72.7879
R1224 pfet_01v8_lvt_W90p63_L0p74_m1__nf1_gboth_sdfull_pc/B.n450 pfet_01v8_lvt_W90p63_L0p74_m1__nf1_gboth_sdfull_pc/B.n449 72.7879
R1225 pfet_01v8_lvt_W90p63_L0p74_m1__nf1_gboth_sdfull_pc/B.n446 pfet_01v8_lvt_W90p63_L0p74_m1__nf1_gboth_sdfull_pc/B.n445 72.7879
R1226 pfet_01v8_lvt_W90p63_L0p74_m1__nf1_gboth_sdfull_pc/B.n440 pfet_01v8_lvt_W90p63_L0p74_m1__nf1_gboth_sdfull_pc/B.n79 72.7879
R1227 pfet_01v8_lvt_W90p63_L0p74_m1__nf1_gboth_sdfull_pc/B.n438 pfet_01v8_lvt_W90p63_L0p74_m1__nf1_gboth_sdfull_pc/B.n437 72.7879
R1228 pfet_01v8_lvt_W90p63_L0p74_m1__nf1_gboth_sdfull_pc/B.n433 pfet_01v8_lvt_W90p63_L0p74_m1__nf1_gboth_sdfull_pc/B.n432 72.7879
R1229 pfet_01v8_lvt_W90p63_L0p74_m1__nf1_gboth_sdfull_pc/B.n431 pfet_01v8_lvt_W90p63_L0p74_m1__nf1_gboth_sdfull_pc/B.n430 72.7879
R1230 pfet_01v8_lvt_W90p63_L0p74_m1__nf1_gboth_sdfull_pc/B.n424 pfet_01v8_lvt_W90p63_L0p74_m1__nf1_gboth_sdfull_pc/B.n423 72.7879
R1231 pfet_01v8_lvt_W90p63_L0p74_m1__nf1_gboth_sdfull_pc/B.n422 pfet_01v8_lvt_W90p63_L0p74_m1__nf1_gboth_sdfull_pc/B.n85 72.7879
R1232 pfet_01v8_lvt_W90p63_L0p74_m1__nf1_gboth_sdfull_pc/B.n417 pfet_01v8_lvt_W90p63_L0p74_m1__nf1_gboth_sdfull_pc/B.n87 72.7879
R1233 pfet_01v8_lvt_W90p63_L0p74_m1__nf1_gboth_sdfull_pc/B.n412 pfet_01v8_lvt_W90p63_L0p74_m1__nf1_gboth_sdfull_pc/B.n411 72.7879
R1234 pfet_01v8_lvt_W90p63_L0p74_m1__nf1_gboth_sdfull_pc/B.n407 pfet_01v8_lvt_W90p63_L0p74_m1__nf1_gboth_sdfull_pc/B.n406 72.7879
R1235 pfet_01v8_lvt_W90p63_L0p74_m1__nf1_gboth_sdfull_pc/B.n405 pfet_01v8_lvt_W90p63_L0p74_m1__nf1_gboth_sdfull_pc/B.n404 72.7879
R1236 pfet_01v8_lvt_W90p63_L0p74_m1__nf1_gboth_sdfull_pc/B.n398 pfet_01v8_lvt_W90p63_L0p74_m1__nf1_gboth_sdfull_pc/B.n91 72.7879
R1237 pfet_01v8_lvt_W90p63_L0p74_m1__nf1_gboth_sdfull_pc/B.n397 pfet_01v8_lvt_W90p63_L0p74_m1__nf1_gboth_sdfull_pc/B.n396 72.7879
R1238 pfet_01v8_lvt_W90p63_L0p74_m1__nf1_gboth_sdfull_pc/B.n390 pfet_01v8_lvt_W90p63_L0p74_m1__nf1_gboth_sdfull_pc/B.n93 72.7879
R1239 pfet_01v8_lvt_W90p63_L0p74_m1__nf1_gboth_sdfull_pc/B.n388 pfet_01v8_lvt_W90p63_L0p74_m1__nf1_gboth_sdfull_pc/B.n95 72.7879
R1240 pfet_01v8_lvt_W90p63_L0p74_m1__nf1_gboth_sdfull_pc/B.n383 pfet_01v8_lvt_W90p63_L0p74_m1__nf1_gboth_sdfull_pc/B.n382 72.7879
R1241 pfet_01v8_lvt_W90p63_L0p74_m1__nf1_gboth_sdfull_pc/B.n377 pfet_01v8_lvt_W90p63_L0p74_m1__nf1_gboth_sdfull_pc/B.n97 72.7879
R1242 pfet_01v8_lvt_W90p63_L0p74_m1__nf1_gboth_sdfull_pc/B.n376 pfet_01v8_lvt_W90p63_L0p74_m1__nf1_gboth_sdfull_pc/B.n375 72.7879
R1243 pfet_01v8_lvt_W90p63_L0p74_m1__nf1_gboth_sdfull_pc/B.n370 pfet_01v8_lvt_W90p63_L0p74_m1__nf1_gboth_sdfull_pc/B.n369 72.7879
R1244 pfet_01v8_lvt_W90p63_L0p74_m1__nf1_gboth_sdfull_pc/B.n368 pfet_01v8_lvt_W90p63_L0p74_m1__nf1_gboth_sdfull_pc/B.n367 72.7879
R1245 pfet_01v8_lvt_W90p63_L0p74_m1__nf1_gboth_sdfull_pc/B.n362 pfet_01v8_lvt_W90p63_L0p74_m1__nf1_gboth_sdfull_pc/B.n361 72.7879
R1246 pfet_01v8_lvt_W90p63_L0p74_m1__nf1_gboth_sdfull_pc/B.n360 pfet_01v8_lvt_W90p63_L0p74_m1__nf1_gboth_sdfull_pc/B.n359 72.7879
R1247 pfet_01v8_lvt_W90p63_L0p74_m1__nf1_gboth_sdfull_pc/B.n353 pfet_01v8_lvt_W90p63_L0p74_m1__nf1_gboth_sdfull_pc/B.n103 72.7879
R1248 pfet_01v8_lvt_W90p63_L0p74_m1__nf1_gboth_sdfull_pc/B.n351 pfet_01v8_lvt_W90p63_L0p74_m1__nf1_gboth_sdfull_pc/B.n350 72.7879
R1249 pfet_01v8_lvt_W90p63_L0p74_m1__nf1_gboth_sdfull_pc/B.n345 pfet_01v8_lvt_W90p63_L0p74_m1__nf1_gboth_sdfull_pc/B.n105 72.7879
R1250 pfet_01v8_lvt_W90p63_L0p74_m1__nf1_gboth_sdfull_pc/B.n344 pfet_01v8_lvt_W90p63_L0p74_m1__nf1_gboth_sdfull_pc/B.n343 72.7879
R1251 pfet_01v8_lvt_W90p63_L0p74_m1__nf1_gboth_sdfull_pc/B.n337 pfet_01v8_lvt_W90p63_L0p74_m1__nf1_gboth_sdfull_pc/B.n107 72.7879
R1252 pfet_01v8_lvt_W90p63_L0p74_m1__nf1_gboth_sdfull_pc/B.n336 pfet_01v8_lvt_W90p63_L0p74_m1__nf1_gboth_sdfull_pc/B.n335 72.7879
R1253 pfet_01v8_lvt_W90p63_L0p74_m1__nf1_gboth_sdfull_pc/B.n329 pfet_01v8_lvt_W90p63_L0p74_m1__nf1_gboth_sdfull_pc/B.n328 72.7879
R1254 pfet_01v8_lvt_W90p63_L0p74_m1__nf1_gboth_sdfull_pc/B.n327 pfet_01v8_lvt_W90p63_L0p74_m1__nf1_gboth_sdfull_pc/B.n111 72.7879
R1255 pfet_01v8_lvt_W90p63_L0p74_m1__nf1_gboth_sdfull_pc/B.n322 pfet_01v8_lvt_W90p63_L0p74_m1__nf1_gboth_sdfull_pc/B.n321 72.7879
R1256 pfet_01v8_lvt_W90p63_L0p74_m1__nf1_gboth_sdfull_pc/B.n316 pfet_01v8_lvt_W90p63_L0p74_m1__nf1_gboth_sdfull_pc/B.n113 72.7879
R1257 pfet_01v8_lvt_W90p63_L0p74_m1__nf1_gboth_sdfull_pc/B.n314 pfet_01v8_lvt_W90p63_L0p74_m1__nf1_gboth_sdfull_pc/B.n115 72.7879
R1258 pfet_01v8_lvt_W90p63_L0p74_m1__nf1_gboth_sdfull_pc/B.n310 pfet_01v8_lvt_W90p63_L0p74_m1__nf1_gboth_sdfull_pc/B.n309 72.7879
R1259 pfet_01v8_lvt_W90p63_L0p74_m1__nf1_gboth_sdfull_pc/B.n304 pfet_01v8_lvt_W90p63_L0p74_m1__nf1_gboth_sdfull_pc/B.n303 72.7879
R1260 pfet_01v8_lvt_W90p63_L0p74_m1__nf1_gboth_sdfull_pc/B.n302 pfet_01v8_lvt_W90p63_L0p74_m1__nf1_gboth_sdfull_pc/B.n301 72.7879
R1261 pfet_01v8_lvt_W90p63_L0p74_m1__nf1_gboth_sdfull_pc/B.n296 pfet_01v8_lvt_W90p63_L0p74_m1__nf1_gboth_sdfull_pc/B.n295 72.7879
R1262 pfet_01v8_lvt_W90p63_L0p74_m1__nf1_gboth_sdfull_pc/B.n293 pfet_01v8_lvt_W90p63_L0p74_m1__nf1_gboth_sdfull_pc/B.n121 72.7879
R1263 pfet_01v8_lvt_W90p63_L0p74_m1__nf1_gboth_sdfull_pc/B.n287 pfet_01v8_lvt_W90p63_L0p74_m1__nf1_gboth_sdfull_pc/B.n286 72.7879
R1264 pfet_01v8_lvt_W90p63_L0p74_m1__nf1_gboth_sdfull_pc/B.n281 pfet_01v8_lvt_W90p63_L0p74_m1__nf1_gboth_sdfull_pc/B.n124 72.7879
R1265 pfet_01v8_lvt_W90p63_L0p74_m1__nf1_gboth_sdfull_pc/B.n280 pfet_01v8_lvt_W90p63_L0p74_m1__nf1_gboth_sdfull_pc/B.n279 72.7879
R1266 pfet_01v8_lvt_W90p63_L0p74_m1__nf1_gboth_sdfull_pc/B.n273 pfet_01v8_lvt_W90p63_L0p74_m1__nf1_gboth_sdfull_pc/B.n126 72.7879
R1267 pfet_01v8_lvt_W90p63_L0p74_m1__nf1_gboth_sdfull_pc/B.n272 pfet_01v8_lvt_W90p63_L0p74_m1__nf1_gboth_sdfull_pc/B.n271 72.7879
R1268 pfet_01v8_lvt_W90p63_L0p74_m1__nf1_gboth_sdfull_pc/B.n265 pfet_01v8_lvt_W90p63_L0p74_m1__nf1_gboth_sdfull_pc/B.n128 72.7879
R1269 pfet_01v8_lvt_W90p63_L0p74_m1__nf1_gboth_sdfull_pc/B.n263 pfet_01v8_lvt_W90p63_L0p74_m1__nf1_gboth_sdfull_pc/B.n262 72.7879
R1270 pfet_01v8_lvt_W90p63_L0p74_m1__nf1_gboth_sdfull_pc/B.n258 pfet_01v8_lvt_W90p63_L0p74_m1__nf1_gboth_sdfull_pc/B.n257 72.7879
R1271 pfet_01v8_lvt_W90p63_L0p74_m1__nf1_gboth_sdfull_pc/B.n255 pfet_01v8_lvt_W90p63_L0p74_m1__nf1_gboth_sdfull_pc/B.n254 72.7879
R1272 pfet_01v8_lvt_W90p63_L0p74_m1__nf1_gboth_sdfull_pc/B.n249 pfet_01v8_lvt_W90p63_L0p74_m1__nf1_gboth_sdfull_pc/B.n132 72.7879
R1273 pfet_01v8_lvt_W90p63_L0p74_m1__nf1_gboth_sdfull_pc/B.n247 pfet_01v8_lvt_W90p63_L0p74_m1__nf1_gboth_sdfull_pc/B.n246 72.7879
R1274 pfet_01v8_lvt_W90p63_L0p74_m1__nf1_gboth_sdfull_pc/B.n242 pfet_01v8_lvt_W90p63_L0p74_m1__nf1_gboth_sdfull_pc/B.n241 72.7879
R1275 pfet_01v8_lvt_W90p63_L0p74_m1__nf1_gboth_sdfull_pc/B.n240 pfet_01v8_lvt_W90p63_L0p74_m1__nf1_gboth_sdfull_pc/B.n239 72.7879
R1276 pfet_01v8_lvt_W90p63_L0p74_m1__nf1_gboth_sdfull_pc/B.n234 pfet_01v8_lvt_W90p63_L0p74_m1__nf1_gboth_sdfull_pc/B.n233 72.7879
R1277 pfet_01v8_lvt_W90p63_L0p74_m1__nf1_gboth_sdfull_pc/B.n231 pfet_01v8_lvt_W90p63_L0p74_m1__nf1_gboth_sdfull_pc/B.n230 72.7879
R1278 pfet_01v8_lvt_W90p63_L0p74_m1__nf1_gboth_sdfull_pc/B.n225 pfet_01v8_lvt_W90p63_L0p74_m1__nf1_gboth_sdfull_pc/B.n138 72.7879
R1279 pfet_01v8_lvt_W90p63_L0p74_m1__nf1_gboth_sdfull_pc/B.n223 pfet_01v8_lvt_W90p63_L0p74_m1__nf1_gboth_sdfull_pc/B.n222 72.7879
R1280 pfet_01v8_lvt_W90p63_L0p74_m1__nf1_gboth_sdfull_pc/B.n217 pfet_01v8_lvt_W90p63_L0p74_m1__nf1_gboth_sdfull_pc/B.n140 72.7879
R1281 pfet_01v8_lvt_W90p63_L0p74_m1__nf1_gboth_sdfull_pc/B.n216 pfet_01v8_lvt_W90p63_L0p74_m1__nf1_gboth_sdfull_pc/B.n215 72.7879
R1282 pfet_01v8_lvt_W90p63_L0p74_m1__nf1_gboth_sdfull_pc/B.n209 pfet_01v8_lvt_W90p63_L0p74_m1__nf1_gboth_sdfull_pc/B.n142 72.7879
R1283 pfet_01v8_lvt_W90p63_L0p74_m1__nf1_gboth_sdfull_pc/B.n207 pfet_01v8_lvt_W90p63_L0p74_m1__nf1_gboth_sdfull_pc/B.n144 72.7879
R1284 pfet_01v8_lvt_W90p63_L0p74_m1__nf1_gboth_sdfull_pc/B.n203 pfet_01v8_lvt_W90p63_L0p74_m1__nf1_gboth_sdfull_pc/B.n202 72.7879
R1285 pfet_01v8_lvt_W90p63_L0p74_m1__nf1_gboth_sdfull_pc/B.n197 pfet_01v8_lvt_W90p63_L0p74_m1__nf1_gboth_sdfull_pc/B.n196 72.7879
R1286 pfet_01v8_lvt_W90p63_L0p74_m1__nf1_gboth_sdfull_pc/B.n195 pfet_01v8_lvt_W90p63_L0p74_m1__nf1_gboth_sdfull_pc/B.n194 72.7879
R1287 pfet_01v8_lvt_W90p63_L0p74_m1__nf1_gboth_sdfull_pc/B.n188 pfet_01v8_lvt_W90p63_L0p74_m1__nf1_gboth_sdfull_pc/B.n148 72.7879
R1288 pfet_01v8_lvt_W90p63_L0p74_m1__nf1_gboth_sdfull_pc/B.n187 pfet_01v8_lvt_W90p63_L0p74_m1__nf1_gboth_sdfull_pc/B.n186 72.7879
R1289 pfet_01v8_lvt_W90p63_L0p74_m1__nf1_gboth_sdfull_pc/B.n180 pfet_01v8_lvt_W90p63_L0p74_m1__nf1_gboth_sdfull_pc/B.n179 72.7879
R1290 pfet_01v8_lvt_W90p63_L0p74_m1__nf1_gboth_sdfull_pc/B.n178 pfet_01v8_lvt_W90p63_L0p74_m1__nf1_gboth_sdfull_pc/B.n152 72.7879
R1291 pfet_01v8_lvt_W90p63_L0p74_m1__nf1_gboth_sdfull_pc/B.n173 pfet_01v8_lvt_W90p63_L0p74_m1__nf1_gboth_sdfull_pc/B.n154 72.7879
R1292 pfet_01v8_lvt_W90p63_L0p74_m1__nf1_gboth_sdfull_pc/B.n168 pfet_01v8_lvt_W90p63_L0p74_m1__nf1_gboth_sdfull_pc/B.n156 72.7879
R1293 pfet_01v8_lvt_W90p63_L0p74_m1__nf1_gboth_sdfull_pc/B.n164 pfet_01v8_lvt_W90p63_L0p74_m1__nf1_gboth_sdfull_pc/B.n163 72.7879
R1294 pfet_01v8_lvt_W90p63_L0p74_m1__nf1_gboth_sdfull_pc/B.n158 pfet_01v8_lvt_W90p63_L0p74_m1__nf1_gboth_sdfull_pc/B.n8 72.7879
R1295 pfet_01v8_lvt_W90p63_L0p74_m1__nf1_gboth_sdfull_pc/B.n828 pfet_01v8_lvt_W90p63_L0p74_m1__nf1_gboth_sdfull_pc/B.n755 72.7879
R1296 pfet_01v8_lvt_W90p63_L0p74_m1__nf1_gboth_sdfull_pc/B.n832 pfet_01v8_lvt_W90p63_L0p74_m1__nf1_gboth_sdfull_pc/B.n754 72.7879
R1297 pfet_01v8_lvt_W90p63_L0p74_m1__nf1_gboth_sdfull_pc/B.n839 pfet_01v8_lvt_W90p63_L0p74_m1__nf1_gboth_sdfull_pc/B.n757 72.7879
R1298 pfet_01v8_lvt_W90p63_L0p74_m1__nf1_gboth_sdfull_pc/B.n843 pfet_01v8_lvt_W90p63_L0p74_m1__nf1_gboth_sdfull_pc/B.n758 72.7879
R1299 pfet_01v8_lvt_W90p63_L0p74_m1__nf1_gboth_sdfull_pc/B.n844 pfet_01v8_lvt_W90p63_L0p74_m1__nf1_gboth_sdfull_pc/B.n753 72.7879
R1300 pfet_01v8_lvt_W90p63_L0p74_m1__nf1_gboth_sdfull_pc/B.n848 pfet_01v8_lvt_W90p63_L0p74_m1__nf1_gboth_sdfull_pc/B.n752 72.7879
R1301 pfet_01v8_lvt_W90p63_L0p74_m1__nf1_gboth_sdfull_pc/B.n853 pfet_01v8_lvt_W90p63_L0p74_m1__nf1_gboth_sdfull_pc/B.n759 72.7879
R1302 pfet_01v8_lvt_W90p63_L0p74_m1__nf1_gboth_sdfull_pc/B.n858 pfet_01v8_lvt_W90p63_L0p74_m1__nf1_gboth_sdfull_pc/B.n750 72.7879
R1303 pfet_01v8_lvt_W90p63_L0p74_m1__nf1_gboth_sdfull_pc/B.n862 pfet_01v8_lvt_W90p63_L0p74_m1__nf1_gboth_sdfull_pc/B.n749 72.7879
R1304 pfet_01v8_lvt_W90p63_L0p74_m1__nf1_gboth_sdfull_pc/B.n867 pfet_01v8_lvt_W90p63_L0p74_m1__nf1_gboth_sdfull_pc/B.n761 72.7879
R1305 pfet_01v8_lvt_W90p63_L0p74_m1__nf1_gboth_sdfull_pc/B.n874 pfet_01v8_lvt_W90p63_L0p74_m1__nf1_gboth_sdfull_pc/B.n747 72.7879
R1306 pfet_01v8_lvt_W90p63_L0p74_m1__nf1_gboth_sdfull_pc/B.n875 pfet_01v8_lvt_W90p63_L0p74_m1__nf1_gboth_sdfull_pc/B.n762 72.7879
R1307 pfet_01v8_lvt_W90p63_L0p74_m1__nf1_gboth_sdfull_pc/B.n879 pfet_01v8_lvt_W90p63_L0p74_m1__nf1_gboth_sdfull_pc/B.n763 72.7879
R1308 pfet_01v8_lvt_W90p63_L0p74_m1__nf1_gboth_sdfull_pc/B.n886 pfet_01v8_lvt_W90p63_L0p74_m1__nf1_gboth_sdfull_pc/B.n746 72.7879
R1309 pfet_01v8_lvt_W90p63_L0p74_m1__nf1_gboth_sdfull_pc/B.n887 pfet_01v8_lvt_W90p63_L0p74_m1__nf1_gboth_sdfull_pc/B.n764 72.7879
R1310 pfet_01v8_lvt_W90p63_L0p74_m1__nf1_gboth_sdfull_pc/B.n895 pfet_01v8_lvt_W90p63_L0p74_m1__nf1_gboth_sdfull_pc/B.n766 72.7879
R1311 pfet_01v8_lvt_W90p63_L0p74_m1__nf1_gboth_sdfull_pc/B.n896 pfet_01v8_lvt_W90p63_L0p74_m1__nf1_gboth_sdfull_pc/B.n745 72.7879
R1312 pfet_01v8_lvt_W90p63_L0p74_m1__nf1_gboth_sdfull_pc/B.n901 pfet_01v8_lvt_W90p63_L0p74_m1__nf1_gboth_sdfull_pc/B.n767 72.7879
R1313 pfet_01v8_lvt_W90p63_L0p74_m1__nf1_gboth_sdfull_pc/B.n906 pfet_01v8_lvt_W90p63_L0p74_m1__nf1_gboth_sdfull_pc/B.n743 72.7879
R1314 pfet_01v8_lvt_W90p63_L0p74_m1__nf1_gboth_sdfull_pc/B.n910 pfet_01v8_lvt_W90p63_L0p74_m1__nf1_gboth_sdfull_pc/B.n742 72.7879
R1315 pfet_01v8_lvt_W90p63_L0p74_m1__nf1_gboth_sdfull_pc/B.n915 pfet_01v8_lvt_W90p63_L0p74_m1__nf1_gboth_sdfull_pc/B.n769 72.7879
R1316 pfet_01v8_lvt_W90p63_L0p74_m1__nf1_gboth_sdfull_pc/B.n920 pfet_01v8_lvt_W90p63_L0p74_m1__nf1_gboth_sdfull_pc/B.n740 72.7879
R1317 pfet_01v8_lvt_W90p63_L0p74_m1__nf1_gboth_sdfull_pc/B.n925 pfet_01v8_lvt_W90p63_L0p74_m1__nf1_gboth_sdfull_pc/B.n771 72.7879
R1318 pfet_01v8_lvt_W90p63_L0p74_m1__nf1_gboth_sdfull_pc/B.n930 pfet_01v8_lvt_W90p63_L0p74_m1__nf1_gboth_sdfull_pc/B.n738 72.7879
R1319 pfet_01v8_lvt_W90p63_L0p74_m1__nf1_gboth_sdfull_pc/B.n934 pfet_01v8_lvt_W90p63_L0p74_m1__nf1_gboth_sdfull_pc/B.n737 72.7879
R1320 pfet_01v8_lvt_W90p63_L0p74_m1__nf1_gboth_sdfull_pc/B.n942 pfet_01v8_lvt_W90p63_L0p74_m1__nf1_gboth_sdfull_pc/B.n735 72.7879
R1321 pfet_01v8_lvt_W90p63_L0p74_m1__nf1_gboth_sdfull_pc/B.n943 pfet_01v8_lvt_W90p63_L0p74_m1__nf1_gboth_sdfull_pc/B.n773 72.7879
R1322 pfet_01v8_lvt_W90p63_L0p74_m1__nf1_gboth_sdfull_pc/B.n948 pfet_01v8_lvt_W90p63_L0p74_m1__nf1_gboth_sdfull_pc/B.n734 72.7879
R1323 pfet_01v8_lvt_W90p63_L0p74_m1__nf1_gboth_sdfull_pc/B.n953 pfet_01v8_lvt_W90p63_L0p74_m1__nf1_gboth_sdfull_pc/B.n775 72.7879
R1324 pfet_01v8_lvt_W90p63_L0p74_m1__nf1_gboth_sdfull_pc/B.n957 pfet_01v8_lvt_W90p63_L0p74_m1__nf1_gboth_sdfull_pc/B.n776 72.7879
R1325 pfet_01v8_lvt_W90p63_L0p74_m1__nf1_gboth_sdfull_pc/B.n962 pfet_01v8_lvt_W90p63_L0p74_m1__nf1_gboth_sdfull_pc/B.n732 72.7879
R1326 pfet_01v8_lvt_W90p63_L0p74_m1__nf1_gboth_sdfull_pc/B.n966 pfet_01v8_lvt_W90p63_L0p74_m1__nf1_gboth_sdfull_pc/B.n731 72.7879
R1327 pfet_01v8_lvt_W90p63_L0p74_m1__nf1_gboth_sdfull_pc/B.n973 pfet_01v8_lvt_W90p63_L0p74_m1__nf1_gboth_sdfull_pc/B.n778 72.7879
R1328 pfet_01v8_lvt_W90p63_L0p74_m1__nf1_gboth_sdfull_pc/B.n974 pfet_01v8_lvt_W90p63_L0p74_m1__nf1_gboth_sdfull_pc/B.n730 72.7879
R1329 pfet_01v8_lvt_W90p63_L0p74_m1__nf1_gboth_sdfull_pc/B.n978 pfet_01v8_lvt_W90p63_L0p74_m1__nf1_gboth_sdfull_pc/B.n729 72.7879
R1330 pfet_01v8_lvt_W90p63_L0p74_m1__nf1_gboth_sdfull_pc/B.n982 pfet_01v8_lvt_W90p63_L0p74_m1__nf1_gboth_sdfull_pc/B.n728 72.7879
R1331 pfet_01v8_lvt_W90p63_L0p74_m1__nf1_gboth_sdfull_pc/B.n989 pfet_01v8_lvt_W90p63_L0p74_m1__nf1_gboth_sdfull_pc/B.n779 72.7879
R1332 pfet_01v8_lvt_W90p63_L0p74_m1__nf1_gboth_sdfull_pc/B.n990 pfet_01v8_lvt_W90p63_L0p74_m1__nf1_gboth_sdfull_pc/B.n727 72.7879
R1333 pfet_01v8_lvt_W90p63_L0p74_m1__nf1_gboth_sdfull_pc/B.n994 pfet_01v8_lvt_W90p63_L0p74_m1__nf1_gboth_sdfull_pc/B.n726 72.7879
R1334 pfet_01v8_lvt_W90p63_L0p74_m1__nf1_gboth_sdfull_pc/B.n999 pfet_01v8_lvt_W90p63_L0p74_m1__nf1_gboth_sdfull_pc/B.n780 72.7879
R1335 pfet_01v8_lvt_W90p63_L0p74_m1__nf1_gboth_sdfull_pc/B.n1004 pfet_01v8_lvt_W90p63_L0p74_m1__nf1_gboth_sdfull_pc/B.n724 72.7879
R1336 pfet_01v8_lvt_W90p63_L0p74_m1__nf1_gboth_sdfull_pc/B.n1009 pfet_01v8_lvt_W90p63_L0p74_m1__nf1_gboth_sdfull_pc/B.n782 72.7879
R1337 pfet_01v8_lvt_W90p63_L0p74_m1__nf1_gboth_sdfull_pc/B.n1014 pfet_01v8_lvt_W90p63_L0p74_m1__nf1_gboth_sdfull_pc/B.n722 72.7879
R1338 pfet_01v8_lvt_W90p63_L0p74_m1__nf1_gboth_sdfull_pc/B.n1019 pfet_01v8_lvt_W90p63_L0p74_m1__nf1_gboth_sdfull_pc/B.n784 72.7879
R1339 pfet_01v8_lvt_W90p63_L0p74_m1__nf1_gboth_sdfull_pc/B.n1023 pfet_01v8_lvt_W90p63_L0p74_m1__nf1_gboth_sdfull_pc/B.n785 72.7879
R1340 pfet_01v8_lvt_W90p63_L0p74_m1__nf1_gboth_sdfull_pc/B.n1030 pfet_01v8_lvt_W90p63_L0p74_m1__nf1_gboth_sdfull_pc/B.n720 72.7879
R1341 pfet_01v8_lvt_W90p63_L0p74_m1__nf1_gboth_sdfull_pc/B.n1031 pfet_01v8_lvt_W90p63_L0p74_m1__nf1_gboth_sdfull_pc/B.n786 72.7879
R1342 pfet_01v8_lvt_W90p63_L0p74_m1__nf1_gboth_sdfull_pc/B.n1036 pfet_01v8_lvt_W90p63_L0p74_m1__nf1_gboth_sdfull_pc/B.n719 72.7879
R1343 pfet_01v8_lvt_W90p63_L0p74_m1__nf1_gboth_sdfull_pc/B.n1040 pfet_01v8_lvt_W90p63_L0p74_m1__nf1_gboth_sdfull_pc/B.n718 72.7879
R1344 pfet_01v8_lvt_W90p63_L0p74_m1__nf1_gboth_sdfull_pc/B.n1044 pfet_01v8_lvt_W90p63_L0p74_m1__nf1_gboth_sdfull_pc/B.n717 72.7879
R1345 pfet_01v8_lvt_W90p63_L0p74_m1__nf1_gboth_sdfull_pc/B.n1048 pfet_01v8_lvt_W90p63_L0p74_m1__nf1_gboth_sdfull_pc/B.n716 72.7879
R1346 pfet_01v8_lvt_W90p63_L0p74_m1__nf1_gboth_sdfull_pc/B.n1055 pfet_01v8_lvt_W90p63_L0p74_m1__nf1_gboth_sdfull_pc/B.n788 72.7879
R1347 pfet_01v8_lvt_W90p63_L0p74_m1__nf1_gboth_sdfull_pc/B.n1056 pfet_01v8_lvt_W90p63_L0p74_m1__nf1_gboth_sdfull_pc/B.n715 72.7879
R1348 pfet_01v8_lvt_W90p63_L0p74_m1__nf1_gboth_sdfull_pc/B.n1061 pfet_01v8_lvt_W90p63_L0p74_m1__nf1_gboth_sdfull_pc/B.n789 72.7879
R1349 pfet_01v8_lvt_W90p63_L0p74_m1__nf1_gboth_sdfull_pc/B.n1065 pfet_01v8_lvt_W90p63_L0p74_m1__nf1_gboth_sdfull_pc/B.n790 72.7879
R1350 pfet_01v8_lvt_W90p63_L0p74_m1__nf1_gboth_sdfull_pc/B.n1069 pfet_01v8_lvt_W90p63_L0p74_m1__nf1_gboth_sdfull_pc/B.n791 72.7879
R1351 pfet_01v8_lvt_W90p63_L0p74_m1__nf1_gboth_sdfull_pc/B.n1073 pfet_01v8_lvt_W90p63_L0p74_m1__nf1_gboth_sdfull_pc/B.n792 72.7879
R1352 pfet_01v8_lvt_W90p63_L0p74_m1__nf1_gboth_sdfull_pc/B.n1078 pfet_01v8_lvt_W90p63_L0p74_m1__nf1_gboth_sdfull_pc/B.n713 72.7879
R1353 pfet_01v8_lvt_W90p63_L0p74_m1__nf1_gboth_sdfull_pc/B.n1083 pfet_01v8_lvt_W90p63_L0p74_m1__nf1_gboth_sdfull_pc/B.n794 72.7879
R1354 pfet_01v8_lvt_W90p63_L0p74_m1__nf1_gboth_sdfull_pc/B.n1091 pfet_01v8_lvt_W90p63_L0p74_m1__nf1_gboth_sdfull_pc/B.n796 72.7879
R1355 pfet_01v8_lvt_W90p63_L0p74_m1__nf1_gboth_sdfull_pc/B.n1092 pfet_01v8_lvt_W90p63_L0p74_m1__nf1_gboth_sdfull_pc/B.n711 72.7879
R1356 pfet_01v8_lvt_W90p63_L0p74_m1__nf1_gboth_sdfull_pc/B.n1097 pfet_01v8_lvt_W90p63_L0p74_m1__nf1_gboth_sdfull_pc/B.n797 72.7879
R1357 pfet_01v8_lvt_W90p63_L0p74_m1__nf1_gboth_sdfull_pc/B.n1101 pfet_01v8_lvt_W90p63_L0p74_m1__nf1_gboth_sdfull_pc/B.n798 72.7879
R1358 pfet_01v8_lvt_W90p63_L0p74_m1__nf1_gboth_sdfull_pc/B.n1105 pfet_01v8_lvt_W90p63_L0p74_m1__nf1_gboth_sdfull_pc/B.n799 72.7879
R1359 pfet_01v8_lvt_W90p63_L0p74_m1__nf1_gboth_sdfull_pc/B.n1113 pfet_01v8_lvt_W90p63_L0p74_m1__nf1_gboth_sdfull_pc/B.n801 72.7879
R1360 pfet_01v8_lvt_W90p63_L0p74_m1__nf1_gboth_sdfull_pc/B.n1114 pfet_01v8_lvt_W90p63_L0p74_m1__nf1_gboth_sdfull_pc/B.n709 72.7879
R1361 pfet_01v8_lvt_W90p63_L0p74_m1__nf1_gboth_sdfull_pc/B.n1118 pfet_01v8_lvt_W90p63_L0p74_m1__nf1_gboth_sdfull_pc/B.n708 72.7879
R1362 pfet_01v8_lvt_W90p63_L0p74_m1__nf1_gboth_sdfull_pc/B.n1123 pfet_01v8_lvt_W90p63_L0p74_m1__nf1_gboth_sdfull_pc/B.n802 72.7879
R1363 pfet_01v8_lvt_W90p63_L0p74_m1__nf1_gboth_sdfull_pc/B.n1130 pfet_01v8_lvt_W90p63_L0p74_m1__nf1_gboth_sdfull_pc/B.n706 72.7879
R1364 pfet_01v8_lvt_W90p63_L0p74_m1__nf1_gboth_sdfull_pc/B.n1131 pfet_01v8_lvt_W90p63_L0p74_m1__nf1_gboth_sdfull_pc/B.n803 72.7879
R1365 pfet_01v8_lvt_W90p63_L0p74_m1__nf1_gboth_sdfull_pc/B.n1136 pfet_01v8_lvt_W90p63_L0p74_m1__nf1_gboth_sdfull_pc/B.n705 72.7879
R1366 pfet_01v8_lvt_W90p63_L0p74_m1__nf1_gboth_sdfull_pc/B.n1141 pfet_01v8_lvt_W90p63_L0p74_m1__nf1_gboth_sdfull_pc/B.n805 72.7879
R1367 pfet_01v8_lvt_W90p63_L0p74_m1__nf1_gboth_sdfull_pc/B.n1145 pfet_01v8_lvt_W90p63_L0p74_m1__nf1_gboth_sdfull_pc/B.n806 72.7879
R1368 pfet_01v8_lvt_W90p63_L0p74_m1__nf1_gboth_sdfull_pc/B.n1152 pfet_01v8_lvt_W90p63_L0p74_m1__nf1_gboth_sdfull_pc/B.n703 72.7879
R1369 pfet_01v8_lvt_W90p63_L0p74_m1__nf1_gboth_sdfull_pc/B.n1153 pfet_01v8_lvt_W90p63_L0p74_m1__nf1_gboth_sdfull_pc/B.n807 72.7879
R1370 pfet_01v8_lvt_W90p63_L0p74_m1__nf1_gboth_sdfull_pc/B.n1161 pfet_01v8_lvt_W90p63_L0p74_m1__nf1_gboth_sdfull_pc/B.n809 72.7879
R1371 pfet_01v8_lvt_W90p63_L0p74_m1__nf1_gboth_sdfull_pc/B.n1162 pfet_01v8_lvt_W90p63_L0p74_m1__nf1_gboth_sdfull_pc/B.n702 72.7879
R1372 pfet_01v8_lvt_W90p63_L0p74_m1__nf1_gboth_sdfull_pc/B.n1169 pfet_01v8_lvt_W90p63_L0p74_m1__nf1_gboth_sdfull_pc/B.n810 72.7879
R1373 pfet_01v8_lvt_W90p63_L0p74_m1__nf1_gboth_sdfull_pc/B.n1170 pfet_01v8_lvt_W90p63_L0p74_m1__nf1_gboth_sdfull_pc/B.n701 72.7879
R1374 pfet_01v8_lvt_W90p63_L0p74_m1__nf1_gboth_sdfull_pc/B.n1174 pfet_01v8_lvt_W90p63_L0p74_m1__nf1_gboth_sdfull_pc/B.n700 72.7879
R1375 pfet_01v8_lvt_W90p63_L0p74_m1__nf1_gboth_sdfull_pc/B.n1179 pfet_01v8_lvt_W90p63_L0p74_m1__nf1_gboth_sdfull_pc/B.n811 72.7879
R1376 pfet_01v8_lvt_W90p63_L0p74_m1__nf1_gboth_sdfull_pc/B.n1186 pfet_01v8_lvt_W90p63_L0p74_m1__nf1_gboth_sdfull_pc/B.n698 72.7879
R1377 pfet_01v8_lvt_W90p63_L0p74_m1__nf1_gboth_sdfull_pc/B.n1187 pfet_01v8_lvt_W90p63_L0p74_m1__nf1_gboth_sdfull_pc/B.n812 72.7879
R1378 pfet_01v8_lvt_W90p63_L0p74_m1__nf1_gboth_sdfull_pc/B.n1194 pfet_01v8_lvt_W90p63_L0p74_m1__nf1_gboth_sdfull_pc/B.n697 72.7879
R1379 pfet_01v8_lvt_W90p63_L0p74_m1__nf1_gboth_sdfull_pc/B.n1195 pfet_01v8_lvt_W90p63_L0p74_m1__nf1_gboth_sdfull_pc/B.n813 72.7879
R1380 pfet_01v8_lvt_W90p63_L0p74_m1__nf1_gboth_sdfull_pc/B.n1199 pfet_01v8_lvt_W90p63_L0p74_m1__nf1_gboth_sdfull_pc/B.n814 72.7879
R1381 pfet_01v8_lvt_W90p63_L0p74_m1__nf1_gboth_sdfull_pc/B.n1206 pfet_01v8_lvt_W90p63_L0p74_m1__nf1_gboth_sdfull_pc/B.n696 72.7879
R1382 pfet_01v8_lvt_W90p63_L0p74_m1__nf1_gboth_sdfull_pc/B.n1207 pfet_01v8_lvt_W90p63_L0p74_m1__nf1_gboth_sdfull_pc/B.n815 72.7879
R1383 pfet_01v8_lvt_W90p63_L0p74_m1__nf1_gboth_sdfull_pc/B.n1212 pfet_01v8_lvt_W90p63_L0p74_m1__nf1_gboth_sdfull_pc/B.n695 72.7879
R1384 pfet_01v8_lvt_W90p63_L0p74_m1__nf1_gboth_sdfull_pc/B.n1216 pfet_01v8_lvt_W90p63_L0p74_m1__nf1_gboth_sdfull_pc/B.n694 72.7879
R1385 pfet_01v8_lvt_W90p63_L0p74_m1__nf1_gboth_sdfull_pc/B.n1220 pfet_01v8_lvt_W90p63_L0p74_m1__nf1_gboth_sdfull_pc/B.n693 72.7879
R1386 pfet_01v8_lvt_W90p63_L0p74_m1__nf1_gboth_sdfull_pc/B.n1227 pfet_01v8_lvt_W90p63_L0p74_m1__nf1_gboth_sdfull_pc/B.n817 72.7879
R1387 pfet_01v8_lvt_W90p63_L0p74_m1__nf1_gboth_sdfull_pc/B.n1228 pfet_01v8_lvt_W90p63_L0p74_m1__nf1_gboth_sdfull_pc/B.n692 72.7879
R1388 pfet_01v8_lvt_W90p63_L0p74_m1__nf1_gboth_sdfull_pc/B.n1232 pfet_01v8_lvt_W90p63_L0p74_m1__nf1_gboth_sdfull_pc/B.n691 72.7879
R1389 pfet_01v8_lvt_W90p63_L0p74_m1__nf1_gboth_sdfull_pc/B.n1239 pfet_01v8_lvt_W90p63_L0p74_m1__nf1_gboth_sdfull_pc/B.n818 72.7879
R1390 pfet_01v8_lvt_W90p63_L0p74_m1__nf1_gboth_sdfull_pc/B.n1240 pfet_01v8_lvt_W90p63_L0p74_m1__nf1_gboth_sdfull_pc/B.n690 72.7879
R1391 pfet_01v8_lvt_W90p63_L0p74_m1__nf1_gboth_sdfull_pc/B.n1244 pfet_01v8_lvt_W90p63_L0p74_m1__nf1_gboth_sdfull_pc/B.n689 72.7879
R1392 pfet_01v8_lvt_W90p63_L0p74_m1__nf1_gboth_sdfull_pc/B.n1248 pfet_01v8_lvt_W90p63_L0p74_m1__nf1_gboth_sdfull_pc/B.n688 72.7879
R1393 pfet_01v8_lvt_W90p63_L0p74_m1__nf1_gboth_sdfull_pc/B.n1252 pfet_01v8_lvt_W90p63_L0p74_m1__nf1_gboth_sdfull_pc/B.n687 72.7879
R1394 pfet_01v8_lvt_W90p63_L0p74_m1__nf1_gboth_sdfull_pc/B.n1256 pfet_01v8_lvt_W90p63_L0p74_m1__nf1_gboth_sdfull_pc/B.n686 72.7879
R1395 pfet_01v8_lvt_W90p63_L0p74_m1__nf1_gboth_sdfull_pc/B.n1260 pfet_01v8_lvt_W90p63_L0p74_m1__nf1_gboth_sdfull_pc/B.n685 72.7879
R1396 pfet_01v8_lvt_W90p63_L0p74_m1__nf1_gboth_sdfull_pc/B.n1264 pfet_01v8_lvt_W90p63_L0p74_m1__nf1_gboth_sdfull_pc/B.n684 72.7879
R1397 pfet_01v8_lvt_W90p63_L0p74_m1__nf1_gboth_sdfull_pc/B.n1268 pfet_01v8_lvt_W90p63_L0p74_m1__nf1_gboth_sdfull_pc/B.n683 72.7879
R1398 pfet_01v8_lvt_W90p63_L0p74_m1__nf1_gboth_sdfull_pc/B.n1272 pfet_01v8_lvt_W90p63_L0p74_m1__nf1_gboth_sdfull_pc/B.n682 72.7879
R1399 pfet_01v8_lvt_W90p63_L0p74_m1__nf1_gboth_sdfull_pc/B.n1276 pfet_01v8_lvt_W90p63_L0p74_m1__nf1_gboth_sdfull_pc/B.n681 72.7879
R1400 pfet_01v8_lvt_W90p63_L0p74_m1__nf1_gboth_sdfull_pc/B.n1283 pfet_01v8_lvt_W90p63_L0p74_m1__nf1_gboth_sdfull_pc/B.n819 72.7879
R1401 pfet_01v8_lvt_W90p63_L0p74_m1__nf1_gboth_sdfull_pc/B.n1284 pfet_01v8_lvt_W90p63_L0p74_m1__nf1_gboth_sdfull_pc/B.n680 72.7879
R1402 pfet_01v8_lvt_W90p63_L0p74_m1__nf1_gboth_sdfull_pc/B.n1288 pfet_01v8_lvt_W90p63_L0p74_m1__nf1_gboth_sdfull_pc/B.n679 72.7879
R1403 pfet_01v8_lvt_W90p63_L0p74_m1__nf1_gboth_sdfull_pc/B.n1295 pfet_01v8_lvt_W90p63_L0p74_m1__nf1_gboth_sdfull_pc/B.n820 72.7879
R1404 pfet_01v8_lvt_W90p63_L0p74_m1__nf1_gboth_sdfull_pc/B.n1296 pfet_01v8_lvt_W90p63_L0p74_m1__nf1_gboth_sdfull_pc/B.n678 72.7879
R1405 pfet_01v8_lvt_W90p63_L0p74_m1__nf1_gboth_sdfull_pc/B.n1303 pfet_01v8_lvt_W90p63_L0p74_m1__nf1_gboth_sdfull_pc/B.n821 72.7879
R1406 pfet_01v8_lvt_W90p63_L0p74_m1__nf1_gboth_sdfull_pc/B.n1304 pfet_01v8_lvt_W90p63_L0p74_m1__nf1_gboth_sdfull_pc/B.n677 72.7879
R1407 pfet_01v8_lvt_W90p63_L0p74_m1__nf1_gboth_sdfull_pc/B.n1311 pfet_01v8_lvt_W90p63_L0p74_m1__nf1_gboth_sdfull_pc/B.n822 72.7879
R1408 pfet_01v8_lvt_W90p63_L0p74_m1__nf1_gboth_sdfull_pc/B.n1312 pfet_01v8_lvt_W90p63_L0p74_m1__nf1_gboth_sdfull_pc/B.n676 72.7879
R1409 pfet_01v8_lvt_W90p63_L0p74_m1__nf1_gboth_sdfull_pc/B.n1317 pfet_01v8_lvt_W90p63_L0p74_m1__nf1_gboth_sdfull_pc/B.n823 72.7879
R1410 pfet_01v8_lvt_W90p63_L0p74_m1__nf1_gboth_sdfull_pc/B.n1324 pfet_01v8_lvt_W90p63_L0p74_m1__nf1_gboth_sdfull_pc/B.n825 72.7879
R1411 pfet_01v8_lvt_W90p63_L0p74_m1__nf1_gboth_sdfull_pc/B.n1327 pfet_01v8_lvt_W90p63_L0p74_m1__nf1_gboth_sdfull_pc/B.n1326 72.7879
R1412 pfet_01v8_lvt_W90p63_L0p74_m1__nf1_gboth_sdfull_pc/B.n1325 pfet_01v8_lvt_W90p63_L0p74_m1__nf1_gboth_sdfull_pc/B.n755 56.1076
R1413 pfet_01v8_lvt_W90p63_L0p74_m1__nf1_gboth_sdfull_pc/B.n1325 pfet_01v8_lvt_W90p63_L0p74_m1__nf1_gboth_sdfull_pc/B.n754 56.1076
R1414 pfet_01v8_lvt_W90p63_L0p74_m1__nf1_gboth_sdfull_pc/B.n1325 pfet_01v8_lvt_W90p63_L0p74_m1__nf1_gboth_sdfull_pc/B.n757 56.1076
R1415 pfet_01v8_lvt_W90p63_L0p74_m1__nf1_gboth_sdfull_pc/B.n1325 pfet_01v8_lvt_W90p63_L0p74_m1__nf1_gboth_sdfull_pc/B.n758 56.1076
R1416 pfet_01v8_lvt_W90p63_L0p74_m1__nf1_gboth_sdfull_pc/B.n1325 pfet_01v8_lvt_W90p63_L0p74_m1__nf1_gboth_sdfull_pc/B.n753 56.1076
R1417 pfet_01v8_lvt_W90p63_L0p74_m1__nf1_gboth_sdfull_pc/B.n1325 pfet_01v8_lvt_W90p63_L0p74_m1__nf1_gboth_sdfull_pc/B.n752 56.1076
R1418 pfet_01v8_lvt_W90p63_L0p74_m1__nf1_gboth_sdfull_pc/B.n1325 pfet_01v8_lvt_W90p63_L0p74_m1__nf1_gboth_sdfull_pc/B.n759 56.1076
R1419 pfet_01v8_lvt_W90p63_L0p74_m1__nf1_gboth_sdfull_pc/B.n1325 pfet_01v8_lvt_W90p63_L0p74_m1__nf1_gboth_sdfull_pc/B.n750 56.1076
R1420 pfet_01v8_lvt_W90p63_L0p74_m1__nf1_gboth_sdfull_pc/B.n1325 pfet_01v8_lvt_W90p63_L0p74_m1__nf1_gboth_sdfull_pc/B.n749 56.1076
R1421 pfet_01v8_lvt_W90p63_L0p74_m1__nf1_gboth_sdfull_pc/B.n1325 pfet_01v8_lvt_W90p63_L0p74_m1__nf1_gboth_sdfull_pc/B.n761 56.1076
R1422 pfet_01v8_lvt_W90p63_L0p74_m1__nf1_gboth_sdfull_pc/B.n1325 pfet_01v8_lvt_W90p63_L0p74_m1__nf1_gboth_sdfull_pc/B.n747 56.1076
R1423 pfet_01v8_lvt_W90p63_L0p74_m1__nf1_gboth_sdfull_pc/B.n1325 pfet_01v8_lvt_W90p63_L0p74_m1__nf1_gboth_sdfull_pc/B.n762 56.1076
R1424 pfet_01v8_lvt_W90p63_L0p74_m1__nf1_gboth_sdfull_pc/B.n1325 pfet_01v8_lvt_W90p63_L0p74_m1__nf1_gboth_sdfull_pc/B.n763 56.1076
R1425 pfet_01v8_lvt_W90p63_L0p74_m1__nf1_gboth_sdfull_pc/B.n1325 pfet_01v8_lvt_W90p63_L0p74_m1__nf1_gboth_sdfull_pc/B.n746 56.1076
R1426 pfet_01v8_lvt_W90p63_L0p74_m1__nf1_gboth_sdfull_pc/B.n1325 pfet_01v8_lvt_W90p63_L0p74_m1__nf1_gboth_sdfull_pc/B.n764 56.1076
R1427 pfet_01v8_lvt_W90p63_L0p74_m1__nf1_gboth_sdfull_pc/B.n1325 pfet_01v8_lvt_W90p63_L0p74_m1__nf1_gboth_sdfull_pc/B.n766 56.1076
R1428 pfet_01v8_lvt_W90p63_L0p74_m1__nf1_gboth_sdfull_pc/B.n1325 pfet_01v8_lvt_W90p63_L0p74_m1__nf1_gboth_sdfull_pc/B.n745 56.1076
R1429 pfet_01v8_lvt_W90p63_L0p74_m1__nf1_gboth_sdfull_pc/B.n1325 pfet_01v8_lvt_W90p63_L0p74_m1__nf1_gboth_sdfull_pc/B.n767 56.1076
R1430 pfet_01v8_lvt_W90p63_L0p74_m1__nf1_gboth_sdfull_pc/B.n1325 pfet_01v8_lvt_W90p63_L0p74_m1__nf1_gboth_sdfull_pc/B.n743 56.1076
R1431 pfet_01v8_lvt_W90p63_L0p74_m1__nf1_gboth_sdfull_pc/B.n1325 pfet_01v8_lvt_W90p63_L0p74_m1__nf1_gboth_sdfull_pc/B.n742 56.1076
R1432 pfet_01v8_lvt_W90p63_L0p74_m1__nf1_gboth_sdfull_pc/B.n1325 pfet_01v8_lvt_W90p63_L0p74_m1__nf1_gboth_sdfull_pc/B.n769 56.1076
R1433 pfet_01v8_lvt_W90p63_L0p74_m1__nf1_gboth_sdfull_pc/B.n1325 pfet_01v8_lvt_W90p63_L0p74_m1__nf1_gboth_sdfull_pc/B.n740 56.1076
R1434 pfet_01v8_lvt_W90p63_L0p74_m1__nf1_gboth_sdfull_pc/B.n1325 pfet_01v8_lvt_W90p63_L0p74_m1__nf1_gboth_sdfull_pc/B.n771 56.1076
R1435 pfet_01v8_lvt_W90p63_L0p74_m1__nf1_gboth_sdfull_pc/B.n1325 pfet_01v8_lvt_W90p63_L0p74_m1__nf1_gboth_sdfull_pc/B.n738 56.1076
R1436 pfet_01v8_lvt_W90p63_L0p74_m1__nf1_gboth_sdfull_pc/B.n1325 pfet_01v8_lvt_W90p63_L0p74_m1__nf1_gboth_sdfull_pc/B.n737 56.1076
R1437 pfet_01v8_lvt_W90p63_L0p74_m1__nf1_gboth_sdfull_pc/B.n1325 pfet_01v8_lvt_W90p63_L0p74_m1__nf1_gboth_sdfull_pc/B.n735 56.1076
R1438 pfet_01v8_lvt_W90p63_L0p74_m1__nf1_gboth_sdfull_pc/B.n1325 pfet_01v8_lvt_W90p63_L0p74_m1__nf1_gboth_sdfull_pc/B.n773 56.1076
R1439 pfet_01v8_lvt_W90p63_L0p74_m1__nf1_gboth_sdfull_pc/B.n1325 pfet_01v8_lvt_W90p63_L0p74_m1__nf1_gboth_sdfull_pc/B.n734 56.1076
R1440 pfet_01v8_lvt_W90p63_L0p74_m1__nf1_gboth_sdfull_pc/B.n1325 pfet_01v8_lvt_W90p63_L0p74_m1__nf1_gboth_sdfull_pc/B.n775 56.1076
R1441 pfet_01v8_lvt_W90p63_L0p74_m1__nf1_gboth_sdfull_pc/B.n1325 pfet_01v8_lvt_W90p63_L0p74_m1__nf1_gboth_sdfull_pc/B.n776 56.1076
R1442 pfet_01v8_lvt_W90p63_L0p74_m1__nf1_gboth_sdfull_pc/B.n1325 pfet_01v8_lvt_W90p63_L0p74_m1__nf1_gboth_sdfull_pc/B.n732 56.1076
R1443 pfet_01v8_lvt_W90p63_L0p74_m1__nf1_gboth_sdfull_pc/B.n1325 pfet_01v8_lvt_W90p63_L0p74_m1__nf1_gboth_sdfull_pc/B.n731 56.1076
R1444 pfet_01v8_lvt_W90p63_L0p74_m1__nf1_gboth_sdfull_pc/B.n1325 pfet_01v8_lvt_W90p63_L0p74_m1__nf1_gboth_sdfull_pc/B.n778 56.1076
R1445 pfet_01v8_lvt_W90p63_L0p74_m1__nf1_gboth_sdfull_pc/B.n1325 pfet_01v8_lvt_W90p63_L0p74_m1__nf1_gboth_sdfull_pc/B.n730 56.1076
R1446 pfet_01v8_lvt_W90p63_L0p74_m1__nf1_gboth_sdfull_pc/B.n1325 pfet_01v8_lvt_W90p63_L0p74_m1__nf1_gboth_sdfull_pc/B.n729 56.1076
R1447 pfet_01v8_lvt_W90p63_L0p74_m1__nf1_gboth_sdfull_pc/B.n1325 pfet_01v8_lvt_W90p63_L0p74_m1__nf1_gboth_sdfull_pc/B.n728 56.1076
R1448 pfet_01v8_lvt_W90p63_L0p74_m1__nf1_gboth_sdfull_pc/B.n1325 pfet_01v8_lvt_W90p63_L0p74_m1__nf1_gboth_sdfull_pc/B.n779 56.1076
R1449 pfet_01v8_lvt_W90p63_L0p74_m1__nf1_gboth_sdfull_pc/B.n1325 pfet_01v8_lvt_W90p63_L0p74_m1__nf1_gboth_sdfull_pc/B.n727 56.1076
R1450 pfet_01v8_lvt_W90p63_L0p74_m1__nf1_gboth_sdfull_pc/B.n1325 pfet_01v8_lvt_W90p63_L0p74_m1__nf1_gboth_sdfull_pc/B.n726 56.1076
R1451 pfet_01v8_lvt_W90p63_L0p74_m1__nf1_gboth_sdfull_pc/B.n1325 pfet_01v8_lvt_W90p63_L0p74_m1__nf1_gboth_sdfull_pc/B.n780 56.1076
R1452 pfet_01v8_lvt_W90p63_L0p74_m1__nf1_gboth_sdfull_pc/B.n1325 pfet_01v8_lvt_W90p63_L0p74_m1__nf1_gboth_sdfull_pc/B.n724 56.1076
R1453 pfet_01v8_lvt_W90p63_L0p74_m1__nf1_gboth_sdfull_pc/B.n1325 pfet_01v8_lvt_W90p63_L0p74_m1__nf1_gboth_sdfull_pc/B.n782 56.1076
R1454 pfet_01v8_lvt_W90p63_L0p74_m1__nf1_gboth_sdfull_pc/B.n1325 pfet_01v8_lvt_W90p63_L0p74_m1__nf1_gboth_sdfull_pc/B.n722 56.1076
R1455 pfet_01v8_lvt_W90p63_L0p74_m1__nf1_gboth_sdfull_pc/B.n1325 pfet_01v8_lvt_W90p63_L0p74_m1__nf1_gboth_sdfull_pc/B.n784 56.1076
R1456 pfet_01v8_lvt_W90p63_L0p74_m1__nf1_gboth_sdfull_pc/B.n1325 pfet_01v8_lvt_W90p63_L0p74_m1__nf1_gboth_sdfull_pc/B.n785 56.1076
R1457 pfet_01v8_lvt_W90p63_L0p74_m1__nf1_gboth_sdfull_pc/B.n1325 pfet_01v8_lvt_W90p63_L0p74_m1__nf1_gboth_sdfull_pc/B.n720 56.1076
R1458 pfet_01v8_lvt_W90p63_L0p74_m1__nf1_gboth_sdfull_pc/B.n1325 pfet_01v8_lvt_W90p63_L0p74_m1__nf1_gboth_sdfull_pc/B.n786 56.1076
R1459 pfet_01v8_lvt_W90p63_L0p74_m1__nf1_gboth_sdfull_pc/B.n1325 pfet_01v8_lvt_W90p63_L0p74_m1__nf1_gboth_sdfull_pc/B.n719 56.1076
R1460 pfet_01v8_lvt_W90p63_L0p74_m1__nf1_gboth_sdfull_pc/B.n1325 pfet_01v8_lvt_W90p63_L0p74_m1__nf1_gboth_sdfull_pc/B.n718 56.1076
R1461 pfet_01v8_lvt_W90p63_L0p74_m1__nf1_gboth_sdfull_pc/B.n1325 pfet_01v8_lvt_W90p63_L0p74_m1__nf1_gboth_sdfull_pc/B.n717 56.1076
R1462 pfet_01v8_lvt_W90p63_L0p74_m1__nf1_gboth_sdfull_pc/B.n1325 pfet_01v8_lvt_W90p63_L0p74_m1__nf1_gboth_sdfull_pc/B.n716 56.1076
R1463 pfet_01v8_lvt_W90p63_L0p74_m1__nf1_gboth_sdfull_pc/B.n1325 pfet_01v8_lvt_W90p63_L0p74_m1__nf1_gboth_sdfull_pc/B.n788 56.1076
R1464 pfet_01v8_lvt_W90p63_L0p74_m1__nf1_gboth_sdfull_pc/B.n1325 pfet_01v8_lvt_W90p63_L0p74_m1__nf1_gboth_sdfull_pc/B.n715 56.1076
R1465 pfet_01v8_lvt_W90p63_L0p74_m1__nf1_gboth_sdfull_pc/B.n1325 pfet_01v8_lvt_W90p63_L0p74_m1__nf1_gboth_sdfull_pc/B.n789 56.1076
R1466 pfet_01v8_lvt_W90p63_L0p74_m1__nf1_gboth_sdfull_pc/B.n1325 pfet_01v8_lvt_W90p63_L0p74_m1__nf1_gboth_sdfull_pc/B.n790 56.1076
R1467 pfet_01v8_lvt_W90p63_L0p74_m1__nf1_gboth_sdfull_pc/B.n1325 pfet_01v8_lvt_W90p63_L0p74_m1__nf1_gboth_sdfull_pc/B.n791 56.1076
R1468 pfet_01v8_lvt_W90p63_L0p74_m1__nf1_gboth_sdfull_pc/B.n1325 pfet_01v8_lvt_W90p63_L0p74_m1__nf1_gboth_sdfull_pc/B.n792 56.1076
R1469 pfet_01v8_lvt_W90p63_L0p74_m1__nf1_gboth_sdfull_pc/B.n1325 pfet_01v8_lvt_W90p63_L0p74_m1__nf1_gboth_sdfull_pc/B.n713 56.1076
R1470 pfet_01v8_lvt_W90p63_L0p74_m1__nf1_gboth_sdfull_pc/B.n1325 pfet_01v8_lvt_W90p63_L0p74_m1__nf1_gboth_sdfull_pc/B.n794 56.1076
R1471 pfet_01v8_lvt_W90p63_L0p74_m1__nf1_gboth_sdfull_pc/B.n1325 pfet_01v8_lvt_W90p63_L0p74_m1__nf1_gboth_sdfull_pc/B.n796 56.1076
R1472 pfet_01v8_lvt_W90p63_L0p74_m1__nf1_gboth_sdfull_pc/B.n1325 pfet_01v8_lvt_W90p63_L0p74_m1__nf1_gboth_sdfull_pc/B.n711 56.1076
R1473 pfet_01v8_lvt_W90p63_L0p74_m1__nf1_gboth_sdfull_pc/B.n1325 pfet_01v8_lvt_W90p63_L0p74_m1__nf1_gboth_sdfull_pc/B.n797 56.1076
R1474 pfet_01v8_lvt_W90p63_L0p74_m1__nf1_gboth_sdfull_pc/B.n1325 pfet_01v8_lvt_W90p63_L0p74_m1__nf1_gboth_sdfull_pc/B.n798 56.1076
R1475 pfet_01v8_lvt_W90p63_L0p74_m1__nf1_gboth_sdfull_pc/B.n1325 pfet_01v8_lvt_W90p63_L0p74_m1__nf1_gboth_sdfull_pc/B.n799 56.1076
R1476 pfet_01v8_lvt_W90p63_L0p74_m1__nf1_gboth_sdfull_pc/B.n1325 pfet_01v8_lvt_W90p63_L0p74_m1__nf1_gboth_sdfull_pc/B.n801 56.1076
R1477 pfet_01v8_lvt_W90p63_L0p74_m1__nf1_gboth_sdfull_pc/B.n1325 pfet_01v8_lvt_W90p63_L0p74_m1__nf1_gboth_sdfull_pc/B.n709 56.1076
R1478 pfet_01v8_lvt_W90p63_L0p74_m1__nf1_gboth_sdfull_pc/B.n1325 pfet_01v8_lvt_W90p63_L0p74_m1__nf1_gboth_sdfull_pc/B.n708 56.1076
R1479 pfet_01v8_lvt_W90p63_L0p74_m1__nf1_gboth_sdfull_pc/B.n1325 pfet_01v8_lvt_W90p63_L0p74_m1__nf1_gboth_sdfull_pc/B.n802 56.1076
R1480 pfet_01v8_lvt_W90p63_L0p74_m1__nf1_gboth_sdfull_pc/B.n1325 pfet_01v8_lvt_W90p63_L0p74_m1__nf1_gboth_sdfull_pc/B.n706 56.1076
R1481 pfet_01v8_lvt_W90p63_L0p74_m1__nf1_gboth_sdfull_pc/B.n1325 pfet_01v8_lvt_W90p63_L0p74_m1__nf1_gboth_sdfull_pc/B.n803 56.1076
R1482 pfet_01v8_lvt_W90p63_L0p74_m1__nf1_gboth_sdfull_pc/B.n1325 pfet_01v8_lvt_W90p63_L0p74_m1__nf1_gboth_sdfull_pc/B.n705 56.1076
R1483 pfet_01v8_lvt_W90p63_L0p74_m1__nf1_gboth_sdfull_pc/B.n1325 pfet_01v8_lvt_W90p63_L0p74_m1__nf1_gboth_sdfull_pc/B.n805 56.1076
R1484 pfet_01v8_lvt_W90p63_L0p74_m1__nf1_gboth_sdfull_pc/B.n1325 pfet_01v8_lvt_W90p63_L0p74_m1__nf1_gboth_sdfull_pc/B.n806 56.1076
R1485 pfet_01v8_lvt_W90p63_L0p74_m1__nf1_gboth_sdfull_pc/B.n1325 pfet_01v8_lvt_W90p63_L0p74_m1__nf1_gboth_sdfull_pc/B.n703 56.1076
R1486 pfet_01v8_lvt_W90p63_L0p74_m1__nf1_gboth_sdfull_pc/B.n1325 pfet_01v8_lvt_W90p63_L0p74_m1__nf1_gboth_sdfull_pc/B.n807 56.1076
R1487 pfet_01v8_lvt_W90p63_L0p74_m1__nf1_gboth_sdfull_pc/B.n1325 pfet_01v8_lvt_W90p63_L0p74_m1__nf1_gboth_sdfull_pc/B.n809 56.1076
R1488 pfet_01v8_lvt_W90p63_L0p74_m1__nf1_gboth_sdfull_pc/B.n1325 pfet_01v8_lvt_W90p63_L0p74_m1__nf1_gboth_sdfull_pc/B.n702 56.1076
R1489 pfet_01v8_lvt_W90p63_L0p74_m1__nf1_gboth_sdfull_pc/B.n1325 pfet_01v8_lvt_W90p63_L0p74_m1__nf1_gboth_sdfull_pc/B.n810 56.1076
R1490 pfet_01v8_lvt_W90p63_L0p74_m1__nf1_gboth_sdfull_pc/B.n1325 pfet_01v8_lvt_W90p63_L0p74_m1__nf1_gboth_sdfull_pc/B.n701 56.1076
R1491 pfet_01v8_lvt_W90p63_L0p74_m1__nf1_gboth_sdfull_pc/B.n1325 pfet_01v8_lvt_W90p63_L0p74_m1__nf1_gboth_sdfull_pc/B.n700 56.1076
R1492 pfet_01v8_lvt_W90p63_L0p74_m1__nf1_gboth_sdfull_pc/B.n1325 pfet_01v8_lvt_W90p63_L0p74_m1__nf1_gboth_sdfull_pc/B.n811 56.1076
R1493 pfet_01v8_lvt_W90p63_L0p74_m1__nf1_gboth_sdfull_pc/B.n1325 pfet_01v8_lvt_W90p63_L0p74_m1__nf1_gboth_sdfull_pc/B.n698 56.1076
R1494 pfet_01v8_lvt_W90p63_L0p74_m1__nf1_gboth_sdfull_pc/B.n1325 pfet_01v8_lvt_W90p63_L0p74_m1__nf1_gboth_sdfull_pc/B.n812 56.1076
R1495 pfet_01v8_lvt_W90p63_L0p74_m1__nf1_gboth_sdfull_pc/B.n1325 pfet_01v8_lvt_W90p63_L0p74_m1__nf1_gboth_sdfull_pc/B.n697 56.1076
R1496 pfet_01v8_lvt_W90p63_L0p74_m1__nf1_gboth_sdfull_pc/B.n1325 pfet_01v8_lvt_W90p63_L0p74_m1__nf1_gboth_sdfull_pc/B.n813 56.1076
R1497 pfet_01v8_lvt_W90p63_L0p74_m1__nf1_gboth_sdfull_pc/B.n1325 pfet_01v8_lvt_W90p63_L0p74_m1__nf1_gboth_sdfull_pc/B.n814 56.1076
R1498 pfet_01v8_lvt_W90p63_L0p74_m1__nf1_gboth_sdfull_pc/B.n1325 pfet_01v8_lvt_W90p63_L0p74_m1__nf1_gboth_sdfull_pc/B.n696 56.1076
R1499 pfet_01v8_lvt_W90p63_L0p74_m1__nf1_gboth_sdfull_pc/B.n1325 pfet_01v8_lvt_W90p63_L0p74_m1__nf1_gboth_sdfull_pc/B.n815 56.1076
R1500 pfet_01v8_lvt_W90p63_L0p74_m1__nf1_gboth_sdfull_pc/B.n1325 pfet_01v8_lvt_W90p63_L0p74_m1__nf1_gboth_sdfull_pc/B.n695 56.1076
R1501 pfet_01v8_lvt_W90p63_L0p74_m1__nf1_gboth_sdfull_pc/B.n1325 pfet_01v8_lvt_W90p63_L0p74_m1__nf1_gboth_sdfull_pc/B.n694 56.1076
R1502 pfet_01v8_lvt_W90p63_L0p74_m1__nf1_gboth_sdfull_pc/B.n1325 pfet_01v8_lvt_W90p63_L0p74_m1__nf1_gboth_sdfull_pc/B.n693 56.1076
R1503 pfet_01v8_lvt_W90p63_L0p74_m1__nf1_gboth_sdfull_pc/B.n1325 pfet_01v8_lvt_W90p63_L0p74_m1__nf1_gboth_sdfull_pc/B.n817 56.1076
R1504 pfet_01v8_lvt_W90p63_L0p74_m1__nf1_gboth_sdfull_pc/B.n1325 pfet_01v8_lvt_W90p63_L0p74_m1__nf1_gboth_sdfull_pc/B.n692 56.1076
R1505 pfet_01v8_lvt_W90p63_L0p74_m1__nf1_gboth_sdfull_pc/B.n1325 pfet_01v8_lvt_W90p63_L0p74_m1__nf1_gboth_sdfull_pc/B.n691 56.1076
R1506 pfet_01v8_lvt_W90p63_L0p74_m1__nf1_gboth_sdfull_pc/B.n1325 pfet_01v8_lvt_W90p63_L0p74_m1__nf1_gboth_sdfull_pc/B.n818 56.1076
R1507 pfet_01v8_lvt_W90p63_L0p74_m1__nf1_gboth_sdfull_pc/B.n1325 pfet_01v8_lvt_W90p63_L0p74_m1__nf1_gboth_sdfull_pc/B.n690 56.1076
R1508 pfet_01v8_lvt_W90p63_L0p74_m1__nf1_gboth_sdfull_pc/B.n1325 pfet_01v8_lvt_W90p63_L0p74_m1__nf1_gboth_sdfull_pc/B.n689 56.1076
R1509 pfet_01v8_lvt_W90p63_L0p74_m1__nf1_gboth_sdfull_pc/B.n1325 pfet_01v8_lvt_W90p63_L0p74_m1__nf1_gboth_sdfull_pc/B.n688 56.1076
R1510 pfet_01v8_lvt_W90p63_L0p74_m1__nf1_gboth_sdfull_pc/B.n1325 pfet_01v8_lvt_W90p63_L0p74_m1__nf1_gboth_sdfull_pc/B.n687 56.1076
R1511 pfet_01v8_lvt_W90p63_L0p74_m1__nf1_gboth_sdfull_pc/B.n1325 pfet_01v8_lvt_W90p63_L0p74_m1__nf1_gboth_sdfull_pc/B.n686 56.1076
R1512 pfet_01v8_lvt_W90p63_L0p74_m1__nf1_gboth_sdfull_pc/B.n1325 pfet_01v8_lvt_W90p63_L0p74_m1__nf1_gboth_sdfull_pc/B.n685 56.1076
R1513 pfet_01v8_lvt_W90p63_L0p74_m1__nf1_gboth_sdfull_pc/B.n1325 pfet_01v8_lvt_W90p63_L0p74_m1__nf1_gboth_sdfull_pc/B.n684 56.1076
R1514 pfet_01v8_lvt_W90p63_L0p74_m1__nf1_gboth_sdfull_pc/B.n1325 pfet_01v8_lvt_W90p63_L0p74_m1__nf1_gboth_sdfull_pc/B.n683 56.1076
R1515 pfet_01v8_lvt_W90p63_L0p74_m1__nf1_gboth_sdfull_pc/B.n1325 pfet_01v8_lvt_W90p63_L0p74_m1__nf1_gboth_sdfull_pc/B.n682 56.1076
R1516 pfet_01v8_lvt_W90p63_L0p74_m1__nf1_gboth_sdfull_pc/B.n1325 pfet_01v8_lvt_W90p63_L0p74_m1__nf1_gboth_sdfull_pc/B.n681 56.1076
R1517 pfet_01v8_lvt_W90p63_L0p74_m1__nf1_gboth_sdfull_pc/B.n1325 pfet_01v8_lvt_W90p63_L0p74_m1__nf1_gboth_sdfull_pc/B.n819 56.1076
R1518 pfet_01v8_lvt_W90p63_L0p74_m1__nf1_gboth_sdfull_pc/B.n1325 pfet_01v8_lvt_W90p63_L0p74_m1__nf1_gboth_sdfull_pc/B.n680 56.1076
R1519 pfet_01v8_lvt_W90p63_L0p74_m1__nf1_gboth_sdfull_pc/B.n1325 pfet_01v8_lvt_W90p63_L0p74_m1__nf1_gboth_sdfull_pc/B.n679 56.1076
R1520 pfet_01v8_lvt_W90p63_L0p74_m1__nf1_gboth_sdfull_pc/B.n1325 pfet_01v8_lvt_W90p63_L0p74_m1__nf1_gboth_sdfull_pc/B.n820 56.1076
R1521 pfet_01v8_lvt_W90p63_L0p74_m1__nf1_gboth_sdfull_pc/B.n1325 pfet_01v8_lvt_W90p63_L0p74_m1__nf1_gboth_sdfull_pc/B.n678 56.1076
R1522 pfet_01v8_lvt_W90p63_L0p74_m1__nf1_gboth_sdfull_pc/B.n1325 pfet_01v8_lvt_W90p63_L0p74_m1__nf1_gboth_sdfull_pc/B.n821 56.1076
R1523 pfet_01v8_lvt_W90p63_L0p74_m1__nf1_gboth_sdfull_pc/B.n1325 pfet_01v8_lvt_W90p63_L0p74_m1__nf1_gboth_sdfull_pc/B.n677 56.1076
R1524 pfet_01v8_lvt_W90p63_L0p74_m1__nf1_gboth_sdfull_pc/B.n1325 pfet_01v8_lvt_W90p63_L0p74_m1__nf1_gboth_sdfull_pc/B.n822 56.1076
R1525 pfet_01v8_lvt_W90p63_L0p74_m1__nf1_gboth_sdfull_pc/B.n1325 pfet_01v8_lvt_W90p63_L0p74_m1__nf1_gboth_sdfull_pc/B.n676 56.1076
R1526 pfet_01v8_lvt_W90p63_L0p74_m1__nf1_gboth_sdfull_pc/B.n1325 pfet_01v8_lvt_W90p63_L0p74_m1__nf1_gboth_sdfull_pc/B.n823 56.1076
R1527 pfet_01v8_lvt_W90p63_L0p74_m1__nf1_gboth_sdfull_pc/B.n1325 pfet_01v8_lvt_W90p63_L0p74_m1__nf1_gboth_sdfull_pc/B.n1324 56.1076
R1528 pfet_01v8_lvt_W90p63_L0p74_m1__nf1_gboth_sdfull_pc/B.n1326 pfet_01v8_lvt_W90p63_L0p74_m1__nf1_gboth_sdfull_pc/B.n1325 56.1076
R1529 pfet_01v8_lvt_W90p63_L0p74_m1__nf1_gboth_sdfull_pc/B.n158 pfet_01v8_lvt_W90p63_L0p74_m1__nf1_gboth_sdfull_pc/B.n9 56.1076
R1530 pfet_01v8_lvt_W90p63_L0p74_m1__nf1_gboth_sdfull_pc/B.n163 pfet_01v8_lvt_W90p63_L0p74_m1__nf1_gboth_sdfull_pc/B.n9 56.1076
R1531 pfet_01v8_lvt_W90p63_L0p74_m1__nf1_gboth_sdfull_pc/B.n156 pfet_01v8_lvt_W90p63_L0p74_m1__nf1_gboth_sdfull_pc/B.n9 56.1076
R1532 pfet_01v8_lvt_W90p63_L0p74_m1__nf1_gboth_sdfull_pc/B.n154 pfet_01v8_lvt_W90p63_L0p74_m1__nf1_gboth_sdfull_pc/B.n9 56.1076
R1533 pfet_01v8_lvt_W90p63_L0p74_m1__nf1_gboth_sdfull_pc/B.n152 pfet_01v8_lvt_W90p63_L0p74_m1__nf1_gboth_sdfull_pc/B.n9 56.1076
R1534 pfet_01v8_lvt_W90p63_L0p74_m1__nf1_gboth_sdfull_pc/B.n180 pfet_01v8_lvt_W90p63_L0p74_m1__nf1_gboth_sdfull_pc/B.n9 56.1076
R1535 pfet_01v8_lvt_W90p63_L0p74_m1__nf1_gboth_sdfull_pc/B.n186 pfet_01v8_lvt_W90p63_L0p74_m1__nf1_gboth_sdfull_pc/B.n9 56.1076
R1536 pfet_01v8_lvt_W90p63_L0p74_m1__nf1_gboth_sdfull_pc/B.n188 pfet_01v8_lvt_W90p63_L0p74_m1__nf1_gboth_sdfull_pc/B.n9 56.1076
R1537 pfet_01v8_lvt_W90p63_L0p74_m1__nf1_gboth_sdfull_pc/B.n194 pfet_01v8_lvt_W90p63_L0p74_m1__nf1_gboth_sdfull_pc/B.n9 56.1076
R1538 pfet_01v8_lvt_W90p63_L0p74_m1__nf1_gboth_sdfull_pc/B.n196 pfet_01v8_lvt_W90p63_L0p74_m1__nf1_gboth_sdfull_pc/B.n9 56.1076
R1539 pfet_01v8_lvt_W90p63_L0p74_m1__nf1_gboth_sdfull_pc/B.n202 pfet_01v8_lvt_W90p63_L0p74_m1__nf1_gboth_sdfull_pc/B.n9 56.1076
R1540 pfet_01v8_lvt_W90p63_L0p74_m1__nf1_gboth_sdfull_pc/B.n144 pfet_01v8_lvt_W90p63_L0p74_m1__nf1_gboth_sdfull_pc/B.n9 56.1076
R1541 pfet_01v8_lvt_W90p63_L0p74_m1__nf1_gboth_sdfull_pc/B.n209 pfet_01v8_lvt_W90p63_L0p74_m1__nf1_gboth_sdfull_pc/B.n9 56.1076
R1542 pfet_01v8_lvt_W90p63_L0p74_m1__nf1_gboth_sdfull_pc/B.n215 pfet_01v8_lvt_W90p63_L0p74_m1__nf1_gboth_sdfull_pc/B.n9 56.1076
R1543 pfet_01v8_lvt_W90p63_L0p74_m1__nf1_gboth_sdfull_pc/B.n217 pfet_01v8_lvt_W90p63_L0p74_m1__nf1_gboth_sdfull_pc/B.n9 56.1076
R1544 pfet_01v8_lvt_W90p63_L0p74_m1__nf1_gboth_sdfull_pc/B.n223 pfet_01v8_lvt_W90p63_L0p74_m1__nf1_gboth_sdfull_pc/B.n9 56.1076
R1545 pfet_01v8_lvt_W90p63_L0p74_m1__nf1_gboth_sdfull_pc/B.n225 pfet_01v8_lvt_W90p63_L0p74_m1__nf1_gboth_sdfull_pc/B.n9 56.1076
R1546 pfet_01v8_lvt_W90p63_L0p74_m1__nf1_gboth_sdfull_pc/B.n231 pfet_01v8_lvt_W90p63_L0p74_m1__nf1_gboth_sdfull_pc/B.n9 56.1076
R1547 pfet_01v8_lvt_W90p63_L0p74_m1__nf1_gboth_sdfull_pc/B.n233 pfet_01v8_lvt_W90p63_L0p74_m1__nf1_gboth_sdfull_pc/B.n9 56.1076
R1548 pfet_01v8_lvt_W90p63_L0p74_m1__nf1_gboth_sdfull_pc/B.n239 pfet_01v8_lvt_W90p63_L0p74_m1__nf1_gboth_sdfull_pc/B.n9 56.1076
R1549 pfet_01v8_lvt_W90p63_L0p74_m1__nf1_gboth_sdfull_pc/B.n241 pfet_01v8_lvt_W90p63_L0p74_m1__nf1_gboth_sdfull_pc/B.n9 56.1076
R1550 pfet_01v8_lvt_W90p63_L0p74_m1__nf1_gboth_sdfull_pc/B.n247 pfet_01v8_lvt_W90p63_L0p74_m1__nf1_gboth_sdfull_pc/B.n9 56.1076
R1551 pfet_01v8_lvt_W90p63_L0p74_m1__nf1_gboth_sdfull_pc/B.n249 pfet_01v8_lvt_W90p63_L0p74_m1__nf1_gboth_sdfull_pc/B.n9 56.1076
R1552 pfet_01v8_lvt_W90p63_L0p74_m1__nf1_gboth_sdfull_pc/B.n255 pfet_01v8_lvt_W90p63_L0p74_m1__nf1_gboth_sdfull_pc/B.n9 56.1076
R1553 pfet_01v8_lvt_W90p63_L0p74_m1__nf1_gboth_sdfull_pc/B.n257 pfet_01v8_lvt_W90p63_L0p74_m1__nf1_gboth_sdfull_pc/B.n9 56.1076
R1554 pfet_01v8_lvt_W90p63_L0p74_m1__nf1_gboth_sdfull_pc/B.n263 pfet_01v8_lvt_W90p63_L0p74_m1__nf1_gboth_sdfull_pc/B.n9 56.1076
R1555 pfet_01v8_lvt_W90p63_L0p74_m1__nf1_gboth_sdfull_pc/B.n265 pfet_01v8_lvt_W90p63_L0p74_m1__nf1_gboth_sdfull_pc/B.n9 56.1076
R1556 pfet_01v8_lvt_W90p63_L0p74_m1__nf1_gboth_sdfull_pc/B.n271 pfet_01v8_lvt_W90p63_L0p74_m1__nf1_gboth_sdfull_pc/B.n9 56.1076
R1557 pfet_01v8_lvt_W90p63_L0p74_m1__nf1_gboth_sdfull_pc/B.n273 pfet_01v8_lvt_W90p63_L0p74_m1__nf1_gboth_sdfull_pc/B.n9 56.1076
R1558 pfet_01v8_lvt_W90p63_L0p74_m1__nf1_gboth_sdfull_pc/B.n279 pfet_01v8_lvt_W90p63_L0p74_m1__nf1_gboth_sdfull_pc/B.n9 56.1076
R1559 pfet_01v8_lvt_W90p63_L0p74_m1__nf1_gboth_sdfull_pc/B.n281 pfet_01v8_lvt_W90p63_L0p74_m1__nf1_gboth_sdfull_pc/B.n9 56.1076
R1560 pfet_01v8_lvt_W90p63_L0p74_m1__nf1_gboth_sdfull_pc/B.n287 pfet_01v8_lvt_W90p63_L0p74_m1__nf1_gboth_sdfull_pc/B.n9 56.1076
R1561 pfet_01v8_lvt_W90p63_L0p74_m1__nf1_gboth_sdfull_pc/B.n121 pfet_01v8_lvt_W90p63_L0p74_m1__nf1_gboth_sdfull_pc/B.n9 56.1076
R1562 pfet_01v8_lvt_W90p63_L0p74_m1__nf1_gboth_sdfull_pc/B.n295 pfet_01v8_lvt_W90p63_L0p74_m1__nf1_gboth_sdfull_pc/B.n9 56.1076
R1563 pfet_01v8_lvt_W90p63_L0p74_m1__nf1_gboth_sdfull_pc/B.n301 pfet_01v8_lvt_W90p63_L0p74_m1__nf1_gboth_sdfull_pc/B.n9 56.1076
R1564 pfet_01v8_lvt_W90p63_L0p74_m1__nf1_gboth_sdfull_pc/B.n303 pfet_01v8_lvt_W90p63_L0p74_m1__nf1_gboth_sdfull_pc/B.n9 56.1076
R1565 pfet_01v8_lvt_W90p63_L0p74_m1__nf1_gboth_sdfull_pc/B.n309 pfet_01v8_lvt_W90p63_L0p74_m1__nf1_gboth_sdfull_pc/B.n9 56.1076
R1566 pfet_01v8_lvt_W90p63_L0p74_m1__nf1_gboth_sdfull_pc/B.n115 pfet_01v8_lvt_W90p63_L0p74_m1__nf1_gboth_sdfull_pc/B.n9 56.1076
R1567 pfet_01v8_lvt_W90p63_L0p74_m1__nf1_gboth_sdfull_pc/B.n316 pfet_01v8_lvt_W90p63_L0p74_m1__nf1_gboth_sdfull_pc/B.n9 56.1076
R1568 pfet_01v8_lvt_W90p63_L0p74_m1__nf1_gboth_sdfull_pc/B.n322 pfet_01v8_lvt_W90p63_L0p74_m1__nf1_gboth_sdfull_pc/B.n9 56.1076
R1569 pfet_01v8_lvt_W90p63_L0p74_m1__nf1_gboth_sdfull_pc/B.n111 pfet_01v8_lvt_W90p63_L0p74_m1__nf1_gboth_sdfull_pc/B.n9 56.1076
R1570 pfet_01v8_lvt_W90p63_L0p74_m1__nf1_gboth_sdfull_pc/B.n329 pfet_01v8_lvt_W90p63_L0p74_m1__nf1_gboth_sdfull_pc/B.n9 56.1076
R1571 pfet_01v8_lvt_W90p63_L0p74_m1__nf1_gboth_sdfull_pc/B.n335 pfet_01v8_lvt_W90p63_L0p74_m1__nf1_gboth_sdfull_pc/B.n9 56.1076
R1572 pfet_01v8_lvt_W90p63_L0p74_m1__nf1_gboth_sdfull_pc/B.n337 pfet_01v8_lvt_W90p63_L0p74_m1__nf1_gboth_sdfull_pc/B.n9 56.1076
R1573 pfet_01v8_lvt_W90p63_L0p74_m1__nf1_gboth_sdfull_pc/B.n343 pfet_01v8_lvt_W90p63_L0p74_m1__nf1_gboth_sdfull_pc/B.n9 56.1076
R1574 pfet_01v8_lvt_W90p63_L0p74_m1__nf1_gboth_sdfull_pc/B.n345 pfet_01v8_lvt_W90p63_L0p74_m1__nf1_gboth_sdfull_pc/B.n9 56.1076
R1575 pfet_01v8_lvt_W90p63_L0p74_m1__nf1_gboth_sdfull_pc/B.n351 pfet_01v8_lvt_W90p63_L0p74_m1__nf1_gboth_sdfull_pc/B.n9 56.1076
R1576 pfet_01v8_lvt_W90p63_L0p74_m1__nf1_gboth_sdfull_pc/B.n353 pfet_01v8_lvt_W90p63_L0p74_m1__nf1_gboth_sdfull_pc/B.n9 56.1076
R1577 pfet_01v8_lvt_W90p63_L0p74_m1__nf1_gboth_sdfull_pc/B.n359 pfet_01v8_lvt_W90p63_L0p74_m1__nf1_gboth_sdfull_pc/B.n9 56.1076
R1578 pfet_01v8_lvt_W90p63_L0p74_m1__nf1_gboth_sdfull_pc/B.n361 pfet_01v8_lvt_W90p63_L0p74_m1__nf1_gboth_sdfull_pc/B.n9 56.1076
R1579 pfet_01v8_lvt_W90p63_L0p74_m1__nf1_gboth_sdfull_pc/B.n367 pfet_01v8_lvt_W90p63_L0p74_m1__nf1_gboth_sdfull_pc/B.n9 56.1076
R1580 pfet_01v8_lvt_W90p63_L0p74_m1__nf1_gboth_sdfull_pc/B.n369 pfet_01v8_lvt_W90p63_L0p74_m1__nf1_gboth_sdfull_pc/B.n9 56.1076
R1581 pfet_01v8_lvt_W90p63_L0p74_m1__nf1_gboth_sdfull_pc/B.n375 pfet_01v8_lvt_W90p63_L0p74_m1__nf1_gboth_sdfull_pc/B.n9 56.1076
R1582 pfet_01v8_lvt_W90p63_L0p74_m1__nf1_gboth_sdfull_pc/B.n377 pfet_01v8_lvt_W90p63_L0p74_m1__nf1_gboth_sdfull_pc/B.n9 56.1076
R1583 pfet_01v8_lvt_W90p63_L0p74_m1__nf1_gboth_sdfull_pc/B.n383 pfet_01v8_lvt_W90p63_L0p74_m1__nf1_gboth_sdfull_pc/B.n9 56.1076
R1584 pfet_01v8_lvt_W90p63_L0p74_m1__nf1_gboth_sdfull_pc/B.n95 pfet_01v8_lvt_W90p63_L0p74_m1__nf1_gboth_sdfull_pc/B.n9 56.1076
R1585 pfet_01v8_lvt_W90p63_L0p74_m1__nf1_gboth_sdfull_pc/B.n390 pfet_01v8_lvt_W90p63_L0p74_m1__nf1_gboth_sdfull_pc/B.n9 56.1076
R1586 pfet_01v8_lvt_W90p63_L0p74_m1__nf1_gboth_sdfull_pc/B.n396 pfet_01v8_lvt_W90p63_L0p74_m1__nf1_gboth_sdfull_pc/B.n9 56.1076
R1587 pfet_01v8_lvt_W90p63_L0p74_m1__nf1_gboth_sdfull_pc/B.n398 pfet_01v8_lvt_W90p63_L0p74_m1__nf1_gboth_sdfull_pc/B.n9 56.1076
R1588 pfet_01v8_lvt_W90p63_L0p74_m1__nf1_gboth_sdfull_pc/B.n404 pfet_01v8_lvt_W90p63_L0p74_m1__nf1_gboth_sdfull_pc/B.n9 56.1076
R1589 pfet_01v8_lvt_W90p63_L0p74_m1__nf1_gboth_sdfull_pc/B.n406 pfet_01v8_lvt_W90p63_L0p74_m1__nf1_gboth_sdfull_pc/B.n9 56.1076
R1590 pfet_01v8_lvt_W90p63_L0p74_m1__nf1_gboth_sdfull_pc/B.n412 pfet_01v8_lvt_W90p63_L0p74_m1__nf1_gboth_sdfull_pc/B.n9 56.1076
R1591 pfet_01v8_lvt_W90p63_L0p74_m1__nf1_gboth_sdfull_pc/B.n87 pfet_01v8_lvt_W90p63_L0p74_m1__nf1_gboth_sdfull_pc/B.n9 56.1076
R1592 pfet_01v8_lvt_W90p63_L0p74_m1__nf1_gboth_sdfull_pc/B.n85 pfet_01v8_lvt_W90p63_L0p74_m1__nf1_gboth_sdfull_pc/B.n9 56.1076
R1593 pfet_01v8_lvt_W90p63_L0p74_m1__nf1_gboth_sdfull_pc/B.n424 pfet_01v8_lvt_W90p63_L0p74_m1__nf1_gboth_sdfull_pc/B.n9 56.1076
R1594 pfet_01v8_lvt_W90p63_L0p74_m1__nf1_gboth_sdfull_pc/B.n430 pfet_01v8_lvt_W90p63_L0p74_m1__nf1_gboth_sdfull_pc/B.n9 56.1076
R1595 pfet_01v8_lvt_W90p63_L0p74_m1__nf1_gboth_sdfull_pc/B.n432 pfet_01v8_lvt_W90p63_L0p74_m1__nf1_gboth_sdfull_pc/B.n9 56.1076
R1596 pfet_01v8_lvt_W90p63_L0p74_m1__nf1_gboth_sdfull_pc/B.n438 pfet_01v8_lvt_W90p63_L0p74_m1__nf1_gboth_sdfull_pc/B.n9 56.1076
R1597 pfet_01v8_lvt_W90p63_L0p74_m1__nf1_gboth_sdfull_pc/B.n440 pfet_01v8_lvt_W90p63_L0p74_m1__nf1_gboth_sdfull_pc/B.n9 56.1076
R1598 pfet_01v8_lvt_W90p63_L0p74_m1__nf1_gboth_sdfull_pc/B.n446 pfet_01v8_lvt_W90p63_L0p74_m1__nf1_gboth_sdfull_pc/B.n9 56.1076
R1599 pfet_01v8_lvt_W90p63_L0p74_m1__nf1_gboth_sdfull_pc/B.n449 pfet_01v8_lvt_W90p63_L0p74_m1__nf1_gboth_sdfull_pc/B.n9 56.1076
R1600 pfet_01v8_lvt_W90p63_L0p74_m1__nf1_gboth_sdfull_pc/B.n455 pfet_01v8_lvt_W90p63_L0p74_m1__nf1_gboth_sdfull_pc/B.n9 56.1076
R1601 pfet_01v8_lvt_W90p63_L0p74_m1__nf1_gboth_sdfull_pc/B.n457 pfet_01v8_lvt_W90p63_L0p74_m1__nf1_gboth_sdfull_pc/B.n9 56.1076
R1602 pfet_01v8_lvt_W90p63_L0p74_m1__nf1_gboth_sdfull_pc/B.n463 pfet_01v8_lvt_W90p63_L0p74_m1__nf1_gboth_sdfull_pc/B.n9 56.1076
R1603 pfet_01v8_lvt_W90p63_L0p74_m1__nf1_gboth_sdfull_pc/B.n72 pfet_01v8_lvt_W90p63_L0p74_m1__nf1_gboth_sdfull_pc/B.n9 56.1076
R1604 pfet_01v8_lvt_W90p63_L0p74_m1__nf1_gboth_sdfull_pc/B.n470 pfet_01v8_lvt_W90p63_L0p74_m1__nf1_gboth_sdfull_pc/B.n9 56.1076
R1605 pfet_01v8_lvt_W90p63_L0p74_m1__nf1_gboth_sdfull_pc/B.n476 pfet_01v8_lvt_W90p63_L0p74_m1__nf1_gboth_sdfull_pc/B.n9 56.1076
R1606 pfet_01v8_lvt_W90p63_L0p74_m1__nf1_gboth_sdfull_pc/B.n68 pfet_01v8_lvt_W90p63_L0p74_m1__nf1_gboth_sdfull_pc/B.n9 56.1076
R1607 pfet_01v8_lvt_W90p63_L0p74_m1__nf1_gboth_sdfull_pc/B.n483 pfet_01v8_lvt_W90p63_L0p74_m1__nf1_gboth_sdfull_pc/B.n9 56.1076
R1608 pfet_01v8_lvt_W90p63_L0p74_m1__nf1_gboth_sdfull_pc/B.n489 pfet_01v8_lvt_W90p63_L0p74_m1__nf1_gboth_sdfull_pc/B.n9 56.1076
R1609 pfet_01v8_lvt_W90p63_L0p74_m1__nf1_gboth_sdfull_pc/B.n491 pfet_01v8_lvt_W90p63_L0p74_m1__nf1_gboth_sdfull_pc/B.n9 56.1076
R1610 pfet_01v8_lvt_W90p63_L0p74_m1__nf1_gboth_sdfull_pc/B.n497 pfet_01v8_lvt_W90p63_L0p74_m1__nf1_gboth_sdfull_pc/B.n9 56.1076
R1611 pfet_01v8_lvt_W90p63_L0p74_m1__nf1_gboth_sdfull_pc/B.n499 pfet_01v8_lvt_W90p63_L0p74_m1__nf1_gboth_sdfull_pc/B.n9 56.1076
R1612 pfet_01v8_lvt_W90p63_L0p74_m1__nf1_gboth_sdfull_pc/B.n505 pfet_01v8_lvt_W90p63_L0p74_m1__nf1_gboth_sdfull_pc/B.n9 56.1076
R1613 pfet_01v8_lvt_W90p63_L0p74_m1__nf1_gboth_sdfull_pc/B.n59 pfet_01v8_lvt_W90p63_L0p74_m1__nf1_gboth_sdfull_pc/B.n9 56.1076
R1614 pfet_01v8_lvt_W90p63_L0p74_m1__nf1_gboth_sdfull_pc/B.n57 pfet_01v8_lvt_W90p63_L0p74_m1__nf1_gboth_sdfull_pc/B.n9 56.1076
R1615 pfet_01v8_lvt_W90p63_L0p74_m1__nf1_gboth_sdfull_pc/B.n55 pfet_01v8_lvt_W90p63_L0p74_m1__nf1_gboth_sdfull_pc/B.n9 56.1076
R1616 pfet_01v8_lvt_W90p63_L0p74_m1__nf1_gboth_sdfull_pc/B.n523 pfet_01v8_lvt_W90p63_L0p74_m1__nf1_gboth_sdfull_pc/B.n9 56.1076
R1617 pfet_01v8_lvt_W90p63_L0p74_m1__nf1_gboth_sdfull_pc/B.n529 pfet_01v8_lvt_W90p63_L0p74_m1__nf1_gboth_sdfull_pc/B.n9 56.1076
R1618 pfet_01v8_lvt_W90p63_L0p74_m1__nf1_gboth_sdfull_pc/B.n51 pfet_01v8_lvt_W90p63_L0p74_m1__nf1_gboth_sdfull_pc/B.n9 56.1076
R1619 pfet_01v8_lvt_W90p63_L0p74_m1__nf1_gboth_sdfull_pc/B.n536 pfet_01v8_lvt_W90p63_L0p74_m1__nf1_gboth_sdfull_pc/B.n9 56.1076
R1620 pfet_01v8_lvt_W90p63_L0p74_m1__nf1_gboth_sdfull_pc/B.n542 pfet_01v8_lvt_W90p63_L0p74_m1__nf1_gboth_sdfull_pc/B.n9 56.1076
R1621 pfet_01v8_lvt_W90p63_L0p74_m1__nf1_gboth_sdfull_pc/B.n545 pfet_01v8_lvt_W90p63_L0p74_m1__nf1_gboth_sdfull_pc/B.n9 56.1076
R1622 pfet_01v8_lvt_W90p63_L0p74_m1__nf1_gboth_sdfull_pc/B.n551 pfet_01v8_lvt_W90p63_L0p74_m1__nf1_gboth_sdfull_pc/B.n9 56.1076
R1623 pfet_01v8_lvt_W90p63_L0p74_m1__nf1_gboth_sdfull_pc/B.n43 pfet_01v8_lvt_W90p63_L0p74_m1__nf1_gboth_sdfull_pc/B.n9 56.1076
R1624 pfet_01v8_lvt_W90p63_L0p74_m1__nf1_gboth_sdfull_pc/B.n559 pfet_01v8_lvt_W90p63_L0p74_m1__nf1_gboth_sdfull_pc/B.n9 56.1076
R1625 pfet_01v8_lvt_W90p63_L0p74_m1__nf1_gboth_sdfull_pc/B.n565 pfet_01v8_lvt_W90p63_L0p74_m1__nf1_gboth_sdfull_pc/B.n9 56.1076
R1626 pfet_01v8_lvt_W90p63_L0p74_m1__nf1_gboth_sdfull_pc/B.n39 pfet_01v8_lvt_W90p63_L0p74_m1__nf1_gboth_sdfull_pc/B.n9 56.1076
R1627 pfet_01v8_lvt_W90p63_L0p74_m1__nf1_gboth_sdfull_pc/B.n572 pfet_01v8_lvt_W90p63_L0p74_m1__nf1_gboth_sdfull_pc/B.n9 56.1076
R1628 pfet_01v8_lvt_W90p63_L0p74_m1__nf1_gboth_sdfull_pc/B.n578 pfet_01v8_lvt_W90p63_L0p74_m1__nf1_gboth_sdfull_pc/B.n9 56.1076
R1629 pfet_01v8_lvt_W90p63_L0p74_m1__nf1_gboth_sdfull_pc/B.n580 pfet_01v8_lvt_W90p63_L0p74_m1__nf1_gboth_sdfull_pc/B.n9 56.1076
R1630 pfet_01v8_lvt_W90p63_L0p74_m1__nf1_gboth_sdfull_pc/B.n586 pfet_01v8_lvt_W90p63_L0p74_m1__nf1_gboth_sdfull_pc/B.n9 56.1076
R1631 pfet_01v8_lvt_W90p63_L0p74_m1__nf1_gboth_sdfull_pc/B.n33 pfet_01v8_lvt_W90p63_L0p74_m1__nf1_gboth_sdfull_pc/B.n9 56.1076
R1632 pfet_01v8_lvt_W90p63_L0p74_m1__nf1_gboth_sdfull_pc/B.n593 pfet_01v8_lvt_W90p63_L0p74_m1__nf1_gboth_sdfull_pc/B.n9 56.1076
R1633 pfet_01v8_lvt_W90p63_L0p74_m1__nf1_gboth_sdfull_pc/B.n599 pfet_01v8_lvt_W90p63_L0p74_m1__nf1_gboth_sdfull_pc/B.n9 56.1076
R1634 pfet_01v8_lvt_W90p63_L0p74_m1__nf1_gboth_sdfull_pc/B.n601 pfet_01v8_lvt_W90p63_L0p74_m1__nf1_gboth_sdfull_pc/B.n9 56.1076
R1635 pfet_01v8_lvt_W90p63_L0p74_m1__nf1_gboth_sdfull_pc/B.n607 pfet_01v8_lvt_W90p63_L0p74_m1__nf1_gboth_sdfull_pc/B.n9 56.1076
R1636 pfet_01v8_lvt_W90p63_L0p74_m1__nf1_gboth_sdfull_pc/B.n609 pfet_01v8_lvt_W90p63_L0p74_m1__nf1_gboth_sdfull_pc/B.n9 56.1076
R1637 pfet_01v8_lvt_W90p63_L0p74_m1__nf1_gboth_sdfull_pc/B.n615 pfet_01v8_lvt_W90p63_L0p74_m1__nf1_gboth_sdfull_pc/B.n9 56.1076
R1638 pfet_01v8_lvt_W90p63_L0p74_m1__nf1_gboth_sdfull_pc/B.n617 pfet_01v8_lvt_W90p63_L0p74_m1__nf1_gboth_sdfull_pc/B.n9 56.1076
R1639 pfet_01v8_lvt_W90p63_L0p74_m1__nf1_gboth_sdfull_pc/B.n623 pfet_01v8_lvt_W90p63_L0p74_m1__nf1_gboth_sdfull_pc/B.n9 56.1076
R1640 pfet_01v8_lvt_W90p63_L0p74_m1__nf1_gboth_sdfull_pc/B.n626 pfet_01v8_lvt_W90p63_L0p74_m1__nf1_gboth_sdfull_pc/B.n9 56.1076
R1641 pfet_01v8_lvt_W90p63_L0p74_m1__nf1_gboth_sdfull_pc/B.n632 pfet_01v8_lvt_W90p63_L0p74_m1__nf1_gboth_sdfull_pc/B.n9 56.1076
R1642 pfet_01v8_lvt_W90p63_L0p74_m1__nf1_gboth_sdfull_pc/B.n20 pfet_01v8_lvt_W90p63_L0p74_m1__nf1_gboth_sdfull_pc/B.n9 56.1076
R1643 pfet_01v8_lvt_W90p63_L0p74_m1__nf1_gboth_sdfull_pc/B.n18 pfet_01v8_lvt_W90p63_L0p74_m1__nf1_gboth_sdfull_pc/B.n9 56.1076
R1644 pfet_01v8_lvt_W90p63_L0p74_m1__nf1_gboth_sdfull_pc/B.n16 pfet_01v8_lvt_W90p63_L0p74_m1__nf1_gboth_sdfull_pc/B.n9 56.1076
R1645 pfet_01v8_lvt_W90p63_L0p74_m1__nf1_gboth_sdfull_pc/B.n14 pfet_01v8_lvt_W90p63_L0p74_m1__nf1_gboth_sdfull_pc/B.n9 56.1076
R1646 pfet_01v8_lvt_W90p63_L0p74_m1__nf1_gboth_sdfull_pc/B.n654 pfet_01v8_lvt_W90p63_L0p74_m1__nf1_gboth_sdfull_pc/B.n9 56.1076
R1647 pfet_01v8_lvt_W90p63_L0p74_m1__nf1_gboth_sdfull_pc/B.n660 pfet_01v8_lvt_W90p63_L0p74_m1__nf1_gboth_sdfull_pc/B.n9 56.1076
R1648 pfet_01v8_lvt_W90p63_L0p74_m1__nf1_gboth_sdfull_pc/B.n662 pfet_01v8_lvt_W90p63_L0p74_m1__nf1_gboth_sdfull_pc/B.n9 56.1076
R1649 pfet_01v8_lvt_W90p63_L0p74_m1__nf1_gboth_sdfull_pc/B.n1334 pfet_01v8_lvt_W90p63_L0p74_m1__nf1_gboth_sdfull_pc/B.n1 25.6005
R1650 pfet_01v8_lvt_W90p63_L0p74_m1__nf1_gboth_sdfull_pc/B.n666 pfet_01v8_lvt_W90p63_L0p74_m1__nf1_gboth_sdfull_pc/B.n0 25.6005
R1651 pfet_01v8_lvt_W90p63_L0p74_m1__nf1_gboth_sdfull_pc/B.n829 pfet_01v8_lvt_W90p63_L0p74_m1__nf1_gboth_sdfull_pc/B.n827 25.6005
R1652 pfet_01v8_lvt_W90p63_L0p74_m1__nf1_gboth_sdfull_pc/B.n830 pfet_01v8_lvt_W90p63_L0p74_m1__nf1_gboth_sdfull_pc/B.n829 25.6005
R1653 pfet_01v8_lvt_W90p63_L0p74_m1__nf1_gboth_sdfull_pc/B.n833 pfet_01v8_lvt_W90p63_L0p74_m1__nf1_gboth_sdfull_pc/B.n830 25.6005
R1654 pfet_01v8_lvt_W90p63_L0p74_m1__nf1_gboth_sdfull_pc/B.n834 pfet_01v8_lvt_W90p63_L0p74_m1__nf1_gboth_sdfull_pc/B.n833 25.6005
R1655 pfet_01v8_lvt_W90p63_L0p74_m1__nf1_gboth_sdfull_pc/B.n837 pfet_01v8_lvt_W90p63_L0p74_m1__nf1_gboth_sdfull_pc/B.n834 25.6005
R1656 pfet_01v8_lvt_W90p63_L0p74_m1__nf1_gboth_sdfull_pc/B.n838 pfet_01v8_lvt_W90p63_L0p74_m1__nf1_gboth_sdfull_pc/B.n837 25.6005
R1657 pfet_01v8_lvt_W90p63_L0p74_m1__nf1_gboth_sdfull_pc/B.n841 pfet_01v8_lvt_W90p63_L0p74_m1__nf1_gboth_sdfull_pc/B.n838 25.6005
R1658 pfet_01v8_lvt_W90p63_L0p74_m1__nf1_gboth_sdfull_pc/B.n842 pfet_01v8_lvt_W90p63_L0p74_m1__nf1_gboth_sdfull_pc/B.n841 25.6005
R1659 pfet_01v8_lvt_W90p63_L0p74_m1__nf1_gboth_sdfull_pc/B.n845 pfet_01v8_lvt_W90p63_L0p74_m1__nf1_gboth_sdfull_pc/B.n842 25.6005
R1660 pfet_01v8_lvt_W90p63_L0p74_m1__nf1_gboth_sdfull_pc/B.n846 pfet_01v8_lvt_W90p63_L0p74_m1__nf1_gboth_sdfull_pc/B.n845 25.6005
R1661 pfet_01v8_lvt_W90p63_L0p74_m1__nf1_gboth_sdfull_pc/B.n849 pfet_01v8_lvt_W90p63_L0p74_m1__nf1_gboth_sdfull_pc/B.n846 25.6005
R1662 pfet_01v8_lvt_W90p63_L0p74_m1__nf1_gboth_sdfull_pc/B.n851 pfet_01v8_lvt_W90p63_L0p74_m1__nf1_gboth_sdfull_pc/B.n849 25.6005
R1663 pfet_01v8_lvt_W90p63_L0p74_m1__nf1_gboth_sdfull_pc/B.n852 pfet_01v8_lvt_W90p63_L0p74_m1__nf1_gboth_sdfull_pc/B.n851 25.6005
R1664 pfet_01v8_lvt_W90p63_L0p74_m1__nf1_gboth_sdfull_pc/B.n854 pfet_01v8_lvt_W90p63_L0p74_m1__nf1_gboth_sdfull_pc/B.n852 25.6005
R1665 pfet_01v8_lvt_W90p63_L0p74_m1__nf1_gboth_sdfull_pc/B.n856 pfet_01v8_lvt_W90p63_L0p74_m1__nf1_gboth_sdfull_pc/B.n854 25.6005
R1666 pfet_01v8_lvt_W90p63_L0p74_m1__nf1_gboth_sdfull_pc/B.n857 pfet_01v8_lvt_W90p63_L0p74_m1__nf1_gboth_sdfull_pc/B.n856 25.6005
R1667 pfet_01v8_lvt_W90p63_L0p74_m1__nf1_gboth_sdfull_pc/B.n859 pfet_01v8_lvt_W90p63_L0p74_m1__nf1_gboth_sdfull_pc/B.n857 25.6005
R1668 pfet_01v8_lvt_W90p63_L0p74_m1__nf1_gboth_sdfull_pc/B.n860 pfet_01v8_lvt_W90p63_L0p74_m1__nf1_gboth_sdfull_pc/B.n859 25.6005
R1669 pfet_01v8_lvt_W90p63_L0p74_m1__nf1_gboth_sdfull_pc/B.n863 pfet_01v8_lvt_W90p63_L0p74_m1__nf1_gboth_sdfull_pc/B.n860 25.6005
R1670 pfet_01v8_lvt_W90p63_L0p74_m1__nf1_gboth_sdfull_pc/B.n865 pfet_01v8_lvt_W90p63_L0p74_m1__nf1_gboth_sdfull_pc/B.n863 25.6005
R1671 pfet_01v8_lvt_W90p63_L0p74_m1__nf1_gboth_sdfull_pc/B.n866 pfet_01v8_lvt_W90p63_L0p74_m1__nf1_gboth_sdfull_pc/B.n865 25.6005
R1672 pfet_01v8_lvt_W90p63_L0p74_m1__nf1_gboth_sdfull_pc/B.n868 pfet_01v8_lvt_W90p63_L0p74_m1__nf1_gboth_sdfull_pc/B.n866 25.6005
R1673 pfet_01v8_lvt_W90p63_L0p74_m1__nf1_gboth_sdfull_pc/B.n869 pfet_01v8_lvt_W90p63_L0p74_m1__nf1_gboth_sdfull_pc/B.n868 25.6005
R1674 pfet_01v8_lvt_W90p63_L0p74_m1__nf1_gboth_sdfull_pc/B.n872 pfet_01v8_lvt_W90p63_L0p74_m1__nf1_gboth_sdfull_pc/B.n869 25.6005
R1675 pfet_01v8_lvt_W90p63_L0p74_m1__nf1_gboth_sdfull_pc/B.n873 pfet_01v8_lvt_W90p63_L0p74_m1__nf1_gboth_sdfull_pc/B.n872 25.6005
R1676 pfet_01v8_lvt_W90p63_L0p74_m1__nf1_gboth_sdfull_pc/B.n876 pfet_01v8_lvt_W90p63_L0p74_m1__nf1_gboth_sdfull_pc/B.n873 25.6005
R1677 pfet_01v8_lvt_W90p63_L0p74_m1__nf1_gboth_sdfull_pc/B.n877 pfet_01v8_lvt_W90p63_L0p74_m1__nf1_gboth_sdfull_pc/B.n876 25.6005
R1678 pfet_01v8_lvt_W90p63_L0p74_m1__nf1_gboth_sdfull_pc/B.n880 pfet_01v8_lvt_W90p63_L0p74_m1__nf1_gboth_sdfull_pc/B.n877 25.6005
R1679 pfet_01v8_lvt_W90p63_L0p74_m1__nf1_gboth_sdfull_pc/B.n881 pfet_01v8_lvt_W90p63_L0p74_m1__nf1_gboth_sdfull_pc/B.n880 25.6005
R1680 pfet_01v8_lvt_W90p63_L0p74_m1__nf1_gboth_sdfull_pc/B.n884 pfet_01v8_lvt_W90p63_L0p74_m1__nf1_gboth_sdfull_pc/B.n881 25.6005
R1681 pfet_01v8_lvt_W90p63_L0p74_m1__nf1_gboth_sdfull_pc/B.n885 pfet_01v8_lvt_W90p63_L0p74_m1__nf1_gboth_sdfull_pc/B.n884 25.6005
R1682 pfet_01v8_lvt_W90p63_L0p74_m1__nf1_gboth_sdfull_pc/B.n888 pfet_01v8_lvt_W90p63_L0p74_m1__nf1_gboth_sdfull_pc/B.n885 25.6005
R1683 pfet_01v8_lvt_W90p63_L0p74_m1__nf1_gboth_sdfull_pc/B.n890 pfet_01v8_lvt_W90p63_L0p74_m1__nf1_gboth_sdfull_pc/B.n888 25.6005
R1684 pfet_01v8_lvt_W90p63_L0p74_m1__nf1_gboth_sdfull_pc/B.n891 pfet_01v8_lvt_W90p63_L0p74_m1__nf1_gboth_sdfull_pc/B.n890 25.6005
R1685 pfet_01v8_lvt_W90p63_L0p74_m1__nf1_gboth_sdfull_pc/B.n893 pfet_01v8_lvt_W90p63_L0p74_m1__nf1_gboth_sdfull_pc/B.n891 25.6005
R1686 pfet_01v8_lvt_W90p63_L0p74_m1__nf1_gboth_sdfull_pc/B.n894 pfet_01v8_lvt_W90p63_L0p74_m1__nf1_gboth_sdfull_pc/B.n893 25.6005
R1687 pfet_01v8_lvt_W90p63_L0p74_m1__nf1_gboth_sdfull_pc/B.n897 pfet_01v8_lvt_W90p63_L0p74_m1__nf1_gboth_sdfull_pc/B.n894 25.6005
R1688 pfet_01v8_lvt_W90p63_L0p74_m1__nf1_gboth_sdfull_pc/B.n899 pfet_01v8_lvt_W90p63_L0p74_m1__nf1_gboth_sdfull_pc/B.n897 25.6005
R1689 pfet_01v8_lvt_W90p63_L0p74_m1__nf1_gboth_sdfull_pc/B.n900 pfet_01v8_lvt_W90p63_L0p74_m1__nf1_gboth_sdfull_pc/B.n899 25.6005
R1690 pfet_01v8_lvt_W90p63_L0p74_m1__nf1_gboth_sdfull_pc/B.n902 pfet_01v8_lvt_W90p63_L0p74_m1__nf1_gboth_sdfull_pc/B.n900 25.6005
R1691 pfet_01v8_lvt_W90p63_L0p74_m1__nf1_gboth_sdfull_pc/B.n904 pfet_01v8_lvt_W90p63_L0p74_m1__nf1_gboth_sdfull_pc/B.n902 25.6005
R1692 pfet_01v8_lvt_W90p63_L0p74_m1__nf1_gboth_sdfull_pc/B.n905 pfet_01v8_lvt_W90p63_L0p74_m1__nf1_gboth_sdfull_pc/B.n904 25.6005
R1693 pfet_01v8_lvt_W90p63_L0p74_m1__nf1_gboth_sdfull_pc/B.n907 pfet_01v8_lvt_W90p63_L0p74_m1__nf1_gboth_sdfull_pc/B.n905 25.6005
R1694 pfet_01v8_lvt_W90p63_L0p74_m1__nf1_gboth_sdfull_pc/B.n908 pfet_01v8_lvt_W90p63_L0p74_m1__nf1_gboth_sdfull_pc/B.n907 25.6005
R1695 pfet_01v8_lvt_W90p63_L0p74_m1__nf1_gboth_sdfull_pc/B.n911 pfet_01v8_lvt_W90p63_L0p74_m1__nf1_gboth_sdfull_pc/B.n908 25.6005
R1696 pfet_01v8_lvt_W90p63_L0p74_m1__nf1_gboth_sdfull_pc/B.n913 pfet_01v8_lvt_W90p63_L0p74_m1__nf1_gboth_sdfull_pc/B.n911 25.6005
R1697 pfet_01v8_lvt_W90p63_L0p74_m1__nf1_gboth_sdfull_pc/B.n914 pfet_01v8_lvt_W90p63_L0p74_m1__nf1_gboth_sdfull_pc/B.n913 25.6005
R1698 pfet_01v8_lvt_W90p63_L0p74_m1__nf1_gboth_sdfull_pc/B.n916 pfet_01v8_lvt_W90p63_L0p74_m1__nf1_gboth_sdfull_pc/B.n914 25.6005
R1699 pfet_01v8_lvt_W90p63_L0p74_m1__nf1_gboth_sdfull_pc/B.n918 pfet_01v8_lvt_W90p63_L0p74_m1__nf1_gboth_sdfull_pc/B.n916 25.6005
R1700 pfet_01v8_lvt_W90p63_L0p74_m1__nf1_gboth_sdfull_pc/B.n919 pfet_01v8_lvt_W90p63_L0p74_m1__nf1_gboth_sdfull_pc/B.n918 25.6005
R1701 pfet_01v8_lvt_W90p63_L0p74_m1__nf1_gboth_sdfull_pc/B.n921 pfet_01v8_lvt_W90p63_L0p74_m1__nf1_gboth_sdfull_pc/B.n919 25.6005
R1702 pfet_01v8_lvt_W90p63_L0p74_m1__nf1_gboth_sdfull_pc/B.n923 pfet_01v8_lvt_W90p63_L0p74_m1__nf1_gboth_sdfull_pc/B.n921 25.6005
R1703 pfet_01v8_lvt_W90p63_L0p74_m1__nf1_gboth_sdfull_pc/B.n924 pfet_01v8_lvt_W90p63_L0p74_m1__nf1_gboth_sdfull_pc/B.n923 25.6005
R1704 pfet_01v8_lvt_W90p63_L0p74_m1__nf1_gboth_sdfull_pc/B.n926 pfet_01v8_lvt_W90p63_L0p74_m1__nf1_gboth_sdfull_pc/B.n924 25.6005
R1705 pfet_01v8_lvt_W90p63_L0p74_m1__nf1_gboth_sdfull_pc/B.n928 pfet_01v8_lvt_W90p63_L0p74_m1__nf1_gboth_sdfull_pc/B.n926 25.6005
R1706 pfet_01v8_lvt_W90p63_L0p74_m1__nf1_gboth_sdfull_pc/B.n929 pfet_01v8_lvt_W90p63_L0p74_m1__nf1_gboth_sdfull_pc/B.n928 25.6005
R1707 pfet_01v8_lvt_W90p63_L0p74_m1__nf1_gboth_sdfull_pc/B.n931 pfet_01v8_lvt_W90p63_L0p74_m1__nf1_gboth_sdfull_pc/B.n929 25.6005
R1708 pfet_01v8_lvt_W90p63_L0p74_m1__nf1_gboth_sdfull_pc/B.n932 pfet_01v8_lvt_W90p63_L0p74_m1__nf1_gboth_sdfull_pc/B.n931 25.6005
R1709 pfet_01v8_lvt_W90p63_L0p74_m1__nf1_gboth_sdfull_pc/B.n935 pfet_01v8_lvt_W90p63_L0p74_m1__nf1_gboth_sdfull_pc/B.n932 25.6005
R1710 pfet_01v8_lvt_W90p63_L0p74_m1__nf1_gboth_sdfull_pc/B.n937 pfet_01v8_lvt_W90p63_L0p74_m1__nf1_gboth_sdfull_pc/B.n935 25.6005
R1711 pfet_01v8_lvt_W90p63_L0p74_m1__nf1_gboth_sdfull_pc/B.n938 pfet_01v8_lvt_W90p63_L0p74_m1__nf1_gboth_sdfull_pc/B.n937 25.6005
R1712 pfet_01v8_lvt_W90p63_L0p74_m1__nf1_gboth_sdfull_pc/B.n940 pfet_01v8_lvt_W90p63_L0p74_m1__nf1_gboth_sdfull_pc/B.n938 25.6005
R1713 pfet_01v8_lvt_W90p63_L0p74_m1__nf1_gboth_sdfull_pc/B.n941 pfet_01v8_lvt_W90p63_L0p74_m1__nf1_gboth_sdfull_pc/B.n940 25.6005
R1714 pfet_01v8_lvt_W90p63_L0p74_m1__nf1_gboth_sdfull_pc/B.n944 pfet_01v8_lvt_W90p63_L0p74_m1__nf1_gboth_sdfull_pc/B.n941 25.6005
R1715 pfet_01v8_lvt_W90p63_L0p74_m1__nf1_gboth_sdfull_pc/B.n946 pfet_01v8_lvt_W90p63_L0p74_m1__nf1_gboth_sdfull_pc/B.n944 25.6005
R1716 pfet_01v8_lvt_W90p63_L0p74_m1__nf1_gboth_sdfull_pc/B.n947 pfet_01v8_lvt_W90p63_L0p74_m1__nf1_gboth_sdfull_pc/B.n946 25.6005
R1717 pfet_01v8_lvt_W90p63_L0p74_m1__nf1_gboth_sdfull_pc/B.n949 pfet_01v8_lvt_W90p63_L0p74_m1__nf1_gboth_sdfull_pc/B.n947 25.6005
R1718 pfet_01v8_lvt_W90p63_L0p74_m1__nf1_gboth_sdfull_pc/B.n951 pfet_01v8_lvt_W90p63_L0p74_m1__nf1_gboth_sdfull_pc/B.n949 25.6005
R1719 pfet_01v8_lvt_W90p63_L0p74_m1__nf1_gboth_sdfull_pc/B.n952 pfet_01v8_lvt_W90p63_L0p74_m1__nf1_gboth_sdfull_pc/B.n951 25.6005
R1720 pfet_01v8_lvt_W90p63_L0p74_m1__nf1_gboth_sdfull_pc/B.n954 pfet_01v8_lvt_W90p63_L0p74_m1__nf1_gboth_sdfull_pc/B.n952 25.6005
R1721 pfet_01v8_lvt_W90p63_L0p74_m1__nf1_gboth_sdfull_pc/B.n955 pfet_01v8_lvt_W90p63_L0p74_m1__nf1_gboth_sdfull_pc/B.n954 25.6005
R1722 pfet_01v8_lvt_W90p63_L0p74_m1__nf1_gboth_sdfull_pc/B.n958 pfet_01v8_lvt_W90p63_L0p74_m1__nf1_gboth_sdfull_pc/B.n955 25.6005
R1723 pfet_01v8_lvt_W90p63_L0p74_m1__nf1_gboth_sdfull_pc/B.n960 pfet_01v8_lvt_W90p63_L0p74_m1__nf1_gboth_sdfull_pc/B.n958 25.6005
R1724 pfet_01v8_lvt_W90p63_L0p74_m1__nf1_gboth_sdfull_pc/B.n961 pfet_01v8_lvt_W90p63_L0p74_m1__nf1_gboth_sdfull_pc/B.n960 25.6005
R1725 pfet_01v8_lvt_W90p63_L0p74_m1__nf1_gboth_sdfull_pc/B.n963 pfet_01v8_lvt_W90p63_L0p74_m1__nf1_gboth_sdfull_pc/B.n961 25.6005
R1726 pfet_01v8_lvt_W90p63_L0p74_m1__nf1_gboth_sdfull_pc/B.n964 pfet_01v8_lvt_W90p63_L0p74_m1__nf1_gboth_sdfull_pc/B.n963 25.6005
R1727 pfet_01v8_lvt_W90p63_L0p74_m1__nf1_gboth_sdfull_pc/B.n967 pfet_01v8_lvt_W90p63_L0p74_m1__nf1_gboth_sdfull_pc/B.n964 25.6005
R1728 pfet_01v8_lvt_W90p63_L0p74_m1__nf1_gboth_sdfull_pc/B.n968 pfet_01v8_lvt_W90p63_L0p74_m1__nf1_gboth_sdfull_pc/B.n967 25.6005
R1729 pfet_01v8_lvt_W90p63_L0p74_m1__nf1_gboth_sdfull_pc/B.n971 pfet_01v8_lvt_W90p63_L0p74_m1__nf1_gboth_sdfull_pc/B.n968 25.6005
R1730 pfet_01v8_lvt_W90p63_L0p74_m1__nf1_gboth_sdfull_pc/B.n972 pfet_01v8_lvt_W90p63_L0p74_m1__nf1_gboth_sdfull_pc/B.n971 25.6005
R1731 pfet_01v8_lvt_W90p63_L0p74_m1__nf1_gboth_sdfull_pc/B.n975 pfet_01v8_lvt_W90p63_L0p74_m1__nf1_gboth_sdfull_pc/B.n972 25.6005
R1732 pfet_01v8_lvt_W90p63_L0p74_m1__nf1_gboth_sdfull_pc/B.n976 pfet_01v8_lvt_W90p63_L0p74_m1__nf1_gboth_sdfull_pc/B.n975 25.6005
R1733 pfet_01v8_lvt_W90p63_L0p74_m1__nf1_gboth_sdfull_pc/B.n979 pfet_01v8_lvt_W90p63_L0p74_m1__nf1_gboth_sdfull_pc/B.n976 25.6005
R1734 pfet_01v8_lvt_W90p63_L0p74_m1__nf1_gboth_sdfull_pc/B.n980 pfet_01v8_lvt_W90p63_L0p74_m1__nf1_gboth_sdfull_pc/B.n979 25.6005
R1735 pfet_01v8_lvt_W90p63_L0p74_m1__nf1_gboth_sdfull_pc/B.n983 pfet_01v8_lvt_W90p63_L0p74_m1__nf1_gboth_sdfull_pc/B.n980 25.6005
R1736 pfet_01v8_lvt_W90p63_L0p74_m1__nf1_gboth_sdfull_pc/B.n984 pfet_01v8_lvt_W90p63_L0p74_m1__nf1_gboth_sdfull_pc/B.n983 25.6005
R1737 pfet_01v8_lvt_W90p63_L0p74_m1__nf1_gboth_sdfull_pc/B.n987 pfet_01v8_lvt_W90p63_L0p74_m1__nf1_gboth_sdfull_pc/B.n984 25.6005
R1738 pfet_01v8_lvt_W90p63_L0p74_m1__nf1_gboth_sdfull_pc/B.n988 pfet_01v8_lvt_W90p63_L0p74_m1__nf1_gboth_sdfull_pc/B.n987 25.6005
R1739 pfet_01v8_lvt_W90p63_L0p74_m1__nf1_gboth_sdfull_pc/B.n991 pfet_01v8_lvt_W90p63_L0p74_m1__nf1_gboth_sdfull_pc/B.n988 25.6005
R1740 pfet_01v8_lvt_W90p63_L0p74_m1__nf1_gboth_sdfull_pc/B.n992 pfet_01v8_lvt_W90p63_L0p74_m1__nf1_gboth_sdfull_pc/B.n991 25.6005
R1741 pfet_01v8_lvt_W90p63_L0p74_m1__nf1_gboth_sdfull_pc/B.n995 pfet_01v8_lvt_W90p63_L0p74_m1__nf1_gboth_sdfull_pc/B.n992 25.6005
R1742 pfet_01v8_lvt_W90p63_L0p74_m1__nf1_gboth_sdfull_pc/B.n997 pfet_01v8_lvt_W90p63_L0p74_m1__nf1_gboth_sdfull_pc/B.n995 25.6005
R1743 pfet_01v8_lvt_W90p63_L0p74_m1__nf1_gboth_sdfull_pc/B.n998 pfet_01v8_lvt_W90p63_L0p74_m1__nf1_gboth_sdfull_pc/B.n997 25.6005
R1744 pfet_01v8_lvt_W90p63_L0p74_m1__nf1_gboth_sdfull_pc/B.n1000 pfet_01v8_lvt_W90p63_L0p74_m1__nf1_gboth_sdfull_pc/B.n998 25.6005
R1745 pfet_01v8_lvt_W90p63_L0p74_m1__nf1_gboth_sdfull_pc/B.n1002 pfet_01v8_lvt_W90p63_L0p74_m1__nf1_gboth_sdfull_pc/B.n1000 25.6005
R1746 pfet_01v8_lvt_W90p63_L0p74_m1__nf1_gboth_sdfull_pc/B.n1003 pfet_01v8_lvt_W90p63_L0p74_m1__nf1_gboth_sdfull_pc/B.n1002 25.6005
R1747 pfet_01v8_lvt_W90p63_L0p74_m1__nf1_gboth_sdfull_pc/B.n1005 pfet_01v8_lvt_W90p63_L0p74_m1__nf1_gboth_sdfull_pc/B.n1003 25.6005
R1748 pfet_01v8_lvt_W90p63_L0p74_m1__nf1_gboth_sdfull_pc/B.n1007 pfet_01v8_lvt_W90p63_L0p74_m1__nf1_gboth_sdfull_pc/B.n1005 25.6005
R1749 pfet_01v8_lvt_W90p63_L0p74_m1__nf1_gboth_sdfull_pc/B.n1008 pfet_01v8_lvt_W90p63_L0p74_m1__nf1_gboth_sdfull_pc/B.n1007 25.6005
R1750 pfet_01v8_lvt_W90p63_L0p74_m1__nf1_gboth_sdfull_pc/B.n1010 pfet_01v8_lvt_W90p63_L0p74_m1__nf1_gboth_sdfull_pc/B.n1008 25.6005
R1751 pfet_01v8_lvt_W90p63_L0p74_m1__nf1_gboth_sdfull_pc/B.n1012 pfet_01v8_lvt_W90p63_L0p74_m1__nf1_gboth_sdfull_pc/B.n1010 25.6005
R1752 pfet_01v8_lvt_W90p63_L0p74_m1__nf1_gboth_sdfull_pc/B.n1013 pfet_01v8_lvt_W90p63_L0p74_m1__nf1_gboth_sdfull_pc/B.n1012 25.6005
R1753 pfet_01v8_lvt_W90p63_L0p74_m1__nf1_gboth_sdfull_pc/B.n1015 pfet_01v8_lvt_W90p63_L0p74_m1__nf1_gboth_sdfull_pc/B.n1013 25.6005
R1754 pfet_01v8_lvt_W90p63_L0p74_m1__nf1_gboth_sdfull_pc/B.n1017 pfet_01v8_lvt_W90p63_L0p74_m1__nf1_gboth_sdfull_pc/B.n1015 25.6005
R1755 pfet_01v8_lvt_W90p63_L0p74_m1__nf1_gboth_sdfull_pc/B.n1018 pfet_01v8_lvt_W90p63_L0p74_m1__nf1_gboth_sdfull_pc/B.n1017 25.6005
R1756 pfet_01v8_lvt_W90p63_L0p74_m1__nf1_gboth_sdfull_pc/B.n1020 pfet_01v8_lvt_W90p63_L0p74_m1__nf1_gboth_sdfull_pc/B.n1018 25.6005
R1757 pfet_01v8_lvt_W90p63_L0p74_m1__nf1_gboth_sdfull_pc/B.n1021 pfet_01v8_lvt_W90p63_L0p74_m1__nf1_gboth_sdfull_pc/B.n1020 25.6005
R1758 pfet_01v8_lvt_W90p63_L0p74_m1__nf1_gboth_sdfull_pc/B.n1024 pfet_01v8_lvt_W90p63_L0p74_m1__nf1_gboth_sdfull_pc/B.n1021 25.6005
R1759 pfet_01v8_lvt_W90p63_L0p74_m1__nf1_gboth_sdfull_pc/B.n1025 pfet_01v8_lvt_W90p63_L0p74_m1__nf1_gboth_sdfull_pc/B.n1024 25.6005
R1760 pfet_01v8_lvt_W90p63_L0p74_m1__nf1_gboth_sdfull_pc/B.n1028 pfet_01v8_lvt_W90p63_L0p74_m1__nf1_gboth_sdfull_pc/B.n1025 25.6005
R1761 pfet_01v8_lvt_W90p63_L0p74_m1__nf1_gboth_sdfull_pc/B.n1029 pfet_01v8_lvt_W90p63_L0p74_m1__nf1_gboth_sdfull_pc/B.n1028 25.6005
R1762 pfet_01v8_lvt_W90p63_L0p74_m1__nf1_gboth_sdfull_pc/B.n1032 pfet_01v8_lvt_W90p63_L0p74_m1__nf1_gboth_sdfull_pc/B.n1029 25.6005
R1763 pfet_01v8_lvt_W90p63_L0p74_m1__nf1_gboth_sdfull_pc/B.n1034 pfet_01v8_lvt_W90p63_L0p74_m1__nf1_gboth_sdfull_pc/B.n1032 25.6005
R1764 pfet_01v8_lvt_W90p63_L0p74_m1__nf1_gboth_sdfull_pc/B.n1035 pfet_01v8_lvt_W90p63_L0p74_m1__nf1_gboth_sdfull_pc/B.n1034 25.6005
R1765 pfet_01v8_lvt_W90p63_L0p74_m1__nf1_gboth_sdfull_pc/B.n1037 pfet_01v8_lvt_W90p63_L0p74_m1__nf1_gboth_sdfull_pc/B.n1035 25.6005
R1766 pfet_01v8_lvt_W90p63_L0p74_m1__nf1_gboth_sdfull_pc/B.n1038 pfet_01v8_lvt_W90p63_L0p74_m1__nf1_gboth_sdfull_pc/B.n1037 25.6005
R1767 pfet_01v8_lvt_W90p63_L0p74_m1__nf1_gboth_sdfull_pc/B.n1041 pfet_01v8_lvt_W90p63_L0p74_m1__nf1_gboth_sdfull_pc/B.n1038 25.6005
R1768 pfet_01v8_lvt_W90p63_L0p74_m1__nf1_gboth_sdfull_pc/B.n1042 pfet_01v8_lvt_W90p63_L0p74_m1__nf1_gboth_sdfull_pc/B.n1041 25.6005
R1769 pfet_01v8_lvt_W90p63_L0p74_m1__nf1_gboth_sdfull_pc/B.n1045 pfet_01v8_lvt_W90p63_L0p74_m1__nf1_gboth_sdfull_pc/B.n1042 25.6005
R1770 pfet_01v8_lvt_W90p63_L0p74_m1__nf1_gboth_sdfull_pc/B.n1046 pfet_01v8_lvt_W90p63_L0p74_m1__nf1_gboth_sdfull_pc/B.n1045 25.6005
R1771 pfet_01v8_lvt_W90p63_L0p74_m1__nf1_gboth_sdfull_pc/B.n1049 pfet_01v8_lvt_W90p63_L0p74_m1__nf1_gboth_sdfull_pc/B.n1046 25.6005
R1772 pfet_01v8_lvt_W90p63_L0p74_m1__nf1_gboth_sdfull_pc/B.n1050 pfet_01v8_lvt_W90p63_L0p74_m1__nf1_gboth_sdfull_pc/B.n1049 25.6005
R1773 pfet_01v8_lvt_W90p63_L0p74_m1__nf1_gboth_sdfull_pc/B.n1053 pfet_01v8_lvt_W90p63_L0p74_m1__nf1_gboth_sdfull_pc/B.n1050 25.6005
R1774 pfet_01v8_lvt_W90p63_L0p74_m1__nf1_gboth_sdfull_pc/B.n1054 pfet_01v8_lvt_W90p63_L0p74_m1__nf1_gboth_sdfull_pc/B.n1053 25.6005
R1775 pfet_01v8_lvt_W90p63_L0p74_m1__nf1_gboth_sdfull_pc/B.n1057 pfet_01v8_lvt_W90p63_L0p74_m1__nf1_gboth_sdfull_pc/B.n1054 25.6005
R1776 pfet_01v8_lvt_W90p63_L0p74_m1__nf1_gboth_sdfull_pc/B.n1059 pfet_01v8_lvt_W90p63_L0p74_m1__nf1_gboth_sdfull_pc/B.n1057 25.6005
R1777 pfet_01v8_lvt_W90p63_L0p74_m1__nf1_gboth_sdfull_pc/B.n1060 pfet_01v8_lvt_W90p63_L0p74_m1__nf1_gboth_sdfull_pc/B.n1059 25.6005
R1778 pfet_01v8_lvt_W90p63_L0p74_m1__nf1_gboth_sdfull_pc/B.n1062 pfet_01v8_lvt_W90p63_L0p74_m1__nf1_gboth_sdfull_pc/B.n1060 25.6005
R1779 pfet_01v8_lvt_W90p63_L0p74_m1__nf1_gboth_sdfull_pc/B.n1063 pfet_01v8_lvt_W90p63_L0p74_m1__nf1_gboth_sdfull_pc/B.n1062 25.6005
R1780 pfet_01v8_lvt_W90p63_L0p74_m1__nf1_gboth_sdfull_pc/B.n1066 pfet_01v8_lvt_W90p63_L0p74_m1__nf1_gboth_sdfull_pc/B.n1063 25.6005
R1781 pfet_01v8_lvt_W90p63_L0p74_m1__nf1_gboth_sdfull_pc/B.n1067 pfet_01v8_lvt_W90p63_L0p74_m1__nf1_gboth_sdfull_pc/B.n1066 25.6005
R1782 pfet_01v8_lvt_W90p63_L0p74_m1__nf1_gboth_sdfull_pc/B.n1070 pfet_01v8_lvt_W90p63_L0p74_m1__nf1_gboth_sdfull_pc/B.n1067 25.6005
R1783 pfet_01v8_lvt_W90p63_L0p74_m1__nf1_gboth_sdfull_pc/B.n1071 pfet_01v8_lvt_W90p63_L0p74_m1__nf1_gboth_sdfull_pc/B.n1070 25.6005
R1784 pfet_01v8_lvt_W90p63_L0p74_m1__nf1_gboth_sdfull_pc/B.n1074 pfet_01v8_lvt_W90p63_L0p74_m1__nf1_gboth_sdfull_pc/B.n1071 25.6005
R1785 pfet_01v8_lvt_W90p63_L0p74_m1__nf1_gboth_sdfull_pc/B.n1076 pfet_01v8_lvt_W90p63_L0p74_m1__nf1_gboth_sdfull_pc/B.n1074 25.6005
R1786 pfet_01v8_lvt_W90p63_L0p74_m1__nf1_gboth_sdfull_pc/B.n1077 pfet_01v8_lvt_W90p63_L0p74_m1__nf1_gboth_sdfull_pc/B.n1076 25.6005
R1787 pfet_01v8_lvt_W90p63_L0p74_m1__nf1_gboth_sdfull_pc/B.n1079 pfet_01v8_lvt_W90p63_L0p74_m1__nf1_gboth_sdfull_pc/B.n1077 25.6005
R1788 pfet_01v8_lvt_W90p63_L0p74_m1__nf1_gboth_sdfull_pc/B.n1081 pfet_01v8_lvt_W90p63_L0p74_m1__nf1_gboth_sdfull_pc/B.n1079 25.6005
R1789 pfet_01v8_lvt_W90p63_L0p74_m1__nf1_gboth_sdfull_pc/B.n1082 pfet_01v8_lvt_W90p63_L0p74_m1__nf1_gboth_sdfull_pc/B.n1081 25.6005
R1790 pfet_01v8_lvt_W90p63_L0p74_m1__nf1_gboth_sdfull_pc/B.n1084 pfet_01v8_lvt_W90p63_L0p74_m1__nf1_gboth_sdfull_pc/B.n1082 25.6005
R1791 pfet_01v8_lvt_W90p63_L0p74_m1__nf1_gboth_sdfull_pc/B.n1086 pfet_01v8_lvt_W90p63_L0p74_m1__nf1_gboth_sdfull_pc/B.n1084 25.6005
R1792 pfet_01v8_lvt_W90p63_L0p74_m1__nf1_gboth_sdfull_pc/B.n1087 pfet_01v8_lvt_W90p63_L0p74_m1__nf1_gboth_sdfull_pc/B.n1086 25.6005
R1793 pfet_01v8_lvt_W90p63_L0p74_m1__nf1_gboth_sdfull_pc/B.n1089 pfet_01v8_lvt_W90p63_L0p74_m1__nf1_gboth_sdfull_pc/B.n1087 25.6005
R1794 pfet_01v8_lvt_W90p63_L0p74_m1__nf1_gboth_sdfull_pc/B.n1090 pfet_01v8_lvt_W90p63_L0p74_m1__nf1_gboth_sdfull_pc/B.n1089 25.6005
R1795 pfet_01v8_lvt_W90p63_L0p74_m1__nf1_gboth_sdfull_pc/B.n1093 pfet_01v8_lvt_W90p63_L0p74_m1__nf1_gboth_sdfull_pc/B.n1090 25.6005
R1796 pfet_01v8_lvt_W90p63_L0p74_m1__nf1_gboth_sdfull_pc/B.n1095 pfet_01v8_lvt_W90p63_L0p74_m1__nf1_gboth_sdfull_pc/B.n1093 25.6005
R1797 pfet_01v8_lvt_W90p63_L0p74_m1__nf1_gboth_sdfull_pc/B.n1096 pfet_01v8_lvt_W90p63_L0p74_m1__nf1_gboth_sdfull_pc/B.n1095 25.6005
R1798 pfet_01v8_lvt_W90p63_L0p74_m1__nf1_gboth_sdfull_pc/B.n1098 pfet_01v8_lvt_W90p63_L0p74_m1__nf1_gboth_sdfull_pc/B.n1096 25.6005
R1799 pfet_01v8_lvt_W90p63_L0p74_m1__nf1_gboth_sdfull_pc/B.n1099 pfet_01v8_lvt_W90p63_L0p74_m1__nf1_gboth_sdfull_pc/B.n1098 25.6005
R1800 pfet_01v8_lvt_W90p63_L0p74_m1__nf1_gboth_sdfull_pc/B.n1102 pfet_01v8_lvt_W90p63_L0p74_m1__nf1_gboth_sdfull_pc/B.n1099 25.6005
R1801 pfet_01v8_lvt_W90p63_L0p74_m1__nf1_gboth_sdfull_pc/B.n1103 pfet_01v8_lvt_W90p63_L0p74_m1__nf1_gboth_sdfull_pc/B.n1102 25.6005
R1802 pfet_01v8_lvt_W90p63_L0p74_m1__nf1_gboth_sdfull_pc/B.n1106 pfet_01v8_lvt_W90p63_L0p74_m1__nf1_gboth_sdfull_pc/B.n1103 25.6005
R1803 pfet_01v8_lvt_W90p63_L0p74_m1__nf1_gboth_sdfull_pc/B.n1108 pfet_01v8_lvt_W90p63_L0p74_m1__nf1_gboth_sdfull_pc/B.n1106 25.6005
R1804 pfet_01v8_lvt_W90p63_L0p74_m1__nf1_gboth_sdfull_pc/B.n1109 pfet_01v8_lvt_W90p63_L0p74_m1__nf1_gboth_sdfull_pc/B.n1108 25.6005
R1805 pfet_01v8_lvt_W90p63_L0p74_m1__nf1_gboth_sdfull_pc/B.n1111 pfet_01v8_lvt_W90p63_L0p74_m1__nf1_gboth_sdfull_pc/B.n1109 25.6005
R1806 pfet_01v8_lvt_W90p63_L0p74_m1__nf1_gboth_sdfull_pc/B.n1112 pfet_01v8_lvt_W90p63_L0p74_m1__nf1_gboth_sdfull_pc/B.n1111 25.6005
R1807 pfet_01v8_lvt_W90p63_L0p74_m1__nf1_gboth_sdfull_pc/B.n1115 pfet_01v8_lvt_W90p63_L0p74_m1__nf1_gboth_sdfull_pc/B.n1112 25.6005
R1808 pfet_01v8_lvt_W90p63_L0p74_m1__nf1_gboth_sdfull_pc/B.n1116 pfet_01v8_lvt_W90p63_L0p74_m1__nf1_gboth_sdfull_pc/B.n1115 25.6005
R1809 pfet_01v8_lvt_W90p63_L0p74_m1__nf1_gboth_sdfull_pc/B.n1119 pfet_01v8_lvt_W90p63_L0p74_m1__nf1_gboth_sdfull_pc/B.n1116 25.6005
R1810 pfet_01v8_lvt_W90p63_L0p74_m1__nf1_gboth_sdfull_pc/B.n1121 pfet_01v8_lvt_W90p63_L0p74_m1__nf1_gboth_sdfull_pc/B.n1119 25.6005
R1811 pfet_01v8_lvt_W90p63_L0p74_m1__nf1_gboth_sdfull_pc/B.n1122 pfet_01v8_lvt_W90p63_L0p74_m1__nf1_gboth_sdfull_pc/B.n1121 25.6005
R1812 pfet_01v8_lvt_W90p63_L0p74_m1__nf1_gboth_sdfull_pc/B.n1124 pfet_01v8_lvt_W90p63_L0p74_m1__nf1_gboth_sdfull_pc/B.n1122 25.6005
R1813 pfet_01v8_lvt_W90p63_L0p74_m1__nf1_gboth_sdfull_pc/B.n1125 pfet_01v8_lvt_W90p63_L0p74_m1__nf1_gboth_sdfull_pc/B.n1124 25.6005
R1814 pfet_01v8_lvt_W90p63_L0p74_m1__nf1_gboth_sdfull_pc/B.n1128 pfet_01v8_lvt_W90p63_L0p74_m1__nf1_gboth_sdfull_pc/B.n1125 25.6005
R1815 pfet_01v8_lvt_W90p63_L0p74_m1__nf1_gboth_sdfull_pc/B.n1129 pfet_01v8_lvt_W90p63_L0p74_m1__nf1_gboth_sdfull_pc/B.n1128 25.6005
R1816 pfet_01v8_lvt_W90p63_L0p74_m1__nf1_gboth_sdfull_pc/B.n1132 pfet_01v8_lvt_W90p63_L0p74_m1__nf1_gboth_sdfull_pc/B.n1129 25.6005
R1817 pfet_01v8_lvt_W90p63_L0p74_m1__nf1_gboth_sdfull_pc/B.n1134 pfet_01v8_lvt_W90p63_L0p74_m1__nf1_gboth_sdfull_pc/B.n1132 25.6005
R1818 pfet_01v8_lvt_W90p63_L0p74_m1__nf1_gboth_sdfull_pc/B.n1135 pfet_01v8_lvt_W90p63_L0p74_m1__nf1_gboth_sdfull_pc/B.n1134 25.6005
R1819 pfet_01v8_lvt_W90p63_L0p74_m1__nf1_gboth_sdfull_pc/B.n1137 pfet_01v8_lvt_W90p63_L0p74_m1__nf1_gboth_sdfull_pc/B.n1135 25.6005
R1820 pfet_01v8_lvt_W90p63_L0p74_m1__nf1_gboth_sdfull_pc/B.n1139 pfet_01v8_lvt_W90p63_L0p74_m1__nf1_gboth_sdfull_pc/B.n1137 25.6005
R1821 pfet_01v8_lvt_W90p63_L0p74_m1__nf1_gboth_sdfull_pc/B.n1140 pfet_01v8_lvt_W90p63_L0p74_m1__nf1_gboth_sdfull_pc/B.n1139 25.6005
R1822 pfet_01v8_lvt_W90p63_L0p74_m1__nf1_gboth_sdfull_pc/B.n1142 pfet_01v8_lvt_W90p63_L0p74_m1__nf1_gboth_sdfull_pc/B.n1140 25.6005
R1823 pfet_01v8_lvt_W90p63_L0p74_m1__nf1_gboth_sdfull_pc/B.n1143 pfet_01v8_lvt_W90p63_L0p74_m1__nf1_gboth_sdfull_pc/B.n1142 25.6005
R1824 pfet_01v8_lvt_W90p63_L0p74_m1__nf1_gboth_sdfull_pc/B.n1146 pfet_01v8_lvt_W90p63_L0p74_m1__nf1_gboth_sdfull_pc/B.n1143 25.6005
R1825 pfet_01v8_lvt_W90p63_L0p74_m1__nf1_gboth_sdfull_pc/B.n1147 pfet_01v8_lvt_W90p63_L0p74_m1__nf1_gboth_sdfull_pc/B.n1146 25.6005
R1826 pfet_01v8_lvt_W90p63_L0p74_m1__nf1_gboth_sdfull_pc/B.n1150 pfet_01v8_lvt_W90p63_L0p74_m1__nf1_gboth_sdfull_pc/B.n1147 25.6005
R1827 pfet_01v8_lvt_W90p63_L0p74_m1__nf1_gboth_sdfull_pc/B.n1151 pfet_01v8_lvt_W90p63_L0p74_m1__nf1_gboth_sdfull_pc/B.n1150 25.6005
R1828 pfet_01v8_lvt_W90p63_L0p74_m1__nf1_gboth_sdfull_pc/B.n1154 pfet_01v8_lvt_W90p63_L0p74_m1__nf1_gboth_sdfull_pc/B.n1151 25.6005
R1829 pfet_01v8_lvt_W90p63_L0p74_m1__nf1_gboth_sdfull_pc/B.n1156 pfet_01v8_lvt_W90p63_L0p74_m1__nf1_gboth_sdfull_pc/B.n1154 25.6005
R1830 pfet_01v8_lvt_W90p63_L0p74_m1__nf1_gboth_sdfull_pc/B.n1157 pfet_01v8_lvt_W90p63_L0p74_m1__nf1_gboth_sdfull_pc/B.n1156 25.6005
R1831 pfet_01v8_lvt_W90p63_L0p74_m1__nf1_gboth_sdfull_pc/B.n1159 pfet_01v8_lvt_W90p63_L0p74_m1__nf1_gboth_sdfull_pc/B.n1157 25.6005
R1832 pfet_01v8_lvt_W90p63_L0p74_m1__nf1_gboth_sdfull_pc/B.n1160 pfet_01v8_lvt_W90p63_L0p74_m1__nf1_gboth_sdfull_pc/B.n1159 25.6005
R1833 pfet_01v8_lvt_W90p63_L0p74_m1__nf1_gboth_sdfull_pc/B.n1163 pfet_01v8_lvt_W90p63_L0p74_m1__nf1_gboth_sdfull_pc/B.n1160 25.6005
R1834 pfet_01v8_lvt_W90p63_L0p74_m1__nf1_gboth_sdfull_pc/B.n1164 pfet_01v8_lvt_W90p63_L0p74_m1__nf1_gboth_sdfull_pc/B.n1163 25.6005
R1835 pfet_01v8_lvt_W90p63_L0p74_m1__nf1_gboth_sdfull_pc/B.n1167 pfet_01v8_lvt_W90p63_L0p74_m1__nf1_gboth_sdfull_pc/B.n1164 25.6005
R1836 pfet_01v8_lvt_W90p63_L0p74_m1__nf1_gboth_sdfull_pc/B.n1168 pfet_01v8_lvt_W90p63_L0p74_m1__nf1_gboth_sdfull_pc/B.n1167 25.6005
R1837 pfet_01v8_lvt_W90p63_L0p74_m1__nf1_gboth_sdfull_pc/B.n1171 pfet_01v8_lvt_W90p63_L0p74_m1__nf1_gboth_sdfull_pc/B.n1168 25.6005
R1838 pfet_01v8_lvt_W90p63_L0p74_m1__nf1_gboth_sdfull_pc/B.n1172 pfet_01v8_lvt_W90p63_L0p74_m1__nf1_gboth_sdfull_pc/B.n1171 25.6005
R1839 pfet_01v8_lvt_W90p63_L0p74_m1__nf1_gboth_sdfull_pc/B.n1175 pfet_01v8_lvt_W90p63_L0p74_m1__nf1_gboth_sdfull_pc/B.n1172 25.6005
R1840 pfet_01v8_lvt_W90p63_L0p74_m1__nf1_gboth_sdfull_pc/B.n1177 pfet_01v8_lvt_W90p63_L0p74_m1__nf1_gboth_sdfull_pc/B.n1175 25.6005
R1841 pfet_01v8_lvt_W90p63_L0p74_m1__nf1_gboth_sdfull_pc/B.n1178 pfet_01v8_lvt_W90p63_L0p74_m1__nf1_gboth_sdfull_pc/B.n1177 25.6005
R1842 pfet_01v8_lvt_W90p63_L0p74_m1__nf1_gboth_sdfull_pc/B.n1180 pfet_01v8_lvt_W90p63_L0p74_m1__nf1_gboth_sdfull_pc/B.n1178 25.6005
R1843 pfet_01v8_lvt_W90p63_L0p74_m1__nf1_gboth_sdfull_pc/B.n1181 pfet_01v8_lvt_W90p63_L0p74_m1__nf1_gboth_sdfull_pc/B.n1180 25.6005
R1844 pfet_01v8_lvt_W90p63_L0p74_m1__nf1_gboth_sdfull_pc/B.n1184 pfet_01v8_lvt_W90p63_L0p74_m1__nf1_gboth_sdfull_pc/B.n1181 25.6005
R1845 pfet_01v8_lvt_W90p63_L0p74_m1__nf1_gboth_sdfull_pc/B.n1185 pfet_01v8_lvt_W90p63_L0p74_m1__nf1_gboth_sdfull_pc/B.n1184 25.6005
R1846 pfet_01v8_lvt_W90p63_L0p74_m1__nf1_gboth_sdfull_pc/B.n1188 pfet_01v8_lvt_W90p63_L0p74_m1__nf1_gboth_sdfull_pc/B.n1185 25.6005
R1847 pfet_01v8_lvt_W90p63_L0p74_m1__nf1_gboth_sdfull_pc/B.n1189 pfet_01v8_lvt_W90p63_L0p74_m1__nf1_gboth_sdfull_pc/B.n1188 25.6005
R1848 pfet_01v8_lvt_W90p63_L0p74_m1__nf1_gboth_sdfull_pc/B.n1192 pfet_01v8_lvt_W90p63_L0p74_m1__nf1_gboth_sdfull_pc/B.n1189 25.6005
R1849 pfet_01v8_lvt_W90p63_L0p74_m1__nf1_gboth_sdfull_pc/B.n1193 pfet_01v8_lvt_W90p63_L0p74_m1__nf1_gboth_sdfull_pc/B.n1192 25.6005
R1850 pfet_01v8_lvt_W90p63_L0p74_m1__nf1_gboth_sdfull_pc/B.n1196 pfet_01v8_lvt_W90p63_L0p74_m1__nf1_gboth_sdfull_pc/B.n1193 25.6005
R1851 pfet_01v8_lvt_W90p63_L0p74_m1__nf1_gboth_sdfull_pc/B.n1197 pfet_01v8_lvt_W90p63_L0p74_m1__nf1_gboth_sdfull_pc/B.n1196 25.6005
R1852 pfet_01v8_lvt_W90p63_L0p74_m1__nf1_gboth_sdfull_pc/B.n1200 pfet_01v8_lvt_W90p63_L0p74_m1__nf1_gboth_sdfull_pc/B.n1197 25.6005
R1853 pfet_01v8_lvt_W90p63_L0p74_m1__nf1_gboth_sdfull_pc/B.n1201 pfet_01v8_lvt_W90p63_L0p74_m1__nf1_gboth_sdfull_pc/B.n1200 25.6005
R1854 pfet_01v8_lvt_W90p63_L0p74_m1__nf1_gboth_sdfull_pc/B.n1204 pfet_01v8_lvt_W90p63_L0p74_m1__nf1_gboth_sdfull_pc/B.n1201 25.6005
R1855 pfet_01v8_lvt_W90p63_L0p74_m1__nf1_gboth_sdfull_pc/B.n1205 pfet_01v8_lvt_W90p63_L0p74_m1__nf1_gboth_sdfull_pc/B.n1204 25.6005
R1856 pfet_01v8_lvt_W90p63_L0p74_m1__nf1_gboth_sdfull_pc/B.n1208 pfet_01v8_lvt_W90p63_L0p74_m1__nf1_gboth_sdfull_pc/B.n1205 25.6005
R1857 pfet_01v8_lvt_W90p63_L0p74_m1__nf1_gboth_sdfull_pc/B.n1210 pfet_01v8_lvt_W90p63_L0p74_m1__nf1_gboth_sdfull_pc/B.n1208 25.6005
R1858 pfet_01v8_lvt_W90p63_L0p74_m1__nf1_gboth_sdfull_pc/B.n1211 pfet_01v8_lvt_W90p63_L0p74_m1__nf1_gboth_sdfull_pc/B.n1210 25.6005
R1859 pfet_01v8_lvt_W90p63_L0p74_m1__nf1_gboth_sdfull_pc/B.n1213 pfet_01v8_lvt_W90p63_L0p74_m1__nf1_gboth_sdfull_pc/B.n1211 25.6005
R1860 pfet_01v8_lvt_W90p63_L0p74_m1__nf1_gboth_sdfull_pc/B.n1214 pfet_01v8_lvt_W90p63_L0p74_m1__nf1_gboth_sdfull_pc/B.n1213 25.6005
R1861 pfet_01v8_lvt_W90p63_L0p74_m1__nf1_gboth_sdfull_pc/B.n1217 pfet_01v8_lvt_W90p63_L0p74_m1__nf1_gboth_sdfull_pc/B.n1214 25.6005
R1862 pfet_01v8_lvt_W90p63_L0p74_m1__nf1_gboth_sdfull_pc/B.n1218 pfet_01v8_lvt_W90p63_L0p74_m1__nf1_gboth_sdfull_pc/B.n1217 25.6005
R1863 pfet_01v8_lvt_W90p63_L0p74_m1__nf1_gboth_sdfull_pc/B.n1221 pfet_01v8_lvt_W90p63_L0p74_m1__nf1_gboth_sdfull_pc/B.n1218 25.6005
R1864 pfet_01v8_lvt_W90p63_L0p74_m1__nf1_gboth_sdfull_pc/B.n1222 pfet_01v8_lvt_W90p63_L0p74_m1__nf1_gboth_sdfull_pc/B.n1221 25.6005
R1865 pfet_01v8_lvt_W90p63_L0p74_m1__nf1_gboth_sdfull_pc/B.n1225 pfet_01v8_lvt_W90p63_L0p74_m1__nf1_gboth_sdfull_pc/B.n1222 25.6005
R1866 pfet_01v8_lvt_W90p63_L0p74_m1__nf1_gboth_sdfull_pc/B.n1226 pfet_01v8_lvt_W90p63_L0p74_m1__nf1_gboth_sdfull_pc/B.n1225 25.6005
R1867 pfet_01v8_lvt_W90p63_L0p74_m1__nf1_gboth_sdfull_pc/B.n1229 pfet_01v8_lvt_W90p63_L0p74_m1__nf1_gboth_sdfull_pc/B.n1226 25.6005
R1868 pfet_01v8_lvt_W90p63_L0p74_m1__nf1_gboth_sdfull_pc/B.n1230 pfet_01v8_lvt_W90p63_L0p74_m1__nf1_gboth_sdfull_pc/B.n1229 25.6005
R1869 pfet_01v8_lvt_W90p63_L0p74_m1__nf1_gboth_sdfull_pc/B.n1233 pfet_01v8_lvt_W90p63_L0p74_m1__nf1_gboth_sdfull_pc/B.n1230 25.6005
R1870 pfet_01v8_lvt_W90p63_L0p74_m1__nf1_gboth_sdfull_pc/B.n1234 pfet_01v8_lvt_W90p63_L0p74_m1__nf1_gboth_sdfull_pc/B.n1233 25.6005
R1871 pfet_01v8_lvt_W90p63_L0p74_m1__nf1_gboth_sdfull_pc/B.n1237 pfet_01v8_lvt_W90p63_L0p74_m1__nf1_gboth_sdfull_pc/B.n1234 25.6005
R1872 pfet_01v8_lvt_W90p63_L0p74_m1__nf1_gboth_sdfull_pc/B.n1238 pfet_01v8_lvt_W90p63_L0p74_m1__nf1_gboth_sdfull_pc/B.n1237 25.6005
R1873 pfet_01v8_lvt_W90p63_L0p74_m1__nf1_gboth_sdfull_pc/B.n1241 pfet_01v8_lvt_W90p63_L0p74_m1__nf1_gboth_sdfull_pc/B.n1238 25.6005
R1874 pfet_01v8_lvt_W90p63_L0p74_m1__nf1_gboth_sdfull_pc/B.n1242 pfet_01v8_lvt_W90p63_L0p74_m1__nf1_gboth_sdfull_pc/B.n1241 25.6005
R1875 pfet_01v8_lvt_W90p63_L0p74_m1__nf1_gboth_sdfull_pc/B.n1245 pfet_01v8_lvt_W90p63_L0p74_m1__nf1_gboth_sdfull_pc/B.n1242 25.6005
R1876 pfet_01v8_lvt_W90p63_L0p74_m1__nf1_gboth_sdfull_pc/B.n1246 pfet_01v8_lvt_W90p63_L0p74_m1__nf1_gboth_sdfull_pc/B.n1245 25.6005
R1877 pfet_01v8_lvt_W90p63_L0p74_m1__nf1_gboth_sdfull_pc/B.n1249 pfet_01v8_lvt_W90p63_L0p74_m1__nf1_gboth_sdfull_pc/B.n1246 25.6005
R1878 pfet_01v8_lvt_W90p63_L0p74_m1__nf1_gboth_sdfull_pc/B.n1250 pfet_01v8_lvt_W90p63_L0p74_m1__nf1_gboth_sdfull_pc/B.n1249 25.6005
R1879 pfet_01v8_lvt_W90p63_L0p74_m1__nf1_gboth_sdfull_pc/B.n1253 pfet_01v8_lvt_W90p63_L0p74_m1__nf1_gboth_sdfull_pc/B.n1250 25.6005
R1880 pfet_01v8_lvt_W90p63_L0p74_m1__nf1_gboth_sdfull_pc/B.n1254 pfet_01v8_lvt_W90p63_L0p74_m1__nf1_gboth_sdfull_pc/B.n1253 25.6005
R1881 pfet_01v8_lvt_W90p63_L0p74_m1__nf1_gboth_sdfull_pc/B.n1257 pfet_01v8_lvt_W90p63_L0p74_m1__nf1_gboth_sdfull_pc/B.n1254 25.6005
R1882 pfet_01v8_lvt_W90p63_L0p74_m1__nf1_gboth_sdfull_pc/B.n1258 pfet_01v8_lvt_W90p63_L0p74_m1__nf1_gboth_sdfull_pc/B.n1257 25.6005
R1883 pfet_01v8_lvt_W90p63_L0p74_m1__nf1_gboth_sdfull_pc/B.n1261 pfet_01v8_lvt_W90p63_L0p74_m1__nf1_gboth_sdfull_pc/B.n1258 25.6005
R1884 pfet_01v8_lvt_W90p63_L0p74_m1__nf1_gboth_sdfull_pc/B.n1262 pfet_01v8_lvt_W90p63_L0p74_m1__nf1_gboth_sdfull_pc/B.n1261 25.6005
R1885 pfet_01v8_lvt_W90p63_L0p74_m1__nf1_gboth_sdfull_pc/B.n1265 pfet_01v8_lvt_W90p63_L0p74_m1__nf1_gboth_sdfull_pc/B.n1262 25.6005
R1886 pfet_01v8_lvt_W90p63_L0p74_m1__nf1_gboth_sdfull_pc/B.n1266 pfet_01v8_lvt_W90p63_L0p74_m1__nf1_gboth_sdfull_pc/B.n1265 25.6005
R1887 pfet_01v8_lvt_W90p63_L0p74_m1__nf1_gboth_sdfull_pc/B.n1269 pfet_01v8_lvt_W90p63_L0p74_m1__nf1_gboth_sdfull_pc/B.n1266 25.6005
R1888 pfet_01v8_lvt_W90p63_L0p74_m1__nf1_gboth_sdfull_pc/B.n1270 pfet_01v8_lvt_W90p63_L0p74_m1__nf1_gboth_sdfull_pc/B.n1269 25.6005
R1889 pfet_01v8_lvt_W90p63_L0p74_m1__nf1_gboth_sdfull_pc/B.n1273 pfet_01v8_lvt_W90p63_L0p74_m1__nf1_gboth_sdfull_pc/B.n1270 25.6005
R1890 pfet_01v8_lvt_W90p63_L0p74_m1__nf1_gboth_sdfull_pc/B.n1274 pfet_01v8_lvt_W90p63_L0p74_m1__nf1_gboth_sdfull_pc/B.n1273 25.6005
R1891 pfet_01v8_lvt_W90p63_L0p74_m1__nf1_gboth_sdfull_pc/B.n1277 pfet_01v8_lvt_W90p63_L0p74_m1__nf1_gboth_sdfull_pc/B.n1274 25.6005
R1892 pfet_01v8_lvt_W90p63_L0p74_m1__nf1_gboth_sdfull_pc/B.n1278 pfet_01v8_lvt_W90p63_L0p74_m1__nf1_gboth_sdfull_pc/B.n1277 25.6005
R1893 pfet_01v8_lvt_W90p63_L0p74_m1__nf1_gboth_sdfull_pc/B.n1281 pfet_01v8_lvt_W90p63_L0p74_m1__nf1_gboth_sdfull_pc/B.n1278 25.6005
R1894 pfet_01v8_lvt_W90p63_L0p74_m1__nf1_gboth_sdfull_pc/B.n1282 pfet_01v8_lvt_W90p63_L0p74_m1__nf1_gboth_sdfull_pc/B.n1281 25.6005
R1895 pfet_01v8_lvt_W90p63_L0p74_m1__nf1_gboth_sdfull_pc/B.n1285 pfet_01v8_lvt_W90p63_L0p74_m1__nf1_gboth_sdfull_pc/B.n1282 25.6005
R1896 pfet_01v8_lvt_W90p63_L0p74_m1__nf1_gboth_sdfull_pc/B.n1286 pfet_01v8_lvt_W90p63_L0p74_m1__nf1_gboth_sdfull_pc/B.n1285 25.6005
R1897 pfet_01v8_lvt_W90p63_L0p74_m1__nf1_gboth_sdfull_pc/B.n1289 pfet_01v8_lvt_W90p63_L0p74_m1__nf1_gboth_sdfull_pc/B.n1286 25.6005
R1898 pfet_01v8_lvt_W90p63_L0p74_m1__nf1_gboth_sdfull_pc/B.n1290 pfet_01v8_lvt_W90p63_L0p74_m1__nf1_gboth_sdfull_pc/B.n1289 25.6005
R1899 pfet_01v8_lvt_W90p63_L0p74_m1__nf1_gboth_sdfull_pc/B.n1293 pfet_01v8_lvt_W90p63_L0p74_m1__nf1_gboth_sdfull_pc/B.n1290 25.6005
R1900 pfet_01v8_lvt_W90p63_L0p74_m1__nf1_gboth_sdfull_pc/B.n1294 pfet_01v8_lvt_W90p63_L0p74_m1__nf1_gboth_sdfull_pc/B.n1293 25.6005
R1901 pfet_01v8_lvt_W90p63_L0p74_m1__nf1_gboth_sdfull_pc/B.n1297 pfet_01v8_lvt_W90p63_L0p74_m1__nf1_gboth_sdfull_pc/B.n1294 25.6005
R1902 pfet_01v8_lvt_W90p63_L0p74_m1__nf1_gboth_sdfull_pc/B.n1298 pfet_01v8_lvt_W90p63_L0p74_m1__nf1_gboth_sdfull_pc/B.n1297 25.6005
R1903 pfet_01v8_lvt_W90p63_L0p74_m1__nf1_gboth_sdfull_pc/B.n1301 pfet_01v8_lvt_W90p63_L0p74_m1__nf1_gboth_sdfull_pc/B.n1298 25.6005
R1904 pfet_01v8_lvt_W90p63_L0p74_m1__nf1_gboth_sdfull_pc/B.n1302 pfet_01v8_lvt_W90p63_L0p74_m1__nf1_gboth_sdfull_pc/B.n1301 25.6005
R1905 pfet_01v8_lvt_W90p63_L0p74_m1__nf1_gboth_sdfull_pc/B.n1305 pfet_01v8_lvt_W90p63_L0p74_m1__nf1_gboth_sdfull_pc/B.n1302 25.6005
R1906 pfet_01v8_lvt_W90p63_L0p74_m1__nf1_gboth_sdfull_pc/B.n1306 pfet_01v8_lvt_W90p63_L0p74_m1__nf1_gboth_sdfull_pc/B.n1305 25.6005
R1907 pfet_01v8_lvt_W90p63_L0p74_m1__nf1_gboth_sdfull_pc/B.n1309 pfet_01v8_lvt_W90p63_L0p74_m1__nf1_gboth_sdfull_pc/B.n1306 25.6005
R1908 pfet_01v8_lvt_W90p63_L0p74_m1__nf1_gboth_sdfull_pc/B.n1310 pfet_01v8_lvt_W90p63_L0p74_m1__nf1_gboth_sdfull_pc/B.n1309 25.6005
R1909 pfet_01v8_lvt_W90p63_L0p74_m1__nf1_gboth_sdfull_pc/B.n1313 pfet_01v8_lvt_W90p63_L0p74_m1__nf1_gboth_sdfull_pc/B.n1310 25.6005
R1910 pfet_01v8_lvt_W90p63_L0p74_m1__nf1_gboth_sdfull_pc/B.n1315 pfet_01v8_lvt_W90p63_L0p74_m1__nf1_gboth_sdfull_pc/B.n1313 25.6005
R1911 pfet_01v8_lvt_W90p63_L0p74_m1__nf1_gboth_sdfull_pc/B.n1316 pfet_01v8_lvt_W90p63_L0p74_m1__nf1_gboth_sdfull_pc/B.n1315 25.6005
R1912 pfet_01v8_lvt_W90p63_L0p74_m1__nf1_gboth_sdfull_pc/B.n1318 pfet_01v8_lvt_W90p63_L0p74_m1__nf1_gboth_sdfull_pc/B.n1316 25.6005
R1913 pfet_01v8_lvt_W90p63_L0p74_m1__nf1_gboth_sdfull_pc/B.n1320 pfet_01v8_lvt_W90p63_L0p74_m1__nf1_gboth_sdfull_pc/B.n1318 25.6005
R1914 pfet_01v8_lvt_W90p63_L0p74_m1__nf1_gboth_sdfull_pc/B.n1321 pfet_01v8_lvt_W90p63_L0p74_m1__nf1_gboth_sdfull_pc/B.n1320 25.6005
R1915 pfet_01v8_lvt_W90p63_L0p74_m1__nf1_gboth_sdfull_pc/B.n1322 pfet_01v8_lvt_W90p63_L0p74_m1__nf1_gboth_sdfull_pc/B.n1321 25.6005
R1916 pfet_01v8_lvt_W90p63_L0p74_m1__nf1_gboth_sdfull_pc/B.n1322 pfet_01v8_lvt_W90p63_L0p74_m1__nf1_gboth_sdfull_pc/B.n826 25.6005
R1917 pfet_01v8_lvt_W90p63_L0p74_m1__nf1_gboth_sdfull_pc/B.n826 pfet_01v8_lvt_W90p63_L0p74_m1__nf1_gboth_sdfull_pc/B.n673 25.6005
R1918 pfet_01v8_lvt_W90p63_L0p74_m1__nf1_gboth_sdfull_pc/B.n1328 pfet_01v8_lvt_W90p63_L0p74_m1__nf1_gboth_sdfull_pc/B.n673 25.6005
R1919 pfet_01v8_lvt_W90p63_L0p74_m1__nf1_gboth_sdfull_pc/B.n1330 pfet_01v8_lvt_W90p63_L0p74_m1__nf1_gboth_sdfull_pc/B.n1329 25.6005
R1920 pfet_01v8_lvt_W90p63_L0p74_m1__nf1_gboth_sdfull_pc/B.n1330 pfet_01v8_lvt_W90p63_L0p74_m1__nf1_gboth_sdfull_pc/B.n672 25.6005
R1921 pfet_01v8_lvt_W90p63_L0p74_m1__nf1_gboth_sdfull_pc/B.n672 pfet_01v8_lvt_W90p63_L0p74_m1__nf1_gboth_sdfull_pc/B.n671 25.6005
R1922 pfet_01v8_lvt_W90p63_L0p74_m1__nf1_gboth_sdfull_pc/B.n665 pfet_01v8_lvt_W90p63_L0p74_m1__nf1_gboth_sdfull_pc/B.n664 25.6005
R1923 pfet_01v8_lvt_W90p63_L0p74_m1__nf1_gboth_sdfull_pc/B.n664 pfet_01v8_lvt_W90p63_L0p74_m1__nf1_gboth_sdfull_pc/B.n11 25.6005
R1924 pfet_01v8_lvt_W90p63_L0p74_m1__nf1_gboth_sdfull_pc/B.n658 pfet_01v8_lvt_W90p63_L0p74_m1__nf1_gboth_sdfull_pc/B.n11 25.6005
R1925 pfet_01v8_lvt_W90p63_L0p74_m1__nf1_gboth_sdfull_pc/B.n658 pfet_01v8_lvt_W90p63_L0p74_m1__nf1_gboth_sdfull_pc/B.n657 25.6005
R1926 pfet_01v8_lvt_W90p63_L0p74_m1__nf1_gboth_sdfull_pc/B.n657 pfet_01v8_lvt_W90p63_L0p74_m1__nf1_gboth_sdfull_pc/B.n656 25.6005
R1927 pfet_01v8_lvt_W90p63_L0p74_m1__nf1_gboth_sdfull_pc/B.n656 pfet_01v8_lvt_W90p63_L0p74_m1__nf1_gboth_sdfull_pc/B.n13 25.6005
R1928 pfet_01v8_lvt_W90p63_L0p74_m1__nf1_gboth_sdfull_pc/B.n651 pfet_01v8_lvt_W90p63_L0p74_m1__nf1_gboth_sdfull_pc/B.n13 25.6005
R1929 pfet_01v8_lvt_W90p63_L0p74_m1__nf1_gboth_sdfull_pc/B.n651 pfet_01v8_lvt_W90p63_L0p74_m1__nf1_gboth_sdfull_pc/B.n650 25.6005
R1930 pfet_01v8_lvt_W90p63_L0p74_m1__nf1_gboth_sdfull_pc/B.n650 pfet_01v8_lvt_W90p63_L0p74_m1__nf1_gboth_sdfull_pc/B.n15 25.6005
R1931 pfet_01v8_lvt_W90p63_L0p74_m1__nf1_gboth_sdfull_pc/B.n646 pfet_01v8_lvt_W90p63_L0p74_m1__nf1_gboth_sdfull_pc/B.n15 25.6005
R1932 pfet_01v8_lvt_W90p63_L0p74_m1__nf1_gboth_sdfull_pc/B.n646 pfet_01v8_lvt_W90p63_L0p74_m1__nf1_gboth_sdfull_pc/B.n645 25.6005
R1933 pfet_01v8_lvt_W90p63_L0p74_m1__nf1_gboth_sdfull_pc/B.n645 pfet_01v8_lvt_W90p63_L0p74_m1__nf1_gboth_sdfull_pc/B.n17 25.6005
R1934 pfet_01v8_lvt_W90p63_L0p74_m1__nf1_gboth_sdfull_pc/B.n641 pfet_01v8_lvt_W90p63_L0p74_m1__nf1_gboth_sdfull_pc/B.n17 25.6005
R1935 pfet_01v8_lvt_W90p63_L0p74_m1__nf1_gboth_sdfull_pc/B.n641 pfet_01v8_lvt_W90p63_L0p74_m1__nf1_gboth_sdfull_pc/B.n640 25.6005
R1936 pfet_01v8_lvt_W90p63_L0p74_m1__nf1_gboth_sdfull_pc/B.n640 pfet_01v8_lvt_W90p63_L0p74_m1__nf1_gboth_sdfull_pc/B.n19 25.6005
R1937 pfet_01v8_lvt_W90p63_L0p74_m1__nf1_gboth_sdfull_pc/B.n636 pfet_01v8_lvt_W90p63_L0p74_m1__nf1_gboth_sdfull_pc/B.n19 25.6005
R1938 pfet_01v8_lvt_W90p63_L0p74_m1__nf1_gboth_sdfull_pc/B.n636 pfet_01v8_lvt_W90p63_L0p74_m1__nf1_gboth_sdfull_pc/B.n635 25.6005
R1939 pfet_01v8_lvt_W90p63_L0p74_m1__nf1_gboth_sdfull_pc/B.n635 pfet_01v8_lvt_W90p63_L0p74_m1__nf1_gboth_sdfull_pc/B.n21 25.6005
R1940 pfet_01v8_lvt_W90p63_L0p74_m1__nf1_gboth_sdfull_pc/B.n630 pfet_01v8_lvt_W90p63_L0p74_m1__nf1_gboth_sdfull_pc/B.n21 25.6005
R1941 pfet_01v8_lvt_W90p63_L0p74_m1__nf1_gboth_sdfull_pc/B.n630 pfet_01v8_lvt_W90p63_L0p74_m1__nf1_gboth_sdfull_pc/B.n629 25.6005
R1942 pfet_01v8_lvt_W90p63_L0p74_m1__nf1_gboth_sdfull_pc/B.n629 pfet_01v8_lvt_W90p63_L0p74_m1__nf1_gboth_sdfull_pc/B.n628 25.6005
R1943 pfet_01v8_lvt_W90p63_L0p74_m1__nf1_gboth_sdfull_pc/B.n628 pfet_01v8_lvt_W90p63_L0p74_m1__nf1_gboth_sdfull_pc/B.n23 25.6005
R1944 pfet_01v8_lvt_W90p63_L0p74_m1__nf1_gboth_sdfull_pc/B.n24 pfet_01v8_lvt_W90p63_L0p74_m1__nf1_gboth_sdfull_pc/B.n23 25.6005
R1945 pfet_01v8_lvt_W90p63_L0p74_m1__nf1_gboth_sdfull_pc/B.n621 pfet_01v8_lvt_W90p63_L0p74_m1__nf1_gboth_sdfull_pc/B.n24 25.6005
R1946 pfet_01v8_lvt_W90p63_L0p74_m1__nf1_gboth_sdfull_pc/B.n621 pfet_01v8_lvt_W90p63_L0p74_m1__nf1_gboth_sdfull_pc/B.n620 25.6005
R1947 pfet_01v8_lvt_W90p63_L0p74_m1__nf1_gboth_sdfull_pc/B.n620 pfet_01v8_lvt_W90p63_L0p74_m1__nf1_gboth_sdfull_pc/B.n619 25.6005
R1948 pfet_01v8_lvt_W90p63_L0p74_m1__nf1_gboth_sdfull_pc/B.n619 pfet_01v8_lvt_W90p63_L0p74_m1__nf1_gboth_sdfull_pc/B.n26 25.6005
R1949 pfet_01v8_lvt_W90p63_L0p74_m1__nf1_gboth_sdfull_pc/B.n613 pfet_01v8_lvt_W90p63_L0p74_m1__nf1_gboth_sdfull_pc/B.n26 25.6005
R1950 pfet_01v8_lvt_W90p63_L0p74_m1__nf1_gboth_sdfull_pc/B.n613 pfet_01v8_lvt_W90p63_L0p74_m1__nf1_gboth_sdfull_pc/B.n612 25.6005
R1951 pfet_01v8_lvt_W90p63_L0p74_m1__nf1_gboth_sdfull_pc/B.n612 pfet_01v8_lvt_W90p63_L0p74_m1__nf1_gboth_sdfull_pc/B.n611 25.6005
R1952 pfet_01v8_lvt_W90p63_L0p74_m1__nf1_gboth_sdfull_pc/B.n611 pfet_01v8_lvt_W90p63_L0p74_m1__nf1_gboth_sdfull_pc/B.n28 25.6005
R1953 pfet_01v8_lvt_W90p63_L0p74_m1__nf1_gboth_sdfull_pc/B.n605 pfet_01v8_lvt_W90p63_L0p74_m1__nf1_gboth_sdfull_pc/B.n28 25.6005
R1954 pfet_01v8_lvt_W90p63_L0p74_m1__nf1_gboth_sdfull_pc/B.n605 pfet_01v8_lvt_W90p63_L0p74_m1__nf1_gboth_sdfull_pc/B.n604 25.6005
R1955 pfet_01v8_lvt_W90p63_L0p74_m1__nf1_gboth_sdfull_pc/B.n604 pfet_01v8_lvt_W90p63_L0p74_m1__nf1_gboth_sdfull_pc/B.n603 25.6005
R1956 pfet_01v8_lvt_W90p63_L0p74_m1__nf1_gboth_sdfull_pc/B.n603 pfet_01v8_lvt_W90p63_L0p74_m1__nf1_gboth_sdfull_pc/B.n30 25.6005
R1957 pfet_01v8_lvt_W90p63_L0p74_m1__nf1_gboth_sdfull_pc/B.n597 pfet_01v8_lvt_W90p63_L0p74_m1__nf1_gboth_sdfull_pc/B.n30 25.6005
R1958 pfet_01v8_lvt_W90p63_L0p74_m1__nf1_gboth_sdfull_pc/B.n597 pfet_01v8_lvt_W90p63_L0p74_m1__nf1_gboth_sdfull_pc/B.n596 25.6005
R1959 pfet_01v8_lvt_W90p63_L0p74_m1__nf1_gboth_sdfull_pc/B.n596 pfet_01v8_lvt_W90p63_L0p74_m1__nf1_gboth_sdfull_pc/B.n595 25.6005
R1960 pfet_01v8_lvt_W90p63_L0p74_m1__nf1_gboth_sdfull_pc/B.n595 pfet_01v8_lvt_W90p63_L0p74_m1__nf1_gboth_sdfull_pc/B.n32 25.6005
R1961 pfet_01v8_lvt_W90p63_L0p74_m1__nf1_gboth_sdfull_pc/B.n590 pfet_01v8_lvt_W90p63_L0p74_m1__nf1_gboth_sdfull_pc/B.n32 25.6005
R1962 pfet_01v8_lvt_W90p63_L0p74_m1__nf1_gboth_sdfull_pc/B.n590 pfet_01v8_lvt_W90p63_L0p74_m1__nf1_gboth_sdfull_pc/B.n589 25.6005
R1963 pfet_01v8_lvt_W90p63_L0p74_m1__nf1_gboth_sdfull_pc/B.n589 pfet_01v8_lvt_W90p63_L0p74_m1__nf1_gboth_sdfull_pc/B.n34 25.6005
R1964 pfet_01v8_lvt_W90p63_L0p74_m1__nf1_gboth_sdfull_pc/B.n584 pfet_01v8_lvt_W90p63_L0p74_m1__nf1_gboth_sdfull_pc/B.n34 25.6005
R1965 pfet_01v8_lvt_W90p63_L0p74_m1__nf1_gboth_sdfull_pc/B.n584 pfet_01v8_lvt_W90p63_L0p74_m1__nf1_gboth_sdfull_pc/B.n583 25.6005
R1966 pfet_01v8_lvt_W90p63_L0p74_m1__nf1_gboth_sdfull_pc/B.n583 pfet_01v8_lvt_W90p63_L0p74_m1__nf1_gboth_sdfull_pc/B.n582 25.6005
R1967 pfet_01v8_lvt_W90p63_L0p74_m1__nf1_gboth_sdfull_pc/B.n582 pfet_01v8_lvt_W90p63_L0p74_m1__nf1_gboth_sdfull_pc/B.n36 25.6005
R1968 pfet_01v8_lvt_W90p63_L0p74_m1__nf1_gboth_sdfull_pc/B.n576 pfet_01v8_lvt_W90p63_L0p74_m1__nf1_gboth_sdfull_pc/B.n36 25.6005
R1969 pfet_01v8_lvt_W90p63_L0p74_m1__nf1_gboth_sdfull_pc/B.n576 pfet_01v8_lvt_W90p63_L0p74_m1__nf1_gboth_sdfull_pc/B.n575 25.6005
R1970 pfet_01v8_lvt_W90p63_L0p74_m1__nf1_gboth_sdfull_pc/B.n575 pfet_01v8_lvt_W90p63_L0p74_m1__nf1_gboth_sdfull_pc/B.n574 25.6005
R1971 pfet_01v8_lvt_W90p63_L0p74_m1__nf1_gboth_sdfull_pc/B.n574 pfet_01v8_lvt_W90p63_L0p74_m1__nf1_gboth_sdfull_pc/B.n38 25.6005
R1972 pfet_01v8_lvt_W90p63_L0p74_m1__nf1_gboth_sdfull_pc/B.n569 pfet_01v8_lvt_W90p63_L0p74_m1__nf1_gboth_sdfull_pc/B.n38 25.6005
R1973 pfet_01v8_lvt_W90p63_L0p74_m1__nf1_gboth_sdfull_pc/B.n569 pfet_01v8_lvt_W90p63_L0p74_m1__nf1_gboth_sdfull_pc/B.n568 25.6005
R1974 pfet_01v8_lvt_W90p63_L0p74_m1__nf1_gboth_sdfull_pc/B.n568 pfet_01v8_lvt_W90p63_L0p74_m1__nf1_gboth_sdfull_pc/B.n40 25.6005
R1975 pfet_01v8_lvt_W90p63_L0p74_m1__nf1_gboth_sdfull_pc/B.n563 pfet_01v8_lvt_W90p63_L0p74_m1__nf1_gboth_sdfull_pc/B.n40 25.6005
R1976 pfet_01v8_lvt_W90p63_L0p74_m1__nf1_gboth_sdfull_pc/B.n563 pfet_01v8_lvt_W90p63_L0p74_m1__nf1_gboth_sdfull_pc/B.n562 25.6005
R1977 pfet_01v8_lvt_W90p63_L0p74_m1__nf1_gboth_sdfull_pc/B.n562 pfet_01v8_lvt_W90p63_L0p74_m1__nf1_gboth_sdfull_pc/B.n561 25.6005
R1978 pfet_01v8_lvt_W90p63_L0p74_m1__nf1_gboth_sdfull_pc/B.n561 pfet_01v8_lvt_W90p63_L0p74_m1__nf1_gboth_sdfull_pc/B.n42 25.6005
R1979 pfet_01v8_lvt_W90p63_L0p74_m1__nf1_gboth_sdfull_pc/B.n556 pfet_01v8_lvt_W90p63_L0p74_m1__nf1_gboth_sdfull_pc/B.n42 25.6005
R1980 pfet_01v8_lvt_W90p63_L0p74_m1__nf1_gboth_sdfull_pc/B.n556 pfet_01v8_lvt_W90p63_L0p74_m1__nf1_gboth_sdfull_pc/B.n555 25.6005
R1981 pfet_01v8_lvt_W90p63_L0p74_m1__nf1_gboth_sdfull_pc/B.n555 pfet_01v8_lvt_W90p63_L0p74_m1__nf1_gboth_sdfull_pc/B.n44 25.6005
R1982 pfet_01v8_lvt_W90p63_L0p74_m1__nf1_gboth_sdfull_pc/B.n45 pfet_01v8_lvt_W90p63_L0p74_m1__nf1_gboth_sdfull_pc/B.n44 25.6005
R1983 pfet_01v8_lvt_W90p63_L0p74_m1__nf1_gboth_sdfull_pc/B.n549 pfet_01v8_lvt_W90p63_L0p74_m1__nf1_gboth_sdfull_pc/B.n45 25.6005
R1984 pfet_01v8_lvt_W90p63_L0p74_m1__nf1_gboth_sdfull_pc/B.n549 pfet_01v8_lvt_W90p63_L0p74_m1__nf1_gboth_sdfull_pc/B.n548 25.6005
R1985 pfet_01v8_lvt_W90p63_L0p74_m1__nf1_gboth_sdfull_pc/B.n548 pfet_01v8_lvt_W90p63_L0p74_m1__nf1_gboth_sdfull_pc/B.n547 25.6005
R1986 pfet_01v8_lvt_W90p63_L0p74_m1__nf1_gboth_sdfull_pc/B.n547 pfet_01v8_lvt_W90p63_L0p74_m1__nf1_gboth_sdfull_pc/B.n47 25.6005
R1987 pfet_01v8_lvt_W90p63_L0p74_m1__nf1_gboth_sdfull_pc/B.n48 pfet_01v8_lvt_W90p63_L0p74_m1__nf1_gboth_sdfull_pc/B.n47 25.6005
R1988 pfet_01v8_lvt_W90p63_L0p74_m1__nf1_gboth_sdfull_pc/B.n540 pfet_01v8_lvt_W90p63_L0p74_m1__nf1_gboth_sdfull_pc/B.n48 25.6005
R1989 pfet_01v8_lvt_W90p63_L0p74_m1__nf1_gboth_sdfull_pc/B.n540 pfet_01v8_lvt_W90p63_L0p74_m1__nf1_gboth_sdfull_pc/B.n539 25.6005
R1990 pfet_01v8_lvt_W90p63_L0p74_m1__nf1_gboth_sdfull_pc/B.n539 pfet_01v8_lvt_W90p63_L0p74_m1__nf1_gboth_sdfull_pc/B.n538 25.6005
R1991 pfet_01v8_lvt_W90p63_L0p74_m1__nf1_gboth_sdfull_pc/B.n538 pfet_01v8_lvt_W90p63_L0p74_m1__nf1_gboth_sdfull_pc/B.n50 25.6005
R1992 pfet_01v8_lvt_W90p63_L0p74_m1__nf1_gboth_sdfull_pc/B.n533 pfet_01v8_lvt_W90p63_L0p74_m1__nf1_gboth_sdfull_pc/B.n50 25.6005
R1993 pfet_01v8_lvt_W90p63_L0p74_m1__nf1_gboth_sdfull_pc/B.n533 pfet_01v8_lvt_W90p63_L0p74_m1__nf1_gboth_sdfull_pc/B.n532 25.6005
R1994 pfet_01v8_lvt_W90p63_L0p74_m1__nf1_gboth_sdfull_pc/B.n532 pfet_01v8_lvt_W90p63_L0p74_m1__nf1_gboth_sdfull_pc/B.n52 25.6005
R1995 pfet_01v8_lvt_W90p63_L0p74_m1__nf1_gboth_sdfull_pc/B.n527 pfet_01v8_lvt_W90p63_L0p74_m1__nf1_gboth_sdfull_pc/B.n52 25.6005
R1996 pfet_01v8_lvt_W90p63_L0p74_m1__nf1_gboth_sdfull_pc/B.n527 pfet_01v8_lvt_W90p63_L0p74_m1__nf1_gboth_sdfull_pc/B.n526 25.6005
R1997 pfet_01v8_lvt_W90p63_L0p74_m1__nf1_gboth_sdfull_pc/B.n526 pfet_01v8_lvt_W90p63_L0p74_m1__nf1_gboth_sdfull_pc/B.n525 25.6005
R1998 pfet_01v8_lvt_W90p63_L0p74_m1__nf1_gboth_sdfull_pc/B.n525 pfet_01v8_lvt_W90p63_L0p74_m1__nf1_gboth_sdfull_pc/B.n54 25.6005
R1999 pfet_01v8_lvt_W90p63_L0p74_m1__nf1_gboth_sdfull_pc/B.n520 pfet_01v8_lvt_W90p63_L0p74_m1__nf1_gboth_sdfull_pc/B.n54 25.6005
R2000 pfet_01v8_lvt_W90p63_L0p74_m1__nf1_gboth_sdfull_pc/B.n520 pfet_01v8_lvt_W90p63_L0p74_m1__nf1_gboth_sdfull_pc/B.n519 25.6005
R2001 pfet_01v8_lvt_W90p63_L0p74_m1__nf1_gboth_sdfull_pc/B.n519 pfet_01v8_lvt_W90p63_L0p74_m1__nf1_gboth_sdfull_pc/B.n56 25.6005
R2002 pfet_01v8_lvt_W90p63_L0p74_m1__nf1_gboth_sdfull_pc/B.n515 pfet_01v8_lvt_W90p63_L0p74_m1__nf1_gboth_sdfull_pc/B.n56 25.6005
R2003 pfet_01v8_lvt_W90p63_L0p74_m1__nf1_gboth_sdfull_pc/B.n515 pfet_01v8_lvt_W90p63_L0p74_m1__nf1_gboth_sdfull_pc/B.n514 25.6005
R2004 pfet_01v8_lvt_W90p63_L0p74_m1__nf1_gboth_sdfull_pc/B.n514 pfet_01v8_lvt_W90p63_L0p74_m1__nf1_gboth_sdfull_pc/B.n58 25.6005
R2005 pfet_01v8_lvt_W90p63_L0p74_m1__nf1_gboth_sdfull_pc/B.n510 pfet_01v8_lvt_W90p63_L0p74_m1__nf1_gboth_sdfull_pc/B.n58 25.6005
R2006 pfet_01v8_lvt_W90p63_L0p74_m1__nf1_gboth_sdfull_pc/B.n510 pfet_01v8_lvt_W90p63_L0p74_m1__nf1_gboth_sdfull_pc/B.n509 25.6005
R2007 pfet_01v8_lvt_W90p63_L0p74_m1__nf1_gboth_sdfull_pc/B.n509 pfet_01v8_lvt_W90p63_L0p74_m1__nf1_gboth_sdfull_pc/B.n60 25.6005
R2008 pfet_01v8_lvt_W90p63_L0p74_m1__nf1_gboth_sdfull_pc/B.n61 pfet_01v8_lvt_W90p63_L0p74_m1__nf1_gboth_sdfull_pc/B.n60 25.6005
R2009 pfet_01v8_lvt_W90p63_L0p74_m1__nf1_gboth_sdfull_pc/B.n503 pfet_01v8_lvt_W90p63_L0p74_m1__nf1_gboth_sdfull_pc/B.n61 25.6005
R2010 pfet_01v8_lvt_W90p63_L0p74_m1__nf1_gboth_sdfull_pc/B.n503 pfet_01v8_lvt_W90p63_L0p74_m1__nf1_gboth_sdfull_pc/B.n502 25.6005
R2011 pfet_01v8_lvt_W90p63_L0p74_m1__nf1_gboth_sdfull_pc/B.n502 pfet_01v8_lvt_W90p63_L0p74_m1__nf1_gboth_sdfull_pc/B.n501 25.6005
R2012 pfet_01v8_lvt_W90p63_L0p74_m1__nf1_gboth_sdfull_pc/B.n501 pfet_01v8_lvt_W90p63_L0p74_m1__nf1_gboth_sdfull_pc/B.n63 25.6005
R2013 pfet_01v8_lvt_W90p63_L0p74_m1__nf1_gboth_sdfull_pc/B.n495 pfet_01v8_lvt_W90p63_L0p74_m1__nf1_gboth_sdfull_pc/B.n63 25.6005
R2014 pfet_01v8_lvt_W90p63_L0p74_m1__nf1_gboth_sdfull_pc/B.n495 pfet_01v8_lvt_W90p63_L0p74_m1__nf1_gboth_sdfull_pc/B.n494 25.6005
R2015 pfet_01v8_lvt_W90p63_L0p74_m1__nf1_gboth_sdfull_pc/B.n494 pfet_01v8_lvt_W90p63_L0p74_m1__nf1_gboth_sdfull_pc/B.n493 25.6005
R2016 pfet_01v8_lvt_W90p63_L0p74_m1__nf1_gboth_sdfull_pc/B.n493 pfet_01v8_lvt_W90p63_L0p74_m1__nf1_gboth_sdfull_pc/B.n65 25.6005
R2017 pfet_01v8_lvt_W90p63_L0p74_m1__nf1_gboth_sdfull_pc/B.n487 pfet_01v8_lvt_W90p63_L0p74_m1__nf1_gboth_sdfull_pc/B.n65 25.6005
R2018 pfet_01v8_lvt_W90p63_L0p74_m1__nf1_gboth_sdfull_pc/B.n487 pfet_01v8_lvt_W90p63_L0p74_m1__nf1_gboth_sdfull_pc/B.n486 25.6005
R2019 pfet_01v8_lvt_W90p63_L0p74_m1__nf1_gboth_sdfull_pc/B.n486 pfet_01v8_lvt_W90p63_L0p74_m1__nf1_gboth_sdfull_pc/B.n485 25.6005
R2020 pfet_01v8_lvt_W90p63_L0p74_m1__nf1_gboth_sdfull_pc/B.n485 pfet_01v8_lvt_W90p63_L0p74_m1__nf1_gboth_sdfull_pc/B.n67 25.6005
R2021 pfet_01v8_lvt_W90p63_L0p74_m1__nf1_gboth_sdfull_pc/B.n480 pfet_01v8_lvt_W90p63_L0p74_m1__nf1_gboth_sdfull_pc/B.n67 25.6005
R2022 pfet_01v8_lvt_W90p63_L0p74_m1__nf1_gboth_sdfull_pc/B.n480 pfet_01v8_lvt_W90p63_L0p74_m1__nf1_gboth_sdfull_pc/B.n479 25.6005
R2023 pfet_01v8_lvt_W90p63_L0p74_m1__nf1_gboth_sdfull_pc/B.n479 pfet_01v8_lvt_W90p63_L0p74_m1__nf1_gboth_sdfull_pc/B.n69 25.6005
R2024 pfet_01v8_lvt_W90p63_L0p74_m1__nf1_gboth_sdfull_pc/B.n474 pfet_01v8_lvt_W90p63_L0p74_m1__nf1_gboth_sdfull_pc/B.n69 25.6005
R2025 pfet_01v8_lvt_W90p63_L0p74_m1__nf1_gboth_sdfull_pc/B.n474 pfet_01v8_lvt_W90p63_L0p74_m1__nf1_gboth_sdfull_pc/B.n473 25.6005
R2026 pfet_01v8_lvt_W90p63_L0p74_m1__nf1_gboth_sdfull_pc/B.n473 pfet_01v8_lvt_W90p63_L0p74_m1__nf1_gboth_sdfull_pc/B.n472 25.6005
R2027 pfet_01v8_lvt_W90p63_L0p74_m1__nf1_gboth_sdfull_pc/B.n472 pfet_01v8_lvt_W90p63_L0p74_m1__nf1_gboth_sdfull_pc/B.n71 25.6005
R2028 pfet_01v8_lvt_W90p63_L0p74_m1__nf1_gboth_sdfull_pc/B.n467 pfet_01v8_lvt_W90p63_L0p74_m1__nf1_gboth_sdfull_pc/B.n71 25.6005
R2029 pfet_01v8_lvt_W90p63_L0p74_m1__nf1_gboth_sdfull_pc/B.n467 pfet_01v8_lvt_W90p63_L0p74_m1__nf1_gboth_sdfull_pc/B.n466 25.6005
R2030 pfet_01v8_lvt_W90p63_L0p74_m1__nf1_gboth_sdfull_pc/B.n466 pfet_01v8_lvt_W90p63_L0p74_m1__nf1_gboth_sdfull_pc/B.n73 25.6005
R2031 pfet_01v8_lvt_W90p63_L0p74_m1__nf1_gboth_sdfull_pc/B.n461 pfet_01v8_lvt_W90p63_L0p74_m1__nf1_gboth_sdfull_pc/B.n73 25.6005
R2032 pfet_01v8_lvt_W90p63_L0p74_m1__nf1_gboth_sdfull_pc/B.n461 pfet_01v8_lvt_W90p63_L0p74_m1__nf1_gboth_sdfull_pc/B.n460 25.6005
R2033 pfet_01v8_lvt_W90p63_L0p74_m1__nf1_gboth_sdfull_pc/B.n460 pfet_01v8_lvt_W90p63_L0p74_m1__nf1_gboth_sdfull_pc/B.n459 25.6005
R2034 pfet_01v8_lvt_W90p63_L0p74_m1__nf1_gboth_sdfull_pc/B.n459 pfet_01v8_lvt_W90p63_L0p74_m1__nf1_gboth_sdfull_pc/B.n75 25.6005
R2035 pfet_01v8_lvt_W90p63_L0p74_m1__nf1_gboth_sdfull_pc/B.n453 pfet_01v8_lvt_W90p63_L0p74_m1__nf1_gboth_sdfull_pc/B.n75 25.6005
R2036 pfet_01v8_lvt_W90p63_L0p74_m1__nf1_gboth_sdfull_pc/B.n453 pfet_01v8_lvt_W90p63_L0p74_m1__nf1_gboth_sdfull_pc/B.n452 25.6005
R2037 pfet_01v8_lvt_W90p63_L0p74_m1__nf1_gboth_sdfull_pc/B.n452 pfet_01v8_lvt_W90p63_L0p74_m1__nf1_gboth_sdfull_pc/B.n451 25.6005
R2038 pfet_01v8_lvt_W90p63_L0p74_m1__nf1_gboth_sdfull_pc/B.n451 pfet_01v8_lvt_W90p63_L0p74_m1__nf1_gboth_sdfull_pc/B.n77 25.6005
R2039 pfet_01v8_lvt_W90p63_L0p74_m1__nf1_gboth_sdfull_pc/B.n78 pfet_01v8_lvt_W90p63_L0p74_m1__nf1_gboth_sdfull_pc/B.n77 25.6005
R2040 pfet_01v8_lvt_W90p63_L0p74_m1__nf1_gboth_sdfull_pc/B.n444 pfet_01v8_lvt_W90p63_L0p74_m1__nf1_gboth_sdfull_pc/B.n78 25.6005
R2041 pfet_01v8_lvt_W90p63_L0p74_m1__nf1_gboth_sdfull_pc/B.n444 pfet_01v8_lvt_W90p63_L0p74_m1__nf1_gboth_sdfull_pc/B.n443 25.6005
R2042 pfet_01v8_lvt_W90p63_L0p74_m1__nf1_gboth_sdfull_pc/B.n443 pfet_01v8_lvt_W90p63_L0p74_m1__nf1_gboth_sdfull_pc/B.n442 25.6005
R2043 pfet_01v8_lvt_W90p63_L0p74_m1__nf1_gboth_sdfull_pc/B.n442 pfet_01v8_lvt_W90p63_L0p74_m1__nf1_gboth_sdfull_pc/B.n80 25.6005
R2044 pfet_01v8_lvt_W90p63_L0p74_m1__nf1_gboth_sdfull_pc/B.n436 pfet_01v8_lvt_W90p63_L0p74_m1__nf1_gboth_sdfull_pc/B.n80 25.6005
R2045 pfet_01v8_lvt_W90p63_L0p74_m1__nf1_gboth_sdfull_pc/B.n436 pfet_01v8_lvt_W90p63_L0p74_m1__nf1_gboth_sdfull_pc/B.n435 25.6005
R2046 pfet_01v8_lvt_W90p63_L0p74_m1__nf1_gboth_sdfull_pc/B.n435 pfet_01v8_lvt_W90p63_L0p74_m1__nf1_gboth_sdfull_pc/B.n434 25.6005
R2047 pfet_01v8_lvt_W90p63_L0p74_m1__nf1_gboth_sdfull_pc/B.n434 pfet_01v8_lvt_W90p63_L0p74_m1__nf1_gboth_sdfull_pc/B.n82 25.6005
R2048 pfet_01v8_lvt_W90p63_L0p74_m1__nf1_gboth_sdfull_pc/B.n428 pfet_01v8_lvt_W90p63_L0p74_m1__nf1_gboth_sdfull_pc/B.n82 25.6005
R2049 pfet_01v8_lvt_W90p63_L0p74_m1__nf1_gboth_sdfull_pc/B.n428 pfet_01v8_lvt_W90p63_L0p74_m1__nf1_gboth_sdfull_pc/B.n427 25.6005
R2050 pfet_01v8_lvt_W90p63_L0p74_m1__nf1_gboth_sdfull_pc/B.n427 pfet_01v8_lvt_W90p63_L0p74_m1__nf1_gboth_sdfull_pc/B.n426 25.6005
R2051 pfet_01v8_lvt_W90p63_L0p74_m1__nf1_gboth_sdfull_pc/B.n426 pfet_01v8_lvt_W90p63_L0p74_m1__nf1_gboth_sdfull_pc/B.n84 25.6005
R2052 pfet_01v8_lvt_W90p63_L0p74_m1__nf1_gboth_sdfull_pc/B.n421 pfet_01v8_lvt_W90p63_L0p74_m1__nf1_gboth_sdfull_pc/B.n84 25.6005
R2053 pfet_01v8_lvt_W90p63_L0p74_m1__nf1_gboth_sdfull_pc/B.n421 pfet_01v8_lvt_W90p63_L0p74_m1__nf1_gboth_sdfull_pc/B.n420 25.6005
R2054 pfet_01v8_lvt_W90p63_L0p74_m1__nf1_gboth_sdfull_pc/B.n420 pfet_01v8_lvt_W90p63_L0p74_m1__nf1_gboth_sdfull_pc/B.n86 25.6005
R2055 pfet_01v8_lvt_W90p63_L0p74_m1__nf1_gboth_sdfull_pc/B.n416 pfet_01v8_lvt_W90p63_L0p74_m1__nf1_gboth_sdfull_pc/B.n86 25.6005
R2056 pfet_01v8_lvt_W90p63_L0p74_m1__nf1_gboth_sdfull_pc/B.n416 pfet_01v8_lvt_W90p63_L0p74_m1__nf1_gboth_sdfull_pc/B.n415 25.6005
R2057 pfet_01v8_lvt_W90p63_L0p74_m1__nf1_gboth_sdfull_pc/B.n415 pfet_01v8_lvt_W90p63_L0p74_m1__nf1_gboth_sdfull_pc/B.n88 25.6005
R2058 pfet_01v8_lvt_W90p63_L0p74_m1__nf1_gboth_sdfull_pc/B.n410 pfet_01v8_lvt_W90p63_L0p74_m1__nf1_gboth_sdfull_pc/B.n88 25.6005
R2059 pfet_01v8_lvt_W90p63_L0p74_m1__nf1_gboth_sdfull_pc/B.n410 pfet_01v8_lvt_W90p63_L0p74_m1__nf1_gboth_sdfull_pc/B.n409 25.6005
R2060 pfet_01v8_lvt_W90p63_L0p74_m1__nf1_gboth_sdfull_pc/B.n409 pfet_01v8_lvt_W90p63_L0p74_m1__nf1_gboth_sdfull_pc/B.n408 25.6005
R2061 pfet_01v8_lvt_W90p63_L0p74_m1__nf1_gboth_sdfull_pc/B.n408 pfet_01v8_lvt_W90p63_L0p74_m1__nf1_gboth_sdfull_pc/B.n90 25.6005
R2062 pfet_01v8_lvt_W90p63_L0p74_m1__nf1_gboth_sdfull_pc/B.n402 pfet_01v8_lvt_W90p63_L0p74_m1__nf1_gboth_sdfull_pc/B.n90 25.6005
R2063 pfet_01v8_lvt_W90p63_L0p74_m1__nf1_gboth_sdfull_pc/B.n402 pfet_01v8_lvt_W90p63_L0p74_m1__nf1_gboth_sdfull_pc/B.n401 25.6005
R2064 pfet_01v8_lvt_W90p63_L0p74_m1__nf1_gboth_sdfull_pc/B.n401 pfet_01v8_lvt_W90p63_L0p74_m1__nf1_gboth_sdfull_pc/B.n400 25.6005
R2065 pfet_01v8_lvt_W90p63_L0p74_m1__nf1_gboth_sdfull_pc/B.n400 pfet_01v8_lvt_W90p63_L0p74_m1__nf1_gboth_sdfull_pc/B.n92 25.6005
R2066 pfet_01v8_lvt_W90p63_L0p74_m1__nf1_gboth_sdfull_pc/B.n394 pfet_01v8_lvt_W90p63_L0p74_m1__nf1_gboth_sdfull_pc/B.n92 25.6005
R2067 pfet_01v8_lvt_W90p63_L0p74_m1__nf1_gboth_sdfull_pc/B.n394 pfet_01v8_lvt_W90p63_L0p74_m1__nf1_gboth_sdfull_pc/B.n393 25.6005
R2068 pfet_01v8_lvt_W90p63_L0p74_m1__nf1_gboth_sdfull_pc/B.n393 pfet_01v8_lvt_W90p63_L0p74_m1__nf1_gboth_sdfull_pc/B.n392 25.6005
R2069 pfet_01v8_lvt_W90p63_L0p74_m1__nf1_gboth_sdfull_pc/B.n392 pfet_01v8_lvt_W90p63_L0p74_m1__nf1_gboth_sdfull_pc/B.n94 25.6005
R2070 pfet_01v8_lvt_W90p63_L0p74_m1__nf1_gboth_sdfull_pc/B.n387 pfet_01v8_lvt_W90p63_L0p74_m1__nf1_gboth_sdfull_pc/B.n94 25.6005
R2071 pfet_01v8_lvt_W90p63_L0p74_m1__nf1_gboth_sdfull_pc/B.n387 pfet_01v8_lvt_W90p63_L0p74_m1__nf1_gboth_sdfull_pc/B.n386 25.6005
R2072 pfet_01v8_lvt_W90p63_L0p74_m1__nf1_gboth_sdfull_pc/B.n386 pfet_01v8_lvt_W90p63_L0p74_m1__nf1_gboth_sdfull_pc/B.n96 25.6005
R2073 pfet_01v8_lvt_W90p63_L0p74_m1__nf1_gboth_sdfull_pc/B.n381 pfet_01v8_lvt_W90p63_L0p74_m1__nf1_gboth_sdfull_pc/B.n96 25.6005
R2074 pfet_01v8_lvt_W90p63_L0p74_m1__nf1_gboth_sdfull_pc/B.n381 pfet_01v8_lvt_W90p63_L0p74_m1__nf1_gboth_sdfull_pc/B.n380 25.6005
R2075 pfet_01v8_lvt_W90p63_L0p74_m1__nf1_gboth_sdfull_pc/B.n380 pfet_01v8_lvt_W90p63_L0p74_m1__nf1_gboth_sdfull_pc/B.n379 25.6005
R2076 pfet_01v8_lvt_W90p63_L0p74_m1__nf1_gboth_sdfull_pc/B.n379 pfet_01v8_lvt_W90p63_L0p74_m1__nf1_gboth_sdfull_pc/B.n98 25.6005
R2077 pfet_01v8_lvt_W90p63_L0p74_m1__nf1_gboth_sdfull_pc/B.n373 pfet_01v8_lvt_W90p63_L0p74_m1__nf1_gboth_sdfull_pc/B.n98 25.6005
R2078 pfet_01v8_lvt_W90p63_L0p74_m1__nf1_gboth_sdfull_pc/B.n373 pfet_01v8_lvt_W90p63_L0p74_m1__nf1_gboth_sdfull_pc/B.n372 25.6005
R2079 pfet_01v8_lvt_W90p63_L0p74_m1__nf1_gboth_sdfull_pc/B.n372 pfet_01v8_lvt_W90p63_L0p74_m1__nf1_gboth_sdfull_pc/B.n371 25.6005
R2080 pfet_01v8_lvt_W90p63_L0p74_m1__nf1_gboth_sdfull_pc/B.n371 pfet_01v8_lvt_W90p63_L0p74_m1__nf1_gboth_sdfull_pc/B.n100 25.6005
R2081 pfet_01v8_lvt_W90p63_L0p74_m1__nf1_gboth_sdfull_pc/B.n365 pfet_01v8_lvt_W90p63_L0p74_m1__nf1_gboth_sdfull_pc/B.n100 25.6005
R2082 pfet_01v8_lvt_W90p63_L0p74_m1__nf1_gboth_sdfull_pc/B.n365 pfet_01v8_lvt_W90p63_L0p74_m1__nf1_gboth_sdfull_pc/B.n364 25.6005
R2083 pfet_01v8_lvt_W90p63_L0p74_m1__nf1_gboth_sdfull_pc/B.n364 pfet_01v8_lvt_W90p63_L0p74_m1__nf1_gboth_sdfull_pc/B.n363 25.6005
R2084 pfet_01v8_lvt_W90p63_L0p74_m1__nf1_gboth_sdfull_pc/B.n363 pfet_01v8_lvt_W90p63_L0p74_m1__nf1_gboth_sdfull_pc/B.n102 25.6005
R2085 pfet_01v8_lvt_W90p63_L0p74_m1__nf1_gboth_sdfull_pc/B.n357 pfet_01v8_lvt_W90p63_L0p74_m1__nf1_gboth_sdfull_pc/B.n102 25.6005
R2086 pfet_01v8_lvt_W90p63_L0p74_m1__nf1_gboth_sdfull_pc/B.n357 pfet_01v8_lvt_W90p63_L0p74_m1__nf1_gboth_sdfull_pc/B.n356 25.6005
R2087 pfet_01v8_lvt_W90p63_L0p74_m1__nf1_gboth_sdfull_pc/B.n356 pfet_01v8_lvt_W90p63_L0p74_m1__nf1_gboth_sdfull_pc/B.n355 25.6005
R2088 pfet_01v8_lvt_W90p63_L0p74_m1__nf1_gboth_sdfull_pc/B.n355 pfet_01v8_lvt_W90p63_L0p74_m1__nf1_gboth_sdfull_pc/B.n104 25.6005
R2089 pfet_01v8_lvt_W90p63_L0p74_m1__nf1_gboth_sdfull_pc/B.n349 pfet_01v8_lvt_W90p63_L0p74_m1__nf1_gboth_sdfull_pc/B.n104 25.6005
R2090 pfet_01v8_lvt_W90p63_L0p74_m1__nf1_gboth_sdfull_pc/B.n349 pfet_01v8_lvt_W90p63_L0p74_m1__nf1_gboth_sdfull_pc/B.n348 25.6005
R2091 pfet_01v8_lvt_W90p63_L0p74_m1__nf1_gboth_sdfull_pc/B.n348 pfet_01v8_lvt_W90p63_L0p74_m1__nf1_gboth_sdfull_pc/B.n347 25.6005
R2092 pfet_01v8_lvt_W90p63_L0p74_m1__nf1_gboth_sdfull_pc/B.n347 pfet_01v8_lvt_W90p63_L0p74_m1__nf1_gboth_sdfull_pc/B.n106 25.6005
R2093 pfet_01v8_lvt_W90p63_L0p74_m1__nf1_gboth_sdfull_pc/B.n341 pfet_01v8_lvt_W90p63_L0p74_m1__nf1_gboth_sdfull_pc/B.n106 25.6005
R2094 pfet_01v8_lvt_W90p63_L0p74_m1__nf1_gboth_sdfull_pc/B.n341 pfet_01v8_lvt_W90p63_L0p74_m1__nf1_gboth_sdfull_pc/B.n340 25.6005
R2095 pfet_01v8_lvt_W90p63_L0p74_m1__nf1_gboth_sdfull_pc/B.n340 pfet_01v8_lvt_W90p63_L0p74_m1__nf1_gboth_sdfull_pc/B.n339 25.6005
R2096 pfet_01v8_lvt_W90p63_L0p74_m1__nf1_gboth_sdfull_pc/B.n339 pfet_01v8_lvt_W90p63_L0p74_m1__nf1_gboth_sdfull_pc/B.n108 25.6005
R2097 pfet_01v8_lvt_W90p63_L0p74_m1__nf1_gboth_sdfull_pc/B.n333 pfet_01v8_lvt_W90p63_L0p74_m1__nf1_gboth_sdfull_pc/B.n108 25.6005
R2098 pfet_01v8_lvt_W90p63_L0p74_m1__nf1_gboth_sdfull_pc/B.n333 pfet_01v8_lvt_W90p63_L0p74_m1__nf1_gboth_sdfull_pc/B.n332 25.6005
R2099 pfet_01v8_lvt_W90p63_L0p74_m1__nf1_gboth_sdfull_pc/B.n332 pfet_01v8_lvt_W90p63_L0p74_m1__nf1_gboth_sdfull_pc/B.n331 25.6005
R2100 pfet_01v8_lvt_W90p63_L0p74_m1__nf1_gboth_sdfull_pc/B.n331 pfet_01v8_lvt_W90p63_L0p74_m1__nf1_gboth_sdfull_pc/B.n110 25.6005
R2101 pfet_01v8_lvt_W90p63_L0p74_m1__nf1_gboth_sdfull_pc/B.n326 pfet_01v8_lvt_W90p63_L0p74_m1__nf1_gboth_sdfull_pc/B.n110 25.6005
R2102 pfet_01v8_lvt_W90p63_L0p74_m1__nf1_gboth_sdfull_pc/B.n326 pfet_01v8_lvt_W90p63_L0p74_m1__nf1_gboth_sdfull_pc/B.n325 25.6005
R2103 pfet_01v8_lvt_W90p63_L0p74_m1__nf1_gboth_sdfull_pc/B.n325 pfet_01v8_lvt_W90p63_L0p74_m1__nf1_gboth_sdfull_pc/B.n112 25.6005
R2104 pfet_01v8_lvt_W90p63_L0p74_m1__nf1_gboth_sdfull_pc/B.n320 pfet_01v8_lvt_W90p63_L0p74_m1__nf1_gboth_sdfull_pc/B.n112 25.6005
R2105 pfet_01v8_lvt_W90p63_L0p74_m1__nf1_gboth_sdfull_pc/B.n320 pfet_01v8_lvt_W90p63_L0p74_m1__nf1_gboth_sdfull_pc/B.n319 25.6005
R2106 pfet_01v8_lvt_W90p63_L0p74_m1__nf1_gboth_sdfull_pc/B.n319 pfet_01v8_lvt_W90p63_L0p74_m1__nf1_gboth_sdfull_pc/B.n318 25.6005
R2107 pfet_01v8_lvt_W90p63_L0p74_m1__nf1_gboth_sdfull_pc/B.n318 pfet_01v8_lvt_W90p63_L0p74_m1__nf1_gboth_sdfull_pc/B.n114 25.6005
R2108 pfet_01v8_lvt_W90p63_L0p74_m1__nf1_gboth_sdfull_pc/B.n313 pfet_01v8_lvt_W90p63_L0p74_m1__nf1_gboth_sdfull_pc/B.n114 25.6005
R2109 pfet_01v8_lvt_W90p63_L0p74_m1__nf1_gboth_sdfull_pc/B.n313 pfet_01v8_lvt_W90p63_L0p74_m1__nf1_gboth_sdfull_pc/B.n312 25.6005
R2110 pfet_01v8_lvt_W90p63_L0p74_m1__nf1_gboth_sdfull_pc/B.n312 pfet_01v8_lvt_W90p63_L0p74_m1__nf1_gboth_sdfull_pc/B.n116 25.6005
R2111 pfet_01v8_lvt_W90p63_L0p74_m1__nf1_gboth_sdfull_pc/B.n307 pfet_01v8_lvt_W90p63_L0p74_m1__nf1_gboth_sdfull_pc/B.n116 25.6005
R2112 pfet_01v8_lvt_W90p63_L0p74_m1__nf1_gboth_sdfull_pc/B.n307 pfet_01v8_lvt_W90p63_L0p74_m1__nf1_gboth_sdfull_pc/B.n306 25.6005
R2113 pfet_01v8_lvt_W90p63_L0p74_m1__nf1_gboth_sdfull_pc/B.n306 pfet_01v8_lvt_W90p63_L0p74_m1__nf1_gboth_sdfull_pc/B.n305 25.6005
R2114 pfet_01v8_lvt_W90p63_L0p74_m1__nf1_gboth_sdfull_pc/B.n305 pfet_01v8_lvt_W90p63_L0p74_m1__nf1_gboth_sdfull_pc/B.n118 25.6005
R2115 pfet_01v8_lvt_W90p63_L0p74_m1__nf1_gboth_sdfull_pc/B.n299 pfet_01v8_lvt_W90p63_L0p74_m1__nf1_gboth_sdfull_pc/B.n118 25.6005
R2116 pfet_01v8_lvt_W90p63_L0p74_m1__nf1_gboth_sdfull_pc/B.n299 pfet_01v8_lvt_W90p63_L0p74_m1__nf1_gboth_sdfull_pc/B.n298 25.6005
R2117 pfet_01v8_lvt_W90p63_L0p74_m1__nf1_gboth_sdfull_pc/B.n298 pfet_01v8_lvt_W90p63_L0p74_m1__nf1_gboth_sdfull_pc/B.n297 25.6005
R2118 pfet_01v8_lvt_W90p63_L0p74_m1__nf1_gboth_sdfull_pc/B.n297 pfet_01v8_lvt_W90p63_L0p74_m1__nf1_gboth_sdfull_pc/B.n120 25.6005
R2119 pfet_01v8_lvt_W90p63_L0p74_m1__nf1_gboth_sdfull_pc/B.n292 pfet_01v8_lvt_W90p63_L0p74_m1__nf1_gboth_sdfull_pc/B.n120 25.6005
R2120 pfet_01v8_lvt_W90p63_L0p74_m1__nf1_gboth_sdfull_pc/B.n292 pfet_01v8_lvt_W90p63_L0p74_m1__nf1_gboth_sdfull_pc/B.n291 25.6005
R2121 pfet_01v8_lvt_W90p63_L0p74_m1__nf1_gboth_sdfull_pc/B.n291 pfet_01v8_lvt_W90p63_L0p74_m1__nf1_gboth_sdfull_pc/B.n122 25.6005
R2122 pfet_01v8_lvt_W90p63_L0p74_m1__nf1_gboth_sdfull_pc/B.n123 pfet_01v8_lvt_W90p63_L0p74_m1__nf1_gboth_sdfull_pc/B.n122 25.6005
R2123 pfet_01v8_lvt_W90p63_L0p74_m1__nf1_gboth_sdfull_pc/B.n285 pfet_01v8_lvt_W90p63_L0p74_m1__nf1_gboth_sdfull_pc/B.n123 25.6005
R2124 pfet_01v8_lvt_W90p63_L0p74_m1__nf1_gboth_sdfull_pc/B.n285 pfet_01v8_lvt_W90p63_L0p74_m1__nf1_gboth_sdfull_pc/B.n284 25.6005
R2125 pfet_01v8_lvt_W90p63_L0p74_m1__nf1_gboth_sdfull_pc/B.n284 pfet_01v8_lvt_W90p63_L0p74_m1__nf1_gboth_sdfull_pc/B.n283 25.6005
R2126 pfet_01v8_lvt_W90p63_L0p74_m1__nf1_gboth_sdfull_pc/B.n283 pfet_01v8_lvt_W90p63_L0p74_m1__nf1_gboth_sdfull_pc/B.n125 25.6005
R2127 pfet_01v8_lvt_W90p63_L0p74_m1__nf1_gboth_sdfull_pc/B.n277 pfet_01v8_lvt_W90p63_L0p74_m1__nf1_gboth_sdfull_pc/B.n125 25.6005
R2128 pfet_01v8_lvt_W90p63_L0p74_m1__nf1_gboth_sdfull_pc/B.n277 pfet_01v8_lvt_W90p63_L0p74_m1__nf1_gboth_sdfull_pc/B.n276 25.6005
R2129 pfet_01v8_lvt_W90p63_L0p74_m1__nf1_gboth_sdfull_pc/B.n276 pfet_01v8_lvt_W90p63_L0p74_m1__nf1_gboth_sdfull_pc/B.n275 25.6005
R2130 pfet_01v8_lvt_W90p63_L0p74_m1__nf1_gboth_sdfull_pc/B.n275 pfet_01v8_lvt_W90p63_L0p74_m1__nf1_gboth_sdfull_pc/B.n127 25.6005
R2131 pfet_01v8_lvt_W90p63_L0p74_m1__nf1_gboth_sdfull_pc/B.n269 pfet_01v8_lvt_W90p63_L0p74_m1__nf1_gboth_sdfull_pc/B.n127 25.6005
R2132 pfet_01v8_lvt_W90p63_L0p74_m1__nf1_gboth_sdfull_pc/B.n269 pfet_01v8_lvt_W90p63_L0p74_m1__nf1_gboth_sdfull_pc/B.n268 25.6005
R2133 pfet_01v8_lvt_W90p63_L0p74_m1__nf1_gboth_sdfull_pc/B.n268 pfet_01v8_lvt_W90p63_L0p74_m1__nf1_gboth_sdfull_pc/B.n267 25.6005
R2134 pfet_01v8_lvt_W90p63_L0p74_m1__nf1_gboth_sdfull_pc/B.n267 pfet_01v8_lvt_W90p63_L0p74_m1__nf1_gboth_sdfull_pc/B.n129 25.6005
R2135 pfet_01v8_lvt_W90p63_L0p74_m1__nf1_gboth_sdfull_pc/B.n261 pfet_01v8_lvt_W90p63_L0p74_m1__nf1_gboth_sdfull_pc/B.n129 25.6005
R2136 pfet_01v8_lvt_W90p63_L0p74_m1__nf1_gboth_sdfull_pc/B.n261 pfet_01v8_lvt_W90p63_L0p74_m1__nf1_gboth_sdfull_pc/B.n260 25.6005
R2137 pfet_01v8_lvt_W90p63_L0p74_m1__nf1_gboth_sdfull_pc/B.n260 pfet_01v8_lvt_W90p63_L0p74_m1__nf1_gboth_sdfull_pc/B.n259 25.6005
R2138 pfet_01v8_lvt_W90p63_L0p74_m1__nf1_gboth_sdfull_pc/B.n259 pfet_01v8_lvt_W90p63_L0p74_m1__nf1_gboth_sdfull_pc/B.n131 25.6005
R2139 pfet_01v8_lvt_W90p63_L0p74_m1__nf1_gboth_sdfull_pc/B.n253 pfet_01v8_lvt_W90p63_L0p74_m1__nf1_gboth_sdfull_pc/B.n131 25.6005
R2140 pfet_01v8_lvt_W90p63_L0p74_m1__nf1_gboth_sdfull_pc/B.n253 pfet_01v8_lvt_W90p63_L0p74_m1__nf1_gboth_sdfull_pc/B.n252 25.6005
R2141 pfet_01v8_lvt_W90p63_L0p74_m1__nf1_gboth_sdfull_pc/B.n252 pfet_01v8_lvt_W90p63_L0p74_m1__nf1_gboth_sdfull_pc/B.n251 25.6005
R2142 pfet_01v8_lvt_W90p63_L0p74_m1__nf1_gboth_sdfull_pc/B.n251 pfet_01v8_lvt_W90p63_L0p74_m1__nf1_gboth_sdfull_pc/B.n133 25.6005
R2143 pfet_01v8_lvt_W90p63_L0p74_m1__nf1_gboth_sdfull_pc/B.n245 pfet_01v8_lvt_W90p63_L0p74_m1__nf1_gboth_sdfull_pc/B.n133 25.6005
R2144 pfet_01v8_lvt_W90p63_L0p74_m1__nf1_gboth_sdfull_pc/B.n245 pfet_01v8_lvt_W90p63_L0p74_m1__nf1_gboth_sdfull_pc/B.n244 25.6005
R2145 pfet_01v8_lvt_W90p63_L0p74_m1__nf1_gboth_sdfull_pc/B.n244 pfet_01v8_lvt_W90p63_L0p74_m1__nf1_gboth_sdfull_pc/B.n243 25.6005
R2146 pfet_01v8_lvt_W90p63_L0p74_m1__nf1_gboth_sdfull_pc/B.n243 pfet_01v8_lvt_W90p63_L0p74_m1__nf1_gboth_sdfull_pc/B.n135 25.6005
R2147 pfet_01v8_lvt_W90p63_L0p74_m1__nf1_gboth_sdfull_pc/B.n237 pfet_01v8_lvt_W90p63_L0p74_m1__nf1_gboth_sdfull_pc/B.n135 25.6005
R2148 pfet_01v8_lvt_W90p63_L0p74_m1__nf1_gboth_sdfull_pc/B.n237 pfet_01v8_lvt_W90p63_L0p74_m1__nf1_gboth_sdfull_pc/B.n236 25.6005
R2149 pfet_01v8_lvt_W90p63_L0p74_m1__nf1_gboth_sdfull_pc/B.n236 pfet_01v8_lvt_W90p63_L0p74_m1__nf1_gboth_sdfull_pc/B.n235 25.6005
R2150 pfet_01v8_lvt_W90p63_L0p74_m1__nf1_gboth_sdfull_pc/B.n235 pfet_01v8_lvt_W90p63_L0p74_m1__nf1_gboth_sdfull_pc/B.n137 25.6005
R2151 pfet_01v8_lvt_W90p63_L0p74_m1__nf1_gboth_sdfull_pc/B.n229 pfet_01v8_lvt_W90p63_L0p74_m1__nf1_gboth_sdfull_pc/B.n137 25.6005
R2152 pfet_01v8_lvt_W90p63_L0p74_m1__nf1_gboth_sdfull_pc/B.n229 pfet_01v8_lvt_W90p63_L0p74_m1__nf1_gboth_sdfull_pc/B.n228 25.6005
R2153 pfet_01v8_lvt_W90p63_L0p74_m1__nf1_gboth_sdfull_pc/B.n228 pfet_01v8_lvt_W90p63_L0p74_m1__nf1_gboth_sdfull_pc/B.n227 25.6005
R2154 pfet_01v8_lvt_W90p63_L0p74_m1__nf1_gboth_sdfull_pc/B.n227 pfet_01v8_lvt_W90p63_L0p74_m1__nf1_gboth_sdfull_pc/B.n139 25.6005
R2155 pfet_01v8_lvt_W90p63_L0p74_m1__nf1_gboth_sdfull_pc/B.n221 pfet_01v8_lvt_W90p63_L0p74_m1__nf1_gboth_sdfull_pc/B.n139 25.6005
R2156 pfet_01v8_lvt_W90p63_L0p74_m1__nf1_gboth_sdfull_pc/B.n221 pfet_01v8_lvt_W90p63_L0p74_m1__nf1_gboth_sdfull_pc/B.n220 25.6005
R2157 pfet_01v8_lvt_W90p63_L0p74_m1__nf1_gboth_sdfull_pc/B.n220 pfet_01v8_lvt_W90p63_L0p74_m1__nf1_gboth_sdfull_pc/B.n219 25.6005
R2158 pfet_01v8_lvt_W90p63_L0p74_m1__nf1_gboth_sdfull_pc/B.n219 pfet_01v8_lvt_W90p63_L0p74_m1__nf1_gboth_sdfull_pc/B.n141 25.6005
R2159 pfet_01v8_lvt_W90p63_L0p74_m1__nf1_gboth_sdfull_pc/B.n213 pfet_01v8_lvt_W90p63_L0p74_m1__nf1_gboth_sdfull_pc/B.n141 25.6005
R2160 pfet_01v8_lvt_W90p63_L0p74_m1__nf1_gboth_sdfull_pc/B.n213 pfet_01v8_lvt_W90p63_L0p74_m1__nf1_gboth_sdfull_pc/B.n212 25.6005
R2161 pfet_01v8_lvt_W90p63_L0p74_m1__nf1_gboth_sdfull_pc/B.n212 pfet_01v8_lvt_W90p63_L0p74_m1__nf1_gboth_sdfull_pc/B.n211 25.6005
R2162 pfet_01v8_lvt_W90p63_L0p74_m1__nf1_gboth_sdfull_pc/B.n211 pfet_01v8_lvt_W90p63_L0p74_m1__nf1_gboth_sdfull_pc/B.n143 25.6005
R2163 pfet_01v8_lvt_W90p63_L0p74_m1__nf1_gboth_sdfull_pc/B.n206 pfet_01v8_lvt_W90p63_L0p74_m1__nf1_gboth_sdfull_pc/B.n143 25.6005
R2164 pfet_01v8_lvt_W90p63_L0p74_m1__nf1_gboth_sdfull_pc/B.n206 pfet_01v8_lvt_W90p63_L0p74_m1__nf1_gboth_sdfull_pc/B.n205 25.6005
R2165 pfet_01v8_lvt_W90p63_L0p74_m1__nf1_gboth_sdfull_pc/B.n205 pfet_01v8_lvt_W90p63_L0p74_m1__nf1_gboth_sdfull_pc/B.n145 25.6005
R2166 pfet_01v8_lvt_W90p63_L0p74_m1__nf1_gboth_sdfull_pc/B.n200 pfet_01v8_lvt_W90p63_L0p74_m1__nf1_gboth_sdfull_pc/B.n145 25.6005
R2167 pfet_01v8_lvt_W90p63_L0p74_m1__nf1_gboth_sdfull_pc/B.n200 pfet_01v8_lvt_W90p63_L0p74_m1__nf1_gboth_sdfull_pc/B.n199 25.6005
R2168 pfet_01v8_lvt_W90p63_L0p74_m1__nf1_gboth_sdfull_pc/B.n199 pfet_01v8_lvt_W90p63_L0p74_m1__nf1_gboth_sdfull_pc/B.n198 25.6005
R2169 pfet_01v8_lvt_W90p63_L0p74_m1__nf1_gboth_sdfull_pc/B.n198 pfet_01v8_lvt_W90p63_L0p74_m1__nf1_gboth_sdfull_pc/B.n147 25.6005
R2170 pfet_01v8_lvt_W90p63_L0p74_m1__nf1_gboth_sdfull_pc/B.n192 pfet_01v8_lvt_W90p63_L0p74_m1__nf1_gboth_sdfull_pc/B.n147 25.6005
R2171 pfet_01v8_lvt_W90p63_L0p74_m1__nf1_gboth_sdfull_pc/B.n192 pfet_01v8_lvt_W90p63_L0p74_m1__nf1_gboth_sdfull_pc/B.n191 25.6005
R2172 pfet_01v8_lvt_W90p63_L0p74_m1__nf1_gboth_sdfull_pc/B.n191 pfet_01v8_lvt_W90p63_L0p74_m1__nf1_gboth_sdfull_pc/B.n190 25.6005
R2173 pfet_01v8_lvt_W90p63_L0p74_m1__nf1_gboth_sdfull_pc/B.n190 pfet_01v8_lvt_W90p63_L0p74_m1__nf1_gboth_sdfull_pc/B.n149 25.6005
R2174 pfet_01v8_lvt_W90p63_L0p74_m1__nf1_gboth_sdfull_pc/B.n184 pfet_01v8_lvt_W90p63_L0p74_m1__nf1_gboth_sdfull_pc/B.n149 25.6005
R2175 pfet_01v8_lvt_W90p63_L0p74_m1__nf1_gboth_sdfull_pc/B.n184 pfet_01v8_lvt_W90p63_L0p74_m1__nf1_gboth_sdfull_pc/B.n183 25.6005
R2176 pfet_01v8_lvt_W90p63_L0p74_m1__nf1_gboth_sdfull_pc/B.n183 pfet_01v8_lvt_W90p63_L0p74_m1__nf1_gboth_sdfull_pc/B.n182 25.6005
R2177 pfet_01v8_lvt_W90p63_L0p74_m1__nf1_gboth_sdfull_pc/B.n182 pfet_01v8_lvt_W90p63_L0p74_m1__nf1_gboth_sdfull_pc/B.n151 25.6005
R2178 pfet_01v8_lvt_W90p63_L0p74_m1__nf1_gboth_sdfull_pc/B.n177 pfet_01v8_lvt_W90p63_L0p74_m1__nf1_gboth_sdfull_pc/B.n151 25.6005
R2179 pfet_01v8_lvt_W90p63_L0p74_m1__nf1_gboth_sdfull_pc/B.n177 pfet_01v8_lvt_W90p63_L0p74_m1__nf1_gboth_sdfull_pc/B.n176 25.6005
R2180 pfet_01v8_lvt_W90p63_L0p74_m1__nf1_gboth_sdfull_pc/B.n176 pfet_01v8_lvt_W90p63_L0p74_m1__nf1_gboth_sdfull_pc/B.n153 25.6005
R2181 pfet_01v8_lvt_W90p63_L0p74_m1__nf1_gboth_sdfull_pc/B.n172 pfet_01v8_lvt_W90p63_L0p74_m1__nf1_gboth_sdfull_pc/B.n153 25.6005
R2182 pfet_01v8_lvt_W90p63_L0p74_m1__nf1_gboth_sdfull_pc/B.n172 pfet_01v8_lvt_W90p63_L0p74_m1__nf1_gboth_sdfull_pc/B.n171 25.6005
R2183 pfet_01v8_lvt_W90p63_L0p74_m1__nf1_gboth_sdfull_pc/B.n171 pfet_01v8_lvt_W90p63_L0p74_m1__nf1_gboth_sdfull_pc/B.n155 25.6005
R2184 pfet_01v8_lvt_W90p63_L0p74_m1__nf1_gboth_sdfull_pc/B.n167 pfet_01v8_lvt_W90p63_L0p74_m1__nf1_gboth_sdfull_pc/B.n155 25.6005
R2185 pfet_01v8_lvt_W90p63_L0p74_m1__nf1_gboth_sdfull_pc/B.n167 pfet_01v8_lvt_W90p63_L0p74_m1__nf1_gboth_sdfull_pc/B.n166 25.6005
R2186 pfet_01v8_lvt_W90p63_L0p74_m1__nf1_gboth_sdfull_pc/B.n166 pfet_01v8_lvt_W90p63_L0p74_m1__nf1_gboth_sdfull_pc/B.n157 25.6005
R2187 pfet_01v8_lvt_W90p63_L0p74_m1__nf1_gboth_sdfull_pc/B.n161 pfet_01v8_lvt_W90p63_L0p74_m1__nf1_gboth_sdfull_pc/B.n157 25.6005
R2188 pfet_01v8_lvt_W90p63_L0p74_m1__nf1_gboth_sdfull_pc/B.n161 pfet_01v8_lvt_W90p63_L0p74_m1__nf1_gboth_sdfull_pc/B.n160 25.6005
R2189 pfet_01v8_lvt_W90p63_L0p74_m1__nf1_gboth_sdfull_pc/B.n160 pfet_01v8_lvt_W90p63_L0p74_m1__nf1_gboth_sdfull_pc/B.n7 25.6005
R2190 B pfet_01v8_lvt_W90p63_L0p74_m1__nf1_gboth_sdfull_pc/B.n0 12.8005
R2191 B pfet_01v8_lvt_W90p63_L0p74_m1__nf1_gboth_sdfull_pc/B.n1334 6.4005
R2192 pfet_01v8_lvt_W90p63_L0p74_m1__nf1_gboth_sdfull_pc/B.n1325 pfet_01v8_lvt_W90p63_L0p74_m1__nf1_gboth_sdfull_pc/B.n4 5.88555
R2193 pfet_01v8_lvt_W90p63_L0p74_m1__nf1_gboth_sdfull_pc/B.n669 pfet_01v8_lvt_W90p63_L0p74_m1__nf1_gboth_sdfull_pc/B.n9 5.88555
R2194 pfet_01v8_lvt_W90p63_L0p74_m1__nf1_gboth_sdfull_pc/B.n1332 pfet_01v8_lvt_W90p63_L0p74_m1__nf1_gboth_sdfull_pc/B.n4 3.48035
R2195 pfet_01v8_lvt_W90p63_L0p74_m1__nf1_gboth_sdfull_pc/B.n669 pfet_01v8_lvt_W90p63_L0p74_m1__nf1_gboth_sdfull_pc/B.n668 3.48035
R2196 pfet_01v8_lvt_W90p63_L0p74_m1__nf1_gboth_sdfull_pc/B.n1332 pfet_01v8_lvt_W90p63_L0p74_m1__nf1_gboth_sdfull_pc/B.t0 1.74043
R2197 pfet_01v8_lvt_W90p63_L0p74_m1__nf1_gboth_sdfull_pc/B.n668 pfet_01v8_lvt_W90p63_L0p74_m1__nf1_gboth_sdfull_pc/B.t0 1.74043
R2198 B.n1360 B.n8 758.823
R2199 B.n1363 B.n1362 758.823
R2200 B.n555 B.n542 758.823
R2201 B.n553 B.n544 758.823
R2202 B.n1360 B.n6 240
R2203 B.n1354 B.n6 240
R2204 B.n1354 B.n10 240
R2205 B.n1345 B.n10 240
R2206 B.n1345 B.n16 240
R2207 B.n1341 B.n16 240
R2208 B.n1341 B.n18 240
R2209 B.n1333 B.n18 240
R2210 B.n1333 B.n24 240
R2211 B.n1329 B.n24 240
R2212 B.n1329 B.n26 240
R2213 B.n1321 B.n26 240
R2214 B.n1321 B.n32 240
R2215 B.n1317 B.n32 240
R2216 B.n1317 B.n34 240
R2217 B.n1309 B.n34 240
R2218 B.n1309 B.n40 240
R2219 B.n1305 B.n40 240
R2220 B.n1305 B.n42 240
R2221 B.n1297 B.n42 240
R2222 B.n1297 B.n48 240
R2223 B.n1293 B.n48 240
R2224 B.n1293 B.n50 240
R2225 B.n1285 B.n50 240
R2226 B.n1285 B.n56 240
R2227 B.n1281 B.n56 240
R2228 B.n1281 B.n58 240
R2229 B.n1273 B.n58 240
R2230 B.n1273 B.n64 240
R2231 B.n1269 B.n64 240
R2232 B.n1269 B.n66 240
R2233 B.n1261 B.n66 240
R2234 B.n1261 B.n72 240
R2235 B.n1257 B.n72 240
R2236 B.n1257 B.n74 240
R2237 B.n1249 B.n74 240
R2238 B.n1249 B.n80 240
R2239 B.n1245 B.n80 240
R2240 B.n1245 B.n82 240
R2241 B.n1237 B.n82 240
R2242 B.n1237 B.n88 240
R2243 B.n1233 B.n88 240
R2244 B.n1233 B.n90 240
R2245 B.n1225 B.n90 240
R2246 B.n1225 B.n96 240
R2247 B.n1221 B.n96 240
R2248 B.n1221 B.n98 240
R2249 B.n1213 B.n98 240
R2250 B.n1213 B.n104 240
R2251 B.n1209 B.n104 240
R2252 B.n1209 B.n106 240
R2253 B.n1201 B.n106 240
R2254 B.n1201 B.n112 240
R2255 B.n1197 B.n112 240
R2256 B.n1197 B.n114 240
R2257 B.n1189 B.n114 240
R2258 B.n1189 B.n120 240
R2259 B.n1185 B.n120 240
R2260 B.n1185 B.n122 240
R2261 B.n1177 B.n122 240
R2262 B.n1177 B.n128 240
R2263 B.n1173 B.n128 240
R2264 B.n1173 B.n130 240
R2265 B.n1165 B.n130 240
R2266 B.n1165 B.n136 240
R2267 B.n1161 B.n136 240
R2268 B.n1161 B.n138 240
R2269 B.n1153 B.n138 240
R2270 B.n1153 B.n144 240
R2271 B.n1149 B.n144 240
R2272 B.n1149 B.n146 240
R2273 B.n1141 B.n146 240
R2274 B.n1141 B.n152 240
R2275 B.n1137 B.n152 240
R2276 B.n1137 B.n154 240
R2277 B.n1129 B.n154 240
R2278 B.n1129 B.n160 240
R2279 B.n1125 B.n160 240
R2280 B.n1125 B.n162 240
R2281 B.n1117 B.n162 240
R2282 B.n1117 B.n168 240
R2283 B.n1113 B.n168 240
R2284 B.n1113 B.n170 240
R2285 B.n1105 B.n170 240
R2286 B.n1105 B.n176 240
R2287 B.n1101 B.n176 240
R2288 B.n1101 B.n178 240
R2289 B.n1093 B.n178 240
R2290 B.n1093 B.n184 240
R2291 B.n1089 B.n184 240
R2292 B.n1089 B.n186 240
R2293 B.n1081 B.n186 240
R2294 B.n1081 B.n192 240
R2295 B.n1077 B.n192 240
R2296 B.n1077 B.n194 240
R2297 B.n1069 B.n194 240
R2298 B.n1069 B.n200 240
R2299 B.n1065 B.n200 240
R2300 B.n1065 B.n202 240
R2301 B.n1057 B.n202 240
R2302 B.n1057 B.n208 240
R2303 B.n1053 B.n208 240
R2304 B.n1053 B.n210 240
R2305 B.n1045 B.n210 240
R2306 B.n1045 B.n216 240
R2307 B.n1041 B.n216 240
R2308 B.n1041 B.n218 240
R2309 B.n1033 B.n218 240
R2310 B.n1033 B.n224 240
R2311 B.n1029 B.n224 240
R2312 B.n1029 B.n226 240
R2313 B.n1021 B.n226 240
R2314 B.n1021 B.n232 240
R2315 B.n1017 B.n232 240
R2316 B.n1017 B.n234 240
R2317 B.n1009 B.n234 240
R2318 B.n1009 B.n240 240
R2319 B.n1005 B.n240 240
R2320 B.n1005 B.n242 240
R2321 B.n997 B.n242 240
R2322 B.n997 B.n248 240
R2323 B.n993 B.n248 240
R2324 B.n993 B.n250 240
R2325 B.n985 B.n250 240
R2326 B.n985 B.n256 240
R2327 B.n981 B.n256 240
R2328 B.n981 B.n258 240
R2329 B.n973 B.n258 240
R2330 B.n973 B.n264 240
R2331 B.n969 B.n264 240
R2332 B.n969 B.n266 240
R2333 B.n961 B.n266 240
R2334 B.n961 B.n272 240
R2335 B.n957 B.n272 240
R2336 B.n957 B.n274 240
R2337 B.n949 B.n274 240
R2338 B.n949 B.n280 240
R2339 B.n945 B.n280 240
R2340 B.n945 B.n282 240
R2341 B.n937 B.n282 240
R2342 B.n937 B.n288 240
R2343 B.n933 B.n288 240
R2344 B.n933 B.n290 240
R2345 B.n925 B.n290 240
R2346 B.n925 B.n296 240
R2347 B.n921 B.n296 240
R2348 B.n921 B.n298 240
R2349 B.n913 B.n298 240
R2350 B.n913 B.n304 240
R2351 B.n909 B.n304 240
R2352 B.n909 B.n306 240
R2353 B.n901 B.n306 240
R2354 B.n901 B.n312 240
R2355 B.n897 B.n312 240
R2356 B.n897 B.n314 240
R2357 B.n889 B.n314 240
R2358 B.n889 B.n320 240
R2359 B.n885 B.n320 240
R2360 B.n885 B.n322 240
R2361 B.n877 B.n322 240
R2362 B.n877 B.n328 240
R2363 B.n873 B.n328 240
R2364 B.n873 B.n330 240
R2365 B.n865 B.n330 240
R2366 B.n865 B.n336 240
R2367 B.n861 B.n336 240
R2368 B.n861 B.n338 240
R2369 B.n853 B.n338 240
R2370 B.n853 B.n344 240
R2371 B.n849 B.n344 240
R2372 B.n849 B.n346 240
R2373 B.n841 B.n346 240
R2374 B.n841 B.n352 240
R2375 B.n837 B.n352 240
R2376 B.n837 B.n354 240
R2377 B.n829 B.n354 240
R2378 B.n829 B.n360 240
R2379 B.n825 B.n360 240
R2380 B.n825 B.n362 240
R2381 B.n817 B.n362 240
R2382 B.n817 B.n368 240
R2383 B.n813 B.n368 240
R2384 B.n813 B.n370 240
R2385 B.n805 B.n370 240
R2386 B.n805 B.n376 240
R2387 B.n801 B.n376 240
R2388 B.n801 B.n378 240
R2389 B.n793 B.n378 240
R2390 B.n793 B.n384 240
R2391 B.n789 B.n384 240
R2392 B.n789 B.n386 240
R2393 B.n781 B.n386 240
R2394 B.n781 B.n392 240
R2395 B.n777 B.n392 240
R2396 B.n777 B.n394 240
R2397 B.n769 B.n394 240
R2398 B.n769 B.n400 240
R2399 B.n765 B.n400 240
R2400 B.n765 B.n402 240
R2401 B.n757 B.n402 240
R2402 B.n757 B.n408 240
R2403 B.n753 B.n408 240
R2404 B.n753 B.n410 240
R2405 B.n745 B.n410 240
R2406 B.n745 B.n416 240
R2407 B.n741 B.n416 240
R2408 B.n741 B.n418 240
R2409 B.n733 B.n418 240
R2410 B.n733 B.n424 240
R2411 B.n729 B.n424 240
R2412 B.n729 B.n426 240
R2413 B.n721 B.n426 240
R2414 B.n721 B.n432 240
R2415 B.n717 B.n432 240
R2416 B.n717 B.n434 240
R2417 B.n709 B.n434 240
R2418 B.n709 B.n440 240
R2419 B.n705 B.n440 240
R2420 B.n705 B.n442 240
R2421 B.n697 B.n442 240
R2422 B.n697 B.n448 240
R2423 B.n693 B.n448 240
R2424 B.n693 B.n450 240
R2425 B.n685 B.n450 240
R2426 B.n685 B.n456 240
R2427 B.n681 B.n456 240
R2428 B.n681 B.n458 240
R2429 B.n673 B.n458 240
R2430 B.n673 B.n464 240
R2431 B.n669 B.n464 240
R2432 B.n669 B.n466 240
R2433 B.n661 B.n466 240
R2434 B.n661 B.n472 240
R2435 B.n657 B.n472 240
R2436 B.n657 B.n474 240
R2437 B.n649 B.n474 240
R2438 B.n649 B.n480 240
R2439 B.n645 B.n480 240
R2440 B.n645 B.n482 240
R2441 B.n637 B.n482 240
R2442 B.n637 B.n488 240
R2443 B.n633 B.n488 240
R2444 B.n633 B.n490 240
R2445 B.n625 B.n490 240
R2446 B.n625 B.n496 240
R2447 B.n621 B.n496 240
R2448 B.n621 B.n498 240
R2449 B.n613 B.n498 240
R2450 B.n613 B.n504 240
R2451 B.n609 B.n504 240
R2452 B.n609 B.n506 240
R2453 B.n601 B.n506 240
R2454 B.n601 B.n512 240
R2455 B.n597 B.n512 240
R2456 B.n597 B.n514 240
R2457 B.n589 B.n514 240
R2458 B.n589 B.n520 240
R2459 B.n585 B.n520 240
R2460 B.n585 B.n522 240
R2461 B.n577 B.n522 240
R2462 B.n577 B.n528 240
R2463 B.n573 B.n528 240
R2464 B.n573 B.n530 240
R2465 B.n565 B.n530 240
R2466 B.n565 B.n536 240
R2467 B.n561 B.n536 240
R2468 B.n561 B.n538 240
R2469 B.n553 B.n538 240
R2470 B.n1365 B.n1 240
R2471 B.n1362 B.n3 240
R2472 B.n1352 B.n3 240
R2473 B.n1352 B.n12 240
R2474 B.n1347 B.n12 240
R2475 B.n1347 B.n14 240
R2476 B.n1339 B.n14 240
R2477 B.n1339 B.n20 240
R2478 B.n1335 B.n20 240
R2479 B.n1335 B.n22 240
R2480 B.n1327 B.n22 240
R2481 B.n1327 B.n28 240
R2482 B.n1323 B.n28 240
R2483 B.n1323 B.n30 240
R2484 B.n1315 B.n30 240
R2485 B.n1315 B.n36 240
R2486 B.n1311 B.n36 240
R2487 B.n1311 B.n38 240
R2488 B.n1303 B.n38 240
R2489 B.n1303 B.n44 240
R2490 B.n1299 B.n44 240
R2491 B.n1299 B.n46 240
R2492 B.n1291 B.n46 240
R2493 B.n1291 B.n52 240
R2494 B.n1287 B.n52 240
R2495 B.n1287 B.n54 240
R2496 B.n1279 B.n54 240
R2497 B.n1279 B.n60 240
R2498 B.n1275 B.n60 240
R2499 B.n1275 B.n62 240
R2500 B.n1267 B.n62 240
R2501 B.n1267 B.n68 240
R2502 B.n1263 B.n68 240
R2503 B.n1263 B.n70 240
R2504 B.n1255 B.n70 240
R2505 B.n1255 B.n76 240
R2506 B.n1251 B.n76 240
R2507 B.n1251 B.n78 240
R2508 B.n1243 B.n78 240
R2509 B.n1243 B.n84 240
R2510 B.n1239 B.n84 240
R2511 B.n1239 B.n86 240
R2512 B.n1231 B.n86 240
R2513 B.n1231 B.n92 240
R2514 B.n1227 B.n92 240
R2515 B.n1227 B.n94 240
R2516 B.n1219 B.n94 240
R2517 B.n1219 B.n100 240
R2518 B.n1215 B.n100 240
R2519 B.n1215 B.n102 240
R2520 B.n1207 B.n102 240
R2521 B.n1207 B.n108 240
R2522 B.n1203 B.n108 240
R2523 B.n1203 B.n110 240
R2524 B.n1195 B.n110 240
R2525 B.n1195 B.n116 240
R2526 B.n1191 B.n116 240
R2527 B.n1191 B.n118 240
R2528 B.n1183 B.n118 240
R2529 B.n1183 B.n124 240
R2530 B.n1179 B.n124 240
R2531 B.n1179 B.n126 240
R2532 B.n1171 B.n126 240
R2533 B.n1171 B.n132 240
R2534 B.n1167 B.n132 240
R2535 B.n1167 B.n134 240
R2536 B.n1159 B.n134 240
R2537 B.n1159 B.n140 240
R2538 B.n1155 B.n140 240
R2539 B.n1155 B.n142 240
R2540 B.n1147 B.n142 240
R2541 B.n1147 B.n148 240
R2542 B.n1143 B.n148 240
R2543 B.n1143 B.n150 240
R2544 B.n1135 B.n150 240
R2545 B.n1135 B.n156 240
R2546 B.n1131 B.n156 240
R2547 B.n1131 B.n158 240
R2548 B.n1123 B.n158 240
R2549 B.n1123 B.n164 240
R2550 B.n1119 B.n164 240
R2551 B.n1119 B.n166 240
R2552 B.n1111 B.n166 240
R2553 B.n1111 B.n172 240
R2554 B.n1107 B.n172 240
R2555 B.n1107 B.n174 240
R2556 B.n1099 B.n174 240
R2557 B.n1099 B.n180 240
R2558 B.n1095 B.n180 240
R2559 B.n1095 B.n182 240
R2560 B.n1087 B.n182 240
R2561 B.n1087 B.n188 240
R2562 B.n1083 B.n188 240
R2563 B.n1083 B.n190 240
R2564 B.n1075 B.n190 240
R2565 B.n1075 B.n196 240
R2566 B.n1071 B.n196 240
R2567 B.n1071 B.n198 240
R2568 B.n1063 B.n198 240
R2569 B.n1063 B.n204 240
R2570 B.n1059 B.n204 240
R2571 B.n1059 B.n206 240
R2572 B.n1051 B.n206 240
R2573 B.n1051 B.n212 240
R2574 B.n1047 B.n212 240
R2575 B.n1047 B.n214 240
R2576 B.n1039 B.n214 240
R2577 B.n1039 B.n220 240
R2578 B.n1035 B.n220 240
R2579 B.n1035 B.n222 240
R2580 B.n1027 B.n222 240
R2581 B.n1027 B.n228 240
R2582 B.n1023 B.n228 240
R2583 B.n1023 B.n230 240
R2584 B.n1015 B.n230 240
R2585 B.n1015 B.n236 240
R2586 B.n1011 B.n236 240
R2587 B.n1011 B.n238 240
R2588 B.n1003 B.n238 240
R2589 B.n1003 B.n244 240
R2590 B.n999 B.n244 240
R2591 B.n999 B.n246 240
R2592 B.n991 B.n246 240
R2593 B.n991 B.n252 240
R2594 B.n987 B.n252 240
R2595 B.n987 B.n254 240
R2596 B.n979 B.n254 240
R2597 B.n979 B.n260 240
R2598 B.n975 B.n260 240
R2599 B.n975 B.n262 240
R2600 B.n967 B.n262 240
R2601 B.n967 B.n268 240
R2602 B.n963 B.n268 240
R2603 B.n963 B.n270 240
R2604 B.n955 B.n270 240
R2605 B.n955 B.n276 240
R2606 B.n951 B.n276 240
R2607 B.n951 B.n278 240
R2608 B.n943 B.n278 240
R2609 B.n943 B.n284 240
R2610 B.n939 B.n284 240
R2611 B.n939 B.n286 240
R2612 B.n931 B.n286 240
R2613 B.n931 B.n292 240
R2614 B.n927 B.n292 240
R2615 B.n927 B.n294 240
R2616 B.n919 B.n294 240
R2617 B.n919 B.n300 240
R2618 B.n915 B.n300 240
R2619 B.n915 B.n302 240
R2620 B.n907 B.n302 240
R2621 B.n907 B.n308 240
R2622 B.n903 B.n308 240
R2623 B.n903 B.n310 240
R2624 B.n895 B.n310 240
R2625 B.n895 B.n316 240
R2626 B.n891 B.n316 240
R2627 B.n891 B.n318 240
R2628 B.n883 B.n318 240
R2629 B.n883 B.n324 240
R2630 B.n879 B.n324 240
R2631 B.n879 B.n326 240
R2632 B.n871 B.n326 240
R2633 B.n871 B.n332 240
R2634 B.n867 B.n332 240
R2635 B.n867 B.n334 240
R2636 B.n859 B.n334 240
R2637 B.n859 B.n340 240
R2638 B.n855 B.n340 240
R2639 B.n855 B.n342 240
R2640 B.n847 B.n342 240
R2641 B.n847 B.n348 240
R2642 B.n843 B.n348 240
R2643 B.n843 B.n350 240
R2644 B.n835 B.n350 240
R2645 B.n835 B.n356 240
R2646 B.n831 B.n356 240
R2647 B.n831 B.n358 240
R2648 B.n823 B.n358 240
R2649 B.n823 B.n364 240
R2650 B.n819 B.n364 240
R2651 B.n819 B.n366 240
R2652 B.n811 B.n366 240
R2653 B.n811 B.n372 240
R2654 B.n807 B.n372 240
R2655 B.n807 B.n374 240
R2656 B.n799 B.n374 240
R2657 B.n799 B.n380 240
R2658 B.n795 B.n380 240
R2659 B.n795 B.n382 240
R2660 B.n787 B.n382 240
R2661 B.n787 B.n388 240
R2662 B.n783 B.n388 240
R2663 B.n783 B.n390 240
R2664 B.n775 B.n390 240
R2665 B.n775 B.n396 240
R2666 B.n771 B.n396 240
R2667 B.n771 B.n398 240
R2668 B.n763 B.n398 240
R2669 B.n763 B.n404 240
R2670 B.n759 B.n404 240
R2671 B.n759 B.n406 240
R2672 B.n751 B.n406 240
R2673 B.n751 B.n412 240
R2674 B.n747 B.n412 240
R2675 B.n747 B.n414 240
R2676 B.n739 B.n414 240
R2677 B.n739 B.n420 240
R2678 B.n735 B.n420 240
R2679 B.n735 B.n422 240
R2680 B.n727 B.n422 240
R2681 B.n727 B.n428 240
R2682 B.n723 B.n428 240
R2683 B.n723 B.n430 240
R2684 B.n715 B.n430 240
R2685 B.n715 B.n436 240
R2686 B.n711 B.n436 240
R2687 B.n711 B.n438 240
R2688 B.n703 B.n438 240
R2689 B.n703 B.n444 240
R2690 B.n699 B.n444 240
R2691 B.n699 B.n446 240
R2692 B.n691 B.n446 240
R2693 B.n691 B.n452 240
R2694 B.n687 B.n452 240
R2695 B.n687 B.n454 240
R2696 B.n679 B.n454 240
R2697 B.n679 B.n460 240
R2698 B.n675 B.n460 240
R2699 B.n675 B.n462 240
R2700 B.n667 B.n462 240
R2701 B.n667 B.n468 240
R2702 B.n663 B.n468 240
R2703 B.n663 B.n470 240
R2704 B.n655 B.n470 240
R2705 B.n655 B.n476 240
R2706 B.n651 B.n476 240
R2707 B.n651 B.n478 240
R2708 B.n643 B.n478 240
R2709 B.n643 B.n484 240
R2710 B.n639 B.n484 240
R2711 B.n639 B.n486 240
R2712 B.n631 B.n486 240
R2713 B.n631 B.n492 240
R2714 B.n627 B.n492 240
R2715 B.n627 B.n494 240
R2716 B.n619 B.n494 240
R2717 B.n619 B.n500 240
R2718 B.n615 B.n500 240
R2719 B.n615 B.n502 240
R2720 B.n607 B.n502 240
R2721 B.n607 B.n508 240
R2722 B.n603 B.n508 240
R2723 B.n603 B.n510 240
R2724 B.n595 B.n510 240
R2725 B.n595 B.n516 240
R2726 B.n591 B.n516 240
R2727 B.n591 B.n518 240
R2728 B.n583 B.n518 240
R2729 B.n583 B.n524 240
R2730 B.n579 B.n524 240
R2731 B.n579 B.n526 240
R2732 B.n571 B.n526 240
R2733 B.n571 B.n532 240
R2734 B.n567 B.n532 240
R2735 B.n567 B.n534 240
R2736 B.n559 B.n534 240
R2737 B.n559 B.n540 240
R2738 B.n555 B.n540 240
R2739 B.n549 B.n547 240
R2740 B.n1361 B.n2 205.833
R2741 B.n554 B.n543 205.833
R2742 B.n1358 B.n8 185
R2743 B.n1357 B.n1 185
R2744 B.n1366 B.n1365 185
R2745 B.n1363 B.n0 185
R2746 B.n1362 B.n1361 185
R2747 B.n1362 B.n4 185
R2748 B.n5 B.n3 185
R2749 B.n1350 B.n3 185
R2750 B.n1353 B.n1352 185
R2751 B.n1352 B.n1351 185
R2752 B.n12 B.n11 185
R2753 B.n1349 B.n12 185
R2754 B.n1347 B.n1346 185
R2755 B.n1348 B.n1347 185
R2756 B.n15 B.n14 185
R2757 B.n14 B.n13 185
R2758 B.n1340 B.n1339 185
R2759 B.n1339 B.n1338 185
R2760 B.n20 B.n19 185
R2761 B.n1337 B.n20 185
R2762 B.n1335 B.n1334 185
R2763 B.n1336 B.n1335 185
R2764 B.n23 B.n22 185
R2765 B.n22 B.n21 185
R2766 B.n1328 B.n1327 185
R2767 B.n1327 B.n1326 185
R2768 B.n28 B.n27 185
R2769 B.n1325 B.n28 185
R2770 B.n1323 B.n1322 185
R2771 B.n1324 B.n1323 185
R2772 B.n31 B.n30 185
R2773 B.n30 B.n29 185
R2774 B.n1316 B.n1315 185
R2775 B.n1315 B.n1314 185
R2776 B.n36 B.n35 185
R2777 B.n1313 B.n36 185
R2778 B.n1311 B.n1310 185
R2779 B.n1312 B.n1311 185
R2780 B.n39 B.n38 185
R2781 B.n38 B.n37 185
R2782 B.n1304 B.n1303 185
R2783 B.n1303 B.n1302 185
R2784 B.n44 B.n43 185
R2785 B.n1301 B.n44 185
R2786 B.n1299 B.n1298 185
R2787 B.n1300 B.n1299 185
R2788 B.n47 B.n46 185
R2789 B.n46 B.n45 185
R2790 B.n1292 B.n1291 185
R2791 B.n1291 B.n1290 185
R2792 B.n52 B.n51 185
R2793 B.n1289 B.n52 185
R2794 B.n1287 B.n1286 185
R2795 B.n1288 B.n1287 185
R2796 B.n55 B.n54 185
R2797 B.n54 B.n53 185
R2798 B.n1280 B.n1279 185
R2799 B.n1279 B.n1278 185
R2800 B.n60 B.n59 185
R2801 B.n1277 B.n60 185
R2802 B.n1275 B.n1274 185
R2803 B.n1276 B.n1275 185
R2804 B.n63 B.n62 185
R2805 B.n62 B.n61 185
R2806 B.n1268 B.n1267 185
R2807 B.n1267 B.n1266 185
R2808 B.n68 B.n67 185
R2809 B.n1265 B.n68 185
R2810 B.n1263 B.n1262 185
R2811 B.n1264 B.n1263 185
R2812 B.n71 B.n70 185
R2813 B.n70 B.n69 185
R2814 B.n1256 B.n1255 185
R2815 B.n1255 B.n1254 185
R2816 B.n76 B.n75 185
R2817 B.n1253 B.n76 185
R2818 B.n1251 B.n1250 185
R2819 B.n1252 B.n1251 185
R2820 B.n79 B.n78 185
R2821 B.n78 B.n77 185
R2822 B.n1244 B.n1243 185
R2823 B.n1243 B.n1242 185
R2824 B.n84 B.n83 185
R2825 B.n1241 B.n84 185
R2826 B.n1239 B.n1238 185
R2827 B.n1240 B.n1239 185
R2828 B.n87 B.n86 185
R2829 B.n86 B.n85 185
R2830 B.n1232 B.n1231 185
R2831 B.n1231 B.n1230 185
R2832 B.n92 B.n91 185
R2833 B.n1229 B.n92 185
R2834 B.n1227 B.n1226 185
R2835 B.n1228 B.n1227 185
R2836 B.n95 B.n94 185
R2837 B.n94 B.n93 185
R2838 B.n1220 B.n1219 185
R2839 B.n1219 B.n1218 185
R2840 B.n100 B.n99 185
R2841 B.n1217 B.n100 185
R2842 B.n1215 B.n1214 185
R2843 B.n1216 B.n1215 185
R2844 B.n103 B.n102 185
R2845 B.n102 B.n101 185
R2846 B.n1208 B.n1207 185
R2847 B.n1207 B.n1206 185
R2848 B.n108 B.n107 185
R2849 B.n1205 B.n108 185
R2850 B.n1203 B.n1202 185
R2851 B.n1204 B.n1203 185
R2852 B.n111 B.n110 185
R2853 B.n110 B.n109 185
R2854 B.n1196 B.n1195 185
R2855 B.n1195 B.n1194 185
R2856 B.n116 B.n115 185
R2857 B.n1193 B.n116 185
R2858 B.n1191 B.n1190 185
R2859 B.n1192 B.n1191 185
R2860 B.n119 B.n118 185
R2861 B.n118 B.n117 185
R2862 B.n1184 B.n1183 185
R2863 B.n1183 B.n1182 185
R2864 B.n124 B.n123 185
R2865 B.n1181 B.n124 185
R2866 B.n1179 B.n1178 185
R2867 B.n1180 B.n1179 185
R2868 B.n127 B.n126 185
R2869 B.n126 B.n125 185
R2870 B.n1172 B.n1171 185
R2871 B.n1171 B.n1170 185
R2872 B.n132 B.n131 185
R2873 B.n1169 B.n132 185
R2874 B.n1167 B.n1166 185
R2875 B.n1168 B.n1167 185
R2876 B.n135 B.n134 185
R2877 B.n134 B.n133 185
R2878 B.n1160 B.n1159 185
R2879 B.n1159 B.n1158 185
R2880 B.n140 B.n139 185
R2881 B.n1157 B.n140 185
R2882 B.n1155 B.n1154 185
R2883 B.n1156 B.n1155 185
R2884 B.n143 B.n142 185
R2885 B.n142 B.n141 185
R2886 B.n1148 B.n1147 185
R2887 B.n1147 B.n1146 185
R2888 B.n148 B.n147 185
R2889 B.n1145 B.n148 185
R2890 B.n1143 B.n1142 185
R2891 B.n1144 B.n1143 185
R2892 B.n151 B.n150 185
R2893 B.n150 B.n149 185
R2894 B.n1136 B.n1135 185
R2895 B.n1135 B.n1134 185
R2896 B.n156 B.n155 185
R2897 B.n1133 B.n156 185
R2898 B.n1131 B.n1130 185
R2899 B.n1132 B.n1131 185
R2900 B.n159 B.n158 185
R2901 B.n158 B.n157 185
R2902 B.n1124 B.n1123 185
R2903 B.n1123 B.n1122 185
R2904 B.n164 B.n163 185
R2905 B.n1121 B.n164 185
R2906 B.n1119 B.n1118 185
R2907 B.n1120 B.n1119 185
R2908 B.n167 B.n166 185
R2909 B.n166 B.n165 185
R2910 B.n1112 B.n1111 185
R2911 B.n1111 B.n1110 185
R2912 B.n172 B.n171 185
R2913 B.n1109 B.n172 185
R2914 B.n1107 B.n1106 185
R2915 B.n1108 B.n1107 185
R2916 B.n175 B.n174 185
R2917 B.n174 B.n173 185
R2918 B.n1100 B.n1099 185
R2919 B.n1099 B.n1098 185
R2920 B.n180 B.n179 185
R2921 B.n1097 B.n180 185
R2922 B.n1095 B.n1094 185
R2923 B.n1096 B.n1095 185
R2924 B.n183 B.n182 185
R2925 B.n182 B.n181 185
R2926 B.n1088 B.n1087 185
R2927 B.n1087 B.n1086 185
R2928 B.n188 B.n187 185
R2929 B.n1085 B.n188 185
R2930 B.n1083 B.n1082 185
R2931 B.n1084 B.n1083 185
R2932 B.n191 B.n190 185
R2933 B.n190 B.n189 185
R2934 B.n1076 B.n1075 185
R2935 B.n1075 B.n1074 185
R2936 B.n196 B.n195 185
R2937 B.n1073 B.n196 185
R2938 B.n1071 B.n1070 185
R2939 B.n1072 B.n1071 185
R2940 B.n199 B.n198 185
R2941 B.n198 B.n197 185
R2942 B.n1064 B.n1063 185
R2943 B.n1063 B.n1062 185
R2944 B.n204 B.n203 185
R2945 B.n1061 B.n204 185
R2946 B.n1059 B.n1058 185
R2947 B.n1060 B.n1059 185
R2948 B.n207 B.n206 185
R2949 B.n206 B.n205 185
R2950 B.n1052 B.n1051 185
R2951 B.n1051 B.n1050 185
R2952 B.n212 B.n211 185
R2953 B.n1049 B.n212 185
R2954 B.n1047 B.n1046 185
R2955 B.n1048 B.n1047 185
R2956 B.n215 B.n214 185
R2957 B.n214 B.n213 185
R2958 B.n1040 B.n1039 185
R2959 B.n1039 B.n1038 185
R2960 B.n220 B.n219 185
R2961 B.n1037 B.n220 185
R2962 B.n1035 B.n1034 185
R2963 B.n1036 B.n1035 185
R2964 B.n223 B.n222 185
R2965 B.n222 B.n221 185
R2966 B.n1028 B.n1027 185
R2967 B.n1027 B.n1026 185
R2968 B.n228 B.n227 185
R2969 B.n1025 B.n228 185
R2970 B.n1023 B.n1022 185
R2971 B.n1024 B.n1023 185
R2972 B.n231 B.n230 185
R2973 B.n230 B.n229 185
R2974 B.n1016 B.n1015 185
R2975 B.n1015 B.n1014 185
R2976 B.n236 B.n235 185
R2977 B.n1013 B.n236 185
R2978 B.n1011 B.n1010 185
R2979 B.n1012 B.n1011 185
R2980 B.n239 B.n238 185
R2981 B.n238 B.n237 185
R2982 B.n1004 B.n1003 185
R2983 B.n1003 B.n1002 185
R2984 B.n244 B.n243 185
R2985 B.n1001 B.n244 185
R2986 B.n999 B.n998 185
R2987 B.n1000 B.n999 185
R2988 B.n247 B.n246 185
R2989 B.n246 B.n245 185
R2990 B.n992 B.n991 185
R2991 B.n991 B.n990 185
R2992 B.n252 B.n251 185
R2993 B.n989 B.n252 185
R2994 B.n987 B.n986 185
R2995 B.n988 B.n987 185
R2996 B.n255 B.n254 185
R2997 B.n254 B.n253 185
R2998 B.n980 B.n979 185
R2999 B.n979 B.n978 185
R3000 B.n260 B.n259 185
R3001 B.n977 B.n260 185
R3002 B.n975 B.n974 185
R3003 B.n976 B.n975 185
R3004 B.n263 B.n262 185
R3005 B.n262 B.n261 185
R3006 B.n968 B.n967 185
R3007 B.n967 B.n966 185
R3008 B.n268 B.n267 185
R3009 B.n965 B.n268 185
R3010 B.n963 B.n962 185
R3011 B.n964 B.n963 185
R3012 B.n271 B.n270 185
R3013 B.n270 B.n269 185
R3014 B.n956 B.n955 185
R3015 B.n955 B.n954 185
R3016 B.n276 B.n275 185
R3017 B.n953 B.n276 185
R3018 B.n951 B.n950 185
R3019 B.n952 B.n951 185
R3020 B.n279 B.n278 185
R3021 B.n278 B.n277 185
R3022 B.n944 B.n943 185
R3023 B.n943 B.n942 185
R3024 B.n284 B.n283 185
R3025 B.n941 B.n284 185
R3026 B.n939 B.n938 185
R3027 B.n940 B.n939 185
R3028 B.n287 B.n286 185
R3029 B.n286 B.n285 185
R3030 B.n932 B.n931 185
R3031 B.n931 B.n930 185
R3032 B.n292 B.n291 185
R3033 B.n929 B.n292 185
R3034 B.n927 B.n926 185
R3035 B.n928 B.n927 185
R3036 B.n295 B.n294 185
R3037 B.n294 B.n293 185
R3038 B.n920 B.n919 185
R3039 B.n919 B.n918 185
R3040 B.n300 B.n299 185
R3041 B.n917 B.n300 185
R3042 B.n915 B.n914 185
R3043 B.n916 B.n915 185
R3044 B.n303 B.n302 185
R3045 B.n302 B.n301 185
R3046 B.n908 B.n907 185
R3047 B.n907 B.n906 185
R3048 B.n308 B.n307 185
R3049 B.n905 B.n308 185
R3050 B.n903 B.n902 185
R3051 B.n904 B.n903 185
R3052 B.n311 B.n310 185
R3053 B.n310 B.n309 185
R3054 B.n896 B.n895 185
R3055 B.n895 B.n894 185
R3056 B.n316 B.n315 185
R3057 B.n893 B.n316 185
R3058 B.n891 B.n890 185
R3059 B.n892 B.n891 185
R3060 B.n319 B.n318 185
R3061 B.n318 B.n317 185
R3062 B.n884 B.n883 185
R3063 B.n883 B.n882 185
R3064 B.n324 B.n323 185
R3065 B.n881 B.n324 185
R3066 B.n879 B.n878 185
R3067 B.n880 B.n879 185
R3068 B.n327 B.n326 185
R3069 B.n326 B.n325 185
R3070 B.n872 B.n871 185
R3071 B.n871 B.n870 185
R3072 B.n332 B.n331 185
R3073 B.n869 B.n332 185
R3074 B.n867 B.n866 185
R3075 B.n868 B.n867 185
R3076 B.n335 B.n334 185
R3077 B.n334 B.n333 185
R3078 B.n860 B.n859 185
R3079 B.n859 B.n858 185
R3080 B.n340 B.n339 185
R3081 B.n857 B.n340 185
R3082 B.n855 B.n854 185
R3083 B.n856 B.n855 185
R3084 B.n343 B.n342 185
R3085 B.n342 B.n341 185
R3086 B.n848 B.n847 185
R3087 B.n847 B.n846 185
R3088 B.n348 B.n347 185
R3089 B.n845 B.n348 185
R3090 B.n843 B.n842 185
R3091 B.n844 B.n843 185
R3092 B.n351 B.n350 185
R3093 B.n350 B.n349 185
R3094 B.n836 B.n835 185
R3095 B.n835 B.n834 185
R3096 B.n356 B.n355 185
R3097 B.n833 B.n356 185
R3098 B.n831 B.n830 185
R3099 B.n832 B.n831 185
R3100 B.n359 B.n358 185
R3101 B.n358 B.n357 185
R3102 B.n824 B.n823 185
R3103 B.n823 B.n822 185
R3104 B.n364 B.n363 185
R3105 B.n821 B.n364 185
R3106 B.n819 B.n818 185
R3107 B.n820 B.n819 185
R3108 B.n367 B.n366 185
R3109 B.n366 B.n365 185
R3110 B.n812 B.n811 185
R3111 B.n811 B.n810 185
R3112 B.n372 B.n371 185
R3113 B.n809 B.n372 185
R3114 B.n807 B.n806 185
R3115 B.n808 B.n807 185
R3116 B.n375 B.n374 185
R3117 B.n374 B.n373 185
R3118 B.n800 B.n799 185
R3119 B.n799 B.n798 185
R3120 B.n380 B.n379 185
R3121 B.n797 B.n380 185
R3122 B.n795 B.n794 185
R3123 B.n796 B.n795 185
R3124 B.n383 B.n382 185
R3125 B.n382 B.n381 185
R3126 B.n788 B.n787 185
R3127 B.n787 B.n786 185
R3128 B.n388 B.n387 185
R3129 B.n785 B.n388 185
R3130 B.n783 B.n782 185
R3131 B.n784 B.n783 185
R3132 B.n391 B.n390 185
R3133 B.n390 B.n389 185
R3134 B.n776 B.n775 185
R3135 B.n775 B.n774 185
R3136 B.n396 B.n395 185
R3137 B.n773 B.n396 185
R3138 B.n771 B.n770 185
R3139 B.n772 B.n771 185
R3140 B.n399 B.n398 185
R3141 B.n398 B.n397 185
R3142 B.n764 B.n763 185
R3143 B.n763 B.n762 185
R3144 B.n404 B.n403 185
R3145 B.n761 B.n404 185
R3146 B.n759 B.n758 185
R3147 B.n760 B.n759 185
R3148 B.n407 B.n406 185
R3149 B.n406 B.n405 185
R3150 B.n752 B.n751 185
R3151 B.n751 B.n750 185
R3152 B.n412 B.n411 185
R3153 B.n749 B.n412 185
R3154 B.n747 B.n746 185
R3155 B.n748 B.n747 185
R3156 B.n415 B.n414 185
R3157 B.n414 B.n413 185
R3158 B.n740 B.n739 185
R3159 B.n739 B.n738 185
R3160 B.n420 B.n419 185
R3161 B.n737 B.n420 185
R3162 B.n735 B.n734 185
R3163 B.n736 B.n735 185
R3164 B.n423 B.n422 185
R3165 B.n422 B.n421 185
R3166 B.n728 B.n727 185
R3167 B.n727 B.n726 185
R3168 B.n428 B.n427 185
R3169 B.n725 B.n428 185
R3170 B.n723 B.n722 185
R3171 B.n724 B.n723 185
R3172 B.n431 B.n430 185
R3173 B.n430 B.n429 185
R3174 B.n716 B.n715 185
R3175 B.n715 B.n714 185
R3176 B.n436 B.n435 185
R3177 B.n713 B.n436 185
R3178 B.n711 B.n710 185
R3179 B.n712 B.n711 185
R3180 B.n439 B.n438 185
R3181 B.n438 B.n437 185
R3182 B.n704 B.n703 185
R3183 B.n703 B.n702 185
R3184 B.n444 B.n443 185
R3185 B.n701 B.n444 185
R3186 B.n699 B.n698 185
R3187 B.n700 B.n699 185
R3188 B.n447 B.n446 185
R3189 B.n446 B.n445 185
R3190 B.n692 B.n691 185
R3191 B.n691 B.n690 185
R3192 B.n452 B.n451 185
R3193 B.n689 B.n452 185
R3194 B.n687 B.n686 185
R3195 B.n688 B.n687 185
R3196 B.n455 B.n454 185
R3197 B.n454 B.n453 185
R3198 B.n680 B.n679 185
R3199 B.n679 B.n678 185
R3200 B.n460 B.n459 185
R3201 B.n677 B.n460 185
R3202 B.n675 B.n674 185
R3203 B.n676 B.n675 185
R3204 B.n463 B.n462 185
R3205 B.n462 B.n461 185
R3206 B.n668 B.n667 185
R3207 B.n667 B.n666 185
R3208 B.n468 B.n467 185
R3209 B.n665 B.n468 185
R3210 B.n663 B.n662 185
R3211 B.n664 B.n663 185
R3212 B.n471 B.n470 185
R3213 B.n470 B.n469 185
R3214 B.n656 B.n655 185
R3215 B.n655 B.n654 185
R3216 B.n476 B.n475 185
R3217 B.n653 B.n476 185
R3218 B.n651 B.n650 185
R3219 B.n652 B.n651 185
R3220 B.n479 B.n478 185
R3221 B.n478 B.n477 185
R3222 B.n644 B.n643 185
R3223 B.n643 B.n642 185
R3224 B.n484 B.n483 185
R3225 B.n641 B.n484 185
R3226 B.n639 B.n638 185
R3227 B.n640 B.n639 185
R3228 B.n487 B.n486 185
R3229 B.n486 B.n485 185
R3230 B.n632 B.n631 185
R3231 B.n631 B.n630 185
R3232 B.n492 B.n491 185
R3233 B.n629 B.n492 185
R3234 B.n627 B.n626 185
R3235 B.n628 B.n627 185
R3236 B.n495 B.n494 185
R3237 B.n494 B.n493 185
R3238 B.n620 B.n619 185
R3239 B.n619 B.n618 185
R3240 B.n500 B.n499 185
R3241 B.n617 B.n500 185
R3242 B.n615 B.n614 185
R3243 B.n616 B.n615 185
R3244 B.n503 B.n502 185
R3245 B.n502 B.n501 185
R3246 B.n608 B.n607 185
R3247 B.n607 B.n606 185
R3248 B.n508 B.n507 185
R3249 B.n605 B.n508 185
R3250 B.n603 B.n602 185
R3251 B.n604 B.n603 185
R3252 B.n511 B.n510 185
R3253 B.n510 B.n509 185
R3254 B.n596 B.n595 185
R3255 B.n595 B.n594 185
R3256 B.n516 B.n515 185
R3257 B.n593 B.n516 185
R3258 B.n591 B.n590 185
R3259 B.n592 B.n591 185
R3260 B.n519 B.n518 185
R3261 B.n518 B.n517 185
R3262 B.n584 B.n583 185
R3263 B.n583 B.n582 185
R3264 B.n524 B.n523 185
R3265 B.n581 B.n524 185
R3266 B.n579 B.n578 185
R3267 B.n580 B.n579 185
R3268 B.n527 B.n526 185
R3269 B.n526 B.n525 185
R3270 B.n572 B.n571 185
R3271 B.n571 B.n570 185
R3272 B.n532 B.n531 185
R3273 B.n569 B.n532 185
R3274 B.n567 B.n566 185
R3275 B.n568 B.n567 185
R3276 B.n535 B.n534 185
R3277 B.n534 B.n533 185
R3278 B.n560 B.n559 185
R3279 B.n559 B.n558 185
R3280 B.n540 B.n539 185
R3281 B.n557 B.n540 185
R3282 B.n555 B.n554 185
R3283 B.n556 B.n555 185
R3284 B.n542 B.n541 185
R3285 B.n547 B.n545 185
R3286 B.n550 B.n549 185
R3287 B.n551 B.n544 185
R3288 B.n554 B.n553 185
R3289 B.n553 B.n552 185
R3290 B.n539 B.n538 185
R3291 B.n538 B.n537 185
R3292 B.n561 B.n560 185
R3293 B.n562 B.n561 185
R3294 B.n536 B.n535 185
R3295 B.n563 B.n536 185
R3296 B.n566 B.n565 185
R3297 B.n565 B.n564 185
R3298 B.n531 B.n530 185
R3299 B.n530 B.n529 185
R3300 B.n573 B.n572 185
R3301 B.n574 B.n573 185
R3302 B.n528 B.n527 185
R3303 B.n575 B.n528 185
R3304 B.n578 B.n577 185
R3305 B.n577 B.n576 185
R3306 B.n523 B.n522 185
R3307 B.n522 B.n521 185
R3308 B.n585 B.n584 185
R3309 B.n586 B.n585 185
R3310 B.n520 B.n519 185
R3311 B.n587 B.n520 185
R3312 B.n590 B.n589 185
R3313 B.n589 B.n588 185
R3314 B.n515 B.n514 185
R3315 B.n514 B.n513 185
R3316 B.n597 B.n596 185
R3317 B.n598 B.n597 185
R3318 B.n512 B.n511 185
R3319 B.n599 B.n512 185
R3320 B.n602 B.n601 185
R3321 B.n601 B.n600 185
R3322 B.n507 B.n506 185
R3323 B.n506 B.n505 185
R3324 B.n609 B.n608 185
R3325 B.n610 B.n609 185
R3326 B.n504 B.n503 185
R3327 B.n611 B.n504 185
R3328 B.n614 B.n613 185
R3329 B.n613 B.n612 185
R3330 B.n499 B.n498 185
R3331 B.n498 B.n497 185
R3332 B.n621 B.n620 185
R3333 B.n622 B.n621 185
R3334 B.n496 B.n495 185
R3335 B.n623 B.n496 185
R3336 B.n626 B.n625 185
R3337 B.n625 B.n624 185
R3338 B.n491 B.n490 185
R3339 B.n490 B.n489 185
R3340 B.n633 B.n632 185
R3341 B.n634 B.n633 185
R3342 B.n488 B.n487 185
R3343 B.n635 B.n488 185
R3344 B.n638 B.n637 185
R3345 B.n637 B.n636 185
R3346 B.n483 B.n482 185
R3347 B.n482 B.n481 185
R3348 B.n645 B.n644 185
R3349 B.n646 B.n645 185
R3350 B.n480 B.n479 185
R3351 B.n647 B.n480 185
R3352 B.n650 B.n649 185
R3353 B.n649 B.n648 185
R3354 B.n475 B.n474 185
R3355 B.n474 B.n473 185
R3356 B.n657 B.n656 185
R3357 B.n658 B.n657 185
R3358 B.n472 B.n471 185
R3359 B.n659 B.n472 185
R3360 B.n662 B.n661 185
R3361 B.n661 B.n660 185
R3362 B.n467 B.n466 185
R3363 B.n466 B.n465 185
R3364 B.n669 B.n668 185
R3365 B.n670 B.n669 185
R3366 B.n464 B.n463 185
R3367 B.n671 B.n464 185
R3368 B.n674 B.n673 185
R3369 B.n673 B.n672 185
R3370 B.n459 B.n458 185
R3371 B.n458 B.n457 185
R3372 B.n681 B.n680 185
R3373 B.n682 B.n681 185
R3374 B.n456 B.n455 185
R3375 B.n683 B.n456 185
R3376 B.n686 B.n685 185
R3377 B.n685 B.n684 185
R3378 B.n451 B.n450 185
R3379 B.n450 B.n449 185
R3380 B.n693 B.n692 185
R3381 B.n694 B.n693 185
R3382 B.n448 B.n447 185
R3383 B.n695 B.n448 185
R3384 B.n698 B.n697 185
R3385 B.n697 B.n696 185
R3386 B.n443 B.n442 185
R3387 B.n442 B.n441 185
R3388 B.n705 B.n704 185
R3389 B.n706 B.n705 185
R3390 B.n440 B.n439 185
R3391 B.n707 B.n440 185
R3392 B.n710 B.n709 185
R3393 B.n709 B.n708 185
R3394 B.n435 B.n434 185
R3395 B.n434 B.n433 185
R3396 B.n717 B.n716 185
R3397 B.n718 B.n717 185
R3398 B.n432 B.n431 185
R3399 B.n719 B.n432 185
R3400 B.n722 B.n721 185
R3401 B.n721 B.n720 185
R3402 B.n427 B.n426 185
R3403 B.n426 B.n425 185
R3404 B.n729 B.n728 185
R3405 B.n730 B.n729 185
R3406 B.n424 B.n423 185
R3407 B.n731 B.n424 185
R3408 B.n734 B.n733 185
R3409 B.n733 B.n732 185
R3410 B.n419 B.n418 185
R3411 B.n418 B.n417 185
R3412 B.n741 B.n740 185
R3413 B.n742 B.n741 185
R3414 B.n416 B.n415 185
R3415 B.n743 B.n416 185
R3416 B.n746 B.n745 185
R3417 B.n745 B.n744 185
R3418 B.n411 B.n410 185
R3419 B.n410 B.n409 185
R3420 B.n753 B.n752 185
R3421 B.n754 B.n753 185
R3422 B.n408 B.n407 185
R3423 B.n755 B.n408 185
R3424 B.n758 B.n757 185
R3425 B.n757 B.n756 185
R3426 B.n403 B.n402 185
R3427 B.n402 B.n401 185
R3428 B.n765 B.n764 185
R3429 B.n766 B.n765 185
R3430 B.n400 B.n399 185
R3431 B.n767 B.n400 185
R3432 B.n770 B.n769 185
R3433 B.n769 B.n768 185
R3434 B.n395 B.n394 185
R3435 B.n394 B.n393 185
R3436 B.n777 B.n776 185
R3437 B.n778 B.n777 185
R3438 B.n392 B.n391 185
R3439 B.n779 B.n392 185
R3440 B.n782 B.n781 185
R3441 B.n781 B.n780 185
R3442 B.n387 B.n386 185
R3443 B.n386 B.n385 185
R3444 B.n789 B.n788 185
R3445 B.n790 B.n789 185
R3446 B.n384 B.n383 185
R3447 B.n791 B.n384 185
R3448 B.n794 B.n793 185
R3449 B.n793 B.n792 185
R3450 B.n379 B.n378 185
R3451 B.n378 B.n377 185
R3452 B.n801 B.n800 185
R3453 B.n802 B.n801 185
R3454 B.n376 B.n375 185
R3455 B.n803 B.n376 185
R3456 B.n806 B.n805 185
R3457 B.n805 B.n804 185
R3458 B.n371 B.n370 185
R3459 B.n370 B.n369 185
R3460 B.n813 B.n812 185
R3461 B.n814 B.n813 185
R3462 B.n368 B.n367 185
R3463 B.n815 B.n368 185
R3464 B.n818 B.n817 185
R3465 B.n817 B.n816 185
R3466 B.n363 B.n362 185
R3467 B.n362 B.n361 185
R3468 B.n825 B.n824 185
R3469 B.n826 B.n825 185
R3470 B.n360 B.n359 185
R3471 B.n827 B.n360 185
R3472 B.n830 B.n829 185
R3473 B.n829 B.n828 185
R3474 B.n355 B.n354 185
R3475 B.n354 B.n353 185
R3476 B.n837 B.n836 185
R3477 B.n838 B.n837 185
R3478 B.n352 B.n351 185
R3479 B.n839 B.n352 185
R3480 B.n842 B.n841 185
R3481 B.n841 B.n840 185
R3482 B.n347 B.n346 185
R3483 B.n346 B.n345 185
R3484 B.n849 B.n848 185
R3485 B.n850 B.n849 185
R3486 B.n344 B.n343 185
R3487 B.n851 B.n344 185
R3488 B.n854 B.n853 185
R3489 B.n853 B.n852 185
R3490 B.n339 B.n338 185
R3491 B.n338 B.n337 185
R3492 B.n861 B.n860 185
R3493 B.n862 B.n861 185
R3494 B.n336 B.n335 185
R3495 B.n863 B.n336 185
R3496 B.n866 B.n865 185
R3497 B.n865 B.n864 185
R3498 B.n331 B.n330 185
R3499 B.n330 B.n329 185
R3500 B.n873 B.n872 185
R3501 B.n874 B.n873 185
R3502 B.n328 B.n327 185
R3503 B.n875 B.n328 185
R3504 B.n878 B.n877 185
R3505 B.n877 B.n876 185
R3506 B.n323 B.n322 185
R3507 B.n322 B.n321 185
R3508 B.n885 B.n884 185
R3509 B.n886 B.n885 185
R3510 B.n320 B.n319 185
R3511 B.n887 B.n320 185
R3512 B.n890 B.n889 185
R3513 B.n889 B.n888 185
R3514 B.n315 B.n314 185
R3515 B.n314 B.n313 185
R3516 B.n897 B.n896 185
R3517 B.n898 B.n897 185
R3518 B.n312 B.n311 185
R3519 B.n899 B.n312 185
R3520 B.n902 B.n901 185
R3521 B.n901 B.n900 185
R3522 B.n307 B.n306 185
R3523 B.n306 B.n305 185
R3524 B.n909 B.n908 185
R3525 B.n910 B.n909 185
R3526 B.n304 B.n303 185
R3527 B.n911 B.n304 185
R3528 B.n914 B.n913 185
R3529 B.n913 B.n912 185
R3530 B.n299 B.n298 185
R3531 B.n298 B.n297 185
R3532 B.n921 B.n920 185
R3533 B.n922 B.n921 185
R3534 B.n296 B.n295 185
R3535 B.n923 B.n296 185
R3536 B.n926 B.n925 185
R3537 B.n925 B.n924 185
R3538 B.n291 B.n290 185
R3539 B.n290 B.n289 185
R3540 B.n933 B.n932 185
R3541 B.n934 B.n933 185
R3542 B.n288 B.n287 185
R3543 B.n935 B.n288 185
R3544 B.n938 B.n937 185
R3545 B.n937 B.n936 185
R3546 B.n283 B.n282 185
R3547 B.n282 B.n281 185
R3548 B.n945 B.n944 185
R3549 B.n946 B.n945 185
R3550 B.n280 B.n279 185
R3551 B.n947 B.n280 185
R3552 B.n950 B.n949 185
R3553 B.n949 B.n948 185
R3554 B.n275 B.n274 185
R3555 B.n274 B.n273 185
R3556 B.n957 B.n956 185
R3557 B.n958 B.n957 185
R3558 B.n272 B.n271 185
R3559 B.n959 B.n272 185
R3560 B.n962 B.n961 185
R3561 B.n961 B.n960 185
R3562 B.n267 B.n266 185
R3563 B.n266 B.n265 185
R3564 B.n969 B.n968 185
R3565 B.n970 B.n969 185
R3566 B.n264 B.n263 185
R3567 B.n971 B.n264 185
R3568 B.n974 B.n973 185
R3569 B.n973 B.n972 185
R3570 B.n259 B.n258 185
R3571 B.n258 B.n257 185
R3572 B.n981 B.n980 185
R3573 B.n982 B.n981 185
R3574 B.n256 B.n255 185
R3575 B.n983 B.n256 185
R3576 B.n986 B.n985 185
R3577 B.n985 B.n984 185
R3578 B.n251 B.n250 185
R3579 B.n250 B.n249 185
R3580 B.n993 B.n992 185
R3581 B.n994 B.n993 185
R3582 B.n248 B.n247 185
R3583 B.n995 B.n248 185
R3584 B.n998 B.n997 185
R3585 B.n997 B.n996 185
R3586 B.n243 B.n242 185
R3587 B.n242 B.n241 185
R3588 B.n1005 B.n1004 185
R3589 B.n1006 B.n1005 185
R3590 B.n240 B.n239 185
R3591 B.n1007 B.n240 185
R3592 B.n1010 B.n1009 185
R3593 B.n1009 B.n1008 185
R3594 B.n235 B.n234 185
R3595 B.n234 B.n233 185
R3596 B.n1017 B.n1016 185
R3597 B.n1018 B.n1017 185
R3598 B.n232 B.n231 185
R3599 B.n1019 B.n232 185
R3600 B.n1022 B.n1021 185
R3601 B.n1021 B.n1020 185
R3602 B.n227 B.n226 185
R3603 B.n226 B.n225 185
R3604 B.n1029 B.n1028 185
R3605 B.n1030 B.n1029 185
R3606 B.n224 B.n223 185
R3607 B.n1031 B.n224 185
R3608 B.n1034 B.n1033 185
R3609 B.n1033 B.n1032 185
R3610 B.n219 B.n218 185
R3611 B.n218 B.n217 185
R3612 B.n1041 B.n1040 185
R3613 B.n1042 B.n1041 185
R3614 B.n216 B.n215 185
R3615 B.n1043 B.n216 185
R3616 B.n1046 B.n1045 185
R3617 B.n1045 B.n1044 185
R3618 B.n211 B.n210 185
R3619 B.n210 B.n209 185
R3620 B.n1053 B.n1052 185
R3621 B.n1054 B.n1053 185
R3622 B.n208 B.n207 185
R3623 B.n1055 B.n208 185
R3624 B.n1058 B.n1057 185
R3625 B.n1057 B.n1056 185
R3626 B.n203 B.n202 185
R3627 B.n202 B.n201 185
R3628 B.n1065 B.n1064 185
R3629 B.n1066 B.n1065 185
R3630 B.n200 B.n199 185
R3631 B.n1067 B.n200 185
R3632 B.n1070 B.n1069 185
R3633 B.n1069 B.n1068 185
R3634 B.n195 B.n194 185
R3635 B.n194 B.n193 185
R3636 B.n1077 B.n1076 185
R3637 B.n1078 B.n1077 185
R3638 B.n192 B.n191 185
R3639 B.n1079 B.n192 185
R3640 B.n1082 B.n1081 185
R3641 B.n1081 B.n1080 185
R3642 B.n187 B.n186 185
R3643 B.n186 B.n185 185
R3644 B.n1089 B.n1088 185
R3645 B.n1090 B.n1089 185
R3646 B.n184 B.n183 185
R3647 B.n1091 B.n184 185
R3648 B.n1094 B.n1093 185
R3649 B.n1093 B.n1092 185
R3650 B.n179 B.n178 185
R3651 B.n178 B.n177 185
R3652 B.n1101 B.n1100 185
R3653 B.n1102 B.n1101 185
R3654 B.n176 B.n175 185
R3655 B.n1103 B.n176 185
R3656 B.n1106 B.n1105 185
R3657 B.n1105 B.n1104 185
R3658 B.n171 B.n170 185
R3659 B.n170 B.n169 185
R3660 B.n1113 B.n1112 185
R3661 B.n1114 B.n1113 185
R3662 B.n168 B.n167 185
R3663 B.n1115 B.n168 185
R3664 B.n1118 B.n1117 185
R3665 B.n1117 B.n1116 185
R3666 B.n163 B.n162 185
R3667 B.n162 B.n161 185
R3668 B.n1125 B.n1124 185
R3669 B.n1126 B.n1125 185
R3670 B.n160 B.n159 185
R3671 B.n1127 B.n160 185
R3672 B.n1130 B.n1129 185
R3673 B.n1129 B.n1128 185
R3674 B.n155 B.n154 185
R3675 B.n154 B.n153 185
R3676 B.n1137 B.n1136 185
R3677 B.n1138 B.n1137 185
R3678 B.n152 B.n151 185
R3679 B.n1139 B.n152 185
R3680 B.n1142 B.n1141 185
R3681 B.n1141 B.n1140 185
R3682 B.n147 B.n146 185
R3683 B.n146 B.n145 185
R3684 B.n1149 B.n1148 185
R3685 B.n1150 B.n1149 185
R3686 B.n144 B.n143 185
R3687 B.n1151 B.n144 185
R3688 B.n1154 B.n1153 185
R3689 B.n1153 B.n1152 185
R3690 B.n139 B.n138 185
R3691 B.n138 B.n137 185
R3692 B.n1161 B.n1160 185
R3693 B.n1162 B.n1161 185
R3694 B.n136 B.n135 185
R3695 B.n1163 B.n136 185
R3696 B.n1166 B.n1165 185
R3697 B.n1165 B.n1164 185
R3698 B.n131 B.n130 185
R3699 B.n130 B.n129 185
R3700 B.n1173 B.n1172 185
R3701 B.n1174 B.n1173 185
R3702 B.n128 B.n127 185
R3703 B.n1175 B.n128 185
R3704 B.n1178 B.n1177 185
R3705 B.n1177 B.n1176 185
R3706 B.n123 B.n122 185
R3707 B.n122 B.n121 185
R3708 B.n1185 B.n1184 185
R3709 B.n1186 B.n1185 185
R3710 B.n120 B.n119 185
R3711 B.n1187 B.n120 185
R3712 B.n1190 B.n1189 185
R3713 B.n1189 B.n1188 185
R3714 B.n115 B.n114 185
R3715 B.n114 B.n113 185
R3716 B.n1197 B.n1196 185
R3717 B.n1198 B.n1197 185
R3718 B.n112 B.n111 185
R3719 B.n1199 B.n112 185
R3720 B.n1202 B.n1201 185
R3721 B.n1201 B.n1200 185
R3722 B.n107 B.n106 185
R3723 B.n106 B.n105 185
R3724 B.n1209 B.n1208 185
R3725 B.n1210 B.n1209 185
R3726 B.n104 B.n103 185
R3727 B.n1211 B.n104 185
R3728 B.n1214 B.n1213 185
R3729 B.n1213 B.n1212 185
R3730 B.n99 B.n98 185
R3731 B.n98 B.n97 185
R3732 B.n1221 B.n1220 185
R3733 B.n1222 B.n1221 185
R3734 B.n96 B.n95 185
R3735 B.n1223 B.n96 185
R3736 B.n1226 B.n1225 185
R3737 B.n1225 B.n1224 185
R3738 B.n91 B.n90 185
R3739 B.n90 B.n89 185
R3740 B.n1233 B.n1232 185
R3741 B.n1234 B.n1233 185
R3742 B.n88 B.n87 185
R3743 B.n1235 B.n88 185
R3744 B.n1238 B.n1237 185
R3745 B.n1237 B.n1236 185
R3746 B.n83 B.n82 185
R3747 B.n82 B.n81 185
R3748 B.n1245 B.n1244 185
R3749 B.n1246 B.n1245 185
R3750 B.n80 B.n79 185
R3751 B.n1247 B.n80 185
R3752 B.n1250 B.n1249 185
R3753 B.n1249 B.n1248 185
R3754 B.n75 B.n74 185
R3755 B.n74 B.n73 185
R3756 B.n1257 B.n1256 185
R3757 B.n1258 B.n1257 185
R3758 B.n72 B.n71 185
R3759 B.n1259 B.n72 185
R3760 B.n1262 B.n1261 185
R3761 B.n1261 B.n1260 185
R3762 B.n67 B.n66 185
R3763 B.n66 B.n65 185
R3764 B.n1269 B.n1268 185
R3765 B.n1270 B.n1269 185
R3766 B.n64 B.n63 185
R3767 B.n1271 B.n64 185
R3768 B.n1274 B.n1273 185
R3769 B.n1273 B.n1272 185
R3770 B.n59 B.n58 185
R3771 B.n58 B.n57 185
R3772 B.n1281 B.n1280 185
R3773 B.n1282 B.n1281 185
R3774 B.n56 B.n55 185
R3775 B.n1283 B.n56 185
R3776 B.n1286 B.n1285 185
R3777 B.n1285 B.n1284 185
R3778 B.n51 B.n50 185
R3779 B.n50 B.n49 185
R3780 B.n1293 B.n1292 185
R3781 B.n1294 B.n1293 185
R3782 B.n48 B.n47 185
R3783 B.n1295 B.n48 185
R3784 B.n1298 B.n1297 185
R3785 B.n1297 B.n1296 185
R3786 B.n43 B.n42 185
R3787 B.n42 B.n41 185
R3788 B.n1305 B.n1304 185
R3789 B.n1306 B.n1305 185
R3790 B.n40 B.n39 185
R3791 B.n1307 B.n40 185
R3792 B.n1310 B.n1309 185
R3793 B.n1309 B.n1308 185
R3794 B.n35 B.n34 185
R3795 B.n34 B.n33 185
R3796 B.n1317 B.n1316 185
R3797 B.n1318 B.n1317 185
R3798 B.n32 B.n31 185
R3799 B.n1319 B.n32 185
R3800 B.n1322 B.n1321 185
R3801 B.n1321 B.n1320 185
R3802 B.n27 B.n26 185
R3803 B.n26 B.n25 185
R3804 B.n1329 B.n1328 185
R3805 B.n1330 B.n1329 185
R3806 B.n24 B.n23 185
R3807 B.n1331 B.n24 185
R3808 B.n1334 B.n1333 185
R3809 B.n1333 B.n1332 185
R3810 B.n19 B.n18 185
R3811 B.n18 B.n17 185
R3812 B.n1341 B.n1340 185
R3813 B.n1342 B.n1341 185
R3814 B.n16 B.n15 185
R3815 B.n1343 B.n16 185
R3816 B.n1346 B.n1345 185
R3817 B.n1345 B.n1344 185
R3818 B.n11 B.n10 185
R3819 B.n10 B.n9 185
R3820 B.n1354 B.n1353 185
R3821 B.n1355 B.n1354 185
R3822 B.n6 B.n5 185
R3823 B.n1356 B.n6 185
R3824 B.n1361 B.n1360 185
R3825 B.n1360 B.n1359 185
R3826 B.n1361 B.n5 119.63
R3827 B.n1353 B.n5 119.63
R3828 B.n1353 B.n11 119.63
R3829 B.n1346 B.n11 119.63
R3830 B.n1346 B.n15 119.63
R3831 B.n1340 B.n15 119.63
R3832 B.n1340 B.n19 119.63
R3833 B.n1334 B.n19 119.63
R3834 B.n1334 B.n23 119.63
R3835 B.n1328 B.n23 119.63
R3836 B.n1328 B.n27 119.63
R3837 B.n1322 B.n27 119.63
R3838 B.n1322 B.n31 119.63
R3839 B.n1316 B.n31 119.63
R3840 B.n1316 B.n35 119.63
R3841 B.n1310 B.n35 119.63
R3842 B.n1310 B.n39 119.63
R3843 B.n1304 B.n39 119.63
R3844 B.n1304 B.n43 119.63
R3845 B.n1298 B.n43 119.63
R3846 B.n1298 B.n47 119.63
R3847 B.n1292 B.n47 119.63
R3848 B.n1292 B.n51 119.63
R3849 B.n1286 B.n51 119.63
R3850 B.n1286 B.n55 119.63
R3851 B.n1280 B.n55 119.63
R3852 B.n1280 B.n59 119.63
R3853 B.n1274 B.n59 119.63
R3854 B.n1274 B.n63 119.63
R3855 B.n1268 B.n63 119.63
R3856 B.n1268 B.n67 119.63
R3857 B.n1262 B.n67 119.63
R3858 B.n1262 B.n71 119.63
R3859 B.n1256 B.n71 119.63
R3860 B.n1256 B.n75 119.63
R3861 B.n1250 B.n75 119.63
R3862 B.n1250 B.n79 119.63
R3863 B.n1244 B.n79 119.63
R3864 B.n1244 B.n83 119.63
R3865 B.n1238 B.n83 119.63
R3866 B.n1238 B.n87 119.63
R3867 B.n1232 B.n87 119.63
R3868 B.n1232 B.n91 119.63
R3869 B.n1226 B.n91 119.63
R3870 B.n1226 B.n95 119.63
R3871 B.n1220 B.n95 119.63
R3872 B.n1220 B.n99 119.63
R3873 B.n1214 B.n99 119.63
R3874 B.n1214 B.n103 119.63
R3875 B.n1208 B.n103 119.63
R3876 B.n1208 B.n107 119.63
R3877 B.n1202 B.n107 119.63
R3878 B.n1202 B.n111 119.63
R3879 B.n1196 B.n111 119.63
R3880 B.n1196 B.n115 119.63
R3881 B.n1190 B.n115 119.63
R3882 B.n1190 B.n119 119.63
R3883 B.n1184 B.n119 119.63
R3884 B.n1184 B.n123 119.63
R3885 B.n1178 B.n123 119.63
R3886 B.n1178 B.n127 119.63
R3887 B.n1172 B.n127 119.63
R3888 B.n1172 B.n131 119.63
R3889 B.n1166 B.n131 119.63
R3890 B.n1166 B.n135 119.63
R3891 B.n1160 B.n135 119.63
R3892 B.n1160 B.n139 119.63
R3893 B.n1154 B.n139 119.63
R3894 B.n1154 B.n143 119.63
R3895 B.n1148 B.n143 119.63
R3896 B.n1148 B.n147 119.63
R3897 B.n1142 B.n147 119.63
R3898 B.n1142 B.n151 119.63
R3899 B.n1136 B.n151 119.63
R3900 B.n1136 B.n155 119.63
R3901 B.n1130 B.n155 119.63
R3902 B.n1130 B.n159 119.63
R3903 B.n1124 B.n159 119.63
R3904 B.n1124 B.n163 119.63
R3905 B.n1118 B.n163 119.63
R3906 B.n1118 B.n167 119.63
R3907 B.n1112 B.n167 119.63
R3908 B.n1112 B.n171 119.63
R3909 B.n1106 B.n171 119.63
R3910 B.n1106 B.n175 119.63
R3911 B.n1100 B.n175 119.63
R3912 B.n1100 B.n179 119.63
R3913 B.n1094 B.n179 119.63
R3914 B.n1094 B.n183 119.63
R3915 B.n1088 B.n183 119.63
R3916 B.n1088 B.n187 119.63
R3917 B.n1082 B.n187 119.63
R3918 B.n1082 B.n191 119.63
R3919 B.n1076 B.n191 119.63
R3920 B.n1076 B.n195 119.63
R3921 B.n1070 B.n195 119.63
R3922 B.n1070 B.n199 119.63
R3923 B.n1064 B.n199 119.63
R3924 B.n1064 B.n203 119.63
R3925 B.n1058 B.n203 119.63
R3926 B.n1058 B.n207 119.63
R3927 B.n1052 B.n207 119.63
R3928 B.n1052 B.n211 119.63
R3929 B.n1046 B.n211 119.63
R3930 B.n1046 B.n215 119.63
R3931 B.n1040 B.n215 119.63
R3932 B.n1040 B.n219 119.63
R3933 B.n1034 B.n219 119.63
R3934 B.n1034 B.n223 119.63
R3935 B.n1028 B.n223 119.63
R3936 B.n1028 B.n227 119.63
R3937 B.n1022 B.n227 119.63
R3938 B.n1022 B.n231 119.63
R3939 B.n1016 B.n231 119.63
R3940 B.n1016 B.n235 119.63
R3941 B.n1010 B.n235 119.63
R3942 B.n1010 B.n239 119.63
R3943 B.n1004 B.n239 119.63
R3944 B.n1004 B.n243 119.63
R3945 B.n998 B.n243 119.63
R3946 B.n998 B.n247 119.63
R3947 B.n992 B.n247 119.63
R3948 B.n992 B.n251 119.63
R3949 B.n986 B.n251 119.63
R3950 B.n986 B.n255 119.63
R3951 B.n980 B.n255 119.63
R3952 B.n980 B.n259 119.63
R3953 B.n974 B.n259 119.63
R3954 B.n974 B.n263 119.63
R3955 B.n968 B.n263 119.63
R3956 B.n968 B.n267 119.63
R3957 B.n962 B.n267 119.63
R3958 B.n962 B.n271 119.63
R3959 B.n956 B.n271 119.63
R3960 B.n956 B.n275 119.63
R3961 B.n950 B.n275 119.63
R3962 B.n950 B.n279 119.63
R3963 B.n944 B.n279 119.63
R3964 B.n944 B.n283 119.63
R3965 B.n938 B.n283 119.63
R3966 B.n938 B.n287 119.63
R3967 B.n932 B.n287 119.63
R3968 B.n932 B.n291 119.63
R3969 B.n926 B.n291 119.63
R3970 B.n926 B.n295 119.63
R3971 B.n920 B.n295 119.63
R3972 B.n920 B.n299 119.63
R3973 B.n914 B.n299 119.63
R3974 B.n914 B.n303 119.63
R3975 B.n908 B.n303 119.63
R3976 B.n908 B.n307 119.63
R3977 B.n902 B.n307 119.63
R3978 B.n902 B.n311 119.63
R3979 B.n896 B.n311 119.63
R3980 B.n896 B.n315 119.63
R3981 B.n890 B.n315 119.63
R3982 B.n890 B.n319 119.63
R3983 B.n884 B.n319 119.63
R3984 B.n884 B.n323 119.63
R3985 B.n878 B.n323 119.63
R3986 B.n878 B.n327 119.63
R3987 B.n872 B.n327 119.63
R3988 B.n872 B.n331 119.63
R3989 B.n866 B.n331 119.63
R3990 B.n866 B.n335 119.63
R3991 B.n860 B.n335 119.63
R3992 B.n860 B.n339 119.63
R3993 B.n854 B.n339 119.63
R3994 B.n854 B.n343 119.63
R3995 B.n848 B.n343 119.63
R3996 B.n848 B.n347 119.63
R3997 B.n842 B.n347 119.63
R3998 B.n842 B.n351 119.63
R3999 B.n836 B.n351 119.63
R4000 B.n836 B.n355 119.63
R4001 B.n830 B.n355 119.63
R4002 B.n830 B.n359 119.63
R4003 B.n824 B.n359 119.63
R4004 B.n824 B.n363 119.63
R4005 B.n818 B.n363 119.63
R4006 B.n818 B.n367 119.63
R4007 B.n812 B.n367 119.63
R4008 B.n812 B.n371 119.63
R4009 B.n806 B.n371 119.63
R4010 B.n806 B.n375 119.63
R4011 B.n800 B.n375 119.63
R4012 B.n800 B.n379 119.63
R4013 B.n794 B.n379 119.63
R4014 B.n794 B.n383 119.63
R4015 B.n788 B.n383 119.63
R4016 B.n788 B.n387 119.63
R4017 B.n782 B.n387 119.63
R4018 B.n782 B.n391 119.63
R4019 B.n776 B.n391 119.63
R4020 B.n776 B.n395 119.63
R4021 B.n770 B.n395 119.63
R4022 B.n770 B.n399 119.63
R4023 B.n764 B.n399 119.63
R4024 B.n764 B.n403 119.63
R4025 B.n758 B.n403 119.63
R4026 B.n758 B.n407 119.63
R4027 B.n752 B.n407 119.63
R4028 B.n752 B.n411 119.63
R4029 B.n746 B.n411 119.63
R4030 B.n746 B.n415 119.63
R4031 B.n740 B.n415 119.63
R4032 B.n740 B.n419 119.63
R4033 B.n734 B.n419 119.63
R4034 B.n734 B.n423 119.63
R4035 B.n728 B.n423 119.63
R4036 B.n728 B.n427 119.63
R4037 B.n722 B.n427 119.63
R4038 B.n722 B.n431 119.63
R4039 B.n716 B.n431 119.63
R4040 B.n716 B.n435 119.63
R4041 B.n710 B.n435 119.63
R4042 B.n710 B.n439 119.63
R4043 B.n704 B.n439 119.63
R4044 B.n704 B.n443 119.63
R4045 B.n698 B.n443 119.63
R4046 B.n698 B.n447 119.63
R4047 B.n692 B.n447 119.63
R4048 B.n692 B.n451 119.63
R4049 B.n686 B.n451 119.63
R4050 B.n686 B.n455 119.63
R4051 B.n680 B.n455 119.63
R4052 B.n680 B.n459 119.63
R4053 B.n674 B.n459 119.63
R4054 B.n674 B.n463 119.63
R4055 B.n668 B.n463 119.63
R4056 B.n668 B.n467 119.63
R4057 B.n662 B.n467 119.63
R4058 B.n662 B.n471 119.63
R4059 B.n656 B.n471 119.63
R4060 B.n656 B.n475 119.63
R4061 B.n650 B.n475 119.63
R4062 B.n650 B.n479 119.63
R4063 B.n644 B.n479 119.63
R4064 B.n644 B.n483 119.63
R4065 B.n638 B.n483 119.63
R4066 B.n638 B.n487 119.63
R4067 B.n632 B.n487 119.63
R4068 B.n632 B.n491 119.63
R4069 B.n626 B.n491 119.63
R4070 B.n626 B.n495 119.63
R4071 B.n620 B.n495 119.63
R4072 B.n620 B.n499 119.63
R4073 B.n614 B.n499 119.63
R4074 B.n614 B.n503 119.63
R4075 B.n608 B.n503 119.63
R4076 B.n608 B.n507 119.63
R4077 B.n602 B.n507 119.63
R4078 B.n602 B.n511 119.63
R4079 B.n596 B.n511 119.63
R4080 B.n596 B.n515 119.63
R4081 B.n590 B.n515 119.63
R4082 B.n590 B.n519 119.63
R4083 B.n584 B.n519 119.63
R4084 B.n584 B.n523 119.63
R4085 B.n578 B.n523 119.63
R4086 B.n578 B.n527 119.63
R4087 B.n572 B.n527 119.63
R4088 B.n572 B.n531 119.63
R4089 B.n566 B.n531 119.63
R4090 B.n566 B.n535 119.63
R4091 B.n560 B.n535 119.63
R4092 B.n560 B.n539 119.63
R4093 B.n554 B.n539 119.63
R4094 B.n4 B.n0 80.9417
R4095 B.n556 B.n541 80.9417
R4096 B.n1359 B.n1358 80.9417
R4097 B.n552 B.n551 80.9417
R4098 B.n8 B.n7 72.7879
R4099 B.n1365 B.n1364 72.7879
R4100 B.n546 B.n542 72.7879
R4101 B.n549 B.n548 72.7879
R4102 B.n1364 B.n1363 72.7879
R4103 B.n7 B.n1 72.7879
R4104 B.n547 B.n546 72.7879
R4105 B.n548 B.n544 72.7879
R4106 B.n7 B.n2 56.1076
R4107 B.n1364 B.n2 56.1076
R4108 B.n546 B.n543 56.1076
R4109 B.n548 B.n543 56.1076
R4110 B.n1366 B.n0 25.6005
R4111 B.n1358 B.n1357 25.6005
R4112 B.n1350 B.n4 25.6005
R4113 B.n1351 B.n1350 25.6005
R4114 B.n1351 B.n1349 25.6005
R4115 B.n1349 B.n1348 25.6005
R4116 B.n1348 B.n13 25.6005
R4117 B.n1338 B.n13 25.6005
R4118 B.n1338 B.n1337 25.6005
R4119 B.n1337 B.n1336 25.6005
R4120 B.n1336 B.n21 25.6005
R4121 B.n1326 B.n21 25.6005
R4122 B.n1326 B.n1325 25.6005
R4123 B.n1325 B.n1324 25.6005
R4124 B.n1324 B.n29 25.6005
R4125 B.n1314 B.n29 25.6005
R4126 B.n1314 B.n1313 25.6005
R4127 B.n1313 B.n1312 25.6005
R4128 B.n1312 B.n37 25.6005
R4129 B.n1302 B.n37 25.6005
R4130 B.n1302 B.n1301 25.6005
R4131 B.n1301 B.n1300 25.6005
R4132 B.n1300 B.n45 25.6005
R4133 B.n1290 B.n45 25.6005
R4134 B.n1290 B.n1289 25.6005
R4135 B.n1289 B.n1288 25.6005
R4136 B.n1288 B.n53 25.6005
R4137 B.n1278 B.n53 25.6005
R4138 B.n1278 B.n1277 25.6005
R4139 B.n1277 B.n1276 25.6005
R4140 B.n1276 B.n61 25.6005
R4141 B.n1266 B.n61 25.6005
R4142 B.n1266 B.n1265 25.6005
R4143 B.n1265 B.n1264 25.6005
R4144 B.n1264 B.n69 25.6005
R4145 B.n1254 B.n69 25.6005
R4146 B.n1254 B.n1253 25.6005
R4147 B.n1253 B.n1252 25.6005
R4148 B.n1252 B.n77 25.6005
R4149 B.n1242 B.n77 25.6005
R4150 B.n1242 B.n1241 25.6005
R4151 B.n1241 B.n1240 25.6005
R4152 B.n1240 B.n85 25.6005
R4153 B.n1230 B.n85 25.6005
R4154 B.n1230 B.n1229 25.6005
R4155 B.n1229 B.n1228 25.6005
R4156 B.n1228 B.n93 25.6005
R4157 B.n1218 B.n93 25.6005
R4158 B.n1218 B.n1217 25.6005
R4159 B.n1217 B.n1216 25.6005
R4160 B.n1216 B.n101 25.6005
R4161 B.n1206 B.n101 25.6005
R4162 B.n1206 B.n1205 25.6005
R4163 B.n1205 B.n1204 25.6005
R4164 B.n1204 B.n109 25.6005
R4165 B.n1194 B.n109 25.6005
R4166 B.n1194 B.n1193 25.6005
R4167 B.n1193 B.n1192 25.6005
R4168 B.n1192 B.n117 25.6005
R4169 B.n1182 B.n117 25.6005
R4170 B.n1182 B.n1181 25.6005
R4171 B.n1181 B.n1180 25.6005
R4172 B.n1180 B.n125 25.6005
R4173 B.n1170 B.n125 25.6005
R4174 B.n1170 B.n1169 25.6005
R4175 B.n1169 B.n1168 25.6005
R4176 B.n1168 B.n133 25.6005
R4177 B.n1158 B.n133 25.6005
R4178 B.n1158 B.n1157 25.6005
R4179 B.n1157 B.n1156 25.6005
R4180 B.n1156 B.n141 25.6005
R4181 B.n1146 B.n141 25.6005
R4182 B.n1146 B.n1145 25.6005
R4183 B.n1145 B.n1144 25.6005
R4184 B.n1144 B.n149 25.6005
R4185 B.n1134 B.n149 25.6005
R4186 B.n1134 B.n1133 25.6005
R4187 B.n1133 B.n1132 25.6005
R4188 B.n1132 B.n157 25.6005
R4189 B.n1122 B.n157 25.6005
R4190 B.n1122 B.n1121 25.6005
R4191 B.n1121 B.n1120 25.6005
R4192 B.n1120 B.n165 25.6005
R4193 B.n1110 B.n165 25.6005
R4194 B.n1110 B.n1109 25.6005
R4195 B.n1109 B.n1108 25.6005
R4196 B.n1108 B.n173 25.6005
R4197 B.n1098 B.n173 25.6005
R4198 B.n1098 B.n1097 25.6005
R4199 B.n1097 B.n1096 25.6005
R4200 B.n1096 B.n181 25.6005
R4201 B.n1086 B.n181 25.6005
R4202 B.n1086 B.n1085 25.6005
R4203 B.n1085 B.n1084 25.6005
R4204 B.n1084 B.n189 25.6005
R4205 B.n1074 B.n189 25.6005
R4206 B.n1074 B.n1073 25.6005
R4207 B.n1073 B.n1072 25.6005
R4208 B.n1072 B.n197 25.6005
R4209 B.n1062 B.n197 25.6005
R4210 B.n1062 B.n1061 25.6005
R4211 B.n1061 B.n1060 25.6005
R4212 B.n1060 B.n205 25.6005
R4213 B.n1050 B.n205 25.6005
R4214 B.n1050 B.n1049 25.6005
R4215 B.n1049 B.n1048 25.6005
R4216 B.n1048 B.n213 25.6005
R4217 B.n1038 B.n213 25.6005
R4218 B.n1038 B.n1037 25.6005
R4219 B.n1037 B.n1036 25.6005
R4220 B.n1036 B.n221 25.6005
R4221 B.n1026 B.n221 25.6005
R4222 B.n1026 B.n1025 25.6005
R4223 B.n1025 B.n1024 25.6005
R4224 B.n1024 B.n229 25.6005
R4225 B.n1014 B.n229 25.6005
R4226 B.n1014 B.n1013 25.6005
R4227 B.n1013 B.n1012 25.6005
R4228 B.n1012 B.n237 25.6005
R4229 B.n1002 B.n237 25.6005
R4230 B.n1002 B.n1001 25.6005
R4231 B.n1001 B.n1000 25.6005
R4232 B.n1000 B.n245 25.6005
R4233 B.n990 B.n245 25.6005
R4234 B.n990 B.n989 25.6005
R4235 B.n989 B.n988 25.6005
R4236 B.n988 B.n253 25.6005
R4237 B.n978 B.n253 25.6005
R4238 B.n978 B.n977 25.6005
R4239 B.n977 B.n976 25.6005
R4240 B.n976 B.n261 25.6005
R4241 B.n966 B.n261 25.6005
R4242 B.n966 B.n965 25.6005
R4243 B.n965 B.n964 25.6005
R4244 B.n964 B.n269 25.6005
R4245 B.n954 B.n269 25.6005
R4246 B.n954 B.n953 25.6005
R4247 B.n953 B.n952 25.6005
R4248 B.n952 B.n277 25.6005
R4249 B.n942 B.n277 25.6005
R4250 B.n942 B.n941 25.6005
R4251 B.n941 B.n940 25.6005
R4252 B.n940 B.n285 25.6005
R4253 B.n930 B.n285 25.6005
R4254 B.n930 B.n929 25.6005
R4255 B.n929 B.n928 25.6005
R4256 B.n928 B.n293 25.6005
R4257 B.n918 B.n293 25.6005
R4258 B.n918 B.n917 25.6005
R4259 B.n917 B.n916 25.6005
R4260 B.n916 B.n301 25.6005
R4261 B.n906 B.n301 25.6005
R4262 B.n906 B.n905 25.6005
R4263 B.n905 B.n904 25.6005
R4264 B.n904 B.n309 25.6005
R4265 B.n894 B.n309 25.6005
R4266 B.n894 B.n893 25.6005
R4267 B.n893 B.n892 25.6005
R4268 B.n892 B.n317 25.6005
R4269 B.n882 B.n317 25.6005
R4270 B.n882 B.n881 25.6005
R4271 B.n881 B.n880 25.6005
R4272 B.n880 B.n325 25.6005
R4273 B.n870 B.n325 25.6005
R4274 B.n870 B.n869 25.6005
R4275 B.n869 B.n868 25.6005
R4276 B.n868 B.n333 25.6005
R4277 B.n858 B.n333 25.6005
R4278 B.n858 B.n857 25.6005
R4279 B.n857 B.n856 25.6005
R4280 B.n856 B.n341 25.6005
R4281 B.n846 B.n341 25.6005
R4282 B.n846 B.n845 25.6005
R4283 B.n845 B.n844 25.6005
R4284 B.n844 B.n349 25.6005
R4285 B.n834 B.n349 25.6005
R4286 B.n834 B.n833 25.6005
R4287 B.n833 B.n832 25.6005
R4288 B.n832 B.n357 25.6005
R4289 B.n822 B.n357 25.6005
R4290 B.n822 B.n821 25.6005
R4291 B.n821 B.n820 25.6005
R4292 B.n820 B.n365 25.6005
R4293 B.n810 B.n365 25.6005
R4294 B.n810 B.n809 25.6005
R4295 B.n809 B.n808 25.6005
R4296 B.n808 B.n373 25.6005
R4297 B.n798 B.n373 25.6005
R4298 B.n798 B.n797 25.6005
R4299 B.n797 B.n796 25.6005
R4300 B.n796 B.n381 25.6005
R4301 B.n786 B.n381 25.6005
R4302 B.n786 B.n785 25.6005
R4303 B.n785 B.n784 25.6005
R4304 B.n784 B.n389 25.6005
R4305 B.n774 B.n389 25.6005
R4306 B.n774 B.n773 25.6005
R4307 B.n773 B.n772 25.6005
R4308 B.n772 B.n397 25.6005
R4309 B.n762 B.n397 25.6005
R4310 B.n762 B.n761 25.6005
R4311 B.n761 B.n760 25.6005
R4312 B.n760 B.n405 25.6005
R4313 B.n750 B.n405 25.6005
R4314 B.n750 B.n749 25.6005
R4315 B.n749 B.n748 25.6005
R4316 B.n748 B.n413 25.6005
R4317 B.n738 B.n413 25.6005
R4318 B.n738 B.n737 25.6005
R4319 B.n737 B.n736 25.6005
R4320 B.n736 B.n421 25.6005
R4321 B.n726 B.n421 25.6005
R4322 B.n726 B.n725 25.6005
R4323 B.n725 B.n724 25.6005
R4324 B.n724 B.n429 25.6005
R4325 B.n714 B.n429 25.6005
R4326 B.n714 B.n713 25.6005
R4327 B.n713 B.n712 25.6005
R4328 B.n712 B.n437 25.6005
R4329 B.n702 B.n437 25.6005
R4330 B.n702 B.n701 25.6005
R4331 B.n701 B.n700 25.6005
R4332 B.n700 B.n445 25.6005
R4333 B.n690 B.n445 25.6005
R4334 B.n690 B.n689 25.6005
R4335 B.n689 B.n688 25.6005
R4336 B.n688 B.n453 25.6005
R4337 B.n678 B.n453 25.6005
R4338 B.n678 B.n677 25.6005
R4339 B.n677 B.n676 25.6005
R4340 B.n676 B.n461 25.6005
R4341 B.n666 B.n461 25.6005
R4342 B.n666 B.n665 25.6005
R4343 B.n665 B.n664 25.6005
R4344 B.n664 B.n469 25.6005
R4345 B.n654 B.n469 25.6005
R4346 B.n654 B.n653 25.6005
R4347 B.n653 B.n652 25.6005
R4348 B.n652 B.n477 25.6005
R4349 B.n642 B.n477 25.6005
R4350 B.n642 B.n641 25.6005
R4351 B.n641 B.n640 25.6005
R4352 B.n640 B.n485 25.6005
R4353 B.n630 B.n485 25.6005
R4354 B.n630 B.n629 25.6005
R4355 B.n629 B.n628 25.6005
R4356 B.n628 B.n493 25.6005
R4357 B.n618 B.n493 25.6005
R4358 B.n618 B.n617 25.6005
R4359 B.n617 B.n616 25.6005
R4360 B.n616 B.n501 25.6005
R4361 B.n606 B.n501 25.6005
R4362 B.n606 B.n605 25.6005
R4363 B.n605 B.n604 25.6005
R4364 B.n604 B.n509 25.6005
R4365 B.n594 B.n509 25.6005
R4366 B.n594 B.n593 25.6005
R4367 B.n593 B.n592 25.6005
R4368 B.n592 B.n517 25.6005
R4369 B.n582 B.n517 25.6005
R4370 B.n582 B.n581 25.6005
R4371 B.n581 B.n580 25.6005
R4372 B.n580 B.n525 25.6005
R4373 B.n570 B.n525 25.6005
R4374 B.n570 B.n569 25.6005
R4375 B.n569 B.n568 25.6005
R4376 B.n568 B.n533 25.6005
R4377 B.n558 B.n533 25.6005
R4378 B.n558 B.n557 25.6005
R4379 B.n557 B.n556 25.6005
R4380 B.n545 B.n541 25.6005
R4381 B.n550 B.n545 25.6005
R4382 B.n551 B.n550 25.6005
R4383 B.n1359 B.n1356 25.6005
R4384 B.n1356 B.n1355 25.6005
R4385 B.n1355 B.n9 25.6005
R4386 B.n1344 B.n9 25.6005
R4387 B.n1344 B.n1343 25.6005
R4388 B.n1343 B.n1342 25.6005
R4389 B.n1342 B.n17 25.6005
R4390 B.n1332 B.n17 25.6005
R4391 B.n1332 B.n1331 25.6005
R4392 B.n1331 B.n1330 25.6005
R4393 B.n1330 B.n25 25.6005
R4394 B.n1320 B.n25 25.6005
R4395 B.n1320 B.n1319 25.6005
R4396 B.n1319 B.n1318 25.6005
R4397 B.n1318 B.n33 25.6005
R4398 B.n1308 B.n33 25.6005
R4399 B.n1308 B.n1307 25.6005
R4400 B.n1307 B.n1306 25.6005
R4401 B.n1306 B.n41 25.6005
R4402 B.n1296 B.n41 25.6005
R4403 B.n1296 B.n1295 25.6005
R4404 B.n1295 B.n1294 25.6005
R4405 B.n1294 B.n49 25.6005
R4406 B.n1284 B.n49 25.6005
R4407 B.n1284 B.n1283 25.6005
R4408 B.n1283 B.n1282 25.6005
R4409 B.n1282 B.n57 25.6005
R4410 B.n1272 B.n57 25.6005
R4411 B.n1272 B.n1271 25.6005
R4412 B.n1271 B.n1270 25.6005
R4413 B.n1270 B.n65 25.6005
R4414 B.n1260 B.n65 25.6005
R4415 B.n1260 B.n1259 25.6005
R4416 B.n1259 B.n1258 25.6005
R4417 B.n1258 B.n73 25.6005
R4418 B.n1248 B.n73 25.6005
R4419 B.n1248 B.n1247 25.6005
R4420 B.n1247 B.n1246 25.6005
R4421 B.n1246 B.n81 25.6005
R4422 B.n1236 B.n81 25.6005
R4423 B.n1236 B.n1235 25.6005
R4424 B.n1235 B.n1234 25.6005
R4425 B.n1234 B.n89 25.6005
R4426 B.n1224 B.n89 25.6005
R4427 B.n1224 B.n1223 25.6005
R4428 B.n1223 B.n1222 25.6005
R4429 B.n1222 B.n97 25.6005
R4430 B.n1212 B.n97 25.6005
R4431 B.n1212 B.n1211 25.6005
R4432 B.n1211 B.n1210 25.6005
R4433 B.n1210 B.n105 25.6005
R4434 B.n1200 B.n105 25.6005
R4435 B.n1200 B.n1199 25.6005
R4436 B.n1199 B.n1198 25.6005
R4437 B.n1198 B.n113 25.6005
R4438 B.n1188 B.n113 25.6005
R4439 B.n1188 B.n1187 25.6005
R4440 B.n1187 B.n1186 25.6005
R4441 B.n1186 B.n121 25.6005
R4442 B.n1176 B.n121 25.6005
R4443 B.n1176 B.n1175 25.6005
R4444 B.n1175 B.n1174 25.6005
R4445 B.n1174 B.n129 25.6005
R4446 B.n1164 B.n129 25.6005
R4447 B.n1164 B.n1163 25.6005
R4448 B.n1163 B.n1162 25.6005
R4449 B.n1162 B.n137 25.6005
R4450 B.n1152 B.n137 25.6005
R4451 B.n1152 B.n1151 25.6005
R4452 B.n1151 B.n1150 25.6005
R4453 B.n1150 B.n145 25.6005
R4454 B.n1140 B.n145 25.6005
R4455 B.n1140 B.n1139 25.6005
R4456 B.n1139 B.n1138 25.6005
R4457 B.n1138 B.n153 25.6005
R4458 B.n1128 B.n153 25.6005
R4459 B.n1128 B.n1127 25.6005
R4460 B.n1127 B.n1126 25.6005
R4461 B.n1126 B.n161 25.6005
R4462 B.n1116 B.n161 25.6005
R4463 B.n1116 B.n1115 25.6005
R4464 B.n1115 B.n1114 25.6005
R4465 B.n1114 B.n169 25.6005
R4466 B.n1104 B.n169 25.6005
R4467 B.n1104 B.n1103 25.6005
R4468 B.n1103 B.n1102 25.6005
R4469 B.n1102 B.n177 25.6005
R4470 B.n1092 B.n177 25.6005
R4471 B.n1092 B.n1091 25.6005
R4472 B.n1091 B.n1090 25.6005
R4473 B.n1090 B.n185 25.6005
R4474 B.n1080 B.n185 25.6005
R4475 B.n1080 B.n1079 25.6005
R4476 B.n1079 B.n1078 25.6005
R4477 B.n1078 B.n193 25.6005
R4478 B.n1068 B.n193 25.6005
R4479 B.n1068 B.n1067 25.6005
R4480 B.n1067 B.n1066 25.6005
R4481 B.n1066 B.n201 25.6005
R4482 B.n1056 B.n201 25.6005
R4483 B.n1056 B.n1055 25.6005
R4484 B.n1055 B.n1054 25.6005
R4485 B.n1054 B.n209 25.6005
R4486 B.n1044 B.n209 25.6005
R4487 B.n1044 B.n1043 25.6005
R4488 B.n1043 B.n1042 25.6005
R4489 B.n1042 B.n217 25.6005
R4490 B.n1032 B.n217 25.6005
R4491 B.n1032 B.n1031 25.6005
R4492 B.n1031 B.n1030 25.6005
R4493 B.n1030 B.n225 25.6005
R4494 B.n1020 B.n225 25.6005
R4495 B.n1020 B.n1019 25.6005
R4496 B.n1019 B.n1018 25.6005
R4497 B.n1018 B.n233 25.6005
R4498 B.n1008 B.n233 25.6005
R4499 B.n1008 B.n1007 25.6005
R4500 B.n1007 B.n1006 25.6005
R4501 B.n1006 B.n241 25.6005
R4502 B.n996 B.n241 25.6005
R4503 B.n996 B.n995 25.6005
R4504 B.n995 B.n994 25.6005
R4505 B.n994 B.n249 25.6005
R4506 B.n984 B.n249 25.6005
R4507 B.n984 B.n983 25.6005
R4508 B.n983 B.n982 25.6005
R4509 B.n982 B.n257 25.6005
R4510 B.n972 B.n257 25.6005
R4511 B.n972 B.n971 25.6005
R4512 B.n971 B.n970 25.6005
R4513 B.n970 B.n265 25.6005
R4514 B.n960 B.n265 25.6005
R4515 B.n960 B.n959 25.6005
R4516 B.n959 B.n958 25.6005
R4517 B.n958 B.n273 25.6005
R4518 B.n948 B.n273 25.6005
R4519 B.n948 B.n947 25.6005
R4520 B.n947 B.n946 25.6005
R4521 B.n946 B.n281 25.6005
R4522 B.n936 B.n281 25.6005
R4523 B.n936 B.n935 25.6005
R4524 B.n935 B.n934 25.6005
R4525 B.n934 B.n289 25.6005
R4526 B.n924 B.n289 25.6005
R4527 B.n924 B.n923 25.6005
R4528 B.n923 B.n922 25.6005
R4529 B.n922 B.n297 25.6005
R4530 B.n912 B.n297 25.6005
R4531 B.n912 B.n911 25.6005
R4532 B.n911 B.n910 25.6005
R4533 B.n910 B.n305 25.6005
R4534 B.n900 B.n305 25.6005
R4535 B.n900 B.n899 25.6005
R4536 B.n899 B.n898 25.6005
R4537 B.n898 B.n313 25.6005
R4538 B.n888 B.n313 25.6005
R4539 B.n888 B.n887 25.6005
R4540 B.n887 B.n886 25.6005
R4541 B.n886 B.n321 25.6005
R4542 B.n876 B.n321 25.6005
R4543 B.n876 B.n875 25.6005
R4544 B.n875 B.n874 25.6005
R4545 B.n874 B.n329 25.6005
R4546 B.n864 B.n329 25.6005
R4547 B.n864 B.n863 25.6005
R4548 B.n863 B.n862 25.6005
R4549 B.n862 B.n337 25.6005
R4550 B.n852 B.n337 25.6005
R4551 B.n852 B.n851 25.6005
R4552 B.n851 B.n850 25.6005
R4553 B.n850 B.n345 25.6005
R4554 B.n840 B.n345 25.6005
R4555 B.n840 B.n839 25.6005
R4556 B.n839 B.n838 25.6005
R4557 B.n838 B.n353 25.6005
R4558 B.n828 B.n353 25.6005
R4559 B.n828 B.n827 25.6005
R4560 B.n827 B.n826 25.6005
R4561 B.n826 B.n361 25.6005
R4562 B.n816 B.n361 25.6005
R4563 B.n816 B.n815 25.6005
R4564 B.n815 B.n814 25.6005
R4565 B.n814 B.n369 25.6005
R4566 B.n804 B.n369 25.6005
R4567 B.n804 B.n803 25.6005
R4568 B.n803 B.n802 25.6005
R4569 B.n802 B.n377 25.6005
R4570 B.n792 B.n377 25.6005
R4571 B.n792 B.n791 25.6005
R4572 B.n791 B.n790 25.6005
R4573 B.n790 B.n385 25.6005
R4574 B.n780 B.n385 25.6005
R4575 B.n780 B.n779 25.6005
R4576 B.n779 B.n778 25.6005
R4577 B.n778 B.n393 25.6005
R4578 B.n768 B.n393 25.6005
R4579 B.n768 B.n767 25.6005
R4580 B.n767 B.n766 25.6005
R4581 B.n766 B.n401 25.6005
R4582 B.n756 B.n401 25.6005
R4583 B.n756 B.n755 25.6005
R4584 B.n755 B.n754 25.6005
R4585 B.n754 B.n409 25.6005
R4586 B.n744 B.n409 25.6005
R4587 B.n744 B.n743 25.6005
R4588 B.n743 B.n742 25.6005
R4589 B.n742 B.n417 25.6005
R4590 B.n732 B.n417 25.6005
R4591 B.n732 B.n731 25.6005
R4592 B.n731 B.n730 25.6005
R4593 B.n730 B.n425 25.6005
R4594 B.n720 B.n425 25.6005
R4595 B.n720 B.n719 25.6005
R4596 B.n719 B.n718 25.6005
R4597 B.n718 B.n433 25.6005
R4598 B.n708 B.n433 25.6005
R4599 B.n708 B.n707 25.6005
R4600 B.n707 B.n706 25.6005
R4601 B.n706 B.n441 25.6005
R4602 B.n696 B.n441 25.6005
R4603 B.n696 B.n695 25.6005
R4604 B.n695 B.n694 25.6005
R4605 B.n694 B.n449 25.6005
R4606 B.n684 B.n449 25.6005
R4607 B.n684 B.n683 25.6005
R4608 B.n683 B.n682 25.6005
R4609 B.n682 B.n457 25.6005
R4610 B.n672 B.n457 25.6005
R4611 B.n672 B.n671 25.6005
R4612 B.n671 B.n670 25.6005
R4613 B.n670 B.n465 25.6005
R4614 B.n660 B.n465 25.6005
R4615 B.n660 B.n659 25.6005
R4616 B.n659 B.n658 25.6005
R4617 B.n658 B.n473 25.6005
R4618 B.n648 B.n473 25.6005
R4619 B.n648 B.n647 25.6005
R4620 B.n647 B.n646 25.6005
R4621 B.n646 B.n481 25.6005
R4622 B.n636 B.n481 25.6005
R4623 B.n636 B.n635 25.6005
R4624 B.n635 B.n634 25.6005
R4625 B.n634 B.n489 25.6005
R4626 B.n624 B.n489 25.6005
R4627 B.n624 B.n623 25.6005
R4628 B.n623 B.n622 25.6005
R4629 B.n622 B.n497 25.6005
R4630 B.n612 B.n497 25.6005
R4631 B.n612 B.n611 25.6005
R4632 B.n611 B.n610 25.6005
R4633 B.n610 B.n505 25.6005
R4634 B.n600 B.n505 25.6005
R4635 B.n600 B.n599 25.6005
R4636 B.n599 B.n598 25.6005
R4637 B.n598 B.n513 25.6005
R4638 B.n588 B.n513 25.6005
R4639 B.n588 B.n587 25.6005
R4640 B.n587 B.n586 25.6005
R4641 B.n586 B.n521 25.6005
R4642 B.n576 B.n521 25.6005
R4643 B.n576 B.n575 25.6005
R4644 B.n575 B.n574 25.6005
R4645 B.n574 B.n529 25.6005
R4646 B.n564 B.n529 25.6005
R4647 B.n564 B.n563 25.6005
R4648 B.n563 B.n562 25.6005
R4649 B.n562 B.n537 25.6005
R4650 B.n552 B.n537 25.6005
R4651 B.n1357 B 19.2005
R4652 B B.n1366 6.4005
C6 S VSUBS 2.42817f
C7 D VSUBS 2.42817f
C8 G VSUBS 0.17244f
C9 B VSUBS 36.93115f
C10 pfet_01v8_lvt_W90p63_L0p74_m1__nf1_gboth_sdfull_pc/B.n0 VSUBS 0.0015f ; **FLOATING
C11 pfet_01v8_lvt_W90p63_L0p74_m1__nf1_gboth_sdfull_pc/B.n1 VSUBS 0.00439f ; **FLOATING
C12 pfet_01v8_lvt_W90p63_L0p74_m1__nf1_gboth_sdfull_pc/B.n2 VSUBS 0.002f ; **FLOATING
C13 pfet_01v8_lvt_W90p63_L0p74_m1__nf1_gboth_sdfull_pc/B.n3 VSUBS 0.00439f ; **FLOATING
C14 pfet_01v8_lvt_W90p63_L0p74_m1__nf1_gboth_sdfull_pc/B.t0 VSUBS 0.54537f ; **FLOATING
C15 pfet_01v8_lvt_W90p63_L0p74_m1__nf1_gboth_sdfull_pc/B.n4 VSUBS 1.46768f ; **FLOATING
C16 pfet_01v8_lvt_W90p63_L0p74_m1__nf1_gboth_sdfull_pc/B.n5 VSUBS 0.002f ; **FLOATING
C17 pfet_01v8_lvt_W90p63_L0p74_m1__nf1_gboth_sdfull_pc/B.n6 VSUBS 0.00439f ; **FLOATING
C18 pfet_01v8_lvt_W90p63_L0p74_m1__nf1_gboth_sdfull_pc/B.n7 VSUBS 0.00442f ; **FLOATING
C19 pfet_01v8_lvt_W90p63_L0p74_m1__nf1_gboth_sdfull_pc/B.n8 VSUBS 0.00442f ; **FLOATING
C20 pfet_01v8_lvt_W90p63_L0p74_m1__nf1_gboth_sdfull_pc/B.n9 VSUBS 1.77244f ; **FLOATING
C21 pfet_01v8_lvt_W90p63_L0p74_m1__nf1_gboth_sdfull_pc/B.n10 VSUBS 0.00442f ; **FLOATING
C22 pfet_01v8_lvt_W90p63_L0p74_m1__nf1_gboth_sdfull_pc/B.n11 VSUBS 0.002f ; **FLOATING
C23 pfet_01v8_lvt_W90p63_L0p74_m1__nf1_gboth_sdfull_pc/B.n12 VSUBS 0.002f ; **FLOATING
C24 pfet_01v8_lvt_W90p63_L0p74_m1__nf1_gboth_sdfull_pc/B.n13 VSUBS 0.002f ; **FLOATING
C25 pfet_01v8_lvt_W90p63_L0p74_m1__nf1_gboth_sdfull_pc/B.n15 VSUBS 0.002f ; **FLOATING
C26 pfet_01v8_lvt_W90p63_L0p74_m1__nf1_gboth_sdfull_pc/B.n17 VSUBS 0.002f ; **FLOATING
C27 pfet_01v8_lvt_W90p63_L0p74_m1__nf1_gboth_sdfull_pc/B.n19 VSUBS 0.002f ; **FLOATING
C28 pfet_01v8_lvt_W90p63_L0p74_m1__nf1_gboth_sdfull_pc/B.n21 VSUBS 0.002f ; **FLOATING
C29 pfet_01v8_lvt_W90p63_L0p74_m1__nf1_gboth_sdfull_pc/B.n22 VSUBS 0.002f ; **FLOATING
C30 pfet_01v8_lvt_W90p63_L0p74_m1__nf1_gboth_sdfull_pc/B.n23 VSUBS 0.002f ; **FLOATING
C31 pfet_01v8_lvt_W90p63_L0p74_m1__nf1_gboth_sdfull_pc/B.n24 VSUBS 0.002f ; **FLOATING
C32 pfet_01v8_lvt_W90p63_L0p74_m1__nf1_gboth_sdfull_pc/B.n25 VSUBS 0.002f ; **FLOATING
C33 pfet_01v8_lvt_W90p63_L0p74_m1__nf1_gboth_sdfull_pc/B.n26 VSUBS 0.002f ; **FLOATING
C34 pfet_01v8_lvt_W90p63_L0p74_m1__nf1_gboth_sdfull_pc/B.n27 VSUBS 0.002f ; **FLOATING
C35 pfet_01v8_lvt_W90p63_L0p74_m1__nf1_gboth_sdfull_pc/B.n28 VSUBS 0.002f ; **FLOATING
C36 pfet_01v8_lvt_W90p63_L0p74_m1__nf1_gboth_sdfull_pc/B.n29 VSUBS 0.002f ; **FLOATING
C37 pfet_01v8_lvt_W90p63_L0p74_m1__nf1_gboth_sdfull_pc/B.n30 VSUBS 0.002f ; **FLOATING
C38 pfet_01v8_lvt_W90p63_L0p74_m1__nf1_gboth_sdfull_pc/B.n31 VSUBS 0.002f ; **FLOATING
C39 pfet_01v8_lvt_W90p63_L0p74_m1__nf1_gboth_sdfull_pc/B.n32 VSUBS 0.002f ; **FLOATING
C40 pfet_01v8_lvt_W90p63_L0p74_m1__nf1_gboth_sdfull_pc/B.n34 VSUBS 0.002f ; **FLOATING
C41 pfet_01v8_lvt_W90p63_L0p74_m1__nf1_gboth_sdfull_pc/B.n35 VSUBS 0.002f ; **FLOATING
C42 pfet_01v8_lvt_W90p63_L0p74_m1__nf1_gboth_sdfull_pc/B.n36 VSUBS 0.002f ; **FLOATING
C43 pfet_01v8_lvt_W90p63_L0p74_m1__nf1_gboth_sdfull_pc/B.n37 VSUBS 0.002f ; **FLOATING
C44 pfet_01v8_lvt_W90p63_L0p74_m1__nf1_gboth_sdfull_pc/B.n38 VSUBS 0.002f ; **FLOATING
C45 pfet_01v8_lvt_W90p63_L0p74_m1__nf1_gboth_sdfull_pc/B.n40 VSUBS 0.002f ; **FLOATING
C46 pfet_01v8_lvt_W90p63_L0p74_m1__nf1_gboth_sdfull_pc/B.n41 VSUBS 0.002f ; **FLOATING
C47 pfet_01v8_lvt_W90p63_L0p74_m1__nf1_gboth_sdfull_pc/B.n42 VSUBS 0.002f ; **FLOATING
C48 pfet_01v8_lvt_W90p63_L0p74_m1__nf1_gboth_sdfull_pc/B.n44 VSUBS 0.002f ; **FLOATING
C49 pfet_01v8_lvt_W90p63_L0p74_m1__nf1_gboth_sdfull_pc/B.n45 VSUBS 0.002f ; **FLOATING
C50 pfet_01v8_lvt_W90p63_L0p74_m1__nf1_gboth_sdfull_pc/B.n46 VSUBS 0.002f ; **FLOATING
C51 pfet_01v8_lvt_W90p63_L0p74_m1__nf1_gboth_sdfull_pc/B.n47 VSUBS 0.002f ; **FLOATING
C52 pfet_01v8_lvt_W90p63_L0p74_m1__nf1_gboth_sdfull_pc/B.n48 VSUBS 0.002f ; **FLOATING
C53 pfet_01v8_lvt_W90p63_L0p74_m1__nf1_gboth_sdfull_pc/B.n49 VSUBS 0.002f ; **FLOATING
C54 pfet_01v8_lvt_W90p63_L0p74_m1__nf1_gboth_sdfull_pc/B.n50 VSUBS 0.002f ; **FLOATING
C55 pfet_01v8_lvt_W90p63_L0p74_m1__nf1_gboth_sdfull_pc/B.n52 VSUBS 0.002f ; **FLOATING
C56 pfet_01v8_lvt_W90p63_L0p74_m1__nf1_gboth_sdfull_pc/B.n53 VSUBS 0.002f ; **FLOATING
C57 pfet_01v8_lvt_W90p63_L0p74_m1__nf1_gboth_sdfull_pc/B.n54 VSUBS 0.002f ; **FLOATING
C58 pfet_01v8_lvt_W90p63_L0p74_m1__nf1_gboth_sdfull_pc/B.n56 VSUBS 0.002f ; **FLOATING
C59 pfet_01v8_lvt_W90p63_L0p74_m1__nf1_gboth_sdfull_pc/B.n58 VSUBS 0.002f ; **FLOATING
C60 pfet_01v8_lvt_W90p63_L0p74_m1__nf1_gboth_sdfull_pc/B.n60 VSUBS 0.002f ; **FLOATING
C61 pfet_01v8_lvt_W90p63_L0p74_m1__nf1_gboth_sdfull_pc/B.n61 VSUBS 0.002f ; **FLOATING
C62 pfet_01v8_lvt_W90p63_L0p74_m1__nf1_gboth_sdfull_pc/B.n62 VSUBS 0.002f ; **FLOATING
C63 pfet_01v8_lvt_W90p63_L0p74_m1__nf1_gboth_sdfull_pc/B.n63 VSUBS 0.002f ; **FLOATING
C64 pfet_01v8_lvt_W90p63_L0p74_m1__nf1_gboth_sdfull_pc/B.n64 VSUBS 0.002f ; **FLOATING
C65 pfet_01v8_lvt_W90p63_L0p74_m1__nf1_gboth_sdfull_pc/B.n65 VSUBS 0.002f ; **FLOATING
C66 pfet_01v8_lvt_W90p63_L0p74_m1__nf1_gboth_sdfull_pc/B.n66 VSUBS 0.002f ; **FLOATING
C67 pfet_01v8_lvt_W90p63_L0p74_m1__nf1_gboth_sdfull_pc/B.n67 VSUBS 0.002f ; **FLOATING
C68 pfet_01v8_lvt_W90p63_L0p74_m1__nf1_gboth_sdfull_pc/B.n69 VSUBS 0.002f ; **FLOATING
C69 pfet_01v8_lvt_W90p63_L0p74_m1__nf1_gboth_sdfull_pc/B.n70 VSUBS 0.002f ; **FLOATING
C70 pfet_01v8_lvt_W90p63_L0p74_m1__nf1_gboth_sdfull_pc/B.n71 VSUBS 0.002f ; **FLOATING
C71 pfet_01v8_lvt_W90p63_L0p74_m1__nf1_gboth_sdfull_pc/B.n73 VSUBS 0.002f ; **FLOATING
C72 pfet_01v8_lvt_W90p63_L0p74_m1__nf1_gboth_sdfull_pc/B.n74 VSUBS 0.002f ; **FLOATING
C73 pfet_01v8_lvt_W90p63_L0p74_m1__nf1_gboth_sdfull_pc/B.n75 VSUBS 0.002f ; **FLOATING
C74 pfet_01v8_lvt_W90p63_L0p74_m1__nf1_gboth_sdfull_pc/B.n76 VSUBS 0.002f ; **FLOATING
C75 pfet_01v8_lvt_W90p63_L0p74_m1__nf1_gboth_sdfull_pc/B.n77 VSUBS 0.002f ; **FLOATING
C76 pfet_01v8_lvt_W90p63_L0p74_m1__nf1_gboth_sdfull_pc/B.n78 VSUBS 0.002f ; **FLOATING
C77 pfet_01v8_lvt_W90p63_L0p74_m1__nf1_gboth_sdfull_pc/B.n79 VSUBS 0.002f ; **FLOATING
C78 pfet_01v8_lvt_W90p63_L0p74_m1__nf1_gboth_sdfull_pc/B.n80 VSUBS 0.002f ; **FLOATING
C79 pfet_01v8_lvt_W90p63_L0p74_m1__nf1_gboth_sdfull_pc/B.n81 VSUBS 0.002f ; **FLOATING
C80 pfet_01v8_lvt_W90p63_L0p74_m1__nf1_gboth_sdfull_pc/B.n82 VSUBS 0.002f ; **FLOATING
C81 pfet_01v8_lvt_W90p63_L0p74_m1__nf1_gboth_sdfull_pc/B.n83 VSUBS 0.002f ; **FLOATING
C82 pfet_01v8_lvt_W90p63_L0p74_m1__nf1_gboth_sdfull_pc/B.n84 VSUBS 0.002f ; **FLOATING
C83 pfet_01v8_lvt_W90p63_L0p74_m1__nf1_gboth_sdfull_pc/B.n86 VSUBS 0.002f ; **FLOATING
C84 pfet_01v8_lvt_W90p63_L0p74_m1__nf1_gboth_sdfull_pc/B.n88 VSUBS 0.002f ; **FLOATING
C85 pfet_01v8_lvt_W90p63_L0p74_m1__nf1_gboth_sdfull_pc/B.n89 VSUBS 0.002f ; **FLOATING
C86 pfet_01v8_lvt_W90p63_L0p74_m1__nf1_gboth_sdfull_pc/B.n90 VSUBS 0.002f ; **FLOATING
C87 pfet_01v8_lvt_W90p63_L0p74_m1__nf1_gboth_sdfull_pc/B.n91 VSUBS 0.002f ; **FLOATING
C88 pfet_01v8_lvt_W90p63_L0p74_m1__nf1_gboth_sdfull_pc/B.n92 VSUBS 0.002f ; **FLOATING
C89 pfet_01v8_lvt_W90p63_L0p74_m1__nf1_gboth_sdfull_pc/B.n93 VSUBS 0.002f ; **FLOATING
C90 pfet_01v8_lvt_W90p63_L0p74_m1__nf1_gboth_sdfull_pc/B.n94 VSUBS 0.002f ; **FLOATING
C91 pfet_01v8_lvt_W90p63_L0p74_m1__nf1_gboth_sdfull_pc/B.n96 VSUBS 0.002f ; **FLOATING
C92 pfet_01v8_lvt_W90p63_L0p74_m1__nf1_gboth_sdfull_pc/B.n97 VSUBS 0.002f ; **FLOATING
C93 pfet_01v8_lvt_W90p63_L0p74_m1__nf1_gboth_sdfull_pc/B.n98 VSUBS 0.002f ; **FLOATING
C94 pfet_01v8_lvt_W90p63_L0p74_m1__nf1_gboth_sdfull_pc/B.n99 VSUBS 0.002f ; **FLOATING
C95 pfet_01v8_lvt_W90p63_L0p74_m1__nf1_gboth_sdfull_pc/B.n100 VSUBS 0.002f ; **FLOATING
C96 pfet_01v8_lvt_W90p63_L0p74_m1__nf1_gboth_sdfull_pc/B.n101 VSUBS 0.002f ; **FLOATING
C97 pfet_01v8_lvt_W90p63_L0p74_m1__nf1_gboth_sdfull_pc/B.n102 VSUBS 0.002f ; **FLOATING
C98 pfet_01v8_lvt_W90p63_L0p74_m1__nf1_gboth_sdfull_pc/B.n103 VSUBS 0.002f ; **FLOATING
C99 pfet_01v8_lvt_W90p63_L0p74_m1__nf1_gboth_sdfull_pc/B.n104 VSUBS 0.002f ; **FLOATING
C100 pfet_01v8_lvt_W90p63_L0p74_m1__nf1_gboth_sdfull_pc/B.n105 VSUBS 0.002f ; **FLOATING
C101 pfet_01v8_lvt_W90p63_L0p74_m1__nf1_gboth_sdfull_pc/B.n106 VSUBS 0.002f ; **FLOATING
C102 pfet_01v8_lvt_W90p63_L0p74_m1__nf1_gboth_sdfull_pc/B.n107 VSUBS 0.002f ; **FLOATING
C103 pfet_01v8_lvt_W90p63_L0p74_m1__nf1_gboth_sdfull_pc/B.n108 VSUBS 0.002f ; **FLOATING
C104 pfet_01v8_lvt_W90p63_L0p74_m1__nf1_gboth_sdfull_pc/B.n109 VSUBS 0.002f ; **FLOATING
C105 pfet_01v8_lvt_W90p63_L0p74_m1__nf1_gboth_sdfull_pc/B.n110 VSUBS 0.002f ; **FLOATING
C106 pfet_01v8_lvt_W90p63_L0p74_m1__nf1_gboth_sdfull_pc/B.n112 VSUBS 0.002f ; **FLOATING
C107 pfet_01v8_lvt_W90p63_L0p74_m1__nf1_gboth_sdfull_pc/B.n113 VSUBS 0.002f ; **FLOATING
C108 pfet_01v8_lvt_W90p63_L0p74_m1__nf1_gboth_sdfull_pc/B.n114 VSUBS 0.002f ; **FLOATING
C109 pfet_01v8_lvt_W90p63_L0p74_m1__nf1_gboth_sdfull_pc/B.n116 VSUBS 0.002f ; **FLOATING
C110 pfet_01v8_lvt_W90p63_L0p74_m1__nf1_gboth_sdfull_pc/B.n117 VSUBS 0.002f ; **FLOATING
C111 pfet_01v8_lvt_W90p63_L0p74_m1__nf1_gboth_sdfull_pc/B.n118 VSUBS 0.002f ; **FLOATING
C112 pfet_01v8_lvt_W90p63_L0p74_m1__nf1_gboth_sdfull_pc/B.n119 VSUBS 0.002f ; **FLOATING
C113 pfet_01v8_lvt_W90p63_L0p74_m1__nf1_gboth_sdfull_pc/B.n120 VSUBS 0.002f ; **FLOATING
C114 pfet_01v8_lvt_W90p63_L0p74_m1__nf1_gboth_sdfull_pc/B.n122 VSUBS 0.002f ; **FLOATING
C115 pfet_01v8_lvt_W90p63_L0p74_m1__nf1_gboth_sdfull_pc/B.n123 VSUBS 0.002f ; **FLOATING
C116 pfet_01v8_lvt_W90p63_L0p74_m1__nf1_gboth_sdfull_pc/B.n124 VSUBS 0.002f ; **FLOATING
C117 pfet_01v8_lvt_W90p63_L0p74_m1__nf1_gboth_sdfull_pc/B.n125 VSUBS 0.002f ; **FLOATING
C118 pfet_01v8_lvt_W90p63_L0p74_m1__nf1_gboth_sdfull_pc/B.n126 VSUBS 0.002f ; **FLOATING
C119 pfet_01v8_lvt_W90p63_L0p74_m1__nf1_gboth_sdfull_pc/B.n127 VSUBS 0.002f ; **FLOATING
C120 pfet_01v8_lvt_W90p63_L0p74_m1__nf1_gboth_sdfull_pc/B.n128 VSUBS 0.002f ; **FLOATING
C121 pfet_01v8_lvt_W90p63_L0p74_m1__nf1_gboth_sdfull_pc/B.n129 VSUBS 0.002f ; **FLOATING
C122 pfet_01v8_lvt_W90p63_L0p74_m1__nf1_gboth_sdfull_pc/B.n130 VSUBS 0.002f ; **FLOATING
C123 pfet_01v8_lvt_W90p63_L0p74_m1__nf1_gboth_sdfull_pc/B.n131 VSUBS 0.002f ; **FLOATING
C124 pfet_01v8_lvt_W90p63_L0p74_m1__nf1_gboth_sdfull_pc/B.n132 VSUBS 0.002f ; **FLOATING
C125 pfet_01v8_lvt_W90p63_L0p74_m1__nf1_gboth_sdfull_pc/B.n133 VSUBS 0.002f ; **FLOATING
C126 pfet_01v8_lvt_W90p63_L0p74_m1__nf1_gboth_sdfull_pc/B.n134 VSUBS 0.002f ; **FLOATING
C127 pfet_01v8_lvt_W90p63_L0p74_m1__nf1_gboth_sdfull_pc/B.n135 VSUBS 0.002f ; **FLOATING
C128 pfet_01v8_lvt_W90p63_L0p74_m1__nf1_gboth_sdfull_pc/B.n136 VSUBS 0.002f ; **FLOATING
C129 pfet_01v8_lvt_W90p63_L0p74_m1__nf1_gboth_sdfull_pc/B.n137 VSUBS 0.002f ; **FLOATING
C130 pfet_01v8_lvt_W90p63_L0p74_m1__nf1_gboth_sdfull_pc/B.n138 VSUBS 0.002f ; **FLOATING
C131 pfet_01v8_lvt_W90p63_L0p74_m1__nf1_gboth_sdfull_pc/B.n139 VSUBS 0.002f ; **FLOATING
C132 pfet_01v8_lvt_W90p63_L0p74_m1__nf1_gboth_sdfull_pc/B.n140 VSUBS 0.002f ; **FLOATING
C133 pfet_01v8_lvt_W90p63_L0p74_m1__nf1_gboth_sdfull_pc/B.n141 VSUBS 0.002f ; **FLOATING
C134 pfet_01v8_lvt_W90p63_L0p74_m1__nf1_gboth_sdfull_pc/B.n142 VSUBS 0.002f ; **FLOATING
C135 pfet_01v8_lvt_W90p63_L0p74_m1__nf1_gboth_sdfull_pc/B.n143 VSUBS 0.002f ; **FLOATING
C136 pfet_01v8_lvt_W90p63_L0p74_m1__nf1_gboth_sdfull_pc/B.n145 VSUBS 0.002f ; **FLOATING
C137 pfet_01v8_lvt_W90p63_L0p74_m1__nf1_gboth_sdfull_pc/B.n146 VSUBS 0.002f ; **FLOATING
C138 pfet_01v8_lvt_W90p63_L0p74_m1__nf1_gboth_sdfull_pc/B.n147 VSUBS 0.002f ; **FLOATING
C139 pfet_01v8_lvt_W90p63_L0p74_m1__nf1_gboth_sdfull_pc/B.n148 VSUBS 0.002f ; **FLOATING
C140 pfet_01v8_lvt_W90p63_L0p74_m1__nf1_gboth_sdfull_pc/B.n149 VSUBS 0.002f ; **FLOATING
C141 pfet_01v8_lvt_W90p63_L0p74_m1__nf1_gboth_sdfull_pc/B.n150 VSUBS 0.002f ; **FLOATING
C142 pfet_01v8_lvt_W90p63_L0p74_m1__nf1_gboth_sdfull_pc/B.n151 VSUBS 0.002f ; **FLOATING
C143 pfet_01v8_lvt_W90p63_L0p74_m1__nf1_gboth_sdfull_pc/B.n153 VSUBS 0.002f ; **FLOATING
C144 pfet_01v8_lvt_W90p63_L0p74_m1__nf1_gboth_sdfull_pc/B.n155 VSUBS 0.002f ; **FLOATING
C145 pfet_01v8_lvt_W90p63_L0p74_m1__nf1_gboth_sdfull_pc/B.n157 VSUBS 0.002f ; **FLOATING
C146 pfet_01v8_lvt_W90p63_L0p74_m1__nf1_gboth_sdfull_pc/B.n159 VSUBS 0.002f ; **FLOATING
C147 pfet_01v8_lvt_W90p63_L0p74_m1__nf1_gboth_sdfull_pc/B.n160 VSUBS 0.002f ; **FLOATING
C148 pfet_01v8_lvt_W90p63_L0p74_m1__nf1_gboth_sdfull_pc/B.n161 VSUBS 0.002f ; **FLOATING
C149 pfet_01v8_lvt_W90p63_L0p74_m1__nf1_gboth_sdfull_pc/B.n162 VSUBS 0.002f ; **FLOATING
C150 pfet_01v8_lvt_W90p63_L0p74_m1__nf1_gboth_sdfull_pc/B.n164 VSUBS 0.002f ; **FLOATING
C151 pfet_01v8_lvt_W90p63_L0p74_m1__nf1_gboth_sdfull_pc/B.n165 VSUBS 0.002f ; **FLOATING
C152 pfet_01v8_lvt_W90p63_L0p74_m1__nf1_gboth_sdfull_pc/B.n166 VSUBS 0.002f ; **FLOATING
C153 pfet_01v8_lvt_W90p63_L0p74_m1__nf1_gboth_sdfull_pc/B.n167 VSUBS 0.002f ; **FLOATING
C154 pfet_01v8_lvt_W90p63_L0p74_m1__nf1_gboth_sdfull_pc/B.n168 VSUBS 0.002f ; **FLOATING
C155 pfet_01v8_lvt_W90p63_L0p74_m1__nf1_gboth_sdfull_pc/B.n169 VSUBS 0.002f ; **FLOATING
C156 pfet_01v8_lvt_W90p63_L0p74_m1__nf1_gboth_sdfull_pc/B.n170 VSUBS 0.002f ; **FLOATING
C157 pfet_01v8_lvt_W90p63_L0p74_m1__nf1_gboth_sdfull_pc/B.n171 VSUBS 0.002f ; **FLOATING
C158 pfet_01v8_lvt_W90p63_L0p74_m1__nf1_gboth_sdfull_pc/B.n172 VSUBS 0.002f ; **FLOATING
C159 pfet_01v8_lvt_W90p63_L0p74_m1__nf1_gboth_sdfull_pc/B.n173 VSUBS 0.002f ; **FLOATING
C160 pfet_01v8_lvt_W90p63_L0p74_m1__nf1_gboth_sdfull_pc/B.n174 VSUBS 0.002f ; **FLOATING
C161 pfet_01v8_lvt_W90p63_L0p74_m1__nf1_gboth_sdfull_pc/B.n175 VSUBS 0.002f ; **FLOATING
C162 pfet_01v8_lvt_W90p63_L0p74_m1__nf1_gboth_sdfull_pc/B.n176 VSUBS 0.002f ; **FLOATING
C163 pfet_01v8_lvt_W90p63_L0p74_m1__nf1_gboth_sdfull_pc/B.n177 VSUBS 0.002f ; **FLOATING
C164 pfet_01v8_lvt_W90p63_L0p74_m1__nf1_gboth_sdfull_pc/B.n178 VSUBS 0.002f ; **FLOATING
C165 pfet_01v8_lvt_W90p63_L0p74_m1__nf1_gboth_sdfull_pc/B.n179 VSUBS 0.002f ; **FLOATING
C166 pfet_01v8_lvt_W90p63_L0p74_m1__nf1_gboth_sdfull_pc/B.n181 VSUBS 0.002f ; **FLOATING
C167 pfet_01v8_lvt_W90p63_L0p74_m1__nf1_gboth_sdfull_pc/B.n182 VSUBS 0.002f ; **FLOATING
C168 pfet_01v8_lvt_W90p63_L0p74_m1__nf1_gboth_sdfull_pc/B.n183 VSUBS 0.002f ; **FLOATING
C169 pfet_01v8_lvt_W90p63_L0p74_m1__nf1_gboth_sdfull_pc/B.n184 VSUBS 0.002f ; **FLOATING
C170 pfet_01v8_lvt_W90p63_L0p74_m1__nf1_gboth_sdfull_pc/B.n185 VSUBS 0.002f ; **FLOATING
C171 pfet_01v8_lvt_W90p63_L0p74_m1__nf1_gboth_sdfull_pc/B.n187 VSUBS 0.002f ; **FLOATING
C172 pfet_01v8_lvt_W90p63_L0p74_m1__nf1_gboth_sdfull_pc/B.n189 VSUBS 0.002f ; **FLOATING
C173 pfet_01v8_lvt_W90p63_L0p74_m1__nf1_gboth_sdfull_pc/B.n190 VSUBS 0.002f ; **FLOATING
C174 pfet_01v8_lvt_W90p63_L0p74_m1__nf1_gboth_sdfull_pc/B.n191 VSUBS 0.002f ; **FLOATING
C175 pfet_01v8_lvt_W90p63_L0p74_m1__nf1_gboth_sdfull_pc/B.n192 VSUBS 0.002f ; **FLOATING
C176 pfet_01v8_lvt_W90p63_L0p74_m1__nf1_gboth_sdfull_pc/B.n193 VSUBS 0.002f ; **FLOATING
C177 pfet_01v8_lvt_W90p63_L0p74_m1__nf1_gboth_sdfull_pc/B.n195 VSUBS 0.002f ; **FLOATING
C178 pfet_01v8_lvt_W90p63_L0p74_m1__nf1_gboth_sdfull_pc/B.n197 VSUBS 0.002f ; **FLOATING
C179 pfet_01v8_lvt_W90p63_L0p74_m1__nf1_gboth_sdfull_pc/B.n198 VSUBS 0.002f ; **FLOATING
C180 pfet_01v8_lvt_W90p63_L0p74_m1__nf1_gboth_sdfull_pc/B.n199 VSUBS 0.002f ; **FLOATING
C181 pfet_01v8_lvt_W90p63_L0p74_m1__nf1_gboth_sdfull_pc/B.n200 VSUBS 0.002f ; **FLOATING
C182 pfet_01v8_lvt_W90p63_L0p74_m1__nf1_gboth_sdfull_pc/B.n201 VSUBS 0.002f ; **FLOATING
C183 pfet_01v8_lvt_W90p63_L0p74_m1__nf1_gboth_sdfull_pc/B.n203 VSUBS 0.002f ; **FLOATING
C184 pfet_01v8_lvt_W90p63_L0p74_m1__nf1_gboth_sdfull_pc/B.n204 VSUBS 0.002f ; **FLOATING
C185 pfet_01v8_lvt_W90p63_L0p74_m1__nf1_gboth_sdfull_pc/B.n205 VSUBS 0.002f ; **FLOATING
C186 pfet_01v8_lvt_W90p63_L0p74_m1__nf1_gboth_sdfull_pc/B.n206 VSUBS 0.002f ; **FLOATING
C187 pfet_01v8_lvt_W90p63_L0p74_m1__nf1_gboth_sdfull_pc/B.n207 VSUBS 0.002f ; **FLOATING
C188 pfet_01v8_lvt_W90p63_L0p74_m1__nf1_gboth_sdfull_pc/B.n208 VSUBS 0.002f ; **FLOATING
C189 pfet_01v8_lvt_W90p63_L0p74_m1__nf1_gboth_sdfull_pc/B.n210 VSUBS 0.002f ; **FLOATING
C190 pfet_01v8_lvt_W90p63_L0p74_m1__nf1_gboth_sdfull_pc/B.n211 VSUBS 0.002f ; **FLOATING
C191 pfet_01v8_lvt_W90p63_L0p74_m1__nf1_gboth_sdfull_pc/B.n212 VSUBS 0.002f ; **FLOATING
C192 pfet_01v8_lvt_W90p63_L0p74_m1__nf1_gboth_sdfull_pc/B.n213 VSUBS 0.002f ; **FLOATING
C193 pfet_01v8_lvt_W90p63_L0p74_m1__nf1_gboth_sdfull_pc/B.n214 VSUBS 0.002f ; **FLOATING
C194 pfet_01v8_lvt_W90p63_L0p74_m1__nf1_gboth_sdfull_pc/B.n216 VSUBS 0.002f ; **FLOATING
C195 pfet_01v8_lvt_W90p63_L0p74_m1__nf1_gboth_sdfull_pc/B.n218 VSUBS 0.002f ; **FLOATING
C196 pfet_01v8_lvt_W90p63_L0p74_m1__nf1_gboth_sdfull_pc/B.n219 VSUBS 0.002f ; **FLOATING
C197 pfet_01v8_lvt_W90p63_L0p74_m1__nf1_gboth_sdfull_pc/B.n220 VSUBS 0.002f ; **FLOATING
C198 pfet_01v8_lvt_W90p63_L0p74_m1__nf1_gboth_sdfull_pc/B.n221 VSUBS 0.002f ; **FLOATING
C199 pfet_01v8_lvt_W90p63_L0p74_m1__nf1_gboth_sdfull_pc/B.n222 VSUBS 0.002f ; **FLOATING
C200 pfet_01v8_lvt_W90p63_L0p74_m1__nf1_gboth_sdfull_pc/B.n224 VSUBS 0.002f ; **FLOATING
C201 pfet_01v8_lvt_W90p63_L0p74_m1__nf1_gboth_sdfull_pc/B.n226 VSUBS 0.002f ; **FLOATING
C202 pfet_01v8_lvt_W90p63_L0p74_m1__nf1_gboth_sdfull_pc/B.n227 VSUBS 0.002f ; **FLOATING
C203 pfet_01v8_lvt_W90p63_L0p74_m1__nf1_gboth_sdfull_pc/B.n228 VSUBS 0.002f ; **FLOATING
C204 pfet_01v8_lvt_W90p63_L0p74_m1__nf1_gboth_sdfull_pc/B.n229 VSUBS 0.002f ; **FLOATING
C205 pfet_01v8_lvt_W90p63_L0p74_m1__nf1_gboth_sdfull_pc/B.n230 VSUBS 0.002f ; **FLOATING
C206 pfet_01v8_lvt_W90p63_L0p74_m1__nf1_gboth_sdfull_pc/B.n232 VSUBS 0.002f ; **FLOATING
C207 pfet_01v8_lvt_W90p63_L0p74_m1__nf1_gboth_sdfull_pc/B.n234 VSUBS 0.002f ; **FLOATING
C208 pfet_01v8_lvt_W90p63_L0p74_m1__nf1_gboth_sdfull_pc/B.n235 VSUBS 0.002f ; **FLOATING
C209 pfet_01v8_lvt_W90p63_L0p74_m1__nf1_gboth_sdfull_pc/B.n236 VSUBS 0.002f ; **FLOATING
C210 pfet_01v8_lvt_W90p63_L0p74_m1__nf1_gboth_sdfull_pc/B.n237 VSUBS 0.002f ; **FLOATING
C211 pfet_01v8_lvt_W90p63_L0p74_m1__nf1_gboth_sdfull_pc/B.n238 VSUBS 0.002f ; **FLOATING
C212 pfet_01v8_lvt_W90p63_L0p74_m1__nf1_gboth_sdfull_pc/B.n240 VSUBS 0.002f ; **FLOATING
C213 pfet_01v8_lvt_W90p63_L0p74_m1__nf1_gboth_sdfull_pc/B.n242 VSUBS 0.002f ; **FLOATING
C214 pfet_01v8_lvt_W90p63_L0p74_m1__nf1_gboth_sdfull_pc/B.n243 VSUBS 0.002f ; **FLOATING
C215 pfet_01v8_lvt_W90p63_L0p74_m1__nf1_gboth_sdfull_pc/B.n244 VSUBS 0.002f ; **FLOATING
C216 pfet_01v8_lvt_W90p63_L0p74_m1__nf1_gboth_sdfull_pc/B.n245 VSUBS 0.002f ; **FLOATING
C217 pfet_01v8_lvt_W90p63_L0p74_m1__nf1_gboth_sdfull_pc/B.n246 VSUBS 0.002f ; **FLOATING
C218 pfet_01v8_lvt_W90p63_L0p74_m1__nf1_gboth_sdfull_pc/B.n248 VSUBS 0.002f ; **FLOATING
C219 pfet_01v8_lvt_W90p63_L0p74_m1__nf1_gboth_sdfull_pc/B.n250 VSUBS 0.002f ; **FLOATING
C220 pfet_01v8_lvt_W90p63_L0p74_m1__nf1_gboth_sdfull_pc/B.n251 VSUBS 0.002f ; **FLOATING
C221 pfet_01v8_lvt_W90p63_L0p74_m1__nf1_gboth_sdfull_pc/B.n252 VSUBS 0.002f ; **FLOATING
C222 pfet_01v8_lvt_W90p63_L0p74_m1__nf1_gboth_sdfull_pc/B.n253 VSUBS 0.002f ; **FLOATING
C223 pfet_01v8_lvt_W90p63_L0p74_m1__nf1_gboth_sdfull_pc/B.n254 VSUBS 0.002f ; **FLOATING
C224 pfet_01v8_lvt_W90p63_L0p74_m1__nf1_gboth_sdfull_pc/B.n256 VSUBS 0.002f ; **FLOATING
C225 pfet_01v8_lvt_W90p63_L0p74_m1__nf1_gboth_sdfull_pc/B.n258 VSUBS 0.002f ; **FLOATING
C226 pfet_01v8_lvt_W90p63_L0p74_m1__nf1_gboth_sdfull_pc/B.n259 VSUBS 0.002f ; **FLOATING
C227 pfet_01v8_lvt_W90p63_L0p74_m1__nf1_gboth_sdfull_pc/B.n260 VSUBS 0.002f ; **FLOATING
C228 pfet_01v8_lvt_W90p63_L0p74_m1__nf1_gboth_sdfull_pc/B.n261 VSUBS 0.002f ; **FLOATING
C229 pfet_01v8_lvt_W90p63_L0p74_m1__nf1_gboth_sdfull_pc/B.n262 VSUBS 0.002f ; **FLOATING
C230 pfet_01v8_lvt_W90p63_L0p74_m1__nf1_gboth_sdfull_pc/B.n264 VSUBS 0.002f ; **FLOATING
C231 pfet_01v8_lvt_W90p63_L0p74_m1__nf1_gboth_sdfull_pc/B.n266 VSUBS 0.002f ; **FLOATING
C232 pfet_01v8_lvt_W90p63_L0p74_m1__nf1_gboth_sdfull_pc/B.n267 VSUBS 0.002f ; **FLOATING
C233 pfet_01v8_lvt_W90p63_L0p74_m1__nf1_gboth_sdfull_pc/B.n268 VSUBS 0.002f ; **FLOATING
C234 pfet_01v8_lvt_W90p63_L0p74_m1__nf1_gboth_sdfull_pc/B.n269 VSUBS 0.002f ; **FLOATING
C235 pfet_01v8_lvt_W90p63_L0p74_m1__nf1_gboth_sdfull_pc/B.n270 VSUBS 0.002f ; **FLOATING
C236 pfet_01v8_lvt_W90p63_L0p74_m1__nf1_gboth_sdfull_pc/B.n272 VSUBS 0.002f ; **FLOATING
C237 pfet_01v8_lvt_W90p63_L0p74_m1__nf1_gboth_sdfull_pc/B.n274 VSUBS 0.002f ; **FLOATING
C238 pfet_01v8_lvt_W90p63_L0p74_m1__nf1_gboth_sdfull_pc/B.n275 VSUBS 0.002f ; **FLOATING
C239 pfet_01v8_lvt_W90p63_L0p74_m1__nf1_gboth_sdfull_pc/B.n276 VSUBS 0.002f ; **FLOATING
C240 pfet_01v8_lvt_W90p63_L0p74_m1__nf1_gboth_sdfull_pc/B.n277 VSUBS 0.002f ; **FLOATING
C241 pfet_01v8_lvt_W90p63_L0p74_m1__nf1_gboth_sdfull_pc/B.n278 VSUBS 0.002f ; **FLOATING
C242 pfet_01v8_lvt_W90p63_L0p74_m1__nf1_gboth_sdfull_pc/B.n280 VSUBS 0.002f ; **FLOATING
C243 pfet_01v8_lvt_W90p63_L0p74_m1__nf1_gboth_sdfull_pc/B.n282 VSUBS 0.002f ; **FLOATING
C244 pfet_01v8_lvt_W90p63_L0p74_m1__nf1_gboth_sdfull_pc/B.n283 VSUBS 0.002f ; **FLOATING
C245 pfet_01v8_lvt_W90p63_L0p74_m1__nf1_gboth_sdfull_pc/B.n284 VSUBS 0.002f ; **FLOATING
C246 pfet_01v8_lvt_W90p63_L0p74_m1__nf1_gboth_sdfull_pc/B.n285 VSUBS 0.002f ; **FLOATING
C247 pfet_01v8_lvt_W90p63_L0p74_m1__nf1_gboth_sdfull_pc/B.n286 VSUBS 0.002f ; **FLOATING
C248 pfet_01v8_lvt_W90p63_L0p74_m1__nf1_gboth_sdfull_pc/B.n288 VSUBS 0.002f ; **FLOATING
C249 pfet_01v8_lvt_W90p63_L0p74_m1__nf1_gboth_sdfull_pc/B.n289 VSUBS 0.002f ; **FLOATING
C250 pfet_01v8_lvt_W90p63_L0p74_m1__nf1_gboth_sdfull_pc/B.n290 VSUBS 0.002f ; **FLOATING
C251 pfet_01v8_lvt_W90p63_L0p74_m1__nf1_gboth_sdfull_pc/B.n291 VSUBS 0.002f ; **FLOATING
C252 pfet_01v8_lvt_W90p63_L0p74_m1__nf1_gboth_sdfull_pc/B.n292 VSUBS 0.002f ; **FLOATING
C253 pfet_01v8_lvt_W90p63_L0p74_m1__nf1_gboth_sdfull_pc/B.n293 VSUBS 0.002f ; **FLOATING
C254 pfet_01v8_lvt_W90p63_L0p74_m1__nf1_gboth_sdfull_pc/B.n294 VSUBS 0.002f ; **FLOATING
C255 pfet_01v8_lvt_W90p63_L0p74_m1__nf1_gboth_sdfull_pc/B.n296 VSUBS 0.002f ; **FLOATING
C256 pfet_01v8_lvt_W90p63_L0p74_m1__nf1_gboth_sdfull_pc/B.n297 VSUBS 0.002f ; **FLOATING
C257 pfet_01v8_lvt_W90p63_L0p74_m1__nf1_gboth_sdfull_pc/B.n298 VSUBS 0.002f ; **FLOATING
C258 pfet_01v8_lvt_W90p63_L0p74_m1__nf1_gboth_sdfull_pc/B.n299 VSUBS 0.002f ; **FLOATING
C259 pfet_01v8_lvt_W90p63_L0p74_m1__nf1_gboth_sdfull_pc/B.n300 VSUBS 0.002f ; **FLOATING
C260 pfet_01v8_lvt_W90p63_L0p74_m1__nf1_gboth_sdfull_pc/B.n302 VSUBS 0.002f ; **FLOATING
C261 pfet_01v8_lvt_W90p63_L0p74_m1__nf1_gboth_sdfull_pc/B.n304 VSUBS 0.002f ; **FLOATING
C262 pfet_01v8_lvt_W90p63_L0p74_m1__nf1_gboth_sdfull_pc/B.n305 VSUBS 0.002f ; **FLOATING
C263 pfet_01v8_lvt_W90p63_L0p74_m1__nf1_gboth_sdfull_pc/B.n306 VSUBS 0.002f ; **FLOATING
C264 pfet_01v8_lvt_W90p63_L0p74_m1__nf1_gboth_sdfull_pc/B.n307 VSUBS 0.002f ; **FLOATING
C265 pfet_01v8_lvt_W90p63_L0p74_m1__nf1_gboth_sdfull_pc/B.n308 VSUBS 0.002f ; **FLOATING
C266 pfet_01v8_lvt_W90p63_L0p74_m1__nf1_gboth_sdfull_pc/B.n310 VSUBS 0.002f ; **FLOATING
C267 pfet_01v8_lvt_W90p63_L0p74_m1__nf1_gboth_sdfull_pc/B.n311 VSUBS 0.002f ; **FLOATING
C268 pfet_01v8_lvt_W90p63_L0p74_m1__nf1_gboth_sdfull_pc/B.n312 VSUBS 0.002f ; **FLOATING
C269 pfet_01v8_lvt_W90p63_L0p74_m1__nf1_gboth_sdfull_pc/B.n313 VSUBS 0.002f ; **FLOATING
C270 pfet_01v8_lvt_W90p63_L0p74_m1__nf1_gboth_sdfull_pc/B.n314 VSUBS 0.002f ; **FLOATING
C271 pfet_01v8_lvt_W90p63_L0p74_m1__nf1_gboth_sdfull_pc/B.n315 VSUBS 0.002f ; **FLOATING
C272 pfet_01v8_lvt_W90p63_L0p74_m1__nf1_gboth_sdfull_pc/B.n317 VSUBS 0.002f ; **FLOATING
C273 pfet_01v8_lvt_W90p63_L0p74_m1__nf1_gboth_sdfull_pc/B.n318 VSUBS 0.002f ; **FLOATING
C274 pfet_01v8_lvt_W90p63_L0p74_m1__nf1_gboth_sdfull_pc/B.n319 VSUBS 0.002f ; **FLOATING
C275 pfet_01v8_lvt_W90p63_L0p74_m1__nf1_gboth_sdfull_pc/B.n320 VSUBS 0.002f ; **FLOATING
C276 pfet_01v8_lvt_W90p63_L0p74_m1__nf1_gboth_sdfull_pc/B.n321 VSUBS 0.002f ; **FLOATING
C277 pfet_01v8_lvt_W90p63_L0p74_m1__nf1_gboth_sdfull_pc/B.n323 VSUBS 0.002f ; **FLOATING
C278 pfet_01v8_lvt_W90p63_L0p74_m1__nf1_gboth_sdfull_pc/B.n324 VSUBS 0.002f ; **FLOATING
C279 pfet_01v8_lvt_W90p63_L0p74_m1__nf1_gboth_sdfull_pc/B.n325 VSUBS 0.002f ; **FLOATING
C280 pfet_01v8_lvt_W90p63_L0p74_m1__nf1_gboth_sdfull_pc/B.n326 VSUBS 0.002f ; **FLOATING
C281 pfet_01v8_lvt_W90p63_L0p74_m1__nf1_gboth_sdfull_pc/B.n327 VSUBS 0.002f ; **FLOATING
C282 pfet_01v8_lvt_W90p63_L0p74_m1__nf1_gboth_sdfull_pc/B.n328 VSUBS 0.002f ; **FLOATING
C283 pfet_01v8_lvt_W90p63_L0p74_m1__nf1_gboth_sdfull_pc/B.n330 VSUBS 0.002f ; **FLOATING
C284 pfet_01v8_lvt_W90p63_L0p74_m1__nf1_gboth_sdfull_pc/B.n331 VSUBS 0.002f ; **FLOATING
C285 pfet_01v8_lvt_W90p63_L0p74_m1__nf1_gboth_sdfull_pc/B.n332 VSUBS 0.002f ; **FLOATING
C286 pfet_01v8_lvt_W90p63_L0p74_m1__nf1_gboth_sdfull_pc/B.n333 VSUBS 0.002f ; **FLOATING
C287 pfet_01v8_lvt_W90p63_L0p74_m1__nf1_gboth_sdfull_pc/B.n334 VSUBS 0.002f ; **FLOATING
C288 pfet_01v8_lvt_W90p63_L0p74_m1__nf1_gboth_sdfull_pc/B.n336 VSUBS 0.002f ; **FLOATING
C289 pfet_01v8_lvt_W90p63_L0p74_m1__nf1_gboth_sdfull_pc/B.n338 VSUBS 0.002f ; **FLOATING
C290 pfet_01v8_lvt_W90p63_L0p74_m1__nf1_gboth_sdfull_pc/B.n339 VSUBS 0.002f ; **FLOATING
C291 pfet_01v8_lvt_W90p63_L0p74_m1__nf1_gboth_sdfull_pc/B.n340 VSUBS 0.002f ; **FLOATING
C292 pfet_01v8_lvt_W90p63_L0p74_m1__nf1_gboth_sdfull_pc/B.n341 VSUBS 0.002f ; **FLOATING
C293 pfet_01v8_lvt_W90p63_L0p74_m1__nf1_gboth_sdfull_pc/B.n342 VSUBS 0.002f ; **FLOATING
C294 pfet_01v8_lvt_W90p63_L0p74_m1__nf1_gboth_sdfull_pc/B.n344 VSUBS 0.002f ; **FLOATING
C295 pfet_01v8_lvt_W90p63_L0p74_m1__nf1_gboth_sdfull_pc/B.n346 VSUBS 0.002f ; **FLOATING
C296 pfet_01v8_lvt_W90p63_L0p74_m1__nf1_gboth_sdfull_pc/B.n347 VSUBS 0.002f ; **FLOATING
C297 pfet_01v8_lvt_W90p63_L0p74_m1__nf1_gboth_sdfull_pc/B.n348 VSUBS 0.002f ; **FLOATING
C298 pfet_01v8_lvt_W90p63_L0p74_m1__nf1_gboth_sdfull_pc/B.n349 VSUBS 0.002f ; **FLOATING
C299 pfet_01v8_lvt_W90p63_L0p74_m1__nf1_gboth_sdfull_pc/B.n350 VSUBS 0.002f ; **FLOATING
C300 pfet_01v8_lvt_W90p63_L0p74_m1__nf1_gboth_sdfull_pc/B.n352 VSUBS 0.002f ; **FLOATING
C301 pfet_01v8_lvt_W90p63_L0p74_m1__nf1_gboth_sdfull_pc/B.n354 VSUBS 0.002f ; **FLOATING
C302 pfet_01v8_lvt_W90p63_L0p74_m1__nf1_gboth_sdfull_pc/B.n355 VSUBS 0.002f ; **FLOATING
C303 pfet_01v8_lvt_W90p63_L0p74_m1__nf1_gboth_sdfull_pc/B.n356 VSUBS 0.002f ; **FLOATING
C304 pfet_01v8_lvt_W90p63_L0p74_m1__nf1_gboth_sdfull_pc/B.n357 VSUBS 0.002f ; **FLOATING
C305 pfet_01v8_lvt_W90p63_L0p74_m1__nf1_gboth_sdfull_pc/B.n358 VSUBS 0.002f ; **FLOATING
C306 pfet_01v8_lvt_W90p63_L0p74_m1__nf1_gboth_sdfull_pc/B.n360 VSUBS 0.002f ; **FLOATING
C307 pfet_01v8_lvt_W90p63_L0p74_m1__nf1_gboth_sdfull_pc/B.n362 VSUBS 0.002f ; **FLOATING
C308 pfet_01v8_lvt_W90p63_L0p74_m1__nf1_gboth_sdfull_pc/B.n363 VSUBS 0.002f ; **FLOATING
C309 pfet_01v8_lvt_W90p63_L0p74_m1__nf1_gboth_sdfull_pc/B.n364 VSUBS 0.002f ; **FLOATING
C310 pfet_01v8_lvt_W90p63_L0p74_m1__nf1_gboth_sdfull_pc/B.n365 VSUBS 0.002f ; **FLOATING
C311 pfet_01v8_lvt_W90p63_L0p74_m1__nf1_gboth_sdfull_pc/B.n366 VSUBS 0.002f ; **FLOATING
C312 pfet_01v8_lvt_W90p63_L0p74_m1__nf1_gboth_sdfull_pc/B.n368 VSUBS 0.002f ; **FLOATING
C313 pfet_01v8_lvt_W90p63_L0p74_m1__nf1_gboth_sdfull_pc/B.n370 VSUBS 0.002f ; **FLOATING
C314 pfet_01v8_lvt_W90p63_L0p74_m1__nf1_gboth_sdfull_pc/B.n371 VSUBS 0.002f ; **FLOATING
C315 pfet_01v8_lvt_W90p63_L0p74_m1__nf1_gboth_sdfull_pc/B.n372 VSUBS 0.002f ; **FLOATING
C316 pfet_01v8_lvt_W90p63_L0p74_m1__nf1_gboth_sdfull_pc/B.n373 VSUBS 0.002f ; **FLOATING
C317 pfet_01v8_lvt_W90p63_L0p74_m1__nf1_gboth_sdfull_pc/B.n374 VSUBS 0.002f ; **FLOATING
C318 pfet_01v8_lvt_W90p63_L0p74_m1__nf1_gboth_sdfull_pc/B.n376 VSUBS 0.002f ; **FLOATING
C319 pfet_01v8_lvt_W90p63_L0p74_m1__nf1_gboth_sdfull_pc/B.n378 VSUBS 0.002f ; **FLOATING
C320 pfet_01v8_lvt_W90p63_L0p74_m1__nf1_gboth_sdfull_pc/B.n379 VSUBS 0.002f ; **FLOATING
C321 pfet_01v8_lvt_W90p63_L0p74_m1__nf1_gboth_sdfull_pc/B.n380 VSUBS 0.002f ; **FLOATING
C322 pfet_01v8_lvt_W90p63_L0p74_m1__nf1_gboth_sdfull_pc/B.n381 VSUBS 0.002f ; **FLOATING
C323 pfet_01v8_lvt_W90p63_L0p74_m1__nf1_gboth_sdfull_pc/B.n382 VSUBS 0.002f ; **FLOATING
C324 pfet_01v8_lvt_W90p63_L0p74_m1__nf1_gboth_sdfull_pc/B.n384 VSUBS 0.002f ; **FLOATING
C325 pfet_01v8_lvt_W90p63_L0p74_m1__nf1_gboth_sdfull_pc/B.n385 VSUBS 0.002f ; **FLOATING
C326 pfet_01v8_lvt_W90p63_L0p74_m1__nf1_gboth_sdfull_pc/B.n386 VSUBS 0.002f ; **FLOATING
C327 pfet_01v8_lvt_W90p63_L0p74_m1__nf1_gboth_sdfull_pc/B.n387 VSUBS 0.002f ; **FLOATING
C328 pfet_01v8_lvt_W90p63_L0p74_m1__nf1_gboth_sdfull_pc/B.n388 VSUBS 0.002f ; **FLOATING
C329 pfet_01v8_lvt_W90p63_L0p74_m1__nf1_gboth_sdfull_pc/B.n389 VSUBS 0.002f ; **FLOATING
C330 pfet_01v8_lvt_W90p63_L0p74_m1__nf1_gboth_sdfull_pc/B.n391 VSUBS 0.002f ; **FLOATING
C331 pfet_01v8_lvt_W90p63_L0p74_m1__nf1_gboth_sdfull_pc/B.n392 VSUBS 0.002f ; **FLOATING
C332 pfet_01v8_lvt_W90p63_L0p74_m1__nf1_gboth_sdfull_pc/B.n393 VSUBS 0.002f ; **FLOATING
C333 pfet_01v8_lvt_W90p63_L0p74_m1__nf1_gboth_sdfull_pc/B.n394 VSUBS 0.002f ; **FLOATING
C334 pfet_01v8_lvt_W90p63_L0p74_m1__nf1_gboth_sdfull_pc/B.n395 VSUBS 0.002f ; **FLOATING
C335 pfet_01v8_lvt_W90p63_L0p74_m1__nf1_gboth_sdfull_pc/B.n397 VSUBS 0.002f ; **FLOATING
C336 pfet_01v8_lvt_W90p63_L0p74_m1__nf1_gboth_sdfull_pc/B.n399 VSUBS 0.002f ; **FLOATING
C337 pfet_01v8_lvt_W90p63_L0p74_m1__nf1_gboth_sdfull_pc/B.n400 VSUBS 0.002f ; **FLOATING
C338 pfet_01v8_lvt_W90p63_L0p74_m1__nf1_gboth_sdfull_pc/B.n401 VSUBS 0.002f ; **FLOATING
C339 pfet_01v8_lvt_W90p63_L0p74_m1__nf1_gboth_sdfull_pc/B.n402 VSUBS 0.002f ; **FLOATING
C340 pfet_01v8_lvt_W90p63_L0p74_m1__nf1_gboth_sdfull_pc/B.n403 VSUBS 0.002f ; **FLOATING
C341 pfet_01v8_lvt_W90p63_L0p74_m1__nf1_gboth_sdfull_pc/B.n405 VSUBS 0.002f ; **FLOATING
C342 pfet_01v8_lvt_W90p63_L0p74_m1__nf1_gboth_sdfull_pc/B.n407 VSUBS 0.002f ; **FLOATING
C343 pfet_01v8_lvt_W90p63_L0p74_m1__nf1_gboth_sdfull_pc/B.n408 VSUBS 0.002f ; **FLOATING
C344 pfet_01v8_lvt_W90p63_L0p74_m1__nf1_gboth_sdfull_pc/B.n409 VSUBS 0.002f ; **FLOATING
C345 pfet_01v8_lvt_W90p63_L0p74_m1__nf1_gboth_sdfull_pc/B.n410 VSUBS 0.002f ; **FLOATING
C346 pfet_01v8_lvt_W90p63_L0p74_m1__nf1_gboth_sdfull_pc/B.n411 VSUBS 0.002f ; **FLOATING
C347 pfet_01v8_lvt_W90p63_L0p74_m1__nf1_gboth_sdfull_pc/B.n413 VSUBS 0.002f ; **FLOATING
C348 pfet_01v8_lvt_W90p63_L0p74_m1__nf1_gboth_sdfull_pc/B.n414 VSUBS 0.002f ; **FLOATING
C349 pfet_01v8_lvt_W90p63_L0p74_m1__nf1_gboth_sdfull_pc/B.n415 VSUBS 0.002f ; **FLOATING
C350 pfet_01v8_lvt_W90p63_L0p74_m1__nf1_gboth_sdfull_pc/B.n416 VSUBS 0.002f ; **FLOATING
C351 pfet_01v8_lvt_W90p63_L0p74_m1__nf1_gboth_sdfull_pc/B.n417 VSUBS 0.002f ; **FLOATING
C352 pfet_01v8_lvt_W90p63_L0p74_m1__nf1_gboth_sdfull_pc/B.n418 VSUBS 0.002f ; **FLOATING
C353 pfet_01v8_lvt_W90p63_L0p74_m1__nf1_gboth_sdfull_pc/B.n419 VSUBS 0.002f ; **FLOATING
C354 pfet_01v8_lvt_W90p63_L0p74_m1__nf1_gboth_sdfull_pc/B.n420 VSUBS 0.002f ; **FLOATING
C355 pfet_01v8_lvt_W90p63_L0p74_m1__nf1_gboth_sdfull_pc/B.n421 VSUBS 0.002f ; **FLOATING
C356 pfet_01v8_lvt_W90p63_L0p74_m1__nf1_gboth_sdfull_pc/B.n422 VSUBS 0.002f ; **FLOATING
C357 pfet_01v8_lvt_W90p63_L0p74_m1__nf1_gboth_sdfull_pc/B.n423 VSUBS 0.002f ; **FLOATING
C358 pfet_01v8_lvt_W90p63_L0p74_m1__nf1_gboth_sdfull_pc/B.n425 VSUBS 0.002f ; **FLOATING
C359 pfet_01v8_lvt_W90p63_L0p74_m1__nf1_gboth_sdfull_pc/B.n426 VSUBS 0.002f ; **FLOATING
C360 pfet_01v8_lvt_W90p63_L0p74_m1__nf1_gboth_sdfull_pc/B.n427 VSUBS 0.002f ; **FLOATING
C361 pfet_01v8_lvt_W90p63_L0p74_m1__nf1_gboth_sdfull_pc/B.n428 VSUBS 0.002f ; **FLOATING
C362 pfet_01v8_lvt_W90p63_L0p74_m1__nf1_gboth_sdfull_pc/B.n429 VSUBS 0.002f ; **FLOATING
C363 pfet_01v8_lvt_W90p63_L0p74_m1__nf1_gboth_sdfull_pc/B.n431 VSUBS 0.002f ; **FLOATING
C364 pfet_01v8_lvt_W90p63_L0p74_m1__nf1_gboth_sdfull_pc/B.n433 VSUBS 0.002f ; **FLOATING
C365 pfet_01v8_lvt_W90p63_L0p74_m1__nf1_gboth_sdfull_pc/B.n434 VSUBS 0.002f ; **FLOATING
C366 pfet_01v8_lvt_W90p63_L0p74_m1__nf1_gboth_sdfull_pc/B.n435 VSUBS 0.002f ; **FLOATING
C367 pfet_01v8_lvt_W90p63_L0p74_m1__nf1_gboth_sdfull_pc/B.n436 VSUBS 0.002f ; **FLOATING
C368 pfet_01v8_lvt_W90p63_L0p74_m1__nf1_gboth_sdfull_pc/B.n437 VSUBS 0.002f ; **FLOATING
C369 pfet_01v8_lvt_W90p63_L0p74_m1__nf1_gboth_sdfull_pc/B.n439 VSUBS 0.002f ; **FLOATING
C370 pfet_01v8_lvt_W90p63_L0p74_m1__nf1_gboth_sdfull_pc/B.n441 VSUBS 0.002f ; **FLOATING
C371 pfet_01v8_lvt_W90p63_L0p74_m1__nf1_gboth_sdfull_pc/B.n442 VSUBS 0.002f ; **FLOATING
C372 pfet_01v8_lvt_W90p63_L0p74_m1__nf1_gboth_sdfull_pc/B.n443 VSUBS 0.002f ; **FLOATING
C373 pfet_01v8_lvt_W90p63_L0p74_m1__nf1_gboth_sdfull_pc/B.n444 VSUBS 0.002f ; **FLOATING
C374 pfet_01v8_lvt_W90p63_L0p74_m1__nf1_gboth_sdfull_pc/B.n445 VSUBS 0.002f ; **FLOATING
C375 pfet_01v8_lvt_W90p63_L0p74_m1__nf1_gboth_sdfull_pc/B.n447 VSUBS 0.002f ; **FLOATING
C376 pfet_01v8_lvt_W90p63_L0p74_m1__nf1_gboth_sdfull_pc/B.n448 VSUBS 0.002f ; **FLOATING
C377 pfet_01v8_lvt_W90p63_L0p74_m1__nf1_gboth_sdfull_pc/B.n450 VSUBS 0.002f ; **FLOATING
C378 pfet_01v8_lvt_W90p63_L0p74_m1__nf1_gboth_sdfull_pc/B.n451 VSUBS 0.002f ; **FLOATING
C379 pfet_01v8_lvt_W90p63_L0p74_m1__nf1_gboth_sdfull_pc/B.n452 VSUBS 0.002f ; **FLOATING
C380 pfet_01v8_lvt_W90p63_L0p74_m1__nf1_gboth_sdfull_pc/B.n453 VSUBS 0.002f ; **FLOATING
C381 pfet_01v8_lvt_W90p63_L0p74_m1__nf1_gboth_sdfull_pc/B.n454 VSUBS 0.002f ; **FLOATING
C382 pfet_01v8_lvt_W90p63_L0p74_m1__nf1_gboth_sdfull_pc/B.n456 VSUBS 0.002f ; **FLOATING
C383 pfet_01v8_lvt_W90p63_L0p74_m1__nf1_gboth_sdfull_pc/B.n458 VSUBS 0.002f ; **FLOATING
C384 pfet_01v8_lvt_W90p63_L0p74_m1__nf1_gboth_sdfull_pc/B.n459 VSUBS 0.002f ; **FLOATING
C385 pfet_01v8_lvt_W90p63_L0p74_m1__nf1_gboth_sdfull_pc/B.n460 VSUBS 0.002f ; **FLOATING
C386 pfet_01v8_lvt_W90p63_L0p74_m1__nf1_gboth_sdfull_pc/B.n461 VSUBS 0.002f ; **FLOATING
C387 pfet_01v8_lvt_W90p63_L0p74_m1__nf1_gboth_sdfull_pc/B.n462 VSUBS 0.002f ; **FLOATING
C388 pfet_01v8_lvt_W90p63_L0p74_m1__nf1_gboth_sdfull_pc/B.n464 VSUBS 0.002f ; **FLOATING
C389 pfet_01v8_lvt_W90p63_L0p74_m1__nf1_gboth_sdfull_pc/B.n465 VSUBS 0.002f ; **FLOATING
C390 pfet_01v8_lvt_W90p63_L0p74_m1__nf1_gboth_sdfull_pc/B.n466 VSUBS 0.002f ; **FLOATING
C391 pfet_01v8_lvt_W90p63_L0p74_m1__nf1_gboth_sdfull_pc/B.n467 VSUBS 0.002f ; **FLOATING
C392 pfet_01v8_lvt_W90p63_L0p74_m1__nf1_gboth_sdfull_pc/B.n468 VSUBS 0.002f ; **FLOATING
C393 pfet_01v8_lvt_W90p63_L0p74_m1__nf1_gboth_sdfull_pc/B.n469 VSUBS 0.002f ; **FLOATING
C394 pfet_01v8_lvt_W90p63_L0p74_m1__nf1_gboth_sdfull_pc/B.n471 VSUBS 0.002f ; **FLOATING
C395 pfet_01v8_lvt_W90p63_L0p74_m1__nf1_gboth_sdfull_pc/B.n472 VSUBS 0.002f ; **FLOATING
C396 pfet_01v8_lvt_W90p63_L0p74_m1__nf1_gboth_sdfull_pc/B.n473 VSUBS 0.002f ; **FLOATING
C397 pfet_01v8_lvt_W90p63_L0p74_m1__nf1_gboth_sdfull_pc/B.n474 VSUBS 0.002f ; **FLOATING
C398 pfet_01v8_lvt_W90p63_L0p74_m1__nf1_gboth_sdfull_pc/B.n475 VSUBS 0.002f ; **FLOATING
C399 pfet_01v8_lvt_W90p63_L0p74_m1__nf1_gboth_sdfull_pc/B.n477 VSUBS 0.002f ; **FLOATING
C400 pfet_01v8_lvt_W90p63_L0p74_m1__nf1_gboth_sdfull_pc/B.n478 VSUBS 0.002f ; **FLOATING
C401 pfet_01v8_lvt_W90p63_L0p74_m1__nf1_gboth_sdfull_pc/B.n479 VSUBS 0.002f ; **FLOATING
C402 pfet_01v8_lvt_W90p63_L0p74_m1__nf1_gboth_sdfull_pc/B.n480 VSUBS 0.002f ; **FLOATING
C403 pfet_01v8_lvt_W90p63_L0p74_m1__nf1_gboth_sdfull_pc/B.n481 VSUBS 0.002f ; **FLOATING
C404 pfet_01v8_lvt_W90p63_L0p74_m1__nf1_gboth_sdfull_pc/B.n482 VSUBS 0.002f ; **FLOATING
C405 pfet_01v8_lvt_W90p63_L0p74_m1__nf1_gboth_sdfull_pc/B.n484 VSUBS 0.002f ; **FLOATING
C406 pfet_01v8_lvt_W90p63_L0p74_m1__nf1_gboth_sdfull_pc/B.n485 VSUBS 0.002f ; **FLOATING
C407 pfet_01v8_lvt_W90p63_L0p74_m1__nf1_gboth_sdfull_pc/B.n486 VSUBS 0.002f ; **FLOATING
C408 pfet_01v8_lvt_W90p63_L0p74_m1__nf1_gboth_sdfull_pc/B.n487 VSUBS 0.002f ; **FLOATING
C409 pfet_01v8_lvt_W90p63_L0p74_m1__nf1_gboth_sdfull_pc/B.n488 VSUBS 0.002f ; **FLOATING
C410 pfet_01v8_lvt_W90p63_L0p74_m1__nf1_gboth_sdfull_pc/B.n490 VSUBS 0.002f ; **FLOATING
C411 pfet_01v8_lvt_W90p63_L0p74_m1__nf1_gboth_sdfull_pc/B.n492 VSUBS 0.002f ; **FLOATING
C412 pfet_01v8_lvt_W90p63_L0p74_m1__nf1_gboth_sdfull_pc/B.n493 VSUBS 0.002f ; **FLOATING
C413 pfet_01v8_lvt_W90p63_L0p74_m1__nf1_gboth_sdfull_pc/B.n494 VSUBS 0.002f ; **FLOATING
C414 pfet_01v8_lvt_W90p63_L0p74_m1__nf1_gboth_sdfull_pc/B.n495 VSUBS 0.002f ; **FLOATING
C415 pfet_01v8_lvt_W90p63_L0p74_m1__nf1_gboth_sdfull_pc/B.n496 VSUBS 0.002f ; **FLOATING
C416 pfet_01v8_lvt_W90p63_L0p74_m1__nf1_gboth_sdfull_pc/B.n498 VSUBS 0.002f ; **FLOATING
C417 pfet_01v8_lvt_W90p63_L0p74_m1__nf1_gboth_sdfull_pc/B.n500 VSUBS 0.002f ; **FLOATING
C418 pfet_01v8_lvt_W90p63_L0p74_m1__nf1_gboth_sdfull_pc/B.n501 VSUBS 0.002f ; **FLOATING
C419 pfet_01v8_lvt_W90p63_L0p74_m1__nf1_gboth_sdfull_pc/B.n502 VSUBS 0.002f ; **FLOATING
C420 pfet_01v8_lvt_W90p63_L0p74_m1__nf1_gboth_sdfull_pc/B.n503 VSUBS 0.002f ; **FLOATING
C421 pfet_01v8_lvt_W90p63_L0p74_m1__nf1_gboth_sdfull_pc/B.n504 VSUBS 0.002f ; **FLOATING
C422 pfet_01v8_lvt_W90p63_L0p74_m1__nf1_gboth_sdfull_pc/B.n506 VSUBS 0.002f ; **FLOATING
C423 pfet_01v8_lvt_W90p63_L0p74_m1__nf1_gboth_sdfull_pc/B.n507 VSUBS 0.002f ; **FLOATING
C424 pfet_01v8_lvt_W90p63_L0p74_m1__nf1_gboth_sdfull_pc/B.n508 VSUBS 0.002f ; **FLOATING
C425 pfet_01v8_lvt_W90p63_L0p74_m1__nf1_gboth_sdfull_pc/B.n509 VSUBS 0.002f ; **FLOATING
C426 pfet_01v8_lvt_W90p63_L0p74_m1__nf1_gboth_sdfull_pc/B.n510 VSUBS 0.002f ; **FLOATING
C427 pfet_01v8_lvt_W90p63_L0p74_m1__nf1_gboth_sdfull_pc/B.n511 VSUBS 0.002f ; **FLOATING
C428 pfet_01v8_lvt_W90p63_L0p74_m1__nf1_gboth_sdfull_pc/B.n512 VSUBS 0.002f ; **FLOATING
C429 pfet_01v8_lvt_W90p63_L0p74_m1__nf1_gboth_sdfull_pc/B.n513 VSUBS 0.002f ; **FLOATING
C430 pfet_01v8_lvt_W90p63_L0p74_m1__nf1_gboth_sdfull_pc/B.n514 VSUBS 0.002f ; **FLOATING
C431 pfet_01v8_lvt_W90p63_L0p74_m1__nf1_gboth_sdfull_pc/B.n515 VSUBS 0.002f ; **FLOATING
C432 pfet_01v8_lvt_W90p63_L0p74_m1__nf1_gboth_sdfull_pc/B.n516 VSUBS 0.002f ; **FLOATING
C433 pfet_01v8_lvt_W90p63_L0p74_m1__nf1_gboth_sdfull_pc/B.n517 VSUBS 0.002f ; **FLOATING
C434 pfet_01v8_lvt_W90p63_L0p74_m1__nf1_gboth_sdfull_pc/B.n518 VSUBS 0.002f ; **FLOATING
C435 pfet_01v8_lvt_W90p63_L0p74_m1__nf1_gboth_sdfull_pc/B.n519 VSUBS 0.002f ; **FLOATING
C436 pfet_01v8_lvt_W90p63_L0p74_m1__nf1_gboth_sdfull_pc/B.n520 VSUBS 0.002f ; **FLOATING
C437 pfet_01v8_lvt_W90p63_L0p74_m1__nf1_gboth_sdfull_pc/B.n521 VSUBS 0.002f ; **FLOATING
C438 pfet_01v8_lvt_W90p63_L0p74_m1__nf1_gboth_sdfull_pc/B.n522 VSUBS 0.002f ; **FLOATING
C439 pfet_01v8_lvt_W90p63_L0p74_m1__nf1_gboth_sdfull_pc/B.n524 VSUBS 0.002f ; **FLOATING
C440 pfet_01v8_lvt_W90p63_L0p74_m1__nf1_gboth_sdfull_pc/B.n525 VSUBS 0.002f ; **FLOATING
C441 pfet_01v8_lvt_W90p63_L0p74_m1__nf1_gboth_sdfull_pc/B.n526 VSUBS 0.002f ; **FLOATING
C442 pfet_01v8_lvt_W90p63_L0p74_m1__nf1_gboth_sdfull_pc/B.n527 VSUBS 0.002f ; **FLOATING
C443 pfet_01v8_lvt_W90p63_L0p74_m1__nf1_gboth_sdfull_pc/B.n528 VSUBS 0.002f ; **FLOATING
C444 pfet_01v8_lvt_W90p63_L0p74_m1__nf1_gboth_sdfull_pc/B.n530 VSUBS 0.002f ; **FLOATING
C445 pfet_01v8_lvt_W90p63_L0p74_m1__nf1_gboth_sdfull_pc/B.n531 VSUBS 0.002f ; **FLOATING
C446 pfet_01v8_lvt_W90p63_L0p74_m1__nf1_gboth_sdfull_pc/B.n532 VSUBS 0.002f ; **FLOATING
C447 pfet_01v8_lvt_W90p63_L0p74_m1__nf1_gboth_sdfull_pc/B.n533 VSUBS 0.002f ; **FLOATING
C448 pfet_01v8_lvt_W90p63_L0p74_m1__nf1_gboth_sdfull_pc/B.n534 VSUBS 0.002f ; **FLOATING
C449 pfet_01v8_lvt_W90p63_L0p74_m1__nf1_gboth_sdfull_pc/B.n535 VSUBS 0.002f ; **FLOATING
C450 pfet_01v8_lvt_W90p63_L0p74_m1__nf1_gboth_sdfull_pc/B.n537 VSUBS 0.002f ; **FLOATING
C451 pfet_01v8_lvt_W90p63_L0p74_m1__nf1_gboth_sdfull_pc/B.n538 VSUBS 0.002f ; **FLOATING
C452 pfet_01v8_lvt_W90p63_L0p74_m1__nf1_gboth_sdfull_pc/B.n539 VSUBS 0.002f ; **FLOATING
C453 pfet_01v8_lvt_W90p63_L0p74_m1__nf1_gboth_sdfull_pc/B.n540 VSUBS 0.002f ; **FLOATING
C454 pfet_01v8_lvt_W90p63_L0p74_m1__nf1_gboth_sdfull_pc/B.n541 VSUBS 0.002f ; **FLOATING
C455 pfet_01v8_lvt_W90p63_L0p74_m1__nf1_gboth_sdfull_pc/B.n543 VSUBS 0.002f ; **FLOATING
C456 pfet_01v8_lvt_W90p63_L0p74_m1__nf1_gboth_sdfull_pc/B.n544 VSUBS 0.002f ; **FLOATING
C457 pfet_01v8_lvt_W90p63_L0p74_m1__nf1_gboth_sdfull_pc/B.n546 VSUBS 0.002f ; **FLOATING
C458 pfet_01v8_lvt_W90p63_L0p74_m1__nf1_gboth_sdfull_pc/B.n547 VSUBS 0.002f ; **FLOATING
C459 pfet_01v8_lvt_W90p63_L0p74_m1__nf1_gboth_sdfull_pc/B.n548 VSUBS 0.002f ; **FLOATING
C460 pfet_01v8_lvt_W90p63_L0p74_m1__nf1_gboth_sdfull_pc/B.n549 VSUBS 0.002f ; **FLOATING
C461 pfet_01v8_lvt_W90p63_L0p74_m1__nf1_gboth_sdfull_pc/B.n550 VSUBS 0.002f ; **FLOATING
C462 pfet_01v8_lvt_W90p63_L0p74_m1__nf1_gboth_sdfull_pc/B.n552 VSUBS 0.002f ; **FLOATING
C463 pfet_01v8_lvt_W90p63_L0p74_m1__nf1_gboth_sdfull_pc/B.n553 VSUBS 0.002f ; **FLOATING
C464 pfet_01v8_lvt_W90p63_L0p74_m1__nf1_gboth_sdfull_pc/B.n554 VSUBS 0.002f ; **FLOATING
C465 pfet_01v8_lvt_W90p63_L0p74_m1__nf1_gboth_sdfull_pc/B.n555 VSUBS 0.002f ; **FLOATING
C466 pfet_01v8_lvt_W90p63_L0p74_m1__nf1_gboth_sdfull_pc/B.n556 VSUBS 0.002f ; **FLOATING
C467 pfet_01v8_lvt_W90p63_L0p74_m1__nf1_gboth_sdfull_pc/B.n557 VSUBS 0.002f ; **FLOATING
C468 pfet_01v8_lvt_W90p63_L0p74_m1__nf1_gboth_sdfull_pc/B.n558 VSUBS 0.002f ; **FLOATING
C469 pfet_01v8_lvt_W90p63_L0p74_m1__nf1_gboth_sdfull_pc/B.n560 VSUBS 0.002f ; **FLOATING
C470 pfet_01v8_lvt_W90p63_L0p74_m1__nf1_gboth_sdfull_pc/B.n561 VSUBS 0.002f ; **FLOATING
C471 pfet_01v8_lvt_W90p63_L0p74_m1__nf1_gboth_sdfull_pc/B.n562 VSUBS 0.002f ; **FLOATING
C472 pfet_01v8_lvt_W90p63_L0p74_m1__nf1_gboth_sdfull_pc/B.n563 VSUBS 0.002f ; **FLOATING
C473 pfet_01v8_lvt_W90p63_L0p74_m1__nf1_gboth_sdfull_pc/B.n564 VSUBS 0.002f ; **FLOATING
C474 pfet_01v8_lvt_W90p63_L0p74_m1__nf1_gboth_sdfull_pc/B.n566 VSUBS 0.002f ; **FLOATING
C475 pfet_01v8_lvt_W90p63_L0p74_m1__nf1_gboth_sdfull_pc/B.n567 VSUBS 0.002f ; **FLOATING
C476 pfet_01v8_lvt_W90p63_L0p74_m1__nf1_gboth_sdfull_pc/B.n568 VSUBS 0.002f ; **FLOATING
C477 pfet_01v8_lvt_W90p63_L0p74_m1__nf1_gboth_sdfull_pc/B.n569 VSUBS 0.002f ; **FLOATING
C478 pfet_01v8_lvt_W90p63_L0p74_m1__nf1_gboth_sdfull_pc/B.n570 VSUBS 0.002f ; **FLOATING
C479 pfet_01v8_lvt_W90p63_L0p74_m1__nf1_gboth_sdfull_pc/B.n571 VSUBS 0.002f ; **FLOATING
C480 pfet_01v8_lvt_W90p63_L0p74_m1__nf1_gboth_sdfull_pc/B.n573 VSUBS 0.002f ; **FLOATING
C481 pfet_01v8_lvt_W90p63_L0p74_m1__nf1_gboth_sdfull_pc/B.n574 VSUBS 0.002f ; **FLOATING
C482 pfet_01v8_lvt_W90p63_L0p74_m1__nf1_gboth_sdfull_pc/B.n575 VSUBS 0.002f ; **FLOATING
C483 pfet_01v8_lvt_W90p63_L0p74_m1__nf1_gboth_sdfull_pc/B.n576 VSUBS 0.002f ; **FLOATING
C484 pfet_01v8_lvt_W90p63_L0p74_m1__nf1_gboth_sdfull_pc/B.n577 VSUBS 0.002f ; **FLOATING
C485 pfet_01v8_lvt_W90p63_L0p74_m1__nf1_gboth_sdfull_pc/B.n579 VSUBS 0.002f ; **FLOATING
C486 pfet_01v8_lvt_W90p63_L0p74_m1__nf1_gboth_sdfull_pc/B.n581 VSUBS 0.002f ; **FLOATING
C487 pfet_01v8_lvt_W90p63_L0p74_m1__nf1_gboth_sdfull_pc/B.n582 VSUBS 0.002f ; **FLOATING
C488 pfet_01v8_lvt_W90p63_L0p74_m1__nf1_gboth_sdfull_pc/B.n583 VSUBS 0.002f ; **FLOATING
C489 pfet_01v8_lvt_W90p63_L0p74_m1__nf1_gboth_sdfull_pc/B.n584 VSUBS 0.002f ; **FLOATING
C490 pfet_01v8_lvt_W90p63_L0p74_m1__nf1_gboth_sdfull_pc/B.n585 VSUBS 0.002f ; **FLOATING
C491 pfet_01v8_lvt_W90p63_L0p74_m1__nf1_gboth_sdfull_pc/B.n587 VSUBS 0.002f ; **FLOATING
C492 pfet_01v8_lvt_W90p63_L0p74_m1__nf1_gboth_sdfull_pc/B.n588 VSUBS 0.002f ; **FLOATING
C493 pfet_01v8_lvt_W90p63_L0p74_m1__nf1_gboth_sdfull_pc/B.n589 VSUBS 0.002f ; **FLOATING
C494 pfet_01v8_lvt_W90p63_L0p74_m1__nf1_gboth_sdfull_pc/B.n590 VSUBS 0.002f ; **FLOATING
C495 pfet_01v8_lvt_W90p63_L0p74_m1__nf1_gboth_sdfull_pc/B.n591 VSUBS 0.002f ; **FLOATING
C496 pfet_01v8_lvt_W90p63_L0p74_m1__nf1_gboth_sdfull_pc/B.n592 VSUBS 0.002f ; **FLOATING
C497 pfet_01v8_lvt_W90p63_L0p74_m1__nf1_gboth_sdfull_pc/B.n594 VSUBS 0.002f ; **FLOATING
C498 pfet_01v8_lvt_W90p63_L0p74_m1__nf1_gboth_sdfull_pc/B.n595 VSUBS 0.002f ; **FLOATING
C499 pfet_01v8_lvt_W90p63_L0p74_m1__nf1_gboth_sdfull_pc/B.n596 VSUBS 0.002f ; **FLOATING
C500 pfet_01v8_lvt_W90p63_L0p74_m1__nf1_gboth_sdfull_pc/B.n597 VSUBS 0.002f ; **FLOATING
C501 pfet_01v8_lvt_W90p63_L0p74_m1__nf1_gboth_sdfull_pc/B.n598 VSUBS 0.002f ; **FLOATING
C502 pfet_01v8_lvt_W90p63_L0p74_m1__nf1_gboth_sdfull_pc/B.n600 VSUBS 0.002f ; **FLOATING
C503 pfet_01v8_lvt_W90p63_L0p74_m1__nf1_gboth_sdfull_pc/B.n602 VSUBS 0.002f ; **FLOATING
C504 pfet_01v8_lvt_W90p63_L0p74_m1__nf1_gboth_sdfull_pc/B.n603 VSUBS 0.002f ; **FLOATING
C505 pfet_01v8_lvt_W90p63_L0p74_m1__nf1_gboth_sdfull_pc/B.n604 VSUBS 0.002f ; **FLOATING
C506 pfet_01v8_lvt_W90p63_L0p74_m1__nf1_gboth_sdfull_pc/B.n605 VSUBS 0.002f ; **FLOATING
C507 pfet_01v8_lvt_W90p63_L0p74_m1__nf1_gboth_sdfull_pc/B.n606 VSUBS 0.002f ; **FLOATING
C508 pfet_01v8_lvt_W90p63_L0p74_m1__nf1_gboth_sdfull_pc/B.n608 VSUBS 0.002f ; **FLOATING
C509 pfet_01v8_lvt_W90p63_L0p74_m1__nf1_gboth_sdfull_pc/B.n610 VSUBS 0.002f ; **FLOATING
C510 pfet_01v8_lvt_W90p63_L0p74_m1__nf1_gboth_sdfull_pc/B.n611 VSUBS 0.002f ; **FLOATING
C511 pfet_01v8_lvt_W90p63_L0p74_m1__nf1_gboth_sdfull_pc/B.n612 VSUBS 0.002f ; **FLOATING
C512 pfet_01v8_lvt_W90p63_L0p74_m1__nf1_gboth_sdfull_pc/B.n613 VSUBS 0.002f ; **FLOATING
C513 pfet_01v8_lvt_W90p63_L0p74_m1__nf1_gboth_sdfull_pc/B.n614 VSUBS 0.002f ; **FLOATING
C514 pfet_01v8_lvt_W90p63_L0p74_m1__nf1_gboth_sdfull_pc/B.n616 VSUBS 0.002f ; **FLOATING
C515 pfet_01v8_lvt_W90p63_L0p74_m1__nf1_gboth_sdfull_pc/B.n618 VSUBS 0.002f ; **FLOATING
C516 pfet_01v8_lvt_W90p63_L0p74_m1__nf1_gboth_sdfull_pc/B.n619 VSUBS 0.002f ; **FLOATING
C517 pfet_01v8_lvt_W90p63_L0p74_m1__nf1_gboth_sdfull_pc/B.n620 VSUBS 0.002f ; **FLOATING
C518 pfet_01v8_lvt_W90p63_L0p74_m1__nf1_gboth_sdfull_pc/B.n621 VSUBS 0.002f ; **FLOATING
C519 pfet_01v8_lvt_W90p63_L0p74_m1__nf1_gboth_sdfull_pc/B.n622 VSUBS 0.002f ; **FLOATING
C520 pfet_01v8_lvt_W90p63_L0p74_m1__nf1_gboth_sdfull_pc/B.n624 VSUBS 0.002f ; **FLOATING
C521 pfet_01v8_lvt_W90p63_L0p74_m1__nf1_gboth_sdfull_pc/B.n625 VSUBS 0.002f ; **FLOATING
C522 pfet_01v8_lvt_W90p63_L0p74_m1__nf1_gboth_sdfull_pc/B.n627 VSUBS 0.002f ; **FLOATING
C523 pfet_01v8_lvt_W90p63_L0p74_m1__nf1_gboth_sdfull_pc/B.n628 VSUBS 0.002f ; **FLOATING
C524 pfet_01v8_lvt_W90p63_L0p74_m1__nf1_gboth_sdfull_pc/B.n629 VSUBS 0.002f ; **FLOATING
C525 pfet_01v8_lvt_W90p63_L0p74_m1__nf1_gboth_sdfull_pc/B.n630 VSUBS 0.002f ; **FLOATING
C526 pfet_01v8_lvt_W90p63_L0p74_m1__nf1_gboth_sdfull_pc/B.n631 VSUBS 0.002f ; **FLOATING
C527 pfet_01v8_lvt_W90p63_L0p74_m1__nf1_gboth_sdfull_pc/B.n633 VSUBS 0.002f ; **FLOATING
C528 pfet_01v8_lvt_W90p63_L0p74_m1__nf1_gboth_sdfull_pc/B.n634 VSUBS 0.002f ; **FLOATING
C529 pfet_01v8_lvt_W90p63_L0p74_m1__nf1_gboth_sdfull_pc/B.n635 VSUBS 0.002f ; **FLOATING
C530 pfet_01v8_lvt_W90p63_L0p74_m1__nf1_gboth_sdfull_pc/B.n636 VSUBS 0.002f ; **FLOATING
C531 pfet_01v8_lvt_W90p63_L0p74_m1__nf1_gboth_sdfull_pc/B.n637 VSUBS 0.002f ; **FLOATING
C532 pfet_01v8_lvt_W90p63_L0p74_m1__nf1_gboth_sdfull_pc/B.n638 VSUBS 0.002f ; **FLOATING
C533 pfet_01v8_lvt_W90p63_L0p74_m1__nf1_gboth_sdfull_pc/B.n639 VSUBS 0.002f ; **FLOATING
C534 pfet_01v8_lvt_W90p63_L0p74_m1__nf1_gboth_sdfull_pc/B.n640 VSUBS 0.002f ; **FLOATING
C535 pfet_01v8_lvt_W90p63_L0p74_m1__nf1_gboth_sdfull_pc/B.n641 VSUBS 0.002f ; **FLOATING
C536 pfet_01v8_lvt_W90p63_L0p74_m1__nf1_gboth_sdfull_pc/B.n642 VSUBS 0.002f ; **FLOATING
C537 pfet_01v8_lvt_W90p63_L0p74_m1__nf1_gboth_sdfull_pc/B.n643 VSUBS 0.002f ; **FLOATING
C538 pfet_01v8_lvt_W90p63_L0p74_m1__nf1_gboth_sdfull_pc/B.n644 VSUBS 0.002f ; **FLOATING
C539 pfet_01v8_lvt_W90p63_L0p74_m1__nf1_gboth_sdfull_pc/B.n645 VSUBS 0.002f ; **FLOATING
C540 pfet_01v8_lvt_W90p63_L0p74_m1__nf1_gboth_sdfull_pc/B.n646 VSUBS 0.002f ; **FLOATING
C541 pfet_01v8_lvt_W90p63_L0p74_m1__nf1_gboth_sdfull_pc/B.n647 VSUBS 0.002f ; **FLOATING
C542 pfet_01v8_lvt_W90p63_L0p74_m1__nf1_gboth_sdfull_pc/B.n648 VSUBS 0.002f ; **FLOATING
C543 pfet_01v8_lvt_W90p63_L0p74_m1__nf1_gboth_sdfull_pc/B.n649 VSUBS 0.002f ; **FLOATING
C544 pfet_01v8_lvt_W90p63_L0p74_m1__nf1_gboth_sdfull_pc/B.n650 VSUBS 0.002f ; **FLOATING
C545 pfet_01v8_lvt_W90p63_L0p74_m1__nf1_gboth_sdfull_pc/B.n651 VSUBS 0.002f ; **FLOATING
C546 pfet_01v8_lvt_W90p63_L0p74_m1__nf1_gboth_sdfull_pc/B.n652 VSUBS 0.002f ; **FLOATING
C547 pfet_01v8_lvt_W90p63_L0p74_m1__nf1_gboth_sdfull_pc/B.n653 VSUBS 0.002f ; **FLOATING
C548 pfet_01v8_lvt_W90p63_L0p74_m1__nf1_gboth_sdfull_pc/B.n655 VSUBS 0.002f ; **FLOATING
C549 pfet_01v8_lvt_W90p63_L0p74_m1__nf1_gboth_sdfull_pc/B.n656 VSUBS 0.002f ; **FLOATING
C550 pfet_01v8_lvt_W90p63_L0p74_m1__nf1_gboth_sdfull_pc/B.n657 VSUBS 0.002f ; **FLOATING
C551 pfet_01v8_lvt_W90p63_L0p74_m1__nf1_gboth_sdfull_pc/B.n658 VSUBS 0.002f ; **FLOATING
C552 pfet_01v8_lvt_W90p63_L0p74_m1__nf1_gboth_sdfull_pc/B.n659 VSUBS 0.002f ; **FLOATING
C553 pfet_01v8_lvt_W90p63_L0p74_m1__nf1_gboth_sdfull_pc/B.n661 VSUBS 0.002f ; **FLOATING
C554 pfet_01v8_lvt_W90p63_L0p74_m1__nf1_gboth_sdfull_pc/B.n663 VSUBS 0.002f ; **FLOATING
C555 pfet_01v8_lvt_W90p63_L0p74_m1__nf1_gboth_sdfull_pc/B.n664 VSUBS 0.002f ; **FLOATING
C556 pfet_01v8_lvt_W90p63_L0p74_m1__nf1_gboth_sdfull_pc/B.n665 VSUBS 0.00442f ; **FLOATING
C557 pfet_01v8_lvt_W90p63_L0p74_m1__nf1_gboth_sdfull_pc/B.n666 VSUBS 0.00439f ; **FLOATING
C558 pfet_01v8_lvt_W90p63_L0p74_m1__nf1_gboth_sdfull_pc/B.n667 VSUBS 0.00439f ; **FLOATING
C559 pfet_01v8_lvt_W90p63_L0p74_m1__nf1_gboth_sdfull_pc/B.n668 VSUBS 0.81805f ; **FLOATING
C560 pfet_01v8_lvt_W90p63_L0p74_m1__nf1_gboth_sdfull_pc/B.n669 VSUBS 1.46768f ; **FLOATING
C561 pfet_01v8_lvt_W90p63_L0p74_m1__nf1_gboth_sdfull_pc/B.n670 VSUBS 0.00439f ; **FLOATING
C562 pfet_01v8_lvt_W90p63_L0p74_m1__nf1_gboth_sdfull_pc/B.n671 VSUBS 0.00439f ; **FLOATING
C563 pfet_01v8_lvt_W90p63_L0p74_m1__nf1_gboth_sdfull_pc/B.n672 VSUBS 0.002f ; **FLOATING
C564 pfet_01v8_lvt_W90p63_L0p74_m1__nf1_gboth_sdfull_pc/B.n673 VSUBS 0.002f ; **FLOATING
C565 pfet_01v8_lvt_W90p63_L0p74_m1__nf1_gboth_sdfull_pc/B.n674 VSUBS 0.002f ; **FLOATING
C566 pfet_01v8_lvt_W90p63_L0p74_m1__nf1_gboth_sdfull_pc/B.n675 VSUBS 0.002f ; **FLOATING
C567 pfet_01v8_lvt_W90p63_L0p74_m1__nf1_gboth_sdfull_pc/B.n699 VSUBS 0.002f ; **FLOATING
C568 pfet_01v8_lvt_W90p63_L0p74_m1__nf1_gboth_sdfull_pc/B.n704 VSUBS 0.002f ; **FLOATING
C569 pfet_01v8_lvt_W90p63_L0p74_m1__nf1_gboth_sdfull_pc/B.n707 VSUBS 0.002f ; **FLOATING
C570 pfet_01v8_lvt_W90p63_L0p74_m1__nf1_gboth_sdfull_pc/B.n710 VSUBS 0.002f ; **FLOATING
C571 pfet_01v8_lvt_W90p63_L0p74_m1__nf1_gboth_sdfull_pc/B.n712 VSUBS 0.002f ; **FLOATING
C572 pfet_01v8_lvt_W90p63_L0p74_m1__nf1_gboth_sdfull_pc/B.n714 VSUBS 0.002f ; **FLOATING
C573 pfet_01v8_lvt_W90p63_L0p74_m1__nf1_gboth_sdfull_pc/B.n721 VSUBS 0.002f ; **FLOATING
C574 pfet_01v8_lvt_W90p63_L0p74_m1__nf1_gboth_sdfull_pc/B.n723 VSUBS 0.002f ; **FLOATING
C575 pfet_01v8_lvt_W90p63_L0p74_m1__nf1_gboth_sdfull_pc/B.n725 VSUBS 0.002f ; **FLOATING
C576 pfet_01v8_lvt_W90p63_L0p74_m1__nf1_gboth_sdfull_pc/B.n733 VSUBS 0.002f ; **FLOATING
C577 pfet_01v8_lvt_W90p63_L0p74_m1__nf1_gboth_sdfull_pc/B.n736 VSUBS 0.002f ; **FLOATING
C578 pfet_01v8_lvt_W90p63_L0p74_m1__nf1_gboth_sdfull_pc/B.n739 VSUBS 0.002f ; **FLOATING
C579 pfet_01v8_lvt_W90p63_L0p74_m1__nf1_gboth_sdfull_pc/B.n741 VSUBS 0.002f ; **FLOATING
C580 pfet_01v8_lvt_W90p63_L0p74_m1__nf1_gboth_sdfull_pc/B.n744 VSUBS 0.002f ; **FLOATING
C581 pfet_01v8_lvt_W90p63_L0p74_m1__nf1_gboth_sdfull_pc/B.n748 VSUBS 0.002f ; **FLOATING
C582 pfet_01v8_lvt_W90p63_L0p74_m1__nf1_gboth_sdfull_pc/B.n751 VSUBS 0.002f ; **FLOATING
C583 pfet_01v8_lvt_W90p63_L0p74_m1__nf1_gboth_sdfull_pc/B.n756 VSUBS 0.00442f ; **FLOATING
C584 pfet_01v8_lvt_W90p63_L0p74_m1__nf1_gboth_sdfull_pc/B.n760 VSUBS 0.002f ; **FLOATING
C585 pfet_01v8_lvt_W90p63_L0p74_m1__nf1_gboth_sdfull_pc/B.n765 VSUBS 0.002f ; **FLOATING
C586 pfet_01v8_lvt_W90p63_L0p74_m1__nf1_gboth_sdfull_pc/B.n768 VSUBS 0.002f ; **FLOATING
C587 pfet_01v8_lvt_W90p63_L0p74_m1__nf1_gboth_sdfull_pc/B.n770 VSUBS 0.002f ; **FLOATING
C588 pfet_01v8_lvt_W90p63_L0p74_m1__nf1_gboth_sdfull_pc/B.n772 VSUBS 0.002f ; **FLOATING
C589 pfet_01v8_lvt_W90p63_L0p74_m1__nf1_gboth_sdfull_pc/B.n774 VSUBS 0.002f ; **FLOATING
C590 pfet_01v8_lvt_W90p63_L0p74_m1__nf1_gboth_sdfull_pc/B.n777 VSUBS 0.002f ; **FLOATING
C591 pfet_01v8_lvt_W90p63_L0p74_m1__nf1_gboth_sdfull_pc/B.n781 VSUBS 0.002f ; **FLOATING
C592 pfet_01v8_lvt_W90p63_L0p74_m1__nf1_gboth_sdfull_pc/B.n783 VSUBS 0.002f ; **FLOATING
C593 pfet_01v8_lvt_W90p63_L0p74_m1__nf1_gboth_sdfull_pc/B.n787 VSUBS 0.002f ; **FLOATING
C594 pfet_01v8_lvt_W90p63_L0p74_m1__nf1_gboth_sdfull_pc/B.n793 VSUBS 0.002f ; **FLOATING
C595 pfet_01v8_lvt_W90p63_L0p74_m1__nf1_gboth_sdfull_pc/B.n795 VSUBS 0.002f ; **FLOATING
C596 pfet_01v8_lvt_W90p63_L0p74_m1__nf1_gboth_sdfull_pc/B.n800 VSUBS 0.002f ; **FLOATING
C597 pfet_01v8_lvt_W90p63_L0p74_m1__nf1_gboth_sdfull_pc/B.n804 VSUBS 0.002f ; **FLOATING
C598 pfet_01v8_lvt_W90p63_L0p74_m1__nf1_gboth_sdfull_pc/B.n808 VSUBS 0.002f ; **FLOATING
C599 pfet_01v8_lvt_W90p63_L0p74_m1__nf1_gboth_sdfull_pc/B.n816 VSUBS 0.002f ; **FLOATING
C600 pfet_01v8_lvt_W90p63_L0p74_m1__nf1_gboth_sdfull_pc/B.n824 VSUBS 0.002f ; **FLOATING
C601 pfet_01v8_lvt_W90p63_L0p74_m1__nf1_gboth_sdfull_pc/B.n825 VSUBS 0.002f ; **FLOATING
C602 pfet_01v8_lvt_W90p63_L0p74_m1__nf1_gboth_sdfull_pc/B.n826 VSUBS 0.002f ; **FLOATING
C603 pfet_01v8_lvt_W90p63_L0p74_m1__nf1_gboth_sdfull_pc/B.n827 VSUBS 0.00442f ; **FLOATING
C604 pfet_01v8_lvt_W90p63_L0p74_m1__nf1_gboth_sdfull_pc/B.n828 VSUBS 0.002f ; **FLOATING
C605 pfet_01v8_lvt_W90p63_L0p74_m1__nf1_gboth_sdfull_pc/B.n829 VSUBS 0.002f ; **FLOATING
C606 pfet_01v8_lvt_W90p63_L0p74_m1__nf1_gboth_sdfull_pc/B.n830 VSUBS 0.002f ; **FLOATING
C607 pfet_01v8_lvt_W90p63_L0p74_m1__nf1_gboth_sdfull_pc/B.n831 VSUBS 0.002f ; **FLOATING
C608 pfet_01v8_lvt_W90p63_L0p74_m1__nf1_gboth_sdfull_pc/B.n832 VSUBS 0.002f ; **FLOATING
C609 pfet_01v8_lvt_W90p63_L0p74_m1__nf1_gboth_sdfull_pc/B.n833 VSUBS 0.002f ; **FLOATING
C610 pfet_01v8_lvt_W90p63_L0p74_m1__nf1_gboth_sdfull_pc/B.n834 VSUBS 0.002f ; **FLOATING
C611 pfet_01v8_lvt_W90p63_L0p74_m1__nf1_gboth_sdfull_pc/B.n835 VSUBS 0.002f ; **FLOATING
C612 pfet_01v8_lvt_W90p63_L0p74_m1__nf1_gboth_sdfull_pc/B.n836 VSUBS 0.002f ; **FLOATING
C613 pfet_01v8_lvt_W90p63_L0p74_m1__nf1_gboth_sdfull_pc/B.n837 VSUBS 0.002f ; **FLOATING
C614 pfet_01v8_lvt_W90p63_L0p74_m1__nf1_gboth_sdfull_pc/B.n838 VSUBS 0.002f ; **FLOATING
C615 pfet_01v8_lvt_W90p63_L0p74_m1__nf1_gboth_sdfull_pc/B.n839 VSUBS 0.002f ; **FLOATING
C616 pfet_01v8_lvt_W90p63_L0p74_m1__nf1_gboth_sdfull_pc/B.n840 VSUBS 0.002f ; **FLOATING
C617 pfet_01v8_lvt_W90p63_L0p74_m1__nf1_gboth_sdfull_pc/B.n841 VSUBS 0.002f ; **FLOATING
C618 pfet_01v8_lvt_W90p63_L0p74_m1__nf1_gboth_sdfull_pc/B.n842 VSUBS 0.002f ; **FLOATING
C619 pfet_01v8_lvt_W90p63_L0p74_m1__nf1_gboth_sdfull_pc/B.n843 VSUBS 0.002f ; **FLOATING
C620 pfet_01v8_lvt_W90p63_L0p74_m1__nf1_gboth_sdfull_pc/B.n844 VSUBS 0.002f ; **FLOATING
C621 pfet_01v8_lvt_W90p63_L0p74_m1__nf1_gboth_sdfull_pc/B.n845 VSUBS 0.002f ; **FLOATING
C622 pfet_01v8_lvt_W90p63_L0p74_m1__nf1_gboth_sdfull_pc/B.n846 VSUBS 0.002f ; **FLOATING
C623 pfet_01v8_lvt_W90p63_L0p74_m1__nf1_gboth_sdfull_pc/B.n847 VSUBS 0.002f ; **FLOATING
C624 pfet_01v8_lvt_W90p63_L0p74_m1__nf1_gboth_sdfull_pc/B.n848 VSUBS 0.002f ; **FLOATING
C625 pfet_01v8_lvt_W90p63_L0p74_m1__nf1_gboth_sdfull_pc/B.n849 VSUBS 0.002f ; **FLOATING
C626 pfet_01v8_lvt_W90p63_L0p74_m1__nf1_gboth_sdfull_pc/B.n850 VSUBS 0.002f ; **FLOATING
C627 pfet_01v8_lvt_W90p63_L0p74_m1__nf1_gboth_sdfull_pc/B.n851 VSUBS 0.002f ; **FLOATING
C628 pfet_01v8_lvt_W90p63_L0p74_m1__nf1_gboth_sdfull_pc/B.n852 VSUBS 0.002f ; **FLOATING
C629 pfet_01v8_lvt_W90p63_L0p74_m1__nf1_gboth_sdfull_pc/B.n853 VSUBS 0.002f ; **FLOATING
C630 pfet_01v8_lvt_W90p63_L0p74_m1__nf1_gboth_sdfull_pc/B.n854 VSUBS 0.002f ; **FLOATING
C631 pfet_01v8_lvt_W90p63_L0p74_m1__nf1_gboth_sdfull_pc/B.n855 VSUBS 0.002f ; **FLOATING
C632 pfet_01v8_lvt_W90p63_L0p74_m1__nf1_gboth_sdfull_pc/B.n856 VSUBS 0.002f ; **FLOATING
C633 pfet_01v8_lvt_W90p63_L0p74_m1__nf1_gboth_sdfull_pc/B.n857 VSUBS 0.002f ; **FLOATING
C634 pfet_01v8_lvt_W90p63_L0p74_m1__nf1_gboth_sdfull_pc/B.n858 VSUBS 0.002f ; **FLOATING
C635 pfet_01v8_lvt_W90p63_L0p74_m1__nf1_gboth_sdfull_pc/B.n859 VSUBS 0.002f ; **FLOATING
C636 pfet_01v8_lvt_W90p63_L0p74_m1__nf1_gboth_sdfull_pc/B.n860 VSUBS 0.002f ; **FLOATING
C637 pfet_01v8_lvt_W90p63_L0p74_m1__nf1_gboth_sdfull_pc/B.n861 VSUBS 0.002f ; **FLOATING
C638 pfet_01v8_lvt_W90p63_L0p74_m1__nf1_gboth_sdfull_pc/B.n862 VSUBS 0.002f ; **FLOATING
C639 pfet_01v8_lvt_W90p63_L0p74_m1__nf1_gboth_sdfull_pc/B.n863 VSUBS 0.002f ; **FLOATING
C640 pfet_01v8_lvt_W90p63_L0p74_m1__nf1_gboth_sdfull_pc/B.n864 VSUBS 0.002f ; **FLOATING
C641 pfet_01v8_lvt_W90p63_L0p74_m1__nf1_gboth_sdfull_pc/B.n865 VSUBS 0.002f ; **FLOATING
C642 pfet_01v8_lvt_W90p63_L0p74_m1__nf1_gboth_sdfull_pc/B.n866 VSUBS 0.002f ; **FLOATING
C643 pfet_01v8_lvt_W90p63_L0p74_m1__nf1_gboth_sdfull_pc/B.n867 VSUBS 0.002f ; **FLOATING
C644 pfet_01v8_lvt_W90p63_L0p74_m1__nf1_gboth_sdfull_pc/B.n868 VSUBS 0.002f ; **FLOATING
C645 pfet_01v8_lvt_W90p63_L0p74_m1__nf1_gboth_sdfull_pc/B.n869 VSUBS 0.002f ; **FLOATING
C646 pfet_01v8_lvt_W90p63_L0p74_m1__nf1_gboth_sdfull_pc/B.n870 VSUBS 0.002f ; **FLOATING
C647 pfet_01v8_lvt_W90p63_L0p74_m1__nf1_gboth_sdfull_pc/B.n871 VSUBS 0.002f ; **FLOATING
C648 pfet_01v8_lvt_W90p63_L0p74_m1__nf1_gboth_sdfull_pc/B.n872 VSUBS 0.002f ; **FLOATING
C649 pfet_01v8_lvt_W90p63_L0p74_m1__nf1_gboth_sdfull_pc/B.n873 VSUBS 0.002f ; **FLOATING
C650 pfet_01v8_lvt_W90p63_L0p74_m1__nf1_gboth_sdfull_pc/B.n874 VSUBS 0.002f ; **FLOATING
C651 pfet_01v8_lvt_W90p63_L0p74_m1__nf1_gboth_sdfull_pc/B.n875 VSUBS 0.002f ; **FLOATING
C652 pfet_01v8_lvt_W90p63_L0p74_m1__nf1_gboth_sdfull_pc/B.n876 VSUBS 0.002f ; **FLOATING
C653 pfet_01v8_lvt_W90p63_L0p74_m1__nf1_gboth_sdfull_pc/B.n877 VSUBS 0.002f ; **FLOATING
C654 pfet_01v8_lvt_W90p63_L0p74_m1__nf1_gboth_sdfull_pc/B.n878 VSUBS 0.002f ; **FLOATING
C655 pfet_01v8_lvt_W90p63_L0p74_m1__nf1_gboth_sdfull_pc/B.n879 VSUBS 0.002f ; **FLOATING
C656 pfet_01v8_lvt_W90p63_L0p74_m1__nf1_gboth_sdfull_pc/B.n880 VSUBS 0.002f ; **FLOATING
C657 pfet_01v8_lvt_W90p63_L0p74_m1__nf1_gboth_sdfull_pc/B.n881 VSUBS 0.002f ; **FLOATING
C658 pfet_01v8_lvt_W90p63_L0p74_m1__nf1_gboth_sdfull_pc/B.n882 VSUBS 0.002f ; **FLOATING
C659 pfet_01v8_lvt_W90p63_L0p74_m1__nf1_gboth_sdfull_pc/B.n883 VSUBS 0.002f ; **FLOATING
C660 pfet_01v8_lvt_W90p63_L0p74_m1__nf1_gboth_sdfull_pc/B.n884 VSUBS 0.002f ; **FLOATING
C661 pfet_01v8_lvt_W90p63_L0p74_m1__nf1_gboth_sdfull_pc/B.n885 VSUBS 0.002f ; **FLOATING
C662 pfet_01v8_lvt_W90p63_L0p74_m1__nf1_gboth_sdfull_pc/B.n886 VSUBS 0.002f ; **FLOATING
C663 pfet_01v8_lvt_W90p63_L0p74_m1__nf1_gboth_sdfull_pc/B.n887 VSUBS 0.002f ; **FLOATING
C664 pfet_01v8_lvt_W90p63_L0p74_m1__nf1_gboth_sdfull_pc/B.n888 VSUBS 0.002f ; **FLOATING
C665 pfet_01v8_lvt_W90p63_L0p74_m1__nf1_gboth_sdfull_pc/B.n889 VSUBS 0.002f ; **FLOATING
C666 pfet_01v8_lvt_W90p63_L0p74_m1__nf1_gboth_sdfull_pc/B.n890 VSUBS 0.002f ; **FLOATING
C667 pfet_01v8_lvt_W90p63_L0p74_m1__nf1_gboth_sdfull_pc/B.n891 VSUBS 0.002f ; **FLOATING
C668 pfet_01v8_lvt_W90p63_L0p74_m1__nf1_gboth_sdfull_pc/B.n892 VSUBS 0.002f ; **FLOATING
C669 pfet_01v8_lvt_W90p63_L0p74_m1__nf1_gboth_sdfull_pc/B.n893 VSUBS 0.002f ; **FLOATING
C670 pfet_01v8_lvt_W90p63_L0p74_m1__nf1_gboth_sdfull_pc/B.n894 VSUBS 0.002f ; **FLOATING
C671 pfet_01v8_lvt_W90p63_L0p74_m1__nf1_gboth_sdfull_pc/B.n895 VSUBS 0.002f ; **FLOATING
C672 pfet_01v8_lvt_W90p63_L0p74_m1__nf1_gboth_sdfull_pc/B.n896 VSUBS 0.002f ; **FLOATING
C673 pfet_01v8_lvt_W90p63_L0p74_m1__nf1_gboth_sdfull_pc/B.n897 VSUBS 0.002f ; **FLOATING
C674 pfet_01v8_lvt_W90p63_L0p74_m1__nf1_gboth_sdfull_pc/B.n898 VSUBS 0.002f ; **FLOATING
C675 pfet_01v8_lvt_W90p63_L0p74_m1__nf1_gboth_sdfull_pc/B.n899 VSUBS 0.002f ; **FLOATING
C676 pfet_01v8_lvt_W90p63_L0p74_m1__nf1_gboth_sdfull_pc/B.n900 VSUBS 0.002f ; **FLOATING
C677 pfet_01v8_lvt_W90p63_L0p74_m1__nf1_gboth_sdfull_pc/B.n901 VSUBS 0.002f ; **FLOATING
C678 pfet_01v8_lvt_W90p63_L0p74_m1__nf1_gboth_sdfull_pc/B.n902 VSUBS 0.002f ; **FLOATING
C679 pfet_01v8_lvt_W90p63_L0p74_m1__nf1_gboth_sdfull_pc/B.n903 VSUBS 0.002f ; **FLOATING
C680 pfet_01v8_lvt_W90p63_L0p74_m1__nf1_gboth_sdfull_pc/B.n904 VSUBS 0.002f ; **FLOATING
C681 pfet_01v8_lvt_W90p63_L0p74_m1__nf1_gboth_sdfull_pc/B.n905 VSUBS 0.002f ; **FLOATING
C682 pfet_01v8_lvt_W90p63_L0p74_m1__nf1_gboth_sdfull_pc/B.n906 VSUBS 0.002f ; **FLOATING
C683 pfet_01v8_lvt_W90p63_L0p74_m1__nf1_gboth_sdfull_pc/B.n907 VSUBS 0.002f ; **FLOATING
C684 pfet_01v8_lvt_W90p63_L0p74_m1__nf1_gboth_sdfull_pc/B.n908 VSUBS 0.002f ; **FLOATING
C685 pfet_01v8_lvt_W90p63_L0p74_m1__nf1_gboth_sdfull_pc/B.n909 VSUBS 0.002f ; **FLOATING
C686 pfet_01v8_lvt_W90p63_L0p74_m1__nf1_gboth_sdfull_pc/B.n910 VSUBS 0.002f ; **FLOATING
C687 pfet_01v8_lvt_W90p63_L0p74_m1__nf1_gboth_sdfull_pc/B.n911 VSUBS 0.002f ; **FLOATING
C688 pfet_01v8_lvt_W90p63_L0p74_m1__nf1_gboth_sdfull_pc/B.n912 VSUBS 0.002f ; **FLOATING
C689 pfet_01v8_lvt_W90p63_L0p74_m1__nf1_gboth_sdfull_pc/B.n913 VSUBS 0.002f ; **FLOATING
C690 pfet_01v8_lvt_W90p63_L0p74_m1__nf1_gboth_sdfull_pc/B.n914 VSUBS 0.002f ; **FLOATING
C691 pfet_01v8_lvt_W90p63_L0p74_m1__nf1_gboth_sdfull_pc/B.n915 VSUBS 0.002f ; **FLOATING
C692 pfet_01v8_lvt_W90p63_L0p74_m1__nf1_gboth_sdfull_pc/B.n916 VSUBS 0.002f ; **FLOATING
C693 pfet_01v8_lvt_W90p63_L0p74_m1__nf1_gboth_sdfull_pc/B.n917 VSUBS 0.002f ; **FLOATING
C694 pfet_01v8_lvt_W90p63_L0p74_m1__nf1_gboth_sdfull_pc/B.n918 VSUBS 0.002f ; **FLOATING
C695 pfet_01v8_lvt_W90p63_L0p74_m1__nf1_gboth_sdfull_pc/B.n919 VSUBS 0.002f ; **FLOATING
C696 pfet_01v8_lvt_W90p63_L0p74_m1__nf1_gboth_sdfull_pc/B.n920 VSUBS 0.002f ; **FLOATING
C697 pfet_01v8_lvt_W90p63_L0p74_m1__nf1_gboth_sdfull_pc/B.n921 VSUBS 0.002f ; **FLOATING
C698 pfet_01v8_lvt_W90p63_L0p74_m1__nf1_gboth_sdfull_pc/B.n922 VSUBS 0.002f ; **FLOATING
C699 pfet_01v8_lvt_W90p63_L0p74_m1__nf1_gboth_sdfull_pc/B.n923 VSUBS 0.002f ; **FLOATING
C700 pfet_01v8_lvt_W90p63_L0p74_m1__nf1_gboth_sdfull_pc/B.n924 VSUBS 0.002f ; **FLOATING
C701 pfet_01v8_lvt_W90p63_L0p74_m1__nf1_gboth_sdfull_pc/B.n925 VSUBS 0.002f ; **FLOATING
C702 pfet_01v8_lvt_W90p63_L0p74_m1__nf1_gboth_sdfull_pc/B.n926 VSUBS 0.002f ; **FLOATING
C703 pfet_01v8_lvt_W90p63_L0p74_m1__nf1_gboth_sdfull_pc/B.n927 VSUBS 0.002f ; **FLOATING
C704 pfet_01v8_lvt_W90p63_L0p74_m1__nf1_gboth_sdfull_pc/B.n928 VSUBS 0.002f ; **FLOATING
C705 pfet_01v8_lvt_W90p63_L0p74_m1__nf1_gboth_sdfull_pc/B.n929 VSUBS 0.002f ; **FLOATING
C706 pfet_01v8_lvt_W90p63_L0p74_m1__nf1_gboth_sdfull_pc/B.n930 VSUBS 0.002f ; **FLOATING
C707 pfet_01v8_lvt_W90p63_L0p74_m1__nf1_gboth_sdfull_pc/B.n931 VSUBS 0.002f ; **FLOATING
C708 pfet_01v8_lvt_W90p63_L0p74_m1__nf1_gboth_sdfull_pc/B.n932 VSUBS 0.002f ; **FLOATING
C709 pfet_01v8_lvt_W90p63_L0p74_m1__nf1_gboth_sdfull_pc/B.n933 VSUBS 0.002f ; **FLOATING
C710 pfet_01v8_lvt_W90p63_L0p74_m1__nf1_gboth_sdfull_pc/B.n934 VSUBS 0.002f ; **FLOATING
C711 pfet_01v8_lvt_W90p63_L0p74_m1__nf1_gboth_sdfull_pc/B.n935 VSUBS 0.002f ; **FLOATING
C712 pfet_01v8_lvt_W90p63_L0p74_m1__nf1_gboth_sdfull_pc/B.n936 VSUBS 0.002f ; **FLOATING
C713 pfet_01v8_lvt_W90p63_L0p74_m1__nf1_gboth_sdfull_pc/B.n937 VSUBS 0.002f ; **FLOATING
C714 pfet_01v8_lvt_W90p63_L0p74_m1__nf1_gboth_sdfull_pc/B.n938 VSUBS 0.002f ; **FLOATING
C715 pfet_01v8_lvt_W90p63_L0p74_m1__nf1_gboth_sdfull_pc/B.n939 VSUBS 0.002f ; **FLOATING
C716 pfet_01v8_lvt_W90p63_L0p74_m1__nf1_gboth_sdfull_pc/B.n940 VSUBS 0.002f ; **FLOATING
C717 pfet_01v8_lvt_W90p63_L0p74_m1__nf1_gboth_sdfull_pc/B.n941 VSUBS 0.002f ; **FLOATING
C718 pfet_01v8_lvt_W90p63_L0p74_m1__nf1_gboth_sdfull_pc/B.n942 VSUBS 0.002f ; **FLOATING
C719 pfet_01v8_lvt_W90p63_L0p74_m1__nf1_gboth_sdfull_pc/B.n943 VSUBS 0.002f ; **FLOATING
C720 pfet_01v8_lvt_W90p63_L0p74_m1__nf1_gboth_sdfull_pc/B.n944 VSUBS 0.002f ; **FLOATING
C721 pfet_01v8_lvt_W90p63_L0p74_m1__nf1_gboth_sdfull_pc/B.n945 VSUBS 0.002f ; **FLOATING
C722 pfet_01v8_lvt_W90p63_L0p74_m1__nf1_gboth_sdfull_pc/B.n946 VSUBS 0.002f ; **FLOATING
C723 pfet_01v8_lvt_W90p63_L0p74_m1__nf1_gboth_sdfull_pc/B.n947 VSUBS 0.002f ; **FLOATING
C724 pfet_01v8_lvt_W90p63_L0p74_m1__nf1_gboth_sdfull_pc/B.n948 VSUBS 0.002f ; **FLOATING
C725 pfet_01v8_lvt_W90p63_L0p74_m1__nf1_gboth_sdfull_pc/B.n949 VSUBS 0.002f ; **FLOATING
C726 pfet_01v8_lvt_W90p63_L0p74_m1__nf1_gboth_sdfull_pc/B.n950 VSUBS 0.002f ; **FLOATING
C727 pfet_01v8_lvt_W90p63_L0p74_m1__nf1_gboth_sdfull_pc/B.n951 VSUBS 0.002f ; **FLOATING
C728 pfet_01v8_lvt_W90p63_L0p74_m1__nf1_gboth_sdfull_pc/B.n952 VSUBS 0.002f ; **FLOATING
C729 pfet_01v8_lvt_W90p63_L0p74_m1__nf1_gboth_sdfull_pc/B.n953 VSUBS 0.002f ; **FLOATING
C730 pfet_01v8_lvt_W90p63_L0p74_m1__nf1_gboth_sdfull_pc/B.n954 VSUBS 0.002f ; **FLOATING
C731 pfet_01v8_lvt_W90p63_L0p74_m1__nf1_gboth_sdfull_pc/B.n955 VSUBS 0.002f ; **FLOATING
C732 pfet_01v8_lvt_W90p63_L0p74_m1__nf1_gboth_sdfull_pc/B.n956 VSUBS 0.002f ; **FLOATING
C733 pfet_01v8_lvt_W90p63_L0p74_m1__nf1_gboth_sdfull_pc/B.n957 VSUBS 0.002f ; **FLOATING
C734 pfet_01v8_lvt_W90p63_L0p74_m1__nf1_gboth_sdfull_pc/B.n958 VSUBS 0.002f ; **FLOATING
C735 pfet_01v8_lvt_W90p63_L0p74_m1__nf1_gboth_sdfull_pc/B.n959 VSUBS 0.002f ; **FLOATING
C736 pfet_01v8_lvt_W90p63_L0p74_m1__nf1_gboth_sdfull_pc/B.n960 VSUBS 0.002f ; **FLOATING
C737 pfet_01v8_lvt_W90p63_L0p74_m1__nf1_gboth_sdfull_pc/B.n961 VSUBS 0.002f ; **FLOATING
C738 pfet_01v8_lvt_W90p63_L0p74_m1__nf1_gboth_sdfull_pc/B.n962 VSUBS 0.002f ; **FLOATING
C739 pfet_01v8_lvt_W90p63_L0p74_m1__nf1_gboth_sdfull_pc/B.n963 VSUBS 0.002f ; **FLOATING
C740 pfet_01v8_lvt_W90p63_L0p74_m1__nf1_gboth_sdfull_pc/B.n964 VSUBS 0.002f ; **FLOATING
C741 pfet_01v8_lvt_W90p63_L0p74_m1__nf1_gboth_sdfull_pc/B.n965 VSUBS 0.002f ; **FLOATING
C742 pfet_01v8_lvt_W90p63_L0p74_m1__nf1_gboth_sdfull_pc/B.n966 VSUBS 0.002f ; **FLOATING
C743 pfet_01v8_lvt_W90p63_L0p74_m1__nf1_gboth_sdfull_pc/B.n967 VSUBS 0.002f ; **FLOATING
C744 pfet_01v8_lvt_W90p63_L0p74_m1__nf1_gboth_sdfull_pc/B.n968 VSUBS 0.002f ; **FLOATING
C745 pfet_01v8_lvt_W90p63_L0p74_m1__nf1_gboth_sdfull_pc/B.n969 VSUBS 0.002f ; **FLOATING
C746 pfet_01v8_lvt_W90p63_L0p74_m1__nf1_gboth_sdfull_pc/B.n970 VSUBS 0.002f ; **FLOATING
C747 pfet_01v8_lvt_W90p63_L0p74_m1__nf1_gboth_sdfull_pc/B.n971 VSUBS 0.002f ; **FLOATING
C748 pfet_01v8_lvt_W90p63_L0p74_m1__nf1_gboth_sdfull_pc/B.n972 VSUBS 0.002f ; **FLOATING
C749 pfet_01v8_lvt_W90p63_L0p74_m1__nf1_gboth_sdfull_pc/B.n973 VSUBS 0.002f ; **FLOATING
C750 pfet_01v8_lvt_W90p63_L0p74_m1__nf1_gboth_sdfull_pc/B.n974 VSUBS 0.002f ; **FLOATING
C751 pfet_01v8_lvt_W90p63_L0p74_m1__nf1_gboth_sdfull_pc/B.n975 VSUBS 0.002f ; **FLOATING
C752 pfet_01v8_lvt_W90p63_L0p74_m1__nf1_gboth_sdfull_pc/B.n976 VSUBS 0.002f ; **FLOATING
C753 pfet_01v8_lvt_W90p63_L0p74_m1__nf1_gboth_sdfull_pc/B.n977 VSUBS 0.002f ; **FLOATING
C754 pfet_01v8_lvt_W90p63_L0p74_m1__nf1_gboth_sdfull_pc/B.n978 VSUBS 0.002f ; **FLOATING
C755 pfet_01v8_lvt_W90p63_L0p74_m1__nf1_gboth_sdfull_pc/B.n979 VSUBS 0.002f ; **FLOATING
C756 pfet_01v8_lvt_W90p63_L0p74_m1__nf1_gboth_sdfull_pc/B.n980 VSUBS 0.002f ; **FLOATING
C757 pfet_01v8_lvt_W90p63_L0p74_m1__nf1_gboth_sdfull_pc/B.n981 VSUBS 0.002f ; **FLOATING
C758 pfet_01v8_lvt_W90p63_L0p74_m1__nf1_gboth_sdfull_pc/B.n982 VSUBS 0.002f ; **FLOATING
C759 pfet_01v8_lvt_W90p63_L0p74_m1__nf1_gboth_sdfull_pc/B.n983 VSUBS 0.002f ; **FLOATING
C760 pfet_01v8_lvt_W90p63_L0p74_m1__nf1_gboth_sdfull_pc/B.n984 VSUBS 0.002f ; **FLOATING
C761 pfet_01v8_lvt_W90p63_L0p74_m1__nf1_gboth_sdfull_pc/B.n985 VSUBS 0.002f ; **FLOATING
C762 pfet_01v8_lvt_W90p63_L0p74_m1__nf1_gboth_sdfull_pc/B.n986 VSUBS 0.002f ; **FLOATING
C763 pfet_01v8_lvt_W90p63_L0p74_m1__nf1_gboth_sdfull_pc/B.n987 VSUBS 0.002f ; **FLOATING
C764 pfet_01v8_lvt_W90p63_L0p74_m1__nf1_gboth_sdfull_pc/B.n988 VSUBS 0.002f ; **FLOATING
C765 pfet_01v8_lvt_W90p63_L0p74_m1__nf1_gboth_sdfull_pc/B.n989 VSUBS 0.002f ; **FLOATING
C766 pfet_01v8_lvt_W90p63_L0p74_m1__nf1_gboth_sdfull_pc/B.n990 VSUBS 0.002f ; **FLOATING
C767 pfet_01v8_lvt_W90p63_L0p74_m1__nf1_gboth_sdfull_pc/B.n991 VSUBS 0.002f ; **FLOATING
C768 pfet_01v8_lvt_W90p63_L0p74_m1__nf1_gboth_sdfull_pc/B.n992 VSUBS 0.002f ; **FLOATING
C769 pfet_01v8_lvt_W90p63_L0p74_m1__nf1_gboth_sdfull_pc/B.n993 VSUBS 0.002f ; **FLOATING
C770 pfet_01v8_lvt_W90p63_L0p74_m1__nf1_gboth_sdfull_pc/B.n994 VSUBS 0.002f ; **FLOATING
C771 pfet_01v8_lvt_W90p63_L0p74_m1__nf1_gboth_sdfull_pc/B.n995 VSUBS 0.002f ; **FLOATING
C772 pfet_01v8_lvt_W90p63_L0p74_m1__nf1_gboth_sdfull_pc/B.n996 VSUBS 0.002f ; **FLOATING
C773 pfet_01v8_lvt_W90p63_L0p74_m1__nf1_gboth_sdfull_pc/B.n997 VSUBS 0.002f ; **FLOATING
C774 pfet_01v8_lvt_W90p63_L0p74_m1__nf1_gboth_sdfull_pc/B.n998 VSUBS 0.002f ; **FLOATING
C775 pfet_01v8_lvt_W90p63_L0p74_m1__nf1_gboth_sdfull_pc/B.n999 VSUBS 0.002f ; **FLOATING
C776 pfet_01v8_lvt_W90p63_L0p74_m1__nf1_gboth_sdfull_pc/B.n1000 VSUBS 0.002f ; **FLOATING
C777 pfet_01v8_lvt_W90p63_L0p74_m1__nf1_gboth_sdfull_pc/B.n1001 VSUBS 0.002f ; **FLOATING
C778 pfet_01v8_lvt_W90p63_L0p74_m1__nf1_gboth_sdfull_pc/B.n1002 VSUBS 0.002f ; **FLOATING
C779 pfet_01v8_lvt_W90p63_L0p74_m1__nf1_gboth_sdfull_pc/B.n1003 VSUBS 0.002f ; **FLOATING
C780 pfet_01v8_lvt_W90p63_L0p74_m1__nf1_gboth_sdfull_pc/B.n1004 VSUBS 0.002f ; **FLOATING
C781 pfet_01v8_lvt_W90p63_L0p74_m1__nf1_gboth_sdfull_pc/B.n1005 VSUBS 0.002f ; **FLOATING
C782 pfet_01v8_lvt_W90p63_L0p74_m1__nf1_gboth_sdfull_pc/B.n1006 VSUBS 0.002f ; **FLOATING
C783 pfet_01v8_lvt_W90p63_L0p74_m1__nf1_gboth_sdfull_pc/B.n1007 VSUBS 0.002f ; **FLOATING
C784 pfet_01v8_lvt_W90p63_L0p74_m1__nf1_gboth_sdfull_pc/B.n1008 VSUBS 0.002f ; **FLOATING
C785 pfet_01v8_lvt_W90p63_L0p74_m1__nf1_gboth_sdfull_pc/B.n1009 VSUBS 0.002f ; **FLOATING
C786 pfet_01v8_lvt_W90p63_L0p74_m1__nf1_gboth_sdfull_pc/B.n1010 VSUBS 0.002f ; **FLOATING
C787 pfet_01v8_lvt_W90p63_L0p74_m1__nf1_gboth_sdfull_pc/B.n1011 VSUBS 0.002f ; **FLOATING
C788 pfet_01v8_lvt_W90p63_L0p74_m1__nf1_gboth_sdfull_pc/B.n1012 VSUBS 0.002f ; **FLOATING
C789 pfet_01v8_lvt_W90p63_L0p74_m1__nf1_gboth_sdfull_pc/B.n1013 VSUBS 0.002f ; **FLOATING
C790 pfet_01v8_lvt_W90p63_L0p74_m1__nf1_gboth_sdfull_pc/B.n1014 VSUBS 0.002f ; **FLOATING
C791 pfet_01v8_lvt_W90p63_L0p74_m1__nf1_gboth_sdfull_pc/B.n1015 VSUBS 0.002f ; **FLOATING
C792 pfet_01v8_lvt_W90p63_L0p74_m1__nf1_gboth_sdfull_pc/B.n1016 VSUBS 0.002f ; **FLOATING
C793 pfet_01v8_lvt_W90p63_L0p74_m1__nf1_gboth_sdfull_pc/B.n1017 VSUBS 0.002f ; **FLOATING
C794 pfet_01v8_lvt_W90p63_L0p74_m1__nf1_gboth_sdfull_pc/B.n1018 VSUBS 0.002f ; **FLOATING
C795 pfet_01v8_lvt_W90p63_L0p74_m1__nf1_gboth_sdfull_pc/B.n1019 VSUBS 0.002f ; **FLOATING
C796 pfet_01v8_lvt_W90p63_L0p74_m1__nf1_gboth_sdfull_pc/B.n1020 VSUBS 0.002f ; **FLOATING
C797 pfet_01v8_lvt_W90p63_L0p74_m1__nf1_gboth_sdfull_pc/B.n1021 VSUBS 0.002f ; **FLOATING
C798 pfet_01v8_lvt_W90p63_L0p74_m1__nf1_gboth_sdfull_pc/B.n1022 VSUBS 0.002f ; **FLOATING
C799 pfet_01v8_lvt_W90p63_L0p74_m1__nf1_gboth_sdfull_pc/B.n1023 VSUBS 0.002f ; **FLOATING
C800 pfet_01v8_lvt_W90p63_L0p74_m1__nf1_gboth_sdfull_pc/B.n1024 VSUBS 0.002f ; **FLOATING
C801 pfet_01v8_lvt_W90p63_L0p74_m1__nf1_gboth_sdfull_pc/B.n1025 VSUBS 0.002f ; **FLOATING
C802 pfet_01v8_lvt_W90p63_L0p74_m1__nf1_gboth_sdfull_pc/B.n1026 VSUBS 0.002f ; **FLOATING
C803 pfet_01v8_lvt_W90p63_L0p74_m1__nf1_gboth_sdfull_pc/B.n1027 VSUBS 0.002f ; **FLOATING
C804 pfet_01v8_lvt_W90p63_L0p74_m1__nf1_gboth_sdfull_pc/B.n1028 VSUBS 0.002f ; **FLOATING
C805 pfet_01v8_lvt_W90p63_L0p74_m1__nf1_gboth_sdfull_pc/B.n1029 VSUBS 0.002f ; **FLOATING
C806 pfet_01v8_lvt_W90p63_L0p74_m1__nf1_gboth_sdfull_pc/B.n1030 VSUBS 0.002f ; **FLOATING
C807 pfet_01v8_lvt_W90p63_L0p74_m1__nf1_gboth_sdfull_pc/B.n1031 VSUBS 0.002f ; **FLOATING
C808 pfet_01v8_lvt_W90p63_L0p74_m1__nf1_gboth_sdfull_pc/B.n1032 VSUBS 0.002f ; **FLOATING
C809 pfet_01v8_lvt_W90p63_L0p74_m1__nf1_gboth_sdfull_pc/B.n1033 VSUBS 0.002f ; **FLOATING
C810 pfet_01v8_lvt_W90p63_L0p74_m1__nf1_gboth_sdfull_pc/B.n1034 VSUBS 0.002f ; **FLOATING
C811 pfet_01v8_lvt_W90p63_L0p74_m1__nf1_gboth_sdfull_pc/B.n1035 VSUBS 0.002f ; **FLOATING
C812 pfet_01v8_lvt_W90p63_L0p74_m1__nf1_gboth_sdfull_pc/B.n1036 VSUBS 0.002f ; **FLOATING
C813 pfet_01v8_lvt_W90p63_L0p74_m1__nf1_gboth_sdfull_pc/B.n1037 VSUBS 0.002f ; **FLOATING
C814 pfet_01v8_lvt_W90p63_L0p74_m1__nf1_gboth_sdfull_pc/B.n1038 VSUBS 0.002f ; **FLOATING
C815 pfet_01v8_lvt_W90p63_L0p74_m1__nf1_gboth_sdfull_pc/B.n1039 VSUBS 0.002f ; **FLOATING
C816 pfet_01v8_lvt_W90p63_L0p74_m1__nf1_gboth_sdfull_pc/B.n1040 VSUBS 0.002f ; **FLOATING
C817 pfet_01v8_lvt_W90p63_L0p74_m1__nf1_gboth_sdfull_pc/B.n1041 VSUBS 0.002f ; **FLOATING
C818 pfet_01v8_lvt_W90p63_L0p74_m1__nf1_gboth_sdfull_pc/B.n1042 VSUBS 0.002f ; **FLOATING
C819 pfet_01v8_lvt_W90p63_L0p74_m1__nf1_gboth_sdfull_pc/B.n1043 VSUBS 0.002f ; **FLOATING
C820 pfet_01v8_lvt_W90p63_L0p74_m1__nf1_gboth_sdfull_pc/B.n1044 VSUBS 0.002f ; **FLOATING
C821 pfet_01v8_lvt_W90p63_L0p74_m1__nf1_gboth_sdfull_pc/B.n1045 VSUBS 0.002f ; **FLOATING
C822 pfet_01v8_lvt_W90p63_L0p74_m1__nf1_gboth_sdfull_pc/B.n1046 VSUBS 0.002f ; **FLOATING
C823 pfet_01v8_lvt_W90p63_L0p74_m1__nf1_gboth_sdfull_pc/B.n1047 VSUBS 0.002f ; **FLOATING
C824 pfet_01v8_lvt_W90p63_L0p74_m1__nf1_gboth_sdfull_pc/B.n1048 VSUBS 0.002f ; **FLOATING
C825 pfet_01v8_lvt_W90p63_L0p74_m1__nf1_gboth_sdfull_pc/B.n1049 VSUBS 0.002f ; **FLOATING
C826 pfet_01v8_lvt_W90p63_L0p74_m1__nf1_gboth_sdfull_pc/B.n1050 VSUBS 0.002f ; **FLOATING
C827 pfet_01v8_lvt_W90p63_L0p74_m1__nf1_gboth_sdfull_pc/B.n1051 VSUBS 0.002f ; **FLOATING
C828 pfet_01v8_lvt_W90p63_L0p74_m1__nf1_gboth_sdfull_pc/B.n1052 VSUBS 0.002f ; **FLOATING
C829 pfet_01v8_lvt_W90p63_L0p74_m1__nf1_gboth_sdfull_pc/B.n1053 VSUBS 0.002f ; **FLOATING
C830 pfet_01v8_lvt_W90p63_L0p74_m1__nf1_gboth_sdfull_pc/B.n1054 VSUBS 0.002f ; **FLOATING
C831 pfet_01v8_lvt_W90p63_L0p74_m1__nf1_gboth_sdfull_pc/B.n1055 VSUBS 0.002f ; **FLOATING
C832 pfet_01v8_lvt_W90p63_L0p74_m1__nf1_gboth_sdfull_pc/B.n1056 VSUBS 0.002f ; **FLOATING
C833 pfet_01v8_lvt_W90p63_L0p74_m1__nf1_gboth_sdfull_pc/B.n1057 VSUBS 0.002f ; **FLOATING
C834 pfet_01v8_lvt_W90p63_L0p74_m1__nf1_gboth_sdfull_pc/B.n1058 VSUBS 0.002f ; **FLOATING
C835 pfet_01v8_lvt_W90p63_L0p74_m1__nf1_gboth_sdfull_pc/B.n1059 VSUBS 0.002f ; **FLOATING
C836 pfet_01v8_lvt_W90p63_L0p74_m1__nf1_gboth_sdfull_pc/B.n1060 VSUBS 0.002f ; **FLOATING
C837 pfet_01v8_lvt_W90p63_L0p74_m1__nf1_gboth_sdfull_pc/B.n1061 VSUBS 0.002f ; **FLOATING
C838 pfet_01v8_lvt_W90p63_L0p74_m1__nf1_gboth_sdfull_pc/B.n1062 VSUBS 0.002f ; **FLOATING
C839 pfet_01v8_lvt_W90p63_L0p74_m1__nf1_gboth_sdfull_pc/B.n1063 VSUBS 0.002f ; **FLOATING
C840 pfet_01v8_lvt_W90p63_L0p74_m1__nf1_gboth_sdfull_pc/B.n1064 VSUBS 0.002f ; **FLOATING
C841 pfet_01v8_lvt_W90p63_L0p74_m1__nf1_gboth_sdfull_pc/B.n1065 VSUBS 0.002f ; **FLOATING
C842 pfet_01v8_lvt_W90p63_L0p74_m1__nf1_gboth_sdfull_pc/B.n1066 VSUBS 0.002f ; **FLOATING
C843 pfet_01v8_lvt_W90p63_L0p74_m1__nf1_gboth_sdfull_pc/B.n1067 VSUBS 0.002f ; **FLOATING
C844 pfet_01v8_lvt_W90p63_L0p74_m1__nf1_gboth_sdfull_pc/B.n1068 VSUBS 0.002f ; **FLOATING
C845 pfet_01v8_lvt_W90p63_L0p74_m1__nf1_gboth_sdfull_pc/B.n1069 VSUBS 0.002f ; **FLOATING
C846 pfet_01v8_lvt_W90p63_L0p74_m1__nf1_gboth_sdfull_pc/B.n1070 VSUBS 0.002f ; **FLOATING
C847 pfet_01v8_lvt_W90p63_L0p74_m1__nf1_gboth_sdfull_pc/B.n1071 VSUBS 0.002f ; **FLOATING
C848 pfet_01v8_lvt_W90p63_L0p74_m1__nf1_gboth_sdfull_pc/B.n1072 VSUBS 0.002f ; **FLOATING
C849 pfet_01v8_lvt_W90p63_L0p74_m1__nf1_gboth_sdfull_pc/B.n1073 VSUBS 0.002f ; **FLOATING
C850 pfet_01v8_lvt_W90p63_L0p74_m1__nf1_gboth_sdfull_pc/B.n1074 VSUBS 0.002f ; **FLOATING
C851 pfet_01v8_lvt_W90p63_L0p74_m1__nf1_gboth_sdfull_pc/B.n1075 VSUBS 0.002f ; **FLOATING
C852 pfet_01v8_lvt_W90p63_L0p74_m1__nf1_gboth_sdfull_pc/B.n1076 VSUBS 0.002f ; **FLOATING
C853 pfet_01v8_lvt_W90p63_L0p74_m1__nf1_gboth_sdfull_pc/B.n1077 VSUBS 0.002f ; **FLOATING
C854 pfet_01v8_lvt_W90p63_L0p74_m1__nf1_gboth_sdfull_pc/B.n1078 VSUBS 0.002f ; **FLOATING
C855 pfet_01v8_lvt_W90p63_L0p74_m1__nf1_gboth_sdfull_pc/B.n1079 VSUBS 0.002f ; **FLOATING
C856 pfet_01v8_lvt_W90p63_L0p74_m1__nf1_gboth_sdfull_pc/B.n1080 VSUBS 0.002f ; **FLOATING
C857 pfet_01v8_lvt_W90p63_L0p74_m1__nf1_gboth_sdfull_pc/B.n1081 VSUBS 0.002f ; **FLOATING
C858 pfet_01v8_lvt_W90p63_L0p74_m1__nf1_gboth_sdfull_pc/B.n1082 VSUBS 0.002f ; **FLOATING
C859 pfet_01v8_lvt_W90p63_L0p74_m1__nf1_gboth_sdfull_pc/B.n1083 VSUBS 0.002f ; **FLOATING
C860 pfet_01v8_lvt_W90p63_L0p74_m1__nf1_gboth_sdfull_pc/B.n1084 VSUBS 0.002f ; **FLOATING
C861 pfet_01v8_lvt_W90p63_L0p74_m1__nf1_gboth_sdfull_pc/B.n1085 VSUBS 0.002f ; **FLOATING
C862 pfet_01v8_lvt_W90p63_L0p74_m1__nf1_gboth_sdfull_pc/B.n1086 VSUBS 0.002f ; **FLOATING
C863 pfet_01v8_lvt_W90p63_L0p74_m1__nf1_gboth_sdfull_pc/B.n1087 VSUBS 0.002f ; **FLOATING
C864 pfet_01v8_lvt_W90p63_L0p74_m1__nf1_gboth_sdfull_pc/B.n1088 VSUBS 0.002f ; **FLOATING
C865 pfet_01v8_lvt_W90p63_L0p74_m1__nf1_gboth_sdfull_pc/B.n1089 VSUBS 0.002f ; **FLOATING
C866 pfet_01v8_lvt_W90p63_L0p74_m1__nf1_gboth_sdfull_pc/B.n1090 VSUBS 0.002f ; **FLOATING
C867 pfet_01v8_lvt_W90p63_L0p74_m1__nf1_gboth_sdfull_pc/B.n1091 VSUBS 0.002f ; **FLOATING
C868 pfet_01v8_lvt_W90p63_L0p74_m1__nf1_gboth_sdfull_pc/B.n1092 VSUBS 0.002f ; **FLOATING
C869 pfet_01v8_lvt_W90p63_L0p74_m1__nf1_gboth_sdfull_pc/B.n1093 VSUBS 0.002f ; **FLOATING
C870 pfet_01v8_lvt_W90p63_L0p74_m1__nf1_gboth_sdfull_pc/B.n1094 VSUBS 0.002f ; **FLOATING
C871 pfet_01v8_lvt_W90p63_L0p74_m1__nf1_gboth_sdfull_pc/B.n1095 VSUBS 0.002f ; **FLOATING
C872 pfet_01v8_lvt_W90p63_L0p74_m1__nf1_gboth_sdfull_pc/B.n1096 VSUBS 0.002f ; **FLOATING
C873 pfet_01v8_lvt_W90p63_L0p74_m1__nf1_gboth_sdfull_pc/B.n1097 VSUBS 0.002f ; **FLOATING
C874 pfet_01v8_lvt_W90p63_L0p74_m1__nf1_gboth_sdfull_pc/B.n1098 VSUBS 0.002f ; **FLOATING
C875 pfet_01v8_lvt_W90p63_L0p74_m1__nf1_gboth_sdfull_pc/B.n1099 VSUBS 0.002f ; **FLOATING
C876 pfet_01v8_lvt_W90p63_L0p74_m1__nf1_gboth_sdfull_pc/B.n1100 VSUBS 0.002f ; **FLOATING
C877 pfet_01v8_lvt_W90p63_L0p74_m1__nf1_gboth_sdfull_pc/B.n1101 VSUBS 0.002f ; **FLOATING
C878 pfet_01v8_lvt_W90p63_L0p74_m1__nf1_gboth_sdfull_pc/B.n1102 VSUBS 0.002f ; **FLOATING
C879 pfet_01v8_lvt_W90p63_L0p74_m1__nf1_gboth_sdfull_pc/B.n1103 VSUBS 0.002f ; **FLOATING
C880 pfet_01v8_lvt_W90p63_L0p74_m1__nf1_gboth_sdfull_pc/B.n1104 VSUBS 0.002f ; **FLOATING
C881 pfet_01v8_lvt_W90p63_L0p74_m1__nf1_gboth_sdfull_pc/B.n1105 VSUBS 0.002f ; **FLOATING
C882 pfet_01v8_lvt_W90p63_L0p74_m1__nf1_gboth_sdfull_pc/B.n1106 VSUBS 0.002f ; **FLOATING
C883 pfet_01v8_lvt_W90p63_L0p74_m1__nf1_gboth_sdfull_pc/B.n1107 VSUBS 0.002f ; **FLOATING
C884 pfet_01v8_lvt_W90p63_L0p74_m1__nf1_gboth_sdfull_pc/B.n1108 VSUBS 0.002f ; **FLOATING
C885 pfet_01v8_lvt_W90p63_L0p74_m1__nf1_gboth_sdfull_pc/B.n1109 VSUBS 0.002f ; **FLOATING
C886 pfet_01v8_lvt_W90p63_L0p74_m1__nf1_gboth_sdfull_pc/B.n1110 VSUBS 0.002f ; **FLOATING
C887 pfet_01v8_lvt_W90p63_L0p74_m1__nf1_gboth_sdfull_pc/B.n1111 VSUBS 0.002f ; **FLOATING
C888 pfet_01v8_lvt_W90p63_L0p74_m1__nf1_gboth_sdfull_pc/B.n1112 VSUBS 0.002f ; **FLOATING
C889 pfet_01v8_lvt_W90p63_L0p74_m1__nf1_gboth_sdfull_pc/B.n1113 VSUBS 0.002f ; **FLOATING
C890 pfet_01v8_lvt_W90p63_L0p74_m1__nf1_gboth_sdfull_pc/B.n1114 VSUBS 0.002f ; **FLOATING
C891 pfet_01v8_lvt_W90p63_L0p74_m1__nf1_gboth_sdfull_pc/B.n1115 VSUBS 0.002f ; **FLOATING
C892 pfet_01v8_lvt_W90p63_L0p74_m1__nf1_gboth_sdfull_pc/B.n1116 VSUBS 0.002f ; **FLOATING
C893 pfet_01v8_lvt_W90p63_L0p74_m1__nf1_gboth_sdfull_pc/B.n1117 VSUBS 0.002f ; **FLOATING
C894 pfet_01v8_lvt_W90p63_L0p74_m1__nf1_gboth_sdfull_pc/B.n1118 VSUBS 0.002f ; **FLOATING
C895 pfet_01v8_lvt_W90p63_L0p74_m1__nf1_gboth_sdfull_pc/B.n1119 VSUBS 0.002f ; **FLOATING
C896 pfet_01v8_lvt_W90p63_L0p74_m1__nf1_gboth_sdfull_pc/B.n1120 VSUBS 0.002f ; **FLOATING
C897 pfet_01v8_lvt_W90p63_L0p74_m1__nf1_gboth_sdfull_pc/B.n1121 VSUBS 0.002f ; **FLOATING
C898 pfet_01v8_lvt_W90p63_L0p74_m1__nf1_gboth_sdfull_pc/B.n1122 VSUBS 0.002f ; **FLOATING
C899 pfet_01v8_lvt_W90p63_L0p74_m1__nf1_gboth_sdfull_pc/B.n1123 VSUBS 0.002f ; **FLOATING
C900 pfet_01v8_lvt_W90p63_L0p74_m1__nf1_gboth_sdfull_pc/B.n1124 VSUBS 0.002f ; **FLOATING
C901 pfet_01v8_lvt_W90p63_L0p74_m1__nf1_gboth_sdfull_pc/B.n1125 VSUBS 0.002f ; **FLOATING
C902 pfet_01v8_lvt_W90p63_L0p74_m1__nf1_gboth_sdfull_pc/B.n1126 VSUBS 0.002f ; **FLOATING
C903 pfet_01v8_lvt_W90p63_L0p74_m1__nf1_gboth_sdfull_pc/B.n1127 VSUBS 0.002f ; **FLOATING
C904 pfet_01v8_lvt_W90p63_L0p74_m1__nf1_gboth_sdfull_pc/B.n1128 VSUBS 0.002f ; **FLOATING
C905 pfet_01v8_lvt_W90p63_L0p74_m1__nf1_gboth_sdfull_pc/B.n1129 VSUBS 0.002f ; **FLOATING
C906 pfet_01v8_lvt_W90p63_L0p74_m1__nf1_gboth_sdfull_pc/B.n1130 VSUBS 0.002f ; **FLOATING
C907 pfet_01v8_lvt_W90p63_L0p74_m1__nf1_gboth_sdfull_pc/B.n1131 VSUBS 0.002f ; **FLOATING
C908 pfet_01v8_lvt_W90p63_L0p74_m1__nf1_gboth_sdfull_pc/B.n1132 VSUBS 0.002f ; **FLOATING
C909 pfet_01v8_lvt_W90p63_L0p74_m1__nf1_gboth_sdfull_pc/B.n1133 VSUBS 0.002f ; **FLOATING
C910 pfet_01v8_lvt_W90p63_L0p74_m1__nf1_gboth_sdfull_pc/B.n1134 VSUBS 0.002f ; **FLOATING
C911 pfet_01v8_lvt_W90p63_L0p74_m1__nf1_gboth_sdfull_pc/B.n1135 VSUBS 0.002f ; **FLOATING
C912 pfet_01v8_lvt_W90p63_L0p74_m1__nf1_gboth_sdfull_pc/B.n1136 VSUBS 0.002f ; **FLOATING
C913 pfet_01v8_lvt_W90p63_L0p74_m1__nf1_gboth_sdfull_pc/B.n1137 VSUBS 0.002f ; **FLOATING
C914 pfet_01v8_lvt_W90p63_L0p74_m1__nf1_gboth_sdfull_pc/B.n1138 VSUBS 0.002f ; **FLOATING
C915 pfet_01v8_lvt_W90p63_L0p74_m1__nf1_gboth_sdfull_pc/B.n1139 VSUBS 0.002f ; **FLOATING
C916 pfet_01v8_lvt_W90p63_L0p74_m1__nf1_gboth_sdfull_pc/B.n1140 VSUBS 0.002f ; **FLOATING
C917 pfet_01v8_lvt_W90p63_L0p74_m1__nf1_gboth_sdfull_pc/B.n1141 VSUBS 0.002f ; **FLOATING
C918 pfet_01v8_lvt_W90p63_L0p74_m1__nf1_gboth_sdfull_pc/B.n1142 VSUBS 0.002f ; **FLOATING
C919 pfet_01v8_lvt_W90p63_L0p74_m1__nf1_gboth_sdfull_pc/B.n1143 VSUBS 0.002f ; **FLOATING
C920 pfet_01v8_lvt_W90p63_L0p74_m1__nf1_gboth_sdfull_pc/B.n1144 VSUBS 0.002f ; **FLOATING
C921 pfet_01v8_lvt_W90p63_L0p74_m1__nf1_gboth_sdfull_pc/B.n1145 VSUBS 0.002f ; **FLOATING
C922 pfet_01v8_lvt_W90p63_L0p74_m1__nf1_gboth_sdfull_pc/B.n1146 VSUBS 0.002f ; **FLOATING
C923 pfet_01v8_lvt_W90p63_L0p74_m1__nf1_gboth_sdfull_pc/B.n1147 VSUBS 0.002f ; **FLOATING
C924 pfet_01v8_lvt_W90p63_L0p74_m1__nf1_gboth_sdfull_pc/B.n1148 VSUBS 0.002f ; **FLOATING
C925 pfet_01v8_lvt_W90p63_L0p74_m1__nf1_gboth_sdfull_pc/B.n1149 VSUBS 0.002f ; **FLOATING
C926 pfet_01v8_lvt_W90p63_L0p74_m1__nf1_gboth_sdfull_pc/B.n1150 VSUBS 0.002f ; **FLOATING
C927 pfet_01v8_lvt_W90p63_L0p74_m1__nf1_gboth_sdfull_pc/B.n1151 VSUBS 0.002f ; **FLOATING
C928 pfet_01v8_lvt_W90p63_L0p74_m1__nf1_gboth_sdfull_pc/B.n1152 VSUBS 0.002f ; **FLOATING
C929 pfet_01v8_lvt_W90p63_L0p74_m1__nf1_gboth_sdfull_pc/B.n1153 VSUBS 0.002f ; **FLOATING
C930 pfet_01v8_lvt_W90p63_L0p74_m1__nf1_gboth_sdfull_pc/B.n1154 VSUBS 0.002f ; **FLOATING
C931 pfet_01v8_lvt_W90p63_L0p74_m1__nf1_gboth_sdfull_pc/B.n1155 VSUBS 0.002f ; **FLOATING
C932 pfet_01v8_lvt_W90p63_L0p74_m1__nf1_gboth_sdfull_pc/B.n1156 VSUBS 0.002f ; **FLOATING
C933 pfet_01v8_lvt_W90p63_L0p74_m1__nf1_gboth_sdfull_pc/B.n1157 VSUBS 0.002f ; **FLOATING
C934 pfet_01v8_lvt_W90p63_L0p74_m1__nf1_gboth_sdfull_pc/B.n1158 VSUBS 0.002f ; **FLOATING
C935 pfet_01v8_lvt_W90p63_L0p74_m1__nf1_gboth_sdfull_pc/B.n1159 VSUBS 0.002f ; **FLOATING
C936 pfet_01v8_lvt_W90p63_L0p74_m1__nf1_gboth_sdfull_pc/B.n1160 VSUBS 0.002f ; **FLOATING
C937 pfet_01v8_lvt_W90p63_L0p74_m1__nf1_gboth_sdfull_pc/B.n1161 VSUBS 0.002f ; **FLOATING
C938 pfet_01v8_lvt_W90p63_L0p74_m1__nf1_gboth_sdfull_pc/B.n1162 VSUBS 0.002f ; **FLOATING
C939 pfet_01v8_lvt_W90p63_L0p74_m1__nf1_gboth_sdfull_pc/B.n1163 VSUBS 0.002f ; **FLOATING
C940 pfet_01v8_lvt_W90p63_L0p74_m1__nf1_gboth_sdfull_pc/B.n1164 VSUBS 0.002f ; **FLOATING
C941 pfet_01v8_lvt_W90p63_L0p74_m1__nf1_gboth_sdfull_pc/B.n1165 VSUBS 0.002f ; **FLOATING
C942 pfet_01v8_lvt_W90p63_L0p74_m1__nf1_gboth_sdfull_pc/B.n1166 VSUBS 0.002f ; **FLOATING
C943 pfet_01v8_lvt_W90p63_L0p74_m1__nf1_gboth_sdfull_pc/B.n1167 VSUBS 0.002f ; **FLOATING
C944 pfet_01v8_lvt_W90p63_L0p74_m1__nf1_gboth_sdfull_pc/B.n1168 VSUBS 0.002f ; **FLOATING
C945 pfet_01v8_lvt_W90p63_L0p74_m1__nf1_gboth_sdfull_pc/B.n1169 VSUBS 0.002f ; **FLOATING
C946 pfet_01v8_lvt_W90p63_L0p74_m1__nf1_gboth_sdfull_pc/B.n1170 VSUBS 0.002f ; **FLOATING
C947 pfet_01v8_lvt_W90p63_L0p74_m1__nf1_gboth_sdfull_pc/B.n1171 VSUBS 0.002f ; **FLOATING
C948 pfet_01v8_lvt_W90p63_L0p74_m1__nf1_gboth_sdfull_pc/B.n1172 VSUBS 0.002f ; **FLOATING
C949 pfet_01v8_lvt_W90p63_L0p74_m1__nf1_gboth_sdfull_pc/B.n1173 VSUBS 0.002f ; **FLOATING
C950 pfet_01v8_lvt_W90p63_L0p74_m1__nf1_gboth_sdfull_pc/B.n1174 VSUBS 0.002f ; **FLOATING
C951 pfet_01v8_lvt_W90p63_L0p74_m1__nf1_gboth_sdfull_pc/B.n1175 VSUBS 0.002f ; **FLOATING
C952 pfet_01v8_lvt_W90p63_L0p74_m1__nf1_gboth_sdfull_pc/B.n1176 VSUBS 0.002f ; **FLOATING
C953 pfet_01v8_lvt_W90p63_L0p74_m1__nf1_gboth_sdfull_pc/B.n1177 VSUBS 0.002f ; **FLOATING
C954 pfet_01v8_lvt_W90p63_L0p74_m1__nf1_gboth_sdfull_pc/B.n1178 VSUBS 0.002f ; **FLOATING
C955 pfet_01v8_lvt_W90p63_L0p74_m1__nf1_gboth_sdfull_pc/B.n1179 VSUBS 0.002f ; **FLOATING
C956 pfet_01v8_lvt_W90p63_L0p74_m1__nf1_gboth_sdfull_pc/B.n1180 VSUBS 0.002f ; **FLOATING
C957 pfet_01v8_lvt_W90p63_L0p74_m1__nf1_gboth_sdfull_pc/B.n1181 VSUBS 0.002f ; **FLOATING
C958 pfet_01v8_lvt_W90p63_L0p74_m1__nf1_gboth_sdfull_pc/B.n1182 VSUBS 0.002f ; **FLOATING
C959 pfet_01v8_lvt_W90p63_L0p74_m1__nf1_gboth_sdfull_pc/B.n1183 VSUBS 0.002f ; **FLOATING
C960 pfet_01v8_lvt_W90p63_L0p74_m1__nf1_gboth_sdfull_pc/B.n1184 VSUBS 0.002f ; **FLOATING
C961 pfet_01v8_lvt_W90p63_L0p74_m1__nf1_gboth_sdfull_pc/B.n1185 VSUBS 0.002f ; **FLOATING
C962 pfet_01v8_lvt_W90p63_L0p74_m1__nf1_gboth_sdfull_pc/B.n1186 VSUBS 0.002f ; **FLOATING
C963 pfet_01v8_lvt_W90p63_L0p74_m1__nf1_gboth_sdfull_pc/B.n1187 VSUBS 0.002f ; **FLOATING
C964 pfet_01v8_lvt_W90p63_L0p74_m1__nf1_gboth_sdfull_pc/B.n1188 VSUBS 0.002f ; **FLOATING
C965 pfet_01v8_lvt_W90p63_L0p74_m1__nf1_gboth_sdfull_pc/B.n1189 VSUBS 0.002f ; **FLOATING
C966 pfet_01v8_lvt_W90p63_L0p74_m1__nf1_gboth_sdfull_pc/B.n1190 VSUBS 0.002f ; **FLOATING
C967 pfet_01v8_lvt_W90p63_L0p74_m1__nf1_gboth_sdfull_pc/B.n1191 VSUBS 0.002f ; **FLOATING
C968 pfet_01v8_lvt_W90p63_L0p74_m1__nf1_gboth_sdfull_pc/B.n1192 VSUBS 0.002f ; **FLOATING
C969 pfet_01v8_lvt_W90p63_L0p74_m1__nf1_gboth_sdfull_pc/B.n1193 VSUBS 0.002f ; **FLOATING
C970 pfet_01v8_lvt_W90p63_L0p74_m1__nf1_gboth_sdfull_pc/B.n1194 VSUBS 0.002f ; **FLOATING
C971 pfet_01v8_lvt_W90p63_L0p74_m1__nf1_gboth_sdfull_pc/B.n1195 VSUBS 0.002f ; **FLOATING
C972 pfet_01v8_lvt_W90p63_L0p74_m1__nf1_gboth_sdfull_pc/B.n1196 VSUBS 0.002f ; **FLOATING
C973 pfet_01v8_lvt_W90p63_L0p74_m1__nf1_gboth_sdfull_pc/B.n1197 VSUBS 0.002f ; **FLOATING
C974 pfet_01v8_lvt_W90p63_L0p74_m1__nf1_gboth_sdfull_pc/B.n1198 VSUBS 0.002f ; **FLOATING
C975 pfet_01v8_lvt_W90p63_L0p74_m1__nf1_gboth_sdfull_pc/B.n1199 VSUBS 0.002f ; **FLOATING
C976 pfet_01v8_lvt_W90p63_L0p74_m1__nf1_gboth_sdfull_pc/B.n1200 VSUBS 0.002f ; **FLOATING
C977 pfet_01v8_lvt_W90p63_L0p74_m1__nf1_gboth_sdfull_pc/B.n1201 VSUBS 0.002f ; **FLOATING
C978 pfet_01v8_lvt_W90p63_L0p74_m1__nf1_gboth_sdfull_pc/B.n1202 VSUBS 0.002f ; **FLOATING
C979 pfet_01v8_lvt_W90p63_L0p74_m1__nf1_gboth_sdfull_pc/B.n1203 VSUBS 0.002f ; **FLOATING
C980 pfet_01v8_lvt_W90p63_L0p74_m1__nf1_gboth_sdfull_pc/B.n1204 VSUBS 0.002f ; **FLOATING
C981 pfet_01v8_lvt_W90p63_L0p74_m1__nf1_gboth_sdfull_pc/B.n1205 VSUBS 0.002f ; **FLOATING
C982 pfet_01v8_lvt_W90p63_L0p74_m1__nf1_gboth_sdfull_pc/B.n1206 VSUBS 0.002f ; **FLOATING
C983 pfet_01v8_lvt_W90p63_L0p74_m1__nf1_gboth_sdfull_pc/B.n1207 VSUBS 0.002f ; **FLOATING
C984 pfet_01v8_lvt_W90p63_L0p74_m1__nf1_gboth_sdfull_pc/B.n1208 VSUBS 0.002f ; **FLOATING
C985 pfet_01v8_lvt_W90p63_L0p74_m1__nf1_gboth_sdfull_pc/B.n1209 VSUBS 0.002f ; **FLOATING
C986 pfet_01v8_lvt_W90p63_L0p74_m1__nf1_gboth_sdfull_pc/B.n1210 VSUBS 0.002f ; **FLOATING
C987 pfet_01v8_lvt_W90p63_L0p74_m1__nf1_gboth_sdfull_pc/B.n1211 VSUBS 0.002f ; **FLOATING
C988 pfet_01v8_lvt_W90p63_L0p74_m1__nf1_gboth_sdfull_pc/B.n1212 VSUBS 0.002f ; **FLOATING
C989 pfet_01v8_lvt_W90p63_L0p74_m1__nf1_gboth_sdfull_pc/B.n1213 VSUBS 0.002f ; **FLOATING
C990 pfet_01v8_lvt_W90p63_L0p74_m1__nf1_gboth_sdfull_pc/B.n1214 VSUBS 0.002f ; **FLOATING
C991 pfet_01v8_lvt_W90p63_L0p74_m1__nf1_gboth_sdfull_pc/B.n1215 VSUBS 0.002f ; **FLOATING
C992 pfet_01v8_lvt_W90p63_L0p74_m1__nf1_gboth_sdfull_pc/B.n1216 VSUBS 0.002f ; **FLOATING
C993 pfet_01v8_lvt_W90p63_L0p74_m1__nf1_gboth_sdfull_pc/B.n1217 VSUBS 0.002f ; **FLOATING
C994 pfet_01v8_lvt_W90p63_L0p74_m1__nf1_gboth_sdfull_pc/B.n1218 VSUBS 0.002f ; **FLOATING
C995 pfet_01v8_lvt_W90p63_L0p74_m1__nf1_gboth_sdfull_pc/B.n1219 VSUBS 0.002f ; **FLOATING
C996 pfet_01v8_lvt_W90p63_L0p74_m1__nf1_gboth_sdfull_pc/B.n1220 VSUBS 0.002f ; **FLOATING
C997 pfet_01v8_lvt_W90p63_L0p74_m1__nf1_gboth_sdfull_pc/B.n1221 VSUBS 0.002f ; **FLOATING
C998 pfet_01v8_lvt_W90p63_L0p74_m1__nf1_gboth_sdfull_pc/B.n1222 VSUBS 0.002f ; **FLOATING
C999 pfet_01v8_lvt_W90p63_L0p74_m1__nf1_gboth_sdfull_pc/B.n1223 VSUBS 0.002f ; **FLOATING
C1000 pfet_01v8_lvt_W90p63_L0p74_m1__nf1_gboth_sdfull_pc/B.n1224 VSUBS 0.002f ; **FLOATING
C1001 pfet_01v8_lvt_W90p63_L0p74_m1__nf1_gboth_sdfull_pc/B.n1225 VSUBS 0.002f ; **FLOATING
C1002 pfet_01v8_lvt_W90p63_L0p74_m1__nf1_gboth_sdfull_pc/B.n1226 VSUBS 0.002f ; **FLOATING
C1003 pfet_01v8_lvt_W90p63_L0p74_m1__nf1_gboth_sdfull_pc/B.n1227 VSUBS 0.002f ; **FLOATING
C1004 pfet_01v8_lvt_W90p63_L0p74_m1__nf1_gboth_sdfull_pc/B.n1228 VSUBS 0.002f ; **FLOATING
C1005 pfet_01v8_lvt_W90p63_L0p74_m1__nf1_gboth_sdfull_pc/B.n1229 VSUBS 0.002f ; **FLOATING
C1006 pfet_01v8_lvt_W90p63_L0p74_m1__nf1_gboth_sdfull_pc/B.n1230 VSUBS 0.002f ; **FLOATING
C1007 pfet_01v8_lvt_W90p63_L0p74_m1__nf1_gboth_sdfull_pc/B.n1231 VSUBS 0.002f ; **FLOATING
C1008 pfet_01v8_lvt_W90p63_L0p74_m1__nf1_gboth_sdfull_pc/B.n1232 VSUBS 0.002f ; **FLOATING
C1009 pfet_01v8_lvt_W90p63_L0p74_m1__nf1_gboth_sdfull_pc/B.n1233 VSUBS 0.002f ; **FLOATING
C1010 pfet_01v8_lvt_W90p63_L0p74_m1__nf1_gboth_sdfull_pc/B.n1234 VSUBS 0.002f ; **FLOATING
C1011 pfet_01v8_lvt_W90p63_L0p74_m1__nf1_gboth_sdfull_pc/B.n1235 VSUBS 0.002f ; **FLOATING
C1012 pfet_01v8_lvt_W90p63_L0p74_m1__nf1_gboth_sdfull_pc/B.n1236 VSUBS 0.002f ; **FLOATING
C1013 pfet_01v8_lvt_W90p63_L0p74_m1__nf1_gboth_sdfull_pc/B.n1237 VSUBS 0.002f ; **FLOATING
C1014 pfet_01v8_lvt_W90p63_L0p74_m1__nf1_gboth_sdfull_pc/B.n1238 VSUBS 0.002f ; **FLOATING
C1015 pfet_01v8_lvt_W90p63_L0p74_m1__nf1_gboth_sdfull_pc/B.n1239 VSUBS 0.002f ; **FLOATING
C1016 pfet_01v8_lvt_W90p63_L0p74_m1__nf1_gboth_sdfull_pc/B.n1240 VSUBS 0.002f ; **FLOATING
C1017 pfet_01v8_lvt_W90p63_L0p74_m1__nf1_gboth_sdfull_pc/B.n1241 VSUBS 0.002f ; **FLOATING
C1018 pfet_01v8_lvt_W90p63_L0p74_m1__nf1_gboth_sdfull_pc/B.n1242 VSUBS 0.002f ; **FLOATING
C1019 pfet_01v8_lvt_W90p63_L0p74_m1__nf1_gboth_sdfull_pc/B.n1243 VSUBS 0.002f ; **FLOATING
C1020 pfet_01v8_lvt_W90p63_L0p74_m1__nf1_gboth_sdfull_pc/B.n1244 VSUBS 0.002f ; **FLOATING
C1021 pfet_01v8_lvt_W90p63_L0p74_m1__nf1_gboth_sdfull_pc/B.n1245 VSUBS 0.002f ; **FLOATING
C1022 pfet_01v8_lvt_W90p63_L0p74_m1__nf1_gboth_sdfull_pc/B.n1246 VSUBS 0.002f ; **FLOATING
C1023 pfet_01v8_lvt_W90p63_L0p74_m1__nf1_gboth_sdfull_pc/B.n1247 VSUBS 0.002f ; **FLOATING
C1024 pfet_01v8_lvt_W90p63_L0p74_m1__nf1_gboth_sdfull_pc/B.n1248 VSUBS 0.002f ; **FLOATING
C1025 pfet_01v8_lvt_W90p63_L0p74_m1__nf1_gboth_sdfull_pc/B.n1249 VSUBS 0.002f ; **FLOATING
C1026 pfet_01v8_lvt_W90p63_L0p74_m1__nf1_gboth_sdfull_pc/B.n1250 VSUBS 0.002f ; **FLOATING
C1027 pfet_01v8_lvt_W90p63_L0p74_m1__nf1_gboth_sdfull_pc/B.n1251 VSUBS 0.002f ; **FLOATING
C1028 pfet_01v8_lvt_W90p63_L0p74_m1__nf1_gboth_sdfull_pc/B.n1252 VSUBS 0.002f ; **FLOATING
C1029 pfet_01v8_lvt_W90p63_L0p74_m1__nf1_gboth_sdfull_pc/B.n1253 VSUBS 0.002f ; **FLOATING
C1030 pfet_01v8_lvt_W90p63_L0p74_m1__nf1_gboth_sdfull_pc/B.n1254 VSUBS 0.002f ; **FLOATING
C1031 pfet_01v8_lvt_W90p63_L0p74_m1__nf1_gboth_sdfull_pc/B.n1255 VSUBS 0.002f ; **FLOATING
C1032 pfet_01v8_lvt_W90p63_L0p74_m1__nf1_gboth_sdfull_pc/B.n1256 VSUBS 0.002f ; **FLOATING
C1033 pfet_01v8_lvt_W90p63_L0p74_m1__nf1_gboth_sdfull_pc/B.n1257 VSUBS 0.002f ; **FLOATING
C1034 pfet_01v8_lvt_W90p63_L0p74_m1__nf1_gboth_sdfull_pc/B.n1258 VSUBS 0.002f ; **FLOATING
C1035 pfet_01v8_lvt_W90p63_L0p74_m1__nf1_gboth_sdfull_pc/B.n1259 VSUBS 0.002f ; **FLOATING
C1036 pfet_01v8_lvt_W90p63_L0p74_m1__nf1_gboth_sdfull_pc/B.n1260 VSUBS 0.002f ; **FLOATING
C1037 pfet_01v8_lvt_W90p63_L0p74_m1__nf1_gboth_sdfull_pc/B.n1261 VSUBS 0.002f ; **FLOATING
C1038 pfet_01v8_lvt_W90p63_L0p74_m1__nf1_gboth_sdfull_pc/B.n1262 VSUBS 0.002f ; **FLOATING
C1039 pfet_01v8_lvt_W90p63_L0p74_m1__nf1_gboth_sdfull_pc/B.n1263 VSUBS 0.002f ; **FLOATING
C1040 pfet_01v8_lvt_W90p63_L0p74_m1__nf1_gboth_sdfull_pc/B.n1264 VSUBS 0.002f ; **FLOATING
C1041 pfet_01v8_lvt_W90p63_L0p74_m1__nf1_gboth_sdfull_pc/B.n1265 VSUBS 0.002f ; **FLOATING
C1042 pfet_01v8_lvt_W90p63_L0p74_m1__nf1_gboth_sdfull_pc/B.n1266 VSUBS 0.002f ; **FLOATING
C1043 pfet_01v8_lvt_W90p63_L0p74_m1__nf1_gboth_sdfull_pc/B.n1267 VSUBS 0.002f ; **FLOATING
C1044 pfet_01v8_lvt_W90p63_L0p74_m1__nf1_gboth_sdfull_pc/B.n1268 VSUBS 0.002f ; **FLOATING
C1045 pfet_01v8_lvt_W90p63_L0p74_m1__nf1_gboth_sdfull_pc/B.n1269 VSUBS 0.002f ; **FLOATING
C1046 pfet_01v8_lvt_W90p63_L0p74_m1__nf1_gboth_sdfull_pc/B.n1270 VSUBS 0.002f ; **FLOATING
C1047 pfet_01v8_lvt_W90p63_L0p74_m1__nf1_gboth_sdfull_pc/B.n1271 VSUBS 0.002f ; **FLOATING
C1048 pfet_01v8_lvt_W90p63_L0p74_m1__nf1_gboth_sdfull_pc/B.n1272 VSUBS 0.002f ; **FLOATING
C1049 pfet_01v8_lvt_W90p63_L0p74_m1__nf1_gboth_sdfull_pc/B.n1273 VSUBS 0.002f ; **FLOATING
C1050 pfet_01v8_lvt_W90p63_L0p74_m1__nf1_gboth_sdfull_pc/B.n1274 VSUBS 0.002f ; **FLOATING
C1051 pfet_01v8_lvt_W90p63_L0p74_m1__nf1_gboth_sdfull_pc/B.n1275 VSUBS 0.002f ; **FLOATING
C1052 pfet_01v8_lvt_W90p63_L0p74_m1__nf1_gboth_sdfull_pc/B.n1276 VSUBS 0.002f ; **FLOATING
C1053 pfet_01v8_lvt_W90p63_L0p74_m1__nf1_gboth_sdfull_pc/B.n1277 VSUBS 0.002f ; **FLOATING
C1054 pfet_01v8_lvt_W90p63_L0p74_m1__nf1_gboth_sdfull_pc/B.n1278 VSUBS 0.002f ; **FLOATING
C1055 pfet_01v8_lvt_W90p63_L0p74_m1__nf1_gboth_sdfull_pc/B.n1279 VSUBS 0.002f ; **FLOATING
C1056 pfet_01v8_lvt_W90p63_L0p74_m1__nf1_gboth_sdfull_pc/B.n1280 VSUBS 0.002f ; **FLOATING
C1057 pfet_01v8_lvt_W90p63_L0p74_m1__nf1_gboth_sdfull_pc/B.n1281 VSUBS 0.002f ; **FLOATING
C1058 pfet_01v8_lvt_W90p63_L0p74_m1__nf1_gboth_sdfull_pc/B.n1282 VSUBS 0.002f ; **FLOATING
C1059 pfet_01v8_lvt_W90p63_L0p74_m1__nf1_gboth_sdfull_pc/B.n1283 VSUBS 0.002f ; **FLOATING
C1060 pfet_01v8_lvt_W90p63_L0p74_m1__nf1_gboth_sdfull_pc/B.n1284 VSUBS 0.002f ; **FLOATING
C1061 pfet_01v8_lvt_W90p63_L0p74_m1__nf1_gboth_sdfull_pc/B.n1285 VSUBS 0.002f ; **FLOATING
C1062 pfet_01v8_lvt_W90p63_L0p74_m1__nf1_gboth_sdfull_pc/B.n1286 VSUBS 0.002f ; **FLOATING
C1063 pfet_01v8_lvt_W90p63_L0p74_m1__nf1_gboth_sdfull_pc/B.n1287 VSUBS 0.002f ; **FLOATING
C1064 pfet_01v8_lvt_W90p63_L0p74_m1__nf1_gboth_sdfull_pc/B.n1288 VSUBS 0.002f ; **FLOATING
C1065 pfet_01v8_lvt_W90p63_L0p74_m1__nf1_gboth_sdfull_pc/B.n1289 VSUBS 0.002f ; **FLOATING
C1066 pfet_01v8_lvt_W90p63_L0p74_m1__nf1_gboth_sdfull_pc/B.n1290 VSUBS 0.002f ; **FLOATING
C1067 pfet_01v8_lvt_W90p63_L0p74_m1__nf1_gboth_sdfull_pc/B.n1291 VSUBS 0.002f ; **FLOATING
C1068 pfet_01v8_lvt_W90p63_L0p74_m1__nf1_gboth_sdfull_pc/B.n1292 VSUBS 0.002f ; **FLOATING
C1069 pfet_01v8_lvt_W90p63_L0p74_m1__nf1_gboth_sdfull_pc/B.n1293 VSUBS 0.002f ; **FLOATING
C1070 pfet_01v8_lvt_W90p63_L0p74_m1__nf1_gboth_sdfull_pc/B.n1294 VSUBS 0.002f ; **FLOATING
C1071 pfet_01v8_lvt_W90p63_L0p74_m1__nf1_gboth_sdfull_pc/B.n1295 VSUBS 0.002f ; **FLOATING
C1072 pfet_01v8_lvt_W90p63_L0p74_m1__nf1_gboth_sdfull_pc/B.n1296 VSUBS 0.002f ; **FLOATING
C1073 pfet_01v8_lvt_W90p63_L0p74_m1__nf1_gboth_sdfull_pc/B.n1297 VSUBS 0.002f ; **FLOATING
C1074 pfet_01v8_lvt_W90p63_L0p74_m1__nf1_gboth_sdfull_pc/B.n1298 VSUBS 0.002f ; **FLOATING
C1075 pfet_01v8_lvt_W90p63_L0p74_m1__nf1_gboth_sdfull_pc/B.n1299 VSUBS 0.002f ; **FLOATING
C1076 pfet_01v8_lvt_W90p63_L0p74_m1__nf1_gboth_sdfull_pc/B.n1300 VSUBS 0.002f ; **FLOATING
C1077 pfet_01v8_lvt_W90p63_L0p74_m1__nf1_gboth_sdfull_pc/B.n1301 VSUBS 0.002f ; **FLOATING
C1078 pfet_01v8_lvt_W90p63_L0p74_m1__nf1_gboth_sdfull_pc/B.n1302 VSUBS 0.002f ; **FLOATING
C1079 pfet_01v8_lvt_W90p63_L0p74_m1__nf1_gboth_sdfull_pc/B.n1303 VSUBS 0.002f ; **FLOATING
C1080 pfet_01v8_lvt_W90p63_L0p74_m1__nf1_gboth_sdfull_pc/B.n1304 VSUBS 0.002f ; **FLOATING
C1081 pfet_01v8_lvt_W90p63_L0p74_m1__nf1_gboth_sdfull_pc/B.n1305 VSUBS 0.002f ; **FLOATING
C1082 pfet_01v8_lvt_W90p63_L0p74_m1__nf1_gboth_sdfull_pc/B.n1306 VSUBS 0.002f ; **FLOATING
C1083 pfet_01v8_lvt_W90p63_L0p74_m1__nf1_gboth_sdfull_pc/B.n1307 VSUBS 0.002f ; **FLOATING
C1084 pfet_01v8_lvt_W90p63_L0p74_m1__nf1_gboth_sdfull_pc/B.n1308 VSUBS 0.002f ; **FLOATING
C1085 pfet_01v8_lvt_W90p63_L0p74_m1__nf1_gboth_sdfull_pc/B.n1309 VSUBS 0.002f ; **FLOATING
C1086 pfet_01v8_lvt_W90p63_L0p74_m1__nf1_gboth_sdfull_pc/B.n1310 VSUBS 0.002f ; **FLOATING
C1087 pfet_01v8_lvt_W90p63_L0p74_m1__nf1_gboth_sdfull_pc/B.n1311 VSUBS 0.002f ; **FLOATING
C1088 pfet_01v8_lvt_W90p63_L0p74_m1__nf1_gboth_sdfull_pc/B.n1312 VSUBS 0.002f ; **FLOATING
C1089 pfet_01v8_lvt_W90p63_L0p74_m1__nf1_gboth_sdfull_pc/B.n1313 VSUBS 0.002f ; **FLOATING
C1090 pfet_01v8_lvt_W90p63_L0p74_m1__nf1_gboth_sdfull_pc/B.n1314 VSUBS 0.002f ; **FLOATING
C1091 pfet_01v8_lvt_W90p63_L0p74_m1__nf1_gboth_sdfull_pc/B.n1315 VSUBS 0.002f ; **FLOATING
C1092 pfet_01v8_lvt_W90p63_L0p74_m1__nf1_gboth_sdfull_pc/B.n1316 VSUBS 0.002f ; **FLOATING
C1093 pfet_01v8_lvt_W90p63_L0p74_m1__nf1_gboth_sdfull_pc/B.n1317 VSUBS 0.002f ; **FLOATING
C1094 pfet_01v8_lvt_W90p63_L0p74_m1__nf1_gboth_sdfull_pc/B.n1318 VSUBS 0.002f ; **FLOATING
C1095 pfet_01v8_lvt_W90p63_L0p74_m1__nf1_gboth_sdfull_pc/B.n1319 VSUBS 0.002f ; **FLOATING
C1096 pfet_01v8_lvt_W90p63_L0p74_m1__nf1_gboth_sdfull_pc/B.n1320 VSUBS 0.002f ; **FLOATING
C1097 pfet_01v8_lvt_W90p63_L0p74_m1__nf1_gboth_sdfull_pc/B.n1321 VSUBS 0.002f ; **FLOATING
C1098 pfet_01v8_lvt_W90p63_L0p74_m1__nf1_gboth_sdfull_pc/B.n1322 VSUBS 0.002f ; **FLOATING
C1099 pfet_01v8_lvt_W90p63_L0p74_m1__nf1_gboth_sdfull_pc/B.n1323 VSUBS 0.002f ; **FLOATING
C1100 pfet_01v8_lvt_W90p63_L0p74_m1__nf1_gboth_sdfull_pc/B.n1325 VSUBS 1.77244f ; **FLOATING
C1101 pfet_01v8_lvt_W90p63_L0p74_m1__nf1_gboth_sdfull_pc/B.n1327 VSUBS 0.00442f ; **FLOATING
C1102 pfet_01v8_lvt_W90p63_L0p74_m1__nf1_gboth_sdfull_pc/B.n1328 VSUBS 0.00442f ; **FLOATING
C1103 pfet_01v8_lvt_W90p63_L0p74_m1__nf1_gboth_sdfull_pc/B.n1329 VSUBS 0.00439f ; **FLOATING
C1104 pfet_01v8_lvt_W90p63_L0p74_m1__nf1_gboth_sdfull_pc/B.n1330 VSUBS 0.002f ; **FLOATING
C1105 pfet_01v8_lvt_W90p63_L0p74_m1__nf1_gboth_sdfull_pc/B.n1331 VSUBS 0.002f ; **FLOATING
C1106 pfet_01v8_lvt_W90p63_L0p74_m1__nf1_gboth_sdfull_pc/B.n1332 VSUBS 0.81805f ; **FLOATING
C1107 pfet_01v8_lvt_W90p63_L0p74_m1__nf1_gboth_sdfull_pc/B.n1333 VSUBS 0.002f ; **FLOATING
C1108 pfet_01v8_lvt_W90p63_L0p74_m1__nf1_gboth_sdfull_pc/B.n1334 VSUBS 0.00125f ; **FLOATING
C1109 pfet_01v8_lvt_W90p63_L0p74_m1__nf1_gboth_sdfull_pc/G.n0 VSUBS 0.0078f ; **FLOATING
C1110 pfet_01v8_lvt_W90p63_L0p74_m1__nf1_gboth_sdfull_pc/G.t0 VSUBS 6.47528f ; **FLOATING
C1111 pfet_01v8_lvt_W90p63_L0p74_m1__nf1_gboth_sdfull_pc/G.n1 VSUBS 2.17317f ; **FLOATING
C1112 pfet_01v8_lvt_W90p63_L0p74_m1__nf1_gboth_sdfull_pc/G.n2 VSUBS 0.0076f ; **FLOATING
