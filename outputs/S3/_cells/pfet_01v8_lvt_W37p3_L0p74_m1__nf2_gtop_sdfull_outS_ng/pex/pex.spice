* NGSPICE file created from pfet_01v8_lvt_W37p3_L0p74_m1__nf2_gtop_sdfull_outS_ng.ext - technology: sky130A

.subckt pfet_01v8_lvt_W37p3_L0p74_m1__nf2_gtop_sdfull_outS_ng S D G B
X0 S G D B sky130_fd_pr__pfet_01v8_lvt ad=5.4085 pd=37.88 as=2.70425 ps=18.94 w=18.65 l=0.74
X1 D G S B sky130_fd_pr__pfet_01v8_lvt ad=2.70425 pd=18.94 as=5.4085 ps=37.88 w=18.65 l=0.74
C0 D S 1.53062f
C1 G D 1.80849f
C2 G S 1.86283f
C3 D B 0.41549f
C4 S B 0.66671f
C5 G B 0.21718f
C6 D VSUBS 0.11069f
C7 S VSUBS 2.75661f
C8 G VSUBS 0.38287f
C9 B VSUBS 4.5528f
.ends
