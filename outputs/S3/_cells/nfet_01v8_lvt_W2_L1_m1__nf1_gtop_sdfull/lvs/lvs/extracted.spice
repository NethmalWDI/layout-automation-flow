* NGSPICE file created from nfet_01v8_lvt_W2_L1_m1__nf1_gtop_sdfull.ext - technology: sky130A

.subckt sky130_fd_pr__nfet_01v8_lvt_C3DN4S G D B S
X0 S G D B sky130_fd_pr__nfet_01v8_lvt ad=0.58 pd=4.58 as=0.58 ps=4.58 w=2 l=1
.ends

.subckt nfet_01v8_lvt_W2_L1_m1__nf1_gtop_sdfull D S G B
Xnfet_01v8_lvt_W2_L1_m1__nf1_gtop_sdfull_pc G D B S sky130_fd_pr__nfet_01v8_lvt_C3DN4S
.ends
