* NGSPICE file created from nfet_01v8_lvt_W484p2_L0p24_m1__nf8_gtop_sdhalf_outD_ng.ext - technology: sky130A

.subckt nfet_01v8_lvt_W484p2_L0p24_m1__nf8_gtop_sdhalf_outD_ng S D G B
X0 S G D B sky130_fd_pr__nfet_01v8_lvt ad=8.77685 pd=60.82 as=17.5537 ps=121.64 w=60.53 l=0.24
X1 S G D B sky130_fd_pr__nfet_01v8_lvt ad=8.77685 pd=60.82 as=8.77685 ps=60.82 w=60.53 l=0.24
X2 D G S B sky130_fd_pr__nfet_01v8_lvt ad=8.77685 pd=60.82 as=8.77685 ps=60.82 w=60.53 l=0.24
X3 S G D B sky130_fd_pr__nfet_01v8_lvt ad=8.77685 pd=60.82 as=8.77685 ps=60.82 w=60.53 l=0.24
X4 D G S B sky130_fd_pr__nfet_01v8_lvt ad=8.77685 pd=60.82 as=8.77685 ps=60.82 w=60.53 l=0.24
X5 D G S B sky130_fd_pr__nfet_01v8_lvt ad=17.5537 pd=121.64 as=8.77685 ps=60.82 w=60.53 l=0.24
X6 D G S B sky130_fd_pr__nfet_01v8_lvt ad=8.77685 pd=60.82 as=8.77685 ps=60.82 w=60.53 l=0.24
X7 S G D B sky130_fd_pr__nfet_01v8_lvt ad=8.77685 pd=60.82 as=8.77685 ps=60.82 w=60.53 l=0.24
C0 S G 4.96938f
C1 D G 4.96938f
C2 S D 17.87501f
C3 S B 0.05494f
C4 D B 4.8358f
C5 G B 1.21477f
.ends
