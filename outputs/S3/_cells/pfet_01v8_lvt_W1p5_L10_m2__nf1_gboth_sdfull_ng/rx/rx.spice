* NGSPICE file created from pfet_01v8_lvt_W1p5_L10_m2__nf1_gboth_sdfull_ng.ext - technology: sky130A

X0 S G D pfet_01v8_lvt_W1p5_L10_m2__nf1_gboth_sdfull_ng_pc/w_n1094_n250.t0 sky130_fd_pr__pfet_01v8_lvt ad=0.435 pd=3.58 as=0.435 ps=3.58 w=1.5 l=10
C0 G B 1.53009f
C1 S G 0.13364f
C2 D G 0.13364f
C3 S B 0.04359f
C4 D B 0.04359f
R0 B pfet_01v8_lvt_W1p5_L10_m2__nf1_gboth_sdfull_ng_pc/w_n1094_n250.t0 2059.6
C5 S VSUBS 0.15326f
C6 D VSUBS 0.15326f
C7 G VSUBS 2.67081f
C8 B VSUBS 3.69001f
C9 pfet_01v8_lvt_W1p5_L10_m2__nf1_gboth_sdfull_ng_pc/w_n1094_n250.t0 VSUBS 1.20925f ; **FLOATING
