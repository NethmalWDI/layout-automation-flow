* NGSPICE file created from nfet_01v8_lvt_W1p2_L0p2_m2__nf1_gboth_sdfull.ext - technology: sky130A

.subckt sky130_fd_pr__nfet_01v8_lvt_AR5CFQ G D B S
X0 S G D B sky130_fd_pr__nfet_01v8_lvt ad=0.348 pd=2.98 as=0.348 ps=2.98 w=1.2 l=0.2
.ends

.subckt nfet_01v8_lvt_W1p2_L0p2_m2__nf1_gboth_sdfull D S G B
Xnfet_01v8_lvt_W1p2_L0p2_m2__nf1_gboth_sdfull_pc G D B S sky130_fd_pr__nfet_01v8_lvt_AR5CFQ
.ends
