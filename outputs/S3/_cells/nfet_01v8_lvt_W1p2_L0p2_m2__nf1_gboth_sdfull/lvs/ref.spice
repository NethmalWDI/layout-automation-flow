.subckt nfet_01v8_lvt_W1p2_L0p2_m2__nf1_gboth_sdfull D G S B
Xnfet_01v8_lvt_W1p2_L0p2_m2__nf1_gboth_sdfull D G S B sky130_fd_pr__nfet_01v8_lvt L=0.2 W=1.2 nf=1
.ends
