* NGSPICE file created from nfet_01v8_lvt_W1p2_L0p2_m2__nf1_gboth_sdfull.ext - technology: sky130A

X0 S G D nfet_01v8_lvt_W1p2_L0p2_m2__nf1_gboth_sdfull_pc/B.t0 sky130_fd_pr__nfet_01v8_lvt ad=0.348 pd=2.98 as=0.348 ps=2.98 w=1.2 l=0.2
C0 S G 0.0287f
C1 G D 0.0287f
C2 S D 0.09394f
R0 nfet_01v8_lvt_W1p2_L0p2_m2__nf1_gboth_sdfull_pc/B.n39 nfet_01v8_lvt_W1p2_L0p2_m2__nf1_gboth_sdfull_pc/B.n3 1268.91
R1 nfet_01v8_lvt_W1p2_L0p2_m2__nf1_gboth_sdfull_pc/B.n13 nfet_01v8_lvt_W1p2_L0p2_m2__nf1_gboth_sdfull_pc/B.n2 1268.91
R2 nfet_01v8_lvt_W1p2_L0p2_m2__nf1_gboth_sdfull_pc/B.n37 nfet_01v8_lvt_W1p2_L0p2_m2__nf1_gboth_sdfull_pc/B.n6 1268.91
R3 nfet_01v8_lvt_W1p2_L0p2_m2__nf1_gboth_sdfull_pc/B.n22 nfet_01v8_lvt_W1p2_L0p2_m2__nf1_gboth_sdfull_pc/B.n5 1268.91
R4 nfet_01v8_lvt_W1p2_L0p2_m2__nf1_gboth_sdfull_pc/B.n38 nfet_01v8_lvt_W1p2_L0p2_m2__nf1_gboth_sdfull_pc/B.n4 886.875
R5 nfet_01v8_lvt_W1p2_L0p2_m2__nf1_gboth_sdfull_pc/B.n9 nfet_01v8_lvt_W1p2_L0p2_m2__nf1_gboth_sdfull_pc/B.n8 886.875
R6 nfet_01v8_lvt_W1p2_L0p2_m2__nf1_gboth_sdfull_pc/B.n38 nfet_01v8_lvt_W1p2_L0p2_m2__nf1_gboth_sdfull_pc/B.n37 585
R7 nfet_01v8_lvt_W1p2_L0p2_m2__nf1_gboth_sdfull_pc/B.n37 nfet_01v8_lvt_W1p2_L0p2_m2__nf1_gboth_sdfull_pc/B.n36 585
R8 nfet_01v8_lvt_W1p2_L0p2_m2__nf1_gboth_sdfull_pc/B.n8 nfet_01v8_lvt_W1p2_L0p2_m2__nf1_gboth_sdfull_pc/B.n5 585
R9 nfet_01v8_lvt_W1p2_L0p2_m2__nf1_gboth_sdfull_pc/B.n24 nfet_01v8_lvt_W1p2_L0p2_m2__nf1_gboth_sdfull_pc/B.n5 585
R10 nfet_01v8_lvt_W1p2_L0p2_m2__nf1_gboth_sdfull_pc/B.n23 nfet_01v8_lvt_W1p2_L0p2_m2__nf1_gboth_sdfull_pc/B.n22 585
R11 nfet_01v8_lvt_W1p2_L0p2_m2__nf1_gboth_sdfull_pc/B.n20 nfet_01v8_lvt_W1p2_L0p2_m2__nf1_gboth_sdfull_pc/B.n7 585
R12 nfet_01v8_lvt_W1p2_L0p2_m2__nf1_gboth_sdfull_pc/B.n19 nfet_01v8_lvt_W1p2_L0p2_m2__nf1_gboth_sdfull_pc/B.n10 585
R13 nfet_01v8_lvt_W1p2_L0p2_m2__nf1_gboth_sdfull_pc/B.n17 nfet_01v8_lvt_W1p2_L0p2_m2__nf1_gboth_sdfull_pc/B.n16 585
R14 nfet_01v8_lvt_W1p2_L0p2_m2__nf1_gboth_sdfull_pc/B.n15 nfet_01v8_lvt_W1p2_L0p2_m2__nf1_gboth_sdfull_pc/B.n11 585
R15 nfet_01v8_lvt_W1p2_L0p2_m2__nf1_gboth_sdfull_pc/B.n14 nfet_01v8_lvt_W1p2_L0p2_m2__nf1_gboth_sdfull_pc/B.n13 585
R16 nfet_01v8_lvt_W1p2_L0p2_m2__nf1_gboth_sdfull_pc/B.n8 nfet_01v8_lvt_W1p2_L0p2_m2__nf1_gboth_sdfull_pc/B.n2 585
R17 nfet_01v8_lvt_W1p2_L0p2_m2__nf1_gboth_sdfull_pc/B.n2 nfet_01v8_lvt_W1p2_L0p2_m2__nf1_gboth_sdfull_pc/B.n0 585
R18 nfet_01v8_lvt_W1p2_L0p2_m2__nf1_gboth_sdfull_pc/B.n39 nfet_01v8_lvt_W1p2_L0p2_m2__nf1_gboth_sdfull_pc/B.n38 585
R19 nfet_01v8_lvt_W1p2_L0p2_m2__nf1_gboth_sdfull_pc/B.n40 nfet_01v8_lvt_W1p2_L0p2_m2__nf1_gboth_sdfull_pc/B.n39 585
R20 nfet_01v8_lvt_W1p2_L0p2_m2__nf1_gboth_sdfull_pc/B.n4 nfet_01v8_lvt_W1p2_L0p2_m2__nf1_gboth_sdfull_pc/B.n3 585
R21 nfet_01v8_lvt_W1p2_L0p2_m2__nf1_gboth_sdfull_pc/B.n3 nfet_01v8_lvt_W1p2_L0p2_m2__nf1_gboth_sdfull_pc/B.n1 585
R22 nfet_01v8_lvt_W1p2_L0p2_m2__nf1_gboth_sdfull_pc/B.n28 nfet_01v8_lvt_W1p2_L0p2_m2__nf1_gboth_sdfull_pc/B.n27 585
R23 nfet_01v8_lvt_W1p2_L0p2_m2__nf1_gboth_sdfull_pc/B.n30 nfet_01v8_lvt_W1p2_L0p2_m2__nf1_gboth_sdfull_pc/B.n29 585
R24 nfet_01v8_lvt_W1p2_L0p2_m2__nf1_gboth_sdfull_pc/B.n31 nfet_01v8_lvt_W1p2_L0p2_m2__nf1_gboth_sdfull_pc/B.n4 585
R25 nfet_01v8_lvt_W1p2_L0p2_m2__nf1_gboth_sdfull_pc/B.n31 nfet_01v8_lvt_W1p2_L0p2_m2__nf1_gboth_sdfull_pc/B.n25 585
R26 nfet_01v8_lvt_W1p2_L0p2_m2__nf1_gboth_sdfull_pc/B.n34 nfet_01v8_lvt_W1p2_L0p2_m2__nf1_gboth_sdfull_pc/B.n33 585
R27 nfet_01v8_lvt_W1p2_L0p2_m2__nf1_gboth_sdfull_pc/B.n35 nfet_01v8_lvt_W1p2_L0p2_m2__nf1_gboth_sdfull_pc/B.n6 585
R28 nfet_01v8_lvt_W1p2_L0p2_m2__nf1_gboth_sdfull_pc/B.n27 nfet_01v8_lvt_W1p2_L0p2_m2__nf1_gboth_sdfull_pc/B.n3 394
R29 nfet_01v8_lvt_W1p2_L0p2_m2__nf1_gboth_sdfull_pc/B.n31 nfet_01v8_lvt_W1p2_L0p2_m2__nf1_gboth_sdfull_pc/B.n30 394
R30 nfet_01v8_lvt_W1p2_L0p2_m2__nf1_gboth_sdfull_pc/B.n33 nfet_01v8_lvt_W1p2_L0p2_m2__nf1_gboth_sdfull_pc/B.n31 394
R31 nfet_01v8_lvt_W1p2_L0p2_m2__nf1_gboth_sdfull_pc/B.n39 nfet_01v8_lvt_W1p2_L0p2_m2__nf1_gboth_sdfull_pc/B.n2 394
R32 nfet_01v8_lvt_W1p2_L0p2_m2__nf1_gboth_sdfull_pc/B.n17 nfet_01v8_lvt_W1p2_L0p2_m2__nf1_gboth_sdfull_pc/B.n11 394
R33 nfet_01v8_lvt_W1p2_L0p2_m2__nf1_gboth_sdfull_pc/B.n20 nfet_01v8_lvt_W1p2_L0p2_m2__nf1_gboth_sdfull_pc/B.n19 394
R34 nfet_01v8_lvt_W1p2_L0p2_m2__nf1_gboth_sdfull_pc/B.n37 nfet_01v8_lvt_W1p2_L0p2_m2__nf1_gboth_sdfull_pc/B.n5 394
R35 nfet_01v8_lvt_W1p2_L0p2_m2__nf1_gboth_sdfull_pc/B.n4 B 295.625
R36 nfet_01v8_lvt_W1p2_L0p2_m2__nf1_gboth_sdfull_pc/B.n38 nfet_01v8_lvt_W1p2_L0p2_m2__nf1_gboth_sdfull_pc/B.t0 233.75
R37 nfet_01v8_lvt_W1p2_L0p2_m2__nf1_gboth_sdfull_pc/B.n8 nfet_01v8_lvt_W1p2_L0p2_m2__nf1_gboth_sdfull_pc/B.t0 233.75
R38 nfet_01v8_lvt_W1p2_L0p2_m2__nf1_gboth_sdfull_pc/B.n21 nfet_01v8_lvt_W1p2_L0p2_m2__nf1_gboth_sdfull_pc/B.n9 218.815
R39 nfet_01v8_lvt_W1p2_L0p2_m2__nf1_gboth_sdfull_pc/B.n18 nfet_01v8_lvt_W1p2_L0p2_m2__nf1_gboth_sdfull_pc/B.n9 218.815
R40 nfet_01v8_lvt_W1p2_L0p2_m2__nf1_gboth_sdfull_pc/B.n12 nfet_01v8_lvt_W1p2_L0p2_m2__nf1_gboth_sdfull_pc/B.n9 218.815
R41 nfet_01v8_lvt_W1p2_L0p2_m2__nf1_gboth_sdfull_pc/B.n26 nfet_01v8_lvt_W1p2_L0p2_m2__nf1_gboth_sdfull_pc/B.n4 218.815
R42 nfet_01v8_lvt_W1p2_L0p2_m2__nf1_gboth_sdfull_pc/B.n32 nfet_01v8_lvt_W1p2_L0p2_m2__nf1_gboth_sdfull_pc/B.n4 218.815
R43 nfet_01v8_lvt_W1p2_L0p2_m2__nf1_gboth_sdfull_pc/B.n22 nfet_01v8_lvt_W1p2_L0p2_m2__nf1_gboth_sdfull_pc/B.n21 147.374
R44 nfet_01v8_lvt_W1p2_L0p2_m2__nf1_gboth_sdfull_pc/B.n19 nfet_01v8_lvt_W1p2_L0p2_m2__nf1_gboth_sdfull_pc/B.n18 147.374
R45 nfet_01v8_lvt_W1p2_L0p2_m2__nf1_gboth_sdfull_pc/B.n12 nfet_01v8_lvt_W1p2_L0p2_m2__nf1_gboth_sdfull_pc/B.n11 147.374
R46 nfet_01v8_lvt_W1p2_L0p2_m2__nf1_gboth_sdfull_pc/B.n27 nfet_01v8_lvt_W1p2_L0p2_m2__nf1_gboth_sdfull_pc/B.n26 147.374
R47 nfet_01v8_lvt_W1p2_L0p2_m2__nf1_gboth_sdfull_pc/B.n33 nfet_01v8_lvt_W1p2_L0p2_m2__nf1_gboth_sdfull_pc/B.n32 147.374
R48 nfet_01v8_lvt_W1p2_L0p2_m2__nf1_gboth_sdfull_pc/B.n30 nfet_01v8_lvt_W1p2_L0p2_m2__nf1_gboth_sdfull_pc/B.n26 147.374
R49 nfet_01v8_lvt_W1p2_L0p2_m2__nf1_gboth_sdfull_pc/B.n32 nfet_01v8_lvt_W1p2_L0p2_m2__nf1_gboth_sdfull_pc/B.n6 147.374
R50 nfet_01v8_lvt_W1p2_L0p2_m2__nf1_gboth_sdfull_pc/B.n13 nfet_01v8_lvt_W1p2_L0p2_m2__nf1_gboth_sdfull_pc/B.n12 147.374
R51 nfet_01v8_lvt_W1p2_L0p2_m2__nf1_gboth_sdfull_pc/B.n18 nfet_01v8_lvt_W1p2_L0p2_m2__nf1_gboth_sdfull_pc/B.n17 147.374
R52 nfet_01v8_lvt_W1p2_L0p2_m2__nf1_gboth_sdfull_pc/B.n21 nfet_01v8_lvt_W1p2_L0p2_m2__nf1_gboth_sdfull_pc/B.n20 147.374
R53 nfet_01v8_lvt_W1p2_L0p2_m2__nf1_gboth_sdfull_pc/B.n40 nfet_01v8_lvt_W1p2_L0p2_m2__nf1_gboth_sdfull_pc/B.n1 82.4476
R54 nfet_01v8_lvt_W1p2_L0p2_m2__nf1_gboth_sdfull_pc/B.n14 nfet_01v8_lvt_W1p2_L0p2_m2__nf1_gboth_sdfull_pc/B.n0 82.4476
R55 nfet_01v8_lvt_W1p2_L0p2_m2__nf1_gboth_sdfull_pc/B.n36 nfet_01v8_lvt_W1p2_L0p2_m2__nf1_gboth_sdfull_pc/B.n35 82.4476
R56 nfet_01v8_lvt_W1p2_L0p2_m2__nf1_gboth_sdfull_pc/B.n24 nfet_01v8_lvt_W1p2_L0p2_m2__nf1_gboth_sdfull_pc/B.n23 82.4476
R57 nfet_01v8_lvt_W1p2_L0p2_m2__nf1_gboth_sdfull_pc/B.n28 nfet_01v8_lvt_W1p2_L0p2_m2__nf1_gboth_sdfull_pc/B.n1 25.6005
R58 nfet_01v8_lvt_W1p2_L0p2_m2__nf1_gboth_sdfull_pc/B.n29 nfet_01v8_lvt_W1p2_L0p2_m2__nf1_gboth_sdfull_pc/B.n28 25.6005
R59 nfet_01v8_lvt_W1p2_L0p2_m2__nf1_gboth_sdfull_pc/B.n29 nfet_01v8_lvt_W1p2_L0p2_m2__nf1_gboth_sdfull_pc/B.n25 25.6005
R60 nfet_01v8_lvt_W1p2_L0p2_m2__nf1_gboth_sdfull_pc/B.n34 nfet_01v8_lvt_W1p2_L0p2_m2__nf1_gboth_sdfull_pc/B.n25 25.6005
R61 nfet_01v8_lvt_W1p2_L0p2_m2__nf1_gboth_sdfull_pc/B.n35 nfet_01v8_lvt_W1p2_L0p2_m2__nf1_gboth_sdfull_pc/B.n34 25.6005
R62 nfet_01v8_lvt_W1p2_L0p2_m2__nf1_gboth_sdfull_pc/B.n15 nfet_01v8_lvt_W1p2_L0p2_m2__nf1_gboth_sdfull_pc/B.n14 25.6005
R63 nfet_01v8_lvt_W1p2_L0p2_m2__nf1_gboth_sdfull_pc/B.n16 nfet_01v8_lvt_W1p2_L0p2_m2__nf1_gboth_sdfull_pc/B.n15 25.6005
R64 nfet_01v8_lvt_W1p2_L0p2_m2__nf1_gboth_sdfull_pc/B.n16 nfet_01v8_lvt_W1p2_L0p2_m2__nf1_gboth_sdfull_pc/B.n10 25.6005
R65 nfet_01v8_lvt_W1p2_L0p2_m2__nf1_gboth_sdfull_pc/B.n10 nfet_01v8_lvt_W1p2_L0p2_m2__nf1_gboth_sdfull_pc/B.n7 25.6005
R66 nfet_01v8_lvt_W1p2_L0p2_m2__nf1_gboth_sdfull_pc/B.n23 nfet_01v8_lvt_W1p2_L0p2_m2__nf1_gboth_sdfull_pc/B.n7 25.6005
R67 nfet_01v8_lvt_W1p2_L0p2_m2__nf1_gboth_sdfull_pc/B.n36 nfet_01v8_lvt_W1p2_L0p2_m2__nf1_gboth_sdfull_pc/B.n24 25.6005
R68 B nfet_01v8_lvt_W1p2_L0p2_m2__nf1_gboth_sdfull_pc/B.n0 19.2005
R69 B nfet_01v8_lvt_W1p2_L0p2_m2__nf1_gboth_sdfull_pc/B.n40 6.4005
R70 B.n17 B.n13 1361.53
R71 B.n36 B.n6 1268.91
R72 B.n39 B.n38 1268.91
R73 B.n16 B.n12 1268.91
R74 B.n18 B.n14 1268.91
R75 B.n37 B.n4 1142.72
R76 B.n37 B.n3 726.215
R77 B.n30 B.n3 726.215
R78 B.n30 B.n9 726.215
R79 B.n23 B.n9 726.215
R80 B.n23 B.n13 726.215
R81 B.n34 B.n6 585
R82 B.n40 B.n39 585
R83 B.n38 B.n37 585
R84 B.n38 B.n0 585
R85 B.n3 B.n2 585
R86 B.n27 B.n2 585
R87 B.n30 B.n29 585
R88 B.n29 B.n28 585
R89 B.n10 B.n9 585
R90 B.n26 B.n10 585
R91 B.n24 B.n23 585
R92 B.n25 B.n24 585
R93 B.n13 B.n12 585
R94 B.n12 B.n11 585
R95 B.n16 B.n15 585
R96 B.n19 B.n18 585
R97 B.n14 B.n13 585
R98 B.n20 B.n14 585
R99 B.n23 B.n22 585
R100 B.n22 B.n21 585
R101 B.n9 B.n8 585
R102 B.n8 B.n7 585
R103 B.n31 B.n30 585
R104 B.n32 B.n31 585
R105 B.n5 B.n3 585
R106 B.n33 B.n5 585
R107 B.n37 B.n36 585
R108 B.n36 B.n35 585
R109 B.n4 B 459.224
R110 B.n36 B.n5 394
R111 B.n31 B.n5 394
R112 B.n31 B.n8 394
R113 B.n22 B.n8 394
R114 B.n22 B.n14 394
R115 B.n38 B.n2 394
R116 B.n29 B.n2 394
R117 B.n29 B.n10 394
R118 B.n24 B.n10 394
R119 B.n24 B.n12 394
R120 B.n4 B.n1 218.815
R121 B.n6 B.n1 147.374
R122 B.n17 B.n16 147.374
R123 B.n39 B.n1 147.374
R124 B.n18 B.n17 147.374
R125 B.n40 B.n0 82.4476
R126 B.n15 B.n11 82.4476
R127 B.n35 B.n34 82.4476
R128 B.n20 B.n19 82.4476
R129 B.n27 B.n0 25.6005
R130 B.n28 B.n27 25.6005
R131 B.n28 B.n26 25.6005
R132 B.n26 B.n25 25.6005
R133 B.n25 B.n11 25.6005
R134 B.n19 B.n15 25.6005
R135 B.n35 B.n33 25.6005
R136 B.n33 B.n32 25.6005
R137 B.n32 B.n7 25.6005
R138 B.n21 B.n7 25.6005
R139 B.n21 B.n20 25.6005
R140 B.n34 B 19.2005
R141 B B.n40 6.4005
R142 w_n43_n43.n18 w_n43_n43.n14 1361.53
R143 w_n43_n43.n39 w_n43_n43.n38 1268.91
R144 w_n43_n43.n36 w_n43_n43.n7 1268.91
R145 w_n43_n43.n17 w_n43_n43.n13 1268.91
R146 w_n43_n43.n19 w_n43_n43.n15 1268.91
R147 w_n43_n43.n37 w_n43_n43.n5 1142.72
R148 w_n43_n43.n37 w_n43_n43.n4 726.215
R149 w_n43_n43.n31 w_n43_n43.n4 726.215
R150 w_n43_n43.n31 w_n43_n43.n10 726.215
R151 w_n43_n43.n24 w_n43_n43.n10 726.215
R152 w_n43_n43.n24 w_n43_n43.n14 726.215
R153 w_n43_n43.n17 w_n43_n43.n16 585
R154 w_n43_n43.n20 w_n43_n43.n19 585
R155 w_n43_n43.n15 w_n43_n43.n14 585
R156 w_n43_n43.n21 w_n43_n43.n15 585
R157 w_n43_n43.n24 w_n43_n43.n23 585
R158 w_n43_n43.n23 w_n43_n43.n22 585
R159 w_n43_n43.n10 w_n43_n43.n9 585
R160 w_n43_n43.n9 w_n43_n43.n8 585
R161 w_n43_n43.n32 w_n43_n43.n31 585
R162 w_n43_n43.n33 w_n43_n43.n32 585
R163 w_n43_n43.n6 w_n43_n43.n4 585
R164 w_n43_n43.n34 w_n43_n43.n6 585
R165 w_n43_n43.n37 w_n43_n43.n36 585
R166 w_n43_n43.n36 w_n43_n43.n35 585
R167 w_n43_n43.n7 w_n43_n43.n0 585
R168 w_n43_n43.n40 w_n43_n43.n39 585
R169 w_n43_n43.n38 w_n43_n43.n37 585
R170 w_n43_n43.n38 w_n43_n43.n1 585
R171 w_n43_n43.n4 w_n43_n43.n3 585
R172 w_n43_n43.n28 w_n43_n43.n3 585
R173 w_n43_n43.n31 w_n43_n43.n30 585
R174 w_n43_n43.n30 w_n43_n43.n29 585
R175 w_n43_n43.n11 w_n43_n43.n10 585
R176 w_n43_n43.n27 w_n43_n43.n11 585
R177 w_n43_n43.n25 w_n43_n43.n24 585
R178 w_n43_n43.n26 w_n43_n43.n25 585
R179 w_n43_n43.n14 w_n43_n43.n13 585
R180 w_n43_n43.n13 w_n43_n43.n12 585
R181 w_n43_n43.n5 B 459.224
R182 w_n43_n43.n38 w_n43_n43.n3 394
R183 w_n43_n43.n30 w_n43_n43.n3 394
R184 w_n43_n43.n30 w_n43_n43.n11 394
R185 w_n43_n43.n25 w_n43_n43.n11 394
R186 w_n43_n43.n25 w_n43_n43.n13 394
R187 w_n43_n43.n36 w_n43_n43.n6 394
R188 w_n43_n43.n32 w_n43_n43.n6 394
R189 w_n43_n43.n32 w_n43_n43.n9 394
R190 w_n43_n43.n23 w_n43_n43.n9 394
R191 w_n43_n43.n23 w_n43_n43.n15 394
R192 w_n43_n43.n5 w_n43_n43.n2 218.815
R193 w_n43_n43.n18 w_n43_n43.n17 147.374
R194 w_n43_n43.n7 w_n43_n43.n2 147.374
R195 w_n43_n43.n39 w_n43_n43.n2 147.374
R196 w_n43_n43.n19 w_n43_n43.n18 147.374
R197 w_n43_n43.n40 w_n43_n43.n1 82.4476
R198 w_n43_n43.n35 w_n43_n43.n0 82.4476
R199 w_n43_n43.n16 w_n43_n43.n12 82.4476
R200 w_n43_n43.n21 w_n43_n43.n20 82.4476
R201 w_n43_n43.n28 w_n43_n43.n1 25.6005
R202 w_n43_n43.n29 w_n43_n43.n28 25.6005
R203 w_n43_n43.n29 w_n43_n43.n27 25.6005
R204 w_n43_n43.n27 w_n43_n43.n26 25.6005
R205 w_n43_n43.n26 w_n43_n43.n12 25.6005
R206 w_n43_n43.n35 w_n43_n43.n34 25.6005
R207 w_n43_n43.n34 w_n43_n43.n33 25.6005
R208 w_n43_n43.n33 w_n43_n43.n8 25.6005
R209 w_n43_n43.n22 w_n43_n43.n8 25.6005
R210 w_n43_n43.n22 w_n43_n43.n21 25.6005
R211 w_n43_n43.n20 w_n43_n43.n16 25.6005
R212 B w_n43_n43.n0 19.2005
R213 B w_n43_n43.n40 6.4005
C3 B.n0 B 0 ; **FLOATING
C4 B.n2 B 0 ; **FLOATING
C5 B.n3 B 0 ; **FLOATING
C6 B.n4 B 0 ; **FLOATING
C7 B.n5 B 0 ; **FLOATING
C8 B.n6 B 0 ; **FLOATING
C9 B.n7 B 0 ; **FLOATING
C10 B.n8 B 0 ; **FLOATING
C11 B.n9 B 0 ; **FLOATING
C12 B.n10 B 0 ; **FLOATING
C13 B.n11 B 0 ; **FLOATING
C14 B.n12 B 0 ; **FLOATING
C15 B.n13 B 0 ; **FLOATING
C16 B.n14 B 0 ; **FLOATING
C17 B.n15 B 0 ; **FLOATING
C18 B.n16 B 0 ; **FLOATING
C19 B.n17 B 0 ; **FLOATING
C20 B.n18 B 0 ; **FLOATING
C21 B.n19 B 0 ; **FLOATING
C22 B.n20 B 0 ; **FLOATING
C23 B.n21 B 0 ; **FLOATING
C24 B.n22 B 0 ; **FLOATING
C25 B.n23 B 0 ; **FLOATING
C26 B.n24 B 0 ; **FLOATING
C27 B.n25 B 0 ; **FLOATING
C28 B.n26 B 0 ; **FLOATING
C29 B.n27 B 0 ; **FLOATING
C30 B.n28 B 0 ; **FLOATING
C31 B.n29 B 0 ; **FLOATING
C32 B.n30 B 0 ; **FLOATING
C33 B.n31 B 0 ; **FLOATING
C34 B.n32 B 0 ; **FLOATING
C35 B.n33 B 0 ; **FLOATING
C36 B.n34 B 0 ; **FLOATING
C37 B.n35 B 0 ; **FLOATING
C38 B.n36 B 0 ; **FLOATING
C39 B.n37 B 0 ; **FLOATING
C40 B.n38 B 0 ; **FLOATING
C41 B.n39 B 0 ; **FLOATING
C42 B.n40 B 0 ; **FLOATING
C43 S B 0.1246f
C44 D B 0.1246f
C45 G B 0.30018f
