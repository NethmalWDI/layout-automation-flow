* NGSPICE file created from pfet_01v8_lvt_W2_L1_m9__nf1_gboth_sdfull.ext - technology: sky130A

X0 S G D B sky130_fd_pr__pfet_01v8_lvt ad=0.58 pd=4.58 as=0.58 ps=4.58 w=2 l=1
C0 S G 0.10986f
C1 G B 0.42288f
C2 S B 0.14797f
C3 D G 0.10986f
C4 S D 0.05958f
C5 D B 0.14797f
C6 S VSUBS 0.06594f
C7 D VSUBS 0.06594f
C8 G VSUBS 0.15704f
C9 B VSUBS 1.93927f
