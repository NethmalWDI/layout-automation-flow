* NGSPICE file created from pfet_01v8_lvt_W5_L1_m2__nf1_gtop_sdfull_ng.ext - technology: sky130A

.subckt sky130_fd_pr__pfet_01v8_lvt_7Q9QDH G D S w_n194_n598#
X0 S G D w_n194_n598# sky130_fd_pr__pfet_01v8_lvt ad=1.45 pd=10.58 as=1.45 ps=10.58 w=5 l=1
.ends

.subckt pfet_01v8_lvt_W5_L1_m2__nf1_gtop_sdfull_ng D S G B
Xpfet_01v8_lvt_W5_L1_m2__nf1_gtop_sdfull_ng_pc G D S B sky130_fd_pr__pfet_01v8_lvt_7Q9QDH
.ends
