* NGSPICE file created from pfet_01v8_W8_L1_m1__nf2_gtop_sdhalf_outD_ng.ext - technology: sky130A

.subckt sky130_fd_pr__pfet_01v8_YTA929 G D0 a_229_n436# w_n323_n498# S1
X0 a_229_n436# G S1 w_n323_n498# sky130_fd_pr__pfet_01v8 ad=1.16 pd=8.58 as=0.58 ps=4.29 w=4 l=1
X1 S1 G D0 w_n323_n498# sky130_fd_pr__pfet_01v8 ad=0.58 pd=4.29 as=1.16 ps=8.58 w=4 l=1
.ends

.subckt pfet_01v8_W8_L1_m1__nf2_gtop_sdhalf_outD_ng S D G B
Xpfet_01v8_W8_L1_m1__nf2_gtop_sdhalf_outD_ng_pc G D D B S sky130_fd_pr__pfet_01v8_YTA929
.ends
