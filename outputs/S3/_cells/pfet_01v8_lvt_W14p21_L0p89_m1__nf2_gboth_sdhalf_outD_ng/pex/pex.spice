* NGSPICE file created from pfet_01v8_lvt_W14p21_L0p89_m1__nf2_gboth_sdhalf_outD_ng.ext - technology: sky130A

.subckt pfet_01v8_lvt_W14p21_L0p89_m1__nf2_gboth_sdhalf_outD_ng S D G B
X0 D G S B sky130_fd_pr__pfet_01v8_lvt ad=2.0619 pd=14.8 as=1.03095 ps=7.4 w=7.11 l=0.89
X1 S G D B sky130_fd_pr__pfet_01v8_lvt ad=1.03095 pd=7.4 as=2.0619 ps=14.8 w=7.11 l=0.89
C0 D S 0.40966f
C1 B G 0.36335f
C2 S G 0.50916f
C3 S B 0.08322f
C4 D G 0.50905f
C5 D B 0.1333f
C6 S VSUBS 0.06943f
C7 D VSUBS 0.58296f
C8 G VSUBS 0.66796f
C9 B VSUBS 2.92933f
.ends
