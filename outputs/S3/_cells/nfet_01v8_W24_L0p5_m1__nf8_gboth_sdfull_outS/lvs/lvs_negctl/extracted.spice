* NGSPICE file created from nfet_01v8_W24_L0p5_m1__nf8_gboth_sdfull_outS.ext - technology: sky130A

.subckt sky130_fd_pr__nfet_01v8_9WTQ3R G B a_603_n300# D6 D4 D2 D0 S7 S5 S3 S1
X0 D6 G S5 B sky130_fd_pr__nfet_01v8 ad=0.435 pd=3.29 as=0.435 ps=3.29 w=3 l=0.5
X1 D2 G S1 B sky130_fd_pr__nfet_01v8 ad=0.435 pd=3.29 as=0.435 ps=3.29 w=3 l=0.5
X2 S5 G D4 B sky130_fd_pr__nfet_01v8 ad=0.435 pd=3.29 as=0.435 ps=3.29 w=3 l=0.5
X3 S7 G D6 B sky130_fd_pr__nfet_01v8 ad=0.435 pd=3.29 as=0.435 ps=3.29 w=3 l=0.5
X4 S1 G D0 B sky130_fd_pr__nfet_01v8 ad=0.435 pd=3.29 as=0.87 ps=6.58 w=3 l=0.5
X5 D4 G S3 B sky130_fd_pr__nfet_01v8 ad=0.435 pd=3.29 as=0.435 ps=3.29 w=3 l=0.5
X6 a_603_n300# G S7 B sky130_fd_pr__nfet_01v8 ad=0.87 pd=6.58 as=0.435 ps=3.29 w=3 l=0.5
X7 S3 G D2 B sky130_fd_pr__nfet_01v8 ad=0.435 pd=3.29 as=0.435 ps=3.29 w=3 l=0.5
.ends

.subckt nfet_01v8_W24_L0p5_m1__nf8_gboth_sdfull_outS S D G B
Xnfet_01v8_W24_L0p5_m1__nf8_gboth_sdfull_outS_pc G B S S S S S D D D D sky130_fd_pr__nfet_01v8_9WTQ3R
.ends
