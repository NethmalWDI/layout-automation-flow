* NGSPICE file created from nfet_01v8_W24_L1_m1__nf4_gboth_sdhalf_outS_ng.ext - technology: sky130A

.subckt sky130_fd_pr__nfet_01v8_HQWJLH G a_487_n600# D2 D0 S3 S1 VSUBS
X0 S3 G D2 VSUBS sky130_fd_pr__nfet_01v8 ad=0.87 pd=6.29 as=0.87 ps=6.29 w=6 l=1
X1 D2 G S1 VSUBS sky130_fd_pr__nfet_01v8 ad=0.87 pd=6.29 as=0.87 ps=6.29 w=6 l=1
X2 S1 G D0 VSUBS sky130_fd_pr__nfet_01v8 ad=0.87 pd=6.29 as=1.74 ps=12.58 w=6 l=1
X3 a_487_n600# G S3 VSUBS sky130_fd_pr__nfet_01v8 ad=1.74 pd=12.58 as=0.87 ps=6.29 w=6 l=1
.ends

.subckt nfet_01v8_W24_L1_m1__nf4_gboth_sdhalf_outS_ng S D G B
Xnfet_01v8_W24_L1_m1__nf4_gboth_sdhalf_outS_ng_pc G S S S D D B sky130_fd_pr__nfet_01v8_HQWJLH
.ends
