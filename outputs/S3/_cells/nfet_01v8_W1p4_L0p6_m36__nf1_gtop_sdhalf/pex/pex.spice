* NGSPICE file created from nfet_01v8_W1p4_L0p6_m36__nf1_gtop_sdhalf.ext - technology: sky130A

.subckt nfet_01v8_W1p4_L0p6_m36__nf1_gtop_sdhalf D S G B
X0 S G D B sky130_fd_pr__nfet_01v8 ad=0.406 pd=3.38 as=0.406 ps=3.38 w=1.4 l=0.6
C0 D S 0.03347f
C1 S G 0.03163f
C2 D G 0.03163f
C3 S B 0.09534f
C4 D B 0.09534f
C5 G B 0.30081f
.ends
