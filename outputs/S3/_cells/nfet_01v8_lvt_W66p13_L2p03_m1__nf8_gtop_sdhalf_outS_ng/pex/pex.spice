* NGSPICE file created from nfet_01v8_lvt_W66p13_L2p03_m1__nf8_gtop_sdhalf_outS_ng.ext - technology: sky130A

.subckt nfet_01v8_lvt_W66p13_L2p03_m1__nf8_gtop_sdhalf_outS_ng S D G B
X0 S G D B sky130_fd_pr__nfet_01v8_lvt ad=1.19915 pd=8.56 as=1.19915 ps=8.56 w=8.27 l=2.03
X1 D G S B sky130_fd_pr__nfet_01v8_lvt ad=1.19915 pd=8.56 as=1.19915 ps=8.56 w=8.27 l=2.03
X2 D G S B sky130_fd_pr__nfet_01v8_lvt ad=1.19915 pd=8.56 as=2.3983 ps=17.12 w=8.27 l=2.03
X3 S G D B sky130_fd_pr__nfet_01v8_lvt ad=1.19915 pd=8.56 as=1.19915 ps=8.56 w=8.27 l=2.03
X4 D G S B sky130_fd_pr__nfet_01v8_lvt ad=1.19915 pd=8.56 as=1.19915 ps=8.56 w=8.27 l=2.03
X5 S G D B sky130_fd_pr__nfet_01v8_lvt ad=1.19915 pd=8.56 as=1.19915 ps=8.56 w=8.27 l=2.03
X6 S G D B sky130_fd_pr__nfet_01v8_lvt ad=2.3983 pd=17.12 as=1.19915 ps=8.56 w=8.27 l=2.03
X7 D G S B sky130_fd_pr__nfet_01v8_lvt ad=1.19915 pd=8.56 as=1.19915 ps=8.56 w=8.27 l=2.03
C0 S D 1.24854f
C1 G S 3.43802f
C2 G D 3.40058f
C3 D B 0.39878f
C4 S B 1.03844f
C5 G B 4.70809f
.ends
