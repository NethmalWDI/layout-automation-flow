* NGSPICE file created from nfet_01v8_lvt_W2_L1_m1__nf1_gboth_sdfull.ext - technology: sky130A

X0 S G D nfet_01v8_lvt_W2_L1_m1__nf1_gboth_sdfull_pc/B.t0 sky130_fd_pr__nfet_01v8_lvt ad=0.58 pd=4.58 as=0.58 ps=4.58 w=2 l=1
C0 D G 0.10986f
C1 S D 0.05958f
C2 S G 0.10986f
R0 nfet_01v8_lvt_W2_L1_m1__nf1_gboth_sdfull_pc/B.n62 nfet_01v8_lvt_W2_L1_m1__nf1_gboth_sdfull_pc/B.n61 1210.97
R1 nfet_01v8_lvt_W2_L1_m1__nf1_gboth_sdfull_pc/B.n59 nfet_01v8_lvt_W2_L1_m1__nf1_gboth_sdfull_pc/B.n8 1210.97
R2 nfet_01v8_lvt_W2_L1_m1__nf1_gboth_sdfull_pc/B.n32 nfet_01v8_lvt_W2_L1_m1__nf1_gboth_sdfull_pc/B.n20 1210.97
R3 nfet_01v8_lvt_W2_L1_m1__nf1_gboth_sdfull_pc/B.n28 nfet_01v8_lvt_W2_L1_m1__nf1_gboth_sdfull_pc/B.n18 1210.97
R4 nfet_01v8_lvt_W2_L1_m1__nf1_gboth_sdfull_pc/B.n60 nfet_01v8_lvt_W2_L1_m1__nf1_gboth_sdfull_pc/B.n3 915.385
R5 nfet_01v8_lvt_W2_L1_m1__nf1_gboth_sdfull_pc/B.n30 nfet_01v8_lvt_W2_L1_m1__nf1_gboth_sdfull_pc/B.n19 915.385
R6 nfet_01v8_lvt_W2_L1_m1__nf1_gboth_sdfull_pc/B.n33 nfet_01v8_lvt_W2_L1_m1__nf1_gboth_sdfull_pc/B.n32 585
R7 nfet_01v8_lvt_W2_L1_m1__nf1_gboth_sdfull_pc/B.n22 nfet_01v8_lvt_W2_L1_m1__nf1_gboth_sdfull_pc/B.n21 585
R8 nfet_01v8_lvt_W2_L1_m1__nf1_gboth_sdfull_pc/B.n30 nfet_01v8_lvt_W2_L1_m1__nf1_gboth_sdfull_pc/B.n23 585
R9 nfet_01v8_lvt_W2_L1_m1__nf1_gboth_sdfull_pc/B.n25 nfet_01v8_lvt_W2_L1_m1__nf1_gboth_sdfull_pc/B.n23 585
R10 nfet_01v8_lvt_W2_L1_m1__nf1_gboth_sdfull_pc/B.n26 nfet_01v8_lvt_W2_L1_m1__nf1_gboth_sdfull_pc/B.n24 585
R11 nfet_01v8_lvt_W2_L1_m1__nf1_gboth_sdfull_pc/B.n28 nfet_01v8_lvt_W2_L1_m1__nf1_gboth_sdfull_pc/B.n27 585
R12 nfet_01v8_lvt_W2_L1_m1__nf1_gboth_sdfull_pc/B.n19 nfet_01v8_lvt_W2_L1_m1__nf1_gboth_sdfull_pc/B.n18 585
R13 nfet_01v8_lvt_W2_L1_m1__nf1_gboth_sdfull_pc/B.n18 nfet_01v8_lvt_W2_L1_m1__nf1_gboth_sdfull_pc/B.n17 585
R14 nfet_01v8_lvt_W2_L1_m1__nf1_gboth_sdfull_pc/B.n38 nfet_01v8_lvt_W2_L1_m1__nf1_gboth_sdfull_pc/B.n37 585
R15 nfet_01v8_lvt_W2_L1_m1__nf1_gboth_sdfull_pc/B.n39 nfet_01v8_lvt_W2_L1_m1__nf1_gboth_sdfull_pc/B.n38 585
R16 nfet_01v8_lvt_W2_L1_m1__nf1_gboth_sdfull_pc/B.n16 nfet_01v8_lvt_W2_L1_m1__nf1_gboth_sdfull_pc/B.n15 585
R17 nfet_01v8_lvt_W2_L1_m1__nf1_gboth_sdfull_pc/B.n40 nfet_01v8_lvt_W2_L1_m1__nf1_gboth_sdfull_pc/B.n16 585
R18 nfet_01v8_lvt_W2_L1_m1__nf1_gboth_sdfull_pc/B.n43 nfet_01v8_lvt_W2_L1_m1__nf1_gboth_sdfull_pc/B.n42 585
R19 nfet_01v8_lvt_W2_L1_m1__nf1_gboth_sdfull_pc/B.n42 nfet_01v8_lvt_W2_L1_m1__nf1_gboth_sdfull_pc/B.n41 585
R20 nfet_01v8_lvt_W2_L1_m1__nf1_gboth_sdfull_pc/B.n11 nfet_01v8_lvt_W2_L1_m1__nf1_gboth_sdfull_pc/B.n10 585
R21 nfet_01v8_lvt_W2_L1_m1__nf1_gboth_sdfull_pc/B.n10 nfet_01v8_lvt_W2_L1_m1__nf1_gboth_sdfull_pc/B.n9 585
R22 nfet_01v8_lvt_W2_L1_m1__nf1_gboth_sdfull_pc/B.n51 nfet_01v8_lvt_W2_L1_m1__nf1_gboth_sdfull_pc/B.n50 585
R23 nfet_01v8_lvt_W2_L1_m1__nf1_gboth_sdfull_pc/B.n52 nfet_01v8_lvt_W2_L1_m1__nf1_gboth_sdfull_pc/B.n51 585
R24 nfet_01v8_lvt_W2_L1_m1__nf1_gboth_sdfull_pc/B.n7 nfet_01v8_lvt_W2_L1_m1__nf1_gboth_sdfull_pc/B.n6 585
R25 nfet_01v8_lvt_W2_L1_m1__nf1_gboth_sdfull_pc/B.n53 nfet_01v8_lvt_W2_L1_m1__nf1_gboth_sdfull_pc/B.n7 585
R26 nfet_01v8_lvt_W2_L1_m1__nf1_gboth_sdfull_pc/B.n60 nfet_01v8_lvt_W2_L1_m1__nf1_gboth_sdfull_pc/B.n59 585
R27 nfet_01v8_lvt_W2_L1_m1__nf1_gboth_sdfull_pc/B.n59 nfet_01v8_lvt_W2_L1_m1__nf1_gboth_sdfull_pc/B.n58 585
R28 nfet_01v8_lvt_W2_L1_m1__nf1_gboth_sdfull_pc/B.n8 nfet_01v8_lvt_W2_L1_m1__nf1_gboth_sdfull_pc/B.n3 585
R29 nfet_01v8_lvt_W2_L1_m1__nf1_gboth_sdfull_pc/B.n57 nfet_01v8_lvt_W2_L1_m1__nf1_gboth_sdfull_pc/B.n8 585
R30 nfet_01v8_lvt_W2_L1_m1__nf1_gboth_sdfull_pc/B.n56 nfet_01v8_lvt_W2_L1_m1__nf1_gboth_sdfull_pc/B.n55 585
R31 nfet_01v8_lvt_W2_L1_m1__nf1_gboth_sdfull_pc/B.n2 nfet_01v8_lvt_W2_L1_m1__nf1_gboth_sdfull_pc/B.n0 585
R32 nfet_01v8_lvt_W2_L1_m1__nf1_gboth_sdfull_pc/B.n65 nfet_01v8_lvt_W2_L1_m1__nf1_gboth_sdfull_pc/B.n64 585
R33 nfet_01v8_lvt_W2_L1_m1__nf1_gboth_sdfull_pc/B.n62 nfet_01v8_lvt_W2_L1_m1__nf1_gboth_sdfull_pc/B.n1 585
R34 nfet_01v8_lvt_W2_L1_m1__nf1_gboth_sdfull_pc/B.n61 nfet_01v8_lvt_W2_L1_m1__nf1_gboth_sdfull_pc/B.n60 585
R35 nfet_01v8_lvt_W2_L1_m1__nf1_gboth_sdfull_pc/B.n61 nfet_01v8_lvt_W2_L1_m1__nf1_gboth_sdfull_pc/B.n5 585
R36 nfet_01v8_lvt_W2_L1_m1__nf1_gboth_sdfull_pc/B.n6 nfet_01v8_lvt_W2_L1_m1__nf1_gboth_sdfull_pc/B.n4 585
R37 nfet_01v8_lvt_W2_L1_m1__nf1_gboth_sdfull_pc/B.n47 nfet_01v8_lvt_W2_L1_m1__nf1_gboth_sdfull_pc/B.n4 585
R38 nfet_01v8_lvt_W2_L1_m1__nf1_gboth_sdfull_pc/B.n50 nfet_01v8_lvt_W2_L1_m1__nf1_gboth_sdfull_pc/B.n49 585
R39 nfet_01v8_lvt_W2_L1_m1__nf1_gboth_sdfull_pc/B.n49 nfet_01v8_lvt_W2_L1_m1__nf1_gboth_sdfull_pc/B.n48 585
R40 nfet_01v8_lvt_W2_L1_m1__nf1_gboth_sdfull_pc/B.n12 nfet_01v8_lvt_W2_L1_m1__nf1_gboth_sdfull_pc/B.n11 585
R41 nfet_01v8_lvt_W2_L1_m1__nf1_gboth_sdfull_pc/B.n46 nfet_01v8_lvt_W2_L1_m1__nf1_gboth_sdfull_pc/B.n12 585
R42 nfet_01v8_lvt_W2_L1_m1__nf1_gboth_sdfull_pc/B.n44 nfet_01v8_lvt_W2_L1_m1__nf1_gboth_sdfull_pc/B.n43 585
R43 nfet_01v8_lvt_W2_L1_m1__nf1_gboth_sdfull_pc/B.n45 nfet_01v8_lvt_W2_L1_m1__nf1_gboth_sdfull_pc/B.n44 585
R44 nfet_01v8_lvt_W2_L1_m1__nf1_gboth_sdfull_pc/B.n15 nfet_01v8_lvt_W2_L1_m1__nf1_gboth_sdfull_pc/B.n14 585
R45 nfet_01v8_lvt_W2_L1_m1__nf1_gboth_sdfull_pc/B.n14 nfet_01v8_lvt_W2_L1_m1__nf1_gboth_sdfull_pc/B.n13 585
R46 nfet_01v8_lvt_W2_L1_m1__nf1_gboth_sdfull_pc/B.n37 nfet_01v8_lvt_W2_L1_m1__nf1_gboth_sdfull_pc/B.n36 585
R47 nfet_01v8_lvt_W2_L1_m1__nf1_gboth_sdfull_pc/B.n36 nfet_01v8_lvt_W2_L1_m1__nf1_gboth_sdfull_pc/B.n35 585
R48 nfet_01v8_lvt_W2_L1_m1__nf1_gboth_sdfull_pc/B.n20 nfet_01v8_lvt_W2_L1_m1__nf1_gboth_sdfull_pc/B.n19 585
R49 nfet_01v8_lvt_W2_L1_m1__nf1_gboth_sdfull_pc/B.n34 nfet_01v8_lvt_W2_L1_m1__nf1_gboth_sdfull_pc/B.n20 585
R50 nfet_01v8_lvt_W2_L1_m1__nf1_gboth_sdfull_pc/B.n60 nfet_01v8_lvt_W2_L1_m1__nf1_gboth_sdfull_pc/B.n6 523.077
R51 nfet_01v8_lvt_W2_L1_m1__nf1_gboth_sdfull_pc/B.n50 nfet_01v8_lvt_W2_L1_m1__nf1_gboth_sdfull_pc/B.n6 523.077
R52 nfet_01v8_lvt_W2_L1_m1__nf1_gboth_sdfull_pc/B.n50 nfet_01v8_lvt_W2_L1_m1__nf1_gboth_sdfull_pc/B.n11 523.077
R53 nfet_01v8_lvt_W2_L1_m1__nf1_gboth_sdfull_pc/B.n43 nfet_01v8_lvt_W2_L1_m1__nf1_gboth_sdfull_pc/B.n15 523.077
R54 nfet_01v8_lvt_W2_L1_m1__nf1_gboth_sdfull_pc/B.n37 nfet_01v8_lvt_W2_L1_m1__nf1_gboth_sdfull_pc/B.n15 523.077
R55 nfet_01v8_lvt_W2_L1_m1__nf1_gboth_sdfull_pc/B.n37 nfet_01v8_lvt_W2_L1_m1__nf1_gboth_sdfull_pc/B.n19 523.077
R56 nfet_01v8_lvt_W2_L1_m1__nf1_gboth_sdfull_pc/B.n61 nfet_01v8_lvt_W2_L1_m1__nf1_gboth_sdfull_pc/B.n4 394
R57 nfet_01v8_lvt_W2_L1_m1__nf1_gboth_sdfull_pc/B.n49 nfet_01v8_lvt_W2_L1_m1__nf1_gboth_sdfull_pc/B.n4 394
R58 nfet_01v8_lvt_W2_L1_m1__nf1_gboth_sdfull_pc/B.n49 nfet_01v8_lvt_W2_L1_m1__nf1_gboth_sdfull_pc/B.n12 394
R59 nfet_01v8_lvt_W2_L1_m1__nf1_gboth_sdfull_pc/B.n44 nfet_01v8_lvt_W2_L1_m1__nf1_gboth_sdfull_pc/B.n12 394
R60 nfet_01v8_lvt_W2_L1_m1__nf1_gboth_sdfull_pc/B.n44 nfet_01v8_lvt_W2_L1_m1__nf1_gboth_sdfull_pc/B.n14 394
R61 nfet_01v8_lvt_W2_L1_m1__nf1_gboth_sdfull_pc/B.n36 nfet_01v8_lvt_W2_L1_m1__nf1_gboth_sdfull_pc/B.n14 394
R62 nfet_01v8_lvt_W2_L1_m1__nf1_gboth_sdfull_pc/B.n36 nfet_01v8_lvt_W2_L1_m1__nf1_gboth_sdfull_pc/B.n20 394
R63 nfet_01v8_lvt_W2_L1_m1__nf1_gboth_sdfull_pc/B.n64 nfet_01v8_lvt_W2_L1_m1__nf1_gboth_sdfull_pc/B.n2 394
R64 nfet_01v8_lvt_W2_L1_m1__nf1_gboth_sdfull_pc/B.n55 nfet_01v8_lvt_W2_L1_m1__nf1_gboth_sdfull_pc/B.n8 394
R65 nfet_01v8_lvt_W2_L1_m1__nf1_gboth_sdfull_pc/B.n59 nfet_01v8_lvt_W2_L1_m1__nf1_gboth_sdfull_pc/B.n7 394
R66 nfet_01v8_lvt_W2_L1_m1__nf1_gboth_sdfull_pc/B.n51 nfet_01v8_lvt_W2_L1_m1__nf1_gboth_sdfull_pc/B.n7 394
R67 nfet_01v8_lvt_W2_L1_m1__nf1_gboth_sdfull_pc/B.n51 nfet_01v8_lvt_W2_L1_m1__nf1_gboth_sdfull_pc/B.n10 394
R68 nfet_01v8_lvt_W2_L1_m1__nf1_gboth_sdfull_pc/B.n42 nfet_01v8_lvt_W2_L1_m1__nf1_gboth_sdfull_pc/B.n10 394
R69 nfet_01v8_lvt_W2_L1_m1__nf1_gboth_sdfull_pc/B.n42 nfet_01v8_lvt_W2_L1_m1__nf1_gboth_sdfull_pc/B.n16 394
R70 nfet_01v8_lvt_W2_L1_m1__nf1_gboth_sdfull_pc/B.n38 nfet_01v8_lvt_W2_L1_m1__nf1_gboth_sdfull_pc/B.n16 394
R71 nfet_01v8_lvt_W2_L1_m1__nf1_gboth_sdfull_pc/B.n38 nfet_01v8_lvt_W2_L1_m1__nf1_gboth_sdfull_pc/B.n18 394
R72 nfet_01v8_lvt_W2_L1_m1__nf1_gboth_sdfull_pc/B.n23 nfet_01v8_lvt_W2_L1_m1__nf1_gboth_sdfull_pc/B.n22 394
R73 nfet_01v8_lvt_W2_L1_m1__nf1_gboth_sdfull_pc/B.n24 nfet_01v8_lvt_W2_L1_m1__nf1_gboth_sdfull_pc/B.n23 394
R74 nfet_01v8_lvt_W2_L1_m1__nf1_gboth_sdfull_pc/B.n3 B 330.769
R75 nfet_01v8_lvt_W2_L1_m1__nf1_gboth_sdfull_pc/B.t0 nfet_01v8_lvt_W2_L1_m1__nf1_gboth_sdfull_pc/B.n11 261.538
R76 nfet_01v8_lvt_W2_L1_m1__nf1_gboth_sdfull_pc/B.n43 nfet_01v8_lvt_W2_L1_m1__nf1_gboth_sdfull_pc/B.t0 261.538
R77 nfet_01v8_lvt_W2_L1_m1__nf1_gboth_sdfull_pc/B.n31 nfet_01v8_lvt_W2_L1_m1__nf1_gboth_sdfull_pc/B.n30 218.815
R78 nfet_01v8_lvt_W2_L1_m1__nf1_gboth_sdfull_pc/B.n30 nfet_01v8_lvt_W2_L1_m1__nf1_gboth_sdfull_pc/B.n29 218.815
R79 nfet_01v8_lvt_W2_L1_m1__nf1_gboth_sdfull_pc/B.n54 nfet_01v8_lvt_W2_L1_m1__nf1_gboth_sdfull_pc/B.n3 218.815
R80 nfet_01v8_lvt_W2_L1_m1__nf1_gboth_sdfull_pc/B.n63 nfet_01v8_lvt_W2_L1_m1__nf1_gboth_sdfull_pc/B.n3 218.815
R81 nfet_01v8_lvt_W2_L1_m1__nf1_gboth_sdfull_pc/B.n32 nfet_01v8_lvt_W2_L1_m1__nf1_gboth_sdfull_pc/B.n31 147.374
R82 nfet_01v8_lvt_W2_L1_m1__nf1_gboth_sdfull_pc/B.n29 nfet_01v8_lvt_W2_L1_m1__nf1_gboth_sdfull_pc/B.n24 147.374
R83 nfet_01v8_lvt_W2_L1_m1__nf1_gboth_sdfull_pc/B.n55 nfet_01v8_lvt_W2_L1_m1__nf1_gboth_sdfull_pc/B.n54 147.374
R84 nfet_01v8_lvt_W2_L1_m1__nf1_gboth_sdfull_pc/B.n64 nfet_01v8_lvt_W2_L1_m1__nf1_gboth_sdfull_pc/B.n63 147.374
R85 nfet_01v8_lvt_W2_L1_m1__nf1_gboth_sdfull_pc/B.n63 nfet_01v8_lvt_W2_L1_m1__nf1_gboth_sdfull_pc/B.n62 147.374
R86 nfet_01v8_lvt_W2_L1_m1__nf1_gboth_sdfull_pc/B.n54 nfet_01v8_lvt_W2_L1_m1__nf1_gboth_sdfull_pc/B.n2 147.374
R87 nfet_01v8_lvt_W2_L1_m1__nf1_gboth_sdfull_pc/B.n31 nfet_01v8_lvt_W2_L1_m1__nf1_gboth_sdfull_pc/B.n22 147.374
R88 nfet_01v8_lvt_W2_L1_m1__nf1_gboth_sdfull_pc/B.n29 nfet_01v8_lvt_W2_L1_m1__nf1_gboth_sdfull_pc/B.n28 147.374
R89 nfet_01v8_lvt_W2_L1_m1__nf1_gboth_sdfull_pc/B.n5 nfet_01v8_lvt_W2_L1_m1__nf1_gboth_sdfull_pc/B.n1 78.6829
R90 nfet_01v8_lvt_W2_L1_m1__nf1_gboth_sdfull_pc/B.n58 nfet_01v8_lvt_W2_L1_m1__nf1_gboth_sdfull_pc/B.n57 78.6829
R91 nfet_01v8_lvt_W2_L1_m1__nf1_gboth_sdfull_pc/B.n34 nfet_01v8_lvt_W2_L1_m1__nf1_gboth_sdfull_pc/B.n33 78.6829
R92 nfet_01v8_lvt_W2_L1_m1__nf1_gboth_sdfull_pc/B.n27 nfet_01v8_lvt_W2_L1_m1__nf1_gboth_sdfull_pc/B.n17 78.6829
R93 nfet_01v8_lvt_W2_L1_m1__nf1_gboth_sdfull_pc/B.n47 nfet_01v8_lvt_W2_L1_m1__nf1_gboth_sdfull_pc/B.n5 25.6005
R94 nfet_01v8_lvt_W2_L1_m1__nf1_gboth_sdfull_pc/B.n48 nfet_01v8_lvt_W2_L1_m1__nf1_gboth_sdfull_pc/B.n47 25.6005
R95 nfet_01v8_lvt_W2_L1_m1__nf1_gboth_sdfull_pc/B.n48 nfet_01v8_lvt_W2_L1_m1__nf1_gboth_sdfull_pc/B.n46 25.6005
R96 nfet_01v8_lvt_W2_L1_m1__nf1_gboth_sdfull_pc/B.n46 nfet_01v8_lvt_W2_L1_m1__nf1_gboth_sdfull_pc/B.n45 25.6005
R97 nfet_01v8_lvt_W2_L1_m1__nf1_gboth_sdfull_pc/B.n45 nfet_01v8_lvt_W2_L1_m1__nf1_gboth_sdfull_pc/B.n13 25.6005
R98 nfet_01v8_lvt_W2_L1_m1__nf1_gboth_sdfull_pc/B.n35 nfet_01v8_lvt_W2_L1_m1__nf1_gboth_sdfull_pc/B.n13 25.6005
R99 nfet_01v8_lvt_W2_L1_m1__nf1_gboth_sdfull_pc/B.n35 nfet_01v8_lvt_W2_L1_m1__nf1_gboth_sdfull_pc/B.n34 25.6005
R100 nfet_01v8_lvt_W2_L1_m1__nf1_gboth_sdfull_pc/B.n65 nfet_01v8_lvt_W2_L1_m1__nf1_gboth_sdfull_pc/B.n1 25.6005
R101 nfet_01v8_lvt_W2_L1_m1__nf1_gboth_sdfull_pc/B.n56 nfet_01v8_lvt_W2_L1_m1__nf1_gboth_sdfull_pc/B.n0 25.6005
R102 nfet_01v8_lvt_W2_L1_m1__nf1_gboth_sdfull_pc/B.n57 nfet_01v8_lvt_W2_L1_m1__nf1_gboth_sdfull_pc/B.n56 25.6005
R103 nfet_01v8_lvt_W2_L1_m1__nf1_gboth_sdfull_pc/B.n58 nfet_01v8_lvt_W2_L1_m1__nf1_gboth_sdfull_pc/B.n53 25.6005
R104 nfet_01v8_lvt_W2_L1_m1__nf1_gboth_sdfull_pc/B.n53 nfet_01v8_lvt_W2_L1_m1__nf1_gboth_sdfull_pc/B.n52 25.6005
R105 nfet_01v8_lvt_W2_L1_m1__nf1_gboth_sdfull_pc/B.n52 nfet_01v8_lvt_W2_L1_m1__nf1_gboth_sdfull_pc/B.n9 25.6005
R106 nfet_01v8_lvt_W2_L1_m1__nf1_gboth_sdfull_pc/B.n41 nfet_01v8_lvt_W2_L1_m1__nf1_gboth_sdfull_pc/B.n9 25.6005
R107 nfet_01v8_lvt_W2_L1_m1__nf1_gboth_sdfull_pc/B.n41 nfet_01v8_lvt_W2_L1_m1__nf1_gboth_sdfull_pc/B.n40 25.6005
R108 nfet_01v8_lvt_W2_L1_m1__nf1_gboth_sdfull_pc/B.n40 nfet_01v8_lvt_W2_L1_m1__nf1_gboth_sdfull_pc/B.n39 25.6005
R109 nfet_01v8_lvt_W2_L1_m1__nf1_gboth_sdfull_pc/B.n39 nfet_01v8_lvt_W2_L1_m1__nf1_gboth_sdfull_pc/B.n17 25.6005
R110 nfet_01v8_lvt_W2_L1_m1__nf1_gboth_sdfull_pc/B.n33 nfet_01v8_lvt_W2_L1_m1__nf1_gboth_sdfull_pc/B.n21 25.6005
R111 nfet_01v8_lvt_W2_L1_m1__nf1_gboth_sdfull_pc/B.n25 nfet_01v8_lvt_W2_L1_m1__nf1_gboth_sdfull_pc/B.n21 25.6005
R112 nfet_01v8_lvt_W2_L1_m1__nf1_gboth_sdfull_pc/B.n26 nfet_01v8_lvt_W2_L1_m1__nf1_gboth_sdfull_pc/B.n25 25.6005
R113 nfet_01v8_lvt_W2_L1_m1__nf1_gboth_sdfull_pc/B.n27 nfet_01v8_lvt_W2_L1_m1__nf1_gboth_sdfull_pc/B.n26 25.6005
R114 B nfet_01v8_lvt_W2_L1_m1__nf1_gboth_sdfull_pc/B.n65 19.2005
R115 B nfet_01v8_lvt_W2_L1_m1__nf1_gboth_sdfull_pc/B.n0 6.4005
R116 B.n64 B.n3 1210.97
R117 B.n56 B.n55 1210.97
R118 B.n33 B.n22 1210.97
R119 B.n35 B.n20 1210.97
R120 B.n65 B.n0 915.385
R121 B.n34 B.n21 915.385
R122 B.n65 B.n64 585
R123 B.n64 B.n63 585
R124 B.n62 B.n4 585
R125 B.n61 B.n60 585
R126 B.n59 B.n58 585
R127 B.n57 B.n56 585
R128 B.n55 B.n0 585
R129 B.n55 B.n6 585
R130 B.n54 B.n53 585
R131 B.n54 B.n8 585
R132 B.n9 B.n7 585
R133 B.n44 B.n7 585
R134 B.n47 B.n46 585
R135 B.n46 B.n45 585
R136 B.n14 B.n13 585
R137 B.n43 B.n14 585
R138 B.n41 B.n40 585
R139 B.n42 B.n41 585
R140 B.n17 B.n16 585
R141 B.n16 B.n15 585
R142 B.n34 B.n33 585
R143 B.n33 B.n32 585
R144 B.n22 B.n21 585
R145 B.n31 B.n22 585
R146 B.n30 B.n29 585
R147 B.n27 B.n23 585
R148 B.n26 B.n24 585
R149 B.n20 B.n19 585
R150 B.n35 B.n34 585
R151 B.n36 B.n35 585
R152 B.n18 B.n17 585
R153 B.n37 B.n18 585
R154 B.n40 B.n39 585
R155 B.n39 B.n38 585
R156 B.n13 B.n12 585
R157 B.n12 B.n11 585
R158 B.n48 B.n47 585
R159 B.n49 B.n48 585
R160 B.n10 B.n9 585
R161 B.n50 B.n10 585
R162 B.n53 B.n52 585
R163 B.n52 B.n51 585
R164 B.n3 B.n0 585
R165 B.n5 B.n3 585
R166 B.n53 B.n0 523.077
R167 B.n53 B.n9 523.077
R168 B.n47 B.n9 523.077
R169 B.n47 B.n13 523.077
R170 B.n40 B.n13 523.077
R171 B.n40 B.n17 523.077
R172 B.n34 B.n17 523.077
R173 B.n52 B.n3 394
R174 B.n52 B.n10 394
R175 B.n48 B.n10 394
R176 B.n48 B.n12 394
R177 B.n39 B.n12 394
R178 B.n39 B.n18 394
R179 B.n35 B.n18 394
R180 B.n60 B.n59 394
R181 B.n64 B.n4 394
R182 B.n55 B.n54 394
R183 B.n54 B.n7 394
R184 B.n46 B.n7 394
R185 B.n46 B.n14 394
R186 B.n41 B.n14 394
R187 B.n41 B.n16 394
R188 B.n33 B.n16 394
R189 B.n29 B.n22 394
R190 B.n27 B.n26 394
R191 B B.n65 330.769
R192 B.n65 B.n2 218.815
R193 B.n65 B.n1 218.815
R194 B.n28 B.n21 218.815
R195 B.n25 B.n21 218.815
R196 B.n4 B.n2 147.374
R197 B.n59 B.n1 147.374
R198 B.n29 B.n28 147.374
R199 B.n26 B.n25 147.374
R200 B.n56 B.n1 147.374
R201 B.n60 B.n2 147.374
R202 B.n28 B.n27 147.374
R203 B.n25 B.n20 147.374
R204 B.n57 B.n6 78.6829
R205 B.n32 B.n31 78.6829
R206 B.n63 B.n5 78.6829
R207 B.n36 B.n19 78.6829
R208 B.n58 B.n57 25.6005
R209 B.n62 B.n61 25.6005
R210 B.n63 B.n62 25.6005
R211 B.n8 B.n6 25.6005
R212 B.n44 B.n8 25.6005
R213 B.n45 B.n44 25.6005
R214 B.n45 B.n43 25.6005
R215 B.n43 B.n42 25.6005
R216 B.n42 B.n15 25.6005
R217 B.n32 B.n15 25.6005
R218 B.n31 B.n30 25.6005
R219 B.n30 B.n23 25.6005
R220 B.n24 B.n23 25.6005
R221 B.n24 B.n19 25.6005
R222 B.n51 B.n5 25.6005
R223 B.n51 B.n50 25.6005
R224 B.n50 B.n49 25.6005
R225 B.n49 B.n11 25.6005
R226 B.n38 B.n11 25.6005
R227 B.n38 B.n37 25.6005
R228 B.n37 B.n36 25.6005
R229 B.n58 B 19.2005
R230 B.n61 B 6.4005
R231 w_n43_n43.n62 w_n43_n43.n61 1210.97
R232 w_n43_n43.n59 w_n43_n43.n8 1210.97
R233 w_n43_n43.n32 w_n43_n43.n20 1210.97
R234 w_n43_n43.n25 w_n43_n43.n18 1210.97
R235 w_n43_n43.n60 w_n43_n43.n3 915.385
R236 w_n43_n43.n31 w_n43_n43.n19 915.385
R237 w_n43_n43.n32 w_n43_n43.n31 585
R238 w_n43_n43.n33 w_n43_n43.n32 585
R239 w_n43_n43.n22 w_n43_n43.n21 585
R240 w_n43_n43.n29 w_n43_n43.n28 585
R241 w_n43_n43.n27 w_n43_n43.n24 585
R242 w_n43_n43.n26 w_n43_n43.n25 585
R243 w_n43_n43.n19 w_n43_n43.n18 585
R244 w_n43_n43.n18 w_n43_n43.n17 585
R245 w_n43_n43.n38 w_n43_n43.n37 585
R246 w_n43_n43.n39 w_n43_n43.n38 585
R247 w_n43_n43.n16 w_n43_n43.n15 585
R248 w_n43_n43.n40 w_n43_n43.n16 585
R249 w_n43_n43.n43 w_n43_n43.n42 585
R250 w_n43_n43.n42 w_n43_n43.n41 585
R251 w_n43_n43.n11 w_n43_n43.n10 585
R252 w_n43_n43.n10 w_n43_n43.n9 585
R253 w_n43_n43.n51 w_n43_n43.n50 585
R254 w_n43_n43.n52 w_n43_n43.n51 585
R255 w_n43_n43.n7 w_n43_n43.n6 585
R256 w_n43_n43.n53 w_n43_n43.n7 585
R257 w_n43_n43.n60 w_n43_n43.n59 585
R258 w_n43_n43.n59 w_n43_n43.n58 585
R259 w_n43_n43.n8 w_n43_n43.n3 585
R260 w_n43_n43.n57 w_n43_n43.n8 585
R261 w_n43_n43.n56 w_n43_n43.n55 585
R262 w_n43_n43.n2 w_n43_n43.n0 585
R263 w_n43_n43.n65 w_n43_n43.n64 585
R264 w_n43_n43.n62 w_n43_n43.n1 585
R265 w_n43_n43.n61 w_n43_n43.n60 585
R266 w_n43_n43.n61 w_n43_n43.n5 585
R267 w_n43_n43.n6 w_n43_n43.n4 585
R268 w_n43_n43.n47 w_n43_n43.n4 585
R269 w_n43_n43.n50 w_n43_n43.n49 585
R270 w_n43_n43.n49 w_n43_n43.n48 585
R271 w_n43_n43.n12 w_n43_n43.n11 585
R272 w_n43_n43.n46 w_n43_n43.n12 585
R273 w_n43_n43.n44 w_n43_n43.n43 585
R274 w_n43_n43.n45 w_n43_n43.n44 585
R275 w_n43_n43.n15 w_n43_n43.n14 585
R276 w_n43_n43.n14 w_n43_n43.n13 585
R277 w_n43_n43.n37 w_n43_n43.n36 585
R278 w_n43_n43.n36 w_n43_n43.n35 585
R279 w_n43_n43.n20 w_n43_n43.n19 585
R280 w_n43_n43.n34 w_n43_n43.n20 585
R281 w_n43_n43.n60 w_n43_n43.n6 523.077
R282 w_n43_n43.n50 w_n43_n43.n6 523.077
R283 w_n43_n43.n50 w_n43_n43.n11 523.077
R284 w_n43_n43.n43 w_n43_n43.n11 523.077
R285 w_n43_n43.n43 w_n43_n43.n15 523.077
R286 w_n43_n43.n37 w_n43_n43.n15 523.077
R287 w_n43_n43.n37 w_n43_n43.n19 523.077
R288 w_n43_n43.n61 w_n43_n43.n4 394
R289 w_n43_n43.n49 w_n43_n43.n4 394
R290 w_n43_n43.n49 w_n43_n43.n12 394
R291 w_n43_n43.n44 w_n43_n43.n12 394
R292 w_n43_n43.n44 w_n43_n43.n14 394
R293 w_n43_n43.n36 w_n43_n43.n14 394
R294 w_n43_n43.n36 w_n43_n43.n20 394
R295 w_n43_n43.n64 w_n43_n43.n2 394
R296 w_n43_n43.n55 w_n43_n43.n8 394
R297 w_n43_n43.n59 w_n43_n43.n7 394
R298 w_n43_n43.n51 w_n43_n43.n7 394
R299 w_n43_n43.n51 w_n43_n43.n10 394
R300 w_n43_n43.n42 w_n43_n43.n10 394
R301 w_n43_n43.n42 w_n43_n43.n16 394
R302 w_n43_n43.n38 w_n43_n43.n16 394
R303 w_n43_n43.n38 w_n43_n43.n18 394
R304 w_n43_n43.n32 w_n43_n43.n22 394
R305 w_n43_n43.n29 w_n43_n43.n24 394
R306 w_n43_n43.n3 B 330.769
R307 w_n43_n43.n31 w_n43_n43.n30 218.815
R308 w_n43_n43.n31 w_n43_n43.n23 218.815
R309 w_n43_n43.n54 w_n43_n43.n3 218.815
R310 w_n43_n43.n63 w_n43_n43.n3 218.815
R311 w_n43_n43.n30 w_n43_n43.n22 147.374
R312 w_n43_n43.n24 w_n43_n43.n23 147.374
R313 w_n43_n43.n55 w_n43_n43.n54 147.374
R314 w_n43_n43.n64 w_n43_n43.n63 147.374
R315 w_n43_n43.n63 w_n43_n43.n62 147.374
R316 w_n43_n43.n54 w_n43_n43.n2 147.374
R317 w_n43_n43.n30 w_n43_n43.n29 147.374
R318 w_n43_n43.n25 w_n43_n43.n23 147.374
R319 w_n43_n43.n5 w_n43_n43.n1 78.6829
R320 w_n43_n43.n58 w_n43_n43.n57 78.6829
R321 w_n43_n43.n34 w_n43_n43.n33 78.6829
R322 w_n43_n43.n26 w_n43_n43.n17 78.6829
R323 w_n43_n43.n47 w_n43_n43.n5 25.6005
R324 w_n43_n43.n48 w_n43_n43.n47 25.6005
R325 w_n43_n43.n48 w_n43_n43.n46 25.6005
R326 w_n43_n43.n46 w_n43_n43.n45 25.6005
R327 w_n43_n43.n45 w_n43_n43.n13 25.6005
R328 w_n43_n43.n35 w_n43_n43.n13 25.6005
R329 w_n43_n43.n35 w_n43_n43.n34 25.6005
R330 w_n43_n43.n65 w_n43_n43.n1 25.6005
R331 w_n43_n43.n56 w_n43_n43.n0 25.6005
R332 w_n43_n43.n57 w_n43_n43.n56 25.6005
R333 w_n43_n43.n58 w_n43_n43.n53 25.6005
R334 w_n43_n43.n53 w_n43_n43.n52 25.6005
R335 w_n43_n43.n52 w_n43_n43.n9 25.6005
R336 w_n43_n43.n41 w_n43_n43.n9 25.6005
R337 w_n43_n43.n41 w_n43_n43.n40 25.6005
R338 w_n43_n43.n40 w_n43_n43.n39 25.6005
R339 w_n43_n43.n39 w_n43_n43.n17 25.6005
R340 w_n43_n43.n33 w_n43_n43.n21 25.6005
R341 w_n43_n43.n28 w_n43_n43.n21 25.6005
R342 w_n43_n43.n28 w_n43_n43.n27 25.6005
R343 w_n43_n43.n27 w_n43_n43.n26 25.6005
R344 B w_n43_n43.n65 19.2005
R345 B w_n43_n43.n0 6.4005
C3 B.n0 B 0 ; **FLOATING
C4 B.n3 B 0 ; **FLOATING
C5 B.n4 B 0 ; **FLOATING
C6 B.n5 B 0 ; **FLOATING
C7 B.n6 B 0 ; **FLOATING
C8 B.n7 B 0 ; **FLOATING
C9 B.n8 B 0 ; **FLOATING
C10 B.n9 B 0 ; **FLOATING
C11 B.n10 B 0 ; **FLOATING
C12 B.n11 B 0 ; **FLOATING
C13 B.n12 B 0 ; **FLOATING
C14 B.n13 B 0 ; **FLOATING
C15 B.n14 B 0 ; **FLOATING
C16 B.n15 B 0 ; **FLOATING
C17 B.n16 B 0 ; **FLOATING
C18 B.n17 B 0 ; **FLOATING
C19 B.n18 B 0 ; **FLOATING
C20 B.n19 B 0 ; **FLOATING
C21 B.n20 B 0 ; **FLOATING
C22 B.n21 B 0 ; **FLOATING
C23 B.n22 B 0 ; **FLOATING
C24 B.n23 B 0 ; **FLOATING
C25 B.n24 B 0 ; **FLOATING
C26 B.n26 B 0 ; **FLOATING
C27 B.n27 B 0 ; **FLOATING
C28 B.n29 B 0 ; **FLOATING
C29 B.n30 B 0 ; **FLOATING
C30 B.n31 B 0 ; **FLOATING
C31 B.n32 B 0 ; **FLOATING
C32 B.n33 B 0 ; **FLOATING
C33 B.n34 B 0 ; **FLOATING
C34 B.n35 B 0 ; **FLOATING
C35 B.n36 B 0 ; **FLOATING
C36 B.n37 B 0 ; **FLOATING
C37 B.n38 B 0 ; **FLOATING
C38 B.n39 B 0 ; **FLOATING
C39 B.n40 B 0 ; **FLOATING
C40 B.n41 B 0 ; **FLOATING
C41 B.n42 B 0 ; **FLOATING
C42 B.n43 B 0 ; **FLOATING
C43 B.n44 B 0 ; **FLOATING
C44 B.n45 B 0 ; **FLOATING
C45 B.n46 B 0 ; **FLOATING
C46 B.n47 B 0 ; **FLOATING
C47 B.n48 B 0 ; **FLOATING
C48 B.n49 B 0 ; **FLOATING
C49 B.n50 B 0 ; **FLOATING
C50 B.n51 B 0 ; **FLOATING
C51 B.n52 B 0 ; **FLOATING
C52 B.n53 B 0 ; **FLOATING
C53 B.n54 B 0 ; **FLOATING
C54 B.n55 B 0 ; **FLOATING
C55 B.n56 B 0 ; **FLOATING
C56 B.n57 B 0 ; **FLOATING
C57 B.n58 B 0 ; **FLOATING
C58 B.n59 B 0 ; **FLOATING
C59 B.n60 B 0 ; **FLOATING
C60 B.n61 B 0 ; **FLOATING
C61 B.n62 B 0 ; **FLOATING
C62 B.n63 B 0 ; **FLOATING
C63 B.n64 B 0 ; **FLOATING
C64 B.n65 B 0 ; **FLOATING
C65 S B 0.21431f
C66 D B 0.21431f
C67 G B 0.55742f
