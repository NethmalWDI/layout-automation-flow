* NGSPICE file created from nfet_01v8_lvt_W1p2_L0p2_m6__nf1_gtop_sdhalf.ext - technology: sky130A

.subckt sky130_fd_pr__nfet_01v8_lvt_YKZE7F G D B S
X0 S G D B sky130_fd_pr__nfet_01v8_lvt ad=0.348 pd=2.98 as=0.348 ps=2.98 w=1.2 l=0.2
.ends

.subckt nfet_01v8_lvt_W1p2_L0p2_m6__nf1_gtop_sdhalf D S G B
Xnfet_01v8_lvt_W1p2_L0p2_m6__nf1_gtop_sdhalf_pc G D B S sky130_fd_pr__nfet_01v8_lvt_YKZE7F
.ends
