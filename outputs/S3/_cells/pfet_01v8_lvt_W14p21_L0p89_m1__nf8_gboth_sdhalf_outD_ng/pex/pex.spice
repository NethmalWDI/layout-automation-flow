* NGSPICE file created from pfet_01v8_lvt_W14p21_L0p89_m1__nf8_gboth_sdhalf_outD_ng.ext - technology: sky130A

.subckt pfet_01v8_lvt_W14p21_L0p89_m1__nf8_gboth_sdhalf_outD_ng S D G B
X0 S G D B sky130_fd_pr__pfet_01v8_lvt ad=0.2581 pd=2.07 as=0.2581 ps=2.07 w=1.78 l=0.89
X1 D G S B sky130_fd_pr__pfet_01v8_lvt ad=0.5162 pd=4.14 as=0.2581 ps=2.07 w=1.78 l=0.89
X2 S G D B sky130_fd_pr__pfet_01v8_lvt ad=0.2581 pd=2.07 as=0.2581 ps=2.07 w=1.78 l=0.89
X3 D G S B sky130_fd_pr__pfet_01v8_lvt ad=0.2581 pd=2.07 as=0.2581 ps=2.07 w=1.78 l=0.89
X4 S G D B sky130_fd_pr__pfet_01v8_lvt ad=0.2581 pd=2.07 as=0.2581 ps=2.07 w=1.78 l=0.89
X5 D G S B sky130_fd_pr__pfet_01v8_lvt ad=0.2581 pd=2.07 as=0.2581 ps=2.07 w=1.78 l=0.89
X6 S G D B sky130_fd_pr__pfet_01v8_lvt ad=0.2581 pd=2.07 as=0.5162 ps=4.14 w=1.78 l=0.89
X7 D G S B sky130_fd_pr__pfet_01v8_lvt ad=0.2581 pd=2.07 as=0.2581 ps=2.07 w=1.78 l=0.89
C0 G B 1.33057f
C1 B D 0.1098f
C2 G D 0.79258f
C3 B S 0.09081f
C4 G S 0.79599f
C5 D S 1.12585f
C6 S VSUBS 0.30054f
C7 D VSUBS 0.46072f
C8 G VSUBS 2.31385f
C9 B VSUBS 3.36602f
.ends
