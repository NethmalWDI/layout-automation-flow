* NGSPICE file created from nfet_01v8_lvt_W5_L20_m2__nf2_gtop_sdhalf_outD_ng.ext - technology: sky130A

.subckt nfet_01v8_lvt_W5_L20_m2__nf2_gtop_sdhalf_outD_ng S D G B
X0 S G D B sky130_fd_pr__nfet_01v8_lvt ad=0.3625 pd=2.79 as=0.725 ps=5.58 w=2.5 l=20
X1 D G S B sky130_fd_pr__nfet_01v8_lvt ad=0.725 pd=5.58 as=0.3625 ps=2.79 w=2.5 l=20
C0 S G 1.64413f
C1 D G 1.3179f
C2 D S 1.33056f
C3 S B 1.18372f
C4 D B 1.14494f
C5 G B 11.27173f
.ends
