* NGSPICE file created from pfet_01v8_lvt_W887p03_L0p74_m1__nf8_gboth_sdfull_outD_ng.ext - technology: sky130A

.subckt sky130_fd_pr__pfet_01v8_lvt_MJS98J G D6 w_n889_n11188# D4 D2 D0 a_795_n11088#
+ S7 S5 S3 S1
X0 S5 G D4 w_n889_n11188# sky130_fd_pr__pfet_01v8_lvt ad=16.0776 pd=111.17 as=16.0776 ps=111.17 w=110.88 l=0.74
X1 a_795_n11088# G S7 w_n889_n11188# sky130_fd_pr__pfet_01v8_lvt ad=32.1552 pd=222.34 as=16.0776 ps=111.17 w=110.88 l=0.74
X2 S3 G D2 w_n889_n11188# sky130_fd_pr__pfet_01v8_lvt ad=16.0776 pd=111.17 as=16.0776 ps=111.17 w=110.88 l=0.74
X3 D4 G S3 w_n889_n11188# sky130_fd_pr__pfet_01v8_lvt ad=16.0776 pd=111.17 as=16.0776 ps=111.17 w=110.88 l=0.74
X4 S1 G D0 w_n889_n11188# sky130_fd_pr__pfet_01v8_lvt ad=16.0776 pd=111.17 as=32.1552 ps=222.34 w=110.88 l=0.74
X5 S7 G D6 w_n889_n11188# sky130_fd_pr__pfet_01v8_lvt ad=16.0776 pd=111.17 as=16.0776 ps=111.17 w=110.88 l=0.74
X6 D2 G S1 w_n889_n11188# sky130_fd_pr__pfet_01v8_lvt ad=16.0776 pd=111.17 as=16.0776 ps=111.17 w=110.88 l=0.74
X7 D6 G S5 w_n889_n11188# sky130_fd_pr__pfet_01v8_lvt ad=16.0776 pd=111.17 as=16.0776 ps=111.17 w=110.88 l=0.74
.ends

.subckt pfet_01v8_lvt_W887p03_L0p74_m1__nf8_gboth_sdfull_outD_ng S D G B
Xpfet_01v8_lvt_W887p03_L0p74_m1__nf8_gboth_sdfull_outD_ng_pc G D B D D D D S S S S
+ sky130_fd_pr__pfet_01v8_lvt_MJS98J
.ends
