.subckt nfet_01v8_lvt_W10_L1_m2__nf4_gtop_sdfull_outD D G S B
Xnfet_01v8_lvt_W10_L1_m2__nf4_gtop_sdfull_outD D G S B sky130_fd_pr__nfet_01v8_lvt L=1.1 W=10 nf=4
.ends
