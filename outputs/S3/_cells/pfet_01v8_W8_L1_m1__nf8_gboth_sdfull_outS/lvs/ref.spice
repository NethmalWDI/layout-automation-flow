.subckt pfet_01v8_W8_L1_m1__nf8_gboth_sdfull_outS D G S B
Xpfet_01v8_W8_L1_m1__nf8_gboth_sdfull_outS D G S B sky130_fd_pr__pfet_01v8 L=1 W=8 nf=8
.ends
