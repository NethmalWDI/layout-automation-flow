* NGSPICE file created from pfet_01v8_lvt_W14p21_L0p89_m1__nf4_gtop_sdfull_outD_ng.ext - technology: sky130A

.subckt sky130_fd_pr__pfet_01v8_lvt_BMWRT6 G D2 D0 S3 w_n537_n453# S1 a_443_n391#
X0 S1 G D0 w_n537_n453# sky130_fd_pr__pfet_01v8_lvt ad=0.51475 pd=3.84 as=1.0295 ps=7.68 w=3.55 l=0.89
X1 a_443_n391# G S3 w_n537_n453# sky130_fd_pr__pfet_01v8_lvt ad=1.0295 pd=7.68 as=0.51475 ps=3.84 w=3.55 l=0.89
X2 S3 G D2 w_n537_n453# sky130_fd_pr__pfet_01v8_lvt ad=0.51475 pd=3.84 as=0.51475 ps=3.84 w=3.55 l=0.89
X3 D2 G S1 w_n537_n453# sky130_fd_pr__pfet_01v8_lvt ad=0.51475 pd=3.84 as=0.51475 ps=3.84 w=3.55 l=0.89
.ends

.subckt pfet_01v8_lvt_W14p21_L0p89_m1__nf4_gtop_sdfull_outD_ng S D G B
Xpfet_01v8_lvt_W14p21_L0p89_m1__nf4_gtop_sdfull_outD_ng_pc G D D S B S D sky130_fd_pr__pfet_01v8_lvt_BMWRT6
.ends
