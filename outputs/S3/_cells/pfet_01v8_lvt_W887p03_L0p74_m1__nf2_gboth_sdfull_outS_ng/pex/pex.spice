* NGSPICE file created from pfet_01v8_lvt_W887p03_L0p74_m1__nf2_gboth_sdfull_outS_ng.ext - technology: sky130A

.subckt pfet_01v8_lvt_W887p03_L0p74_m1__nf2_gboth_sdfull_outS_ng S D G B
X0 S G D B sky130_fd_pr__pfet_01v8_lvt ad=128.6208 pd=887.62 as=64.3104 ps=443.81 w=443.51999 l=0.74
X1 D G S B sky130_fd_pr__pfet_01v8_lvt ad=64.3104 pd=443.81 as=128.6208 ps=887.62 w=443.51999 l=0.74
C0 S G 40.93949f
C1 D G 40.93687f
C2 S B 15.48846f
C3 D B 9.59599f
C4 G B 0.33131f
C5 D S 33.17421f
C6 S VSUBS 62.35909f
C7 G VSUBS 0.62543f
C8 B VSUBS 0.13932p
.ends
