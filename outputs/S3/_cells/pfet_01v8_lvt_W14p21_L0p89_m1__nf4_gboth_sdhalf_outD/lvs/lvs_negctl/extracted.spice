* NGSPICE file created from pfet_01v8_lvt_W14p21_L0p89_m1__nf4_gboth_sdhalf_outD.ext - technology: sky130A

.subckt sky130_fd_pr__pfet_01v8_lvt_37QT9V G B D2 D0 S3 a_443_n355# S1
X0 S3 G D2 B sky130_fd_pr__pfet_01v8_lvt ad=0.51475 pd=3.84 as=0.51475 ps=3.84 w=3.55 l=0.89
X1 D2 G S1 B sky130_fd_pr__pfet_01v8_lvt ad=0.51475 pd=3.84 as=0.51475 ps=3.84 w=3.55 l=0.89
X2 S1 G D0 B sky130_fd_pr__pfet_01v8_lvt ad=0.51475 pd=3.84 as=1.0295 ps=7.68 w=3.55 l=0.89
X3 a_443_n355# G S3 B sky130_fd_pr__pfet_01v8_lvt ad=1.0295 pd=7.68 as=0.51475 ps=3.84 w=3.55 l=0.89
.ends

.subckt pfet_01v8_lvt_W14p21_L0p89_m1__nf4_gboth_sdhalf_outD S D G B
Xpfet_01v8_lvt_W14p21_L0p89_m1__nf4_gboth_sdhalf_outD_pc G B D D S D S sky130_fd_pr__pfet_01v8_lvt_37QT9V
.ends
