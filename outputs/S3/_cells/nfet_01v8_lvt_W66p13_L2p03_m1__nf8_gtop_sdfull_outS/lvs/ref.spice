.subckt nfet_01v8_lvt_W66p13_L2p03_m1__nf8_gtop_sdfull_outS D G S B
Xnfet_01v8_lvt_W66p13_L2p03_m1__nf8_gtop_sdfull_outS D G S B sky130_fd_pr__nfet_01v8_lvt L=2.03 W=66.13 nf=8
.ends
