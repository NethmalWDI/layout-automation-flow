* NGSPICE file created from nfet_01v8_lvt_W5_L20_m2__nf1_gtop_sdfull_ng.ext - technology: sky130A

.subckt sky130_fd_pr__nfet_01v8_lvt_287V9Q G D S VSUBS
X0 S G D VSUBS sky130_fd_pr__nfet_01v8_lvt ad=1.45 pd=10.58 as=1.45 ps=10.58 w=5 l=20
.ends

.subckt nfet_01v8_lvt_W5_L20_m2__nf1_gtop_sdfull_ng D S G B
Xnfet_01v8_lvt_W5_L20_m2__nf1_gtop_sdfull_ng_pc G D S B sky130_fd_pr__nfet_01v8_lvt_287V9Q
.ends
