* NGSPICE file created from pfet_01v8_lvt_W90p63_L0p74_m1__nf2_gboth_sdhalf_outD_ng.ext - technology: sky130A

.subckt pfet_01v8_lvt_W90p63_L0p74_m1__nf2_gboth_sdhalf_outD_ng S D G B
X0 D G S B sky130_fd_pr__pfet_01v8_lvt ad=13.1428 pd=91.22 as=6.5714 ps=45.61 w=45.32 l=0.74
X1 S G D B sky130_fd_pr__pfet_01v8_lvt ad=6.5714 pd=45.61 as=13.1428 ps=91.22 w=45.32 l=0.74
C0 G S 2.24434f
C1 B S 0.48445f
C2 G B 0.33175f
C3 S D 1.86099f
C4 G D 2.24435f
C5 B D 0.78535f
C6 S VSUBS 0.04802f
C7 D VSUBS 3.23616f
C8 G VSUBS 0.63421f
C9 B VSUBS 8.2341f
.ends
