* NGSPICE file created from nfet_01v8_lvt_W4_L4_m2__nf4_gboth_sdfull_outS_ng.ext - technology: sky130A

.subckt sky130_fd_pr__nfet_01v8_lvt_4XRYMB G a_1687_n100# D2 D0 S3 S1 VSUBS
X0 S1 G D0 VSUBS sky130_fd_pr__nfet_01v8_lvt ad=0.145 pd=1.29 as=0.29 ps=2.58 w=1 l=4
X1 S3 G D2 VSUBS sky130_fd_pr__nfet_01v8_lvt ad=0.145 pd=1.29 as=0.145 ps=1.29 w=1 l=4
X2 D2 G S1 VSUBS sky130_fd_pr__nfet_01v8_lvt ad=0.145 pd=1.29 as=0.145 ps=1.29 w=1 l=4
X3 a_1687_n100# G S3 VSUBS sky130_fd_pr__nfet_01v8_lvt ad=0.29 pd=2.58 as=0.145 ps=1.29 w=1 l=4
.ends

.subckt nfet_01v8_lvt_W4_L4_m2__nf4_gboth_sdfull_outS_ng S D G B
Xnfet_01v8_lvt_W4_L4_m2__nf4_gboth_sdfull_outS_ng_pc G S S S D D B sky130_fd_pr__nfet_01v8_lvt_4XRYMB
.ends
