* NGSPICE file created from pfet_01v8_lvt_W887p03_L0p74_m1__nf2_gboth_sdfull_outS.ext - technology: sky130A

.subckt pfet_01v8_lvt_W887p03_L0p74_m1__nf2_gboth_sdfull_outS S D G B
X0 S G D B sky130_fd_pr__pfet_01v8_lvt ad=128.6208 pd=887.62 as=64.3104 ps=443.81 w=443.51999 l=0.74
X1 D G S B sky130_fd_pr__pfet_01v8_lvt ad=64.3104 pd=443.81 as=128.6208 ps=887.62 w=443.51999 l=0.74
C0 S B 51.30702f
C1 B G 0.70212f
C2 S G 40.93949f
C3 B D 9.614f
C4 S D 33.17421f
C5 G D 40.93687f
C6 S VSUBS 23.72383f
C7 G VSUBS 0.28742f
C8 B VSUBS 0.23198p
.ends
