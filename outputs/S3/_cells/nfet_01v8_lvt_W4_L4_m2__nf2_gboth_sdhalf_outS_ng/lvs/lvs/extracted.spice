* NGSPICE file created from nfet_01v8_lvt_W4_L4_m2__nf2_gboth_sdhalf_outS_ng.ext - technology: sky130A

.subckt sky130_fd_pr__nfet_01v8_lvt_A4AKJU G D0 S1 a_829_n200# VSUBS
X0 a_829_n200# G S1 VSUBS sky130_fd_pr__nfet_01v8_lvt ad=0.58 pd=4.58 as=0.29 ps=2.29 w=2 l=4
X1 S1 G D0 VSUBS sky130_fd_pr__nfet_01v8_lvt ad=0.29 pd=2.29 as=0.58 ps=4.58 w=2 l=4
.ends

.subckt nfet_01v8_lvt_W4_L4_m2__nf2_gboth_sdhalf_outS_ng S D G B
Xnfet_01v8_lvt_W4_L4_m2__nf2_gboth_sdhalf_outS_ng_pc G S D S B sky130_fd_pr__nfet_01v8_lvt_A4AKJU
.ends
