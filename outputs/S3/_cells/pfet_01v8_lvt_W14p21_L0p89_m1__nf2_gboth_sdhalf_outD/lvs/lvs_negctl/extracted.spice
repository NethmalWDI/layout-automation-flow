* NGSPICE file created from pfet_01v8_lvt_W14p21_L0p89_m1__nf2_gboth_sdhalf_outD.ext - technology: sky130A

.subckt sky130_fd_pr__pfet_01v8_lvt_YXK2ZV G B D0 a_207_n711# S1
X0 a_207_n711# G S1 B sky130_fd_pr__pfet_01v8_lvt ad=2.0619 pd=14.8 as=1.03095 ps=7.4 w=7.11 l=0.89
X1 S1 G D0 B sky130_fd_pr__pfet_01v8_lvt ad=1.03095 pd=7.4 as=2.0619 ps=14.8 w=7.11 l=0.89
.ends

.subckt pfet_01v8_lvt_W14p21_L0p89_m1__nf2_gboth_sdhalf_outD S D G B
Xpfet_01v8_lvt_W14p21_L0p89_m1__nf2_gboth_sdhalf_outD_pc G B D D S sky130_fd_pr__pfet_01v8_lvt_YXK2ZV
.ends
