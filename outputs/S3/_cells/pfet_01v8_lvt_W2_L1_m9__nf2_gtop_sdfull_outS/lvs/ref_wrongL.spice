.subckt pfet_01v8_lvt_W2_L1_m9__nf2_gtop_sdfull_outS D G S B
Xpfet_01v8_lvt_W2_L1_m9__nf2_gtop_sdfull_outS D G S B sky130_fd_pr__pfet_01v8_lvt L=1.1 W=2 nf=2
.ends
