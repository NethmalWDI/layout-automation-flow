* NGSPICE file created from pfet_01v8_lvt_W37p3_L0p74_m1__nf2_gboth_sdhalf_outS.ext - technology: sky130A

.subckt pfet_01v8_lvt_W37p3_L0p74_m1__nf2_gboth_sdhalf_outS S D G B
X0 S G D B sky130_fd_pr__pfet_01v8_lvt ad=5.4085 pd=37.88 as=2.70425 ps=18.94 w=18.65 l=0.74
X1 D G S B sky130_fd_pr__pfet_01v8_lvt ad=2.70425 pd=18.94 as=5.4085 ps=37.88 w=18.65 l=0.74
C0 S B 1.25114f
C1 G B 0.96078f
C2 D S 0.86428f
C3 G D 1.01527f
C4 G S 1.01528f
C5 D B 0.24642f
C6 D VSUBS 0.05169f
C7 S VSUBS 0.54379f
C8 G VSUBS 0.28742f
C9 B VSUBS 10.6479f
.ends
