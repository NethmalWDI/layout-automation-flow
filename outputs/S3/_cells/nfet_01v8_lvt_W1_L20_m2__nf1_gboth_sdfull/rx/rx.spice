* NGSPICE file created from nfet_01v8_lvt_W1_L20_m2__nf1_gboth_sdfull.ext - technology: sky130A

X0 S G D nfet_01v8_lvt_W1_L20_m2__nf1_gboth_sdfull_pc/B.t0 sky130_fd_pr__nfet_01v8_lvt ad=0.29 pd=2.58 as=0.29 ps=2.58 w=1 l=20
C0 S G 0.08977f
C1 D G 0.08977f
R0 nfet_01v8_lvt_W1_L20_m2__nf1_gboth_sdfull_pc/B.n259 nfet_01v8_lvt_W1_L20_m2__nf1_gboth_sdfull_pc/B.n258 1199.38
R1 nfet_01v8_lvt_W1_L20_m2__nf1_gboth_sdfull_pc/B.n78 nfet_01v8_lvt_W1_L20_m2__nf1_gboth_sdfull_pc/B.n66 1199.38
R2 nfet_01v8_lvt_W1_L20_m2__nf1_gboth_sdfull_pc/B.n266 nfet_01v8_lvt_W1_L20_m2__nf1_gboth_sdfull_pc/B.n219 1199.38
R3 nfet_01v8_lvt_W1_L20_m2__nf1_gboth_sdfull_pc/B.n75 nfet_01v8_lvt_W1_L20_m2__nf1_gboth_sdfull_pc/B.n64 1199.38
R4 nfet_01v8_lvt_W1_L20_m2__nf1_gboth_sdfull_pc/B.n264 nfet_01v8_lvt_W1_L20_m2__nf1_gboth_sdfull_pc/B.n218 755.333
R5 nfet_01v8_lvt_W1_L20_m2__nf1_gboth_sdfull_pc/B.n76 nfet_01v8_lvt_W1_L20_m2__nf1_gboth_sdfull_pc/B.n65 755.333
R6 nfet_01v8_lvt_W1_L20_m2__nf1_gboth_sdfull_pc/B.n219 nfet_01v8_lvt_W1_L20_m2__nf1_gboth_sdfull_pc/B.n218 585
R7 nfet_01v8_lvt_W1_L20_m2__nf1_gboth_sdfull_pc/B.n268 nfet_01v8_lvt_W1_L20_m2__nf1_gboth_sdfull_pc/B.n219 585
R8 nfet_01v8_lvt_W1_L20_m2__nf1_gboth_sdfull_pc/B.n271 nfet_01v8_lvt_W1_L20_m2__nf1_gboth_sdfull_pc/B.n270 585
R9 nfet_01v8_lvt_W1_L20_m2__nf1_gboth_sdfull_pc/B.n270 nfet_01v8_lvt_W1_L20_m2__nf1_gboth_sdfull_pc/B.n269 585
R10 nfet_01v8_lvt_W1_L20_m2__nf1_gboth_sdfull_pc/B.n272 nfet_01v8_lvt_W1_L20_m2__nf1_gboth_sdfull_pc/B.n214 585
R11 nfet_01v8_lvt_W1_L20_m2__nf1_gboth_sdfull_pc/B.n214 nfet_01v8_lvt_W1_L20_m2__nf1_gboth_sdfull_pc/B.n213 585
R12 nfet_01v8_lvt_W1_L20_m2__nf1_gboth_sdfull_pc/B.n274 nfet_01v8_lvt_W1_L20_m2__nf1_gboth_sdfull_pc/B.n273 585
R13 nfet_01v8_lvt_W1_L20_m2__nf1_gboth_sdfull_pc/B.n275 nfet_01v8_lvt_W1_L20_m2__nf1_gboth_sdfull_pc/B.n274 585
R14 nfet_01v8_lvt_W1_L20_m2__nf1_gboth_sdfull_pc/B.n212 nfet_01v8_lvt_W1_L20_m2__nf1_gboth_sdfull_pc/B.n211 585
R15 nfet_01v8_lvt_W1_L20_m2__nf1_gboth_sdfull_pc/B.n276 nfet_01v8_lvt_W1_L20_m2__nf1_gboth_sdfull_pc/B.n212 585
R16 nfet_01v8_lvt_W1_L20_m2__nf1_gboth_sdfull_pc/B.n279 nfet_01v8_lvt_W1_L20_m2__nf1_gboth_sdfull_pc/B.n278 585
R17 nfet_01v8_lvt_W1_L20_m2__nf1_gboth_sdfull_pc/B.n278 nfet_01v8_lvt_W1_L20_m2__nf1_gboth_sdfull_pc/B.n277 585
R18 nfet_01v8_lvt_W1_L20_m2__nf1_gboth_sdfull_pc/B.n280 nfet_01v8_lvt_W1_L20_m2__nf1_gboth_sdfull_pc/B.n207 585
R19 nfet_01v8_lvt_W1_L20_m2__nf1_gboth_sdfull_pc/B.n207 nfet_01v8_lvt_W1_L20_m2__nf1_gboth_sdfull_pc/B.n206 585
R20 nfet_01v8_lvt_W1_L20_m2__nf1_gboth_sdfull_pc/B.n282 nfet_01v8_lvt_W1_L20_m2__nf1_gboth_sdfull_pc/B.n281 585
R21 nfet_01v8_lvt_W1_L20_m2__nf1_gboth_sdfull_pc/B.n283 nfet_01v8_lvt_W1_L20_m2__nf1_gboth_sdfull_pc/B.n282 585
R22 nfet_01v8_lvt_W1_L20_m2__nf1_gboth_sdfull_pc/B.n205 nfet_01v8_lvt_W1_L20_m2__nf1_gboth_sdfull_pc/B.n204 585
R23 nfet_01v8_lvt_W1_L20_m2__nf1_gboth_sdfull_pc/B.n284 nfet_01v8_lvt_W1_L20_m2__nf1_gboth_sdfull_pc/B.n205 585
R24 nfet_01v8_lvt_W1_L20_m2__nf1_gboth_sdfull_pc/B.n287 nfet_01v8_lvt_W1_L20_m2__nf1_gboth_sdfull_pc/B.n286 585
R25 nfet_01v8_lvt_W1_L20_m2__nf1_gboth_sdfull_pc/B.n286 nfet_01v8_lvt_W1_L20_m2__nf1_gboth_sdfull_pc/B.n285 585
R26 nfet_01v8_lvt_W1_L20_m2__nf1_gboth_sdfull_pc/B.n288 nfet_01v8_lvt_W1_L20_m2__nf1_gboth_sdfull_pc/B.n200 585
R27 nfet_01v8_lvt_W1_L20_m2__nf1_gboth_sdfull_pc/B.n200 nfet_01v8_lvt_W1_L20_m2__nf1_gboth_sdfull_pc/B.n199 585
R28 nfet_01v8_lvt_W1_L20_m2__nf1_gboth_sdfull_pc/B.n290 nfet_01v8_lvt_W1_L20_m2__nf1_gboth_sdfull_pc/B.n289 585
R29 nfet_01v8_lvt_W1_L20_m2__nf1_gboth_sdfull_pc/B.n291 nfet_01v8_lvt_W1_L20_m2__nf1_gboth_sdfull_pc/B.n290 585
R30 nfet_01v8_lvt_W1_L20_m2__nf1_gboth_sdfull_pc/B.n198 nfet_01v8_lvt_W1_L20_m2__nf1_gboth_sdfull_pc/B.n197 585
R31 nfet_01v8_lvt_W1_L20_m2__nf1_gboth_sdfull_pc/B.n292 nfet_01v8_lvt_W1_L20_m2__nf1_gboth_sdfull_pc/B.n198 585
R32 nfet_01v8_lvt_W1_L20_m2__nf1_gboth_sdfull_pc/B.n295 nfet_01v8_lvt_W1_L20_m2__nf1_gboth_sdfull_pc/B.n294 585
R33 nfet_01v8_lvt_W1_L20_m2__nf1_gboth_sdfull_pc/B.n294 nfet_01v8_lvt_W1_L20_m2__nf1_gboth_sdfull_pc/B.n293 585
R34 nfet_01v8_lvt_W1_L20_m2__nf1_gboth_sdfull_pc/B.n296 nfet_01v8_lvt_W1_L20_m2__nf1_gboth_sdfull_pc/B.n193 585
R35 nfet_01v8_lvt_W1_L20_m2__nf1_gboth_sdfull_pc/B.n193 nfet_01v8_lvt_W1_L20_m2__nf1_gboth_sdfull_pc/B.n192 585
R36 nfet_01v8_lvt_W1_L20_m2__nf1_gboth_sdfull_pc/B.n298 nfet_01v8_lvt_W1_L20_m2__nf1_gboth_sdfull_pc/B.n297 585
R37 nfet_01v8_lvt_W1_L20_m2__nf1_gboth_sdfull_pc/B.n299 nfet_01v8_lvt_W1_L20_m2__nf1_gboth_sdfull_pc/B.n298 585
R38 nfet_01v8_lvt_W1_L20_m2__nf1_gboth_sdfull_pc/B.n191 nfet_01v8_lvt_W1_L20_m2__nf1_gboth_sdfull_pc/B.n190 585
R39 nfet_01v8_lvt_W1_L20_m2__nf1_gboth_sdfull_pc/B.n300 nfet_01v8_lvt_W1_L20_m2__nf1_gboth_sdfull_pc/B.n191 585
R40 nfet_01v8_lvt_W1_L20_m2__nf1_gboth_sdfull_pc/B.n303 nfet_01v8_lvt_W1_L20_m2__nf1_gboth_sdfull_pc/B.n302 585
R41 nfet_01v8_lvt_W1_L20_m2__nf1_gboth_sdfull_pc/B.n302 nfet_01v8_lvt_W1_L20_m2__nf1_gboth_sdfull_pc/B.n301 585
R42 nfet_01v8_lvt_W1_L20_m2__nf1_gboth_sdfull_pc/B.n304 nfet_01v8_lvt_W1_L20_m2__nf1_gboth_sdfull_pc/B.n186 585
R43 nfet_01v8_lvt_W1_L20_m2__nf1_gboth_sdfull_pc/B.n186 nfet_01v8_lvt_W1_L20_m2__nf1_gboth_sdfull_pc/B.n185 585
R44 nfet_01v8_lvt_W1_L20_m2__nf1_gboth_sdfull_pc/B.n306 nfet_01v8_lvt_W1_L20_m2__nf1_gboth_sdfull_pc/B.n305 585
R45 nfet_01v8_lvt_W1_L20_m2__nf1_gboth_sdfull_pc/B.n307 nfet_01v8_lvt_W1_L20_m2__nf1_gboth_sdfull_pc/B.n306 585
R46 nfet_01v8_lvt_W1_L20_m2__nf1_gboth_sdfull_pc/B.n184 nfet_01v8_lvt_W1_L20_m2__nf1_gboth_sdfull_pc/B.n183 585
R47 nfet_01v8_lvt_W1_L20_m2__nf1_gboth_sdfull_pc/B.n308 nfet_01v8_lvt_W1_L20_m2__nf1_gboth_sdfull_pc/B.n184 585
R48 nfet_01v8_lvt_W1_L20_m2__nf1_gboth_sdfull_pc/B.n311 nfet_01v8_lvt_W1_L20_m2__nf1_gboth_sdfull_pc/B.n310 585
R49 nfet_01v8_lvt_W1_L20_m2__nf1_gboth_sdfull_pc/B.n310 nfet_01v8_lvt_W1_L20_m2__nf1_gboth_sdfull_pc/B.n309 585
R50 nfet_01v8_lvt_W1_L20_m2__nf1_gboth_sdfull_pc/B.n312 nfet_01v8_lvt_W1_L20_m2__nf1_gboth_sdfull_pc/B.n179 585
R51 nfet_01v8_lvt_W1_L20_m2__nf1_gboth_sdfull_pc/B.n179 nfet_01v8_lvt_W1_L20_m2__nf1_gboth_sdfull_pc/B.n178 585
R52 nfet_01v8_lvt_W1_L20_m2__nf1_gboth_sdfull_pc/B.n314 nfet_01v8_lvt_W1_L20_m2__nf1_gboth_sdfull_pc/B.n313 585
R53 nfet_01v8_lvt_W1_L20_m2__nf1_gboth_sdfull_pc/B.n315 nfet_01v8_lvt_W1_L20_m2__nf1_gboth_sdfull_pc/B.n314 585
R54 nfet_01v8_lvt_W1_L20_m2__nf1_gboth_sdfull_pc/B.n177 nfet_01v8_lvt_W1_L20_m2__nf1_gboth_sdfull_pc/B.n176 585
R55 nfet_01v8_lvt_W1_L20_m2__nf1_gboth_sdfull_pc/B.n316 nfet_01v8_lvt_W1_L20_m2__nf1_gboth_sdfull_pc/B.n177 585
R56 nfet_01v8_lvt_W1_L20_m2__nf1_gboth_sdfull_pc/B.n319 nfet_01v8_lvt_W1_L20_m2__nf1_gboth_sdfull_pc/B.n318 585
R57 nfet_01v8_lvt_W1_L20_m2__nf1_gboth_sdfull_pc/B.n318 nfet_01v8_lvt_W1_L20_m2__nf1_gboth_sdfull_pc/B.n317 585
R58 nfet_01v8_lvt_W1_L20_m2__nf1_gboth_sdfull_pc/B.n320 nfet_01v8_lvt_W1_L20_m2__nf1_gboth_sdfull_pc/B.n172 585
R59 nfet_01v8_lvt_W1_L20_m2__nf1_gboth_sdfull_pc/B.n172 nfet_01v8_lvt_W1_L20_m2__nf1_gboth_sdfull_pc/B.n171 585
R60 nfet_01v8_lvt_W1_L20_m2__nf1_gboth_sdfull_pc/B.n322 nfet_01v8_lvt_W1_L20_m2__nf1_gboth_sdfull_pc/B.n321 585
R61 nfet_01v8_lvt_W1_L20_m2__nf1_gboth_sdfull_pc/B.n323 nfet_01v8_lvt_W1_L20_m2__nf1_gboth_sdfull_pc/B.n322 585
R62 nfet_01v8_lvt_W1_L20_m2__nf1_gboth_sdfull_pc/B.n6 nfet_01v8_lvt_W1_L20_m2__nf1_gboth_sdfull_pc/B.n4 585
R63 nfet_01v8_lvt_W1_L20_m2__nf1_gboth_sdfull_pc/B.n324 nfet_01v8_lvt_W1_L20_m2__nf1_gboth_sdfull_pc/B.n6 585
R64 nfet_01v8_lvt_W1_L20_m2__nf1_gboth_sdfull_pc/B.n327 nfet_01v8_lvt_W1_L20_m2__nf1_gboth_sdfull_pc/B.n326 585
R65 nfet_01v8_lvt_W1_L20_m2__nf1_gboth_sdfull_pc/B.n326 nfet_01v8_lvt_W1_L20_m2__nf1_gboth_sdfull_pc/B.n325 585
R66 nfet_01v8_lvt_W1_L20_m2__nf1_gboth_sdfull_pc/B.n5 nfet_01v8_lvt_W1_L20_m2__nf1_gboth_sdfull_pc/B.t0 585
R67 nfet_01v8_lvt_W1_L20_m2__nf1_gboth_sdfull_pc/B.n170 nfet_01v8_lvt_W1_L20_m2__nf1_gboth_sdfull_pc/B.n5 585
R68 nfet_01v8_lvt_W1_L20_m2__nf1_gboth_sdfull_pc/B.n168 nfet_01v8_lvt_W1_L20_m2__nf1_gboth_sdfull_pc/B.n167 585
R69 nfet_01v8_lvt_W1_L20_m2__nf1_gboth_sdfull_pc/B.n169 nfet_01v8_lvt_W1_L20_m2__nf1_gboth_sdfull_pc/B.n168 585
R70 nfet_01v8_lvt_W1_L20_m2__nf1_gboth_sdfull_pc/B.n9 nfet_01v8_lvt_W1_L20_m2__nf1_gboth_sdfull_pc/B.n8 585
R71 nfet_01v8_lvt_W1_L20_m2__nf1_gboth_sdfull_pc/B.n8 nfet_01v8_lvt_W1_L20_m2__nf1_gboth_sdfull_pc/B.n7 585
R72 nfet_01v8_lvt_W1_L20_m2__nf1_gboth_sdfull_pc/B.n161 nfet_01v8_lvt_W1_L20_m2__nf1_gboth_sdfull_pc/B.n160 585
R73 nfet_01v8_lvt_W1_L20_m2__nf1_gboth_sdfull_pc/B.n160 nfet_01v8_lvt_W1_L20_m2__nf1_gboth_sdfull_pc/B.n159 585
R74 nfet_01v8_lvt_W1_L20_m2__nf1_gboth_sdfull_pc/B.n14 nfet_01v8_lvt_W1_L20_m2__nf1_gboth_sdfull_pc/B.n13 585
R75 nfet_01v8_lvt_W1_L20_m2__nf1_gboth_sdfull_pc/B.n158 nfet_01v8_lvt_W1_L20_m2__nf1_gboth_sdfull_pc/B.n14 585
R76 nfet_01v8_lvt_W1_L20_m2__nf1_gboth_sdfull_pc/B.n156 nfet_01v8_lvt_W1_L20_m2__nf1_gboth_sdfull_pc/B.n155 585
R77 nfet_01v8_lvt_W1_L20_m2__nf1_gboth_sdfull_pc/B.n157 nfet_01v8_lvt_W1_L20_m2__nf1_gboth_sdfull_pc/B.n156 585
R78 nfet_01v8_lvt_W1_L20_m2__nf1_gboth_sdfull_pc/B.n17 nfet_01v8_lvt_W1_L20_m2__nf1_gboth_sdfull_pc/B.n16 585
R79 nfet_01v8_lvt_W1_L20_m2__nf1_gboth_sdfull_pc/B.n16 nfet_01v8_lvt_W1_L20_m2__nf1_gboth_sdfull_pc/B.n15 585
R80 nfet_01v8_lvt_W1_L20_m2__nf1_gboth_sdfull_pc/B.n149 nfet_01v8_lvt_W1_L20_m2__nf1_gboth_sdfull_pc/B.n148 585
R81 nfet_01v8_lvt_W1_L20_m2__nf1_gboth_sdfull_pc/B.n148 nfet_01v8_lvt_W1_L20_m2__nf1_gboth_sdfull_pc/B.n147 585
R82 nfet_01v8_lvt_W1_L20_m2__nf1_gboth_sdfull_pc/B.n22 nfet_01v8_lvt_W1_L20_m2__nf1_gboth_sdfull_pc/B.n21 585
R83 nfet_01v8_lvt_W1_L20_m2__nf1_gboth_sdfull_pc/B.n146 nfet_01v8_lvt_W1_L20_m2__nf1_gboth_sdfull_pc/B.n22 585
R84 nfet_01v8_lvt_W1_L20_m2__nf1_gboth_sdfull_pc/B.n144 nfet_01v8_lvt_W1_L20_m2__nf1_gboth_sdfull_pc/B.n143 585
R85 nfet_01v8_lvt_W1_L20_m2__nf1_gboth_sdfull_pc/B.n145 nfet_01v8_lvt_W1_L20_m2__nf1_gboth_sdfull_pc/B.n144 585
R86 nfet_01v8_lvt_W1_L20_m2__nf1_gboth_sdfull_pc/B.n25 nfet_01v8_lvt_W1_L20_m2__nf1_gboth_sdfull_pc/B.n24 585
R87 nfet_01v8_lvt_W1_L20_m2__nf1_gboth_sdfull_pc/B.n24 nfet_01v8_lvt_W1_L20_m2__nf1_gboth_sdfull_pc/B.n23 585
R88 nfet_01v8_lvt_W1_L20_m2__nf1_gboth_sdfull_pc/B.n137 nfet_01v8_lvt_W1_L20_m2__nf1_gboth_sdfull_pc/B.n136 585
R89 nfet_01v8_lvt_W1_L20_m2__nf1_gboth_sdfull_pc/B.n136 nfet_01v8_lvt_W1_L20_m2__nf1_gboth_sdfull_pc/B.n135 585
R90 nfet_01v8_lvt_W1_L20_m2__nf1_gboth_sdfull_pc/B.n30 nfet_01v8_lvt_W1_L20_m2__nf1_gboth_sdfull_pc/B.n29 585
R91 nfet_01v8_lvt_W1_L20_m2__nf1_gboth_sdfull_pc/B.n134 nfet_01v8_lvt_W1_L20_m2__nf1_gboth_sdfull_pc/B.n30 585
R92 nfet_01v8_lvt_W1_L20_m2__nf1_gboth_sdfull_pc/B.n132 nfet_01v8_lvt_W1_L20_m2__nf1_gboth_sdfull_pc/B.n131 585
R93 nfet_01v8_lvt_W1_L20_m2__nf1_gboth_sdfull_pc/B.n133 nfet_01v8_lvt_W1_L20_m2__nf1_gboth_sdfull_pc/B.n132 585
R94 nfet_01v8_lvt_W1_L20_m2__nf1_gboth_sdfull_pc/B.n33 nfet_01v8_lvt_W1_L20_m2__nf1_gboth_sdfull_pc/B.n32 585
R95 nfet_01v8_lvt_W1_L20_m2__nf1_gboth_sdfull_pc/B.n32 nfet_01v8_lvt_W1_L20_m2__nf1_gboth_sdfull_pc/B.n31 585
R96 nfet_01v8_lvt_W1_L20_m2__nf1_gboth_sdfull_pc/B.n125 nfet_01v8_lvt_W1_L20_m2__nf1_gboth_sdfull_pc/B.n124 585
R97 nfet_01v8_lvt_W1_L20_m2__nf1_gboth_sdfull_pc/B.n124 nfet_01v8_lvt_W1_L20_m2__nf1_gboth_sdfull_pc/B.n123 585
R98 nfet_01v8_lvt_W1_L20_m2__nf1_gboth_sdfull_pc/B.n38 nfet_01v8_lvt_W1_L20_m2__nf1_gboth_sdfull_pc/B.n37 585
R99 nfet_01v8_lvt_W1_L20_m2__nf1_gboth_sdfull_pc/B.n122 nfet_01v8_lvt_W1_L20_m2__nf1_gboth_sdfull_pc/B.n38 585
R100 nfet_01v8_lvt_W1_L20_m2__nf1_gboth_sdfull_pc/B.n120 nfet_01v8_lvt_W1_L20_m2__nf1_gboth_sdfull_pc/B.n119 585
R101 nfet_01v8_lvt_W1_L20_m2__nf1_gboth_sdfull_pc/B.n121 nfet_01v8_lvt_W1_L20_m2__nf1_gboth_sdfull_pc/B.n120 585
R102 nfet_01v8_lvt_W1_L20_m2__nf1_gboth_sdfull_pc/B.n41 nfet_01v8_lvt_W1_L20_m2__nf1_gboth_sdfull_pc/B.n40 585
R103 nfet_01v8_lvt_W1_L20_m2__nf1_gboth_sdfull_pc/B.n40 nfet_01v8_lvt_W1_L20_m2__nf1_gboth_sdfull_pc/B.n39 585
R104 nfet_01v8_lvt_W1_L20_m2__nf1_gboth_sdfull_pc/B.n113 nfet_01v8_lvt_W1_L20_m2__nf1_gboth_sdfull_pc/B.n112 585
R105 nfet_01v8_lvt_W1_L20_m2__nf1_gboth_sdfull_pc/B.n112 nfet_01v8_lvt_W1_L20_m2__nf1_gboth_sdfull_pc/B.n111 585
R106 nfet_01v8_lvt_W1_L20_m2__nf1_gboth_sdfull_pc/B.n46 nfet_01v8_lvt_W1_L20_m2__nf1_gboth_sdfull_pc/B.n45 585
R107 nfet_01v8_lvt_W1_L20_m2__nf1_gboth_sdfull_pc/B.n110 nfet_01v8_lvt_W1_L20_m2__nf1_gboth_sdfull_pc/B.n46 585
R108 nfet_01v8_lvt_W1_L20_m2__nf1_gboth_sdfull_pc/B.n108 nfet_01v8_lvt_W1_L20_m2__nf1_gboth_sdfull_pc/B.n107 585
R109 nfet_01v8_lvt_W1_L20_m2__nf1_gboth_sdfull_pc/B.n109 nfet_01v8_lvt_W1_L20_m2__nf1_gboth_sdfull_pc/B.n108 585
R110 nfet_01v8_lvt_W1_L20_m2__nf1_gboth_sdfull_pc/B.n49 nfet_01v8_lvt_W1_L20_m2__nf1_gboth_sdfull_pc/B.n48 585
R111 nfet_01v8_lvt_W1_L20_m2__nf1_gboth_sdfull_pc/B.n48 nfet_01v8_lvt_W1_L20_m2__nf1_gboth_sdfull_pc/B.n47 585
R112 nfet_01v8_lvt_W1_L20_m2__nf1_gboth_sdfull_pc/B.n101 nfet_01v8_lvt_W1_L20_m2__nf1_gboth_sdfull_pc/B.n100 585
R113 nfet_01v8_lvt_W1_L20_m2__nf1_gboth_sdfull_pc/B.n100 nfet_01v8_lvt_W1_L20_m2__nf1_gboth_sdfull_pc/B.n99 585
R114 nfet_01v8_lvt_W1_L20_m2__nf1_gboth_sdfull_pc/B.n54 nfet_01v8_lvt_W1_L20_m2__nf1_gboth_sdfull_pc/B.n53 585
R115 nfet_01v8_lvt_W1_L20_m2__nf1_gboth_sdfull_pc/B.n98 nfet_01v8_lvt_W1_L20_m2__nf1_gboth_sdfull_pc/B.n54 585
R116 nfet_01v8_lvt_W1_L20_m2__nf1_gboth_sdfull_pc/B.n96 nfet_01v8_lvt_W1_L20_m2__nf1_gboth_sdfull_pc/B.n95 585
R117 nfet_01v8_lvt_W1_L20_m2__nf1_gboth_sdfull_pc/B.n97 nfet_01v8_lvt_W1_L20_m2__nf1_gboth_sdfull_pc/B.n96 585
R118 nfet_01v8_lvt_W1_L20_m2__nf1_gboth_sdfull_pc/B.n57 nfet_01v8_lvt_W1_L20_m2__nf1_gboth_sdfull_pc/B.n56 585
R119 nfet_01v8_lvt_W1_L20_m2__nf1_gboth_sdfull_pc/B.n56 nfet_01v8_lvt_W1_L20_m2__nf1_gboth_sdfull_pc/B.n55 585
R120 nfet_01v8_lvt_W1_L20_m2__nf1_gboth_sdfull_pc/B.n89 nfet_01v8_lvt_W1_L20_m2__nf1_gboth_sdfull_pc/B.n88 585
R121 nfet_01v8_lvt_W1_L20_m2__nf1_gboth_sdfull_pc/B.n88 nfet_01v8_lvt_W1_L20_m2__nf1_gboth_sdfull_pc/B.n87 585
R122 nfet_01v8_lvt_W1_L20_m2__nf1_gboth_sdfull_pc/B.n62 nfet_01v8_lvt_W1_L20_m2__nf1_gboth_sdfull_pc/B.n61 585
R123 nfet_01v8_lvt_W1_L20_m2__nf1_gboth_sdfull_pc/B.n86 nfet_01v8_lvt_W1_L20_m2__nf1_gboth_sdfull_pc/B.n62 585
R124 nfet_01v8_lvt_W1_L20_m2__nf1_gboth_sdfull_pc/B.n84 nfet_01v8_lvt_W1_L20_m2__nf1_gboth_sdfull_pc/B.n83 585
R125 nfet_01v8_lvt_W1_L20_m2__nf1_gboth_sdfull_pc/B.n85 nfet_01v8_lvt_W1_L20_m2__nf1_gboth_sdfull_pc/B.n84 585
R126 nfet_01v8_lvt_W1_L20_m2__nf1_gboth_sdfull_pc/B.n65 nfet_01v8_lvt_W1_L20_m2__nf1_gboth_sdfull_pc/B.n64 585
R127 nfet_01v8_lvt_W1_L20_m2__nf1_gboth_sdfull_pc/B.n64 nfet_01v8_lvt_W1_L20_m2__nf1_gboth_sdfull_pc/B.n63 585
R128 nfet_01v8_lvt_W1_L20_m2__nf1_gboth_sdfull_pc/B.n76 nfet_01v8_lvt_W1_L20_m2__nf1_gboth_sdfull_pc/B.n75 585
R129 nfet_01v8_lvt_W1_L20_m2__nf1_gboth_sdfull_pc/B.n75 nfet_01v8_lvt_W1_L20_m2__nf1_gboth_sdfull_pc/B.n74 585
R130 nfet_01v8_lvt_W1_L20_m2__nf1_gboth_sdfull_pc/B.n73 nfet_01v8_lvt_W1_L20_m2__nf1_gboth_sdfull_pc/B.n70 585
R131 nfet_01v8_lvt_W1_L20_m2__nf1_gboth_sdfull_pc/B.n72 nfet_01v8_lvt_W1_L20_m2__nf1_gboth_sdfull_pc/B.n71 585
R132 nfet_01v8_lvt_W1_L20_m2__nf1_gboth_sdfull_pc/B.n68 nfet_01v8_lvt_W1_L20_m2__nf1_gboth_sdfull_pc/B.n67 585
R133 nfet_01v8_lvt_W1_L20_m2__nf1_gboth_sdfull_pc/B.n79 nfet_01v8_lvt_W1_L20_m2__nf1_gboth_sdfull_pc/B.n78 585
R134 nfet_01v8_lvt_W1_L20_m2__nf1_gboth_sdfull_pc/B.n66 nfet_01v8_lvt_W1_L20_m2__nf1_gboth_sdfull_pc/B.n65 585
R135 nfet_01v8_lvt_W1_L20_m2__nf1_gboth_sdfull_pc/B.n80 nfet_01v8_lvt_W1_L20_m2__nf1_gboth_sdfull_pc/B.n66 585
R136 nfet_01v8_lvt_W1_L20_m2__nf1_gboth_sdfull_pc/B.n83 nfet_01v8_lvt_W1_L20_m2__nf1_gboth_sdfull_pc/B.n82 585
R137 nfet_01v8_lvt_W1_L20_m2__nf1_gboth_sdfull_pc/B.n82 nfet_01v8_lvt_W1_L20_m2__nf1_gboth_sdfull_pc/B.n81 585
R138 nfet_01v8_lvt_W1_L20_m2__nf1_gboth_sdfull_pc/B.n61 nfet_01v8_lvt_W1_L20_m2__nf1_gboth_sdfull_pc/B.n60 585
R139 nfet_01v8_lvt_W1_L20_m2__nf1_gboth_sdfull_pc/B.n60 nfet_01v8_lvt_W1_L20_m2__nf1_gboth_sdfull_pc/B.n59 585
R140 nfet_01v8_lvt_W1_L20_m2__nf1_gboth_sdfull_pc/B.n90 nfet_01v8_lvt_W1_L20_m2__nf1_gboth_sdfull_pc/B.n89 585
R141 nfet_01v8_lvt_W1_L20_m2__nf1_gboth_sdfull_pc/B.n91 nfet_01v8_lvt_W1_L20_m2__nf1_gboth_sdfull_pc/B.n90 585
R142 nfet_01v8_lvt_W1_L20_m2__nf1_gboth_sdfull_pc/B.n58 nfet_01v8_lvt_W1_L20_m2__nf1_gboth_sdfull_pc/B.n57 585
R143 nfet_01v8_lvt_W1_L20_m2__nf1_gboth_sdfull_pc/B.n92 nfet_01v8_lvt_W1_L20_m2__nf1_gboth_sdfull_pc/B.n58 585
R144 nfet_01v8_lvt_W1_L20_m2__nf1_gboth_sdfull_pc/B.n95 nfet_01v8_lvt_W1_L20_m2__nf1_gboth_sdfull_pc/B.n94 585
R145 nfet_01v8_lvt_W1_L20_m2__nf1_gboth_sdfull_pc/B.n94 nfet_01v8_lvt_W1_L20_m2__nf1_gboth_sdfull_pc/B.n93 585
R146 nfet_01v8_lvt_W1_L20_m2__nf1_gboth_sdfull_pc/B.n53 nfet_01v8_lvt_W1_L20_m2__nf1_gboth_sdfull_pc/B.n52 585
R147 nfet_01v8_lvt_W1_L20_m2__nf1_gboth_sdfull_pc/B.n52 nfet_01v8_lvt_W1_L20_m2__nf1_gboth_sdfull_pc/B.n51 585
R148 nfet_01v8_lvt_W1_L20_m2__nf1_gboth_sdfull_pc/B.n102 nfet_01v8_lvt_W1_L20_m2__nf1_gboth_sdfull_pc/B.n101 585
R149 nfet_01v8_lvt_W1_L20_m2__nf1_gboth_sdfull_pc/B.n103 nfet_01v8_lvt_W1_L20_m2__nf1_gboth_sdfull_pc/B.n102 585
R150 nfet_01v8_lvt_W1_L20_m2__nf1_gboth_sdfull_pc/B.n50 nfet_01v8_lvt_W1_L20_m2__nf1_gboth_sdfull_pc/B.n49 585
R151 nfet_01v8_lvt_W1_L20_m2__nf1_gboth_sdfull_pc/B.n104 nfet_01v8_lvt_W1_L20_m2__nf1_gboth_sdfull_pc/B.n50 585
R152 nfet_01v8_lvt_W1_L20_m2__nf1_gboth_sdfull_pc/B.n107 nfet_01v8_lvt_W1_L20_m2__nf1_gboth_sdfull_pc/B.n106 585
R153 nfet_01v8_lvt_W1_L20_m2__nf1_gboth_sdfull_pc/B.n106 nfet_01v8_lvt_W1_L20_m2__nf1_gboth_sdfull_pc/B.n105 585
R154 nfet_01v8_lvt_W1_L20_m2__nf1_gboth_sdfull_pc/B.n45 nfet_01v8_lvt_W1_L20_m2__nf1_gboth_sdfull_pc/B.n44 585
R155 nfet_01v8_lvt_W1_L20_m2__nf1_gboth_sdfull_pc/B.n44 nfet_01v8_lvt_W1_L20_m2__nf1_gboth_sdfull_pc/B.n43 585
R156 nfet_01v8_lvt_W1_L20_m2__nf1_gboth_sdfull_pc/B.n114 nfet_01v8_lvt_W1_L20_m2__nf1_gboth_sdfull_pc/B.n113 585
R157 nfet_01v8_lvt_W1_L20_m2__nf1_gboth_sdfull_pc/B.n115 nfet_01v8_lvt_W1_L20_m2__nf1_gboth_sdfull_pc/B.n114 585
R158 nfet_01v8_lvt_W1_L20_m2__nf1_gboth_sdfull_pc/B.n42 nfet_01v8_lvt_W1_L20_m2__nf1_gboth_sdfull_pc/B.n41 585
R159 nfet_01v8_lvt_W1_L20_m2__nf1_gboth_sdfull_pc/B.n116 nfet_01v8_lvt_W1_L20_m2__nf1_gboth_sdfull_pc/B.n42 585
R160 nfet_01v8_lvt_W1_L20_m2__nf1_gboth_sdfull_pc/B.n119 nfet_01v8_lvt_W1_L20_m2__nf1_gboth_sdfull_pc/B.n118 585
R161 nfet_01v8_lvt_W1_L20_m2__nf1_gboth_sdfull_pc/B.n118 nfet_01v8_lvt_W1_L20_m2__nf1_gboth_sdfull_pc/B.n117 585
R162 nfet_01v8_lvt_W1_L20_m2__nf1_gboth_sdfull_pc/B.n37 nfet_01v8_lvt_W1_L20_m2__nf1_gboth_sdfull_pc/B.n36 585
R163 nfet_01v8_lvt_W1_L20_m2__nf1_gboth_sdfull_pc/B.n36 nfet_01v8_lvt_W1_L20_m2__nf1_gboth_sdfull_pc/B.n35 585
R164 nfet_01v8_lvt_W1_L20_m2__nf1_gboth_sdfull_pc/B.n126 nfet_01v8_lvt_W1_L20_m2__nf1_gboth_sdfull_pc/B.n125 585
R165 nfet_01v8_lvt_W1_L20_m2__nf1_gboth_sdfull_pc/B.n127 nfet_01v8_lvt_W1_L20_m2__nf1_gboth_sdfull_pc/B.n126 585
R166 nfet_01v8_lvt_W1_L20_m2__nf1_gboth_sdfull_pc/B.n34 nfet_01v8_lvt_W1_L20_m2__nf1_gboth_sdfull_pc/B.n33 585
R167 nfet_01v8_lvt_W1_L20_m2__nf1_gboth_sdfull_pc/B.n128 nfet_01v8_lvt_W1_L20_m2__nf1_gboth_sdfull_pc/B.n34 585
R168 nfet_01v8_lvt_W1_L20_m2__nf1_gboth_sdfull_pc/B.n131 nfet_01v8_lvt_W1_L20_m2__nf1_gboth_sdfull_pc/B.n130 585
R169 nfet_01v8_lvt_W1_L20_m2__nf1_gboth_sdfull_pc/B.n130 nfet_01v8_lvt_W1_L20_m2__nf1_gboth_sdfull_pc/B.n129 585
R170 nfet_01v8_lvt_W1_L20_m2__nf1_gboth_sdfull_pc/B.n29 nfet_01v8_lvt_W1_L20_m2__nf1_gboth_sdfull_pc/B.n28 585
R171 nfet_01v8_lvt_W1_L20_m2__nf1_gboth_sdfull_pc/B.n28 nfet_01v8_lvt_W1_L20_m2__nf1_gboth_sdfull_pc/B.n27 585
R172 nfet_01v8_lvt_W1_L20_m2__nf1_gboth_sdfull_pc/B.n138 nfet_01v8_lvt_W1_L20_m2__nf1_gboth_sdfull_pc/B.n137 585
R173 nfet_01v8_lvt_W1_L20_m2__nf1_gboth_sdfull_pc/B.n139 nfet_01v8_lvt_W1_L20_m2__nf1_gboth_sdfull_pc/B.n138 585
R174 nfet_01v8_lvt_W1_L20_m2__nf1_gboth_sdfull_pc/B.n26 nfet_01v8_lvt_W1_L20_m2__nf1_gboth_sdfull_pc/B.n25 585
R175 nfet_01v8_lvt_W1_L20_m2__nf1_gboth_sdfull_pc/B.n140 nfet_01v8_lvt_W1_L20_m2__nf1_gboth_sdfull_pc/B.n26 585
R176 nfet_01v8_lvt_W1_L20_m2__nf1_gboth_sdfull_pc/B.n143 nfet_01v8_lvt_W1_L20_m2__nf1_gboth_sdfull_pc/B.n142 585
R177 nfet_01v8_lvt_W1_L20_m2__nf1_gboth_sdfull_pc/B.n142 nfet_01v8_lvt_W1_L20_m2__nf1_gboth_sdfull_pc/B.n141 585
R178 nfet_01v8_lvt_W1_L20_m2__nf1_gboth_sdfull_pc/B.n21 nfet_01v8_lvt_W1_L20_m2__nf1_gboth_sdfull_pc/B.n20 585
R179 nfet_01v8_lvt_W1_L20_m2__nf1_gboth_sdfull_pc/B.n20 nfet_01v8_lvt_W1_L20_m2__nf1_gboth_sdfull_pc/B.n19 585
R180 nfet_01v8_lvt_W1_L20_m2__nf1_gboth_sdfull_pc/B.n150 nfet_01v8_lvt_W1_L20_m2__nf1_gboth_sdfull_pc/B.n149 585
R181 nfet_01v8_lvt_W1_L20_m2__nf1_gboth_sdfull_pc/B.n151 nfet_01v8_lvt_W1_L20_m2__nf1_gboth_sdfull_pc/B.n150 585
R182 nfet_01v8_lvt_W1_L20_m2__nf1_gboth_sdfull_pc/B.n18 nfet_01v8_lvt_W1_L20_m2__nf1_gboth_sdfull_pc/B.n17 585
R183 nfet_01v8_lvt_W1_L20_m2__nf1_gboth_sdfull_pc/B.n152 nfet_01v8_lvt_W1_L20_m2__nf1_gboth_sdfull_pc/B.n18 585
R184 nfet_01v8_lvt_W1_L20_m2__nf1_gboth_sdfull_pc/B.n155 nfet_01v8_lvt_W1_L20_m2__nf1_gboth_sdfull_pc/B.n154 585
R185 nfet_01v8_lvt_W1_L20_m2__nf1_gboth_sdfull_pc/B.n154 nfet_01v8_lvt_W1_L20_m2__nf1_gboth_sdfull_pc/B.n153 585
R186 nfet_01v8_lvt_W1_L20_m2__nf1_gboth_sdfull_pc/B.n13 nfet_01v8_lvt_W1_L20_m2__nf1_gboth_sdfull_pc/B.n12 585
R187 nfet_01v8_lvt_W1_L20_m2__nf1_gboth_sdfull_pc/B.n12 nfet_01v8_lvt_W1_L20_m2__nf1_gboth_sdfull_pc/B.n11 585
R188 nfet_01v8_lvt_W1_L20_m2__nf1_gboth_sdfull_pc/B.n162 nfet_01v8_lvt_W1_L20_m2__nf1_gboth_sdfull_pc/B.n161 585
R189 nfet_01v8_lvt_W1_L20_m2__nf1_gboth_sdfull_pc/B.n163 nfet_01v8_lvt_W1_L20_m2__nf1_gboth_sdfull_pc/B.n162 585
R190 nfet_01v8_lvt_W1_L20_m2__nf1_gboth_sdfull_pc/B.n10 nfet_01v8_lvt_W1_L20_m2__nf1_gboth_sdfull_pc/B.n9 585
R191 nfet_01v8_lvt_W1_L20_m2__nf1_gboth_sdfull_pc/B.n164 nfet_01v8_lvt_W1_L20_m2__nf1_gboth_sdfull_pc/B.n10 585
R192 nfet_01v8_lvt_W1_L20_m2__nf1_gboth_sdfull_pc/B.n167 nfet_01v8_lvt_W1_L20_m2__nf1_gboth_sdfull_pc/B.n166 585
R193 nfet_01v8_lvt_W1_L20_m2__nf1_gboth_sdfull_pc/B.n166 nfet_01v8_lvt_W1_L20_m2__nf1_gboth_sdfull_pc/B.n165 585
R194 nfet_01v8_lvt_W1_L20_m2__nf1_gboth_sdfull_pc/B.t0 nfet_01v8_lvt_W1_L20_m2__nf1_gboth_sdfull_pc/B.n2 585
R195 nfet_01v8_lvt_W1_L20_m2__nf1_gboth_sdfull_pc/B.n2 nfet_01v8_lvt_W1_L20_m2__nf1_gboth_sdfull_pc/B.n0 585
R196 nfet_01v8_lvt_W1_L20_m2__nf1_gboth_sdfull_pc/B.n328 nfet_01v8_lvt_W1_L20_m2__nf1_gboth_sdfull_pc/B.n327 585
R197 nfet_01v8_lvt_W1_L20_m2__nf1_gboth_sdfull_pc/B.n329 nfet_01v8_lvt_W1_L20_m2__nf1_gboth_sdfull_pc/B.n328 585
R198 nfet_01v8_lvt_W1_L20_m2__nf1_gboth_sdfull_pc/B.n4 nfet_01v8_lvt_W1_L20_m2__nf1_gboth_sdfull_pc/B.n3 585
R199 nfet_01v8_lvt_W1_L20_m2__nf1_gboth_sdfull_pc/B.n3 nfet_01v8_lvt_W1_L20_m2__nf1_gboth_sdfull_pc/B.n1 585
R200 nfet_01v8_lvt_W1_L20_m2__nf1_gboth_sdfull_pc/B.n321 nfet_01v8_lvt_W1_L20_m2__nf1_gboth_sdfull_pc/B.n173 585
R201 nfet_01v8_lvt_W1_L20_m2__nf1_gboth_sdfull_pc/B.n224 nfet_01v8_lvt_W1_L20_m2__nf1_gboth_sdfull_pc/B.n173 585
R202 nfet_01v8_lvt_W1_L20_m2__nf1_gboth_sdfull_pc/B.n320 nfet_01v8_lvt_W1_L20_m2__nf1_gboth_sdfull_pc/B.n174 585
R203 nfet_01v8_lvt_W1_L20_m2__nf1_gboth_sdfull_pc/B.n225 nfet_01v8_lvt_W1_L20_m2__nf1_gboth_sdfull_pc/B.n174 585
R204 nfet_01v8_lvt_W1_L20_m2__nf1_gboth_sdfull_pc/B.n319 nfet_01v8_lvt_W1_L20_m2__nf1_gboth_sdfull_pc/B.n175 585
R205 nfet_01v8_lvt_W1_L20_m2__nf1_gboth_sdfull_pc/B.n226 nfet_01v8_lvt_W1_L20_m2__nf1_gboth_sdfull_pc/B.n175 585
R206 nfet_01v8_lvt_W1_L20_m2__nf1_gboth_sdfull_pc/B.n227 nfet_01v8_lvt_W1_L20_m2__nf1_gboth_sdfull_pc/B.n176 585
R207 nfet_01v8_lvt_W1_L20_m2__nf1_gboth_sdfull_pc/B.n228 nfet_01v8_lvt_W1_L20_m2__nf1_gboth_sdfull_pc/B.n227 585
R208 nfet_01v8_lvt_W1_L20_m2__nf1_gboth_sdfull_pc/B.n313 nfet_01v8_lvt_W1_L20_m2__nf1_gboth_sdfull_pc/B.n180 585
R209 nfet_01v8_lvt_W1_L20_m2__nf1_gboth_sdfull_pc/B.n229 nfet_01v8_lvt_W1_L20_m2__nf1_gboth_sdfull_pc/B.n180 585
R210 nfet_01v8_lvt_W1_L20_m2__nf1_gboth_sdfull_pc/B.n312 nfet_01v8_lvt_W1_L20_m2__nf1_gboth_sdfull_pc/B.n181 585
R211 nfet_01v8_lvt_W1_L20_m2__nf1_gboth_sdfull_pc/B.n230 nfet_01v8_lvt_W1_L20_m2__nf1_gboth_sdfull_pc/B.n181 585
R212 nfet_01v8_lvt_W1_L20_m2__nf1_gboth_sdfull_pc/B.n311 nfet_01v8_lvt_W1_L20_m2__nf1_gboth_sdfull_pc/B.n182 585
R213 nfet_01v8_lvt_W1_L20_m2__nf1_gboth_sdfull_pc/B.n231 nfet_01v8_lvt_W1_L20_m2__nf1_gboth_sdfull_pc/B.n182 585
R214 nfet_01v8_lvt_W1_L20_m2__nf1_gboth_sdfull_pc/B.n232 nfet_01v8_lvt_W1_L20_m2__nf1_gboth_sdfull_pc/B.n183 585
R215 nfet_01v8_lvt_W1_L20_m2__nf1_gboth_sdfull_pc/B.n233 nfet_01v8_lvt_W1_L20_m2__nf1_gboth_sdfull_pc/B.n232 585
R216 nfet_01v8_lvt_W1_L20_m2__nf1_gboth_sdfull_pc/B.n305 nfet_01v8_lvt_W1_L20_m2__nf1_gboth_sdfull_pc/B.n187 585
R217 nfet_01v8_lvt_W1_L20_m2__nf1_gboth_sdfull_pc/B.n234 nfet_01v8_lvt_W1_L20_m2__nf1_gboth_sdfull_pc/B.n187 585
R218 nfet_01v8_lvt_W1_L20_m2__nf1_gboth_sdfull_pc/B.n304 nfet_01v8_lvt_W1_L20_m2__nf1_gboth_sdfull_pc/B.n188 585
R219 nfet_01v8_lvt_W1_L20_m2__nf1_gboth_sdfull_pc/B.n235 nfet_01v8_lvt_W1_L20_m2__nf1_gboth_sdfull_pc/B.n188 585
R220 nfet_01v8_lvt_W1_L20_m2__nf1_gboth_sdfull_pc/B.n303 nfet_01v8_lvt_W1_L20_m2__nf1_gboth_sdfull_pc/B.n189 585
R221 nfet_01v8_lvt_W1_L20_m2__nf1_gboth_sdfull_pc/B.n236 nfet_01v8_lvt_W1_L20_m2__nf1_gboth_sdfull_pc/B.n189 585
R222 nfet_01v8_lvt_W1_L20_m2__nf1_gboth_sdfull_pc/B.n237 nfet_01v8_lvt_W1_L20_m2__nf1_gboth_sdfull_pc/B.n190 585
R223 nfet_01v8_lvt_W1_L20_m2__nf1_gboth_sdfull_pc/B.n238 nfet_01v8_lvt_W1_L20_m2__nf1_gboth_sdfull_pc/B.n237 585
R224 nfet_01v8_lvt_W1_L20_m2__nf1_gboth_sdfull_pc/B.n297 nfet_01v8_lvt_W1_L20_m2__nf1_gboth_sdfull_pc/B.n194 585
R225 nfet_01v8_lvt_W1_L20_m2__nf1_gboth_sdfull_pc/B.n239 nfet_01v8_lvt_W1_L20_m2__nf1_gboth_sdfull_pc/B.n194 585
R226 nfet_01v8_lvt_W1_L20_m2__nf1_gboth_sdfull_pc/B.n296 nfet_01v8_lvt_W1_L20_m2__nf1_gboth_sdfull_pc/B.n195 585
R227 nfet_01v8_lvt_W1_L20_m2__nf1_gboth_sdfull_pc/B.n240 nfet_01v8_lvt_W1_L20_m2__nf1_gboth_sdfull_pc/B.n195 585
R228 nfet_01v8_lvt_W1_L20_m2__nf1_gboth_sdfull_pc/B.n295 nfet_01v8_lvt_W1_L20_m2__nf1_gboth_sdfull_pc/B.n196 585
R229 nfet_01v8_lvt_W1_L20_m2__nf1_gboth_sdfull_pc/B.n241 nfet_01v8_lvt_W1_L20_m2__nf1_gboth_sdfull_pc/B.n196 585
R230 nfet_01v8_lvt_W1_L20_m2__nf1_gboth_sdfull_pc/B.n242 nfet_01v8_lvt_W1_L20_m2__nf1_gboth_sdfull_pc/B.n197 585
R231 nfet_01v8_lvt_W1_L20_m2__nf1_gboth_sdfull_pc/B.n243 nfet_01v8_lvt_W1_L20_m2__nf1_gboth_sdfull_pc/B.n242 585
R232 nfet_01v8_lvt_W1_L20_m2__nf1_gboth_sdfull_pc/B.n289 nfet_01v8_lvt_W1_L20_m2__nf1_gboth_sdfull_pc/B.n201 585
R233 nfet_01v8_lvt_W1_L20_m2__nf1_gboth_sdfull_pc/B.n244 nfet_01v8_lvt_W1_L20_m2__nf1_gboth_sdfull_pc/B.n201 585
R234 nfet_01v8_lvt_W1_L20_m2__nf1_gboth_sdfull_pc/B.n288 nfet_01v8_lvt_W1_L20_m2__nf1_gboth_sdfull_pc/B.n202 585
R235 nfet_01v8_lvt_W1_L20_m2__nf1_gboth_sdfull_pc/B.n245 nfet_01v8_lvt_W1_L20_m2__nf1_gboth_sdfull_pc/B.n202 585
R236 nfet_01v8_lvt_W1_L20_m2__nf1_gboth_sdfull_pc/B.n287 nfet_01v8_lvt_W1_L20_m2__nf1_gboth_sdfull_pc/B.n203 585
R237 nfet_01v8_lvt_W1_L20_m2__nf1_gboth_sdfull_pc/B.n246 nfet_01v8_lvt_W1_L20_m2__nf1_gboth_sdfull_pc/B.n203 585
R238 nfet_01v8_lvt_W1_L20_m2__nf1_gboth_sdfull_pc/B.n247 nfet_01v8_lvt_W1_L20_m2__nf1_gboth_sdfull_pc/B.n204 585
R239 nfet_01v8_lvt_W1_L20_m2__nf1_gboth_sdfull_pc/B.n248 nfet_01v8_lvt_W1_L20_m2__nf1_gboth_sdfull_pc/B.n247 585
R240 nfet_01v8_lvt_W1_L20_m2__nf1_gboth_sdfull_pc/B.n281 nfet_01v8_lvt_W1_L20_m2__nf1_gboth_sdfull_pc/B.n208 585
R241 nfet_01v8_lvt_W1_L20_m2__nf1_gboth_sdfull_pc/B.n249 nfet_01v8_lvt_W1_L20_m2__nf1_gboth_sdfull_pc/B.n208 585
R242 nfet_01v8_lvt_W1_L20_m2__nf1_gboth_sdfull_pc/B.n280 nfet_01v8_lvt_W1_L20_m2__nf1_gboth_sdfull_pc/B.n209 585
R243 nfet_01v8_lvt_W1_L20_m2__nf1_gboth_sdfull_pc/B.n250 nfet_01v8_lvt_W1_L20_m2__nf1_gboth_sdfull_pc/B.n209 585
R244 nfet_01v8_lvt_W1_L20_m2__nf1_gboth_sdfull_pc/B.n279 nfet_01v8_lvt_W1_L20_m2__nf1_gboth_sdfull_pc/B.n210 585
R245 nfet_01v8_lvt_W1_L20_m2__nf1_gboth_sdfull_pc/B.n251 nfet_01v8_lvt_W1_L20_m2__nf1_gboth_sdfull_pc/B.n210 585
R246 nfet_01v8_lvt_W1_L20_m2__nf1_gboth_sdfull_pc/B.n252 nfet_01v8_lvt_W1_L20_m2__nf1_gboth_sdfull_pc/B.n211 585
R247 nfet_01v8_lvt_W1_L20_m2__nf1_gboth_sdfull_pc/B.n253 nfet_01v8_lvt_W1_L20_m2__nf1_gboth_sdfull_pc/B.n252 585
R248 nfet_01v8_lvt_W1_L20_m2__nf1_gboth_sdfull_pc/B.n273 nfet_01v8_lvt_W1_L20_m2__nf1_gboth_sdfull_pc/B.n215 585
R249 nfet_01v8_lvt_W1_L20_m2__nf1_gboth_sdfull_pc/B.n254 nfet_01v8_lvt_W1_L20_m2__nf1_gboth_sdfull_pc/B.n215 585
R250 nfet_01v8_lvt_W1_L20_m2__nf1_gboth_sdfull_pc/B.n272 nfet_01v8_lvt_W1_L20_m2__nf1_gboth_sdfull_pc/B.n216 585
R251 nfet_01v8_lvt_W1_L20_m2__nf1_gboth_sdfull_pc/B.n255 nfet_01v8_lvt_W1_L20_m2__nf1_gboth_sdfull_pc/B.n216 585
R252 nfet_01v8_lvt_W1_L20_m2__nf1_gboth_sdfull_pc/B.n271 nfet_01v8_lvt_W1_L20_m2__nf1_gboth_sdfull_pc/B.n217 585
R253 nfet_01v8_lvt_W1_L20_m2__nf1_gboth_sdfull_pc/B.n256 nfet_01v8_lvt_W1_L20_m2__nf1_gboth_sdfull_pc/B.n217 585
R254 nfet_01v8_lvt_W1_L20_m2__nf1_gboth_sdfull_pc/B.n258 nfet_01v8_lvt_W1_L20_m2__nf1_gboth_sdfull_pc/B.n218 585
R255 nfet_01v8_lvt_W1_L20_m2__nf1_gboth_sdfull_pc/B.n258 nfet_01v8_lvt_W1_L20_m2__nf1_gboth_sdfull_pc/B.n257 585
R256 nfet_01v8_lvt_W1_L20_m2__nf1_gboth_sdfull_pc/B.n260 nfet_01v8_lvt_W1_L20_m2__nf1_gboth_sdfull_pc/B.n259 585
R257 nfet_01v8_lvt_W1_L20_m2__nf1_gboth_sdfull_pc/B.n261 nfet_01v8_lvt_W1_L20_m2__nf1_gboth_sdfull_pc/B.n223 585
R258 nfet_01v8_lvt_W1_L20_m2__nf1_gboth_sdfull_pc/B.n264 nfet_01v8_lvt_W1_L20_m2__nf1_gboth_sdfull_pc/B.n263 585
R259 nfet_01v8_lvt_W1_L20_m2__nf1_gboth_sdfull_pc/B.n263 nfet_01v8_lvt_W1_L20_m2__nf1_gboth_sdfull_pc/B.n262 585
R260 nfet_01v8_lvt_W1_L20_m2__nf1_gboth_sdfull_pc/B.n221 nfet_01v8_lvt_W1_L20_m2__nf1_gboth_sdfull_pc/B.n220 585
R261 nfet_01v8_lvt_W1_L20_m2__nf1_gboth_sdfull_pc/B.n267 nfet_01v8_lvt_W1_L20_m2__nf1_gboth_sdfull_pc/B.n266 585
R262 nfet_01v8_lvt_W1_L20_m2__nf1_gboth_sdfull_pc/B.n271 nfet_01v8_lvt_W1_L20_m2__nf1_gboth_sdfull_pc/B.n218 498.668
R263 nfet_01v8_lvt_W1_L20_m2__nf1_gboth_sdfull_pc/B.n272 nfet_01v8_lvt_W1_L20_m2__nf1_gboth_sdfull_pc/B.n271 498.668
R264 nfet_01v8_lvt_W1_L20_m2__nf1_gboth_sdfull_pc/B.n273 nfet_01v8_lvt_W1_L20_m2__nf1_gboth_sdfull_pc/B.n272 498.668
R265 nfet_01v8_lvt_W1_L20_m2__nf1_gboth_sdfull_pc/B.n273 nfet_01v8_lvt_W1_L20_m2__nf1_gboth_sdfull_pc/B.n211 498.668
R266 nfet_01v8_lvt_W1_L20_m2__nf1_gboth_sdfull_pc/B.n279 nfet_01v8_lvt_W1_L20_m2__nf1_gboth_sdfull_pc/B.n211 498.668
R267 nfet_01v8_lvt_W1_L20_m2__nf1_gboth_sdfull_pc/B.n280 nfet_01v8_lvt_W1_L20_m2__nf1_gboth_sdfull_pc/B.n279 498.668
R268 nfet_01v8_lvt_W1_L20_m2__nf1_gboth_sdfull_pc/B.n281 nfet_01v8_lvt_W1_L20_m2__nf1_gboth_sdfull_pc/B.n280 498.668
R269 nfet_01v8_lvt_W1_L20_m2__nf1_gboth_sdfull_pc/B.n281 nfet_01v8_lvt_W1_L20_m2__nf1_gboth_sdfull_pc/B.n204 498.668
R270 nfet_01v8_lvt_W1_L20_m2__nf1_gboth_sdfull_pc/B.n287 nfet_01v8_lvt_W1_L20_m2__nf1_gboth_sdfull_pc/B.n204 498.668
R271 nfet_01v8_lvt_W1_L20_m2__nf1_gboth_sdfull_pc/B.n288 nfet_01v8_lvt_W1_L20_m2__nf1_gboth_sdfull_pc/B.n287 498.668
R272 nfet_01v8_lvt_W1_L20_m2__nf1_gboth_sdfull_pc/B.n289 nfet_01v8_lvt_W1_L20_m2__nf1_gboth_sdfull_pc/B.n288 498.668
R273 nfet_01v8_lvt_W1_L20_m2__nf1_gboth_sdfull_pc/B.n289 nfet_01v8_lvt_W1_L20_m2__nf1_gboth_sdfull_pc/B.n197 498.668
R274 nfet_01v8_lvt_W1_L20_m2__nf1_gboth_sdfull_pc/B.n295 nfet_01v8_lvt_W1_L20_m2__nf1_gboth_sdfull_pc/B.n197 498.668
R275 nfet_01v8_lvt_W1_L20_m2__nf1_gboth_sdfull_pc/B.n296 nfet_01v8_lvt_W1_L20_m2__nf1_gboth_sdfull_pc/B.n295 498.668
R276 nfet_01v8_lvt_W1_L20_m2__nf1_gboth_sdfull_pc/B.n297 nfet_01v8_lvt_W1_L20_m2__nf1_gboth_sdfull_pc/B.n296 498.668
R277 nfet_01v8_lvt_W1_L20_m2__nf1_gboth_sdfull_pc/B.n297 nfet_01v8_lvt_W1_L20_m2__nf1_gboth_sdfull_pc/B.n190 498.668
R278 nfet_01v8_lvt_W1_L20_m2__nf1_gboth_sdfull_pc/B.n303 nfet_01v8_lvt_W1_L20_m2__nf1_gboth_sdfull_pc/B.n190 498.668
R279 nfet_01v8_lvt_W1_L20_m2__nf1_gboth_sdfull_pc/B.n304 nfet_01v8_lvt_W1_L20_m2__nf1_gboth_sdfull_pc/B.n303 498.668
R280 nfet_01v8_lvt_W1_L20_m2__nf1_gboth_sdfull_pc/B.n305 nfet_01v8_lvt_W1_L20_m2__nf1_gboth_sdfull_pc/B.n304 498.668
R281 nfet_01v8_lvt_W1_L20_m2__nf1_gboth_sdfull_pc/B.n305 nfet_01v8_lvt_W1_L20_m2__nf1_gboth_sdfull_pc/B.n183 498.668
R282 nfet_01v8_lvt_W1_L20_m2__nf1_gboth_sdfull_pc/B.n311 nfet_01v8_lvt_W1_L20_m2__nf1_gboth_sdfull_pc/B.n183 498.668
R283 nfet_01v8_lvt_W1_L20_m2__nf1_gboth_sdfull_pc/B.n312 nfet_01v8_lvt_W1_L20_m2__nf1_gboth_sdfull_pc/B.n311 498.668
R284 nfet_01v8_lvt_W1_L20_m2__nf1_gboth_sdfull_pc/B.n313 nfet_01v8_lvt_W1_L20_m2__nf1_gboth_sdfull_pc/B.n312 498.668
R285 nfet_01v8_lvt_W1_L20_m2__nf1_gboth_sdfull_pc/B.n313 nfet_01v8_lvt_W1_L20_m2__nf1_gboth_sdfull_pc/B.n176 498.668
R286 nfet_01v8_lvt_W1_L20_m2__nf1_gboth_sdfull_pc/B.n319 nfet_01v8_lvt_W1_L20_m2__nf1_gboth_sdfull_pc/B.n176 498.668
R287 nfet_01v8_lvt_W1_L20_m2__nf1_gboth_sdfull_pc/B.n320 nfet_01v8_lvt_W1_L20_m2__nf1_gboth_sdfull_pc/B.n319 498.668
R288 nfet_01v8_lvt_W1_L20_m2__nf1_gboth_sdfull_pc/B.n321 nfet_01v8_lvt_W1_L20_m2__nf1_gboth_sdfull_pc/B.n320 498.668
R289 nfet_01v8_lvt_W1_L20_m2__nf1_gboth_sdfull_pc/B.n321 nfet_01v8_lvt_W1_L20_m2__nf1_gboth_sdfull_pc/B.n4 498.668
R290 nfet_01v8_lvt_W1_L20_m2__nf1_gboth_sdfull_pc/B.n327 nfet_01v8_lvt_W1_L20_m2__nf1_gboth_sdfull_pc/B.n4 498.668
R291 nfet_01v8_lvt_W1_L20_m2__nf1_gboth_sdfull_pc/B.n327 nfet_01v8_lvt_W1_L20_m2__nf1_gboth_sdfull_pc/B.t0 498.668
R292 nfet_01v8_lvt_W1_L20_m2__nf1_gboth_sdfull_pc/B.n167 nfet_01v8_lvt_W1_L20_m2__nf1_gboth_sdfull_pc/B.t0 498.668
R293 nfet_01v8_lvt_W1_L20_m2__nf1_gboth_sdfull_pc/B.n167 nfet_01v8_lvt_W1_L20_m2__nf1_gboth_sdfull_pc/B.n9 498.668
R294 nfet_01v8_lvt_W1_L20_m2__nf1_gboth_sdfull_pc/B.n161 nfet_01v8_lvt_W1_L20_m2__nf1_gboth_sdfull_pc/B.n9 498.668
R295 nfet_01v8_lvt_W1_L20_m2__nf1_gboth_sdfull_pc/B.n161 nfet_01v8_lvt_W1_L20_m2__nf1_gboth_sdfull_pc/B.n13 498.668
R296 nfet_01v8_lvt_W1_L20_m2__nf1_gboth_sdfull_pc/B.n155 nfet_01v8_lvt_W1_L20_m2__nf1_gboth_sdfull_pc/B.n13 498.668
R297 nfet_01v8_lvt_W1_L20_m2__nf1_gboth_sdfull_pc/B.n155 nfet_01v8_lvt_W1_L20_m2__nf1_gboth_sdfull_pc/B.n17 498.668
R298 nfet_01v8_lvt_W1_L20_m2__nf1_gboth_sdfull_pc/B.n149 nfet_01v8_lvt_W1_L20_m2__nf1_gboth_sdfull_pc/B.n17 498.668
R299 nfet_01v8_lvt_W1_L20_m2__nf1_gboth_sdfull_pc/B.n149 nfet_01v8_lvt_W1_L20_m2__nf1_gboth_sdfull_pc/B.n21 498.668
R300 nfet_01v8_lvt_W1_L20_m2__nf1_gboth_sdfull_pc/B.n143 nfet_01v8_lvt_W1_L20_m2__nf1_gboth_sdfull_pc/B.n21 498.668
R301 nfet_01v8_lvt_W1_L20_m2__nf1_gboth_sdfull_pc/B.n143 nfet_01v8_lvt_W1_L20_m2__nf1_gboth_sdfull_pc/B.n25 498.668
R302 nfet_01v8_lvt_W1_L20_m2__nf1_gboth_sdfull_pc/B.n137 nfet_01v8_lvt_W1_L20_m2__nf1_gboth_sdfull_pc/B.n25 498.668
R303 nfet_01v8_lvt_W1_L20_m2__nf1_gboth_sdfull_pc/B.n137 nfet_01v8_lvt_W1_L20_m2__nf1_gboth_sdfull_pc/B.n29 498.668
R304 nfet_01v8_lvt_W1_L20_m2__nf1_gboth_sdfull_pc/B.n131 nfet_01v8_lvt_W1_L20_m2__nf1_gboth_sdfull_pc/B.n29 498.668
R305 nfet_01v8_lvt_W1_L20_m2__nf1_gboth_sdfull_pc/B.n131 nfet_01v8_lvt_W1_L20_m2__nf1_gboth_sdfull_pc/B.n33 498.668
R306 nfet_01v8_lvt_W1_L20_m2__nf1_gboth_sdfull_pc/B.n125 nfet_01v8_lvt_W1_L20_m2__nf1_gboth_sdfull_pc/B.n33 498.668
R307 nfet_01v8_lvt_W1_L20_m2__nf1_gboth_sdfull_pc/B.n125 nfet_01v8_lvt_W1_L20_m2__nf1_gboth_sdfull_pc/B.n37 498.668
R308 nfet_01v8_lvt_W1_L20_m2__nf1_gboth_sdfull_pc/B.n119 nfet_01v8_lvt_W1_L20_m2__nf1_gboth_sdfull_pc/B.n37 498.668
R309 nfet_01v8_lvt_W1_L20_m2__nf1_gboth_sdfull_pc/B.n119 nfet_01v8_lvt_W1_L20_m2__nf1_gboth_sdfull_pc/B.n41 498.668
R310 nfet_01v8_lvt_W1_L20_m2__nf1_gboth_sdfull_pc/B.n113 nfet_01v8_lvt_W1_L20_m2__nf1_gboth_sdfull_pc/B.n41 498.668
R311 nfet_01v8_lvt_W1_L20_m2__nf1_gboth_sdfull_pc/B.n113 nfet_01v8_lvt_W1_L20_m2__nf1_gboth_sdfull_pc/B.n45 498.668
R312 nfet_01v8_lvt_W1_L20_m2__nf1_gboth_sdfull_pc/B.n107 nfet_01v8_lvt_W1_L20_m2__nf1_gboth_sdfull_pc/B.n45 498.668
R313 nfet_01v8_lvt_W1_L20_m2__nf1_gboth_sdfull_pc/B.n107 nfet_01v8_lvt_W1_L20_m2__nf1_gboth_sdfull_pc/B.n49 498.668
R314 nfet_01v8_lvt_W1_L20_m2__nf1_gboth_sdfull_pc/B.n101 nfet_01v8_lvt_W1_L20_m2__nf1_gboth_sdfull_pc/B.n49 498.668
R315 nfet_01v8_lvt_W1_L20_m2__nf1_gboth_sdfull_pc/B.n101 nfet_01v8_lvt_W1_L20_m2__nf1_gboth_sdfull_pc/B.n53 498.668
R316 nfet_01v8_lvt_W1_L20_m2__nf1_gboth_sdfull_pc/B.n95 nfet_01v8_lvt_W1_L20_m2__nf1_gboth_sdfull_pc/B.n53 498.668
R317 nfet_01v8_lvt_W1_L20_m2__nf1_gboth_sdfull_pc/B.n95 nfet_01v8_lvt_W1_L20_m2__nf1_gboth_sdfull_pc/B.n57 498.668
R318 nfet_01v8_lvt_W1_L20_m2__nf1_gboth_sdfull_pc/B.n89 nfet_01v8_lvt_W1_L20_m2__nf1_gboth_sdfull_pc/B.n57 498.668
R319 nfet_01v8_lvt_W1_L20_m2__nf1_gboth_sdfull_pc/B.n89 nfet_01v8_lvt_W1_L20_m2__nf1_gboth_sdfull_pc/B.n61 498.668
R320 nfet_01v8_lvt_W1_L20_m2__nf1_gboth_sdfull_pc/B.n83 nfet_01v8_lvt_W1_L20_m2__nf1_gboth_sdfull_pc/B.n61 498.668
R321 nfet_01v8_lvt_W1_L20_m2__nf1_gboth_sdfull_pc/B.n83 nfet_01v8_lvt_W1_L20_m2__nf1_gboth_sdfull_pc/B.n65 498.668
R322 nfet_01v8_lvt_W1_L20_m2__nf1_gboth_sdfull_pc/B.n263 nfet_01v8_lvt_W1_L20_m2__nf1_gboth_sdfull_pc/B.n223 394
R323 nfet_01v8_lvt_W1_L20_m2__nf1_gboth_sdfull_pc/B.n263 nfet_01v8_lvt_W1_L20_m2__nf1_gboth_sdfull_pc/B.n221 394
R324 nfet_01v8_lvt_W1_L20_m2__nf1_gboth_sdfull_pc/B.n258 nfet_01v8_lvt_W1_L20_m2__nf1_gboth_sdfull_pc/B.n217 394
R325 nfet_01v8_lvt_W1_L20_m2__nf1_gboth_sdfull_pc/B.n217 nfet_01v8_lvt_W1_L20_m2__nf1_gboth_sdfull_pc/B.n216 394
R326 nfet_01v8_lvt_W1_L20_m2__nf1_gboth_sdfull_pc/B.n216 nfet_01v8_lvt_W1_L20_m2__nf1_gboth_sdfull_pc/B.n215 394
R327 nfet_01v8_lvt_W1_L20_m2__nf1_gboth_sdfull_pc/B.n252 nfet_01v8_lvt_W1_L20_m2__nf1_gboth_sdfull_pc/B.n215 394
R328 nfet_01v8_lvt_W1_L20_m2__nf1_gboth_sdfull_pc/B.n252 nfet_01v8_lvt_W1_L20_m2__nf1_gboth_sdfull_pc/B.n210 394
R329 nfet_01v8_lvt_W1_L20_m2__nf1_gboth_sdfull_pc/B.n210 nfet_01v8_lvt_W1_L20_m2__nf1_gboth_sdfull_pc/B.n209 394
R330 nfet_01v8_lvt_W1_L20_m2__nf1_gboth_sdfull_pc/B.n209 nfet_01v8_lvt_W1_L20_m2__nf1_gboth_sdfull_pc/B.n208 394
R331 nfet_01v8_lvt_W1_L20_m2__nf1_gboth_sdfull_pc/B.n247 nfet_01v8_lvt_W1_L20_m2__nf1_gboth_sdfull_pc/B.n208 394
R332 nfet_01v8_lvt_W1_L20_m2__nf1_gboth_sdfull_pc/B.n247 nfet_01v8_lvt_W1_L20_m2__nf1_gboth_sdfull_pc/B.n203 394
R333 nfet_01v8_lvt_W1_L20_m2__nf1_gboth_sdfull_pc/B.n203 nfet_01v8_lvt_W1_L20_m2__nf1_gboth_sdfull_pc/B.n202 394
R334 nfet_01v8_lvt_W1_L20_m2__nf1_gboth_sdfull_pc/B.n202 nfet_01v8_lvt_W1_L20_m2__nf1_gboth_sdfull_pc/B.n201 394
R335 nfet_01v8_lvt_W1_L20_m2__nf1_gboth_sdfull_pc/B.n242 nfet_01v8_lvt_W1_L20_m2__nf1_gboth_sdfull_pc/B.n201 394
R336 nfet_01v8_lvt_W1_L20_m2__nf1_gboth_sdfull_pc/B.n242 nfet_01v8_lvt_W1_L20_m2__nf1_gboth_sdfull_pc/B.n196 394
R337 nfet_01v8_lvt_W1_L20_m2__nf1_gboth_sdfull_pc/B.n196 nfet_01v8_lvt_W1_L20_m2__nf1_gboth_sdfull_pc/B.n195 394
R338 nfet_01v8_lvt_W1_L20_m2__nf1_gboth_sdfull_pc/B.n195 nfet_01v8_lvt_W1_L20_m2__nf1_gboth_sdfull_pc/B.n194 394
R339 nfet_01v8_lvt_W1_L20_m2__nf1_gboth_sdfull_pc/B.n237 nfet_01v8_lvt_W1_L20_m2__nf1_gboth_sdfull_pc/B.n194 394
R340 nfet_01v8_lvt_W1_L20_m2__nf1_gboth_sdfull_pc/B.n237 nfet_01v8_lvt_W1_L20_m2__nf1_gboth_sdfull_pc/B.n189 394
R341 nfet_01v8_lvt_W1_L20_m2__nf1_gboth_sdfull_pc/B.n189 nfet_01v8_lvt_W1_L20_m2__nf1_gboth_sdfull_pc/B.n188 394
R342 nfet_01v8_lvt_W1_L20_m2__nf1_gboth_sdfull_pc/B.n188 nfet_01v8_lvt_W1_L20_m2__nf1_gboth_sdfull_pc/B.n187 394
R343 nfet_01v8_lvt_W1_L20_m2__nf1_gboth_sdfull_pc/B.n232 nfet_01v8_lvt_W1_L20_m2__nf1_gboth_sdfull_pc/B.n187 394
R344 nfet_01v8_lvt_W1_L20_m2__nf1_gboth_sdfull_pc/B.n232 nfet_01v8_lvt_W1_L20_m2__nf1_gboth_sdfull_pc/B.n182 394
R345 nfet_01v8_lvt_W1_L20_m2__nf1_gboth_sdfull_pc/B.n182 nfet_01v8_lvt_W1_L20_m2__nf1_gboth_sdfull_pc/B.n181 394
R346 nfet_01v8_lvt_W1_L20_m2__nf1_gboth_sdfull_pc/B.n181 nfet_01v8_lvt_W1_L20_m2__nf1_gboth_sdfull_pc/B.n180 394
R347 nfet_01v8_lvt_W1_L20_m2__nf1_gboth_sdfull_pc/B.n227 nfet_01v8_lvt_W1_L20_m2__nf1_gboth_sdfull_pc/B.n180 394
R348 nfet_01v8_lvt_W1_L20_m2__nf1_gboth_sdfull_pc/B.n227 nfet_01v8_lvt_W1_L20_m2__nf1_gboth_sdfull_pc/B.n175 394
R349 nfet_01v8_lvt_W1_L20_m2__nf1_gboth_sdfull_pc/B.n175 nfet_01v8_lvt_W1_L20_m2__nf1_gboth_sdfull_pc/B.n174 394
R350 nfet_01v8_lvt_W1_L20_m2__nf1_gboth_sdfull_pc/B.n174 nfet_01v8_lvt_W1_L20_m2__nf1_gboth_sdfull_pc/B.n173 394
R351 nfet_01v8_lvt_W1_L20_m2__nf1_gboth_sdfull_pc/B.n173 nfet_01v8_lvt_W1_L20_m2__nf1_gboth_sdfull_pc/B.n3 394
R352 nfet_01v8_lvt_W1_L20_m2__nf1_gboth_sdfull_pc/B.n328 nfet_01v8_lvt_W1_L20_m2__nf1_gboth_sdfull_pc/B.n3 394
R353 nfet_01v8_lvt_W1_L20_m2__nf1_gboth_sdfull_pc/B.n328 nfet_01v8_lvt_W1_L20_m2__nf1_gboth_sdfull_pc/B.n2 394
R354 nfet_01v8_lvt_W1_L20_m2__nf1_gboth_sdfull_pc/B.n166 nfet_01v8_lvt_W1_L20_m2__nf1_gboth_sdfull_pc/B.n2 394
R355 nfet_01v8_lvt_W1_L20_m2__nf1_gboth_sdfull_pc/B.n166 nfet_01v8_lvt_W1_L20_m2__nf1_gboth_sdfull_pc/B.n10 394
R356 nfet_01v8_lvt_W1_L20_m2__nf1_gboth_sdfull_pc/B.n162 nfet_01v8_lvt_W1_L20_m2__nf1_gboth_sdfull_pc/B.n10 394
R357 nfet_01v8_lvt_W1_L20_m2__nf1_gboth_sdfull_pc/B.n162 nfet_01v8_lvt_W1_L20_m2__nf1_gboth_sdfull_pc/B.n12 394
R358 nfet_01v8_lvt_W1_L20_m2__nf1_gboth_sdfull_pc/B.n154 nfet_01v8_lvt_W1_L20_m2__nf1_gboth_sdfull_pc/B.n12 394
R359 nfet_01v8_lvt_W1_L20_m2__nf1_gboth_sdfull_pc/B.n154 nfet_01v8_lvt_W1_L20_m2__nf1_gboth_sdfull_pc/B.n18 394
R360 nfet_01v8_lvt_W1_L20_m2__nf1_gboth_sdfull_pc/B.n150 nfet_01v8_lvt_W1_L20_m2__nf1_gboth_sdfull_pc/B.n18 394
R361 nfet_01v8_lvt_W1_L20_m2__nf1_gboth_sdfull_pc/B.n150 nfet_01v8_lvt_W1_L20_m2__nf1_gboth_sdfull_pc/B.n20 394
R362 nfet_01v8_lvt_W1_L20_m2__nf1_gboth_sdfull_pc/B.n142 nfet_01v8_lvt_W1_L20_m2__nf1_gboth_sdfull_pc/B.n20 394
R363 nfet_01v8_lvt_W1_L20_m2__nf1_gboth_sdfull_pc/B.n142 nfet_01v8_lvt_W1_L20_m2__nf1_gboth_sdfull_pc/B.n26 394
R364 nfet_01v8_lvt_W1_L20_m2__nf1_gboth_sdfull_pc/B.n138 nfet_01v8_lvt_W1_L20_m2__nf1_gboth_sdfull_pc/B.n26 394
R365 nfet_01v8_lvt_W1_L20_m2__nf1_gboth_sdfull_pc/B.n138 nfet_01v8_lvt_W1_L20_m2__nf1_gboth_sdfull_pc/B.n28 394
R366 nfet_01v8_lvt_W1_L20_m2__nf1_gboth_sdfull_pc/B.n130 nfet_01v8_lvt_W1_L20_m2__nf1_gboth_sdfull_pc/B.n28 394
R367 nfet_01v8_lvt_W1_L20_m2__nf1_gboth_sdfull_pc/B.n130 nfet_01v8_lvt_W1_L20_m2__nf1_gboth_sdfull_pc/B.n34 394
R368 nfet_01v8_lvt_W1_L20_m2__nf1_gboth_sdfull_pc/B.n126 nfet_01v8_lvt_W1_L20_m2__nf1_gboth_sdfull_pc/B.n34 394
R369 nfet_01v8_lvt_W1_L20_m2__nf1_gboth_sdfull_pc/B.n126 nfet_01v8_lvt_W1_L20_m2__nf1_gboth_sdfull_pc/B.n36 394
R370 nfet_01v8_lvt_W1_L20_m2__nf1_gboth_sdfull_pc/B.n118 nfet_01v8_lvt_W1_L20_m2__nf1_gboth_sdfull_pc/B.n36 394
R371 nfet_01v8_lvt_W1_L20_m2__nf1_gboth_sdfull_pc/B.n118 nfet_01v8_lvt_W1_L20_m2__nf1_gboth_sdfull_pc/B.n42 394
R372 nfet_01v8_lvt_W1_L20_m2__nf1_gboth_sdfull_pc/B.n114 nfet_01v8_lvt_W1_L20_m2__nf1_gboth_sdfull_pc/B.n42 394
R373 nfet_01v8_lvt_W1_L20_m2__nf1_gboth_sdfull_pc/B.n114 nfet_01v8_lvt_W1_L20_m2__nf1_gboth_sdfull_pc/B.n44 394
R374 nfet_01v8_lvt_W1_L20_m2__nf1_gboth_sdfull_pc/B.n106 nfet_01v8_lvt_W1_L20_m2__nf1_gboth_sdfull_pc/B.n44 394
R375 nfet_01v8_lvt_W1_L20_m2__nf1_gboth_sdfull_pc/B.n106 nfet_01v8_lvt_W1_L20_m2__nf1_gboth_sdfull_pc/B.n50 394
R376 nfet_01v8_lvt_W1_L20_m2__nf1_gboth_sdfull_pc/B.n102 nfet_01v8_lvt_W1_L20_m2__nf1_gboth_sdfull_pc/B.n50 394
R377 nfet_01v8_lvt_W1_L20_m2__nf1_gboth_sdfull_pc/B.n102 nfet_01v8_lvt_W1_L20_m2__nf1_gboth_sdfull_pc/B.n52 394
R378 nfet_01v8_lvt_W1_L20_m2__nf1_gboth_sdfull_pc/B.n94 nfet_01v8_lvt_W1_L20_m2__nf1_gboth_sdfull_pc/B.n52 394
R379 nfet_01v8_lvt_W1_L20_m2__nf1_gboth_sdfull_pc/B.n94 nfet_01v8_lvt_W1_L20_m2__nf1_gboth_sdfull_pc/B.n58 394
R380 nfet_01v8_lvt_W1_L20_m2__nf1_gboth_sdfull_pc/B.n90 nfet_01v8_lvt_W1_L20_m2__nf1_gboth_sdfull_pc/B.n58 394
R381 nfet_01v8_lvt_W1_L20_m2__nf1_gboth_sdfull_pc/B.n90 nfet_01v8_lvt_W1_L20_m2__nf1_gboth_sdfull_pc/B.n60 394
R382 nfet_01v8_lvt_W1_L20_m2__nf1_gboth_sdfull_pc/B.n82 nfet_01v8_lvt_W1_L20_m2__nf1_gboth_sdfull_pc/B.n60 394
R383 nfet_01v8_lvt_W1_L20_m2__nf1_gboth_sdfull_pc/B.n82 nfet_01v8_lvt_W1_L20_m2__nf1_gboth_sdfull_pc/B.n66 394
R384 nfet_01v8_lvt_W1_L20_m2__nf1_gboth_sdfull_pc/B.n71 nfet_01v8_lvt_W1_L20_m2__nf1_gboth_sdfull_pc/B.n68 394
R385 nfet_01v8_lvt_W1_L20_m2__nf1_gboth_sdfull_pc/B.n75 nfet_01v8_lvt_W1_L20_m2__nf1_gboth_sdfull_pc/B.n70 394
R386 nfet_01v8_lvt_W1_L20_m2__nf1_gboth_sdfull_pc/B.n270 nfet_01v8_lvt_W1_L20_m2__nf1_gboth_sdfull_pc/B.n219 394
R387 nfet_01v8_lvt_W1_L20_m2__nf1_gboth_sdfull_pc/B.n270 nfet_01v8_lvt_W1_L20_m2__nf1_gboth_sdfull_pc/B.n214 394
R388 nfet_01v8_lvt_W1_L20_m2__nf1_gboth_sdfull_pc/B.n274 nfet_01v8_lvt_W1_L20_m2__nf1_gboth_sdfull_pc/B.n214 394
R389 nfet_01v8_lvt_W1_L20_m2__nf1_gboth_sdfull_pc/B.n274 nfet_01v8_lvt_W1_L20_m2__nf1_gboth_sdfull_pc/B.n212 394
R390 nfet_01v8_lvt_W1_L20_m2__nf1_gboth_sdfull_pc/B.n278 nfet_01v8_lvt_W1_L20_m2__nf1_gboth_sdfull_pc/B.n212 394
R391 nfet_01v8_lvt_W1_L20_m2__nf1_gboth_sdfull_pc/B.n278 nfet_01v8_lvt_W1_L20_m2__nf1_gboth_sdfull_pc/B.n207 394
R392 nfet_01v8_lvt_W1_L20_m2__nf1_gboth_sdfull_pc/B.n282 nfet_01v8_lvt_W1_L20_m2__nf1_gboth_sdfull_pc/B.n207 394
R393 nfet_01v8_lvt_W1_L20_m2__nf1_gboth_sdfull_pc/B.n282 nfet_01v8_lvt_W1_L20_m2__nf1_gboth_sdfull_pc/B.n205 394
R394 nfet_01v8_lvt_W1_L20_m2__nf1_gboth_sdfull_pc/B.n286 nfet_01v8_lvt_W1_L20_m2__nf1_gboth_sdfull_pc/B.n205 394
R395 nfet_01v8_lvt_W1_L20_m2__nf1_gboth_sdfull_pc/B.n286 nfet_01v8_lvt_W1_L20_m2__nf1_gboth_sdfull_pc/B.n200 394
R396 nfet_01v8_lvt_W1_L20_m2__nf1_gboth_sdfull_pc/B.n290 nfet_01v8_lvt_W1_L20_m2__nf1_gboth_sdfull_pc/B.n200 394
R397 nfet_01v8_lvt_W1_L20_m2__nf1_gboth_sdfull_pc/B.n290 nfet_01v8_lvt_W1_L20_m2__nf1_gboth_sdfull_pc/B.n198 394
R398 nfet_01v8_lvt_W1_L20_m2__nf1_gboth_sdfull_pc/B.n294 nfet_01v8_lvt_W1_L20_m2__nf1_gboth_sdfull_pc/B.n198 394
R399 nfet_01v8_lvt_W1_L20_m2__nf1_gboth_sdfull_pc/B.n294 nfet_01v8_lvt_W1_L20_m2__nf1_gboth_sdfull_pc/B.n193 394
R400 nfet_01v8_lvt_W1_L20_m2__nf1_gboth_sdfull_pc/B.n298 nfet_01v8_lvt_W1_L20_m2__nf1_gboth_sdfull_pc/B.n193 394
R401 nfet_01v8_lvt_W1_L20_m2__nf1_gboth_sdfull_pc/B.n298 nfet_01v8_lvt_W1_L20_m2__nf1_gboth_sdfull_pc/B.n191 394
R402 nfet_01v8_lvt_W1_L20_m2__nf1_gboth_sdfull_pc/B.n302 nfet_01v8_lvt_W1_L20_m2__nf1_gboth_sdfull_pc/B.n191 394
R403 nfet_01v8_lvt_W1_L20_m2__nf1_gboth_sdfull_pc/B.n302 nfet_01v8_lvt_W1_L20_m2__nf1_gboth_sdfull_pc/B.n186 394
R404 nfet_01v8_lvt_W1_L20_m2__nf1_gboth_sdfull_pc/B.n306 nfet_01v8_lvt_W1_L20_m2__nf1_gboth_sdfull_pc/B.n186 394
R405 nfet_01v8_lvt_W1_L20_m2__nf1_gboth_sdfull_pc/B.n306 nfet_01v8_lvt_W1_L20_m2__nf1_gboth_sdfull_pc/B.n184 394
R406 nfet_01v8_lvt_W1_L20_m2__nf1_gboth_sdfull_pc/B.n310 nfet_01v8_lvt_W1_L20_m2__nf1_gboth_sdfull_pc/B.n184 394
R407 nfet_01v8_lvt_W1_L20_m2__nf1_gboth_sdfull_pc/B.n310 nfet_01v8_lvt_W1_L20_m2__nf1_gboth_sdfull_pc/B.n179 394
R408 nfet_01v8_lvt_W1_L20_m2__nf1_gboth_sdfull_pc/B.n314 nfet_01v8_lvt_W1_L20_m2__nf1_gboth_sdfull_pc/B.n179 394
R409 nfet_01v8_lvt_W1_L20_m2__nf1_gboth_sdfull_pc/B.n314 nfet_01v8_lvt_W1_L20_m2__nf1_gboth_sdfull_pc/B.n177 394
R410 nfet_01v8_lvt_W1_L20_m2__nf1_gboth_sdfull_pc/B.n318 nfet_01v8_lvt_W1_L20_m2__nf1_gboth_sdfull_pc/B.n177 394
R411 nfet_01v8_lvt_W1_L20_m2__nf1_gboth_sdfull_pc/B.n318 nfet_01v8_lvt_W1_L20_m2__nf1_gboth_sdfull_pc/B.n172 394
R412 nfet_01v8_lvt_W1_L20_m2__nf1_gboth_sdfull_pc/B.n322 nfet_01v8_lvt_W1_L20_m2__nf1_gboth_sdfull_pc/B.n172 394
R413 nfet_01v8_lvt_W1_L20_m2__nf1_gboth_sdfull_pc/B.n322 nfet_01v8_lvt_W1_L20_m2__nf1_gboth_sdfull_pc/B.n6 394
R414 nfet_01v8_lvt_W1_L20_m2__nf1_gboth_sdfull_pc/B.n326 nfet_01v8_lvt_W1_L20_m2__nf1_gboth_sdfull_pc/B.n6 394
R415 nfet_01v8_lvt_W1_L20_m2__nf1_gboth_sdfull_pc/B.n326 nfet_01v8_lvt_W1_L20_m2__nf1_gboth_sdfull_pc/B.n5 394
R416 nfet_01v8_lvt_W1_L20_m2__nf1_gboth_sdfull_pc/B.n168 nfet_01v8_lvt_W1_L20_m2__nf1_gboth_sdfull_pc/B.n5 394
R417 nfet_01v8_lvt_W1_L20_m2__nf1_gboth_sdfull_pc/B.n168 nfet_01v8_lvt_W1_L20_m2__nf1_gboth_sdfull_pc/B.n8 394
R418 nfet_01v8_lvt_W1_L20_m2__nf1_gboth_sdfull_pc/B.n160 nfet_01v8_lvt_W1_L20_m2__nf1_gboth_sdfull_pc/B.n8 394
R419 nfet_01v8_lvt_W1_L20_m2__nf1_gboth_sdfull_pc/B.n160 nfet_01v8_lvt_W1_L20_m2__nf1_gboth_sdfull_pc/B.n14 394
R420 nfet_01v8_lvt_W1_L20_m2__nf1_gboth_sdfull_pc/B.n156 nfet_01v8_lvt_W1_L20_m2__nf1_gboth_sdfull_pc/B.n14 394
R421 nfet_01v8_lvt_W1_L20_m2__nf1_gboth_sdfull_pc/B.n156 nfet_01v8_lvt_W1_L20_m2__nf1_gboth_sdfull_pc/B.n16 394
R422 nfet_01v8_lvt_W1_L20_m2__nf1_gboth_sdfull_pc/B.n148 nfet_01v8_lvt_W1_L20_m2__nf1_gboth_sdfull_pc/B.n16 394
R423 nfet_01v8_lvt_W1_L20_m2__nf1_gboth_sdfull_pc/B.n148 nfet_01v8_lvt_W1_L20_m2__nf1_gboth_sdfull_pc/B.n22 394
R424 nfet_01v8_lvt_W1_L20_m2__nf1_gboth_sdfull_pc/B.n144 nfet_01v8_lvt_W1_L20_m2__nf1_gboth_sdfull_pc/B.n22 394
R425 nfet_01v8_lvt_W1_L20_m2__nf1_gboth_sdfull_pc/B.n144 nfet_01v8_lvt_W1_L20_m2__nf1_gboth_sdfull_pc/B.n24 394
R426 nfet_01v8_lvt_W1_L20_m2__nf1_gboth_sdfull_pc/B.n136 nfet_01v8_lvt_W1_L20_m2__nf1_gboth_sdfull_pc/B.n24 394
R427 nfet_01v8_lvt_W1_L20_m2__nf1_gboth_sdfull_pc/B.n136 nfet_01v8_lvt_W1_L20_m2__nf1_gboth_sdfull_pc/B.n30 394
R428 nfet_01v8_lvt_W1_L20_m2__nf1_gboth_sdfull_pc/B.n132 nfet_01v8_lvt_W1_L20_m2__nf1_gboth_sdfull_pc/B.n30 394
R429 nfet_01v8_lvt_W1_L20_m2__nf1_gboth_sdfull_pc/B.n132 nfet_01v8_lvt_W1_L20_m2__nf1_gboth_sdfull_pc/B.n32 394
R430 nfet_01v8_lvt_W1_L20_m2__nf1_gboth_sdfull_pc/B.n124 nfet_01v8_lvt_W1_L20_m2__nf1_gboth_sdfull_pc/B.n32 394
R431 nfet_01v8_lvt_W1_L20_m2__nf1_gboth_sdfull_pc/B.n124 nfet_01v8_lvt_W1_L20_m2__nf1_gboth_sdfull_pc/B.n38 394
R432 nfet_01v8_lvt_W1_L20_m2__nf1_gboth_sdfull_pc/B.n120 nfet_01v8_lvt_W1_L20_m2__nf1_gboth_sdfull_pc/B.n38 394
R433 nfet_01v8_lvt_W1_L20_m2__nf1_gboth_sdfull_pc/B.n120 nfet_01v8_lvt_W1_L20_m2__nf1_gboth_sdfull_pc/B.n40 394
R434 nfet_01v8_lvt_W1_L20_m2__nf1_gboth_sdfull_pc/B.n112 nfet_01v8_lvt_W1_L20_m2__nf1_gboth_sdfull_pc/B.n40 394
R435 nfet_01v8_lvt_W1_L20_m2__nf1_gboth_sdfull_pc/B.n112 nfet_01v8_lvt_W1_L20_m2__nf1_gboth_sdfull_pc/B.n46 394
R436 nfet_01v8_lvt_W1_L20_m2__nf1_gboth_sdfull_pc/B.n108 nfet_01v8_lvt_W1_L20_m2__nf1_gboth_sdfull_pc/B.n46 394
R437 nfet_01v8_lvt_W1_L20_m2__nf1_gboth_sdfull_pc/B.n108 nfet_01v8_lvt_W1_L20_m2__nf1_gboth_sdfull_pc/B.n48 394
R438 nfet_01v8_lvt_W1_L20_m2__nf1_gboth_sdfull_pc/B.n100 nfet_01v8_lvt_W1_L20_m2__nf1_gboth_sdfull_pc/B.n48 394
R439 nfet_01v8_lvt_W1_L20_m2__nf1_gboth_sdfull_pc/B.n100 nfet_01v8_lvt_W1_L20_m2__nf1_gboth_sdfull_pc/B.n54 394
R440 nfet_01v8_lvt_W1_L20_m2__nf1_gboth_sdfull_pc/B.n96 nfet_01v8_lvt_W1_L20_m2__nf1_gboth_sdfull_pc/B.n54 394
R441 nfet_01v8_lvt_W1_L20_m2__nf1_gboth_sdfull_pc/B.n96 nfet_01v8_lvt_W1_L20_m2__nf1_gboth_sdfull_pc/B.n56 394
R442 nfet_01v8_lvt_W1_L20_m2__nf1_gboth_sdfull_pc/B.n88 nfet_01v8_lvt_W1_L20_m2__nf1_gboth_sdfull_pc/B.n56 394
R443 nfet_01v8_lvt_W1_L20_m2__nf1_gboth_sdfull_pc/B.n88 nfet_01v8_lvt_W1_L20_m2__nf1_gboth_sdfull_pc/B.n62 394
R444 nfet_01v8_lvt_W1_L20_m2__nf1_gboth_sdfull_pc/B.n84 nfet_01v8_lvt_W1_L20_m2__nf1_gboth_sdfull_pc/B.n62 394
R445 nfet_01v8_lvt_W1_L20_m2__nf1_gboth_sdfull_pc/B.n84 nfet_01v8_lvt_W1_L20_m2__nf1_gboth_sdfull_pc/B.n64 394
R446 nfet_01v8_lvt_W1_L20_m2__nf1_gboth_sdfull_pc/B.n264 B 315.334
R447 nfet_01v8_lvt_W1_L20_m2__nf1_gboth_sdfull_pc/B.n76 nfet_01v8_lvt_W1_L20_m2__nf1_gboth_sdfull_pc/B.n69 218.815
R448 nfet_01v8_lvt_W1_L20_m2__nf1_gboth_sdfull_pc/B.n77 nfet_01v8_lvt_W1_L20_m2__nf1_gboth_sdfull_pc/B.n76 218.815
R449 nfet_01v8_lvt_W1_L20_m2__nf1_gboth_sdfull_pc/B.n264 nfet_01v8_lvt_W1_L20_m2__nf1_gboth_sdfull_pc/B.n222 218.815
R450 nfet_01v8_lvt_W1_L20_m2__nf1_gboth_sdfull_pc/B.n265 nfet_01v8_lvt_W1_L20_m2__nf1_gboth_sdfull_pc/B.n264 218.815
R451 nfet_01v8_lvt_W1_L20_m2__nf1_gboth_sdfull_pc/B.n70 nfet_01v8_lvt_W1_L20_m2__nf1_gboth_sdfull_pc/B.n69 147.374
R452 nfet_01v8_lvt_W1_L20_m2__nf1_gboth_sdfull_pc/B.n77 nfet_01v8_lvt_W1_L20_m2__nf1_gboth_sdfull_pc/B.n68 147.374
R453 nfet_01v8_lvt_W1_L20_m2__nf1_gboth_sdfull_pc/B.n259 nfet_01v8_lvt_W1_L20_m2__nf1_gboth_sdfull_pc/B.n222 147.374
R454 nfet_01v8_lvt_W1_L20_m2__nf1_gboth_sdfull_pc/B.n265 nfet_01v8_lvt_W1_L20_m2__nf1_gboth_sdfull_pc/B.n221 147.374
R455 nfet_01v8_lvt_W1_L20_m2__nf1_gboth_sdfull_pc/B.n223 nfet_01v8_lvt_W1_L20_m2__nf1_gboth_sdfull_pc/B.n222 147.374
R456 nfet_01v8_lvt_W1_L20_m2__nf1_gboth_sdfull_pc/B.n266 nfet_01v8_lvt_W1_L20_m2__nf1_gboth_sdfull_pc/B.n265 147.374
R457 nfet_01v8_lvt_W1_L20_m2__nf1_gboth_sdfull_pc/B.n78 nfet_01v8_lvt_W1_L20_m2__nf1_gboth_sdfull_pc/B.n77 147.374
R458 nfet_01v8_lvt_W1_L20_m2__nf1_gboth_sdfull_pc/B.n71 nfet_01v8_lvt_W1_L20_m2__nf1_gboth_sdfull_pc/B.n69 147.374
R459 nfet_01v8_lvt_W1_L20_m2__nf1_gboth_sdfull_pc/B.n260 nfet_01v8_lvt_W1_L20_m2__nf1_gboth_sdfull_pc/B.n257 77.9299
R460 nfet_01v8_lvt_W1_L20_m2__nf1_gboth_sdfull_pc/B.n80 nfet_01v8_lvt_W1_L20_m2__nf1_gboth_sdfull_pc/B.n79 77.9299
R461 nfet_01v8_lvt_W1_L20_m2__nf1_gboth_sdfull_pc/B.n268 nfet_01v8_lvt_W1_L20_m2__nf1_gboth_sdfull_pc/B.n267 77.9299
R462 nfet_01v8_lvt_W1_L20_m2__nf1_gboth_sdfull_pc/B.n74 nfet_01v8_lvt_W1_L20_m2__nf1_gboth_sdfull_pc/B.n63 77.9299
R463 nfet_01v8_lvt_W1_L20_m2__nf1_gboth_sdfull_pc/B.n261 nfet_01v8_lvt_W1_L20_m2__nf1_gboth_sdfull_pc/B.n260 25.6005
R464 nfet_01v8_lvt_W1_L20_m2__nf1_gboth_sdfull_pc/B.n262 nfet_01v8_lvt_W1_L20_m2__nf1_gboth_sdfull_pc/B.n261 25.6005
R465 nfet_01v8_lvt_W1_L20_m2__nf1_gboth_sdfull_pc/B.n262 nfet_01v8_lvt_W1_L20_m2__nf1_gboth_sdfull_pc/B.n220 25.6005
R466 nfet_01v8_lvt_W1_L20_m2__nf1_gboth_sdfull_pc/B.n267 nfet_01v8_lvt_W1_L20_m2__nf1_gboth_sdfull_pc/B.n220 25.6005
R467 nfet_01v8_lvt_W1_L20_m2__nf1_gboth_sdfull_pc/B.n257 nfet_01v8_lvt_W1_L20_m2__nf1_gboth_sdfull_pc/B.n256 25.6005
R468 nfet_01v8_lvt_W1_L20_m2__nf1_gboth_sdfull_pc/B.n256 nfet_01v8_lvt_W1_L20_m2__nf1_gboth_sdfull_pc/B.n255 25.6005
R469 nfet_01v8_lvt_W1_L20_m2__nf1_gboth_sdfull_pc/B.n255 nfet_01v8_lvt_W1_L20_m2__nf1_gboth_sdfull_pc/B.n254 25.6005
R470 nfet_01v8_lvt_W1_L20_m2__nf1_gboth_sdfull_pc/B.n254 nfet_01v8_lvt_W1_L20_m2__nf1_gboth_sdfull_pc/B.n253 25.6005
R471 nfet_01v8_lvt_W1_L20_m2__nf1_gboth_sdfull_pc/B.n253 nfet_01v8_lvt_W1_L20_m2__nf1_gboth_sdfull_pc/B.n251 25.6005
R472 nfet_01v8_lvt_W1_L20_m2__nf1_gboth_sdfull_pc/B.n251 nfet_01v8_lvt_W1_L20_m2__nf1_gboth_sdfull_pc/B.n250 25.6005
R473 nfet_01v8_lvt_W1_L20_m2__nf1_gboth_sdfull_pc/B.n250 nfet_01v8_lvt_W1_L20_m2__nf1_gboth_sdfull_pc/B.n249 25.6005
R474 nfet_01v8_lvt_W1_L20_m2__nf1_gboth_sdfull_pc/B.n249 nfet_01v8_lvt_W1_L20_m2__nf1_gboth_sdfull_pc/B.n248 25.6005
R475 nfet_01v8_lvt_W1_L20_m2__nf1_gboth_sdfull_pc/B.n248 nfet_01v8_lvt_W1_L20_m2__nf1_gboth_sdfull_pc/B.n246 25.6005
R476 nfet_01v8_lvt_W1_L20_m2__nf1_gboth_sdfull_pc/B.n246 nfet_01v8_lvt_W1_L20_m2__nf1_gboth_sdfull_pc/B.n245 25.6005
R477 nfet_01v8_lvt_W1_L20_m2__nf1_gboth_sdfull_pc/B.n245 nfet_01v8_lvt_W1_L20_m2__nf1_gboth_sdfull_pc/B.n244 25.6005
R478 nfet_01v8_lvt_W1_L20_m2__nf1_gboth_sdfull_pc/B.n244 nfet_01v8_lvt_W1_L20_m2__nf1_gboth_sdfull_pc/B.n243 25.6005
R479 nfet_01v8_lvt_W1_L20_m2__nf1_gboth_sdfull_pc/B.n243 nfet_01v8_lvt_W1_L20_m2__nf1_gboth_sdfull_pc/B.n241 25.6005
R480 nfet_01v8_lvt_W1_L20_m2__nf1_gboth_sdfull_pc/B.n241 nfet_01v8_lvt_W1_L20_m2__nf1_gboth_sdfull_pc/B.n240 25.6005
R481 nfet_01v8_lvt_W1_L20_m2__nf1_gboth_sdfull_pc/B.n240 nfet_01v8_lvt_W1_L20_m2__nf1_gboth_sdfull_pc/B.n239 25.6005
R482 nfet_01v8_lvt_W1_L20_m2__nf1_gboth_sdfull_pc/B.n239 nfet_01v8_lvt_W1_L20_m2__nf1_gboth_sdfull_pc/B.n238 25.6005
R483 nfet_01v8_lvt_W1_L20_m2__nf1_gboth_sdfull_pc/B.n238 nfet_01v8_lvt_W1_L20_m2__nf1_gboth_sdfull_pc/B.n236 25.6005
R484 nfet_01v8_lvt_W1_L20_m2__nf1_gboth_sdfull_pc/B.n236 nfet_01v8_lvt_W1_L20_m2__nf1_gboth_sdfull_pc/B.n235 25.6005
R485 nfet_01v8_lvt_W1_L20_m2__nf1_gboth_sdfull_pc/B.n235 nfet_01v8_lvt_W1_L20_m2__nf1_gboth_sdfull_pc/B.n234 25.6005
R486 nfet_01v8_lvt_W1_L20_m2__nf1_gboth_sdfull_pc/B.n234 nfet_01v8_lvt_W1_L20_m2__nf1_gboth_sdfull_pc/B.n233 25.6005
R487 nfet_01v8_lvt_W1_L20_m2__nf1_gboth_sdfull_pc/B.n233 nfet_01v8_lvt_W1_L20_m2__nf1_gboth_sdfull_pc/B.n231 25.6005
R488 nfet_01v8_lvt_W1_L20_m2__nf1_gboth_sdfull_pc/B.n231 nfet_01v8_lvt_W1_L20_m2__nf1_gboth_sdfull_pc/B.n230 25.6005
R489 nfet_01v8_lvt_W1_L20_m2__nf1_gboth_sdfull_pc/B.n230 nfet_01v8_lvt_W1_L20_m2__nf1_gboth_sdfull_pc/B.n229 25.6005
R490 nfet_01v8_lvt_W1_L20_m2__nf1_gboth_sdfull_pc/B.n229 nfet_01v8_lvt_W1_L20_m2__nf1_gboth_sdfull_pc/B.n228 25.6005
R491 nfet_01v8_lvt_W1_L20_m2__nf1_gboth_sdfull_pc/B.n228 nfet_01v8_lvt_W1_L20_m2__nf1_gboth_sdfull_pc/B.n226 25.6005
R492 nfet_01v8_lvt_W1_L20_m2__nf1_gboth_sdfull_pc/B.n226 nfet_01v8_lvt_W1_L20_m2__nf1_gboth_sdfull_pc/B.n225 25.6005
R493 nfet_01v8_lvt_W1_L20_m2__nf1_gboth_sdfull_pc/B.n225 nfet_01v8_lvt_W1_L20_m2__nf1_gboth_sdfull_pc/B.n224 25.6005
R494 nfet_01v8_lvt_W1_L20_m2__nf1_gboth_sdfull_pc/B.n224 nfet_01v8_lvt_W1_L20_m2__nf1_gboth_sdfull_pc/B.n1 25.6005
R495 nfet_01v8_lvt_W1_L20_m2__nf1_gboth_sdfull_pc/B.n329 nfet_01v8_lvt_W1_L20_m2__nf1_gboth_sdfull_pc/B.n1 25.6005
R496 nfet_01v8_lvt_W1_L20_m2__nf1_gboth_sdfull_pc/B.n165 nfet_01v8_lvt_W1_L20_m2__nf1_gboth_sdfull_pc/B.n0 25.6005
R497 nfet_01v8_lvt_W1_L20_m2__nf1_gboth_sdfull_pc/B.n165 nfet_01v8_lvt_W1_L20_m2__nf1_gboth_sdfull_pc/B.n164 25.6005
R498 nfet_01v8_lvt_W1_L20_m2__nf1_gboth_sdfull_pc/B.n164 nfet_01v8_lvt_W1_L20_m2__nf1_gboth_sdfull_pc/B.n163 25.6005
R499 nfet_01v8_lvt_W1_L20_m2__nf1_gboth_sdfull_pc/B.n163 nfet_01v8_lvt_W1_L20_m2__nf1_gboth_sdfull_pc/B.n11 25.6005
R500 nfet_01v8_lvt_W1_L20_m2__nf1_gboth_sdfull_pc/B.n153 nfet_01v8_lvt_W1_L20_m2__nf1_gboth_sdfull_pc/B.n11 25.6005
R501 nfet_01v8_lvt_W1_L20_m2__nf1_gboth_sdfull_pc/B.n153 nfet_01v8_lvt_W1_L20_m2__nf1_gboth_sdfull_pc/B.n152 25.6005
R502 nfet_01v8_lvt_W1_L20_m2__nf1_gboth_sdfull_pc/B.n152 nfet_01v8_lvt_W1_L20_m2__nf1_gboth_sdfull_pc/B.n151 25.6005
R503 nfet_01v8_lvt_W1_L20_m2__nf1_gboth_sdfull_pc/B.n151 nfet_01v8_lvt_W1_L20_m2__nf1_gboth_sdfull_pc/B.n19 25.6005
R504 nfet_01v8_lvt_W1_L20_m2__nf1_gboth_sdfull_pc/B.n141 nfet_01v8_lvt_W1_L20_m2__nf1_gboth_sdfull_pc/B.n19 25.6005
R505 nfet_01v8_lvt_W1_L20_m2__nf1_gboth_sdfull_pc/B.n141 nfet_01v8_lvt_W1_L20_m2__nf1_gboth_sdfull_pc/B.n140 25.6005
R506 nfet_01v8_lvt_W1_L20_m2__nf1_gboth_sdfull_pc/B.n140 nfet_01v8_lvt_W1_L20_m2__nf1_gboth_sdfull_pc/B.n139 25.6005
R507 nfet_01v8_lvt_W1_L20_m2__nf1_gboth_sdfull_pc/B.n139 nfet_01v8_lvt_W1_L20_m2__nf1_gboth_sdfull_pc/B.n27 25.6005
R508 nfet_01v8_lvt_W1_L20_m2__nf1_gboth_sdfull_pc/B.n129 nfet_01v8_lvt_W1_L20_m2__nf1_gboth_sdfull_pc/B.n27 25.6005
R509 nfet_01v8_lvt_W1_L20_m2__nf1_gboth_sdfull_pc/B.n129 nfet_01v8_lvt_W1_L20_m2__nf1_gboth_sdfull_pc/B.n128 25.6005
R510 nfet_01v8_lvt_W1_L20_m2__nf1_gboth_sdfull_pc/B.n128 nfet_01v8_lvt_W1_L20_m2__nf1_gboth_sdfull_pc/B.n127 25.6005
R511 nfet_01v8_lvt_W1_L20_m2__nf1_gboth_sdfull_pc/B.n127 nfet_01v8_lvt_W1_L20_m2__nf1_gboth_sdfull_pc/B.n35 25.6005
R512 nfet_01v8_lvt_W1_L20_m2__nf1_gboth_sdfull_pc/B.n117 nfet_01v8_lvt_W1_L20_m2__nf1_gboth_sdfull_pc/B.n35 25.6005
R513 nfet_01v8_lvt_W1_L20_m2__nf1_gboth_sdfull_pc/B.n117 nfet_01v8_lvt_W1_L20_m2__nf1_gboth_sdfull_pc/B.n116 25.6005
R514 nfet_01v8_lvt_W1_L20_m2__nf1_gboth_sdfull_pc/B.n116 nfet_01v8_lvt_W1_L20_m2__nf1_gboth_sdfull_pc/B.n115 25.6005
R515 nfet_01v8_lvt_W1_L20_m2__nf1_gboth_sdfull_pc/B.n115 nfet_01v8_lvt_W1_L20_m2__nf1_gboth_sdfull_pc/B.n43 25.6005
R516 nfet_01v8_lvt_W1_L20_m2__nf1_gboth_sdfull_pc/B.n105 nfet_01v8_lvt_W1_L20_m2__nf1_gboth_sdfull_pc/B.n43 25.6005
R517 nfet_01v8_lvt_W1_L20_m2__nf1_gboth_sdfull_pc/B.n105 nfet_01v8_lvt_W1_L20_m2__nf1_gboth_sdfull_pc/B.n104 25.6005
R518 nfet_01v8_lvt_W1_L20_m2__nf1_gboth_sdfull_pc/B.n104 nfet_01v8_lvt_W1_L20_m2__nf1_gboth_sdfull_pc/B.n103 25.6005
R519 nfet_01v8_lvt_W1_L20_m2__nf1_gboth_sdfull_pc/B.n103 nfet_01v8_lvt_W1_L20_m2__nf1_gboth_sdfull_pc/B.n51 25.6005
R520 nfet_01v8_lvt_W1_L20_m2__nf1_gboth_sdfull_pc/B.n93 nfet_01v8_lvt_W1_L20_m2__nf1_gboth_sdfull_pc/B.n51 25.6005
R521 nfet_01v8_lvt_W1_L20_m2__nf1_gboth_sdfull_pc/B.n93 nfet_01v8_lvt_W1_L20_m2__nf1_gboth_sdfull_pc/B.n92 25.6005
R522 nfet_01v8_lvt_W1_L20_m2__nf1_gboth_sdfull_pc/B.n92 nfet_01v8_lvt_W1_L20_m2__nf1_gboth_sdfull_pc/B.n91 25.6005
R523 nfet_01v8_lvt_W1_L20_m2__nf1_gboth_sdfull_pc/B.n91 nfet_01v8_lvt_W1_L20_m2__nf1_gboth_sdfull_pc/B.n59 25.6005
R524 nfet_01v8_lvt_W1_L20_m2__nf1_gboth_sdfull_pc/B.n81 nfet_01v8_lvt_W1_L20_m2__nf1_gboth_sdfull_pc/B.n59 25.6005
R525 nfet_01v8_lvt_W1_L20_m2__nf1_gboth_sdfull_pc/B.n81 nfet_01v8_lvt_W1_L20_m2__nf1_gboth_sdfull_pc/B.n80 25.6005
R526 nfet_01v8_lvt_W1_L20_m2__nf1_gboth_sdfull_pc/B.n79 nfet_01v8_lvt_W1_L20_m2__nf1_gboth_sdfull_pc/B.n67 25.6005
R527 nfet_01v8_lvt_W1_L20_m2__nf1_gboth_sdfull_pc/B.n72 nfet_01v8_lvt_W1_L20_m2__nf1_gboth_sdfull_pc/B.n67 25.6005
R528 nfet_01v8_lvt_W1_L20_m2__nf1_gboth_sdfull_pc/B.n73 nfet_01v8_lvt_W1_L20_m2__nf1_gboth_sdfull_pc/B.n72 25.6005
R529 nfet_01v8_lvt_W1_L20_m2__nf1_gboth_sdfull_pc/B.n74 nfet_01v8_lvt_W1_L20_m2__nf1_gboth_sdfull_pc/B.n73 25.6005
R530 nfet_01v8_lvt_W1_L20_m2__nf1_gboth_sdfull_pc/B.n269 nfet_01v8_lvt_W1_L20_m2__nf1_gboth_sdfull_pc/B.n268 25.6005
R531 nfet_01v8_lvt_W1_L20_m2__nf1_gboth_sdfull_pc/B.n269 nfet_01v8_lvt_W1_L20_m2__nf1_gboth_sdfull_pc/B.n213 25.6005
R532 nfet_01v8_lvt_W1_L20_m2__nf1_gboth_sdfull_pc/B.n275 nfet_01v8_lvt_W1_L20_m2__nf1_gboth_sdfull_pc/B.n213 25.6005
R533 nfet_01v8_lvt_W1_L20_m2__nf1_gboth_sdfull_pc/B.n276 nfet_01v8_lvt_W1_L20_m2__nf1_gboth_sdfull_pc/B.n275 25.6005
R534 nfet_01v8_lvt_W1_L20_m2__nf1_gboth_sdfull_pc/B.n277 nfet_01v8_lvt_W1_L20_m2__nf1_gboth_sdfull_pc/B.n276 25.6005
R535 nfet_01v8_lvt_W1_L20_m2__nf1_gboth_sdfull_pc/B.n277 nfet_01v8_lvt_W1_L20_m2__nf1_gboth_sdfull_pc/B.n206 25.6005
R536 nfet_01v8_lvt_W1_L20_m2__nf1_gboth_sdfull_pc/B.n283 nfet_01v8_lvt_W1_L20_m2__nf1_gboth_sdfull_pc/B.n206 25.6005
R537 nfet_01v8_lvt_W1_L20_m2__nf1_gboth_sdfull_pc/B.n284 nfet_01v8_lvt_W1_L20_m2__nf1_gboth_sdfull_pc/B.n283 25.6005
R538 nfet_01v8_lvt_W1_L20_m2__nf1_gboth_sdfull_pc/B.n285 nfet_01v8_lvt_W1_L20_m2__nf1_gboth_sdfull_pc/B.n284 25.6005
R539 nfet_01v8_lvt_W1_L20_m2__nf1_gboth_sdfull_pc/B.n285 nfet_01v8_lvt_W1_L20_m2__nf1_gboth_sdfull_pc/B.n199 25.6005
R540 nfet_01v8_lvt_W1_L20_m2__nf1_gboth_sdfull_pc/B.n291 nfet_01v8_lvt_W1_L20_m2__nf1_gboth_sdfull_pc/B.n199 25.6005
R541 nfet_01v8_lvt_W1_L20_m2__nf1_gboth_sdfull_pc/B.n292 nfet_01v8_lvt_W1_L20_m2__nf1_gboth_sdfull_pc/B.n291 25.6005
R542 nfet_01v8_lvt_W1_L20_m2__nf1_gboth_sdfull_pc/B.n293 nfet_01v8_lvt_W1_L20_m2__nf1_gboth_sdfull_pc/B.n292 25.6005
R543 nfet_01v8_lvt_W1_L20_m2__nf1_gboth_sdfull_pc/B.n293 nfet_01v8_lvt_W1_L20_m2__nf1_gboth_sdfull_pc/B.n192 25.6005
R544 nfet_01v8_lvt_W1_L20_m2__nf1_gboth_sdfull_pc/B.n299 nfet_01v8_lvt_W1_L20_m2__nf1_gboth_sdfull_pc/B.n192 25.6005
R545 nfet_01v8_lvt_W1_L20_m2__nf1_gboth_sdfull_pc/B.n300 nfet_01v8_lvt_W1_L20_m2__nf1_gboth_sdfull_pc/B.n299 25.6005
R546 nfet_01v8_lvt_W1_L20_m2__nf1_gboth_sdfull_pc/B.n301 nfet_01v8_lvt_W1_L20_m2__nf1_gboth_sdfull_pc/B.n300 25.6005
R547 nfet_01v8_lvt_W1_L20_m2__nf1_gboth_sdfull_pc/B.n301 nfet_01v8_lvt_W1_L20_m2__nf1_gboth_sdfull_pc/B.n185 25.6005
R548 nfet_01v8_lvt_W1_L20_m2__nf1_gboth_sdfull_pc/B.n307 nfet_01v8_lvt_W1_L20_m2__nf1_gboth_sdfull_pc/B.n185 25.6005
R549 nfet_01v8_lvt_W1_L20_m2__nf1_gboth_sdfull_pc/B.n308 nfet_01v8_lvt_W1_L20_m2__nf1_gboth_sdfull_pc/B.n307 25.6005
R550 nfet_01v8_lvt_W1_L20_m2__nf1_gboth_sdfull_pc/B.n309 nfet_01v8_lvt_W1_L20_m2__nf1_gboth_sdfull_pc/B.n308 25.6005
R551 nfet_01v8_lvt_W1_L20_m2__nf1_gboth_sdfull_pc/B.n309 nfet_01v8_lvt_W1_L20_m2__nf1_gboth_sdfull_pc/B.n178 25.6005
R552 nfet_01v8_lvt_W1_L20_m2__nf1_gboth_sdfull_pc/B.n315 nfet_01v8_lvt_W1_L20_m2__nf1_gboth_sdfull_pc/B.n178 25.6005
R553 nfet_01v8_lvt_W1_L20_m2__nf1_gboth_sdfull_pc/B.n316 nfet_01v8_lvt_W1_L20_m2__nf1_gboth_sdfull_pc/B.n315 25.6005
R554 nfet_01v8_lvt_W1_L20_m2__nf1_gboth_sdfull_pc/B.n317 nfet_01v8_lvt_W1_L20_m2__nf1_gboth_sdfull_pc/B.n316 25.6005
R555 nfet_01v8_lvt_W1_L20_m2__nf1_gboth_sdfull_pc/B.n317 nfet_01v8_lvt_W1_L20_m2__nf1_gboth_sdfull_pc/B.n171 25.6005
R556 nfet_01v8_lvt_W1_L20_m2__nf1_gboth_sdfull_pc/B.n323 nfet_01v8_lvt_W1_L20_m2__nf1_gboth_sdfull_pc/B.n171 25.6005
R557 nfet_01v8_lvt_W1_L20_m2__nf1_gboth_sdfull_pc/B.n324 nfet_01v8_lvt_W1_L20_m2__nf1_gboth_sdfull_pc/B.n323 25.6005
R558 nfet_01v8_lvt_W1_L20_m2__nf1_gboth_sdfull_pc/B.n325 nfet_01v8_lvt_W1_L20_m2__nf1_gboth_sdfull_pc/B.n324 25.6005
R559 nfet_01v8_lvt_W1_L20_m2__nf1_gboth_sdfull_pc/B.n325 nfet_01v8_lvt_W1_L20_m2__nf1_gboth_sdfull_pc/B.n170 25.6005
R560 nfet_01v8_lvt_W1_L20_m2__nf1_gboth_sdfull_pc/B.n170 nfet_01v8_lvt_W1_L20_m2__nf1_gboth_sdfull_pc/B.n169 25.6005
R561 nfet_01v8_lvt_W1_L20_m2__nf1_gboth_sdfull_pc/B.n169 nfet_01v8_lvt_W1_L20_m2__nf1_gboth_sdfull_pc/B.n7 25.6005
R562 nfet_01v8_lvt_W1_L20_m2__nf1_gboth_sdfull_pc/B.n159 nfet_01v8_lvt_W1_L20_m2__nf1_gboth_sdfull_pc/B.n7 25.6005
R563 nfet_01v8_lvt_W1_L20_m2__nf1_gboth_sdfull_pc/B.n159 nfet_01v8_lvt_W1_L20_m2__nf1_gboth_sdfull_pc/B.n158 25.6005
R564 nfet_01v8_lvt_W1_L20_m2__nf1_gboth_sdfull_pc/B.n158 nfet_01v8_lvt_W1_L20_m2__nf1_gboth_sdfull_pc/B.n157 25.6005
R565 nfet_01v8_lvt_W1_L20_m2__nf1_gboth_sdfull_pc/B.n157 nfet_01v8_lvt_W1_L20_m2__nf1_gboth_sdfull_pc/B.n15 25.6005
R566 nfet_01v8_lvt_W1_L20_m2__nf1_gboth_sdfull_pc/B.n147 nfet_01v8_lvt_W1_L20_m2__nf1_gboth_sdfull_pc/B.n15 25.6005
R567 nfet_01v8_lvt_W1_L20_m2__nf1_gboth_sdfull_pc/B.n147 nfet_01v8_lvt_W1_L20_m2__nf1_gboth_sdfull_pc/B.n146 25.6005
R568 nfet_01v8_lvt_W1_L20_m2__nf1_gboth_sdfull_pc/B.n146 nfet_01v8_lvt_W1_L20_m2__nf1_gboth_sdfull_pc/B.n145 25.6005
R569 nfet_01v8_lvt_W1_L20_m2__nf1_gboth_sdfull_pc/B.n145 nfet_01v8_lvt_W1_L20_m2__nf1_gboth_sdfull_pc/B.n23 25.6005
R570 nfet_01v8_lvt_W1_L20_m2__nf1_gboth_sdfull_pc/B.n135 nfet_01v8_lvt_W1_L20_m2__nf1_gboth_sdfull_pc/B.n23 25.6005
R571 nfet_01v8_lvt_W1_L20_m2__nf1_gboth_sdfull_pc/B.n135 nfet_01v8_lvt_W1_L20_m2__nf1_gboth_sdfull_pc/B.n134 25.6005
R572 nfet_01v8_lvt_W1_L20_m2__nf1_gboth_sdfull_pc/B.n134 nfet_01v8_lvt_W1_L20_m2__nf1_gboth_sdfull_pc/B.n133 25.6005
R573 nfet_01v8_lvt_W1_L20_m2__nf1_gboth_sdfull_pc/B.n133 nfet_01v8_lvt_W1_L20_m2__nf1_gboth_sdfull_pc/B.n31 25.6005
R574 nfet_01v8_lvt_W1_L20_m2__nf1_gboth_sdfull_pc/B.n123 nfet_01v8_lvt_W1_L20_m2__nf1_gboth_sdfull_pc/B.n31 25.6005
R575 nfet_01v8_lvt_W1_L20_m2__nf1_gboth_sdfull_pc/B.n123 nfet_01v8_lvt_W1_L20_m2__nf1_gboth_sdfull_pc/B.n122 25.6005
R576 nfet_01v8_lvt_W1_L20_m2__nf1_gboth_sdfull_pc/B.n122 nfet_01v8_lvt_W1_L20_m2__nf1_gboth_sdfull_pc/B.n121 25.6005
R577 nfet_01v8_lvt_W1_L20_m2__nf1_gboth_sdfull_pc/B.n121 nfet_01v8_lvt_W1_L20_m2__nf1_gboth_sdfull_pc/B.n39 25.6005
R578 nfet_01v8_lvt_W1_L20_m2__nf1_gboth_sdfull_pc/B.n111 nfet_01v8_lvt_W1_L20_m2__nf1_gboth_sdfull_pc/B.n39 25.6005
R579 nfet_01v8_lvt_W1_L20_m2__nf1_gboth_sdfull_pc/B.n111 nfet_01v8_lvt_W1_L20_m2__nf1_gboth_sdfull_pc/B.n110 25.6005
R580 nfet_01v8_lvt_W1_L20_m2__nf1_gboth_sdfull_pc/B.n110 nfet_01v8_lvt_W1_L20_m2__nf1_gboth_sdfull_pc/B.n109 25.6005
R581 nfet_01v8_lvt_W1_L20_m2__nf1_gboth_sdfull_pc/B.n109 nfet_01v8_lvt_W1_L20_m2__nf1_gboth_sdfull_pc/B.n47 25.6005
R582 nfet_01v8_lvt_W1_L20_m2__nf1_gboth_sdfull_pc/B.n99 nfet_01v8_lvt_W1_L20_m2__nf1_gboth_sdfull_pc/B.n47 25.6005
R583 nfet_01v8_lvt_W1_L20_m2__nf1_gboth_sdfull_pc/B.n99 nfet_01v8_lvt_W1_L20_m2__nf1_gboth_sdfull_pc/B.n98 25.6005
R584 nfet_01v8_lvt_W1_L20_m2__nf1_gboth_sdfull_pc/B.n98 nfet_01v8_lvt_W1_L20_m2__nf1_gboth_sdfull_pc/B.n97 25.6005
R585 nfet_01v8_lvt_W1_L20_m2__nf1_gboth_sdfull_pc/B.n97 nfet_01v8_lvt_W1_L20_m2__nf1_gboth_sdfull_pc/B.n55 25.6005
R586 nfet_01v8_lvt_W1_L20_m2__nf1_gboth_sdfull_pc/B.n87 nfet_01v8_lvt_W1_L20_m2__nf1_gboth_sdfull_pc/B.n55 25.6005
R587 nfet_01v8_lvt_W1_L20_m2__nf1_gboth_sdfull_pc/B.n87 nfet_01v8_lvt_W1_L20_m2__nf1_gboth_sdfull_pc/B.n86 25.6005
R588 nfet_01v8_lvt_W1_L20_m2__nf1_gboth_sdfull_pc/B.n86 nfet_01v8_lvt_W1_L20_m2__nf1_gboth_sdfull_pc/B.n85 25.6005
R589 nfet_01v8_lvt_W1_L20_m2__nf1_gboth_sdfull_pc/B.n85 nfet_01v8_lvt_W1_L20_m2__nf1_gboth_sdfull_pc/B.n63 25.6005
R590 B nfet_01v8_lvt_W1_L20_m2__nf1_gboth_sdfull_pc/B.n329 19.2005
R591 B nfet_01v8_lvt_W1_L20_m2__nf1_gboth_sdfull_pc/B.n0 6.4005
R592 B.n137 B.n125 1199.38
R593 B.n329 B.n4 1199.38
R594 B.n319 B.n10 1199.38
R595 B.n130 B.n123 1199.38
R596 B.n330 B.n0 755.333
R597 B.n136 B.n124 755.333
R598 B.n125 B.n124 585
R599 B.n139 B.n125 585
R600 B.n142 B.n141 585
R601 B.n141 B.n140 585
R602 B.n120 B.n119 585
R603 B.n119 B.n118 585
R604 B.n149 B.n148 585
R605 B.n150 B.n149 585
R606 B.n117 B.n116 585
R607 B.n151 B.n117 585
R608 B.n154 B.n153 585
R609 B.n153 B.n152 585
R610 B.n112 B.n111 585
R611 B.n111 B.n110 585
R612 B.n161 B.n160 585
R613 B.n162 B.n161 585
R614 B.n109 B.n108 585
R615 B.n163 B.n109 585
R616 B.n166 B.n165 585
R617 B.n165 B.n164 585
R618 B.n104 B.n103 585
R619 B.n103 B.n102 585
R620 B.n173 B.n172 585
R621 B.n174 B.n173 585
R622 B.n101 B.n100 585
R623 B.n175 B.n101 585
R624 B.n178 B.n177 585
R625 B.n177 B.n176 585
R626 B.n96 B.n95 585
R627 B.n95 B.n94 585
R628 B.n185 B.n184 585
R629 B.n186 B.n185 585
R630 B.n93 B.n92 585
R631 B.n187 B.n93 585
R632 B.n190 B.n189 585
R633 B.n189 B.n188 585
R634 B.n88 B.n87 585
R635 B.n87 B.n86 585
R636 B.n197 B.n196 585
R637 B.n198 B.n197 585
R638 B.n85 B.n84 585
R639 B.n199 B.n85 585
R640 B.n202 B.n201 585
R641 B.n201 B.n200 585
R642 B.n80 B.n79 585
R643 B.n79 B.n78 585
R644 B.n209 B.n208 585
R645 B.n210 B.n209 585
R646 B.n77 B.n76 585
R647 B.n211 B.n77 585
R648 B.n214 B.n213 585
R649 B.n213 B.n212 585
R650 B.n72 B.n71 585
R651 B.n71 B.n70 585
R652 B.n221 B.n220 585
R653 B.n222 B.n221 585
R654 B.n69 B.n68 585
R655 B.n223 B.n69 585
R656 B.n227 B.n226 585
R657 B.n226 B.n225 585
R658 B.n64 B.n63 585
R659 B.n224 B.n63 585
R660 B.n234 B.n233 585
R661 B.n235 B.n234 585
R662 B.n62 B.n61 585
R663 B.n236 B.n62 585
R664 B.n239 B.n238 585
R665 B.n238 B.n237 585
R666 B.n57 B.n56 585
R667 B.n56 B.n55 585
R668 B.n246 B.n245 585
R669 B.n247 B.n246 585
R670 B.n54 B.n53 585
R671 B.n248 B.n54 585
R672 B.n251 B.n250 585
R673 B.n250 B.n249 585
R674 B.n49 B.n48 585
R675 B.n48 B.n47 585
R676 B.n258 B.n257 585
R677 B.n259 B.n258 585
R678 B.n46 B.n45 585
R679 B.n260 B.n46 585
R680 B.n263 B.n262 585
R681 B.n262 B.n261 585
R682 B.n41 B.n40 585
R683 B.n40 B.n39 585
R684 B.n270 B.n269 585
R685 B.n271 B.n270 585
R686 B.n38 B.n37 585
R687 B.n272 B.n38 585
R688 B.n275 B.n274 585
R689 B.n274 B.n273 585
R690 B.n33 B.n32 585
R691 B.n32 B.n31 585
R692 B.n282 B.n281 585
R693 B.n283 B.n282 585
R694 B.n30 B.n29 585
R695 B.n284 B.n30 585
R696 B.n287 B.n286 585
R697 B.n286 B.n285 585
R698 B.n25 B.n24 585
R699 B.n24 B.n23 585
R700 B.n294 B.n293 585
R701 B.n295 B.n294 585
R702 B.n22 B.n21 585
R703 B.n296 B.n22 585
R704 B.n299 B.n298 585
R705 B.n298 B.n297 585
R706 B.n17 B.n16 585
R707 B.n16 B.n15 585
R708 B.n306 B.n305 585
R709 B.n307 B.n306 585
R710 B.n14 B.n13 585
R711 B.n308 B.n14 585
R712 B.n311 B.n310 585
R713 B.n310 B.n309 585
R714 B.n8 B.n7 585
R715 B.n7 B.n6 585
R716 B.n325 B.n324 585
R717 B.n326 B.n325 585
R718 B.n4 B.n0 585
R719 B.n327 B.n4 585
R720 B.n330 B.n329 585
R721 B.n329 B.n328 585
R722 B.n5 B.n3 585
R723 B.n316 B.n315 585
R724 B.n318 B.n317 585
R725 B.n320 B.n319 585
R726 B.n10 B.n0 585
R727 B.n321 B.n10 585
R728 B.n324 B.n323 585
R729 B.n323 B.n322 585
R730 B.n9 B.n8 585
R731 B.n314 B.n9 585
R732 B.n312 B.n311 585
R733 B.n313 B.n312 585
R734 B.n13 B.n12 585
R735 B.n12 B.n11 585
R736 B.n305 B.n304 585
R737 B.n304 B.n303 585
R738 B.n18 B.n17 585
R739 B.n302 B.n18 585
R740 B.n300 B.n299 585
R741 B.n301 B.n300 585
R742 B.n21 B.n20 585
R743 B.n20 B.n19 585
R744 B.n293 B.n292 585
R745 B.n292 B.n291 585
R746 B.n26 B.n25 585
R747 B.n290 B.n26 585
R748 B.n288 B.n287 585
R749 B.n289 B.n288 585
R750 B.n29 B.n28 585
R751 B.n28 B.n27 585
R752 B.n281 B.n280 585
R753 B.n280 B.n279 585
R754 B.n34 B.n33 585
R755 B.n278 B.n34 585
R756 B.n276 B.n275 585
R757 B.n277 B.n276 585
R758 B.n37 B.n36 585
R759 B.n36 B.n35 585
R760 B.n269 B.n268 585
R761 B.n268 B.n267 585
R762 B.n42 B.n41 585
R763 B.n266 B.n42 585
R764 B.n264 B.n263 585
R765 B.n265 B.n264 585
R766 B.n45 B.n44 585
R767 B.n44 B.n43 585
R768 B.n257 B.n256 585
R769 B.n256 B.n255 585
R770 B.n50 B.n49 585
R771 B.n254 B.n50 585
R772 B.n252 B.n251 585
R773 B.n253 B.n252 585
R774 B.n53 B.n52 585
R775 B.n52 B.n51 585
R776 B.n245 B.n244 585
R777 B.n244 B.n243 585
R778 B.n58 B.n57 585
R779 B.n242 B.n58 585
R780 B.n240 B.n239 585
R781 B.n241 B.n240 585
R782 B.n61 B.n60 585
R783 B.n60 B.n59 585
R784 B.n233 B.n232 585
R785 B.n232 B.n231 585
R786 B.n65 B.n64 585
R787 B.n230 B.n65 585
R788 B.n228 B.n227 585
R789 B.n229 B.n228 585
R790 B.n68 B.n67 585
R791 B.n67 B.n66 585
R792 B.n220 B.n219 585
R793 B.n219 B.n218 585
R794 B.n73 B.n72 585
R795 B.n217 B.n73 585
R796 B.n215 B.n214 585
R797 B.n216 B.n215 585
R798 B.n76 B.n75 585
R799 B.n75 B.n74 585
R800 B.n208 B.n207 585
R801 B.n207 B.n206 585
R802 B.n81 B.n80 585
R803 B.n205 B.n81 585
R804 B.n203 B.n202 585
R805 B.n204 B.n203 585
R806 B.n84 B.n83 585
R807 B.n83 B.n82 585
R808 B.n196 B.n195 585
R809 B.n195 B.n194 585
R810 B.n89 B.n88 585
R811 B.n193 B.n89 585
R812 B.n191 B.n190 585
R813 B.n192 B.n191 585
R814 B.n92 B.n91 585
R815 B.n91 B.n90 585
R816 B.n184 B.n183 585
R817 B.n183 B.n182 585
R818 B.n97 B.n96 585
R819 B.n181 B.n97 585
R820 B.n179 B.n178 585
R821 B.n180 B.n179 585
R822 B.n100 B.n99 585
R823 B.n99 B.n98 585
R824 B.n172 B.n171 585
R825 B.n171 B.n170 585
R826 B.n105 B.n104 585
R827 B.n169 B.n105 585
R828 B.n167 B.n166 585
R829 B.n168 B.n167 585
R830 B.n108 B.n107 585
R831 B.n107 B.n106 585
R832 B.n160 B.n159 585
R833 B.n159 B.n158 585
R834 B.n113 B.n112 585
R835 B.n157 B.n113 585
R836 B.n155 B.n154 585
R837 B.n156 B.n155 585
R838 B.n116 B.n115 585
R839 B.n115 B.n114 585
R840 B.n148 B.n147 585
R841 B.n147 B.n146 585
R842 B.n121 B.n120 585
R843 B.n145 B.n121 585
R844 B.n143 B.n142 585
R845 B.n144 B.n143 585
R846 B.n124 B.n123 585
R847 B.n123 B.n122 585
R848 B.n131 B.n130 585
R849 B.n132 B.n129 585
R850 B.n134 B.n133 585
R851 B.n127 B.n126 585
R852 B.n137 B.n136 585
R853 B.n138 B.n137 585
R854 B.n324 B.n0 498.668
R855 B.n324 B.n8 498.668
R856 B.n311 B.n8 498.668
R857 B.n311 B.n13 498.668
R858 B.n305 B.n13 498.668
R859 B.n305 B.n17 498.668
R860 B.n299 B.n17 498.668
R861 B.n299 B.n21 498.668
R862 B.n293 B.n21 498.668
R863 B.n293 B.n25 498.668
R864 B.n287 B.n25 498.668
R865 B.n287 B.n29 498.668
R866 B.n281 B.n29 498.668
R867 B.n281 B.n33 498.668
R868 B.n275 B.n33 498.668
R869 B.n275 B.n37 498.668
R870 B.n269 B.n37 498.668
R871 B.n269 B.n41 498.668
R872 B.n263 B.n41 498.668
R873 B.n263 B.n45 498.668
R874 B.n257 B.n45 498.668
R875 B.n257 B.n49 498.668
R876 B.n251 B.n49 498.668
R877 B.n251 B.n53 498.668
R878 B.n245 B.n53 498.668
R879 B.n245 B.n57 498.668
R880 B.n239 B.n57 498.668
R881 B.n239 B.n61 498.668
R882 B.n233 B.n61 498.668
R883 B.n233 B.n64 498.668
R884 B.n227 B.n64 498.668
R885 B.n227 B.n68 498.668
R886 B.n220 B.n68 498.668
R887 B.n220 B.n72 498.668
R888 B.n214 B.n72 498.668
R889 B.n214 B.n76 498.668
R890 B.n208 B.n76 498.668
R891 B.n208 B.n80 498.668
R892 B.n202 B.n80 498.668
R893 B.n202 B.n84 498.668
R894 B.n196 B.n84 498.668
R895 B.n196 B.n88 498.668
R896 B.n190 B.n88 498.668
R897 B.n190 B.n92 498.668
R898 B.n184 B.n92 498.668
R899 B.n184 B.n96 498.668
R900 B.n178 B.n96 498.668
R901 B.n178 B.n100 498.668
R902 B.n172 B.n100 498.668
R903 B.n172 B.n104 498.668
R904 B.n166 B.n104 498.668
R905 B.n166 B.n108 498.668
R906 B.n160 B.n108 498.668
R907 B.n160 B.n112 498.668
R908 B.n154 B.n112 498.668
R909 B.n154 B.n116 498.668
R910 B.n148 B.n116 498.668
R911 B.n148 B.n120 498.668
R912 B.n142 B.n120 498.668
R913 B.n142 B.n124 498.668
R914 B.n137 B.n127 394
R915 B.n134 B.n129 394
R916 B.n325 B.n4 394
R917 B.n325 B.n7 394
R918 B.n310 B.n7 394
R919 B.n310 B.n14 394
R920 B.n306 B.n14 394
R921 B.n306 B.n16 394
R922 B.n298 B.n16 394
R923 B.n298 B.n22 394
R924 B.n294 B.n22 394
R925 B.n294 B.n24 394
R926 B.n286 B.n24 394
R927 B.n286 B.n30 394
R928 B.n282 B.n30 394
R929 B.n282 B.n32 394
R930 B.n274 B.n32 394
R931 B.n274 B.n38 394
R932 B.n270 B.n38 394
R933 B.n270 B.n40 394
R934 B.n262 B.n40 394
R935 B.n262 B.n46 394
R936 B.n258 B.n46 394
R937 B.n258 B.n48 394
R938 B.n250 B.n48 394
R939 B.n250 B.n54 394
R940 B.n246 B.n54 394
R941 B.n246 B.n56 394
R942 B.n238 B.n56 394
R943 B.n238 B.n62 394
R944 B.n234 B.n62 394
R945 B.n234 B.n63 394
R946 B.n226 B.n63 394
R947 B.n226 B.n69 394
R948 B.n221 B.n69 394
R949 B.n221 B.n71 394
R950 B.n213 B.n71 394
R951 B.n213 B.n77 394
R952 B.n209 B.n77 394
R953 B.n209 B.n79 394
R954 B.n201 B.n79 394
R955 B.n201 B.n85 394
R956 B.n197 B.n85 394
R957 B.n197 B.n87 394
R958 B.n189 B.n87 394
R959 B.n189 B.n93 394
R960 B.n185 B.n93 394
R961 B.n185 B.n95 394
R962 B.n177 B.n95 394
R963 B.n177 B.n101 394
R964 B.n173 B.n101 394
R965 B.n173 B.n103 394
R966 B.n165 B.n103 394
R967 B.n165 B.n109 394
R968 B.n161 B.n109 394
R969 B.n161 B.n111 394
R970 B.n153 B.n111 394
R971 B.n153 B.n117 394
R972 B.n149 B.n117 394
R973 B.n149 B.n119 394
R974 B.n141 B.n119 394
R975 B.n141 B.n125 394
R976 B.n329 B.n3 394
R977 B.n317 B.n316 394
R978 B.n323 B.n10 394
R979 B.n323 B.n9 394
R980 B.n312 B.n9 394
R981 B.n312 B.n12 394
R982 B.n304 B.n12 394
R983 B.n304 B.n18 394
R984 B.n300 B.n18 394
R985 B.n300 B.n20 394
R986 B.n292 B.n20 394
R987 B.n292 B.n26 394
R988 B.n288 B.n26 394
R989 B.n288 B.n28 394
R990 B.n280 B.n28 394
R991 B.n280 B.n34 394
R992 B.n276 B.n34 394
R993 B.n276 B.n36 394
R994 B.n268 B.n36 394
R995 B.n268 B.n42 394
R996 B.n264 B.n42 394
R997 B.n264 B.n44 394
R998 B.n256 B.n44 394
R999 B.n256 B.n50 394
R1000 B.n252 B.n50 394
R1001 B.n252 B.n52 394
R1002 B.n244 B.n52 394
R1003 B.n244 B.n58 394
R1004 B.n240 B.n58 394
R1005 B.n240 B.n60 394
R1006 B.n232 B.n60 394
R1007 B.n232 B.n65 394
R1008 B.n228 B.n65 394
R1009 B.n228 B.n67 394
R1010 B.n219 B.n67 394
R1011 B.n219 B.n73 394
R1012 B.n215 B.n73 394
R1013 B.n215 B.n75 394
R1014 B.n207 B.n75 394
R1015 B.n207 B.n81 394
R1016 B.n203 B.n81 394
R1017 B.n203 B.n83 394
R1018 B.n195 B.n83 394
R1019 B.n195 B.n89 394
R1020 B.n191 B.n89 394
R1021 B.n191 B.n91 394
R1022 B.n183 B.n91 394
R1023 B.n183 B.n97 394
R1024 B.n179 B.n97 394
R1025 B.n179 B.n99 394
R1026 B.n171 B.n99 394
R1027 B.n171 B.n105 394
R1028 B.n167 B.n105 394
R1029 B.n167 B.n107 394
R1030 B.n159 B.n107 394
R1031 B.n159 B.n113 394
R1032 B.n155 B.n113 394
R1033 B.n155 B.n115 394
R1034 B.n147 B.n115 394
R1035 B.n147 B.n121 394
R1036 B.n143 B.n121 394
R1037 B.n143 B.n123 394
R1038 B B.n330 315.334
R1039 B.n330 B.n2 218.815
R1040 B.n330 B.n1 218.815
R1041 B.n136 B.n128 218.815
R1042 B.n136 B.n135 218.815
R1043 B.n3 B.n2 147.374
R1044 B.n317 B.n1 147.374
R1045 B.n129 B.n128 147.374
R1046 B.n135 B.n127 147.374
R1047 B.n135 B.n134 147.374
R1048 B.n130 B.n128 147.374
R1049 B.n316 B.n2 147.374
R1050 B.n319 B.n1 147.374
R1051 B.n328 B.n327 77.9299
R1052 B.n321 B.n320 77.9299
R1053 B.n139 B.n138 77.9299
R1054 B.n131 B.n122 77.9299
R1055 B.n327 B.n326 25.6005
R1056 B.n326 B.n6 25.6005
R1057 B.n309 B.n6 25.6005
R1058 B.n309 B.n308 25.6005
R1059 B.n308 B.n307 25.6005
R1060 B.n307 B.n15 25.6005
R1061 B.n297 B.n15 25.6005
R1062 B.n297 B.n296 25.6005
R1063 B.n296 B.n295 25.6005
R1064 B.n295 B.n23 25.6005
R1065 B.n285 B.n23 25.6005
R1066 B.n285 B.n284 25.6005
R1067 B.n284 B.n283 25.6005
R1068 B.n283 B.n31 25.6005
R1069 B.n273 B.n31 25.6005
R1070 B.n273 B.n272 25.6005
R1071 B.n272 B.n271 25.6005
R1072 B.n271 B.n39 25.6005
R1073 B.n261 B.n39 25.6005
R1074 B.n261 B.n260 25.6005
R1075 B.n260 B.n259 25.6005
R1076 B.n259 B.n47 25.6005
R1077 B.n249 B.n47 25.6005
R1078 B.n249 B.n248 25.6005
R1079 B.n248 B.n247 25.6005
R1080 B.n247 B.n55 25.6005
R1081 B.n237 B.n55 25.6005
R1082 B.n237 B.n236 25.6005
R1083 B.n236 B.n235 25.6005
R1084 B.n225 B.n224 25.6005
R1085 B.n225 B.n223 25.6005
R1086 B.n223 B.n222 25.6005
R1087 B.n222 B.n70 25.6005
R1088 B.n212 B.n70 25.6005
R1089 B.n212 B.n211 25.6005
R1090 B.n211 B.n210 25.6005
R1091 B.n210 B.n78 25.6005
R1092 B.n200 B.n78 25.6005
R1093 B.n200 B.n199 25.6005
R1094 B.n199 B.n198 25.6005
R1095 B.n198 B.n86 25.6005
R1096 B.n188 B.n86 25.6005
R1097 B.n188 B.n187 25.6005
R1098 B.n187 B.n186 25.6005
R1099 B.n186 B.n94 25.6005
R1100 B.n176 B.n94 25.6005
R1101 B.n176 B.n175 25.6005
R1102 B.n175 B.n174 25.6005
R1103 B.n174 B.n102 25.6005
R1104 B.n164 B.n102 25.6005
R1105 B.n164 B.n163 25.6005
R1106 B.n163 B.n162 25.6005
R1107 B.n162 B.n110 25.6005
R1108 B.n152 B.n110 25.6005
R1109 B.n152 B.n151 25.6005
R1110 B.n151 B.n150 25.6005
R1111 B.n150 B.n118 25.6005
R1112 B.n140 B.n118 25.6005
R1113 B.n140 B.n139 25.6005
R1114 B.n328 B.n5 25.6005
R1115 B.n315 B.n5 25.6005
R1116 B.n318 B.n315 25.6005
R1117 B.n320 B.n318 25.6005
R1118 B.n322 B.n321 25.6005
R1119 B.n322 B.n314 25.6005
R1120 B.n314 B.n313 25.6005
R1121 B.n313 B.n11 25.6005
R1122 B.n303 B.n11 25.6005
R1123 B.n303 B.n302 25.6005
R1124 B.n302 B.n301 25.6005
R1125 B.n301 B.n19 25.6005
R1126 B.n291 B.n19 25.6005
R1127 B.n291 B.n290 25.6005
R1128 B.n290 B.n289 25.6005
R1129 B.n289 B.n27 25.6005
R1130 B.n279 B.n27 25.6005
R1131 B.n279 B.n278 25.6005
R1132 B.n278 B.n277 25.6005
R1133 B.n277 B.n35 25.6005
R1134 B.n267 B.n35 25.6005
R1135 B.n267 B.n266 25.6005
R1136 B.n266 B.n265 25.6005
R1137 B.n265 B.n43 25.6005
R1138 B.n255 B.n43 25.6005
R1139 B.n255 B.n254 25.6005
R1140 B.n254 B.n253 25.6005
R1141 B.n253 B.n51 25.6005
R1142 B.n243 B.n51 25.6005
R1143 B.n243 B.n242 25.6005
R1144 B.n242 B.n241 25.6005
R1145 B.n241 B.n59 25.6005
R1146 B.n231 B.n59 25.6005
R1147 B.n231 B.n230 25.6005
R1148 B.n230 B.n229 25.6005
R1149 B.n229 B.n66 25.6005
R1150 B.n218 B.n66 25.6005
R1151 B.n218 B.n217 25.6005
R1152 B.n217 B.n216 25.6005
R1153 B.n216 B.n74 25.6005
R1154 B.n206 B.n74 25.6005
R1155 B.n206 B.n205 25.6005
R1156 B.n205 B.n204 25.6005
R1157 B.n204 B.n82 25.6005
R1158 B.n194 B.n82 25.6005
R1159 B.n194 B.n193 25.6005
R1160 B.n193 B.n192 25.6005
R1161 B.n192 B.n90 25.6005
R1162 B.n182 B.n90 25.6005
R1163 B.n182 B.n181 25.6005
R1164 B.n181 B.n180 25.6005
R1165 B.n180 B.n98 25.6005
R1166 B.n170 B.n98 25.6005
R1167 B.n170 B.n169 25.6005
R1168 B.n169 B.n168 25.6005
R1169 B.n168 B.n106 25.6005
R1170 B.n158 B.n106 25.6005
R1171 B.n158 B.n157 25.6005
R1172 B.n157 B.n156 25.6005
R1173 B.n156 B.n114 25.6005
R1174 B.n146 B.n114 25.6005
R1175 B.n146 B.n145 25.6005
R1176 B.n145 B.n144 25.6005
R1177 B.n144 B.n122 25.6005
R1178 B.n138 B.n126 25.6005
R1179 B.n133 B.n126 25.6005
R1180 B.n133 B.n132 25.6005
R1181 B.n132 B.n131 25.6005
R1182 B.n235 B 19.2005
R1183 B.n224 B 6.4005
R1184 w_n43_n43.n264 w_n43_n43.n225 1199.38
R1185 w_n43_n43.n79 w_n43_n43.n67 1199.38
R1186 w_n43_n43.n267 w_n43_n43.n220 1199.38
R1187 w_n43_n43.n76 w_n43_n43.n65 1199.38
R1188 w_n43_n43.n265 w_n43_n43.n219 755.333
R1189 w_n43_n43.n77 w_n43_n43.n66 755.333
R1190 w_n43_n43.n220 w_n43_n43.n219 585
R1191 w_n43_n43.n269 w_n43_n43.n220 585
R1192 w_n43_n43.n272 w_n43_n43.n271 585
R1193 w_n43_n43.n271 w_n43_n43.n270 585
R1194 w_n43_n43.n273 w_n43_n43.n215 585
R1195 w_n43_n43.n215 w_n43_n43.n214 585
R1196 w_n43_n43.n275 w_n43_n43.n274 585
R1197 w_n43_n43.n276 w_n43_n43.n275 585
R1198 w_n43_n43.n213 w_n43_n43.n212 585
R1199 w_n43_n43.n277 w_n43_n43.n213 585
R1200 w_n43_n43.n280 w_n43_n43.n279 585
R1201 w_n43_n43.n279 w_n43_n43.n278 585
R1202 w_n43_n43.n281 w_n43_n43.n208 585
R1203 w_n43_n43.n208 w_n43_n43.n207 585
R1204 w_n43_n43.n283 w_n43_n43.n282 585
R1205 w_n43_n43.n284 w_n43_n43.n283 585
R1206 w_n43_n43.n206 w_n43_n43.n205 585
R1207 w_n43_n43.n285 w_n43_n43.n206 585
R1208 w_n43_n43.n288 w_n43_n43.n287 585
R1209 w_n43_n43.n287 w_n43_n43.n286 585
R1210 w_n43_n43.n289 w_n43_n43.n201 585
R1211 w_n43_n43.n201 w_n43_n43.n200 585
R1212 w_n43_n43.n291 w_n43_n43.n290 585
R1213 w_n43_n43.n292 w_n43_n43.n291 585
R1214 w_n43_n43.n199 w_n43_n43.n198 585
R1215 w_n43_n43.n293 w_n43_n43.n199 585
R1216 w_n43_n43.n296 w_n43_n43.n295 585
R1217 w_n43_n43.n295 w_n43_n43.n294 585
R1218 w_n43_n43.n297 w_n43_n43.n194 585
R1219 w_n43_n43.n194 w_n43_n43.n193 585
R1220 w_n43_n43.n299 w_n43_n43.n298 585
R1221 w_n43_n43.n300 w_n43_n43.n299 585
R1222 w_n43_n43.n192 w_n43_n43.n191 585
R1223 w_n43_n43.n301 w_n43_n43.n192 585
R1224 w_n43_n43.n304 w_n43_n43.n303 585
R1225 w_n43_n43.n303 w_n43_n43.n302 585
R1226 w_n43_n43.n305 w_n43_n43.n187 585
R1227 w_n43_n43.n187 w_n43_n43.n186 585
R1228 w_n43_n43.n307 w_n43_n43.n306 585
R1229 w_n43_n43.n308 w_n43_n43.n307 585
R1230 w_n43_n43.n185 w_n43_n43.n184 585
R1231 w_n43_n43.n309 w_n43_n43.n185 585
R1232 w_n43_n43.n312 w_n43_n43.n311 585
R1233 w_n43_n43.n311 w_n43_n43.n310 585
R1234 w_n43_n43.n313 w_n43_n43.n180 585
R1235 w_n43_n43.n180 w_n43_n43.n179 585
R1236 w_n43_n43.n315 w_n43_n43.n314 585
R1237 w_n43_n43.n316 w_n43_n43.n315 585
R1238 w_n43_n43.n178 w_n43_n43.n177 585
R1239 w_n43_n43.n317 w_n43_n43.n178 585
R1240 w_n43_n43.n320 w_n43_n43.n319 585
R1241 w_n43_n43.n319 w_n43_n43.n318 585
R1242 w_n43_n43.n321 w_n43_n43.n173 585
R1243 w_n43_n43.n173 w_n43_n43.n172 585
R1244 w_n43_n43.n323 w_n43_n43.n322 585
R1245 w_n43_n43.n324 w_n43_n43.n323 585
R1246 w_n43_n43.n7 w_n43_n43.n5 585
R1247 w_n43_n43.n325 w_n43_n43.n7 585
R1248 w_n43_n43.n328 w_n43_n43.n327 585
R1249 w_n43_n43.n327 w_n43_n43.n326 585
R1250 w_n43_n43.n6 w_n43_n43.n4 585
R1251 w_n43_n43.n171 w_n43_n43.n6 585
R1252 w_n43_n43.n169 w_n43_n43.n168 585
R1253 w_n43_n43.n170 w_n43_n43.n169 585
R1254 w_n43_n43.n10 w_n43_n43.n9 585
R1255 w_n43_n43.n9 w_n43_n43.n8 585
R1256 w_n43_n43.n162 w_n43_n43.n161 585
R1257 w_n43_n43.n161 w_n43_n43.n160 585
R1258 w_n43_n43.n15 w_n43_n43.n14 585
R1259 w_n43_n43.n159 w_n43_n43.n15 585
R1260 w_n43_n43.n157 w_n43_n43.n156 585
R1261 w_n43_n43.n158 w_n43_n43.n157 585
R1262 w_n43_n43.n18 w_n43_n43.n17 585
R1263 w_n43_n43.n17 w_n43_n43.n16 585
R1264 w_n43_n43.n150 w_n43_n43.n149 585
R1265 w_n43_n43.n149 w_n43_n43.n148 585
R1266 w_n43_n43.n23 w_n43_n43.n22 585
R1267 w_n43_n43.n147 w_n43_n43.n23 585
R1268 w_n43_n43.n145 w_n43_n43.n144 585
R1269 w_n43_n43.n146 w_n43_n43.n145 585
R1270 w_n43_n43.n26 w_n43_n43.n25 585
R1271 w_n43_n43.n25 w_n43_n43.n24 585
R1272 w_n43_n43.n138 w_n43_n43.n137 585
R1273 w_n43_n43.n137 w_n43_n43.n136 585
R1274 w_n43_n43.n31 w_n43_n43.n30 585
R1275 w_n43_n43.n135 w_n43_n43.n31 585
R1276 w_n43_n43.n133 w_n43_n43.n132 585
R1277 w_n43_n43.n134 w_n43_n43.n133 585
R1278 w_n43_n43.n34 w_n43_n43.n33 585
R1279 w_n43_n43.n33 w_n43_n43.n32 585
R1280 w_n43_n43.n126 w_n43_n43.n125 585
R1281 w_n43_n43.n125 w_n43_n43.n124 585
R1282 w_n43_n43.n39 w_n43_n43.n38 585
R1283 w_n43_n43.n123 w_n43_n43.n39 585
R1284 w_n43_n43.n121 w_n43_n43.n120 585
R1285 w_n43_n43.n122 w_n43_n43.n121 585
R1286 w_n43_n43.n42 w_n43_n43.n41 585
R1287 w_n43_n43.n41 w_n43_n43.n40 585
R1288 w_n43_n43.n114 w_n43_n43.n113 585
R1289 w_n43_n43.n113 w_n43_n43.n112 585
R1290 w_n43_n43.n47 w_n43_n43.n46 585
R1291 w_n43_n43.n111 w_n43_n43.n47 585
R1292 w_n43_n43.n109 w_n43_n43.n108 585
R1293 w_n43_n43.n110 w_n43_n43.n109 585
R1294 w_n43_n43.n50 w_n43_n43.n49 585
R1295 w_n43_n43.n49 w_n43_n43.n48 585
R1296 w_n43_n43.n102 w_n43_n43.n101 585
R1297 w_n43_n43.n101 w_n43_n43.n100 585
R1298 w_n43_n43.n55 w_n43_n43.n54 585
R1299 w_n43_n43.n99 w_n43_n43.n55 585
R1300 w_n43_n43.n97 w_n43_n43.n96 585
R1301 w_n43_n43.n98 w_n43_n43.n97 585
R1302 w_n43_n43.n58 w_n43_n43.n57 585
R1303 w_n43_n43.n57 w_n43_n43.n56 585
R1304 w_n43_n43.n90 w_n43_n43.n89 585
R1305 w_n43_n43.n89 w_n43_n43.n88 585
R1306 w_n43_n43.n63 w_n43_n43.n62 585
R1307 w_n43_n43.n87 w_n43_n43.n63 585
R1308 w_n43_n43.n85 w_n43_n43.n84 585
R1309 w_n43_n43.n86 w_n43_n43.n85 585
R1310 w_n43_n43.n66 w_n43_n43.n65 585
R1311 w_n43_n43.n65 w_n43_n43.n64 585
R1312 w_n43_n43.n77 w_n43_n43.n76 585
R1313 w_n43_n43.n76 w_n43_n43.n75 585
R1314 w_n43_n43.n74 w_n43_n43.n71 585
R1315 w_n43_n43.n73 w_n43_n43.n72 585
R1316 w_n43_n43.n69 w_n43_n43.n68 585
R1317 w_n43_n43.n80 w_n43_n43.n79 585
R1318 w_n43_n43.n67 w_n43_n43.n66 585
R1319 w_n43_n43.n81 w_n43_n43.n67 585
R1320 w_n43_n43.n84 w_n43_n43.n83 585
R1321 w_n43_n43.n83 w_n43_n43.n82 585
R1322 w_n43_n43.n62 w_n43_n43.n61 585
R1323 w_n43_n43.n61 w_n43_n43.n60 585
R1324 w_n43_n43.n91 w_n43_n43.n90 585
R1325 w_n43_n43.n92 w_n43_n43.n91 585
R1326 w_n43_n43.n59 w_n43_n43.n58 585
R1327 w_n43_n43.n93 w_n43_n43.n59 585
R1328 w_n43_n43.n96 w_n43_n43.n95 585
R1329 w_n43_n43.n95 w_n43_n43.n94 585
R1330 w_n43_n43.n54 w_n43_n43.n53 585
R1331 w_n43_n43.n53 w_n43_n43.n52 585
R1332 w_n43_n43.n103 w_n43_n43.n102 585
R1333 w_n43_n43.n104 w_n43_n43.n103 585
R1334 w_n43_n43.n51 w_n43_n43.n50 585
R1335 w_n43_n43.n105 w_n43_n43.n51 585
R1336 w_n43_n43.n108 w_n43_n43.n107 585
R1337 w_n43_n43.n107 w_n43_n43.n106 585
R1338 w_n43_n43.n46 w_n43_n43.n45 585
R1339 w_n43_n43.n45 w_n43_n43.n44 585
R1340 w_n43_n43.n115 w_n43_n43.n114 585
R1341 w_n43_n43.n116 w_n43_n43.n115 585
R1342 w_n43_n43.n43 w_n43_n43.n42 585
R1343 w_n43_n43.n117 w_n43_n43.n43 585
R1344 w_n43_n43.n120 w_n43_n43.n119 585
R1345 w_n43_n43.n119 w_n43_n43.n118 585
R1346 w_n43_n43.n38 w_n43_n43.n37 585
R1347 w_n43_n43.n37 w_n43_n43.n36 585
R1348 w_n43_n43.n127 w_n43_n43.n126 585
R1349 w_n43_n43.n128 w_n43_n43.n127 585
R1350 w_n43_n43.n35 w_n43_n43.n34 585
R1351 w_n43_n43.n129 w_n43_n43.n35 585
R1352 w_n43_n43.n132 w_n43_n43.n131 585
R1353 w_n43_n43.n131 w_n43_n43.n130 585
R1354 w_n43_n43.n30 w_n43_n43.n29 585
R1355 w_n43_n43.n29 w_n43_n43.n28 585
R1356 w_n43_n43.n139 w_n43_n43.n138 585
R1357 w_n43_n43.n140 w_n43_n43.n139 585
R1358 w_n43_n43.n27 w_n43_n43.n26 585
R1359 w_n43_n43.n141 w_n43_n43.n27 585
R1360 w_n43_n43.n144 w_n43_n43.n143 585
R1361 w_n43_n43.n143 w_n43_n43.n142 585
R1362 w_n43_n43.n22 w_n43_n43.n21 585
R1363 w_n43_n43.n21 w_n43_n43.n20 585
R1364 w_n43_n43.n151 w_n43_n43.n150 585
R1365 w_n43_n43.n152 w_n43_n43.n151 585
R1366 w_n43_n43.n19 w_n43_n43.n18 585
R1367 w_n43_n43.n153 w_n43_n43.n19 585
R1368 w_n43_n43.n156 w_n43_n43.n155 585
R1369 w_n43_n43.n155 w_n43_n43.n154 585
R1370 w_n43_n43.n14 w_n43_n43.n13 585
R1371 w_n43_n43.n13 w_n43_n43.n12 585
R1372 w_n43_n43.n163 w_n43_n43.n162 585
R1373 w_n43_n43.n164 w_n43_n43.n163 585
R1374 w_n43_n43.n11 w_n43_n43.n10 585
R1375 w_n43_n43.n165 w_n43_n43.n11 585
R1376 w_n43_n43.n168 w_n43_n43.n167 585
R1377 w_n43_n43.n167 w_n43_n43.n166 585
R1378 w_n43_n43.n4 w_n43_n43.n2 585
R1379 w_n43_n43.n2 w_n43_n43.n0 585
R1380 w_n43_n43.n329 w_n43_n43.n328 585
R1381 w_n43_n43.n330 w_n43_n43.n329 585
R1382 w_n43_n43.n5 w_n43_n43.n3 585
R1383 w_n43_n43.n3 w_n43_n43.n1 585
R1384 w_n43_n43.n322 w_n43_n43.n174 585
R1385 w_n43_n43.n229 w_n43_n43.n174 585
R1386 w_n43_n43.n321 w_n43_n43.n175 585
R1387 w_n43_n43.n230 w_n43_n43.n175 585
R1388 w_n43_n43.n320 w_n43_n43.n176 585
R1389 w_n43_n43.n231 w_n43_n43.n176 585
R1390 w_n43_n43.n232 w_n43_n43.n177 585
R1391 w_n43_n43.n233 w_n43_n43.n232 585
R1392 w_n43_n43.n314 w_n43_n43.n181 585
R1393 w_n43_n43.n234 w_n43_n43.n181 585
R1394 w_n43_n43.n313 w_n43_n43.n182 585
R1395 w_n43_n43.n235 w_n43_n43.n182 585
R1396 w_n43_n43.n312 w_n43_n43.n183 585
R1397 w_n43_n43.n236 w_n43_n43.n183 585
R1398 w_n43_n43.n237 w_n43_n43.n184 585
R1399 w_n43_n43.n238 w_n43_n43.n237 585
R1400 w_n43_n43.n306 w_n43_n43.n188 585
R1401 w_n43_n43.n239 w_n43_n43.n188 585
R1402 w_n43_n43.n305 w_n43_n43.n189 585
R1403 w_n43_n43.n240 w_n43_n43.n189 585
R1404 w_n43_n43.n304 w_n43_n43.n190 585
R1405 w_n43_n43.n241 w_n43_n43.n190 585
R1406 w_n43_n43.n242 w_n43_n43.n191 585
R1407 w_n43_n43.n243 w_n43_n43.n242 585
R1408 w_n43_n43.n298 w_n43_n43.n195 585
R1409 w_n43_n43.n244 w_n43_n43.n195 585
R1410 w_n43_n43.n297 w_n43_n43.n196 585
R1411 w_n43_n43.n245 w_n43_n43.n196 585
R1412 w_n43_n43.n296 w_n43_n43.n197 585
R1413 w_n43_n43.n246 w_n43_n43.n197 585
R1414 w_n43_n43.n247 w_n43_n43.n198 585
R1415 w_n43_n43.n248 w_n43_n43.n247 585
R1416 w_n43_n43.n290 w_n43_n43.n202 585
R1417 w_n43_n43.n249 w_n43_n43.n202 585
R1418 w_n43_n43.n289 w_n43_n43.n203 585
R1419 w_n43_n43.n250 w_n43_n43.n203 585
R1420 w_n43_n43.n288 w_n43_n43.n204 585
R1421 w_n43_n43.n251 w_n43_n43.n204 585
R1422 w_n43_n43.n252 w_n43_n43.n205 585
R1423 w_n43_n43.n253 w_n43_n43.n252 585
R1424 w_n43_n43.n282 w_n43_n43.n209 585
R1425 w_n43_n43.n254 w_n43_n43.n209 585
R1426 w_n43_n43.n281 w_n43_n43.n210 585
R1427 w_n43_n43.n255 w_n43_n43.n210 585
R1428 w_n43_n43.n280 w_n43_n43.n211 585
R1429 w_n43_n43.n256 w_n43_n43.n211 585
R1430 w_n43_n43.n257 w_n43_n43.n212 585
R1431 w_n43_n43.n258 w_n43_n43.n257 585
R1432 w_n43_n43.n274 w_n43_n43.n216 585
R1433 w_n43_n43.n259 w_n43_n43.n216 585
R1434 w_n43_n43.n273 w_n43_n43.n217 585
R1435 w_n43_n43.n260 w_n43_n43.n217 585
R1436 w_n43_n43.n272 w_n43_n43.n218 585
R1437 w_n43_n43.n261 w_n43_n43.n218 585
R1438 w_n43_n43.n225 w_n43_n43.n219 585
R1439 w_n43_n43.n262 w_n43_n43.n225 585
R1440 w_n43_n43.n265 w_n43_n43.n264 585
R1441 w_n43_n43.n264 w_n43_n43.n263 585
R1442 w_n43_n43.n228 w_n43_n43.n224 585
R1443 w_n43_n43.n227 w_n43_n43.n226 585
R1444 w_n43_n43.n222 w_n43_n43.n221 585
R1445 w_n43_n43.n268 w_n43_n43.n267 585
R1446 w_n43_n43.n272 w_n43_n43.n219 498.668
R1447 w_n43_n43.n273 w_n43_n43.n272 498.668
R1448 w_n43_n43.n274 w_n43_n43.n273 498.668
R1449 w_n43_n43.n274 w_n43_n43.n212 498.668
R1450 w_n43_n43.n280 w_n43_n43.n212 498.668
R1451 w_n43_n43.n281 w_n43_n43.n280 498.668
R1452 w_n43_n43.n282 w_n43_n43.n281 498.668
R1453 w_n43_n43.n282 w_n43_n43.n205 498.668
R1454 w_n43_n43.n288 w_n43_n43.n205 498.668
R1455 w_n43_n43.n289 w_n43_n43.n288 498.668
R1456 w_n43_n43.n290 w_n43_n43.n289 498.668
R1457 w_n43_n43.n290 w_n43_n43.n198 498.668
R1458 w_n43_n43.n296 w_n43_n43.n198 498.668
R1459 w_n43_n43.n297 w_n43_n43.n296 498.668
R1460 w_n43_n43.n298 w_n43_n43.n297 498.668
R1461 w_n43_n43.n298 w_n43_n43.n191 498.668
R1462 w_n43_n43.n304 w_n43_n43.n191 498.668
R1463 w_n43_n43.n305 w_n43_n43.n304 498.668
R1464 w_n43_n43.n306 w_n43_n43.n305 498.668
R1465 w_n43_n43.n306 w_n43_n43.n184 498.668
R1466 w_n43_n43.n312 w_n43_n43.n184 498.668
R1467 w_n43_n43.n313 w_n43_n43.n312 498.668
R1468 w_n43_n43.n314 w_n43_n43.n313 498.668
R1469 w_n43_n43.n314 w_n43_n43.n177 498.668
R1470 w_n43_n43.n320 w_n43_n43.n177 498.668
R1471 w_n43_n43.n321 w_n43_n43.n320 498.668
R1472 w_n43_n43.n322 w_n43_n43.n321 498.668
R1473 w_n43_n43.n322 w_n43_n43.n5 498.668
R1474 w_n43_n43.n328 w_n43_n43.n5 498.668
R1475 w_n43_n43.n328 w_n43_n43.n4 498.668
R1476 w_n43_n43.n168 w_n43_n43.n4 498.668
R1477 w_n43_n43.n168 w_n43_n43.n10 498.668
R1478 w_n43_n43.n162 w_n43_n43.n10 498.668
R1479 w_n43_n43.n162 w_n43_n43.n14 498.668
R1480 w_n43_n43.n156 w_n43_n43.n14 498.668
R1481 w_n43_n43.n156 w_n43_n43.n18 498.668
R1482 w_n43_n43.n150 w_n43_n43.n18 498.668
R1483 w_n43_n43.n150 w_n43_n43.n22 498.668
R1484 w_n43_n43.n144 w_n43_n43.n22 498.668
R1485 w_n43_n43.n144 w_n43_n43.n26 498.668
R1486 w_n43_n43.n138 w_n43_n43.n26 498.668
R1487 w_n43_n43.n138 w_n43_n43.n30 498.668
R1488 w_n43_n43.n132 w_n43_n43.n30 498.668
R1489 w_n43_n43.n132 w_n43_n43.n34 498.668
R1490 w_n43_n43.n126 w_n43_n43.n34 498.668
R1491 w_n43_n43.n126 w_n43_n43.n38 498.668
R1492 w_n43_n43.n120 w_n43_n43.n38 498.668
R1493 w_n43_n43.n120 w_n43_n43.n42 498.668
R1494 w_n43_n43.n114 w_n43_n43.n42 498.668
R1495 w_n43_n43.n114 w_n43_n43.n46 498.668
R1496 w_n43_n43.n108 w_n43_n43.n46 498.668
R1497 w_n43_n43.n108 w_n43_n43.n50 498.668
R1498 w_n43_n43.n102 w_n43_n43.n50 498.668
R1499 w_n43_n43.n102 w_n43_n43.n54 498.668
R1500 w_n43_n43.n96 w_n43_n43.n54 498.668
R1501 w_n43_n43.n96 w_n43_n43.n58 498.668
R1502 w_n43_n43.n90 w_n43_n43.n58 498.668
R1503 w_n43_n43.n90 w_n43_n43.n62 498.668
R1504 w_n43_n43.n84 w_n43_n43.n62 498.668
R1505 w_n43_n43.n84 w_n43_n43.n66 498.668
R1506 w_n43_n43.n264 w_n43_n43.n224 394
R1507 w_n43_n43.n226 w_n43_n43.n222 394
R1508 w_n43_n43.n225 w_n43_n43.n218 394
R1509 w_n43_n43.n218 w_n43_n43.n217 394
R1510 w_n43_n43.n217 w_n43_n43.n216 394
R1511 w_n43_n43.n257 w_n43_n43.n216 394
R1512 w_n43_n43.n257 w_n43_n43.n211 394
R1513 w_n43_n43.n211 w_n43_n43.n210 394
R1514 w_n43_n43.n210 w_n43_n43.n209 394
R1515 w_n43_n43.n252 w_n43_n43.n209 394
R1516 w_n43_n43.n252 w_n43_n43.n204 394
R1517 w_n43_n43.n204 w_n43_n43.n203 394
R1518 w_n43_n43.n203 w_n43_n43.n202 394
R1519 w_n43_n43.n247 w_n43_n43.n202 394
R1520 w_n43_n43.n247 w_n43_n43.n197 394
R1521 w_n43_n43.n197 w_n43_n43.n196 394
R1522 w_n43_n43.n196 w_n43_n43.n195 394
R1523 w_n43_n43.n242 w_n43_n43.n195 394
R1524 w_n43_n43.n242 w_n43_n43.n190 394
R1525 w_n43_n43.n190 w_n43_n43.n189 394
R1526 w_n43_n43.n189 w_n43_n43.n188 394
R1527 w_n43_n43.n237 w_n43_n43.n188 394
R1528 w_n43_n43.n237 w_n43_n43.n183 394
R1529 w_n43_n43.n183 w_n43_n43.n182 394
R1530 w_n43_n43.n182 w_n43_n43.n181 394
R1531 w_n43_n43.n232 w_n43_n43.n181 394
R1532 w_n43_n43.n232 w_n43_n43.n176 394
R1533 w_n43_n43.n176 w_n43_n43.n175 394
R1534 w_n43_n43.n175 w_n43_n43.n174 394
R1535 w_n43_n43.n174 w_n43_n43.n3 394
R1536 w_n43_n43.n329 w_n43_n43.n3 394
R1537 w_n43_n43.n329 w_n43_n43.n2 394
R1538 w_n43_n43.n167 w_n43_n43.n2 394
R1539 w_n43_n43.n167 w_n43_n43.n11 394
R1540 w_n43_n43.n163 w_n43_n43.n11 394
R1541 w_n43_n43.n163 w_n43_n43.n13 394
R1542 w_n43_n43.n155 w_n43_n43.n13 394
R1543 w_n43_n43.n155 w_n43_n43.n19 394
R1544 w_n43_n43.n151 w_n43_n43.n19 394
R1545 w_n43_n43.n151 w_n43_n43.n21 394
R1546 w_n43_n43.n143 w_n43_n43.n21 394
R1547 w_n43_n43.n143 w_n43_n43.n27 394
R1548 w_n43_n43.n139 w_n43_n43.n27 394
R1549 w_n43_n43.n139 w_n43_n43.n29 394
R1550 w_n43_n43.n131 w_n43_n43.n29 394
R1551 w_n43_n43.n131 w_n43_n43.n35 394
R1552 w_n43_n43.n127 w_n43_n43.n35 394
R1553 w_n43_n43.n127 w_n43_n43.n37 394
R1554 w_n43_n43.n119 w_n43_n43.n37 394
R1555 w_n43_n43.n119 w_n43_n43.n43 394
R1556 w_n43_n43.n115 w_n43_n43.n43 394
R1557 w_n43_n43.n115 w_n43_n43.n45 394
R1558 w_n43_n43.n107 w_n43_n43.n45 394
R1559 w_n43_n43.n107 w_n43_n43.n51 394
R1560 w_n43_n43.n103 w_n43_n43.n51 394
R1561 w_n43_n43.n103 w_n43_n43.n53 394
R1562 w_n43_n43.n95 w_n43_n43.n53 394
R1563 w_n43_n43.n95 w_n43_n43.n59 394
R1564 w_n43_n43.n91 w_n43_n43.n59 394
R1565 w_n43_n43.n91 w_n43_n43.n61 394
R1566 w_n43_n43.n83 w_n43_n43.n61 394
R1567 w_n43_n43.n83 w_n43_n43.n67 394
R1568 w_n43_n43.n72 w_n43_n43.n69 394
R1569 w_n43_n43.n76 w_n43_n43.n71 394
R1570 w_n43_n43.n271 w_n43_n43.n220 394
R1571 w_n43_n43.n271 w_n43_n43.n215 394
R1572 w_n43_n43.n275 w_n43_n43.n215 394
R1573 w_n43_n43.n275 w_n43_n43.n213 394
R1574 w_n43_n43.n279 w_n43_n43.n213 394
R1575 w_n43_n43.n279 w_n43_n43.n208 394
R1576 w_n43_n43.n283 w_n43_n43.n208 394
R1577 w_n43_n43.n283 w_n43_n43.n206 394
R1578 w_n43_n43.n287 w_n43_n43.n206 394
R1579 w_n43_n43.n287 w_n43_n43.n201 394
R1580 w_n43_n43.n291 w_n43_n43.n201 394
R1581 w_n43_n43.n291 w_n43_n43.n199 394
R1582 w_n43_n43.n295 w_n43_n43.n199 394
R1583 w_n43_n43.n295 w_n43_n43.n194 394
R1584 w_n43_n43.n299 w_n43_n43.n194 394
R1585 w_n43_n43.n299 w_n43_n43.n192 394
R1586 w_n43_n43.n303 w_n43_n43.n192 394
R1587 w_n43_n43.n303 w_n43_n43.n187 394
R1588 w_n43_n43.n307 w_n43_n43.n187 394
R1589 w_n43_n43.n307 w_n43_n43.n185 394
R1590 w_n43_n43.n311 w_n43_n43.n185 394
R1591 w_n43_n43.n311 w_n43_n43.n180 394
R1592 w_n43_n43.n315 w_n43_n43.n180 394
R1593 w_n43_n43.n315 w_n43_n43.n178 394
R1594 w_n43_n43.n319 w_n43_n43.n178 394
R1595 w_n43_n43.n319 w_n43_n43.n173 394
R1596 w_n43_n43.n323 w_n43_n43.n173 394
R1597 w_n43_n43.n323 w_n43_n43.n7 394
R1598 w_n43_n43.n327 w_n43_n43.n7 394
R1599 w_n43_n43.n327 w_n43_n43.n6 394
R1600 w_n43_n43.n169 w_n43_n43.n6 394
R1601 w_n43_n43.n169 w_n43_n43.n9 394
R1602 w_n43_n43.n161 w_n43_n43.n9 394
R1603 w_n43_n43.n161 w_n43_n43.n15 394
R1604 w_n43_n43.n157 w_n43_n43.n15 394
R1605 w_n43_n43.n157 w_n43_n43.n17 394
R1606 w_n43_n43.n149 w_n43_n43.n17 394
R1607 w_n43_n43.n149 w_n43_n43.n23 394
R1608 w_n43_n43.n145 w_n43_n43.n23 394
R1609 w_n43_n43.n145 w_n43_n43.n25 394
R1610 w_n43_n43.n137 w_n43_n43.n25 394
R1611 w_n43_n43.n137 w_n43_n43.n31 394
R1612 w_n43_n43.n133 w_n43_n43.n31 394
R1613 w_n43_n43.n133 w_n43_n43.n33 394
R1614 w_n43_n43.n125 w_n43_n43.n33 394
R1615 w_n43_n43.n125 w_n43_n43.n39 394
R1616 w_n43_n43.n121 w_n43_n43.n39 394
R1617 w_n43_n43.n121 w_n43_n43.n41 394
R1618 w_n43_n43.n113 w_n43_n43.n41 394
R1619 w_n43_n43.n113 w_n43_n43.n47 394
R1620 w_n43_n43.n109 w_n43_n43.n47 394
R1621 w_n43_n43.n109 w_n43_n43.n49 394
R1622 w_n43_n43.n101 w_n43_n43.n49 394
R1623 w_n43_n43.n101 w_n43_n43.n55 394
R1624 w_n43_n43.n97 w_n43_n43.n55 394
R1625 w_n43_n43.n97 w_n43_n43.n57 394
R1626 w_n43_n43.n89 w_n43_n43.n57 394
R1627 w_n43_n43.n89 w_n43_n43.n63 394
R1628 w_n43_n43.n85 w_n43_n43.n63 394
R1629 w_n43_n43.n85 w_n43_n43.n65 394
R1630 w_n43_n43.n265 B 315.334
R1631 w_n43_n43.n77 w_n43_n43.n70 218.815
R1632 w_n43_n43.n78 w_n43_n43.n77 218.815
R1633 w_n43_n43.n265 w_n43_n43.n223 218.815
R1634 w_n43_n43.n266 w_n43_n43.n265 218.815
R1635 w_n43_n43.n71 w_n43_n43.n70 147.374
R1636 w_n43_n43.n78 w_n43_n43.n69 147.374
R1637 w_n43_n43.n224 w_n43_n43.n223 147.374
R1638 w_n43_n43.n266 w_n43_n43.n222 147.374
R1639 w_n43_n43.n226 w_n43_n43.n223 147.374
R1640 w_n43_n43.n267 w_n43_n43.n266 147.374
R1641 w_n43_n43.n79 w_n43_n43.n78 147.374
R1642 w_n43_n43.n72 w_n43_n43.n70 147.374
R1643 w_n43_n43.n263 w_n43_n43.n262 77.9299
R1644 w_n43_n43.n81 w_n43_n43.n80 77.9299
R1645 w_n43_n43.n269 w_n43_n43.n268 77.9299
R1646 w_n43_n43.n75 w_n43_n43.n64 77.9299
R1647 w_n43_n43.n263 w_n43_n43.n228 25.6005
R1648 w_n43_n43.n228 w_n43_n43.n227 25.6005
R1649 w_n43_n43.n227 w_n43_n43.n221 25.6005
R1650 w_n43_n43.n268 w_n43_n43.n221 25.6005
R1651 w_n43_n43.n262 w_n43_n43.n261 25.6005
R1652 w_n43_n43.n261 w_n43_n43.n260 25.6005
R1653 w_n43_n43.n260 w_n43_n43.n259 25.6005
R1654 w_n43_n43.n259 w_n43_n43.n258 25.6005
R1655 w_n43_n43.n258 w_n43_n43.n256 25.6005
R1656 w_n43_n43.n256 w_n43_n43.n255 25.6005
R1657 w_n43_n43.n255 w_n43_n43.n254 25.6005
R1658 w_n43_n43.n254 w_n43_n43.n253 25.6005
R1659 w_n43_n43.n253 w_n43_n43.n251 25.6005
R1660 w_n43_n43.n251 w_n43_n43.n250 25.6005
R1661 w_n43_n43.n250 w_n43_n43.n249 25.6005
R1662 w_n43_n43.n249 w_n43_n43.n248 25.6005
R1663 w_n43_n43.n248 w_n43_n43.n246 25.6005
R1664 w_n43_n43.n246 w_n43_n43.n245 25.6005
R1665 w_n43_n43.n245 w_n43_n43.n244 25.6005
R1666 w_n43_n43.n244 w_n43_n43.n243 25.6005
R1667 w_n43_n43.n243 w_n43_n43.n241 25.6005
R1668 w_n43_n43.n241 w_n43_n43.n240 25.6005
R1669 w_n43_n43.n240 w_n43_n43.n239 25.6005
R1670 w_n43_n43.n239 w_n43_n43.n238 25.6005
R1671 w_n43_n43.n238 w_n43_n43.n236 25.6005
R1672 w_n43_n43.n236 w_n43_n43.n235 25.6005
R1673 w_n43_n43.n235 w_n43_n43.n234 25.6005
R1674 w_n43_n43.n234 w_n43_n43.n233 25.6005
R1675 w_n43_n43.n233 w_n43_n43.n231 25.6005
R1676 w_n43_n43.n231 w_n43_n43.n230 25.6005
R1677 w_n43_n43.n230 w_n43_n43.n229 25.6005
R1678 w_n43_n43.n229 w_n43_n43.n1 25.6005
R1679 w_n43_n43.n330 w_n43_n43.n1 25.6005
R1680 w_n43_n43.n166 w_n43_n43.n0 25.6005
R1681 w_n43_n43.n166 w_n43_n43.n165 25.6005
R1682 w_n43_n43.n165 w_n43_n43.n164 25.6005
R1683 w_n43_n43.n164 w_n43_n43.n12 25.6005
R1684 w_n43_n43.n154 w_n43_n43.n12 25.6005
R1685 w_n43_n43.n154 w_n43_n43.n153 25.6005
R1686 w_n43_n43.n153 w_n43_n43.n152 25.6005
R1687 w_n43_n43.n152 w_n43_n43.n20 25.6005
R1688 w_n43_n43.n142 w_n43_n43.n20 25.6005
R1689 w_n43_n43.n142 w_n43_n43.n141 25.6005
R1690 w_n43_n43.n141 w_n43_n43.n140 25.6005
R1691 w_n43_n43.n140 w_n43_n43.n28 25.6005
R1692 w_n43_n43.n130 w_n43_n43.n28 25.6005
R1693 w_n43_n43.n130 w_n43_n43.n129 25.6005
R1694 w_n43_n43.n129 w_n43_n43.n128 25.6005
R1695 w_n43_n43.n128 w_n43_n43.n36 25.6005
R1696 w_n43_n43.n118 w_n43_n43.n36 25.6005
R1697 w_n43_n43.n118 w_n43_n43.n117 25.6005
R1698 w_n43_n43.n117 w_n43_n43.n116 25.6005
R1699 w_n43_n43.n116 w_n43_n43.n44 25.6005
R1700 w_n43_n43.n106 w_n43_n43.n44 25.6005
R1701 w_n43_n43.n106 w_n43_n43.n105 25.6005
R1702 w_n43_n43.n105 w_n43_n43.n104 25.6005
R1703 w_n43_n43.n104 w_n43_n43.n52 25.6005
R1704 w_n43_n43.n94 w_n43_n43.n52 25.6005
R1705 w_n43_n43.n94 w_n43_n43.n93 25.6005
R1706 w_n43_n43.n93 w_n43_n43.n92 25.6005
R1707 w_n43_n43.n92 w_n43_n43.n60 25.6005
R1708 w_n43_n43.n82 w_n43_n43.n60 25.6005
R1709 w_n43_n43.n82 w_n43_n43.n81 25.6005
R1710 w_n43_n43.n80 w_n43_n43.n68 25.6005
R1711 w_n43_n43.n73 w_n43_n43.n68 25.6005
R1712 w_n43_n43.n74 w_n43_n43.n73 25.6005
R1713 w_n43_n43.n75 w_n43_n43.n74 25.6005
R1714 w_n43_n43.n270 w_n43_n43.n269 25.6005
R1715 w_n43_n43.n270 w_n43_n43.n214 25.6005
R1716 w_n43_n43.n276 w_n43_n43.n214 25.6005
R1717 w_n43_n43.n277 w_n43_n43.n276 25.6005
R1718 w_n43_n43.n278 w_n43_n43.n277 25.6005
R1719 w_n43_n43.n278 w_n43_n43.n207 25.6005
R1720 w_n43_n43.n284 w_n43_n43.n207 25.6005
R1721 w_n43_n43.n285 w_n43_n43.n284 25.6005
R1722 w_n43_n43.n286 w_n43_n43.n285 25.6005
R1723 w_n43_n43.n286 w_n43_n43.n200 25.6005
R1724 w_n43_n43.n292 w_n43_n43.n200 25.6005
R1725 w_n43_n43.n293 w_n43_n43.n292 25.6005
R1726 w_n43_n43.n294 w_n43_n43.n293 25.6005
R1727 w_n43_n43.n294 w_n43_n43.n193 25.6005
R1728 w_n43_n43.n300 w_n43_n43.n193 25.6005
R1729 w_n43_n43.n301 w_n43_n43.n300 25.6005
R1730 w_n43_n43.n302 w_n43_n43.n301 25.6005
R1731 w_n43_n43.n302 w_n43_n43.n186 25.6005
R1732 w_n43_n43.n308 w_n43_n43.n186 25.6005
R1733 w_n43_n43.n309 w_n43_n43.n308 25.6005
R1734 w_n43_n43.n310 w_n43_n43.n309 25.6005
R1735 w_n43_n43.n310 w_n43_n43.n179 25.6005
R1736 w_n43_n43.n316 w_n43_n43.n179 25.6005
R1737 w_n43_n43.n317 w_n43_n43.n316 25.6005
R1738 w_n43_n43.n318 w_n43_n43.n317 25.6005
R1739 w_n43_n43.n318 w_n43_n43.n172 25.6005
R1740 w_n43_n43.n324 w_n43_n43.n172 25.6005
R1741 w_n43_n43.n325 w_n43_n43.n324 25.6005
R1742 w_n43_n43.n326 w_n43_n43.n325 25.6005
R1743 w_n43_n43.n326 w_n43_n43.n171 25.6005
R1744 w_n43_n43.n171 w_n43_n43.n170 25.6005
R1745 w_n43_n43.n170 w_n43_n43.n8 25.6005
R1746 w_n43_n43.n160 w_n43_n43.n8 25.6005
R1747 w_n43_n43.n160 w_n43_n43.n159 25.6005
R1748 w_n43_n43.n159 w_n43_n43.n158 25.6005
R1749 w_n43_n43.n158 w_n43_n43.n16 25.6005
R1750 w_n43_n43.n148 w_n43_n43.n16 25.6005
R1751 w_n43_n43.n148 w_n43_n43.n147 25.6005
R1752 w_n43_n43.n147 w_n43_n43.n146 25.6005
R1753 w_n43_n43.n146 w_n43_n43.n24 25.6005
R1754 w_n43_n43.n136 w_n43_n43.n24 25.6005
R1755 w_n43_n43.n136 w_n43_n43.n135 25.6005
R1756 w_n43_n43.n135 w_n43_n43.n134 25.6005
R1757 w_n43_n43.n134 w_n43_n43.n32 25.6005
R1758 w_n43_n43.n124 w_n43_n43.n32 25.6005
R1759 w_n43_n43.n124 w_n43_n43.n123 25.6005
R1760 w_n43_n43.n123 w_n43_n43.n122 25.6005
R1761 w_n43_n43.n122 w_n43_n43.n40 25.6005
R1762 w_n43_n43.n112 w_n43_n43.n40 25.6005
R1763 w_n43_n43.n112 w_n43_n43.n111 25.6005
R1764 w_n43_n43.n111 w_n43_n43.n110 25.6005
R1765 w_n43_n43.n110 w_n43_n43.n48 25.6005
R1766 w_n43_n43.n100 w_n43_n43.n48 25.6005
R1767 w_n43_n43.n100 w_n43_n43.n99 25.6005
R1768 w_n43_n43.n99 w_n43_n43.n98 25.6005
R1769 w_n43_n43.n98 w_n43_n43.n56 25.6005
R1770 w_n43_n43.n88 w_n43_n43.n56 25.6005
R1771 w_n43_n43.n88 w_n43_n43.n87 25.6005
R1772 w_n43_n43.n87 w_n43_n43.n86 25.6005
R1773 w_n43_n43.n86 w_n43_n43.n64 25.6005
R1774 B w_n43_n43.n330 19.2005
R1775 B w_n43_n43.n0 6.4005
C2 B.n0 B 0 ; **FLOATING
C3 B.n3 B 0 ; **FLOATING
C4 B.n4 B 0 ; **FLOATING
C5 B.n5 B 0 ; **FLOATING
C6 B.n6 B 0 ; **FLOATING
C7 B.n7 B 0 ; **FLOATING
C8 B.n8 B 0 ; **FLOATING
C9 B.n9 B 0 ; **FLOATING
C10 B.n10 B 0 ; **FLOATING
C11 B.n11 B 0 ; **FLOATING
C12 B.n12 B 0 ; **FLOATING
C13 B.n13 B 0 ; **FLOATING
C14 B.n14 B 0 ; **FLOATING
C15 B.n15 B 0 ; **FLOATING
C16 B.n16 B 0 ; **FLOATING
C17 B.n17 B 0 ; **FLOATING
C18 B.n18 B 0 ; **FLOATING
C19 B.n19 B 0 ; **FLOATING
C20 B.n20 B 0 ; **FLOATING
C21 B.n21 B 0 ; **FLOATING
C22 B.n22 B 0 ; **FLOATING
C23 B.n23 B 0 ; **FLOATING
C24 B.n24 B 0 ; **FLOATING
C25 B.n25 B 0 ; **FLOATING
C26 B.n26 B 0 ; **FLOATING
C27 B.n27 B 0 ; **FLOATING
C28 B.n28 B 0 ; **FLOATING
C29 B.n29 B 0 ; **FLOATING
C30 B.n30 B 0 ; **FLOATING
C31 B.n31 B 0 ; **FLOATING
C32 B.n32 B 0 ; **FLOATING
C33 B.n33 B 0 ; **FLOATING
C34 B.n34 B 0 ; **FLOATING
C35 B.n35 B 0 ; **FLOATING
C36 B.n36 B 0 ; **FLOATING
C37 B.n37 B 0 ; **FLOATING
C38 B.n38 B 0 ; **FLOATING
C39 B.n39 B 0 ; **FLOATING
C40 B.n40 B 0 ; **FLOATING
C41 B.n41 B 0 ; **FLOATING
C42 B.n42 B 0 ; **FLOATING
C43 B.n43 B 0 ; **FLOATING
C44 B.n44 B 0 ; **FLOATING
C45 B.n45 B 0 ; **FLOATING
C46 B.n46 B 0 ; **FLOATING
C47 B.n47 B 0 ; **FLOATING
C48 B.n48 B 0 ; **FLOATING
C49 B.n49 B 0 ; **FLOATING
C50 B.n50 B 0 ; **FLOATING
C51 B.n51 B 0 ; **FLOATING
C52 B.n52 B 0 ; **FLOATING
C53 B.n53 B 0 ; **FLOATING
C54 B.n54 B 0 ; **FLOATING
C55 B.n55 B 0 ; **FLOATING
C56 B.n56 B 0 ; **FLOATING
C57 B.n57 B 0 ; **FLOATING
C58 B.n58 B 0 ; **FLOATING
C59 B.n59 B 0 ; **FLOATING
C60 B.n60 B 0 ; **FLOATING
C61 B.n61 B 0 ; **FLOATING
C62 B.n62 B 0 ; **FLOATING
C63 B.n63 B 0 ; **FLOATING
C64 B.n64 B 0 ; **FLOATING
C65 B.n65 B 0 ; **FLOATING
C66 B.n66 B 0 ; **FLOATING
C67 B.n67 B 0 ; **FLOATING
C68 B.n68 B 0 ; **FLOATING
C69 B.n69 B 0 ; **FLOATING
C70 B.n70 B 0 ; **FLOATING
C71 B.n71 B 0 ; **FLOATING
C72 B.n72 B 0 ; **FLOATING
C73 B.n73 B 0 ; **FLOATING
C74 B.n74 B 0 ; **FLOATING
C75 B.n75 B 0 ; **FLOATING
C76 B.n76 B 0 ; **FLOATING
C77 B.n77 B 0 ; **FLOATING
C78 B.n78 B 0 ; **FLOATING
C79 B.n79 B 0 ; **FLOATING
C80 B.n80 B 0 ; **FLOATING
C81 B.n81 B 0 ; **FLOATING
C82 B.n82 B 0 ; **FLOATING
C83 B.n83 B 0 ; **FLOATING
C84 B.n84 B 0 ; **FLOATING
C85 B.n85 B 0 ; **FLOATING
C86 B.n86 B 0 ; **FLOATING
C87 B.n87 B 0 ; **FLOATING
C88 B.n88 B 0 ; **FLOATING
C89 B.n89 B 0 ; **FLOATING
C90 B.n90 B 0 ; **FLOATING
C91 B.n91 B 0 ; **FLOATING
C92 B.n92 B 0 ; **FLOATING
C93 B.n93 B 0 ; **FLOATING
C94 B.n94 B 0 ; **FLOATING
C95 B.n95 B 0 ; **FLOATING
C96 B.n96 B 0 ; **FLOATING
C97 B.n97 B 0 ; **FLOATING
C98 B.n98 B 0 ; **FLOATING
C99 B.n99 B 0 ; **FLOATING
C100 B.n100 B 0 ; **FLOATING
C101 B.n101 B 0 ; **FLOATING
C102 B.n102 B 0 ; **FLOATING
C103 B.n103 B 0 ; **FLOATING
C104 B.n104 B 0 ; **FLOATING
C105 B.n105 B 0 ; **FLOATING
C106 B.n106 B 0 ; **FLOATING
C107 B.n107 B 0 ; **FLOATING
C108 B.n108 B 0 ; **FLOATING
C109 B.n109 B 0 ; **FLOATING
C110 B.n110 B 0 ; **FLOATING
C111 B.n111 B 0 ; **FLOATING
C112 B.n112 B 0 ; **FLOATING
C113 B.n113 B 0 ; **FLOATING
C114 B.n114 B 0 ; **FLOATING
C115 B.n115 B 0 ; **FLOATING
C116 B.n116 B 0 ; **FLOATING
C117 B.n117 B 0 ; **FLOATING
C118 B.n118 B 0 ; **FLOATING
C119 B.n119 B 0 ; **FLOATING
C120 B.n120 B 0 ; **FLOATING
C121 B.n121 B 0 ; **FLOATING
C122 B.n122 B 0 ; **FLOATING
C123 B.n123 B 0 ; **FLOATING
C124 B.n124 B 0 ; **FLOATING
C125 B.n125 B 0 ; **FLOATING
C126 B.n126 B 0 ; **FLOATING
C127 B.n127 B 0 ; **FLOATING
C128 B.n129 B 0 ; **FLOATING
C129 B.n130 B 0 ; **FLOATING
C130 B.n131 B 0 ; **FLOATING
C131 B.n132 B 0 ; **FLOATING
C132 B.n133 B 0 ; **FLOATING
C133 B.n134 B 0 ; **FLOATING
C134 B.n136 B 0 ; **FLOATING
C135 B.n137 B 0 ; **FLOATING
C136 B.n138 B 0 ; **FLOATING
C137 B.n139 B 0 ; **FLOATING
C138 B.n140 B 0 ; **FLOATING
C139 B.n141 B 0 ; **FLOATING
C140 B.n142 B 0 ; **FLOATING
C141 B.n143 B 0 ; **FLOATING
C142 B.n144 B 0 ; **FLOATING
C143 B.n145 B 0 ; **FLOATING
C144 B.n146 B 0 ; **FLOATING
C145 B.n147 B 0 ; **FLOATING
C146 B.n148 B 0 ; **FLOATING
C147 B.n149 B 0 ; **FLOATING
C148 B.n150 B 0 ; **FLOATING
C149 B.n151 B 0 ; **FLOATING
C150 B.n152 B 0 ; **FLOATING
C151 B.n153 B 0 ; **FLOATING
C152 B.n154 B 0 ; **FLOATING
C153 B.n155 B 0 ; **FLOATING
C154 B.n156 B 0 ; **FLOATING
C155 B.n157 B 0 ; **FLOATING
C156 B.n158 B 0 ; **FLOATING
C157 B.n159 B 0 ; **FLOATING
C158 B.n160 B 0 ; **FLOATING
C159 B.n161 B 0 ; **FLOATING
C160 B.n162 B 0 ; **FLOATING
C161 B.n163 B 0 ; **FLOATING
C162 B.n164 B 0 ; **FLOATING
C163 B.n165 B 0 ; **FLOATING
C164 B.n166 B 0 ; **FLOATING
C165 B.n167 B 0 ; **FLOATING
C166 B.n168 B 0 ; **FLOATING
C167 B.n169 B 0 ; **FLOATING
C168 B.n170 B 0 ; **FLOATING
C169 B.n171 B 0 ; **FLOATING
C170 B.n172 B 0 ; **FLOATING
C171 B.n173 B 0 ; **FLOATING
C172 B.n174 B 0 ; **FLOATING
C173 B.n175 B 0 ; **FLOATING
C174 B.n176 B 0 ; **FLOATING
C175 B.n177 B 0 ; **FLOATING
C176 B.n178 B 0 ; **FLOATING
C177 B.n179 B 0 ; **FLOATING
C178 B.n180 B 0 ; **FLOATING
C179 B.n181 B 0 ; **FLOATING
C180 B.n182 B 0 ; **FLOATING
C181 B.n183 B 0 ; **FLOATING
C182 B.n184 B 0 ; **FLOATING
C183 B.n185 B 0 ; **FLOATING
C184 B.n186 B 0 ; **FLOATING
C185 B.n187 B 0 ; **FLOATING
C186 B.n188 B 0 ; **FLOATING
C187 B.n189 B 0 ; **FLOATING
C188 B.n190 B 0 ; **FLOATING
C189 B.n191 B 0 ; **FLOATING
C190 B.n192 B 0 ; **FLOATING
C191 B.n193 B 0 ; **FLOATING
C192 B.n194 B 0 ; **FLOATING
C193 B.n195 B 0 ; **FLOATING
C194 B.n196 B 0 ; **FLOATING
C195 B.n197 B 0 ; **FLOATING
C196 B.n198 B 0 ; **FLOATING
C197 B.n199 B 0 ; **FLOATING
C198 B.n200 B 0 ; **FLOATING
C199 B.n201 B 0 ; **FLOATING
C200 B.n202 B 0 ; **FLOATING
C201 B.n203 B 0 ; **FLOATING
C202 B.n204 B 0 ; **FLOATING
C203 B.n205 B 0 ; **FLOATING
C204 B.n206 B 0 ; **FLOATING
C205 B.n207 B 0 ; **FLOATING
C206 B.n208 B 0 ; **FLOATING
C207 B.n209 B 0 ; **FLOATING
C208 B.n210 B 0 ; **FLOATING
C209 B.n211 B 0 ; **FLOATING
C210 B.n212 B 0 ; **FLOATING
C211 B.n213 B 0 ; **FLOATING
C212 B.n214 B 0 ; **FLOATING
C213 B.n215 B 0 ; **FLOATING
C214 B.n216 B 0 ; **FLOATING
C215 B.n217 B 0 ; **FLOATING
C216 B.n218 B 0 ; **FLOATING
C217 B.n219 B 0 ; **FLOATING
C218 B.n220 B 0 ; **FLOATING
C219 B.n221 B 0 ; **FLOATING
C220 B.n222 B 0 ; **FLOATING
C221 B.n223 B 0 ; **FLOATING
C222 B.n224 B 0 ; **FLOATING
C223 B.n225 B 0 ; **FLOATING
C224 B.n226 B 0 ; **FLOATING
C225 B.n227 B 0 ; **FLOATING
C226 B.n228 B 0 ; **FLOATING
C227 B.n229 B 0 ; **FLOATING
C228 B.n230 B 0 ; **FLOATING
C229 B.n231 B 0 ; **FLOATING
C230 B.n232 B 0 ; **FLOATING
C231 B.n233 B 0 ; **FLOATING
C232 B.n234 B 0 ; **FLOATING
C233 B.n235 B 0 ; **FLOATING
C234 B.n236 B 0 ; **FLOATING
C235 B.n237 B 0 ; **FLOATING
C236 B.n238 B 0 ; **FLOATING
C237 B.n239 B 0 ; **FLOATING
C238 B.n240 B 0 ; **FLOATING
C239 B.n241 B 0 ; **FLOATING
C240 B.n242 B 0 ; **FLOATING
C241 B.n243 B 0 ; **FLOATING
C242 B.n244 B 0 ; **FLOATING
C243 B.n245 B 0 ; **FLOATING
C244 B.n246 B 0 ; **FLOATING
C245 B.n247 B 0 ; **FLOATING
C246 B.n248 B 0 ; **FLOATING
C247 B.n249 B 0 ; **FLOATING
C248 B.n250 B 0 ; **FLOATING
C249 B.n251 B 0 ; **FLOATING
C250 B.n252 B 0 ; **FLOATING
C251 B.n253 B 0 ; **FLOATING
C252 B.n254 B 0 ; **FLOATING
C253 B.n255 B 0 ; **FLOATING
C254 B.n256 B 0 ; **FLOATING
C255 B.n257 B 0 ; **FLOATING
C256 B.n258 B 0 ; **FLOATING
C257 B.n259 B 0 ; **FLOATING
C258 B.n260 B 0 ; **FLOATING
C259 B.n261 B 0 ; **FLOATING
C260 B.n262 B 0 ; **FLOATING
C261 B.n263 B 0 ; **FLOATING
C262 B.n264 B 0 ; **FLOATING
C263 B.n265 B 0 ; **FLOATING
C264 B.n266 B 0 ; **FLOATING
C265 B.n267 B 0 ; **FLOATING
C266 B.n268 B 0 ; **FLOATING
C267 B.n269 B 0 ; **FLOATING
C268 B.n270 B 0 ; **FLOATING
C269 B.n271 B 0 ; **FLOATING
C270 B.n272 B 0 ; **FLOATING
C271 B.n273 B 0 ; **FLOATING
C272 B.n274 B 0 ; **FLOATING
C273 B.n275 B 0 ; **FLOATING
C274 B.n276 B 0 ; **FLOATING
C275 B.n277 B 0 ; **FLOATING
C276 B.n278 B 0 ; **FLOATING
C277 B.n279 B 0 ; **FLOATING
C278 B.n280 B 0 ; **FLOATING
C279 B.n281 B 0 ; **FLOATING
C280 B.n282 B 0 ; **FLOATING
C281 B.n283 B 0 ; **FLOATING
C282 B.n284 B 0 ; **FLOATING
C283 B.n285 B 0 ; **FLOATING
C284 B.n286 B 0 ; **FLOATING
C285 B.n287 B 0 ; **FLOATING
C286 B.n288 B 0 ; **FLOATING
C287 B.n289 B 0 ; **FLOATING
C288 B.n290 B 0 ; **FLOATING
C289 B.n291 B 0 ; **FLOATING
C290 B.n292 B 0 ; **FLOATING
C291 B.n293 B 0 ; **FLOATING
C292 B.n294 B 0 ; **FLOATING
C293 B.n295 B 0 ; **FLOATING
C294 B.n296 B 0 ; **FLOATING
C295 B.n297 B 0 ; **FLOATING
C296 B.n298 B 0 ; **FLOATING
C297 B.n299 B 0 ; **FLOATING
C298 B.n300 B 0 ; **FLOATING
C299 B.n301 B 0 ; **FLOATING
C300 B.n302 B 0 ; **FLOATING
C301 B.n303 B 0 ; **FLOATING
C302 B.n304 B 0 ; **FLOATING
C303 B.n305 B 0 ; **FLOATING
C304 B.n306 B 0 ; **FLOATING
C305 B.n307 B 0 ; **FLOATING
C306 B.n308 B 0 ; **FLOATING
C307 B.n309 B 0 ; **FLOATING
C308 B.n310 B 0 ; **FLOATING
C309 B.n311 B 0 ; **FLOATING
C310 B.n312 B 0 ; **FLOATING
C311 B.n313 B 0 ; **FLOATING
C312 B.n314 B 0 ; **FLOATING
C313 B.n315 B 0 ; **FLOATING
C314 B.n316 B 0 ; **FLOATING
C315 B.n317 B 0 ; **FLOATING
C316 B.n318 B 0 ; **FLOATING
C317 B.n319 B 0 ; **FLOATING
C318 B.n320 B 0 ; **FLOATING
C319 B.n321 B 0 ; **FLOATING
C320 B.n322 B 0 ; **FLOATING
C321 B.n323 B 0 ; **FLOATING
C322 B.n324 B 0 ; **FLOATING
C323 B.n325 B 0 ; **FLOATING
C324 B.n326 B 0 ; **FLOATING
C325 B.n327 B 0 ; **FLOATING
C326 B.n328 B 0 ; **FLOATING
C327 B.n329 B 0 ; **FLOATING
C328 B.n330 B 0 ; **FLOATING
C329 S B 0.15176f
C330 D B 0.15176f
C331 G B 8.10371f
