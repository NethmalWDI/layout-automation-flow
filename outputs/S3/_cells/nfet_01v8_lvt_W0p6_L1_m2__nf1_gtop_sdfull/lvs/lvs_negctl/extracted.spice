* NGSPICE file created from nfet_01v8_lvt_W0p6_L1_m2__nf1_gtop_sdfull.ext - technology: sky130A

.subckt sky130_fd_pr__nfet_01v8_lvt_ELTGRQ G D B S
X0 S G D B sky130_fd_pr__nfet_01v8_lvt ad=0.174 pd=1.78 as=0.174 ps=1.78 w=0.6 l=1
.ends

.subckt nfet_01v8_lvt_W0p6_L1_m2__nf1_gtop_sdfull D S G B
Xnfet_01v8_lvt_W0p6_L1_m2__nf1_gtop_sdfull_pc G D B S sky130_fd_pr__nfet_01v8_lvt_ELTGRQ
.ends
