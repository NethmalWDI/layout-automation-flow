* NGSPICE file created from pfet_01v8_lvt_W5_L1_m2__nf4_gtop_sdfull_outS_ng.ext - technology: sky130A

.subckt sky130_fd_pr__pfet_01v8_lvt_2UKYQY G a_487_n161# D2 D0 w_n581_n223# S3 S1
X0 S3 G D2 w_n581_n223# sky130_fd_pr__pfet_01v8_lvt ad=0.18125 pd=1.54 as=0.18125 ps=1.54 w=1.25 l=1
X1 D2 G S1 w_n581_n223# sky130_fd_pr__pfet_01v8_lvt ad=0.18125 pd=1.54 as=0.18125 ps=1.54 w=1.25 l=1
X2 S1 G D0 w_n581_n223# sky130_fd_pr__pfet_01v8_lvt ad=0.18125 pd=1.54 as=0.3625 ps=3.08 w=1.25 l=1
X3 a_487_n161# G S3 w_n581_n223# sky130_fd_pr__pfet_01v8_lvt ad=0.3625 pd=3.08 as=0.18125 ps=1.54 w=1.25 l=1
.ends

.subckt pfet_01v8_lvt_W5_L1_m2__nf4_gtop_sdfull_outS_ng S D G B
Xpfet_01v8_lvt_W5_L1_m2__nf4_gtop_sdfull_outS_ng_pc G S S S B D D sky130_fd_pr__pfet_01v8_lvt_2UKYQY
.ends
