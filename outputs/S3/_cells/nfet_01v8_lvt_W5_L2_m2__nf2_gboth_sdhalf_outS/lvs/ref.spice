.subckt nfet_01v8_lvt_W5_L2_m2__nf2_gboth_sdhalf_outS D G S B
Xnfet_01v8_lvt_W5_L2_m2__nf2_gboth_sdhalf_outS D G S B sky130_fd_pr__nfet_01v8_lvt L=2 W=5 nf=2
.ends
