* NGSPICE file created from nfet_01v8_lvt_W5_L2_m2__nf2_gboth_sdhalf_outS.ext - technology: sky130A

.subckt nfet_01v8_lvt_W5_L2_m2__nf2_gboth_sdhalf_outS S D G B
X0 D G S B sky130_fd_pr__nfet_01v8_lvt ad=0.3625 pd=2.79 as=0.725 ps=5.58 w=2.5 l=2
X1 S G D B sky130_fd_pr__nfet_01v8_lvt ad=0.725 pd=5.58 as=0.3625 ps=2.79 w=2.5 l=2
C0 D S 0.32691f
C1 G D 0.37406f
C2 G S 0.3747f
C3 D B 0.1678f
C4 S B 0.41482f
C5 G B 1.85168f
.ends
