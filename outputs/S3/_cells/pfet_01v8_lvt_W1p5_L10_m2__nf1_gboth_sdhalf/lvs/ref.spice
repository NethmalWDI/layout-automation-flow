.subckt pfet_01v8_lvt_W1p5_L10_m2__nf1_gboth_sdhalf D G S B
Xpfet_01v8_lvt_W1p5_L10_m2__nf1_gboth_sdhalf D G S B sky130_fd_pr__pfet_01v8_lvt L=10 W=1.5 nf=1
.ends
