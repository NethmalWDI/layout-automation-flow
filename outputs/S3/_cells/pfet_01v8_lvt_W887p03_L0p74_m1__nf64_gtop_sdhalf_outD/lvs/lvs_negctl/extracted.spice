* NGSPICE file created from pfet_01v8_lvt_W887p03_L0p74_m1__nf64_gtop_sdhalf_outD.ext - technology: sky130A

.subckt sky130_fd_pr__pfet_01v8_lvt_328ZPL D54 S49 D44 D32 S27 D22 S17 D10 S59 D42
+ S37 D20 S15 G D52 S47 D30 S25 D62 S57 D40 S35 S13 D50 S45 S23 D60 S55 S33 S11 B
+ S43 S21 S63 S53 S41 S31 S51 S61 D8 D6 D4 D2 D0 S9 S7 D18 a_6563_n1422# D28 S5 D38
+ D16 D48 D26 S3 D58 D36 D14 D46 D24 S19 S1 D56 S39 D34 S29 D12
X0 S23 G D22 B sky130_fd_pr__pfet_01v8_lvt ad=2.0097 pd=14.15 as=2.0097 ps=14.15 w=13.86 l=0.74
X1 D22 G S21 B sky130_fd_pr__pfet_01v8_lvt ad=2.0097 pd=14.15 as=2.0097 ps=14.15 w=13.86 l=0.74
X2 D42 G S41 B sky130_fd_pr__pfet_01v8_lvt ad=2.0097 pd=14.15 as=2.0097 ps=14.15 w=13.86 l=0.74
X3 D58 G S57 B sky130_fd_pr__pfet_01v8_lvt ad=2.0097 pd=14.15 as=2.0097 ps=14.15 w=13.86 l=0.74
X4 S15 G D14 B sky130_fd_pr__pfet_01v8_lvt ad=2.0097 pd=14.15 as=2.0097 ps=14.15 w=13.86 l=0.74
X5 D16 G S15 B sky130_fd_pr__pfet_01v8_lvt ad=2.0097 pd=14.15 as=2.0097 ps=14.15 w=13.86 l=0.74
X6 S35 G D34 B sky130_fd_pr__pfet_01v8_lvt ad=2.0097 pd=14.15 as=2.0097 ps=14.15 w=13.86 l=0.74
X7 D50 G S49 B sky130_fd_pr__pfet_01v8_lvt ad=2.0097 pd=14.15 as=2.0097 ps=14.15 w=13.86 l=0.74
X8 D8 G S7 B sky130_fd_pr__pfet_01v8_lvt ad=2.0097 pd=14.15 as=2.0097 ps=14.15 w=13.86 l=0.74
X9 D32 G S31 B sky130_fd_pr__pfet_01v8_lvt ad=2.0097 pd=14.15 as=2.0097 ps=14.15 w=13.86 l=0.74
X10 D36 G S35 B sky130_fd_pr__pfet_01v8_lvt ad=2.0097 pd=14.15 as=2.0097 ps=14.15 w=13.86 l=0.74
X11 S51 G D50 B sky130_fd_pr__pfet_01v8_lvt ad=2.0097 pd=14.15 as=2.0097 ps=14.15 w=13.86 l=0.74
X12 S1 G D0 B sky130_fd_pr__pfet_01v8_lvt ad=2.0097 pd=14.15 as=4.0194 ps=28.3 w=13.86 l=0.74
X13 S7 G D6 B sky130_fd_pr__pfet_01v8_lvt ad=2.0097 pd=14.15 as=2.0097 ps=14.15 w=13.86 l=0.74
X14 S57 G D56 B sky130_fd_pr__pfet_01v8_lvt ad=2.0097 pd=14.15 as=2.0097 ps=14.15 w=13.86 l=0.74
X15 D18 G S17 B sky130_fd_pr__pfet_01v8_lvt ad=2.0097 pd=14.15 as=2.0097 ps=14.15 w=13.86 l=0.74
X16 D40 G S39 B sky130_fd_pr__pfet_01v8_lvt ad=2.0097 pd=14.15 as=2.0097 ps=14.15 w=13.86 l=0.74
X17 S41 G D40 B sky130_fd_pr__pfet_01v8_lvt ad=2.0097 pd=14.15 as=2.0097 ps=14.15 w=13.86 l=0.74
X18 S17 G D16 B sky130_fd_pr__pfet_01v8_lvt ad=2.0097 pd=14.15 as=2.0097 ps=14.15 w=13.86 l=0.74
X19 D34 G S33 B sky130_fd_pr__pfet_01v8_lvt ad=2.0097 pd=14.15 as=2.0097 ps=14.15 w=13.86 l=0.74
X20 S49 G D48 B sky130_fd_pr__pfet_01v8_lvt ad=2.0097 pd=14.15 as=2.0097 ps=14.15 w=13.86 l=0.74
X21 S55 G D54 B sky130_fd_pr__pfet_01v8_lvt ad=2.0097 pd=14.15 as=2.0097 ps=14.15 w=13.86 l=0.74
X22 S3 G D2 B sky130_fd_pr__pfet_01v8_lvt ad=2.0097 pd=14.15 as=2.0097 ps=14.15 w=13.86 l=0.74
X23 D24 G S23 B sky130_fd_pr__pfet_01v8_lvt ad=2.0097 pd=14.15 as=2.0097 ps=14.15 w=13.86 l=0.74
X24 D56 G S55 B sky130_fd_pr__pfet_01v8_lvt ad=2.0097 pd=14.15 as=2.0097 ps=14.15 w=13.86 l=0.74
X25 D2 G S1 B sky130_fd_pr__pfet_01v8_lvt ad=2.0097 pd=14.15 as=2.0097 ps=14.15 w=13.86 l=0.74
X26 a_6563_n1422# G S63 B sky130_fd_pr__pfet_01v8_lvt ad=4.0194 pd=28.3 as=2.0097 ps=14.15 w=13.86 l=0.74
X27 S9 G D8 B sky130_fd_pr__pfet_01v8_lvt ad=2.0097 pd=14.15 as=2.0097 ps=14.15 w=13.86 l=0.74
X28 S39 G D38 B sky130_fd_pr__pfet_01v8_lvt ad=2.0097 pd=14.15 as=2.0097 ps=14.15 w=13.86 l=0.74
X29 S13 G D12 B sky130_fd_pr__pfet_01v8_lvt ad=2.0097 pd=14.15 as=2.0097 ps=14.15 w=13.86 l=0.74
X30 D12 G S11 B sky130_fd_pr__pfet_01v8_lvt ad=2.0097 pd=14.15 as=2.0097 ps=14.15 w=13.86 l=0.74
X31 D48 G S47 B sky130_fd_pr__pfet_01v8_lvt ad=2.0097 pd=14.15 as=2.0097 ps=14.15 w=13.86 l=0.74
X32 S25 G D24 B sky130_fd_pr__pfet_01v8_lvt ad=2.0097 pd=14.15 as=2.0097 ps=14.15 w=13.86 l=0.74
X33 D26 G S25 B sky130_fd_pr__pfet_01v8_lvt ad=2.0097 pd=14.15 as=2.0097 ps=14.15 w=13.86 l=0.74
X34 D54 G S53 B sky130_fd_pr__pfet_01v8_lvt ad=2.0097 pd=14.15 as=2.0097 ps=14.15 w=13.86 l=0.74
X35 D60 G S59 B sky130_fd_pr__pfet_01v8_lvt ad=2.0097 pd=14.15 as=2.0097 ps=14.15 w=13.86 l=0.74
X36 S19 G D18 B sky130_fd_pr__pfet_01v8_lvt ad=2.0097 pd=14.15 as=2.0097 ps=14.15 w=13.86 l=0.74
X37 S61 G D60 B sky130_fd_pr__pfet_01v8_lvt ad=2.0097 pd=14.15 as=2.0097 ps=14.15 w=13.86 l=0.74
X38 D62 G S61 B sky130_fd_pr__pfet_01v8_lvt ad=2.0097 pd=14.15 as=2.0097 ps=14.15 w=13.86 l=0.74
X39 S11 G D10 B sky130_fd_pr__pfet_01v8_lvt ad=2.0097 pd=14.15 as=2.0097 ps=14.15 w=13.86 l=0.74
X40 S47 G D46 B sky130_fd_pr__pfet_01v8_lvt ad=2.0097 pd=14.15 as=2.0097 ps=14.15 w=13.86 l=0.74
X41 S63 G D62 B sky130_fd_pr__pfet_01v8_lvt ad=2.0097 pd=14.15 as=2.0097 ps=14.15 w=13.86 l=0.74
X42 D10 G S9 B sky130_fd_pr__pfet_01v8_lvt ad=2.0097 pd=14.15 as=2.0097 ps=14.15 w=13.86 l=0.74
X43 S29 G D28 B sky130_fd_pr__pfet_01v8_lvt ad=2.0097 pd=14.15 as=2.0097 ps=14.15 w=13.86 l=0.74
X44 D4 G S3 B sky130_fd_pr__pfet_01v8_lvt ad=2.0097 pd=14.15 as=2.0097 ps=14.15 w=13.86 l=0.74
X45 D38 G S37 B sky130_fd_pr__pfet_01v8_lvt ad=2.0097 pd=14.15 as=2.0097 ps=14.15 w=13.86 l=0.74
X46 D44 G S43 B sky130_fd_pr__pfet_01v8_lvt ad=2.0097 pd=14.15 as=2.0097 ps=14.15 w=13.86 l=0.74
X47 D28 G S27 B sky130_fd_pr__pfet_01v8_lvt ad=2.0097 pd=14.15 as=2.0097 ps=14.15 w=13.86 l=0.74
X48 S27 G D26 B sky130_fd_pr__pfet_01v8_lvt ad=2.0097 pd=14.15 as=2.0097 ps=14.15 w=13.86 l=0.74
X49 S53 G D52 B sky130_fd_pr__pfet_01v8_lvt ad=2.0097 pd=14.15 as=2.0097 ps=14.15 w=13.86 l=0.74
X50 S59 G D58 B sky130_fd_pr__pfet_01v8_lvt ad=2.0097 pd=14.15 as=2.0097 ps=14.15 w=13.86 l=0.74
X51 D20 G S19 B sky130_fd_pr__pfet_01v8_lvt ad=2.0097 pd=14.15 as=2.0097 ps=14.15 w=13.86 l=0.74
X52 S21 G D20 B sky130_fd_pr__pfet_01v8_lvt ad=2.0097 pd=14.15 as=2.0097 ps=14.15 w=13.86 l=0.74
X53 S45 G D44 B sky130_fd_pr__pfet_01v8_lvt ad=2.0097 pd=14.15 as=2.0097 ps=14.15 w=13.86 l=0.74
X54 D14 G S13 B sky130_fd_pr__pfet_01v8_lvt ad=2.0097 pd=14.15 as=2.0097 ps=14.15 w=13.86 l=0.74
X55 S37 G D36 B sky130_fd_pr__pfet_01v8_lvt ad=2.0097 pd=14.15 as=2.0097 ps=14.15 w=13.86 l=0.74
X56 D46 G S45 B sky130_fd_pr__pfet_01v8_lvt ad=2.0097 pd=14.15 as=2.0097 ps=14.15 w=13.86 l=0.74
X57 D6 G S5 B sky130_fd_pr__pfet_01v8_lvt ad=2.0097 pd=14.15 as=2.0097 ps=14.15 w=13.86 l=0.74
X58 S31 G D30 B sky130_fd_pr__pfet_01v8_lvt ad=2.0097 pd=14.15 as=2.0097 ps=14.15 w=13.86 l=0.74
X59 S33 G D32 B sky130_fd_pr__pfet_01v8_lvt ad=2.0097 pd=14.15 as=2.0097 ps=14.15 w=13.86 l=0.74
X60 D52 G S51 B sky130_fd_pr__pfet_01v8_lvt ad=2.0097 pd=14.15 as=2.0097 ps=14.15 w=13.86 l=0.74
X61 S5 G D4 B sky130_fd_pr__pfet_01v8_lvt ad=2.0097 pd=14.15 as=2.0097 ps=14.15 w=13.86 l=0.74
X62 D30 G S29 B sky130_fd_pr__pfet_01v8_lvt ad=2.0097 pd=14.15 as=2.0097 ps=14.15 w=13.86 l=0.74
X63 S43 G D42 B sky130_fd_pr__pfet_01v8_lvt ad=2.0097 pd=14.15 as=2.0097 ps=14.15 w=13.86 l=0.74
.ends

.subckt pfet_01v8_lvt_W887p03_L0p74_m1__nf64_gtop_sdhalf_outD S D G B
Xpfet_01v8_lvt_W887p03_L0p74_m1__nf64_gtop_sdhalf_outD_pc D S D D S D S D S D S D
+ S G D S D S D S D S S D S S D S S S B S S S S S S S S D D D D D S S D D D S D D
+ D D S D D D D D S S D S D S D sky130_fd_pr__pfet_01v8_lvt_328ZPL
.ends
