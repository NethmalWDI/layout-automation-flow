* NGSPICE file created from nfet_01v8_W24_L0p5_m1__nf8_gtop_sdfull_outD.ext - technology: sky130A

.subckt sky130_fd_pr__nfet_01v8_KUM4AP G B D6 D4 D2 D0 S7 S5 S3 a_603_n331# S1
X0 S3 G D2 B sky130_fd_pr__nfet_01v8 ad=0.435 pd=3.29 as=0.435 ps=3.29 w=3 l=0.5
X1 D6 G S5 B sky130_fd_pr__nfet_01v8 ad=0.435 pd=3.29 as=0.435 ps=3.29 w=3 l=0.5
X2 D2 G S1 B sky130_fd_pr__nfet_01v8 ad=0.435 pd=3.29 as=0.435 ps=3.29 w=3 l=0.5
X3 S5 G D4 B sky130_fd_pr__nfet_01v8 ad=0.435 pd=3.29 as=0.435 ps=3.29 w=3 l=0.5
X4 S7 G D6 B sky130_fd_pr__nfet_01v8 ad=0.435 pd=3.29 as=0.435 ps=3.29 w=3 l=0.5
X5 S1 G D0 B sky130_fd_pr__nfet_01v8 ad=0.435 pd=3.29 as=0.87 ps=6.58 w=3 l=0.5
X6 D4 G S3 B sky130_fd_pr__nfet_01v8 ad=0.435 pd=3.29 as=0.435 ps=3.29 w=3 l=0.5
X7 a_603_n331# G S7 B sky130_fd_pr__nfet_01v8 ad=0.87 pd=6.58 as=0.435 ps=3.29 w=3 l=0.5
.ends

.subckt nfet_01v8_W24_L0p5_m1__nf8_gtop_sdfull_outD S D G B
Xnfet_01v8_W24_L0p5_m1__nf8_gtop_sdfull_outD_pc G B D D D D S S S D S sky130_fd_pr__nfet_01v8_KUM4AP
.ends
