.subckt nfet_01v8_lvt_W5_L20_m2__nf1_gboth_sdhalf D G S B
Xnfet_01v8_lvt_W5_L20_m2__nf1_gboth_sdhalf D G S B sky130_fd_pr__nfet_01v8_lvt L=22 W=5 nf=1
.ends
