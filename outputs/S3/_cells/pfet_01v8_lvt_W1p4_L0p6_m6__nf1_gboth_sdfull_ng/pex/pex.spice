* NGSPICE file created from pfet_01v8_lvt_W1p4_L0p6_m6__nf1_gboth_sdfull_ng.ext - technology: sky130A

.subckt pfet_01v8_lvt_W1p4_L0p6_m6__nf1_gboth_sdfull_ng D S G B
X0 S G D B sky130_fd_pr__pfet_01v8_lvt ad=0.406 pd=3.38 as=0.406 ps=3.38 w=1.4 l=0.6
C0 S D 0.06099f
C1 B D 0.02505f
C2 G S 0.05758f
C3 B G 0.13758f
C4 B S 0.02505f
C5 G D 0.05758f
C6 S VSUBS 0.12656f
C7 D VSUBS 0.12656f
C8 G VSUBS 0.25958f
C9 B VSUBS 0.44352f
.ends
