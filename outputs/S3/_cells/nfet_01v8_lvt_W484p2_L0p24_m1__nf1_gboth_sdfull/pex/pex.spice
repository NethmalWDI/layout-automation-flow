* NGSPICE file created from nfet_01v8_lvt_W484p2_L0p24_m1__nf1_gboth_sdfull.ext - technology: sky130A

.subckt nfet_01v8_lvt_W484p2_L0p24_m1__nf1_gboth_sdfull D S G B
X0 S G D B sky130_fd_pr__nfet_01v8_lvt ad=140.418 pd=968.97998 as=140.418 ps=968.97998 w=484.20001 l=0.24
C0 S G 9.46369f
C1 D G 9.46369f
C2 S D 34.7351f
C3 G B 0.30668f
C4 S B 36.66436f
C5 D B 36.66436f
.ends
