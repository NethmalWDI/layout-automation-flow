* NGSPICE file created from nfet_01v8_lvt_W484p2_L0p24_m1__nf8_gboth_sdfull_outD_ng.ext - technology: sky130A

.subckt nfet_01v8_lvt_W484p2_L0p24_m1__nf8_gboth_sdfull_outD_ng S D G B
X0 D G S B sky130_fd_pr__nfet_01v8_lvt ad=8.77685 pd=60.82 as=8.77685 ps=60.82 w=60.53 l=0.24
X1 D G S B sky130_fd_pr__nfet_01v8_lvt ad=8.77685 pd=60.82 as=8.77685 ps=60.82 w=60.53 l=0.24
X2 S G D B sky130_fd_pr__nfet_01v8_lvt ad=8.77685 pd=60.82 as=8.77685 ps=60.82 w=60.53 l=0.24
X3 S G D B sky130_fd_pr__nfet_01v8_lvt ad=8.77685 pd=60.82 as=17.5537 ps=121.64 w=60.53 l=0.24
X4 S G D B sky130_fd_pr__nfet_01v8_lvt ad=8.77685 pd=60.82 as=8.77685 ps=60.82 w=60.53 l=0.24
X5 D G S B sky130_fd_pr__nfet_01v8_lvt ad=8.77685 pd=60.82 as=8.77685 ps=60.82 w=60.53 l=0.24
X6 S G D B sky130_fd_pr__nfet_01v8_lvt ad=8.77685 pd=60.82 as=8.77685 ps=60.82 w=60.53 l=0.24
X7 D G S B sky130_fd_pr__nfet_01v8_lvt ad=17.5537 pd=121.64 as=8.77685 ps=60.82 w=60.53 l=0.24
C0 G S 9.91801f
C1 S D 35.1293f
C2 G D 9.91163f
C3 S B 0.17206f
C4 D B 9.74312f
C5 G B 2.02707f
.ends
