* NGSPICE file created from pfet_01v8_lvt_W5_L1_m2__nf2_gtop_sdfull_outS_ng.ext - technology: sky130A

.subckt sky130_fd_pr__pfet_01v8_lvt_S8XDLV G w_n323_n348# D0 S1 a_229_n286#
X0 S1 G D0 w_n323_n348# sky130_fd_pr__pfet_01v8_lvt ad=0.3625 pd=2.79 as=0.725 ps=5.58 w=2.5 l=1
X1 a_229_n286# G S1 w_n323_n348# sky130_fd_pr__pfet_01v8_lvt ad=0.725 pd=5.58 as=0.3625 ps=2.79 w=2.5 l=1
.ends

.subckt pfet_01v8_lvt_W5_L1_m2__nf2_gtop_sdfull_outS_ng S D G B
Xpfet_01v8_lvt_W5_L1_m2__nf2_gtop_sdfull_outS_ng_pc G B S D S sky130_fd_pr__pfet_01v8_lvt_S8XDLV
.ends
