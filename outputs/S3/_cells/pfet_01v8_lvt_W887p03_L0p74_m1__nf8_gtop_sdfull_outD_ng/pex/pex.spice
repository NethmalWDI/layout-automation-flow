* NGSPICE file created from pfet_01v8_lvt_W887p03_L0p74_m1__nf8_gtop_sdfull_outD_ng.ext - technology: sky130A

.subckt pfet_01v8_lvt_W887p03_L0p74_m1__nf8_gtop_sdfull_outD_ng S D G B
X0 D G S B sky130_fd_pr__pfet_01v8_lvt ad=16.0776 pd=111.17 as=16.0776 ps=111.17 w=110.88 l=0.74
X1 D G S B sky130_fd_pr__pfet_01v8_lvt ad=16.0776 pd=111.17 as=16.0776 ps=111.17 w=110.88 l=0.74
X2 S G D B sky130_fd_pr__pfet_01v8_lvt ad=16.0776 pd=111.17 as=16.0776 ps=111.17 w=110.88 l=0.74
X3 D G S B sky130_fd_pr__pfet_01v8_lvt ad=32.1552 pd=222.34 as=16.0776 ps=111.17 w=110.88 l=0.74
X4 S G D B sky130_fd_pr__pfet_01v8_lvt ad=16.0776 pd=111.17 as=16.0776 ps=111.17 w=110.88 l=0.74
X5 D G S B sky130_fd_pr__pfet_01v8_lvt ad=16.0776 pd=111.17 as=16.0776 ps=111.17 w=110.88 l=0.74
X6 S G D B sky130_fd_pr__pfet_01v8_lvt ad=16.0776 pd=111.17 as=32.1552 ps=222.34 w=110.88 l=0.74
X7 S G D B sky130_fd_pr__pfet_01v8_lvt ad=16.0776 pd=111.17 as=16.0776 ps=111.17 w=110.88 l=0.74
C0 G B 0.8264f
C1 G S 41.36116f
C2 S B 9.61967f
C3 D G 41.14376f
C4 D B 11.10534f
C5 D S 33.5115f
C6 S VSUBS 0.32094f
C7 D VSUBS 15.93138f
C8 G VSUBS 1.344f
C9 B VSUBS 0.10339p
.ends
