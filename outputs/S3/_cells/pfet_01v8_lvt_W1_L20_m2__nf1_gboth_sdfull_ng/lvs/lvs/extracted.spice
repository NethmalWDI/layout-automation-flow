* NGSPICE file created from pfet_01v8_lvt_W1_L20_m2__nf1_gboth_sdfull_ng.ext - technology: sky130A

.subckt sky130_fd_pr__pfet_01v8_lvt_UEXLP8 G D w_n2094_n200# S
X0 S G D w_n2094_n200# sky130_fd_pr__pfet_01v8_lvt ad=0.29 pd=2.58 as=0.29 ps=2.58 w=1 l=20
.ends

.subckt pfet_01v8_lvt_W1_L20_m2__nf1_gboth_sdfull_ng D S G B
Xpfet_01v8_lvt_W1_L20_m2__nf1_gboth_sdfull_ng_pc G D B S sky130_fd_pr__pfet_01v8_lvt_UEXLP8
.ends
