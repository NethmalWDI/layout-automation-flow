* NGSPICE file created from pfet_01v8_lvt_W1_L20_m2__nf1_gboth_sdfull_ng.ext - technology: sky130A

.subckt pfet_01v8_lvt_W1_L20_m2__nf1_gboth_sdfull_ng D S G B
X0 S G D B sky130_fd_pr__pfet_01v8_lvt ad=0.29 pd=2.58 as=0.29 ps=2.58 w=1 l=20
C0 S G 0.08977f
C1 D B 0.04332f
C2 G B 2.84458f
C3 G D 0.08977f
C4 S B 0.04332f
C5 S VSUBS 0.11179f
C6 D VSUBS 0.11179f
C7 G VSUBS 5.2326f
C8 B VSUBS 5.0256f
.ends
