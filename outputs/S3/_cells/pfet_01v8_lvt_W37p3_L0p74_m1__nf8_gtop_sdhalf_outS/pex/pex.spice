* NGSPICE file created from pfet_01v8_lvt_W37p3_L0p74_m1__nf8_gtop_sdhalf_outS.ext - technology: sky130A

.subckt pfet_01v8_lvt_W37p3_L0p74_m1__nf8_gtop_sdhalf_outS S D G B
X0 D G S B sky130_fd_pr__pfet_01v8_lvt ad=0.6757 pd=4.95 as=0.6757 ps=4.95 w=4.66 l=0.74
X1 S G D B sky130_fd_pr__pfet_01v8_lvt ad=0.6757 pd=4.95 as=0.6757 ps=4.95 w=4.66 l=0.74
X2 S G D B sky130_fd_pr__pfet_01v8_lvt ad=0.6757 pd=4.95 as=0.6757 ps=4.95 w=4.66 l=0.74
X3 D G S B sky130_fd_pr__pfet_01v8_lvt ad=0.6757 pd=4.95 as=0.6757 ps=4.95 w=4.66 l=0.74
X4 S G D B sky130_fd_pr__pfet_01v8_lvt ad=0.6757 pd=4.95 as=0.6757 ps=4.95 w=4.66 l=0.74
X5 D G S B sky130_fd_pr__pfet_01v8_lvt ad=0.6757 pd=4.95 as=1.3514 ps=9.9 w=4.66 l=0.74
X6 D G S B sky130_fd_pr__pfet_01v8_lvt ad=0.6757 pd=4.95 as=0.6757 ps=4.95 w=4.66 l=0.74
X7 S G D B sky130_fd_pr__pfet_01v8_lvt ad=1.3514 pd=9.9 as=0.6757 ps=4.95 w=4.66 l=0.74
C0 B S 0.6341f
C1 G S 1.23742f
C2 B D 0.36954f
C3 G D 1.2054f
C4 S D 1.30609f
C5 G B 1.90307f
C6 D VSUBS 0.19438f
C7 S VSUBS 0.31484f
C8 G VSUBS 0.60275f
C9 B VSUBS 8.53341f
.ends
