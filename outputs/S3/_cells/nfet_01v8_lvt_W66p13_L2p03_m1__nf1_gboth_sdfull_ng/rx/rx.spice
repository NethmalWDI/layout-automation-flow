* NGSPICE file created from nfet_01v8_lvt_W66p13_L2p03_m1__nf1_gboth_sdfull_ng.ext - technology: sky130A

X0 S nfet_01v8_lvt_W66p13_L2p03_m1__nf1_gboth_sdfull_ng_pc/G.t0 D B sky130_fd_pr__nfet_01v8_lvt ad=19.1777 pd=132.84 as=19.1777 ps=132.84 w=66.13 l=2.03
C0 D G 4.70208f
C1 S D 1.06115f
C2 S G 4.70208f
R0 nfet_01v8_lvt_W66p13_L2p03_m1__nf1_gboth_sdfull_ng_pc/G.n4 nfet_01v8_lvt_W66p13_L2p03_m1__nf1_gboth_sdfull_ng_pc/G.t0 785.091
R1 nfet_01v8_lvt_W66p13_L2p03_m1__nf1_gboth_sdfull_ng_pc/G.n3 nfet_01v8_lvt_W66p13_L2p03_m1__nf1_gboth_sdfull_ng_pc/G.n0 152
R2 nfet_01v8_lvt_W66p13_L2p03_m1__nf1_gboth_sdfull_ng_pc/G.n3 nfet_01v8_lvt_W66p13_L2p03_m1__nf1_gboth_sdfull_ng_pc/G.n2 119.715
R3 nfet_01v8_lvt_W66p13_L2p03_m1__nf1_gboth_sdfull_ng_pc/G.n5 nfet_01v8_lvt_W66p13_L2p03_m1__nf1_gboth_sdfull_ng_pc/G.n4 89.5295
R4 nfet_01v8_lvt_W66p13_L2p03_m1__nf1_gboth_sdfull_ng_pc/G.n4 nfet_01v8_lvt_W66p13_L2p03_m1__nf1_gboth_sdfull_ng_pc/G.n3 18.6232
R5 nfet_01v8_lvt_W66p13_L2p03_m1__nf1_gboth_sdfull_ng_pc/G.n2 G 17.8797
R6 nfet_01v8_lvt_W66p13_L2p03_m1__nf1_gboth_sdfull_ng_pc/G.n2 nfet_01v8_lvt_W66p13_L2p03_m1__nf1_gboth_sdfull_ng_pc/G.n1 17.8466
R7 nfet_01v8_lvt_W66p13_L2p03_m1__nf1_gboth_sdfull_ng_pc/G.n1 nfet_01v8_lvt_W66p13_L2p03_m1__nf1_gboth_sdfull_ng_pc/G.n0 14.3064
R8 G nfet_01v8_lvt_W66p13_L2p03_m1__nf1_gboth_sdfull_ng_pc/G.n0 12.8005
R9 nfet_01v8_lvt_W66p13_L2p03_m1__nf1_gboth_sdfull_ng_pc/G.n1 G 9.3005
R10 G nfet_01v8_lvt_W66p13_L2p03_m1__nf1_gboth_sdfull_ng_pc/G.n5 4.7713
R11 nfet_01v8_lvt_W66p13_L2p03_m1__nf1_gboth_sdfull_ng_pc/G.n5 G 2.90603
C3 S B 6.35285f
C4 D B 6.35285f
C5 G B 1.11052f
C6 nfet_01v8_lvt_W66p13_L2p03_m1__nf1_gboth_sdfull_ng_pc/G.n0 B 0.00209f ; **FLOATING
C7 nfet_01v8_lvt_W66p13_L2p03_m1__nf1_gboth_sdfull_ng_pc/G.t0 B 6.99518f ; **FLOATING
C8 nfet_01v8_lvt_W66p13_L2p03_m1__nf1_gboth_sdfull_ng_pc/G.n1 B 0.00274f ; **FLOATING
C9 nfet_01v8_lvt_W66p13_L2p03_m1__nf1_gboth_sdfull_ng_pc/G.n2 B 0.01042f ; **FLOATING
C10 nfet_01v8_lvt_W66p13_L2p03_m1__nf1_gboth_sdfull_ng_pc/G.n3 B 0.02044f ; **FLOATING
C11 nfet_01v8_lvt_W66p13_L2p03_m1__nf1_gboth_sdfull_ng_pc/G.n4 B 2.31526f ; **FLOATING
C12 nfet_01v8_lvt_W66p13_L2p03_m1__nf1_gboth_sdfull_ng_pc/G.n5 B 0.01199f ; **FLOATING
