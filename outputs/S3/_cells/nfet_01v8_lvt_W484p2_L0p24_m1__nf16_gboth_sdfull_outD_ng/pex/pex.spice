* NGSPICE file created from nfet_01v8_lvt_W484p2_L0p24_m1__nf16_gboth_sdfull_outD_ng.ext - technology: sky130A

.subckt nfet_01v8_lvt_W484p2_L0p24_m1__nf16_gboth_sdfull_outD_ng S D G B
X0 S G D B sky130_fd_pr__nfet_01v8_lvt ad=4.3877 pd=30.55 as=8.7754 ps=61.1 w=30.26 l=0.24
X1 S G D B sky130_fd_pr__nfet_01v8_lvt ad=4.3877 pd=30.55 as=4.3877 ps=30.55 w=30.26 l=0.24
X2 D G S B sky130_fd_pr__nfet_01v8_lvt ad=4.3877 pd=30.55 as=4.3877 ps=30.55 w=30.26 l=0.24
X3 D G S B sky130_fd_pr__nfet_01v8_lvt ad=4.3877 pd=30.55 as=4.3877 ps=30.55 w=30.26 l=0.24
X4 D G S B sky130_fd_pr__nfet_01v8_lvt ad=4.3877 pd=30.55 as=4.3877 ps=30.55 w=30.26 l=0.24
X5 D G S B sky130_fd_pr__nfet_01v8_lvt ad=4.3877 pd=30.55 as=4.3877 ps=30.55 w=30.26 l=0.24
X6 S G D B sky130_fd_pr__nfet_01v8_lvt ad=4.3877 pd=30.55 as=4.3877 ps=30.55 w=30.26 l=0.24
X7 S G D B sky130_fd_pr__nfet_01v8_lvt ad=4.3877 pd=30.55 as=4.3877 ps=30.55 w=30.26 l=0.24
X8 S G D B sky130_fd_pr__nfet_01v8_lvt ad=4.3877 pd=30.55 as=4.3877 ps=30.55 w=30.26 l=0.24
X9 D G S B sky130_fd_pr__nfet_01v8_lvt ad=8.7754 pd=61.1 as=4.3877 ps=30.55 w=30.26 l=0.24
X10 D G S B sky130_fd_pr__nfet_01v8_lvt ad=4.3877 pd=30.55 as=4.3877 ps=30.55 w=30.26 l=0.24
X11 D G S B sky130_fd_pr__nfet_01v8_lvt ad=4.3877 pd=30.55 as=4.3877 ps=30.55 w=30.26 l=0.24
X12 S G D B sky130_fd_pr__nfet_01v8_lvt ad=4.3877 pd=30.55 as=4.3877 ps=30.55 w=30.26 l=0.24
X13 S G D B sky130_fd_pr__nfet_01v8_lvt ad=4.3877 pd=30.55 as=4.3877 ps=30.55 w=30.26 l=0.24
X14 D G S B sky130_fd_pr__nfet_01v8_lvt ad=4.3877 pd=30.55 as=4.3877 ps=30.55 w=30.26 l=0.24
X15 S G D B sky130_fd_pr__nfet_01v8_lvt ad=4.3877 pd=30.55 as=4.3877 ps=30.55 w=30.26 l=0.24
C0 S G 10.38106f
C1 S D 35.48647f
C2 G D 10.36833f
C3 S B 0.30773f
C4 D B 5.10599f
C5 G B 3.90059f
.ends
