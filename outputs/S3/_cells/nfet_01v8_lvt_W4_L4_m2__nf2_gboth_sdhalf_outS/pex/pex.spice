* NGSPICE file created from nfet_01v8_lvt_W4_L4_m2__nf2_gboth_sdhalf_outS.ext - technology: sky130A

.subckt nfet_01v8_lvt_W4_L4_m2__nf2_gboth_sdhalf_outS S D G B
X0 S G D B sky130_fd_pr__nfet_01v8_lvt ad=0.58 pd=4.58 as=0.29 ps=2.29 w=2 l=4
X1 D G S B sky130_fd_pr__nfet_01v8_lvt ad=0.29 pd=2.29 as=0.58 ps=4.58 w=2 l=4
C0 S G 0.50042f
C1 S D 0.5177f
C2 D G 0.49958f
C3 D B 0.29666f
C4 S B 0.50371f
C5 G B 3.3228f
.ends
