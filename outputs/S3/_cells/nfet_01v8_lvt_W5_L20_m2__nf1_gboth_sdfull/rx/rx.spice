* NGSPICE file created from nfet_01v8_lvt_W5_L20_m2__nf1_gboth_sdfull.ext - technology: sky130A

X0 nfet_01v8_lvt_W5_L20_m2__nf1_gboth_sdfull_pc/S.t0 G nfet_01v8_lvt_W5_L20_m2__nf1_gboth_sdfull_pc/D.t0 nfet_01v8_lvt_W5_L20_m2__nf1_gboth_sdfull_pc/B.t0 sky130_fd_pr__nfet_01v8_lvt ad=1.45 pd=10.58 as=1.45 ps=10.58 w=5 l=20
C0 S G 0.44075f
C1 G D 0.44075f
R0 nfet_01v8_lvt_W5_L20_m2__nf1_gboth_sdfull_pc/S.t0 nfet_01v8_lvt_W5_L20_m2__nf1_gboth_sdfull_pc/S.n0 174.857
R1 nfet_01v8_lvt_W5_L20_m2__nf1_gboth_sdfull_pc/S.n1 nfet_01v8_lvt_W5_L20_m2__nf1_gboth_sdfull_pc/S.t0 174.857
R2 S nfet_01v8_lvt_W5_L20_m2__nf1_gboth_sdfull_pc/S.n0 15.6333
R3 S nfet_01v8_lvt_W5_L20_m2__nf1_gboth_sdfull_pc/S.n1 15.6333
R4 nfet_01v8_lvt_W5_L20_m2__nf1_gboth_sdfull_pc/S.n1 S 5.29315
R5 S nfet_01v8_lvt_W5_L20_m2__nf1_gboth_sdfull_pc/S.n0 5.18989
R6 nfet_01v8_lvt_W5_L20_m2__nf1_gboth_sdfull_pc/D.t0 nfet_01v8_lvt_W5_L20_m2__nf1_gboth_sdfull_pc/D.n0 174.857
R7 nfet_01v8_lvt_W5_L20_m2__nf1_gboth_sdfull_pc/D.n1 nfet_01v8_lvt_W5_L20_m2__nf1_gboth_sdfull_pc/D.t0 174.857
R8 D nfet_01v8_lvt_W5_L20_m2__nf1_gboth_sdfull_pc/D.n0 15.6333
R9 D nfet_01v8_lvt_W5_L20_m2__nf1_gboth_sdfull_pc/D.n1 15.6333
R10 nfet_01v8_lvt_W5_L20_m2__nf1_gboth_sdfull_pc/D.n1 D 5.29315
R11 D nfet_01v8_lvt_W5_L20_m2__nf1_gboth_sdfull_pc/D.n0 5.18989
R12 nfet_01v8_lvt_W5_L20_m2__nf1_gboth_sdfull_pc/B.n297 nfet_01v8_lvt_W5_L20_m2__nf1_gboth_sdfull_pc/B.n296 1153.03
R13 nfet_01v8_lvt_W5_L20_m2__nf1_gboth_sdfull_pc/B.n108 nfet_01v8_lvt_W5_L20_m2__nf1_gboth_sdfull_pc/B.n66 1153.03
R14 nfet_01v8_lvt_W5_L20_m2__nf1_gboth_sdfull_pc/B.n326 nfet_01v8_lvt_W5_L20_m2__nf1_gboth_sdfull_pc/B.n249 1153.03
R15 nfet_01v8_lvt_W5_L20_m2__nf1_gboth_sdfull_pc/B.n105 nfet_01v8_lvt_W5_L20_m2__nf1_gboth_sdfull_pc/B.n64 1153.03
R16 nfet_01v8_lvt_W5_L20_m2__nf1_gboth_sdfull_pc/B.n249 nfet_01v8_lvt_W5_L20_m2__nf1_gboth_sdfull_pc/B.n248 585
R17 nfet_01v8_lvt_W5_L20_m2__nf1_gboth_sdfull_pc/B.n328 nfet_01v8_lvt_W5_L20_m2__nf1_gboth_sdfull_pc/B.n249 585
R18 nfet_01v8_lvt_W5_L20_m2__nf1_gboth_sdfull_pc/B.n331 nfet_01v8_lvt_W5_L20_m2__nf1_gboth_sdfull_pc/B.n330 585
R19 nfet_01v8_lvt_W5_L20_m2__nf1_gboth_sdfull_pc/B.n330 nfet_01v8_lvt_W5_L20_m2__nf1_gboth_sdfull_pc/B.n329 585
R20 nfet_01v8_lvt_W5_L20_m2__nf1_gboth_sdfull_pc/B.n332 nfet_01v8_lvt_W5_L20_m2__nf1_gboth_sdfull_pc/B.n244 585
R21 nfet_01v8_lvt_W5_L20_m2__nf1_gboth_sdfull_pc/B.n244 nfet_01v8_lvt_W5_L20_m2__nf1_gboth_sdfull_pc/B.n243 585
R22 nfet_01v8_lvt_W5_L20_m2__nf1_gboth_sdfull_pc/B.n334 nfet_01v8_lvt_W5_L20_m2__nf1_gboth_sdfull_pc/B.n333 585
R23 nfet_01v8_lvt_W5_L20_m2__nf1_gboth_sdfull_pc/B.n335 nfet_01v8_lvt_W5_L20_m2__nf1_gboth_sdfull_pc/B.n334 585
R24 nfet_01v8_lvt_W5_L20_m2__nf1_gboth_sdfull_pc/B.n242 nfet_01v8_lvt_W5_L20_m2__nf1_gboth_sdfull_pc/B.n241 585
R25 nfet_01v8_lvt_W5_L20_m2__nf1_gboth_sdfull_pc/B.n336 nfet_01v8_lvt_W5_L20_m2__nf1_gboth_sdfull_pc/B.n242 585
R26 nfet_01v8_lvt_W5_L20_m2__nf1_gboth_sdfull_pc/B.n339 nfet_01v8_lvt_W5_L20_m2__nf1_gboth_sdfull_pc/B.n338 585
R27 nfet_01v8_lvt_W5_L20_m2__nf1_gboth_sdfull_pc/B.n338 nfet_01v8_lvt_W5_L20_m2__nf1_gboth_sdfull_pc/B.n337 585
R28 nfet_01v8_lvt_W5_L20_m2__nf1_gboth_sdfull_pc/B.n340 nfet_01v8_lvt_W5_L20_m2__nf1_gboth_sdfull_pc/B.n237 585
R29 nfet_01v8_lvt_W5_L20_m2__nf1_gboth_sdfull_pc/B.n237 nfet_01v8_lvt_W5_L20_m2__nf1_gboth_sdfull_pc/B.n236 585
R30 nfet_01v8_lvt_W5_L20_m2__nf1_gboth_sdfull_pc/B.n342 nfet_01v8_lvt_W5_L20_m2__nf1_gboth_sdfull_pc/B.n341 585
R31 nfet_01v8_lvt_W5_L20_m2__nf1_gboth_sdfull_pc/B.n343 nfet_01v8_lvt_W5_L20_m2__nf1_gboth_sdfull_pc/B.n342 585
R32 nfet_01v8_lvt_W5_L20_m2__nf1_gboth_sdfull_pc/B.n235 nfet_01v8_lvt_W5_L20_m2__nf1_gboth_sdfull_pc/B.n234 585
R33 nfet_01v8_lvt_W5_L20_m2__nf1_gboth_sdfull_pc/B.n344 nfet_01v8_lvt_W5_L20_m2__nf1_gboth_sdfull_pc/B.n235 585
R34 nfet_01v8_lvt_W5_L20_m2__nf1_gboth_sdfull_pc/B.n347 nfet_01v8_lvt_W5_L20_m2__nf1_gboth_sdfull_pc/B.n346 585
R35 nfet_01v8_lvt_W5_L20_m2__nf1_gboth_sdfull_pc/B.n346 nfet_01v8_lvt_W5_L20_m2__nf1_gboth_sdfull_pc/B.n345 585
R36 nfet_01v8_lvt_W5_L20_m2__nf1_gboth_sdfull_pc/B.n348 nfet_01v8_lvt_W5_L20_m2__nf1_gboth_sdfull_pc/B.n230 585
R37 nfet_01v8_lvt_W5_L20_m2__nf1_gboth_sdfull_pc/B.n230 nfet_01v8_lvt_W5_L20_m2__nf1_gboth_sdfull_pc/B.n229 585
R38 nfet_01v8_lvt_W5_L20_m2__nf1_gboth_sdfull_pc/B.n350 nfet_01v8_lvt_W5_L20_m2__nf1_gboth_sdfull_pc/B.n349 585
R39 nfet_01v8_lvt_W5_L20_m2__nf1_gboth_sdfull_pc/B.n351 nfet_01v8_lvt_W5_L20_m2__nf1_gboth_sdfull_pc/B.n350 585
R40 nfet_01v8_lvt_W5_L20_m2__nf1_gboth_sdfull_pc/B.n228 nfet_01v8_lvt_W5_L20_m2__nf1_gboth_sdfull_pc/B.n227 585
R41 nfet_01v8_lvt_W5_L20_m2__nf1_gboth_sdfull_pc/B.n352 nfet_01v8_lvt_W5_L20_m2__nf1_gboth_sdfull_pc/B.n228 585
R42 nfet_01v8_lvt_W5_L20_m2__nf1_gboth_sdfull_pc/B.n355 nfet_01v8_lvt_W5_L20_m2__nf1_gboth_sdfull_pc/B.n354 585
R43 nfet_01v8_lvt_W5_L20_m2__nf1_gboth_sdfull_pc/B.n354 nfet_01v8_lvt_W5_L20_m2__nf1_gboth_sdfull_pc/B.n353 585
R44 nfet_01v8_lvt_W5_L20_m2__nf1_gboth_sdfull_pc/B.n356 nfet_01v8_lvt_W5_L20_m2__nf1_gboth_sdfull_pc/B.n223 585
R45 nfet_01v8_lvt_W5_L20_m2__nf1_gboth_sdfull_pc/B.n223 nfet_01v8_lvt_W5_L20_m2__nf1_gboth_sdfull_pc/B.n222 585
R46 nfet_01v8_lvt_W5_L20_m2__nf1_gboth_sdfull_pc/B.n358 nfet_01v8_lvt_W5_L20_m2__nf1_gboth_sdfull_pc/B.n357 585
R47 nfet_01v8_lvt_W5_L20_m2__nf1_gboth_sdfull_pc/B.n359 nfet_01v8_lvt_W5_L20_m2__nf1_gboth_sdfull_pc/B.n358 585
R48 nfet_01v8_lvt_W5_L20_m2__nf1_gboth_sdfull_pc/B.n221 nfet_01v8_lvt_W5_L20_m2__nf1_gboth_sdfull_pc/B.n220 585
R49 nfet_01v8_lvt_W5_L20_m2__nf1_gboth_sdfull_pc/B.n360 nfet_01v8_lvt_W5_L20_m2__nf1_gboth_sdfull_pc/B.n221 585
R50 nfet_01v8_lvt_W5_L20_m2__nf1_gboth_sdfull_pc/B.n363 nfet_01v8_lvt_W5_L20_m2__nf1_gboth_sdfull_pc/B.n362 585
R51 nfet_01v8_lvt_W5_L20_m2__nf1_gboth_sdfull_pc/B.n362 nfet_01v8_lvt_W5_L20_m2__nf1_gboth_sdfull_pc/B.n361 585
R52 nfet_01v8_lvt_W5_L20_m2__nf1_gboth_sdfull_pc/B.n364 nfet_01v8_lvt_W5_L20_m2__nf1_gboth_sdfull_pc/B.n216 585
R53 nfet_01v8_lvt_W5_L20_m2__nf1_gboth_sdfull_pc/B.n216 nfet_01v8_lvt_W5_L20_m2__nf1_gboth_sdfull_pc/B.n215 585
R54 nfet_01v8_lvt_W5_L20_m2__nf1_gboth_sdfull_pc/B.n366 nfet_01v8_lvt_W5_L20_m2__nf1_gboth_sdfull_pc/B.n365 585
R55 nfet_01v8_lvt_W5_L20_m2__nf1_gboth_sdfull_pc/B.n367 nfet_01v8_lvt_W5_L20_m2__nf1_gboth_sdfull_pc/B.n366 585
R56 nfet_01v8_lvt_W5_L20_m2__nf1_gboth_sdfull_pc/B.n214 nfet_01v8_lvt_W5_L20_m2__nf1_gboth_sdfull_pc/B.n213 585
R57 nfet_01v8_lvt_W5_L20_m2__nf1_gboth_sdfull_pc/B.n368 nfet_01v8_lvt_W5_L20_m2__nf1_gboth_sdfull_pc/B.n214 585
R58 nfet_01v8_lvt_W5_L20_m2__nf1_gboth_sdfull_pc/B.n371 nfet_01v8_lvt_W5_L20_m2__nf1_gboth_sdfull_pc/B.n370 585
R59 nfet_01v8_lvt_W5_L20_m2__nf1_gboth_sdfull_pc/B.n370 nfet_01v8_lvt_W5_L20_m2__nf1_gboth_sdfull_pc/B.n369 585
R60 nfet_01v8_lvt_W5_L20_m2__nf1_gboth_sdfull_pc/B.n372 nfet_01v8_lvt_W5_L20_m2__nf1_gboth_sdfull_pc/B.n209 585
R61 nfet_01v8_lvt_W5_L20_m2__nf1_gboth_sdfull_pc/B.n209 nfet_01v8_lvt_W5_L20_m2__nf1_gboth_sdfull_pc/B.n208 585
R62 nfet_01v8_lvt_W5_L20_m2__nf1_gboth_sdfull_pc/B.n374 nfet_01v8_lvt_W5_L20_m2__nf1_gboth_sdfull_pc/B.n373 585
R63 nfet_01v8_lvt_W5_L20_m2__nf1_gboth_sdfull_pc/B.n375 nfet_01v8_lvt_W5_L20_m2__nf1_gboth_sdfull_pc/B.n374 585
R64 nfet_01v8_lvt_W5_L20_m2__nf1_gboth_sdfull_pc/B.n207 nfet_01v8_lvt_W5_L20_m2__nf1_gboth_sdfull_pc/B.n206 585
R65 nfet_01v8_lvt_W5_L20_m2__nf1_gboth_sdfull_pc/B.n376 nfet_01v8_lvt_W5_L20_m2__nf1_gboth_sdfull_pc/B.n207 585
R66 nfet_01v8_lvt_W5_L20_m2__nf1_gboth_sdfull_pc/B.n379 nfet_01v8_lvt_W5_L20_m2__nf1_gboth_sdfull_pc/B.n378 585
R67 nfet_01v8_lvt_W5_L20_m2__nf1_gboth_sdfull_pc/B.n378 nfet_01v8_lvt_W5_L20_m2__nf1_gboth_sdfull_pc/B.n377 585
R68 nfet_01v8_lvt_W5_L20_m2__nf1_gboth_sdfull_pc/B.n380 nfet_01v8_lvt_W5_L20_m2__nf1_gboth_sdfull_pc/B.n202 585
R69 nfet_01v8_lvt_W5_L20_m2__nf1_gboth_sdfull_pc/B.n202 nfet_01v8_lvt_W5_L20_m2__nf1_gboth_sdfull_pc/B.n201 585
R70 nfet_01v8_lvt_W5_L20_m2__nf1_gboth_sdfull_pc/B.n382 nfet_01v8_lvt_W5_L20_m2__nf1_gboth_sdfull_pc/B.n381 585
R71 nfet_01v8_lvt_W5_L20_m2__nf1_gboth_sdfull_pc/B.n383 nfet_01v8_lvt_W5_L20_m2__nf1_gboth_sdfull_pc/B.n382 585
R72 nfet_01v8_lvt_W5_L20_m2__nf1_gboth_sdfull_pc/B.n6 nfet_01v8_lvt_W5_L20_m2__nf1_gboth_sdfull_pc/B.n4 585
R73 nfet_01v8_lvt_W5_L20_m2__nf1_gboth_sdfull_pc/B.n384 nfet_01v8_lvt_W5_L20_m2__nf1_gboth_sdfull_pc/B.n6 585
R74 nfet_01v8_lvt_W5_L20_m2__nf1_gboth_sdfull_pc/B.n387 nfet_01v8_lvt_W5_L20_m2__nf1_gboth_sdfull_pc/B.n386 585
R75 nfet_01v8_lvt_W5_L20_m2__nf1_gboth_sdfull_pc/B.n386 nfet_01v8_lvt_W5_L20_m2__nf1_gboth_sdfull_pc/B.n385 585
R76 nfet_01v8_lvt_W5_L20_m2__nf1_gboth_sdfull_pc/B.n5 nfet_01v8_lvt_W5_L20_m2__nf1_gboth_sdfull_pc/B.t0 585
R77 nfet_01v8_lvt_W5_L20_m2__nf1_gboth_sdfull_pc/B.n200 nfet_01v8_lvt_W5_L20_m2__nf1_gboth_sdfull_pc/B.n5 585
R78 nfet_01v8_lvt_W5_L20_m2__nf1_gboth_sdfull_pc/B.n198 nfet_01v8_lvt_W5_L20_m2__nf1_gboth_sdfull_pc/B.n197 585
R79 nfet_01v8_lvt_W5_L20_m2__nf1_gboth_sdfull_pc/B.n199 nfet_01v8_lvt_W5_L20_m2__nf1_gboth_sdfull_pc/B.n198 585
R80 nfet_01v8_lvt_W5_L20_m2__nf1_gboth_sdfull_pc/B.n9 nfet_01v8_lvt_W5_L20_m2__nf1_gboth_sdfull_pc/B.n8 585
R81 nfet_01v8_lvt_W5_L20_m2__nf1_gboth_sdfull_pc/B.n8 nfet_01v8_lvt_W5_L20_m2__nf1_gboth_sdfull_pc/B.n7 585
R82 nfet_01v8_lvt_W5_L20_m2__nf1_gboth_sdfull_pc/B.n191 nfet_01v8_lvt_W5_L20_m2__nf1_gboth_sdfull_pc/B.n190 585
R83 nfet_01v8_lvt_W5_L20_m2__nf1_gboth_sdfull_pc/B.n190 nfet_01v8_lvt_W5_L20_m2__nf1_gboth_sdfull_pc/B.n189 585
R84 nfet_01v8_lvt_W5_L20_m2__nf1_gboth_sdfull_pc/B.n14 nfet_01v8_lvt_W5_L20_m2__nf1_gboth_sdfull_pc/B.n13 585
R85 nfet_01v8_lvt_W5_L20_m2__nf1_gboth_sdfull_pc/B.n188 nfet_01v8_lvt_W5_L20_m2__nf1_gboth_sdfull_pc/B.n14 585
R86 nfet_01v8_lvt_W5_L20_m2__nf1_gboth_sdfull_pc/B.n186 nfet_01v8_lvt_W5_L20_m2__nf1_gboth_sdfull_pc/B.n185 585
R87 nfet_01v8_lvt_W5_L20_m2__nf1_gboth_sdfull_pc/B.n187 nfet_01v8_lvt_W5_L20_m2__nf1_gboth_sdfull_pc/B.n186 585
R88 nfet_01v8_lvt_W5_L20_m2__nf1_gboth_sdfull_pc/B.n17 nfet_01v8_lvt_W5_L20_m2__nf1_gboth_sdfull_pc/B.n16 585
R89 nfet_01v8_lvt_W5_L20_m2__nf1_gboth_sdfull_pc/B.n16 nfet_01v8_lvt_W5_L20_m2__nf1_gboth_sdfull_pc/B.n15 585
R90 nfet_01v8_lvt_W5_L20_m2__nf1_gboth_sdfull_pc/B.n179 nfet_01v8_lvt_W5_L20_m2__nf1_gboth_sdfull_pc/B.n178 585
R91 nfet_01v8_lvt_W5_L20_m2__nf1_gboth_sdfull_pc/B.n178 nfet_01v8_lvt_W5_L20_m2__nf1_gboth_sdfull_pc/B.n177 585
R92 nfet_01v8_lvt_W5_L20_m2__nf1_gboth_sdfull_pc/B.n22 nfet_01v8_lvt_W5_L20_m2__nf1_gboth_sdfull_pc/B.n21 585
R93 nfet_01v8_lvt_W5_L20_m2__nf1_gboth_sdfull_pc/B.n176 nfet_01v8_lvt_W5_L20_m2__nf1_gboth_sdfull_pc/B.n22 585
R94 nfet_01v8_lvt_W5_L20_m2__nf1_gboth_sdfull_pc/B.n174 nfet_01v8_lvt_W5_L20_m2__nf1_gboth_sdfull_pc/B.n173 585
R95 nfet_01v8_lvt_W5_L20_m2__nf1_gboth_sdfull_pc/B.n175 nfet_01v8_lvt_W5_L20_m2__nf1_gboth_sdfull_pc/B.n174 585
R96 nfet_01v8_lvt_W5_L20_m2__nf1_gboth_sdfull_pc/B.n25 nfet_01v8_lvt_W5_L20_m2__nf1_gboth_sdfull_pc/B.n24 585
R97 nfet_01v8_lvt_W5_L20_m2__nf1_gboth_sdfull_pc/B.n24 nfet_01v8_lvt_W5_L20_m2__nf1_gboth_sdfull_pc/B.n23 585
R98 nfet_01v8_lvt_W5_L20_m2__nf1_gboth_sdfull_pc/B.n167 nfet_01v8_lvt_W5_L20_m2__nf1_gboth_sdfull_pc/B.n166 585
R99 nfet_01v8_lvt_W5_L20_m2__nf1_gboth_sdfull_pc/B.n166 nfet_01v8_lvt_W5_L20_m2__nf1_gboth_sdfull_pc/B.n165 585
R100 nfet_01v8_lvt_W5_L20_m2__nf1_gboth_sdfull_pc/B.n30 nfet_01v8_lvt_W5_L20_m2__nf1_gboth_sdfull_pc/B.n29 585
R101 nfet_01v8_lvt_W5_L20_m2__nf1_gboth_sdfull_pc/B.n164 nfet_01v8_lvt_W5_L20_m2__nf1_gboth_sdfull_pc/B.n30 585
R102 nfet_01v8_lvt_W5_L20_m2__nf1_gboth_sdfull_pc/B.n162 nfet_01v8_lvt_W5_L20_m2__nf1_gboth_sdfull_pc/B.n161 585
R103 nfet_01v8_lvt_W5_L20_m2__nf1_gboth_sdfull_pc/B.n163 nfet_01v8_lvt_W5_L20_m2__nf1_gboth_sdfull_pc/B.n162 585
R104 nfet_01v8_lvt_W5_L20_m2__nf1_gboth_sdfull_pc/B.n33 nfet_01v8_lvt_W5_L20_m2__nf1_gboth_sdfull_pc/B.n32 585
R105 nfet_01v8_lvt_W5_L20_m2__nf1_gboth_sdfull_pc/B.n32 nfet_01v8_lvt_W5_L20_m2__nf1_gboth_sdfull_pc/B.n31 585
R106 nfet_01v8_lvt_W5_L20_m2__nf1_gboth_sdfull_pc/B.n155 nfet_01v8_lvt_W5_L20_m2__nf1_gboth_sdfull_pc/B.n154 585
R107 nfet_01v8_lvt_W5_L20_m2__nf1_gboth_sdfull_pc/B.n154 nfet_01v8_lvt_W5_L20_m2__nf1_gboth_sdfull_pc/B.n153 585
R108 nfet_01v8_lvt_W5_L20_m2__nf1_gboth_sdfull_pc/B.n38 nfet_01v8_lvt_W5_L20_m2__nf1_gboth_sdfull_pc/B.n37 585
R109 nfet_01v8_lvt_W5_L20_m2__nf1_gboth_sdfull_pc/B.n152 nfet_01v8_lvt_W5_L20_m2__nf1_gboth_sdfull_pc/B.n38 585
R110 nfet_01v8_lvt_W5_L20_m2__nf1_gboth_sdfull_pc/B.n150 nfet_01v8_lvt_W5_L20_m2__nf1_gboth_sdfull_pc/B.n149 585
R111 nfet_01v8_lvt_W5_L20_m2__nf1_gboth_sdfull_pc/B.n151 nfet_01v8_lvt_W5_L20_m2__nf1_gboth_sdfull_pc/B.n150 585
R112 nfet_01v8_lvt_W5_L20_m2__nf1_gboth_sdfull_pc/B.n41 nfet_01v8_lvt_W5_L20_m2__nf1_gboth_sdfull_pc/B.n40 585
R113 nfet_01v8_lvt_W5_L20_m2__nf1_gboth_sdfull_pc/B.n40 nfet_01v8_lvt_W5_L20_m2__nf1_gboth_sdfull_pc/B.n39 585
R114 nfet_01v8_lvt_W5_L20_m2__nf1_gboth_sdfull_pc/B.n143 nfet_01v8_lvt_W5_L20_m2__nf1_gboth_sdfull_pc/B.n142 585
R115 nfet_01v8_lvt_W5_L20_m2__nf1_gboth_sdfull_pc/B.n142 nfet_01v8_lvt_W5_L20_m2__nf1_gboth_sdfull_pc/B.n141 585
R116 nfet_01v8_lvt_W5_L20_m2__nf1_gboth_sdfull_pc/B.n46 nfet_01v8_lvt_W5_L20_m2__nf1_gboth_sdfull_pc/B.n45 585
R117 nfet_01v8_lvt_W5_L20_m2__nf1_gboth_sdfull_pc/B.n140 nfet_01v8_lvt_W5_L20_m2__nf1_gboth_sdfull_pc/B.n46 585
R118 nfet_01v8_lvt_W5_L20_m2__nf1_gboth_sdfull_pc/B.n138 nfet_01v8_lvt_W5_L20_m2__nf1_gboth_sdfull_pc/B.n137 585
R119 nfet_01v8_lvt_W5_L20_m2__nf1_gboth_sdfull_pc/B.n139 nfet_01v8_lvt_W5_L20_m2__nf1_gboth_sdfull_pc/B.n138 585
R120 nfet_01v8_lvt_W5_L20_m2__nf1_gboth_sdfull_pc/B.n49 nfet_01v8_lvt_W5_L20_m2__nf1_gboth_sdfull_pc/B.n48 585
R121 nfet_01v8_lvt_W5_L20_m2__nf1_gboth_sdfull_pc/B.n48 nfet_01v8_lvt_W5_L20_m2__nf1_gboth_sdfull_pc/B.n47 585
R122 nfet_01v8_lvt_W5_L20_m2__nf1_gboth_sdfull_pc/B.n131 nfet_01v8_lvt_W5_L20_m2__nf1_gboth_sdfull_pc/B.n130 585
R123 nfet_01v8_lvt_W5_L20_m2__nf1_gboth_sdfull_pc/B.n130 nfet_01v8_lvt_W5_L20_m2__nf1_gboth_sdfull_pc/B.n129 585
R124 nfet_01v8_lvt_W5_L20_m2__nf1_gboth_sdfull_pc/B.n54 nfet_01v8_lvt_W5_L20_m2__nf1_gboth_sdfull_pc/B.n53 585
R125 nfet_01v8_lvt_W5_L20_m2__nf1_gboth_sdfull_pc/B.n128 nfet_01v8_lvt_W5_L20_m2__nf1_gboth_sdfull_pc/B.n54 585
R126 nfet_01v8_lvt_W5_L20_m2__nf1_gboth_sdfull_pc/B.n126 nfet_01v8_lvt_W5_L20_m2__nf1_gboth_sdfull_pc/B.n125 585
R127 nfet_01v8_lvt_W5_L20_m2__nf1_gboth_sdfull_pc/B.n127 nfet_01v8_lvt_W5_L20_m2__nf1_gboth_sdfull_pc/B.n126 585
R128 nfet_01v8_lvt_W5_L20_m2__nf1_gboth_sdfull_pc/B.n57 nfet_01v8_lvt_W5_L20_m2__nf1_gboth_sdfull_pc/B.n56 585
R129 nfet_01v8_lvt_W5_L20_m2__nf1_gboth_sdfull_pc/B.n56 nfet_01v8_lvt_W5_L20_m2__nf1_gboth_sdfull_pc/B.n55 585
R130 nfet_01v8_lvt_W5_L20_m2__nf1_gboth_sdfull_pc/B.n119 nfet_01v8_lvt_W5_L20_m2__nf1_gboth_sdfull_pc/B.n118 585
R131 nfet_01v8_lvt_W5_L20_m2__nf1_gboth_sdfull_pc/B.n118 nfet_01v8_lvt_W5_L20_m2__nf1_gboth_sdfull_pc/B.n117 585
R132 nfet_01v8_lvt_W5_L20_m2__nf1_gboth_sdfull_pc/B.n62 nfet_01v8_lvt_W5_L20_m2__nf1_gboth_sdfull_pc/B.n61 585
R133 nfet_01v8_lvt_W5_L20_m2__nf1_gboth_sdfull_pc/B.n116 nfet_01v8_lvt_W5_L20_m2__nf1_gboth_sdfull_pc/B.n62 585
R134 nfet_01v8_lvt_W5_L20_m2__nf1_gboth_sdfull_pc/B.n114 nfet_01v8_lvt_W5_L20_m2__nf1_gboth_sdfull_pc/B.n113 585
R135 nfet_01v8_lvt_W5_L20_m2__nf1_gboth_sdfull_pc/B.n115 nfet_01v8_lvt_W5_L20_m2__nf1_gboth_sdfull_pc/B.n114 585
R136 nfet_01v8_lvt_W5_L20_m2__nf1_gboth_sdfull_pc/B.n65 nfet_01v8_lvt_W5_L20_m2__nf1_gboth_sdfull_pc/B.n64 585
R137 nfet_01v8_lvt_W5_L20_m2__nf1_gboth_sdfull_pc/B.n64 nfet_01v8_lvt_W5_L20_m2__nf1_gboth_sdfull_pc/B.n63 585
R138 nfet_01v8_lvt_W5_L20_m2__nf1_gboth_sdfull_pc/B.n106 nfet_01v8_lvt_W5_L20_m2__nf1_gboth_sdfull_pc/B.n105 585
R139 nfet_01v8_lvt_W5_L20_m2__nf1_gboth_sdfull_pc/B.n105 nfet_01v8_lvt_W5_L20_m2__nf1_gboth_sdfull_pc/B.n104 585
R140 nfet_01v8_lvt_W5_L20_m2__nf1_gboth_sdfull_pc/B.n103 nfet_01v8_lvt_W5_L20_m2__nf1_gboth_sdfull_pc/B.n76 585
R141 nfet_01v8_lvt_W5_L20_m2__nf1_gboth_sdfull_pc/B.n102 nfet_01v8_lvt_W5_L20_m2__nf1_gboth_sdfull_pc/B.n101 585
R142 nfet_01v8_lvt_W5_L20_m2__nf1_gboth_sdfull_pc/B.n100 nfet_01v8_lvt_W5_L20_m2__nf1_gboth_sdfull_pc/B.n99 585
R143 nfet_01v8_lvt_W5_L20_m2__nf1_gboth_sdfull_pc/B.n98 nfet_01v8_lvt_W5_L20_m2__nf1_gboth_sdfull_pc/B.n97 585
R144 nfet_01v8_lvt_W5_L20_m2__nf1_gboth_sdfull_pc/B.n96 nfet_01v8_lvt_W5_L20_m2__nf1_gboth_sdfull_pc/B.n95 585
R145 nfet_01v8_lvt_W5_L20_m2__nf1_gboth_sdfull_pc/B.n94 nfet_01v8_lvt_W5_L20_m2__nf1_gboth_sdfull_pc/B.n93 585
R146 nfet_01v8_lvt_W5_L20_m2__nf1_gboth_sdfull_pc/B.n92 nfet_01v8_lvt_W5_L20_m2__nf1_gboth_sdfull_pc/B.n91 585
R147 nfet_01v8_lvt_W5_L20_m2__nf1_gboth_sdfull_pc/B.n90 nfet_01v8_lvt_W5_L20_m2__nf1_gboth_sdfull_pc/B.n89 585
R148 nfet_01v8_lvt_W5_L20_m2__nf1_gboth_sdfull_pc/B.n88 nfet_01v8_lvt_W5_L20_m2__nf1_gboth_sdfull_pc/B.n87 585
R149 nfet_01v8_lvt_W5_L20_m2__nf1_gboth_sdfull_pc/B.n86 nfet_01v8_lvt_W5_L20_m2__nf1_gboth_sdfull_pc/B.n85 585
R150 nfet_01v8_lvt_W5_L20_m2__nf1_gboth_sdfull_pc/B.n84 nfet_01v8_lvt_W5_L20_m2__nf1_gboth_sdfull_pc/B.n83 585
R151 nfet_01v8_lvt_W5_L20_m2__nf1_gboth_sdfull_pc/B.n82 nfet_01v8_lvt_W5_L20_m2__nf1_gboth_sdfull_pc/B.n81 585
R152 nfet_01v8_lvt_W5_L20_m2__nf1_gboth_sdfull_pc/B.n80 nfet_01v8_lvt_W5_L20_m2__nf1_gboth_sdfull_pc/B.n79 585
R153 nfet_01v8_lvt_W5_L20_m2__nf1_gboth_sdfull_pc/B.n78 nfet_01v8_lvt_W5_L20_m2__nf1_gboth_sdfull_pc/B.n77 585
R154 nfet_01v8_lvt_W5_L20_m2__nf1_gboth_sdfull_pc/B.n68 nfet_01v8_lvt_W5_L20_m2__nf1_gboth_sdfull_pc/B.n67 585
R155 nfet_01v8_lvt_W5_L20_m2__nf1_gboth_sdfull_pc/B.n109 nfet_01v8_lvt_W5_L20_m2__nf1_gboth_sdfull_pc/B.n108 585
R156 nfet_01v8_lvt_W5_L20_m2__nf1_gboth_sdfull_pc/B.n66 nfet_01v8_lvt_W5_L20_m2__nf1_gboth_sdfull_pc/B.n65 585
R157 nfet_01v8_lvt_W5_L20_m2__nf1_gboth_sdfull_pc/B.n110 nfet_01v8_lvt_W5_L20_m2__nf1_gboth_sdfull_pc/B.n66 585
R158 nfet_01v8_lvt_W5_L20_m2__nf1_gboth_sdfull_pc/B.n113 nfet_01v8_lvt_W5_L20_m2__nf1_gboth_sdfull_pc/B.n112 585
R159 nfet_01v8_lvt_W5_L20_m2__nf1_gboth_sdfull_pc/B.n112 nfet_01v8_lvt_W5_L20_m2__nf1_gboth_sdfull_pc/B.n111 585
R160 nfet_01v8_lvt_W5_L20_m2__nf1_gboth_sdfull_pc/B.n61 nfet_01v8_lvt_W5_L20_m2__nf1_gboth_sdfull_pc/B.n60 585
R161 nfet_01v8_lvt_W5_L20_m2__nf1_gboth_sdfull_pc/B.n60 nfet_01v8_lvt_W5_L20_m2__nf1_gboth_sdfull_pc/B.n59 585
R162 nfet_01v8_lvt_W5_L20_m2__nf1_gboth_sdfull_pc/B.n120 nfet_01v8_lvt_W5_L20_m2__nf1_gboth_sdfull_pc/B.n119 585
R163 nfet_01v8_lvt_W5_L20_m2__nf1_gboth_sdfull_pc/B.n121 nfet_01v8_lvt_W5_L20_m2__nf1_gboth_sdfull_pc/B.n120 585
R164 nfet_01v8_lvt_W5_L20_m2__nf1_gboth_sdfull_pc/B.n58 nfet_01v8_lvt_W5_L20_m2__nf1_gboth_sdfull_pc/B.n57 585
R165 nfet_01v8_lvt_W5_L20_m2__nf1_gboth_sdfull_pc/B.n122 nfet_01v8_lvt_W5_L20_m2__nf1_gboth_sdfull_pc/B.n58 585
R166 nfet_01v8_lvt_W5_L20_m2__nf1_gboth_sdfull_pc/B.n125 nfet_01v8_lvt_W5_L20_m2__nf1_gboth_sdfull_pc/B.n124 585
R167 nfet_01v8_lvt_W5_L20_m2__nf1_gboth_sdfull_pc/B.n124 nfet_01v8_lvt_W5_L20_m2__nf1_gboth_sdfull_pc/B.n123 585
R168 nfet_01v8_lvt_W5_L20_m2__nf1_gboth_sdfull_pc/B.n53 nfet_01v8_lvt_W5_L20_m2__nf1_gboth_sdfull_pc/B.n52 585
R169 nfet_01v8_lvt_W5_L20_m2__nf1_gboth_sdfull_pc/B.n52 nfet_01v8_lvt_W5_L20_m2__nf1_gboth_sdfull_pc/B.n51 585
R170 nfet_01v8_lvt_W5_L20_m2__nf1_gboth_sdfull_pc/B.n132 nfet_01v8_lvt_W5_L20_m2__nf1_gboth_sdfull_pc/B.n131 585
R171 nfet_01v8_lvt_W5_L20_m2__nf1_gboth_sdfull_pc/B.n133 nfet_01v8_lvt_W5_L20_m2__nf1_gboth_sdfull_pc/B.n132 585
R172 nfet_01v8_lvt_W5_L20_m2__nf1_gboth_sdfull_pc/B.n50 nfet_01v8_lvt_W5_L20_m2__nf1_gboth_sdfull_pc/B.n49 585
R173 nfet_01v8_lvt_W5_L20_m2__nf1_gboth_sdfull_pc/B.n134 nfet_01v8_lvt_W5_L20_m2__nf1_gboth_sdfull_pc/B.n50 585
R174 nfet_01v8_lvt_W5_L20_m2__nf1_gboth_sdfull_pc/B.n137 nfet_01v8_lvt_W5_L20_m2__nf1_gboth_sdfull_pc/B.n136 585
R175 nfet_01v8_lvt_W5_L20_m2__nf1_gboth_sdfull_pc/B.n136 nfet_01v8_lvt_W5_L20_m2__nf1_gboth_sdfull_pc/B.n135 585
R176 nfet_01v8_lvt_W5_L20_m2__nf1_gboth_sdfull_pc/B.n45 nfet_01v8_lvt_W5_L20_m2__nf1_gboth_sdfull_pc/B.n44 585
R177 nfet_01v8_lvt_W5_L20_m2__nf1_gboth_sdfull_pc/B.n44 nfet_01v8_lvt_W5_L20_m2__nf1_gboth_sdfull_pc/B.n43 585
R178 nfet_01v8_lvt_W5_L20_m2__nf1_gboth_sdfull_pc/B.n144 nfet_01v8_lvt_W5_L20_m2__nf1_gboth_sdfull_pc/B.n143 585
R179 nfet_01v8_lvt_W5_L20_m2__nf1_gboth_sdfull_pc/B.n145 nfet_01v8_lvt_W5_L20_m2__nf1_gboth_sdfull_pc/B.n144 585
R180 nfet_01v8_lvt_W5_L20_m2__nf1_gboth_sdfull_pc/B.n42 nfet_01v8_lvt_W5_L20_m2__nf1_gboth_sdfull_pc/B.n41 585
R181 nfet_01v8_lvt_W5_L20_m2__nf1_gboth_sdfull_pc/B.n146 nfet_01v8_lvt_W5_L20_m2__nf1_gboth_sdfull_pc/B.n42 585
R182 nfet_01v8_lvt_W5_L20_m2__nf1_gboth_sdfull_pc/B.n149 nfet_01v8_lvt_W5_L20_m2__nf1_gboth_sdfull_pc/B.n148 585
R183 nfet_01v8_lvt_W5_L20_m2__nf1_gboth_sdfull_pc/B.n148 nfet_01v8_lvt_W5_L20_m2__nf1_gboth_sdfull_pc/B.n147 585
R184 nfet_01v8_lvt_W5_L20_m2__nf1_gboth_sdfull_pc/B.n37 nfet_01v8_lvt_W5_L20_m2__nf1_gboth_sdfull_pc/B.n36 585
R185 nfet_01v8_lvt_W5_L20_m2__nf1_gboth_sdfull_pc/B.n36 nfet_01v8_lvt_W5_L20_m2__nf1_gboth_sdfull_pc/B.n35 585
R186 nfet_01v8_lvt_W5_L20_m2__nf1_gboth_sdfull_pc/B.n156 nfet_01v8_lvt_W5_L20_m2__nf1_gboth_sdfull_pc/B.n155 585
R187 nfet_01v8_lvt_W5_L20_m2__nf1_gboth_sdfull_pc/B.n157 nfet_01v8_lvt_W5_L20_m2__nf1_gboth_sdfull_pc/B.n156 585
R188 nfet_01v8_lvt_W5_L20_m2__nf1_gboth_sdfull_pc/B.n34 nfet_01v8_lvt_W5_L20_m2__nf1_gboth_sdfull_pc/B.n33 585
R189 nfet_01v8_lvt_W5_L20_m2__nf1_gboth_sdfull_pc/B.n158 nfet_01v8_lvt_W5_L20_m2__nf1_gboth_sdfull_pc/B.n34 585
R190 nfet_01v8_lvt_W5_L20_m2__nf1_gboth_sdfull_pc/B.n161 nfet_01v8_lvt_W5_L20_m2__nf1_gboth_sdfull_pc/B.n160 585
R191 nfet_01v8_lvt_W5_L20_m2__nf1_gboth_sdfull_pc/B.n160 nfet_01v8_lvt_W5_L20_m2__nf1_gboth_sdfull_pc/B.n159 585
R192 nfet_01v8_lvt_W5_L20_m2__nf1_gboth_sdfull_pc/B.n29 nfet_01v8_lvt_W5_L20_m2__nf1_gboth_sdfull_pc/B.n28 585
R193 nfet_01v8_lvt_W5_L20_m2__nf1_gboth_sdfull_pc/B.n28 nfet_01v8_lvt_W5_L20_m2__nf1_gboth_sdfull_pc/B.n27 585
R194 nfet_01v8_lvt_W5_L20_m2__nf1_gboth_sdfull_pc/B.n168 nfet_01v8_lvt_W5_L20_m2__nf1_gboth_sdfull_pc/B.n167 585
R195 nfet_01v8_lvt_W5_L20_m2__nf1_gboth_sdfull_pc/B.n169 nfet_01v8_lvt_W5_L20_m2__nf1_gboth_sdfull_pc/B.n168 585
R196 nfet_01v8_lvt_W5_L20_m2__nf1_gboth_sdfull_pc/B.n26 nfet_01v8_lvt_W5_L20_m2__nf1_gboth_sdfull_pc/B.n25 585
R197 nfet_01v8_lvt_W5_L20_m2__nf1_gboth_sdfull_pc/B.n170 nfet_01v8_lvt_W5_L20_m2__nf1_gboth_sdfull_pc/B.n26 585
R198 nfet_01v8_lvt_W5_L20_m2__nf1_gboth_sdfull_pc/B.n173 nfet_01v8_lvt_W5_L20_m2__nf1_gboth_sdfull_pc/B.n172 585
R199 nfet_01v8_lvt_W5_L20_m2__nf1_gboth_sdfull_pc/B.n172 nfet_01v8_lvt_W5_L20_m2__nf1_gboth_sdfull_pc/B.n171 585
R200 nfet_01v8_lvt_W5_L20_m2__nf1_gboth_sdfull_pc/B.n21 nfet_01v8_lvt_W5_L20_m2__nf1_gboth_sdfull_pc/B.n20 585
R201 nfet_01v8_lvt_W5_L20_m2__nf1_gboth_sdfull_pc/B.n20 nfet_01v8_lvt_W5_L20_m2__nf1_gboth_sdfull_pc/B.n19 585
R202 nfet_01v8_lvt_W5_L20_m2__nf1_gboth_sdfull_pc/B.n180 nfet_01v8_lvt_W5_L20_m2__nf1_gboth_sdfull_pc/B.n179 585
R203 nfet_01v8_lvt_W5_L20_m2__nf1_gboth_sdfull_pc/B.n181 nfet_01v8_lvt_W5_L20_m2__nf1_gboth_sdfull_pc/B.n180 585
R204 nfet_01v8_lvt_W5_L20_m2__nf1_gboth_sdfull_pc/B.n18 nfet_01v8_lvt_W5_L20_m2__nf1_gboth_sdfull_pc/B.n17 585
R205 nfet_01v8_lvt_W5_L20_m2__nf1_gboth_sdfull_pc/B.n182 nfet_01v8_lvt_W5_L20_m2__nf1_gboth_sdfull_pc/B.n18 585
R206 nfet_01v8_lvt_W5_L20_m2__nf1_gboth_sdfull_pc/B.n185 nfet_01v8_lvt_W5_L20_m2__nf1_gboth_sdfull_pc/B.n184 585
R207 nfet_01v8_lvt_W5_L20_m2__nf1_gboth_sdfull_pc/B.n184 nfet_01v8_lvt_W5_L20_m2__nf1_gboth_sdfull_pc/B.n183 585
R208 nfet_01v8_lvt_W5_L20_m2__nf1_gboth_sdfull_pc/B.n13 nfet_01v8_lvt_W5_L20_m2__nf1_gboth_sdfull_pc/B.n12 585
R209 nfet_01v8_lvt_W5_L20_m2__nf1_gboth_sdfull_pc/B.n12 nfet_01v8_lvt_W5_L20_m2__nf1_gboth_sdfull_pc/B.n11 585
R210 nfet_01v8_lvt_W5_L20_m2__nf1_gboth_sdfull_pc/B.n192 nfet_01v8_lvt_W5_L20_m2__nf1_gboth_sdfull_pc/B.n191 585
R211 nfet_01v8_lvt_W5_L20_m2__nf1_gboth_sdfull_pc/B.n193 nfet_01v8_lvt_W5_L20_m2__nf1_gboth_sdfull_pc/B.n192 585
R212 nfet_01v8_lvt_W5_L20_m2__nf1_gboth_sdfull_pc/B.n10 nfet_01v8_lvt_W5_L20_m2__nf1_gboth_sdfull_pc/B.n9 585
R213 nfet_01v8_lvt_W5_L20_m2__nf1_gboth_sdfull_pc/B.n194 nfet_01v8_lvt_W5_L20_m2__nf1_gboth_sdfull_pc/B.n10 585
R214 nfet_01v8_lvt_W5_L20_m2__nf1_gboth_sdfull_pc/B.n197 nfet_01v8_lvt_W5_L20_m2__nf1_gboth_sdfull_pc/B.n196 585
R215 nfet_01v8_lvt_W5_L20_m2__nf1_gboth_sdfull_pc/B.n196 nfet_01v8_lvt_W5_L20_m2__nf1_gboth_sdfull_pc/B.n195 585
R216 nfet_01v8_lvt_W5_L20_m2__nf1_gboth_sdfull_pc/B.t0 nfet_01v8_lvt_W5_L20_m2__nf1_gboth_sdfull_pc/B.n2 585
R217 nfet_01v8_lvt_W5_L20_m2__nf1_gboth_sdfull_pc/B.n2 nfet_01v8_lvt_W5_L20_m2__nf1_gboth_sdfull_pc/B.n0 585
R218 nfet_01v8_lvt_W5_L20_m2__nf1_gboth_sdfull_pc/B.n388 nfet_01v8_lvt_W5_L20_m2__nf1_gboth_sdfull_pc/B.n387 585
R219 nfet_01v8_lvt_W5_L20_m2__nf1_gboth_sdfull_pc/B.n389 nfet_01v8_lvt_W5_L20_m2__nf1_gboth_sdfull_pc/B.n388 585
R220 nfet_01v8_lvt_W5_L20_m2__nf1_gboth_sdfull_pc/B.n4 nfet_01v8_lvt_W5_L20_m2__nf1_gboth_sdfull_pc/B.n3 585
R221 nfet_01v8_lvt_W5_L20_m2__nf1_gboth_sdfull_pc/B.n3 nfet_01v8_lvt_W5_L20_m2__nf1_gboth_sdfull_pc/B.n1 585
R222 nfet_01v8_lvt_W5_L20_m2__nf1_gboth_sdfull_pc/B.n381 nfet_01v8_lvt_W5_L20_m2__nf1_gboth_sdfull_pc/B.n203 585
R223 nfet_01v8_lvt_W5_L20_m2__nf1_gboth_sdfull_pc/B.n262 nfet_01v8_lvt_W5_L20_m2__nf1_gboth_sdfull_pc/B.n203 585
R224 nfet_01v8_lvt_W5_L20_m2__nf1_gboth_sdfull_pc/B.n380 nfet_01v8_lvt_W5_L20_m2__nf1_gboth_sdfull_pc/B.n204 585
R225 nfet_01v8_lvt_W5_L20_m2__nf1_gboth_sdfull_pc/B.n263 nfet_01v8_lvt_W5_L20_m2__nf1_gboth_sdfull_pc/B.n204 585
R226 nfet_01v8_lvt_W5_L20_m2__nf1_gboth_sdfull_pc/B.n379 nfet_01v8_lvt_W5_L20_m2__nf1_gboth_sdfull_pc/B.n205 585
R227 nfet_01v8_lvt_W5_L20_m2__nf1_gboth_sdfull_pc/B.n264 nfet_01v8_lvt_W5_L20_m2__nf1_gboth_sdfull_pc/B.n205 585
R228 nfet_01v8_lvt_W5_L20_m2__nf1_gboth_sdfull_pc/B.n265 nfet_01v8_lvt_W5_L20_m2__nf1_gboth_sdfull_pc/B.n206 585
R229 nfet_01v8_lvt_W5_L20_m2__nf1_gboth_sdfull_pc/B.n266 nfet_01v8_lvt_W5_L20_m2__nf1_gboth_sdfull_pc/B.n265 585
R230 nfet_01v8_lvt_W5_L20_m2__nf1_gboth_sdfull_pc/B.n373 nfet_01v8_lvt_W5_L20_m2__nf1_gboth_sdfull_pc/B.n210 585
R231 nfet_01v8_lvt_W5_L20_m2__nf1_gboth_sdfull_pc/B.n267 nfet_01v8_lvt_W5_L20_m2__nf1_gboth_sdfull_pc/B.n210 585
R232 nfet_01v8_lvt_W5_L20_m2__nf1_gboth_sdfull_pc/B.n372 nfet_01v8_lvt_W5_L20_m2__nf1_gboth_sdfull_pc/B.n211 585
R233 nfet_01v8_lvt_W5_L20_m2__nf1_gboth_sdfull_pc/B.n268 nfet_01v8_lvt_W5_L20_m2__nf1_gboth_sdfull_pc/B.n211 585
R234 nfet_01v8_lvt_W5_L20_m2__nf1_gboth_sdfull_pc/B.n371 nfet_01v8_lvt_W5_L20_m2__nf1_gboth_sdfull_pc/B.n212 585
R235 nfet_01v8_lvt_W5_L20_m2__nf1_gboth_sdfull_pc/B.n269 nfet_01v8_lvt_W5_L20_m2__nf1_gboth_sdfull_pc/B.n212 585
R236 nfet_01v8_lvt_W5_L20_m2__nf1_gboth_sdfull_pc/B.n270 nfet_01v8_lvt_W5_L20_m2__nf1_gboth_sdfull_pc/B.n213 585
R237 nfet_01v8_lvt_W5_L20_m2__nf1_gboth_sdfull_pc/B.n271 nfet_01v8_lvt_W5_L20_m2__nf1_gboth_sdfull_pc/B.n270 585
R238 nfet_01v8_lvt_W5_L20_m2__nf1_gboth_sdfull_pc/B.n365 nfet_01v8_lvt_W5_L20_m2__nf1_gboth_sdfull_pc/B.n217 585
R239 nfet_01v8_lvt_W5_L20_m2__nf1_gboth_sdfull_pc/B.n272 nfet_01v8_lvt_W5_L20_m2__nf1_gboth_sdfull_pc/B.n217 585
R240 nfet_01v8_lvt_W5_L20_m2__nf1_gboth_sdfull_pc/B.n364 nfet_01v8_lvt_W5_L20_m2__nf1_gboth_sdfull_pc/B.n218 585
R241 nfet_01v8_lvt_W5_L20_m2__nf1_gboth_sdfull_pc/B.n273 nfet_01v8_lvt_W5_L20_m2__nf1_gboth_sdfull_pc/B.n218 585
R242 nfet_01v8_lvt_W5_L20_m2__nf1_gboth_sdfull_pc/B.n363 nfet_01v8_lvt_W5_L20_m2__nf1_gboth_sdfull_pc/B.n219 585
R243 nfet_01v8_lvt_W5_L20_m2__nf1_gboth_sdfull_pc/B.n274 nfet_01v8_lvt_W5_L20_m2__nf1_gboth_sdfull_pc/B.n219 585
R244 nfet_01v8_lvt_W5_L20_m2__nf1_gboth_sdfull_pc/B.n275 nfet_01v8_lvt_W5_L20_m2__nf1_gboth_sdfull_pc/B.n220 585
R245 nfet_01v8_lvt_W5_L20_m2__nf1_gboth_sdfull_pc/B.n276 nfet_01v8_lvt_W5_L20_m2__nf1_gboth_sdfull_pc/B.n275 585
R246 nfet_01v8_lvt_W5_L20_m2__nf1_gboth_sdfull_pc/B.n357 nfet_01v8_lvt_W5_L20_m2__nf1_gboth_sdfull_pc/B.n224 585
R247 nfet_01v8_lvt_W5_L20_m2__nf1_gboth_sdfull_pc/B.n277 nfet_01v8_lvt_W5_L20_m2__nf1_gboth_sdfull_pc/B.n224 585
R248 nfet_01v8_lvt_W5_L20_m2__nf1_gboth_sdfull_pc/B.n356 nfet_01v8_lvt_W5_L20_m2__nf1_gboth_sdfull_pc/B.n225 585
R249 nfet_01v8_lvt_W5_L20_m2__nf1_gboth_sdfull_pc/B.n278 nfet_01v8_lvt_W5_L20_m2__nf1_gboth_sdfull_pc/B.n225 585
R250 nfet_01v8_lvt_W5_L20_m2__nf1_gboth_sdfull_pc/B.n355 nfet_01v8_lvt_W5_L20_m2__nf1_gboth_sdfull_pc/B.n226 585
R251 nfet_01v8_lvt_W5_L20_m2__nf1_gboth_sdfull_pc/B.n279 nfet_01v8_lvt_W5_L20_m2__nf1_gboth_sdfull_pc/B.n226 585
R252 nfet_01v8_lvt_W5_L20_m2__nf1_gboth_sdfull_pc/B.n280 nfet_01v8_lvt_W5_L20_m2__nf1_gboth_sdfull_pc/B.n227 585
R253 nfet_01v8_lvt_W5_L20_m2__nf1_gboth_sdfull_pc/B.n281 nfet_01v8_lvt_W5_L20_m2__nf1_gboth_sdfull_pc/B.n280 585
R254 nfet_01v8_lvt_W5_L20_m2__nf1_gboth_sdfull_pc/B.n349 nfet_01v8_lvt_W5_L20_m2__nf1_gboth_sdfull_pc/B.n231 585
R255 nfet_01v8_lvt_W5_L20_m2__nf1_gboth_sdfull_pc/B.n282 nfet_01v8_lvt_W5_L20_m2__nf1_gboth_sdfull_pc/B.n231 585
R256 nfet_01v8_lvt_W5_L20_m2__nf1_gboth_sdfull_pc/B.n348 nfet_01v8_lvt_W5_L20_m2__nf1_gboth_sdfull_pc/B.n232 585
R257 nfet_01v8_lvt_W5_L20_m2__nf1_gboth_sdfull_pc/B.n283 nfet_01v8_lvt_W5_L20_m2__nf1_gboth_sdfull_pc/B.n232 585
R258 nfet_01v8_lvt_W5_L20_m2__nf1_gboth_sdfull_pc/B.n347 nfet_01v8_lvt_W5_L20_m2__nf1_gboth_sdfull_pc/B.n233 585
R259 nfet_01v8_lvt_W5_L20_m2__nf1_gboth_sdfull_pc/B.n284 nfet_01v8_lvt_W5_L20_m2__nf1_gboth_sdfull_pc/B.n233 585
R260 nfet_01v8_lvt_W5_L20_m2__nf1_gboth_sdfull_pc/B.n285 nfet_01v8_lvt_W5_L20_m2__nf1_gboth_sdfull_pc/B.n234 585
R261 nfet_01v8_lvt_W5_L20_m2__nf1_gboth_sdfull_pc/B.n286 nfet_01v8_lvt_W5_L20_m2__nf1_gboth_sdfull_pc/B.n285 585
R262 nfet_01v8_lvt_W5_L20_m2__nf1_gboth_sdfull_pc/B.n341 nfet_01v8_lvt_W5_L20_m2__nf1_gboth_sdfull_pc/B.n238 585
R263 nfet_01v8_lvt_W5_L20_m2__nf1_gboth_sdfull_pc/B.n287 nfet_01v8_lvt_W5_L20_m2__nf1_gboth_sdfull_pc/B.n238 585
R264 nfet_01v8_lvt_W5_L20_m2__nf1_gboth_sdfull_pc/B.n340 nfet_01v8_lvt_W5_L20_m2__nf1_gboth_sdfull_pc/B.n239 585
R265 nfet_01v8_lvt_W5_L20_m2__nf1_gboth_sdfull_pc/B.n288 nfet_01v8_lvt_W5_L20_m2__nf1_gboth_sdfull_pc/B.n239 585
R266 nfet_01v8_lvt_W5_L20_m2__nf1_gboth_sdfull_pc/B.n339 nfet_01v8_lvt_W5_L20_m2__nf1_gboth_sdfull_pc/B.n240 585
R267 nfet_01v8_lvt_W5_L20_m2__nf1_gboth_sdfull_pc/B.n289 nfet_01v8_lvt_W5_L20_m2__nf1_gboth_sdfull_pc/B.n240 585
R268 nfet_01v8_lvt_W5_L20_m2__nf1_gboth_sdfull_pc/B.n290 nfet_01v8_lvt_W5_L20_m2__nf1_gboth_sdfull_pc/B.n241 585
R269 nfet_01v8_lvt_W5_L20_m2__nf1_gboth_sdfull_pc/B.n291 nfet_01v8_lvt_W5_L20_m2__nf1_gboth_sdfull_pc/B.n290 585
R270 nfet_01v8_lvt_W5_L20_m2__nf1_gboth_sdfull_pc/B.n333 nfet_01v8_lvt_W5_L20_m2__nf1_gboth_sdfull_pc/B.n245 585
R271 nfet_01v8_lvt_W5_L20_m2__nf1_gboth_sdfull_pc/B.n292 nfet_01v8_lvt_W5_L20_m2__nf1_gboth_sdfull_pc/B.n245 585
R272 nfet_01v8_lvt_W5_L20_m2__nf1_gboth_sdfull_pc/B.n332 nfet_01v8_lvt_W5_L20_m2__nf1_gboth_sdfull_pc/B.n246 585
R273 nfet_01v8_lvt_W5_L20_m2__nf1_gboth_sdfull_pc/B.n293 nfet_01v8_lvt_W5_L20_m2__nf1_gboth_sdfull_pc/B.n246 585
R274 nfet_01v8_lvt_W5_L20_m2__nf1_gboth_sdfull_pc/B.n331 nfet_01v8_lvt_W5_L20_m2__nf1_gboth_sdfull_pc/B.n247 585
R275 nfet_01v8_lvt_W5_L20_m2__nf1_gboth_sdfull_pc/B.n294 nfet_01v8_lvt_W5_L20_m2__nf1_gboth_sdfull_pc/B.n247 585
R276 nfet_01v8_lvt_W5_L20_m2__nf1_gboth_sdfull_pc/B.n296 nfet_01v8_lvt_W5_L20_m2__nf1_gboth_sdfull_pc/B.n248 585
R277 nfet_01v8_lvt_W5_L20_m2__nf1_gboth_sdfull_pc/B.n296 nfet_01v8_lvt_W5_L20_m2__nf1_gboth_sdfull_pc/B.n295 585
R278 nfet_01v8_lvt_W5_L20_m2__nf1_gboth_sdfull_pc/B.n298 nfet_01v8_lvt_W5_L20_m2__nf1_gboth_sdfull_pc/B.n297 585
R279 nfet_01v8_lvt_W5_L20_m2__nf1_gboth_sdfull_pc/B.n300 nfet_01v8_lvt_W5_L20_m2__nf1_gboth_sdfull_pc/B.n299 585
R280 nfet_01v8_lvt_W5_L20_m2__nf1_gboth_sdfull_pc/B.n302 nfet_01v8_lvt_W5_L20_m2__nf1_gboth_sdfull_pc/B.n301 585
R281 nfet_01v8_lvt_W5_L20_m2__nf1_gboth_sdfull_pc/B.n304 nfet_01v8_lvt_W5_L20_m2__nf1_gboth_sdfull_pc/B.n303 585
R282 nfet_01v8_lvt_W5_L20_m2__nf1_gboth_sdfull_pc/B.n306 nfet_01v8_lvt_W5_L20_m2__nf1_gboth_sdfull_pc/B.n305 585
R283 nfet_01v8_lvt_W5_L20_m2__nf1_gboth_sdfull_pc/B.n308 nfet_01v8_lvt_W5_L20_m2__nf1_gboth_sdfull_pc/B.n307 585
R284 nfet_01v8_lvt_W5_L20_m2__nf1_gboth_sdfull_pc/B.n310 nfet_01v8_lvt_W5_L20_m2__nf1_gboth_sdfull_pc/B.n309 585
R285 nfet_01v8_lvt_W5_L20_m2__nf1_gboth_sdfull_pc/B.n312 nfet_01v8_lvt_W5_L20_m2__nf1_gboth_sdfull_pc/B.n311 585
R286 nfet_01v8_lvt_W5_L20_m2__nf1_gboth_sdfull_pc/B.n324 nfet_01v8_lvt_W5_L20_m2__nf1_gboth_sdfull_pc/B.n257 585
R287 nfet_01v8_lvt_W5_L20_m2__nf1_gboth_sdfull_pc/B.n313 nfet_01v8_lvt_W5_L20_m2__nf1_gboth_sdfull_pc/B.n257 585
R288 nfet_01v8_lvt_W5_L20_m2__nf1_gboth_sdfull_pc/B.n315 nfet_01v8_lvt_W5_L20_m2__nf1_gboth_sdfull_pc/B.n314 585
R289 nfet_01v8_lvt_W5_L20_m2__nf1_gboth_sdfull_pc/B.n317 nfet_01v8_lvt_W5_L20_m2__nf1_gboth_sdfull_pc/B.n316 585
R290 nfet_01v8_lvt_W5_L20_m2__nf1_gboth_sdfull_pc/B.n319 nfet_01v8_lvt_W5_L20_m2__nf1_gboth_sdfull_pc/B.n318 585
R291 nfet_01v8_lvt_W5_L20_m2__nf1_gboth_sdfull_pc/B.n320 nfet_01v8_lvt_W5_L20_m2__nf1_gboth_sdfull_pc/B.n260 585
R292 nfet_01v8_lvt_W5_L20_m2__nf1_gboth_sdfull_pc/B.n322 nfet_01v8_lvt_W5_L20_m2__nf1_gboth_sdfull_pc/B.n321 585
R293 nfet_01v8_lvt_W5_L20_m2__nf1_gboth_sdfull_pc/B.n261 nfet_01v8_lvt_W5_L20_m2__nf1_gboth_sdfull_pc/B.n259 585
R294 nfet_01v8_lvt_W5_L20_m2__nf1_gboth_sdfull_pc/B.n251 nfet_01v8_lvt_W5_L20_m2__nf1_gboth_sdfull_pc/B.n250 585
R295 nfet_01v8_lvt_W5_L20_m2__nf1_gboth_sdfull_pc/B.n327 nfet_01v8_lvt_W5_L20_m2__nf1_gboth_sdfull_pc/B.n326 585
R296 nfet_01v8_lvt_W5_L20_m2__nf1_gboth_sdfull_pc/B.n301 nfet_01v8_lvt_W5_L20_m2__nf1_gboth_sdfull_pc/B.n300 394
R297 nfet_01v8_lvt_W5_L20_m2__nf1_gboth_sdfull_pc/B.n305 nfet_01v8_lvt_W5_L20_m2__nf1_gboth_sdfull_pc/B.n304 394
R298 nfet_01v8_lvt_W5_L20_m2__nf1_gboth_sdfull_pc/B.n309 nfet_01v8_lvt_W5_L20_m2__nf1_gboth_sdfull_pc/B.n308 394
R299 nfet_01v8_lvt_W5_L20_m2__nf1_gboth_sdfull_pc/B.n311 nfet_01v8_lvt_W5_L20_m2__nf1_gboth_sdfull_pc/B.n257 394
R300 nfet_01v8_lvt_W5_L20_m2__nf1_gboth_sdfull_pc/B.n314 nfet_01v8_lvt_W5_L20_m2__nf1_gboth_sdfull_pc/B.n257 394
R301 nfet_01v8_lvt_W5_L20_m2__nf1_gboth_sdfull_pc/B.n318 nfet_01v8_lvt_W5_L20_m2__nf1_gboth_sdfull_pc/B.n317 394
R302 nfet_01v8_lvt_W5_L20_m2__nf1_gboth_sdfull_pc/B.n322 nfet_01v8_lvt_W5_L20_m2__nf1_gboth_sdfull_pc/B.n260 394
R303 nfet_01v8_lvt_W5_L20_m2__nf1_gboth_sdfull_pc/B.n259 nfet_01v8_lvt_W5_L20_m2__nf1_gboth_sdfull_pc/B.n251 394
R304 nfet_01v8_lvt_W5_L20_m2__nf1_gboth_sdfull_pc/B.n296 nfet_01v8_lvt_W5_L20_m2__nf1_gboth_sdfull_pc/B.n247 394
R305 nfet_01v8_lvt_W5_L20_m2__nf1_gboth_sdfull_pc/B.n247 nfet_01v8_lvt_W5_L20_m2__nf1_gboth_sdfull_pc/B.n246 394
R306 nfet_01v8_lvt_W5_L20_m2__nf1_gboth_sdfull_pc/B.n246 nfet_01v8_lvt_W5_L20_m2__nf1_gboth_sdfull_pc/B.n245 394
R307 nfet_01v8_lvt_W5_L20_m2__nf1_gboth_sdfull_pc/B.n290 nfet_01v8_lvt_W5_L20_m2__nf1_gboth_sdfull_pc/B.n245 394
R308 nfet_01v8_lvt_W5_L20_m2__nf1_gboth_sdfull_pc/B.n290 nfet_01v8_lvt_W5_L20_m2__nf1_gboth_sdfull_pc/B.n240 394
R309 nfet_01v8_lvt_W5_L20_m2__nf1_gboth_sdfull_pc/B.n240 nfet_01v8_lvt_W5_L20_m2__nf1_gboth_sdfull_pc/B.n239 394
R310 nfet_01v8_lvt_W5_L20_m2__nf1_gboth_sdfull_pc/B.n239 nfet_01v8_lvt_W5_L20_m2__nf1_gboth_sdfull_pc/B.n238 394
R311 nfet_01v8_lvt_W5_L20_m2__nf1_gboth_sdfull_pc/B.n285 nfet_01v8_lvt_W5_L20_m2__nf1_gboth_sdfull_pc/B.n238 394
R312 nfet_01v8_lvt_W5_L20_m2__nf1_gboth_sdfull_pc/B.n285 nfet_01v8_lvt_W5_L20_m2__nf1_gboth_sdfull_pc/B.n233 394
R313 nfet_01v8_lvt_W5_L20_m2__nf1_gboth_sdfull_pc/B.n233 nfet_01v8_lvt_W5_L20_m2__nf1_gboth_sdfull_pc/B.n232 394
R314 nfet_01v8_lvt_W5_L20_m2__nf1_gboth_sdfull_pc/B.n232 nfet_01v8_lvt_W5_L20_m2__nf1_gboth_sdfull_pc/B.n231 394
R315 nfet_01v8_lvt_W5_L20_m2__nf1_gboth_sdfull_pc/B.n280 nfet_01v8_lvt_W5_L20_m2__nf1_gboth_sdfull_pc/B.n231 394
R316 nfet_01v8_lvt_W5_L20_m2__nf1_gboth_sdfull_pc/B.n280 nfet_01v8_lvt_W5_L20_m2__nf1_gboth_sdfull_pc/B.n226 394
R317 nfet_01v8_lvt_W5_L20_m2__nf1_gboth_sdfull_pc/B.n226 nfet_01v8_lvt_W5_L20_m2__nf1_gboth_sdfull_pc/B.n225 394
R318 nfet_01v8_lvt_W5_L20_m2__nf1_gboth_sdfull_pc/B.n225 nfet_01v8_lvt_W5_L20_m2__nf1_gboth_sdfull_pc/B.n224 394
R319 nfet_01v8_lvt_W5_L20_m2__nf1_gboth_sdfull_pc/B.n275 nfet_01v8_lvt_W5_L20_m2__nf1_gboth_sdfull_pc/B.n224 394
R320 nfet_01v8_lvt_W5_L20_m2__nf1_gboth_sdfull_pc/B.n275 nfet_01v8_lvt_W5_L20_m2__nf1_gboth_sdfull_pc/B.n219 394
R321 nfet_01v8_lvt_W5_L20_m2__nf1_gboth_sdfull_pc/B.n219 nfet_01v8_lvt_W5_L20_m2__nf1_gboth_sdfull_pc/B.n218 394
R322 nfet_01v8_lvt_W5_L20_m2__nf1_gboth_sdfull_pc/B.n218 nfet_01v8_lvt_W5_L20_m2__nf1_gboth_sdfull_pc/B.n217 394
R323 nfet_01v8_lvt_W5_L20_m2__nf1_gboth_sdfull_pc/B.n270 nfet_01v8_lvt_W5_L20_m2__nf1_gboth_sdfull_pc/B.n217 394
R324 nfet_01v8_lvt_W5_L20_m2__nf1_gboth_sdfull_pc/B.n270 nfet_01v8_lvt_W5_L20_m2__nf1_gboth_sdfull_pc/B.n212 394
R325 nfet_01v8_lvt_W5_L20_m2__nf1_gboth_sdfull_pc/B.n212 nfet_01v8_lvt_W5_L20_m2__nf1_gboth_sdfull_pc/B.n211 394
R326 nfet_01v8_lvt_W5_L20_m2__nf1_gboth_sdfull_pc/B.n211 nfet_01v8_lvt_W5_L20_m2__nf1_gboth_sdfull_pc/B.n210 394
R327 nfet_01v8_lvt_W5_L20_m2__nf1_gboth_sdfull_pc/B.n265 nfet_01v8_lvt_W5_L20_m2__nf1_gboth_sdfull_pc/B.n210 394
R328 nfet_01v8_lvt_W5_L20_m2__nf1_gboth_sdfull_pc/B.n265 nfet_01v8_lvt_W5_L20_m2__nf1_gboth_sdfull_pc/B.n205 394
R329 nfet_01v8_lvt_W5_L20_m2__nf1_gboth_sdfull_pc/B.n205 nfet_01v8_lvt_W5_L20_m2__nf1_gboth_sdfull_pc/B.n204 394
R330 nfet_01v8_lvt_W5_L20_m2__nf1_gboth_sdfull_pc/B.n204 nfet_01v8_lvt_W5_L20_m2__nf1_gboth_sdfull_pc/B.n203 394
R331 nfet_01v8_lvt_W5_L20_m2__nf1_gboth_sdfull_pc/B.n203 nfet_01v8_lvt_W5_L20_m2__nf1_gboth_sdfull_pc/B.n3 394
R332 nfet_01v8_lvt_W5_L20_m2__nf1_gboth_sdfull_pc/B.n388 nfet_01v8_lvt_W5_L20_m2__nf1_gboth_sdfull_pc/B.n3 394
R333 nfet_01v8_lvt_W5_L20_m2__nf1_gboth_sdfull_pc/B.n388 nfet_01v8_lvt_W5_L20_m2__nf1_gboth_sdfull_pc/B.n2 394
R334 nfet_01v8_lvt_W5_L20_m2__nf1_gboth_sdfull_pc/B.n196 nfet_01v8_lvt_W5_L20_m2__nf1_gboth_sdfull_pc/B.n2 394
R335 nfet_01v8_lvt_W5_L20_m2__nf1_gboth_sdfull_pc/B.n196 nfet_01v8_lvt_W5_L20_m2__nf1_gboth_sdfull_pc/B.n10 394
R336 nfet_01v8_lvt_W5_L20_m2__nf1_gboth_sdfull_pc/B.n192 nfet_01v8_lvt_W5_L20_m2__nf1_gboth_sdfull_pc/B.n10 394
R337 nfet_01v8_lvt_W5_L20_m2__nf1_gboth_sdfull_pc/B.n192 nfet_01v8_lvt_W5_L20_m2__nf1_gboth_sdfull_pc/B.n12 394
R338 nfet_01v8_lvt_W5_L20_m2__nf1_gboth_sdfull_pc/B.n184 nfet_01v8_lvt_W5_L20_m2__nf1_gboth_sdfull_pc/B.n12 394
R339 nfet_01v8_lvt_W5_L20_m2__nf1_gboth_sdfull_pc/B.n184 nfet_01v8_lvt_W5_L20_m2__nf1_gboth_sdfull_pc/B.n18 394
R340 nfet_01v8_lvt_W5_L20_m2__nf1_gboth_sdfull_pc/B.n180 nfet_01v8_lvt_W5_L20_m2__nf1_gboth_sdfull_pc/B.n18 394
R341 nfet_01v8_lvt_W5_L20_m2__nf1_gboth_sdfull_pc/B.n180 nfet_01v8_lvt_W5_L20_m2__nf1_gboth_sdfull_pc/B.n20 394
R342 nfet_01v8_lvt_W5_L20_m2__nf1_gboth_sdfull_pc/B.n172 nfet_01v8_lvt_W5_L20_m2__nf1_gboth_sdfull_pc/B.n20 394
R343 nfet_01v8_lvt_W5_L20_m2__nf1_gboth_sdfull_pc/B.n172 nfet_01v8_lvt_W5_L20_m2__nf1_gboth_sdfull_pc/B.n26 394
R344 nfet_01v8_lvt_W5_L20_m2__nf1_gboth_sdfull_pc/B.n168 nfet_01v8_lvt_W5_L20_m2__nf1_gboth_sdfull_pc/B.n26 394
R345 nfet_01v8_lvt_W5_L20_m2__nf1_gboth_sdfull_pc/B.n168 nfet_01v8_lvt_W5_L20_m2__nf1_gboth_sdfull_pc/B.n28 394
R346 nfet_01v8_lvt_W5_L20_m2__nf1_gboth_sdfull_pc/B.n160 nfet_01v8_lvt_W5_L20_m2__nf1_gboth_sdfull_pc/B.n28 394
R347 nfet_01v8_lvt_W5_L20_m2__nf1_gboth_sdfull_pc/B.n160 nfet_01v8_lvt_W5_L20_m2__nf1_gboth_sdfull_pc/B.n34 394
R348 nfet_01v8_lvt_W5_L20_m2__nf1_gboth_sdfull_pc/B.n156 nfet_01v8_lvt_W5_L20_m2__nf1_gboth_sdfull_pc/B.n34 394
R349 nfet_01v8_lvt_W5_L20_m2__nf1_gboth_sdfull_pc/B.n156 nfet_01v8_lvt_W5_L20_m2__nf1_gboth_sdfull_pc/B.n36 394
R350 nfet_01v8_lvt_W5_L20_m2__nf1_gboth_sdfull_pc/B.n148 nfet_01v8_lvt_W5_L20_m2__nf1_gboth_sdfull_pc/B.n36 394
R351 nfet_01v8_lvt_W5_L20_m2__nf1_gboth_sdfull_pc/B.n148 nfet_01v8_lvt_W5_L20_m2__nf1_gboth_sdfull_pc/B.n42 394
R352 nfet_01v8_lvt_W5_L20_m2__nf1_gboth_sdfull_pc/B.n144 nfet_01v8_lvt_W5_L20_m2__nf1_gboth_sdfull_pc/B.n42 394
R353 nfet_01v8_lvt_W5_L20_m2__nf1_gboth_sdfull_pc/B.n144 nfet_01v8_lvt_W5_L20_m2__nf1_gboth_sdfull_pc/B.n44 394
R354 nfet_01v8_lvt_W5_L20_m2__nf1_gboth_sdfull_pc/B.n136 nfet_01v8_lvt_W5_L20_m2__nf1_gboth_sdfull_pc/B.n44 394
R355 nfet_01v8_lvt_W5_L20_m2__nf1_gboth_sdfull_pc/B.n136 nfet_01v8_lvt_W5_L20_m2__nf1_gboth_sdfull_pc/B.n50 394
R356 nfet_01v8_lvt_W5_L20_m2__nf1_gboth_sdfull_pc/B.n132 nfet_01v8_lvt_W5_L20_m2__nf1_gboth_sdfull_pc/B.n50 394
R357 nfet_01v8_lvt_W5_L20_m2__nf1_gboth_sdfull_pc/B.n132 nfet_01v8_lvt_W5_L20_m2__nf1_gboth_sdfull_pc/B.n52 394
R358 nfet_01v8_lvt_W5_L20_m2__nf1_gboth_sdfull_pc/B.n124 nfet_01v8_lvt_W5_L20_m2__nf1_gboth_sdfull_pc/B.n52 394
R359 nfet_01v8_lvt_W5_L20_m2__nf1_gboth_sdfull_pc/B.n124 nfet_01v8_lvt_W5_L20_m2__nf1_gboth_sdfull_pc/B.n58 394
R360 nfet_01v8_lvt_W5_L20_m2__nf1_gboth_sdfull_pc/B.n120 nfet_01v8_lvt_W5_L20_m2__nf1_gboth_sdfull_pc/B.n58 394
R361 nfet_01v8_lvt_W5_L20_m2__nf1_gboth_sdfull_pc/B.n120 nfet_01v8_lvt_W5_L20_m2__nf1_gboth_sdfull_pc/B.n60 394
R362 nfet_01v8_lvt_W5_L20_m2__nf1_gboth_sdfull_pc/B.n112 nfet_01v8_lvt_W5_L20_m2__nf1_gboth_sdfull_pc/B.n60 394
R363 nfet_01v8_lvt_W5_L20_m2__nf1_gboth_sdfull_pc/B.n112 nfet_01v8_lvt_W5_L20_m2__nf1_gboth_sdfull_pc/B.n66 394
R364 nfet_01v8_lvt_W5_L20_m2__nf1_gboth_sdfull_pc/B.n77 nfet_01v8_lvt_W5_L20_m2__nf1_gboth_sdfull_pc/B.n68 394
R365 nfet_01v8_lvt_W5_L20_m2__nf1_gboth_sdfull_pc/B.n81 nfet_01v8_lvt_W5_L20_m2__nf1_gboth_sdfull_pc/B.n80 394
R366 nfet_01v8_lvt_W5_L20_m2__nf1_gboth_sdfull_pc/B.n85 nfet_01v8_lvt_W5_L20_m2__nf1_gboth_sdfull_pc/B.n84 394
R367 nfet_01v8_lvt_W5_L20_m2__nf1_gboth_sdfull_pc/B.n89 nfet_01v8_lvt_W5_L20_m2__nf1_gboth_sdfull_pc/B.n88 394
R368 nfet_01v8_lvt_W5_L20_m2__nf1_gboth_sdfull_pc/B.n93 nfet_01v8_lvt_W5_L20_m2__nf1_gboth_sdfull_pc/B.n92 394
R369 nfet_01v8_lvt_W5_L20_m2__nf1_gboth_sdfull_pc/B.n97 nfet_01v8_lvt_W5_L20_m2__nf1_gboth_sdfull_pc/B.n96 394
R370 nfet_01v8_lvt_W5_L20_m2__nf1_gboth_sdfull_pc/B.n101 nfet_01v8_lvt_W5_L20_m2__nf1_gboth_sdfull_pc/B.n100 394
R371 nfet_01v8_lvt_W5_L20_m2__nf1_gboth_sdfull_pc/B.n105 nfet_01v8_lvt_W5_L20_m2__nf1_gboth_sdfull_pc/B.n76 394
R372 nfet_01v8_lvt_W5_L20_m2__nf1_gboth_sdfull_pc/B.n330 nfet_01v8_lvt_W5_L20_m2__nf1_gboth_sdfull_pc/B.n249 394
R373 nfet_01v8_lvt_W5_L20_m2__nf1_gboth_sdfull_pc/B.n330 nfet_01v8_lvt_W5_L20_m2__nf1_gboth_sdfull_pc/B.n244 394
R374 nfet_01v8_lvt_W5_L20_m2__nf1_gboth_sdfull_pc/B.n334 nfet_01v8_lvt_W5_L20_m2__nf1_gboth_sdfull_pc/B.n244 394
R375 nfet_01v8_lvt_W5_L20_m2__nf1_gboth_sdfull_pc/B.n334 nfet_01v8_lvt_W5_L20_m2__nf1_gboth_sdfull_pc/B.n242 394
R376 nfet_01v8_lvt_W5_L20_m2__nf1_gboth_sdfull_pc/B.n338 nfet_01v8_lvt_W5_L20_m2__nf1_gboth_sdfull_pc/B.n242 394
R377 nfet_01v8_lvt_W5_L20_m2__nf1_gboth_sdfull_pc/B.n338 nfet_01v8_lvt_W5_L20_m2__nf1_gboth_sdfull_pc/B.n237 394
R378 nfet_01v8_lvt_W5_L20_m2__nf1_gboth_sdfull_pc/B.n342 nfet_01v8_lvt_W5_L20_m2__nf1_gboth_sdfull_pc/B.n237 394
R379 nfet_01v8_lvt_W5_L20_m2__nf1_gboth_sdfull_pc/B.n342 nfet_01v8_lvt_W5_L20_m2__nf1_gboth_sdfull_pc/B.n235 394
R380 nfet_01v8_lvt_W5_L20_m2__nf1_gboth_sdfull_pc/B.n346 nfet_01v8_lvt_W5_L20_m2__nf1_gboth_sdfull_pc/B.n235 394
R381 nfet_01v8_lvt_W5_L20_m2__nf1_gboth_sdfull_pc/B.n346 nfet_01v8_lvt_W5_L20_m2__nf1_gboth_sdfull_pc/B.n230 394
R382 nfet_01v8_lvt_W5_L20_m2__nf1_gboth_sdfull_pc/B.n350 nfet_01v8_lvt_W5_L20_m2__nf1_gboth_sdfull_pc/B.n230 394
R383 nfet_01v8_lvt_W5_L20_m2__nf1_gboth_sdfull_pc/B.n350 nfet_01v8_lvt_W5_L20_m2__nf1_gboth_sdfull_pc/B.n228 394
R384 nfet_01v8_lvt_W5_L20_m2__nf1_gboth_sdfull_pc/B.n354 nfet_01v8_lvt_W5_L20_m2__nf1_gboth_sdfull_pc/B.n228 394
R385 nfet_01v8_lvt_W5_L20_m2__nf1_gboth_sdfull_pc/B.n354 nfet_01v8_lvt_W5_L20_m2__nf1_gboth_sdfull_pc/B.n223 394
R386 nfet_01v8_lvt_W5_L20_m2__nf1_gboth_sdfull_pc/B.n358 nfet_01v8_lvt_W5_L20_m2__nf1_gboth_sdfull_pc/B.n223 394
R387 nfet_01v8_lvt_W5_L20_m2__nf1_gboth_sdfull_pc/B.n358 nfet_01v8_lvt_W5_L20_m2__nf1_gboth_sdfull_pc/B.n221 394
R388 nfet_01v8_lvt_W5_L20_m2__nf1_gboth_sdfull_pc/B.n362 nfet_01v8_lvt_W5_L20_m2__nf1_gboth_sdfull_pc/B.n221 394
R389 nfet_01v8_lvt_W5_L20_m2__nf1_gboth_sdfull_pc/B.n362 nfet_01v8_lvt_W5_L20_m2__nf1_gboth_sdfull_pc/B.n216 394
R390 nfet_01v8_lvt_W5_L20_m2__nf1_gboth_sdfull_pc/B.n366 nfet_01v8_lvt_W5_L20_m2__nf1_gboth_sdfull_pc/B.n216 394
R391 nfet_01v8_lvt_W5_L20_m2__nf1_gboth_sdfull_pc/B.n366 nfet_01v8_lvt_W5_L20_m2__nf1_gboth_sdfull_pc/B.n214 394
R392 nfet_01v8_lvt_W5_L20_m2__nf1_gboth_sdfull_pc/B.n370 nfet_01v8_lvt_W5_L20_m2__nf1_gboth_sdfull_pc/B.n214 394
R393 nfet_01v8_lvt_W5_L20_m2__nf1_gboth_sdfull_pc/B.n370 nfet_01v8_lvt_W5_L20_m2__nf1_gboth_sdfull_pc/B.n209 394
R394 nfet_01v8_lvt_W5_L20_m2__nf1_gboth_sdfull_pc/B.n374 nfet_01v8_lvt_W5_L20_m2__nf1_gboth_sdfull_pc/B.n209 394
R395 nfet_01v8_lvt_W5_L20_m2__nf1_gboth_sdfull_pc/B.n374 nfet_01v8_lvt_W5_L20_m2__nf1_gboth_sdfull_pc/B.n207 394
R396 nfet_01v8_lvt_W5_L20_m2__nf1_gboth_sdfull_pc/B.n378 nfet_01v8_lvt_W5_L20_m2__nf1_gboth_sdfull_pc/B.n207 394
R397 nfet_01v8_lvt_W5_L20_m2__nf1_gboth_sdfull_pc/B.n378 nfet_01v8_lvt_W5_L20_m2__nf1_gboth_sdfull_pc/B.n202 394
R398 nfet_01v8_lvt_W5_L20_m2__nf1_gboth_sdfull_pc/B.n382 nfet_01v8_lvt_W5_L20_m2__nf1_gboth_sdfull_pc/B.n202 394
R399 nfet_01v8_lvt_W5_L20_m2__nf1_gboth_sdfull_pc/B.n382 nfet_01v8_lvt_W5_L20_m2__nf1_gboth_sdfull_pc/B.n6 394
R400 nfet_01v8_lvt_W5_L20_m2__nf1_gboth_sdfull_pc/B.n386 nfet_01v8_lvt_W5_L20_m2__nf1_gboth_sdfull_pc/B.n6 394
R401 nfet_01v8_lvt_W5_L20_m2__nf1_gboth_sdfull_pc/B.n386 nfet_01v8_lvt_W5_L20_m2__nf1_gboth_sdfull_pc/B.n5 394
R402 nfet_01v8_lvt_W5_L20_m2__nf1_gboth_sdfull_pc/B.n198 nfet_01v8_lvt_W5_L20_m2__nf1_gboth_sdfull_pc/B.n5 394
R403 nfet_01v8_lvt_W5_L20_m2__nf1_gboth_sdfull_pc/B.n198 nfet_01v8_lvt_W5_L20_m2__nf1_gboth_sdfull_pc/B.n8 394
R404 nfet_01v8_lvt_W5_L20_m2__nf1_gboth_sdfull_pc/B.n190 nfet_01v8_lvt_W5_L20_m2__nf1_gboth_sdfull_pc/B.n8 394
R405 nfet_01v8_lvt_W5_L20_m2__nf1_gboth_sdfull_pc/B.n190 nfet_01v8_lvt_W5_L20_m2__nf1_gboth_sdfull_pc/B.n14 394
R406 nfet_01v8_lvt_W5_L20_m2__nf1_gboth_sdfull_pc/B.n186 nfet_01v8_lvt_W5_L20_m2__nf1_gboth_sdfull_pc/B.n14 394
R407 nfet_01v8_lvt_W5_L20_m2__nf1_gboth_sdfull_pc/B.n186 nfet_01v8_lvt_W5_L20_m2__nf1_gboth_sdfull_pc/B.n16 394
R408 nfet_01v8_lvt_W5_L20_m2__nf1_gboth_sdfull_pc/B.n178 nfet_01v8_lvt_W5_L20_m2__nf1_gboth_sdfull_pc/B.n16 394
R409 nfet_01v8_lvt_W5_L20_m2__nf1_gboth_sdfull_pc/B.n178 nfet_01v8_lvt_W5_L20_m2__nf1_gboth_sdfull_pc/B.n22 394
R410 nfet_01v8_lvt_W5_L20_m2__nf1_gboth_sdfull_pc/B.n174 nfet_01v8_lvt_W5_L20_m2__nf1_gboth_sdfull_pc/B.n22 394
R411 nfet_01v8_lvt_W5_L20_m2__nf1_gboth_sdfull_pc/B.n174 nfet_01v8_lvt_W5_L20_m2__nf1_gboth_sdfull_pc/B.n24 394
R412 nfet_01v8_lvt_W5_L20_m2__nf1_gboth_sdfull_pc/B.n166 nfet_01v8_lvt_W5_L20_m2__nf1_gboth_sdfull_pc/B.n24 394
R413 nfet_01v8_lvt_W5_L20_m2__nf1_gboth_sdfull_pc/B.n166 nfet_01v8_lvt_W5_L20_m2__nf1_gboth_sdfull_pc/B.n30 394
R414 nfet_01v8_lvt_W5_L20_m2__nf1_gboth_sdfull_pc/B.n162 nfet_01v8_lvt_W5_L20_m2__nf1_gboth_sdfull_pc/B.n30 394
R415 nfet_01v8_lvt_W5_L20_m2__nf1_gboth_sdfull_pc/B.n162 nfet_01v8_lvt_W5_L20_m2__nf1_gboth_sdfull_pc/B.n32 394
R416 nfet_01v8_lvt_W5_L20_m2__nf1_gboth_sdfull_pc/B.n154 nfet_01v8_lvt_W5_L20_m2__nf1_gboth_sdfull_pc/B.n32 394
R417 nfet_01v8_lvt_W5_L20_m2__nf1_gboth_sdfull_pc/B.n154 nfet_01v8_lvt_W5_L20_m2__nf1_gboth_sdfull_pc/B.n38 394
R418 nfet_01v8_lvt_W5_L20_m2__nf1_gboth_sdfull_pc/B.n150 nfet_01v8_lvt_W5_L20_m2__nf1_gboth_sdfull_pc/B.n38 394
R419 nfet_01v8_lvt_W5_L20_m2__nf1_gboth_sdfull_pc/B.n150 nfet_01v8_lvt_W5_L20_m2__nf1_gboth_sdfull_pc/B.n40 394
R420 nfet_01v8_lvt_W5_L20_m2__nf1_gboth_sdfull_pc/B.n142 nfet_01v8_lvt_W5_L20_m2__nf1_gboth_sdfull_pc/B.n40 394
R421 nfet_01v8_lvt_W5_L20_m2__nf1_gboth_sdfull_pc/B.n142 nfet_01v8_lvt_W5_L20_m2__nf1_gboth_sdfull_pc/B.n46 394
R422 nfet_01v8_lvt_W5_L20_m2__nf1_gboth_sdfull_pc/B.n138 nfet_01v8_lvt_W5_L20_m2__nf1_gboth_sdfull_pc/B.n46 394
R423 nfet_01v8_lvt_W5_L20_m2__nf1_gboth_sdfull_pc/B.n138 nfet_01v8_lvt_W5_L20_m2__nf1_gboth_sdfull_pc/B.n48 394
R424 nfet_01v8_lvt_W5_L20_m2__nf1_gboth_sdfull_pc/B.n130 nfet_01v8_lvt_W5_L20_m2__nf1_gboth_sdfull_pc/B.n48 394
R425 nfet_01v8_lvt_W5_L20_m2__nf1_gboth_sdfull_pc/B.n130 nfet_01v8_lvt_W5_L20_m2__nf1_gboth_sdfull_pc/B.n54 394
R426 nfet_01v8_lvt_W5_L20_m2__nf1_gboth_sdfull_pc/B.n126 nfet_01v8_lvt_W5_L20_m2__nf1_gboth_sdfull_pc/B.n54 394
R427 nfet_01v8_lvt_W5_L20_m2__nf1_gboth_sdfull_pc/B.n126 nfet_01v8_lvt_W5_L20_m2__nf1_gboth_sdfull_pc/B.n56 394
R428 nfet_01v8_lvt_W5_L20_m2__nf1_gboth_sdfull_pc/B.n118 nfet_01v8_lvt_W5_L20_m2__nf1_gboth_sdfull_pc/B.n56 394
R429 nfet_01v8_lvt_W5_L20_m2__nf1_gboth_sdfull_pc/B.n118 nfet_01v8_lvt_W5_L20_m2__nf1_gboth_sdfull_pc/B.n62 394
R430 nfet_01v8_lvt_W5_L20_m2__nf1_gboth_sdfull_pc/B.n114 nfet_01v8_lvt_W5_L20_m2__nf1_gboth_sdfull_pc/B.n62 394
R431 nfet_01v8_lvt_W5_L20_m2__nf1_gboth_sdfull_pc/B.n114 nfet_01v8_lvt_W5_L20_m2__nf1_gboth_sdfull_pc/B.n64 394
R432 nfet_01v8_lvt_W5_L20_m2__nf1_gboth_sdfull_pc/B.n324 nfet_01v8_lvt_W5_L20_m2__nf1_gboth_sdfull_pc/B.n248 323.714
R433 nfet_01v8_lvt_W5_L20_m2__nf1_gboth_sdfull_pc/B.n106 nfet_01v8_lvt_W5_L20_m2__nf1_gboth_sdfull_pc/B.n65 323.714
R434 nfet_01v8_lvt_W5_L20_m2__nf1_gboth_sdfull_pc/B.n106 nfet_01v8_lvt_W5_L20_m2__nf1_gboth_sdfull_pc/B.n75 218.815
R435 nfet_01v8_lvt_W5_L20_m2__nf1_gboth_sdfull_pc/B.n106 nfet_01v8_lvt_W5_L20_m2__nf1_gboth_sdfull_pc/B.n74 218.815
R436 nfet_01v8_lvt_W5_L20_m2__nf1_gboth_sdfull_pc/B.n106 nfet_01v8_lvt_W5_L20_m2__nf1_gboth_sdfull_pc/B.n73 218.815
R437 nfet_01v8_lvt_W5_L20_m2__nf1_gboth_sdfull_pc/B.n106 nfet_01v8_lvt_W5_L20_m2__nf1_gboth_sdfull_pc/B.n72 218.815
R438 nfet_01v8_lvt_W5_L20_m2__nf1_gboth_sdfull_pc/B.n106 nfet_01v8_lvt_W5_L20_m2__nf1_gboth_sdfull_pc/B.n71 218.815
R439 nfet_01v8_lvt_W5_L20_m2__nf1_gboth_sdfull_pc/B.n106 nfet_01v8_lvt_W5_L20_m2__nf1_gboth_sdfull_pc/B.n70 218.815
R440 nfet_01v8_lvt_W5_L20_m2__nf1_gboth_sdfull_pc/B.n106 nfet_01v8_lvt_W5_L20_m2__nf1_gboth_sdfull_pc/B.n69 218.815
R441 nfet_01v8_lvt_W5_L20_m2__nf1_gboth_sdfull_pc/B.n107 nfet_01v8_lvt_W5_L20_m2__nf1_gboth_sdfull_pc/B.n106 218.815
R442 nfet_01v8_lvt_W5_L20_m2__nf1_gboth_sdfull_pc/B.n324 nfet_01v8_lvt_W5_L20_m2__nf1_gboth_sdfull_pc/B.n253 218.815
R443 nfet_01v8_lvt_W5_L20_m2__nf1_gboth_sdfull_pc/B.n324 nfet_01v8_lvt_W5_L20_m2__nf1_gboth_sdfull_pc/B.n254 218.815
R444 nfet_01v8_lvt_W5_L20_m2__nf1_gboth_sdfull_pc/B.n324 nfet_01v8_lvt_W5_L20_m2__nf1_gboth_sdfull_pc/B.n255 218.815
R445 nfet_01v8_lvt_W5_L20_m2__nf1_gboth_sdfull_pc/B.n324 nfet_01v8_lvt_W5_L20_m2__nf1_gboth_sdfull_pc/B.n256 218.815
R446 nfet_01v8_lvt_W5_L20_m2__nf1_gboth_sdfull_pc/B.n324 nfet_01v8_lvt_W5_L20_m2__nf1_gboth_sdfull_pc/B.n258 218.815
R447 nfet_01v8_lvt_W5_L20_m2__nf1_gboth_sdfull_pc/B.n324 nfet_01v8_lvt_W5_L20_m2__nf1_gboth_sdfull_pc/B.n252 218.815
R448 nfet_01v8_lvt_W5_L20_m2__nf1_gboth_sdfull_pc/B.n324 nfet_01v8_lvt_W5_L20_m2__nf1_gboth_sdfull_pc/B.n323 218.815
R449 nfet_01v8_lvt_W5_L20_m2__nf1_gboth_sdfull_pc/B.n325 nfet_01v8_lvt_W5_L20_m2__nf1_gboth_sdfull_pc/B.n324 218.815
R450 nfet_01v8_lvt_W5_L20_m2__nf1_gboth_sdfull_pc/B.n331 nfet_01v8_lvt_W5_L20_m2__nf1_gboth_sdfull_pc/B.n248 213.714
R451 nfet_01v8_lvt_W5_L20_m2__nf1_gboth_sdfull_pc/B.n332 nfet_01v8_lvt_W5_L20_m2__nf1_gboth_sdfull_pc/B.n331 213.714
R452 nfet_01v8_lvt_W5_L20_m2__nf1_gboth_sdfull_pc/B.n333 nfet_01v8_lvt_W5_L20_m2__nf1_gboth_sdfull_pc/B.n332 213.714
R453 nfet_01v8_lvt_W5_L20_m2__nf1_gboth_sdfull_pc/B.n333 nfet_01v8_lvt_W5_L20_m2__nf1_gboth_sdfull_pc/B.n241 213.714
R454 nfet_01v8_lvt_W5_L20_m2__nf1_gboth_sdfull_pc/B.n339 nfet_01v8_lvt_W5_L20_m2__nf1_gboth_sdfull_pc/B.n241 213.714
R455 nfet_01v8_lvt_W5_L20_m2__nf1_gboth_sdfull_pc/B.n340 nfet_01v8_lvt_W5_L20_m2__nf1_gboth_sdfull_pc/B.n339 213.714
R456 nfet_01v8_lvt_W5_L20_m2__nf1_gboth_sdfull_pc/B.n341 nfet_01v8_lvt_W5_L20_m2__nf1_gboth_sdfull_pc/B.n340 213.714
R457 nfet_01v8_lvt_W5_L20_m2__nf1_gboth_sdfull_pc/B.n341 nfet_01v8_lvt_W5_L20_m2__nf1_gboth_sdfull_pc/B.n234 213.714
R458 nfet_01v8_lvt_W5_L20_m2__nf1_gboth_sdfull_pc/B.n347 nfet_01v8_lvt_W5_L20_m2__nf1_gboth_sdfull_pc/B.n234 213.714
R459 nfet_01v8_lvt_W5_L20_m2__nf1_gboth_sdfull_pc/B.n348 nfet_01v8_lvt_W5_L20_m2__nf1_gboth_sdfull_pc/B.n347 213.714
R460 nfet_01v8_lvt_W5_L20_m2__nf1_gboth_sdfull_pc/B.n349 nfet_01v8_lvt_W5_L20_m2__nf1_gboth_sdfull_pc/B.n348 213.714
R461 nfet_01v8_lvt_W5_L20_m2__nf1_gboth_sdfull_pc/B.n349 nfet_01v8_lvt_W5_L20_m2__nf1_gboth_sdfull_pc/B.n227 213.714
R462 nfet_01v8_lvt_W5_L20_m2__nf1_gboth_sdfull_pc/B.n355 nfet_01v8_lvt_W5_L20_m2__nf1_gboth_sdfull_pc/B.n227 213.714
R463 nfet_01v8_lvt_W5_L20_m2__nf1_gboth_sdfull_pc/B.n356 nfet_01v8_lvt_W5_L20_m2__nf1_gboth_sdfull_pc/B.n355 213.714
R464 nfet_01v8_lvt_W5_L20_m2__nf1_gboth_sdfull_pc/B.n357 nfet_01v8_lvt_W5_L20_m2__nf1_gboth_sdfull_pc/B.n356 213.714
R465 nfet_01v8_lvt_W5_L20_m2__nf1_gboth_sdfull_pc/B.n357 nfet_01v8_lvt_W5_L20_m2__nf1_gboth_sdfull_pc/B.n220 213.714
R466 nfet_01v8_lvt_W5_L20_m2__nf1_gboth_sdfull_pc/B.n363 nfet_01v8_lvt_W5_L20_m2__nf1_gboth_sdfull_pc/B.n220 213.714
R467 nfet_01v8_lvt_W5_L20_m2__nf1_gboth_sdfull_pc/B.n364 nfet_01v8_lvt_W5_L20_m2__nf1_gboth_sdfull_pc/B.n363 213.714
R468 nfet_01v8_lvt_W5_L20_m2__nf1_gboth_sdfull_pc/B.n365 nfet_01v8_lvt_W5_L20_m2__nf1_gboth_sdfull_pc/B.n364 213.714
R469 nfet_01v8_lvt_W5_L20_m2__nf1_gboth_sdfull_pc/B.n365 nfet_01v8_lvt_W5_L20_m2__nf1_gboth_sdfull_pc/B.n213 213.714
R470 nfet_01v8_lvt_W5_L20_m2__nf1_gboth_sdfull_pc/B.n371 nfet_01v8_lvt_W5_L20_m2__nf1_gboth_sdfull_pc/B.n213 213.714
R471 nfet_01v8_lvt_W5_L20_m2__nf1_gboth_sdfull_pc/B.n372 nfet_01v8_lvt_W5_L20_m2__nf1_gboth_sdfull_pc/B.n371 213.714
R472 nfet_01v8_lvt_W5_L20_m2__nf1_gboth_sdfull_pc/B.n373 nfet_01v8_lvt_W5_L20_m2__nf1_gboth_sdfull_pc/B.n372 213.714
R473 nfet_01v8_lvt_W5_L20_m2__nf1_gboth_sdfull_pc/B.n373 nfet_01v8_lvt_W5_L20_m2__nf1_gboth_sdfull_pc/B.n206 213.714
R474 nfet_01v8_lvt_W5_L20_m2__nf1_gboth_sdfull_pc/B.n379 nfet_01v8_lvt_W5_L20_m2__nf1_gboth_sdfull_pc/B.n206 213.714
R475 nfet_01v8_lvt_W5_L20_m2__nf1_gboth_sdfull_pc/B.n380 nfet_01v8_lvt_W5_L20_m2__nf1_gboth_sdfull_pc/B.n379 213.714
R476 nfet_01v8_lvt_W5_L20_m2__nf1_gboth_sdfull_pc/B.n381 nfet_01v8_lvt_W5_L20_m2__nf1_gboth_sdfull_pc/B.n380 213.714
R477 nfet_01v8_lvt_W5_L20_m2__nf1_gboth_sdfull_pc/B.n381 nfet_01v8_lvt_W5_L20_m2__nf1_gboth_sdfull_pc/B.n4 213.714
R478 nfet_01v8_lvt_W5_L20_m2__nf1_gboth_sdfull_pc/B.n387 nfet_01v8_lvt_W5_L20_m2__nf1_gboth_sdfull_pc/B.n4 213.714
R479 nfet_01v8_lvt_W5_L20_m2__nf1_gboth_sdfull_pc/B.n387 nfet_01v8_lvt_W5_L20_m2__nf1_gboth_sdfull_pc/B.t0 213.714
R480 nfet_01v8_lvt_W5_L20_m2__nf1_gboth_sdfull_pc/B.n197 nfet_01v8_lvt_W5_L20_m2__nf1_gboth_sdfull_pc/B.t0 213.714
R481 nfet_01v8_lvt_W5_L20_m2__nf1_gboth_sdfull_pc/B.n197 nfet_01v8_lvt_W5_L20_m2__nf1_gboth_sdfull_pc/B.n9 213.714
R482 nfet_01v8_lvt_W5_L20_m2__nf1_gboth_sdfull_pc/B.n191 nfet_01v8_lvt_W5_L20_m2__nf1_gboth_sdfull_pc/B.n9 213.714
R483 nfet_01v8_lvt_W5_L20_m2__nf1_gboth_sdfull_pc/B.n191 nfet_01v8_lvt_W5_L20_m2__nf1_gboth_sdfull_pc/B.n13 213.714
R484 nfet_01v8_lvt_W5_L20_m2__nf1_gboth_sdfull_pc/B.n185 nfet_01v8_lvt_W5_L20_m2__nf1_gboth_sdfull_pc/B.n13 213.714
R485 nfet_01v8_lvt_W5_L20_m2__nf1_gboth_sdfull_pc/B.n185 nfet_01v8_lvt_W5_L20_m2__nf1_gboth_sdfull_pc/B.n17 213.714
R486 nfet_01v8_lvt_W5_L20_m2__nf1_gboth_sdfull_pc/B.n179 nfet_01v8_lvt_W5_L20_m2__nf1_gboth_sdfull_pc/B.n17 213.714
R487 nfet_01v8_lvt_W5_L20_m2__nf1_gboth_sdfull_pc/B.n179 nfet_01v8_lvt_W5_L20_m2__nf1_gboth_sdfull_pc/B.n21 213.714
R488 nfet_01v8_lvt_W5_L20_m2__nf1_gboth_sdfull_pc/B.n173 nfet_01v8_lvt_W5_L20_m2__nf1_gboth_sdfull_pc/B.n21 213.714
R489 nfet_01v8_lvt_W5_L20_m2__nf1_gboth_sdfull_pc/B.n173 nfet_01v8_lvt_W5_L20_m2__nf1_gboth_sdfull_pc/B.n25 213.714
R490 nfet_01v8_lvt_W5_L20_m2__nf1_gboth_sdfull_pc/B.n167 nfet_01v8_lvt_W5_L20_m2__nf1_gboth_sdfull_pc/B.n25 213.714
R491 nfet_01v8_lvt_W5_L20_m2__nf1_gboth_sdfull_pc/B.n167 nfet_01v8_lvt_W5_L20_m2__nf1_gboth_sdfull_pc/B.n29 213.714
R492 nfet_01v8_lvt_W5_L20_m2__nf1_gboth_sdfull_pc/B.n161 nfet_01v8_lvt_W5_L20_m2__nf1_gboth_sdfull_pc/B.n29 213.714
R493 nfet_01v8_lvt_W5_L20_m2__nf1_gboth_sdfull_pc/B.n161 nfet_01v8_lvt_W5_L20_m2__nf1_gboth_sdfull_pc/B.n33 213.714
R494 nfet_01v8_lvt_W5_L20_m2__nf1_gboth_sdfull_pc/B.n155 nfet_01v8_lvt_W5_L20_m2__nf1_gboth_sdfull_pc/B.n33 213.714
R495 nfet_01v8_lvt_W5_L20_m2__nf1_gboth_sdfull_pc/B.n155 nfet_01v8_lvt_W5_L20_m2__nf1_gboth_sdfull_pc/B.n37 213.714
R496 nfet_01v8_lvt_W5_L20_m2__nf1_gboth_sdfull_pc/B.n149 nfet_01v8_lvt_W5_L20_m2__nf1_gboth_sdfull_pc/B.n37 213.714
R497 nfet_01v8_lvt_W5_L20_m2__nf1_gboth_sdfull_pc/B.n149 nfet_01v8_lvt_W5_L20_m2__nf1_gboth_sdfull_pc/B.n41 213.714
R498 nfet_01v8_lvt_W5_L20_m2__nf1_gboth_sdfull_pc/B.n143 nfet_01v8_lvt_W5_L20_m2__nf1_gboth_sdfull_pc/B.n41 213.714
R499 nfet_01v8_lvt_W5_L20_m2__nf1_gboth_sdfull_pc/B.n143 nfet_01v8_lvt_W5_L20_m2__nf1_gboth_sdfull_pc/B.n45 213.714
R500 nfet_01v8_lvt_W5_L20_m2__nf1_gboth_sdfull_pc/B.n137 nfet_01v8_lvt_W5_L20_m2__nf1_gboth_sdfull_pc/B.n45 213.714
R501 nfet_01v8_lvt_W5_L20_m2__nf1_gboth_sdfull_pc/B.n137 nfet_01v8_lvt_W5_L20_m2__nf1_gboth_sdfull_pc/B.n49 213.714
R502 nfet_01v8_lvt_W5_L20_m2__nf1_gboth_sdfull_pc/B.n131 nfet_01v8_lvt_W5_L20_m2__nf1_gboth_sdfull_pc/B.n49 213.714
R503 nfet_01v8_lvt_W5_L20_m2__nf1_gboth_sdfull_pc/B.n131 nfet_01v8_lvt_W5_L20_m2__nf1_gboth_sdfull_pc/B.n53 213.714
R504 nfet_01v8_lvt_W5_L20_m2__nf1_gboth_sdfull_pc/B.n125 nfet_01v8_lvt_W5_L20_m2__nf1_gboth_sdfull_pc/B.n53 213.714
R505 nfet_01v8_lvt_W5_L20_m2__nf1_gboth_sdfull_pc/B.n125 nfet_01v8_lvt_W5_L20_m2__nf1_gboth_sdfull_pc/B.n57 213.714
R506 nfet_01v8_lvt_W5_L20_m2__nf1_gboth_sdfull_pc/B.n119 nfet_01v8_lvt_W5_L20_m2__nf1_gboth_sdfull_pc/B.n57 213.714
R507 nfet_01v8_lvt_W5_L20_m2__nf1_gboth_sdfull_pc/B.n119 nfet_01v8_lvt_W5_L20_m2__nf1_gboth_sdfull_pc/B.n61 213.714
R508 nfet_01v8_lvt_W5_L20_m2__nf1_gboth_sdfull_pc/B.n113 nfet_01v8_lvt_W5_L20_m2__nf1_gboth_sdfull_pc/B.n61 213.714
R509 nfet_01v8_lvt_W5_L20_m2__nf1_gboth_sdfull_pc/B.n113 nfet_01v8_lvt_W5_L20_m2__nf1_gboth_sdfull_pc/B.n65 213.714
R510 nfet_01v8_lvt_W5_L20_m2__nf1_gboth_sdfull_pc/B.n76 nfet_01v8_lvt_W5_L20_m2__nf1_gboth_sdfull_pc/B.n75 147.374
R511 nfet_01v8_lvt_W5_L20_m2__nf1_gboth_sdfull_pc/B.n100 nfet_01v8_lvt_W5_L20_m2__nf1_gboth_sdfull_pc/B.n74 147.374
R512 nfet_01v8_lvt_W5_L20_m2__nf1_gboth_sdfull_pc/B.n96 nfet_01v8_lvt_W5_L20_m2__nf1_gboth_sdfull_pc/B.n73 147.374
R513 nfet_01v8_lvt_W5_L20_m2__nf1_gboth_sdfull_pc/B.n92 nfet_01v8_lvt_W5_L20_m2__nf1_gboth_sdfull_pc/B.n72 147.374
R514 nfet_01v8_lvt_W5_L20_m2__nf1_gboth_sdfull_pc/B.n88 nfet_01v8_lvt_W5_L20_m2__nf1_gboth_sdfull_pc/B.n71 147.374
R515 nfet_01v8_lvt_W5_L20_m2__nf1_gboth_sdfull_pc/B.n84 nfet_01v8_lvt_W5_L20_m2__nf1_gboth_sdfull_pc/B.n70 147.374
R516 nfet_01v8_lvt_W5_L20_m2__nf1_gboth_sdfull_pc/B.n80 nfet_01v8_lvt_W5_L20_m2__nf1_gboth_sdfull_pc/B.n69 147.374
R517 nfet_01v8_lvt_W5_L20_m2__nf1_gboth_sdfull_pc/B.n107 nfet_01v8_lvt_W5_L20_m2__nf1_gboth_sdfull_pc/B.n68 147.374
R518 nfet_01v8_lvt_W5_L20_m2__nf1_gboth_sdfull_pc/B.n300 nfet_01v8_lvt_W5_L20_m2__nf1_gboth_sdfull_pc/B.n253 147.374
R519 nfet_01v8_lvt_W5_L20_m2__nf1_gboth_sdfull_pc/B.n304 nfet_01v8_lvt_W5_L20_m2__nf1_gboth_sdfull_pc/B.n254 147.374
R520 nfet_01v8_lvt_W5_L20_m2__nf1_gboth_sdfull_pc/B.n308 nfet_01v8_lvt_W5_L20_m2__nf1_gboth_sdfull_pc/B.n255 147.374
R521 nfet_01v8_lvt_W5_L20_m2__nf1_gboth_sdfull_pc/B.n311 nfet_01v8_lvt_W5_L20_m2__nf1_gboth_sdfull_pc/B.n256 147.374
R522 nfet_01v8_lvt_W5_L20_m2__nf1_gboth_sdfull_pc/B.n314 nfet_01v8_lvt_W5_L20_m2__nf1_gboth_sdfull_pc/B.n258 147.374
R523 nfet_01v8_lvt_W5_L20_m2__nf1_gboth_sdfull_pc/B.n260 nfet_01v8_lvt_W5_L20_m2__nf1_gboth_sdfull_pc/B.n252 147.374
R524 nfet_01v8_lvt_W5_L20_m2__nf1_gboth_sdfull_pc/B.n323 nfet_01v8_lvt_W5_L20_m2__nf1_gboth_sdfull_pc/B.n322 147.374
R525 nfet_01v8_lvt_W5_L20_m2__nf1_gboth_sdfull_pc/B.n325 nfet_01v8_lvt_W5_L20_m2__nf1_gboth_sdfull_pc/B.n251 147.374
R526 nfet_01v8_lvt_W5_L20_m2__nf1_gboth_sdfull_pc/B.n297 nfet_01v8_lvt_W5_L20_m2__nf1_gboth_sdfull_pc/B.n253 147.374
R527 nfet_01v8_lvt_W5_L20_m2__nf1_gboth_sdfull_pc/B.n301 nfet_01v8_lvt_W5_L20_m2__nf1_gboth_sdfull_pc/B.n254 147.374
R528 nfet_01v8_lvt_W5_L20_m2__nf1_gboth_sdfull_pc/B.n305 nfet_01v8_lvt_W5_L20_m2__nf1_gboth_sdfull_pc/B.n255 147.374
R529 nfet_01v8_lvt_W5_L20_m2__nf1_gboth_sdfull_pc/B.n309 nfet_01v8_lvt_W5_L20_m2__nf1_gboth_sdfull_pc/B.n256 147.374
R530 nfet_01v8_lvt_W5_L20_m2__nf1_gboth_sdfull_pc/B.n317 nfet_01v8_lvt_W5_L20_m2__nf1_gboth_sdfull_pc/B.n258 147.374
R531 nfet_01v8_lvt_W5_L20_m2__nf1_gboth_sdfull_pc/B.n318 nfet_01v8_lvt_W5_L20_m2__nf1_gboth_sdfull_pc/B.n252 147.374
R532 nfet_01v8_lvt_W5_L20_m2__nf1_gboth_sdfull_pc/B.n323 nfet_01v8_lvt_W5_L20_m2__nf1_gboth_sdfull_pc/B.n259 147.374
R533 nfet_01v8_lvt_W5_L20_m2__nf1_gboth_sdfull_pc/B.n326 nfet_01v8_lvt_W5_L20_m2__nf1_gboth_sdfull_pc/B.n325 147.374
R534 nfet_01v8_lvt_W5_L20_m2__nf1_gboth_sdfull_pc/B.n108 nfet_01v8_lvt_W5_L20_m2__nf1_gboth_sdfull_pc/B.n107 147.374
R535 nfet_01v8_lvt_W5_L20_m2__nf1_gboth_sdfull_pc/B.n77 nfet_01v8_lvt_W5_L20_m2__nf1_gboth_sdfull_pc/B.n69 147.374
R536 nfet_01v8_lvt_W5_L20_m2__nf1_gboth_sdfull_pc/B.n81 nfet_01v8_lvt_W5_L20_m2__nf1_gboth_sdfull_pc/B.n70 147.374
R537 nfet_01v8_lvt_W5_L20_m2__nf1_gboth_sdfull_pc/B.n85 nfet_01v8_lvt_W5_L20_m2__nf1_gboth_sdfull_pc/B.n71 147.374
R538 nfet_01v8_lvt_W5_L20_m2__nf1_gboth_sdfull_pc/B.n89 nfet_01v8_lvt_W5_L20_m2__nf1_gboth_sdfull_pc/B.n72 147.374
R539 nfet_01v8_lvt_W5_L20_m2__nf1_gboth_sdfull_pc/B.n93 nfet_01v8_lvt_W5_L20_m2__nf1_gboth_sdfull_pc/B.n73 147.374
R540 nfet_01v8_lvt_W5_L20_m2__nf1_gboth_sdfull_pc/B.n97 nfet_01v8_lvt_W5_L20_m2__nf1_gboth_sdfull_pc/B.n74 147.374
R541 nfet_01v8_lvt_W5_L20_m2__nf1_gboth_sdfull_pc/B.n101 nfet_01v8_lvt_W5_L20_m2__nf1_gboth_sdfull_pc/B.n75 147.374
R542 nfet_01v8_lvt_W5_L20_m2__nf1_gboth_sdfull_pc/B.n324 B 135.143
R543 nfet_01v8_lvt_W5_L20_m2__nf1_gboth_sdfull_pc/B.n298 nfet_01v8_lvt_W5_L20_m2__nf1_gboth_sdfull_pc/B.n295 74.9181
R544 nfet_01v8_lvt_W5_L20_m2__nf1_gboth_sdfull_pc/B.n110 nfet_01v8_lvt_W5_L20_m2__nf1_gboth_sdfull_pc/B.n109 74.9181
R545 nfet_01v8_lvt_W5_L20_m2__nf1_gboth_sdfull_pc/B.n328 nfet_01v8_lvt_W5_L20_m2__nf1_gboth_sdfull_pc/B.n327 74.9181
R546 nfet_01v8_lvt_W5_L20_m2__nf1_gboth_sdfull_pc/B.n104 nfet_01v8_lvt_W5_L20_m2__nf1_gboth_sdfull_pc/B.n63 74.9181
R547 nfet_01v8_lvt_W5_L20_m2__nf1_gboth_sdfull_pc/B.n299 nfet_01v8_lvt_W5_L20_m2__nf1_gboth_sdfull_pc/B.n298 25.6005
R548 nfet_01v8_lvt_W5_L20_m2__nf1_gboth_sdfull_pc/B.n302 nfet_01v8_lvt_W5_L20_m2__nf1_gboth_sdfull_pc/B.n299 25.6005
R549 nfet_01v8_lvt_W5_L20_m2__nf1_gboth_sdfull_pc/B.n303 nfet_01v8_lvt_W5_L20_m2__nf1_gboth_sdfull_pc/B.n302 25.6005
R550 nfet_01v8_lvt_W5_L20_m2__nf1_gboth_sdfull_pc/B.n306 nfet_01v8_lvt_W5_L20_m2__nf1_gboth_sdfull_pc/B.n303 25.6005
R551 nfet_01v8_lvt_W5_L20_m2__nf1_gboth_sdfull_pc/B.n307 nfet_01v8_lvt_W5_L20_m2__nf1_gboth_sdfull_pc/B.n306 25.6005
R552 nfet_01v8_lvt_W5_L20_m2__nf1_gboth_sdfull_pc/B.n310 nfet_01v8_lvt_W5_L20_m2__nf1_gboth_sdfull_pc/B.n307 25.6005
R553 nfet_01v8_lvt_W5_L20_m2__nf1_gboth_sdfull_pc/B.n312 nfet_01v8_lvt_W5_L20_m2__nf1_gboth_sdfull_pc/B.n310 25.6005
R554 nfet_01v8_lvt_W5_L20_m2__nf1_gboth_sdfull_pc/B.n313 nfet_01v8_lvt_W5_L20_m2__nf1_gboth_sdfull_pc/B.n312 25.6005
R555 nfet_01v8_lvt_W5_L20_m2__nf1_gboth_sdfull_pc/B.n315 nfet_01v8_lvt_W5_L20_m2__nf1_gboth_sdfull_pc/B.n313 25.6005
R556 nfet_01v8_lvt_W5_L20_m2__nf1_gboth_sdfull_pc/B.n316 nfet_01v8_lvt_W5_L20_m2__nf1_gboth_sdfull_pc/B.n315 25.6005
R557 nfet_01v8_lvt_W5_L20_m2__nf1_gboth_sdfull_pc/B.n319 nfet_01v8_lvt_W5_L20_m2__nf1_gboth_sdfull_pc/B.n316 25.6005
R558 nfet_01v8_lvt_W5_L20_m2__nf1_gboth_sdfull_pc/B.n320 nfet_01v8_lvt_W5_L20_m2__nf1_gboth_sdfull_pc/B.n319 25.6005
R559 nfet_01v8_lvt_W5_L20_m2__nf1_gboth_sdfull_pc/B.n321 nfet_01v8_lvt_W5_L20_m2__nf1_gboth_sdfull_pc/B.n320 25.6005
R560 nfet_01v8_lvt_W5_L20_m2__nf1_gboth_sdfull_pc/B.n321 nfet_01v8_lvt_W5_L20_m2__nf1_gboth_sdfull_pc/B.n261 25.6005
R561 nfet_01v8_lvt_W5_L20_m2__nf1_gboth_sdfull_pc/B.n261 nfet_01v8_lvt_W5_L20_m2__nf1_gboth_sdfull_pc/B.n250 25.6005
R562 nfet_01v8_lvt_W5_L20_m2__nf1_gboth_sdfull_pc/B.n327 nfet_01v8_lvt_W5_L20_m2__nf1_gboth_sdfull_pc/B.n250 25.6005
R563 nfet_01v8_lvt_W5_L20_m2__nf1_gboth_sdfull_pc/B.n295 nfet_01v8_lvt_W5_L20_m2__nf1_gboth_sdfull_pc/B.n294 25.6005
R564 nfet_01v8_lvt_W5_L20_m2__nf1_gboth_sdfull_pc/B.n294 nfet_01v8_lvt_W5_L20_m2__nf1_gboth_sdfull_pc/B.n293 25.6005
R565 nfet_01v8_lvt_W5_L20_m2__nf1_gboth_sdfull_pc/B.n293 nfet_01v8_lvt_W5_L20_m2__nf1_gboth_sdfull_pc/B.n292 25.6005
R566 nfet_01v8_lvt_W5_L20_m2__nf1_gboth_sdfull_pc/B.n292 nfet_01v8_lvt_W5_L20_m2__nf1_gboth_sdfull_pc/B.n291 25.6005
R567 nfet_01v8_lvt_W5_L20_m2__nf1_gboth_sdfull_pc/B.n291 nfet_01v8_lvt_W5_L20_m2__nf1_gboth_sdfull_pc/B.n289 25.6005
R568 nfet_01v8_lvt_W5_L20_m2__nf1_gboth_sdfull_pc/B.n289 nfet_01v8_lvt_W5_L20_m2__nf1_gboth_sdfull_pc/B.n288 25.6005
R569 nfet_01v8_lvt_W5_L20_m2__nf1_gboth_sdfull_pc/B.n288 nfet_01v8_lvt_W5_L20_m2__nf1_gboth_sdfull_pc/B.n287 25.6005
R570 nfet_01v8_lvt_W5_L20_m2__nf1_gboth_sdfull_pc/B.n287 nfet_01v8_lvt_W5_L20_m2__nf1_gboth_sdfull_pc/B.n286 25.6005
R571 nfet_01v8_lvt_W5_L20_m2__nf1_gboth_sdfull_pc/B.n286 nfet_01v8_lvt_W5_L20_m2__nf1_gboth_sdfull_pc/B.n284 25.6005
R572 nfet_01v8_lvt_W5_L20_m2__nf1_gboth_sdfull_pc/B.n284 nfet_01v8_lvt_W5_L20_m2__nf1_gboth_sdfull_pc/B.n283 25.6005
R573 nfet_01v8_lvt_W5_L20_m2__nf1_gboth_sdfull_pc/B.n283 nfet_01v8_lvt_W5_L20_m2__nf1_gboth_sdfull_pc/B.n282 25.6005
R574 nfet_01v8_lvt_W5_L20_m2__nf1_gboth_sdfull_pc/B.n282 nfet_01v8_lvt_W5_L20_m2__nf1_gboth_sdfull_pc/B.n281 25.6005
R575 nfet_01v8_lvt_W5_L20_m2__nf1_gboth_sdfull_pc/B.n281 nfet_01v8_lvt_W5_L20_m2__nf1_gboth_sdfull_pc/B.n279 25.6005
R576 nfet_01v8_lvt_W5_L20_m2__nf1_gboth_sdfull_pc/B.n279 nfet_01v8_lvt_W5_L20_m2__nf1_gboth_sdfull_pc/B.n278 25.6005
R577 nfet_01v8_lvt_W5_L20_m2__nf1_gboth_sdfull_pc/B.n278 nfet_01v8_lvt_W5_L20_m2__nf1_gboth_sdfull_pc/B.n277 25.6005
R578 nfet_01v8_lvt_W5_L20_m2__nf1_gboth_sdfull_pc/B.n277 nfet_01v8_lvt_W5_L20_m2__nf1_gboth_sdfull_pc/B.n276 25.6005
R579 nfet_01v8_lvt_W5_L20_m2__nf1_gboth_sdfull_pc/B.n276 nfet_01v8_lvt_W5_L20_m2__nf1_gboth_sdfull_pc/B.n274 25.6005
R580 nfet_01v8_lvt_W5_L20_m2__nf1_gboth_sdfull_pc/B.n274 nfet_01v8_lvt_W5_L20_m2__nf1_gboth_sdfull_pc/B.n273 25.6005
R581 nfet_01v8_lvt_W5_L20_m2__nf1_gboth_sdfull_pc/B.n273 nfet_01v8_lvt_W5_L20_m2__nf1_gboth_sdfull_pc/B.n272 25.6005
R582 nfet_01v8_lvt_W5_L20_m2__nf1_gboth_sdfull_pc/B.n272 nfet_01v8_lvt_W5_L20_m2__nf1_gboth_sdfull_pc/B.n271 25.6005
R583 nfet_01v8_lvt_W5_L20_m2__nf1_gboth_sdfull_pc/B.n271 nfet_01v8_lvt_W5_L20_m2__nf1_gboth_sdfull_pc/B.n269 25.6005
R584 nfet_01v8_lvt_W5_L20_m2__nf1_gboth_sdfull_pc/B.n269 nfet_01v8_lvt_W5_L20_m2__nf1_gboth_sdfull_pc/B.n268 25.6005
R585 nfet_01v8_lvt_W5_L20_m2__nf1_gboth_sdfull_pc/B.n268 nfet_01v8_lvt_W5_L20_m2__nf1_gboth_sdfull_pc/B.n267 25.6005
R586 nfet_01v8_lvt_W5_L20_m2__nf1_gboth_sdfull_pc/B.n267 nfet_01v8_lvt_W5_L20_m2__nf1_gboth_sdfull_pc/B.n266 25.6005
R587 nfet_01v8_lvt_W5_L20_m2__nf1_gboth_sdfull_pc/B.n266 nfet_01v8_lvt_W5_L20_m2__nf1_gboth_sdfull_pc/B.n264 25.6005
R588 nfet_01v8_lvt_W5_L20_m2__nf1_gboth_sdfull_pc/B.n264 nfet_01v8_lvt_W5_L20_m2__nf1_gboth_sdfull_pc/B.n263 25.6005
R589 nfet_01v8_lvt_W5_L20_m2__nf1_gboth_sdfull_pc/B.n263 nfet_01v8_lvt_W5_L20_m2__nf1_gboth_sdfull_pc/B.n262 25.6005
R590 nfet_01v8_lvt_W5_L20_m2__nf1_gboth_sdfull_pc/B.n262 nfet_01v8_lvt_W5_L20_m2__nf1_gboth_sdfull_pc/B.n1 25.6005
R591 nfet_01v8_lvt_W5_L20_m2__nf1_gboth_sdfull_pc/B.n389 nfet_01v8_lvt_W5_L20_m2__nf1_gboth_sdfull_pc/B.n1 25.6005
R592 nfet_01v8_lvt_W5_L20_m2__nf1_gboth_sdfull_pc/B.n195 nfet_01v8_lvt_W5_L20_m2__nf1_gboth_sdfull_pc/B.n0 25.6005
R593 nfet_01v8_lvt_W5_L20_m2__nf1_gboth_sdfull_pc/B.n195 nfet_01v8_lvt_W5_L20_m2__nf1_gboth_sdfull_pc/B.n194 25.6005
R594 nfet_01v8_lvt_W5_L20_m2__nf1_gboth_sdfull_pc/B.n194 nfet_01v8_lvt_W5_L20_m2__nf1_gboth_sdfull_pc/B.n193 25.6005
R595 nfet_01v8_lvt_W5_L20_m2__nf1_gboth_sdfull_pc/B.n193 nfet_01v8_lvt_W5_L20_m2__nf1_gboth_sdfull_pc/B.n11 25.6005
R596 nfet_01v8_lvt_W5_L20_m2__nf1_gboth_sdfull_pc/B.n183 nfet_01v8_lvt_W5_L20_m2__nf1_gboth_sdfull_pc/B.n11 25.6005
R597 nfet_01v8_lvt_W5_L20_m2__nf1_gboth_sdfull_pc/B.n183 nfet_01v8_lvt_W5_L20_m2__nf1_gboth_sdfull_pc/B.n182 25.6005
R598 nfet_01v8_lvt_W5_L20_m2__nf1_gboth_sdfull_pc/B.n182 nfet_01v8_lvt_W5_L20_m2__nf1_gboth_sdfull_pc/B.n181 25.6005
R599 nfet_01v8_lvt_W5_L20_m2__nf1_gboth_sdfull_pc/B.n181 nfet_01v8_lvt_W5_L20_m2__nf1_gboth_sdfull_pc/B.n19 25.6005
R600 nfet_01v8_lvt_W5_L20_m2__nf1_gboth_sdfull_pc/B.n171 nfet_01v8_lvt_W5_L20_m2__nf1_gboth_sdfull_pc/B.n19 25.6005
R601 nfet_01v8_lvt_W5_L20_m2__nf1_gboth_sdfull_pc/B.n171 nfet_01v8_lvt_W5_L20_m2__nf1_gboth_sdfull_pc/B.n170 25.6005
R602 nfet_01v8_lvt_W5_L20_m2__nf1_gboth_sdfull_pc/B.n170 nfet_01v8_lvt_W5_L20_m2__nf1_gboth_sdfull_pc/B.n169 25.6005
R603 nfet_01v8_lvt_W5_L20_m2__nf1_gboth_sdfull_pc/B.n169 nfet_01v8_lvt_W5_L20_m2__nf1_gboth_sdfull_pc/B.n27 25.6005
R604 nfet_01v8_lvt_W5_L20_m2__nf1_gboth_sdfull_pc/B.n159 nfet_01v8_lvt_W5_L20_m2__nf1_gboth_sdfull_pc/B.n27 25.6005
R605 nfet_01v8_lvt_W5_L20_m2__nf1_gboth_sdfull_pc/B.n159 nfet_01v8_lvt_W5_L20_m2__nf1_gboth_sdfull_pc/B.n158 25.6005
R606 nfet_01v8_lvt_W5_L20_m2__nf1_gboth_sdfull_pc/B.n158 nfet_01v8_lvt_W5_L20_m2__nf1_gboth_sdfull_pc/B.n157 25.6005
R607 nfet_01v8_lvt_W5_L20_m2__nf1_gboth_sdfull_pc/B.n157 nfet_01v8_lvt_W5_L20_m2__nf1_gboth_sdfull_pc/B.n35 25.6005
R608 nfet_01v8_lvt_W5_L20_m2__nf1_gboth_sdfull_pc/B.n147 nfet_01v8_lvt_W5_L20_m2__nf1_gboth_sdfull_pc/B.n35 25.6005
R609 nfet_01v8_lvt_W5_L20_m2__nf1_gboth_sdfull_pc/B.n147 nfet_01v8_lvt_W5_L20_m2__nf1_gboth_sdfull_pc/B.n146 25.6005
R610 nfet_01v8_lvt_W5_L20_m2__nf1_gboth_sdfull_pc/B.n146 nfet_01v8_lvt_W5_L20_m2__nf1_gboth_sdfull_pc/B.n145 25.6005
R611 nfet_01v8_lvt_W5_L20_m2__nf1_gboth_sdfull_pc/B.n145 nfet_01v8_lvt_W5_L20_m2__nf1_gboth_sdfull_pc/B.n43 25.6005
R612 nfet_01v8_lvt_W5_L20_m2__nf1_gboth_sdfull_pc/B.n135 nfet_01v8_lvt_W5_L20_m2__nf1_gboth_sdfull_pc/B.n43 25.6005
R613 nfet_01v8_lvt_W5_L20_m2__nf1_gboth_sdfull_pc/B.n135 nfet_01v8_lvt_W5_L20_m2__nf1_gboth_sdfull_pc/B.n134 25.6005
R614 nfet_01v8_lvt_W5_L20_m2__nf1_gboth_sdfull_pc/B.n134 nfet_01v8_lvt_W5_L20_m2__nf1_gboth_sdfull_pc/B.n133 25.6005
R615 nfet_01v8_lvt_W5_L20_m2__nf1_gboth_sdfull_pc/B.n133 nfet_01v8_lvt_W5_L20_m2__nf1_gboth_sdfull_pc/B.n51 25.6005
R616 nfet_01v8_lvt_W5_L20_m2__nf1_gboth_sdfull_pc/B.n123 nfet_01v8_lvt_W5_L20_m2__nf1_gboth_sdfull_pc/B.n51 25.6005
R617 nfet_01v8_lvt_W5_L20_m2__nf1_gboth_sdfull_pc/B.n123 nfet_01v8_lvt_W5_L20_m2__nf1_gboth_sdfull_pc/B.n122 25.6005
R618 nfet_01v8_lvt_W5_L20_m2__nf1_gboth_sdfull_pc/B.n122 nfet_01v8_lvt_W5_L20_m2__nf1_gboth_sdfull_pc/B.n121 25.6005
R619 nfet_01v8_lvt_W5_L20_m2__nf1_gboth_sdfull_pc/B.n121 nfet_01v8_lvt_W5_L20_m2__nf1_gboth_sdfull_pc/B.n59 25.6005
R620 nfet_01v8_lvt_W5_L20_m2__nf1_gboth_sdfull_pc/B.n111 nfet_01v8_lvt_W5_L20_m2__nf1_gboth_sdfull_pc/B.n59 25.6005
R621 nfet_01v8_lvt_W5_L20_m2__nf1_gboth_sdfull_pc/B.n111 nfet_01v8_lvt_W5_L20_m2__nf1_gboth_sdfull_pc/B.n110 25.6005
R622 nfet_01v8_lvt_W5_L20_m2__nf1_gboth_sdfull_pc/B.n109 nfet_01v8_lvt_W5_L20_m2__nf1_gboth_sdfull_pc/B.n67 25.6005
R623 nfet_01v8_lvt_W5_L20_m2__nf1_gboth_sdfull_pc/B.n78 nfet_01v8_lvt_W5_L20_m2__nf1_gboth_sdfull_pc/B.n67 25.6005
R624 nfet_01v8_lvt_W5_L20_m2__nf1_gboth_sdfull_pc/B.n79 nfet_01v8_lvt_W5_L20_m2__nf1_gboth_sdfull_pc/B.n78 25.6005
R625 nfet_01v8_lvt_W5_L20_m2__nf1_gboth_sdfull_pc/B.n82 nfet_01v8_lvt_W5_L20_m2__nf1_gboth_sdfull_pc/B.n79 25.6005
R626 nfet_01v8_lvt_W5_L20_m2__nf1_gboth_sdfull_pc/B.n83 nfet_01v8_lvt_W5_L20_m2__nf1_gboth_sdfull_pc/B.n82 25.6005
R627 nfet_01v8_lvt_W5_L20_m2__nf1_gboth_sdfull_pc/B.n86 nfet_01v8_lvt_W5_L20_m2__nf1_gboth_sdfull_pc/B.n83 25.6005
R628 nfet_01v8_lvt_W5_L20_m2__nf1_gboth_sdfull_pc/B.n87 nfet_01v8_lvt_W5_L20_m2__nf1_gboth_sdfull_pc/B.n86 25.6005
R629 nfet_01v8_lvt_W5_L20_m2__nf1_gboth_sdfull_pc/B.n90 nfet_01v8_lvt_W5_L20_m2__nf1_gboth_sdfull_pc/B.n87 25.6005
R630 nfet_01v8_lvt_W5_L20_m2__nf1_gboth_sdfull_pc/B.n91 nfet_01v8_lvt_W5_L20_m2__nf1_gboth_sdfull_pc/B.n90 25.6005
R631 nfet_01v8_lvt_W5_L20_m2__nf1_gboth_sdfull_pc/B.n94 nfet_01v8_lvt_W5_L20_m2__nf1_gboth_sdfull_pc/B.n91 25.6005
R632 nfet_01v8_lvt_W5_L20_m2__nf1_gboth_sdfull_pc/B.n95 nfet_01v8_lvt_W5_L20_m2__nf1_gboth_sdfull_pc/B.n94 25.6005
R633 nfet_01v8_lvt_W5_L20_m2__nf1_gboth_sdfull_pc/B.n98 nfet_01v8_lvt_W5_L20_m2__nf1_gboth_sdfull_pc/B.n95 25.6005
R634 nfet_01v8_lvt_W5_L20_m2__nf1_gboth_sdfull_pc/B.n99 nfet_01v8_lvt_W5_L20_m2__nf1_gboth_sdfull_pc/B.n98 25.6005
R635 nfet_01v8_lvt_W5_L20_m2__nf1_gboth_sdfull_pc/B.n102 nfet_01v8_lvt_W5_L20_m2__nf1_gboth_sdfull_pc/B.n99 25.6005
R636 nfet_01v8_lvt_W5_L20_m2__nf1_gboth_sdfull_pc/B.n103 nfet_01v8_lvt_W5_L20_m2__nf1_gboth_sdfull_pc/B.n102 25.6005
R637 nfet_01v8_lvt_W5_L20_m2__nf1_gboth_sdfull_pc/B.n104 nfet_01v8_lvt_W5_L20_m2__nf1_gboth_sdfull_pc/B.n103 25.6005
R638 nfet_01v8_lvt_W5_L20_m2__nf1_gboth_sdfull_pc/B.n329 nfet_01v8_lvt_W5_L20_m2__nf1_gboth_sdfull_pc/B.n328 25.6005
R639 nfet_01v8_lvt_W5_L20_m2__nf1_gboth_sdfull_pc/B.n329 nfet_01v8_lvt_W5_L20_m2__nf1_gboth_sdfull_pc/B.n243 25.6005
R640 nfet_01v8_lvt_W5_L20_m2__nf1_gboth_sdfull_pc/B.n335 nfet_01v8_lvt_W5_L20_m2__nf1_gboth_sdfull_pc/B.n243 25.6005
R641 nfet_01v8_lvt_W5_L20_m2__nf1_gboth_sdfull_pc/B.n336 nfet_01v8_lvt_W5_L20_m2__nf1_gboth_sdfull_pc/B.n335 25.6005
R642 nfet_01v8_lvt_W5_L20_m2__nf1_gboth_sdfull_pc/B.n337 nfet_01v8_lvt_W5_L20_m2__nf1_gboth_sdfull_pc/B.n336 25.6005
R643 nfet_01v8_lvt_W5_L20_m2__nf1_gboth_sdfull_pc/B.n337 nfet_01v8_lvt_W5_L20_m2__nf1_gboth_sdfull_pc/B.n236 25.6005
R644 nfet_01v8_lvt_W5_L20_m2__nf1_gboth_sdfull_pc/B.n343 nfet_01v8_lvt_W5_L20_m2__nf1_gboth_sdfull_pc/B.n236 25.6005
R645 nfet_01v8_lvt_W5_L20_m2__nf1_gboth_sdfull_pc/B.n344 nfet_01v8_lvt_W5_L20_m2__nf1_gboth_sdfull_pc/B.n343 25.6005
R646 nfet_01v8_lvt_W5_L20_m2__nf1_gboth_sdfull_pc/B.n345 nfet_01v8_lvt_W5_L20_m2__nf1_gboth_sdfull_pc/B.n344 25.6005
R647 nfet_01v8_lvt_W5_L20_m2__nf1_gboth_sdfull_pc/B.n345 nfet_01v8_lvt_W5_L20_m2__nf1_gboth_sdfull_pc/B.n229 25.6005
R648 nfet_01v8_lvt_W5_L20_m2__nf1_gboth_sdfull_pc/B.n351 nfet_01v8_lvt_W5_L20_m2__nf1_gboth_sdfull_pc/B.n229 25.6005
R649 nfet_01v8_lvt_W5_L20_m2__nf1_gboth_sdfull_pc/B.n352 nfet_01v8_lvt_W5_L20_m2__nf1_gboth_sdfull_pc/B.n351 25.6005
R650 nfet_01v8_lvt_W5_L20_m2__nf1_gboth_sdfull_pc/B.n353 nfet_01v8_lvt_W5_L20_m2__nf1_gboth_sdfull_pc/B.n352 25.6005
R651 nfet_01v8_lvt_W5_L20_m2__nf1_gboth_sdfull_pc/B.n353 nfet_01v8_lvt_W5_L20_m2__nf1_gboth_sdfull_pc/B.n222 25.6005
R652 nfet_01v8_lvt_W5_L20_m2__nf1_gboth_sdfull_pc/B.n359 nfet_01v8_lvt_W5_L20_m2__nf1_gboth_sdfull_pc/B.n222 25.6005
R653 nfet_01v8_lvt_W5_L20_m2__nf1_gboth_sdfull_pc/B.n360 nfet_01v8_lvt_W5_L20_m2__nf1_gboth_sdfull_pc/B.n359 25.6005
R654 nfet_01v8_lvt_W5_L20_m2__nf1_gboth_sdfull_pc/B.n361 nfet_01v8_lvt_W5_L20_m2__nf1_gboth_sdfull_pc/B.n360 25.6005
R655 nfet_01v8_lvt_W5_L20_m2__nf1_gboth_sdfull_pc/B.n361 nfet_01v8_lvt_W5_L20_m2__nf1_gboth_sdfull_pc/B.n215 25.6005
R656 nfet_01v8_lvt_W5_L20_m2__nf1_gboth_sdfull_pc/B.n367 nfet_01v8_lvt_W5_L20_m2__nf1_gboth_sdfull_pc/B.n215 25.6005
R657 nfet_01v8_lvt_W5_L20_m2__nf1_gboth_sdfull_pc/B.n368 nfet_01v8_lvt_W5_L20_m2__nf1_gboth_sdfull_pc/B.n367 25.6005
R658 nfet_01v8_lvt_W5_L20_m2__nf1_gboth_sdfull_pc/B.n369 nfet_01v8_lvt_W5_L20_m2__nf1_gboth_sdfull_pc/B.n368 25.6005
R659 nfet_01v8_lvt_W5_L20_m2__nf1_gboth_sdfull_pc/B.n369 nfet_01v8_lvt_W5_L20_m2__nf1_gboth_sdfull_pc/B.n208 25.6005
R660 nfet_01v8_lvt_W5_L20_m2__nf1_gboth_sdfull_pc/B.n375 nfet_01v8_lvt_W5_L20_m2__nf1_gboth_sdfull_pc/B.n208 25.6005
R661 nfet_01v8_lvt_W5_L20_m2__nf1_gboth_sdfull_pc/B.n376 nfet_01v8_lvt_W5_L20_m2__nf1_gboth_sdfull_pc/B.n375 25.6005
R662 nfet_01v8_lvt_W5_L20_m2__nf1_gboth_sdfull_pc/B.n377 nfet_01v8_lvt_W5_L20_m2__nf1_gboth_sdfull_pc/B.n376 25.6005
R663 nfet_01v8_lvt_W5_L20_m2__nf1_gboth_sdfull_pc/B.n377 nfet_01v8_lvt_W5_L20_m2__nf1_gboth_sdfull_pc/B.n201 25.6005
R664 nfet_01v8_lvt_W5_L20_m2__nf1_gboth_sdfull_pc/B.n383 nfet_01v8_lvt_W5_L20_m2__nf1_gboth_sdfull_pc/B.n201 25.6005
R665 nfet_01v8_lvt_W5_L20_m2__nf1_gboth_sdfull_pc/B.n384 nfet_01v8_lvt_W5_L20_m2__nf1_gboth_sdfull_pc/B.n383 25.6005
R666 nfet_01v8_lvt_W5_L20_m2__nf1_gboth_sdfull_pc/B.n385 nfet_01v8_lvt_W5_L20_m2__nf1_gboth_sdfull_pc/B.n384 25.6005
R667 nfet_01v8_lvt_W5_L20_m2__nf1_gboth_sdfull_pc/B.n385 nfet_01v8_lvt_W5_L20_m2__nf1_gboth_sdfull_pc/B.n200 25.6005
R668 nfet_01v8_lvt_W5_L20_m2__nf1_gboth_sdfull_pc/B.n200 nfet_01v8_lvt_W5_L20_m2__nf1_gboth_sdfull_pc/B.n199 25.6005
R669 nfet_01v8_lvt_W5_L20_m2__nf1_gboth_sdfull_pc/B.n199 nfet_01v8_lvt_W5_L20_m2__nf1_gboth_sdfull_pc/B.n7 25.6005
R670 nfet_01v8_lvt_W5_L20_m2__nf1_gboth_sdfull_pc/B.n189 nfet_01v8_lvt_W5_L20_m2__nf1_gboth_sdfull_pc/B.n7 25.6005
R671 nfet_01v8_lvt_W5_L20_m2__nf1_gboth_sdfull_pc/B.n189 nfet_01v8_lvt_W5_L20_m2__nf1_gboth_sdfull_pc/B.n188 25.6005
R672 nfet_01v8_lvt_W5_L20_m2__nf1_gboth_sdfull_pc/B.n188 nfet_01v8_lvt_W5_L20_m2__nf1_gboth_sdfull_pc/B.n187 25.6005
R673 nfet_01v8_lvt_W5_L20_m2__nf1_gboth_sdfull_pc/B.n187 nfet_01v8_lvt_W5_L20_m2__nf1_gboth_sdfull_pc/B.n15 25.6005
R674 nfet_01v8_lvt_W5_L20_m2__nf1_gboth_sdfull_pc/B.n177 nfet_01v8_lvt_W5_L20_m2__nf1_gboth_sdfull_pc/B.n15 25.6005
R675 nfet_01v8_lvt_W5_L20_m2__nf1_gboth_sdfull_pc/B.n177 nfet_01v8_lvt_W5_L20_m2__nf1_gboth_sdfull_pc/B.n176 25.6005
R676 nfet_01v8_lvt_W5_L20_m2__nf1_gboth_sdfull_pc/B.n176 nfet_01v8_lvt_W5_L20_m2__nf1_gboth_sdfull_pc/B.n175 25.6005
R677 nfet_01v8_lvt_W5_L20_m2__nf1_gboth_sdfull_pc/B.n175 nfet_01v8_lvt_W5_L20_m2__nf1_gboth_sdfull_pc/B.n23 25.6005
R678 nfet_01v8_lvt_W5_L20_m2__nf1_gboth_sdfull_pc/B.n165 nfet_01v8_lvt_W5_L20_m2__nf1_gboth_sdfull_pc/B.n23 25.6005
R679 nfet_01v8_lvt_W5_L20_m2__nf1_gboth_sdfull_pc/B.n165 nfet_01v8_lvt_W5_L20_m2__nf1_gboth_sdfull_pc/B.n164 25.6005
R680 nfet_01v8_lvt_W5_L20_m2__nf1_gboth_sdfull_pc/B.n164 nfet_01v8_lvt_W5_L20_m2__nf1_gboth_sdfull_pc/B.n163 25.6005
R681 nfet_01v8_lvt_W5_L20_m2__nf1_gboth_sdfull_pc/B.n163 nfet_01v8_lvt_W5_L20_m2__nf1_gboth_sdfull_pc/B.n31 25.6005
R682 nfet_01v8_lvt_W5_L20_m2__nf1_gboth_sdfull_pc/B.n153 nfet_01v8_lvt_W5_L20_m2__nf1_gboth_sdfull_pc/B.n31 25.6005
R683 nfet_01v8_lvt_W5_L20_m2__nf1_gboth_sdfull_pc/B.n153 nfet_01v8_lvt_W5_L20_m2__nf1_gboth_sdfull_pc/B.n152 25.6005
R684 nfet_01v8_lvt_W5_L20_m2__nf1_gboth_sdfull_pc/B.n152 nfet_01v8_lvt_W5_L20_m2__nf1_gboth_sdfull_pc/B.n151 25.6005
R685 nfet_01v8_lvt_W5_L20_m2__nf1_gboth_sdfull_pc/B.n151 nfet_01v8_lvt_W5_L20_m2__nf1_gboth_sdfull_pc/B.n39 25.6005
R686 nfet_01v8_lvt_W5_L20_m2__nf1_gboth_sdfull_pc/B.n141 nfet_01v8_lvt_W5_L20_m2__nf1_gboth_sdfull_pc/B.n39 25.6005
R687 nfet_01v8_lvt_W5_L20_m2__nf1_gboth_sdfull_pc/B.n141 nfet_01v8_lvt_W5_L20_m2__nf1_gboth_sdfull_pc/B.n140 25.6005
R688 nfet_01v8_lvt_W5_L20_m2__nf1_gboth_sdfull_pc/B.n140 nfet_01v8_lvt_W5_L20_m2__nf1_gboth_sdfull_pc/B.n139 25.6005
R689 nfet_01v8_lvt_W5_L20_m2__nf1_gboth_sdfull_pc/B.n139 nfet_01v8_lvt_W5_L20_m2__nf1_gboth_sdfull_pc/B.n47 25.6005
R690 nfet_01v8_lvt_W5_L20_m2__nf1_gboth_sdfull_pc/B.n129 nfet_01v8_lvt_W5_L20_m2__nf1_gboth_sdfull_pc/B.n47 25.6005
R691 nfet_01v8_lvt_W5_L20_m2__nf1_gboth_sdfull_pc/B.n129 nfet_01v8_lvt_W5_L20_m2__nf1_gboth_sdfull_pc/B.n128 25.6005
R692 nfet_01v8_lvt_W5_L20_m2__nf1_gboth_sdfull_pc/B.n128 nfet_01v8_lvt_W5_L20_m2__nf1_gboth_sdfull_pc/B.n127 25.6005
R693 nfet_01v8_lvt_W5_L20_m2__nf1_gboth_sdfull_pc/B.n127 nfet_01v8_lvt_W5_L20_m2__nf1_gboth_sdfull_pc/B.n55 25.6005
R694 nfet_01v8_lvt_W5_L20_m2__nf1_gboth_sdfull_pc/B.n117 nfet_01v8_lvt_W5_L20_m2__nf1_gboth_sdfull_pc/B.n55 25.6005
R695 nfet_01v8_lvt_W5_L20_m2__nf1_gboth_sdfull_pc/B.n117 nfet_01v8_lvt_W5_L20_m2__nf1_gboth_sdfull_pc/B.n116 25.6005
R696 nfet_01v8_lvt_W5_L20_m2__nf1_gboth_sdfull_pc/B.n116 nfet_01v8_lvt_W5_L20_m2__nf1_gboth_sdfull_pc/B.n115 25.6005
R697 nfet_01v8_lvt_W5_L20_m2__nf1_gboth_sdfull_pc/B.n115 nfet_01v8_lvt_W5_L20_m2__nf1_gboth_sdfull_pc/B.n63 25.6005
R698 B nfet_01v8_lvt_W5_L20_m2__nf1_gboth_sdfull_pc/B.n389 19.2005
R699 B nfet_01v8_lvt_W5_L20_m2__nf1_gboth_sdfull_pc/B.n0 6.4005
R700 B.n172 B.n131 1153.03
R701 B.n388 B.n10 1153.03
R702 B.n378 B.n16 1153.03
R703 B.n143 B.n129 1153.03
R704 B.n131 B.n130 585
R705 B.n174 B.n131 585
R706 B.n177 B.n176 585
R707 B.n176 B.n175 585
R708 B.n126 B.n125 585
R709 B.n125 B.n124 585
R710 B.n184 B.n183 585
R711 B.n185 B.n184 585
R712 B.n123 B.n122 585
R713 B.n186 B.n123 585
R714 B.n189 B.n188 585
R715 B.n188 B.n187 585
R716 B.n118 B.n117 585
R717 B.n117 B.n116 585
R718 B.n196 B.n195 585
R719 B.n197 B.n196 585
R720 B.n115 B.n114 585
R721 B.n198 B.n115 585
R722 B.n201 B.n200 585
R723 B.n200 B.n199 585
R724 B.n110 B.n109 585
R725 B.n109 B.n108 585
R726 B.n208 B.n207 585
R727 B.n209 B.n208 585
R728 B.n107 B.n106 585
R729 B.n210 B.n107 585
R730 B.n213 B.n212 585
R731 B.n212 B.n211 585
R732 B.n102 B.n101 585
R733 B.n101 B.n100 585
R734 B.n220 B.n219 585
R735 B.n221 B.n220 585
R736 B.n99 B.n98 585
R737 B.n222 B.n99 585
R738 B.n225 B.n224 585
R739 B.n224 B.n223 585
R740 B.n94 B.n93 585
R741 B.n93 B.n92 585
R742 B.n232 B.n231 585
R743 B.n233 B.n232 585
R744 B.n91 B.n90 585
R745 B.n234 B.n91 585
R746 B.n237 B.n236 585
R747 B.n236 B.n235 585
R748 B.n86 B.n85 585
R749 B.n85 B.n84 585
R750 B.n244 B.n243 585
R751 B.n245 B.n244 585
R752 B.n83 B.n82 585
R753 B.n246 B.n83 585
R754 B.n249 B.n248 585
R755 B.n248 B.n247 585
R756 B.n78 B.n77 585
R757 B.n77 B.n76 585
R758 B.n256 B.n255 585
R759 B.n257 B.n256 585
R760 B.n75 B.n74 585
R761 B.n258 B.n75 585
R762 B.n262 B.n261 585
R763 B.n261 B.n260 585
R764 B.n70 B.n69 585
R765 B.n259 B.n69 585
R766 B.n269 B.n268 585
R767 B.n270 B.n269 585
R768 B.n68 B.n67 585
R769 B.n271 B.n68 585
R770 B.n274 B.n273 585
R771 B.n273 B.n272 585
R772 B.n63 B.n62 585
R773 B.n62 B.n61 585
R774 B.n281 B.n280 585
R775 B.n282 B.n281 585
R776 B.n60 B.n59 585
R777 B.n283 B.n60 585
R778 B.n286 B.n285 585
R779 B.n285 B.n284 585
R780 B.n55 B.n54 585
R781 B.n54 B.n53 585
R782 B.n293 B.n292 585
R783 B.n294 B.n293 585
R784 B.n52 B.n51 585
R785 B.n295 B.n52 585
R786 B.n298 B.n297 585
R787 B.n297 B.n296 585
R788 B.n47 B.n46 585
R789 B.n46 B.n45 585
R790 B.n305 B.n304 585
R791 B.n306 B.n305 585
R792 B.n44 B.n43 585
R793 B.n307 B.n44 585
R794 B.n310 B.n309 585
R795 B.n309 B.n308 585
R796 B.n39 B.n38 585
R797 B.n38 B.n37 585
R798 B.n317 B.n316 585
R799 B.n318 B.n317 585
R800 B.n36 B.n35 585
R801 B.n319 B.n36 585
R802 B.n322 B.n321 585
R803 B.n321 B.n320 585
R804 B.n31 B.n30 585
R805 B.n30 B.n29 585
R806 B.n329 B.n328 585
R807 B.n330 B.n329 585
R808 B.n28 B.n27 585
R809 B.n331 B.n28 585
R810 B.n334 B.n333 585
R811 B.n333 B.n332 585
R812 B.n23 B.n22 585
R813 B.n22 B.n21 585
R814 B.n341 B.n340 585
R815 B.n342 B.n341 585
R816 B.n20 B.n19 585
R817 B.n343 B.n20 585
R818 B.n346 B.n345 585
R819 B.n345 B.n344 585
R820 B.n14 B.n13 585
R821 B.n13 B.n12 585
R822 B.n384 B.n383 585
R823 B.n385 B.n384 585
R824 B.n10 B.n0 585
R825 B.n386 B.n10 585
R826 B.n389 B.n388 585
R827 B.n388 B.n387 585
R828 B.n11 B.n9 585
R829 B.n351 B.n350 585
R830 B.n353 B.n352 585
R831 B.n355 B.n354 585
R832 B.n357 B.n356 585
R833 B.n359 B.n358 585
R834 B.n361 B.n360 585
R835 B.n363 B.n362 585
R836 B.n365 B.n364 585
R837 B.n367 B.n366 585
R838 B.n369 B.n368 585
R839 B.n371 B.n370 585
R840 B.n373 B.n372 585
R841 B.n375 B.n374 585
R842 B.n377 B.n376 585
R843 B.n379 B.n378 585
R844 B.n16 B.n0 585
R845 B.n380 B.n16 585
R846 B.n383 B.n382 585
R847 B.n382 B.n381 585
R848 B.n15 B.n14 585
R849 B.n349 B.n15 585
R850 B.n347 B.n346 585
R851 B.n348 B.n347 585
R852 B.n19 B.n18 585
R853 B.n18 B.n17 585
R854 B.n340 B.n339 585
R855 B.n339 B.n338 585
R856 B.n24 B.n23 585
R857 B.n337 B.n24 585
R858 B.n335 B.n334 585
R859 B.n336 B.n335 585
R860 B.n27 B.n26 585
R861 B.n26 B.n25 585
R862 B.n328 B.n327 585
R863 B.n327 B.n326 585
R864 B.n32 B.n31 585
R865 B.n325 B.n32 585
R866 B.n323 B.n322 585
R867 B.n324 B.n323 585
R868 B.n35 B.n34 585
R869 B.n34 B.n33 585
R870 B.n316 B.n315 585
R871 B.n315 B.n314 585
R872 B.n40 B.n39 585
R873 B.n313 B.n40 585
R874 B.n311 B.n310 585
R875 B.n312 B.n311 585
R876 B.n43 B.n42 585
R877 B.n42 B.n41 585
R878 B.n304 B.n303 585
R879 B.n303 B.n302 585
R880 B.n48 B.n47 585
R881 B.n301 B.n48 585
R882 B.n299 B.n298 585
R883 B.n300 B.n299 585
R884 B.n51 B.n50 585
R885 B.n50 B.n49 585
R886 B.n292 B.n291 585
R887 B.n291 B.n290 585
R888 B.n56 B.n55 585
R889 B.n289 B.n56 585
R890 B.n287 B.n286 585
R891 B.n288 B.n287 585
R892 B.n59 B.n58 585
R893 B.n58 B.n57 585
R894 B.n280 B.n279 585
R895 B.n279 B.n278 585
R896 B.n64 B.n63 585
R897 B.n277 B.n64 585
R898 B.n275 B.n274 585
R899 B.n276 B.n275 585
R900 B.n67 B.n66 585
R901 B.n66 B.n65 585
R902 B.n268 B.n267 585
R903 B.n267 B.n266 585
R904 B.n71 B.n70 585
R905 B.n265 B.n71 585
R906 B.n263 B.n262 585
R907 B.n264 B.n263 585
R908 B.n74 B.n73 585
R909 B.n73 B.n72 585
R910 B.n255 B.n254 585
R911 B.n254 B.n253 585
R912 B.n79 B.n78 585
R913 B.n252 B.n79 585
R914 B.n250 B.n249 585
R915 B.n251 B.n250 585
R916 B.n82 B.n81 585
R917 B.n81 B.n80 585
R918 B.n243 B.n242 585
R919 B.n242 B.n241 585
R920 B.n87 B.n86 585
R921 B.n240 B.n87 585
R922 B.n238 B.n237 585
R923 B.n239 B.n238 585
R924 B.n90 B.n89 585
R925 B.n89 B.n88 585
R926 B.n231 B.n230 585
R927 B.n230 B.n229 585
R928 B.n95 B.n94 585
R929 B.n228 B.n95 585
R930 B.n226 B.n225 585
R931 B.n227 B.n226 585
R932 B.n98 B.n97 585
R933 B.n97 B.n96 585
R934 B.n219 B.n218 585
R935 B.n218 B.n217 585
R936 B.n103 B.n102 585
R937 B.n216 B.n103 585
R938 B.n214 B.n213 585
R939 B.n215 B.n214 585
R940 B.n106 B.n105 585
R941 B.n105 B.n104 585
R942 B.n207 B.n206 585
R943 B.n206 B.n205 585
R944 B.n111 B.n110 585
R945 B.n204 B.n111 585
R946 B.n202 B.n201 585
R947 B.n203 B.n202 585
R948 B.n114 B.n113 585
R949 B.n113 B.n112 585
R950 B.n195 B.n194 585
R951 B.n194 B.n193 585
R952 B.n119 B.n118 585
R953 B.n192 B.n119 585
R954 B.n190 B.n189 585
R955 B.n191 B.n190 585
R956 B.n122 B.n121 585
R957 B.n121 B.n120 585
R958 B.n183 B.n182 585
R959 B.n182 B.n181 585
R960 B.n127 B.n126 585
R961 B.n180 B.n127 585
R962 B.n178 B.n177 585
R963 B.n179 B.n178 585
R964 B.n130 B.n129 585
R965 B.n129 B.n128 585
R966 B.n144 B.n143 585
R967 B.n146 B.n145 585
R968 B.n148 B.n147 585
R969 B.n150 B.n149 585
R970 B.n171 B.n136 585
R971 B.n151 B.n136 585
R972 B.n153 B.n152 585
R973 B.n155 B.n154 585
R974 B.n157 B.n156 585
R975 B.n159 B.n158 585
R976 B.n161 B.n160 585
R977 B.n163 B.n162 585
R978 B.n171 B.n140 585
R979 B.n164 B.n140 585
R980 B.n166 B.n165 585
R981 B.n167 B.n142 585
R982 B.n169 B.n168 585
R983 B.n133 B.n132 585
R984 B.n172 B.n171 585
R985 B.n173 B.n172 585
R986 B.n172 B.n133 394
R987 B.n169 B.n142 394
R988 B.n165 B.n140 394
R989 B.n162 B.n140 394
R990 B.n160 B.n159 394
R991 B.n156 B.n155 394
R992 B.n152 B.n136 394
R993 B.n149 B.n136 394
R994 B.n147 B.n146 394
R995 B.n384 B.n10 394
R996 B.n384 B.n13 394
R997 B.n345 B.n13 394
R998 B.n345 B.n20 394
R999 B.n341 B.n20 394
R1000 B.n341 B.n22 394
R1001 B.n333 B.n22 394
R1002 B.n333 B.n28 394
R1003 B.n329 B.n28 394
R1004 B.n329 B.n30 394
R1005 B.n321 B.n30 394
R1006 B.n321 B.n36 394
R1007 B.n317 B.n36 394
R1008 B.n317 B.n38 394
R1009 B.n309 B.n38 394
R1010 B.n309 B.n44 394
R1011 B.n305 B.n44 394
R1012 B.n305 B.n46 394
R1013 B.n297 B.n46 394
R1014 B.n297 B.n52 394
R1015 B.n293 B.n52 394
R1016 B.n293 B.n54 394
R1017 B.n285 B.n54 394
R1018 B.n285 B.n60 394
R1019 B.n281 B.n60 394
R1020 B.n281 B.n62 394
R1021 B.n273 B.n62 394
R1022 B.n273 B.n68 394
R1023 B.n269 B.n68 394
R1024 B.n269 B.n69 394
R1025 B.n261 B.n69 394
R1026 B.n261 B.n75 394
R1027 B.n256 B.n75 394
R1028 B.n256 B.n77 394
R1029 B.n248 B.n77 394
R1030 B.n248 B.n83 394
R1031 B.n244 B.n83 394
R1032 B.n244 B.n85 394
R1033 B.n236 B.n85 394
R1034 B.n236 B.n91 394
R1035 B.n232 B.n91 394
R1036 B.n232 B.n93 394
R1037 B.n224 B.n93 394
R1038 B.n224 B.n99 394
R1039 B.n220 B.n99 394
R1040 B.n220 B.n101 394
R1041 B.n212 B.n101 394
R1042 B.n212 B.n107 394
R1043 B.n208 B.n107 394
R1044 B.n208 B.n109 394
R1045 B.n200 B.n109 394
R1046 B.n200 B.n115 394
R1047 B.n196 B.n115 394
R1048 B.n196 B.n117 394
R1049 B.n188 B.n117 394
R1050 B.n188 B.n123 394
R1051 B.n184 B.n123 394
R1052 B.n184 B.n125 394
R1053 B.n176 B.n125 394
R1054 B.n176 B.n131 394
R1055 B.n388 B.n9 394
R1056 B.n352 B.n351 394
R1057 B.n356 B.n355 394
R1058 B.n360 B.n359 394
R1059 B.n364 B.n363 394
R1060 B.n368 B.n367 394
R1061 B.n372 B.n371 394
R1062 B.n376 B.n375 394
R1063 B.n382 B.n16 394
R1064 B.n382 B.n15 394
R1065 B.n347 B.n15 394
R1066 B.n347 B.n18 394
R1067 B.n339 B.n18 394
R1068 B.n339 B.n24 394
R1069 B.n335 B.n24 394
R1070 B.n335 B.n26 394
R1071 B.n327 B.n26 394
R1072 B.n327 B.n32 394
R1073 B.n323 B.n32 394
R1074 B.n323 B.n34 394
R1075 B.n315 B.n34 394
R1076 B.n315 B.n40 394
R1077 B.n311 B.n40 394
R1078 B.n311 B.n42 394
R1079 B.n303 B.n42 394
R1080 B.n303 B.n48 394
R1081 B.n299 B.n48 394
R1082 B.n299 B.n50 394
R1083 B.n291 B.n50 394
R1084 B.n291 B.n56 394
R1085 B.n287 B.n56 394
R1086 B.n287 B.n58 394
R1087 B.n279 B.n58 394
R1088 B.n279 B.n64 394
R1089 B.n275 B.n64 394
R1090 B.n275 B.n66 394
R1091 B.n267 B.n66 394
R1092 B.n267 B.n71 394
R1093 B.n263 B.n71 394
R1094 B.n263 B.n73 394
R1095 B.n254 B.n73 394
R1096 B.n254 B.n79 394
R1097 B.n250 B.n79 394
R1098 B.n250 B.n81 394
R1099 B.n242 B.n81 394
R1100 B.n242 B.n87 394
R1101 B.n238 B.n87 394
R1102 B.n238 B.n89 394
R1103 B.n230 B.n89 394
R1104 B.n230 B.n95 394
R1105 B.n226 B.n95 394
R1106 B.n226 B.n97 394
R1107 B.n218 B.n97 394
R1108 B.n218 B.n103 394
R1109 B.n214 B.n103 394
R1110 B.n214 B.n105 394
R1111 B.n206 B.n105 394
R1112 B.n206 B.n111 394
R1113 B.n202 B.n111 394
R1114 B.n202 B.n113 394
R1115 B.n194 B.n113 394
R1116 B.n194 B.n119 394
R1117 B.n190 B.n119 394
R1118 B.n190 B.n121 394
R1119 B.n182 B.n121 394
R1120 B.n182 B.n127 394
R1121 B.n178 B.n127 394
R1122 B.n178 B.n129 394
R1123 B.n389 B.n0 323.714
R1124 B.n171 B.n130 323.714
R1125 B.n389 B.n8 218.815
R1126 B.n389 B.n7 218.815
R1127 B.n389 B.n6 218.815
R1128 B.n389 B.n5 218.815
R1129 B.n389 B.n4 218.815
R1130 B.n389 B.n3 218.815
R1131 B.n389 B.n2 218.815
R1132 B.n389 B.n1 218.815
R1133 B.n171 B.n134 218.815
R1134 B.n171 B.n135 218.815
R1135 B.n171 B.n137 218.815
R1136 B.n171 B.n138 218.815
R1137 B.n171 B.n139 218.815
R1138 B.n171 B.n141 218.815
R1139 B.n171 B.n170 218.815
R1140 B.n383 B.n0 213.714
R1141 B.n383 B.n14 213.714
R1142 B.n346 B.n14 213.714
R1143 B.n346 B.n19 213.714
R1144 B.n340 B.n19 213.714
R1145 B.n340 B.n23 213.714
R1146 B.n334 B.n23 213.714
R1147 B.n334 B.n27 213.714
R1148 B.n328 B.n27 213.714
R1149 B.n328 B.n31 213.714
R1150 B.n322 B.n31 213.714
R1151 B.n322 B.n35 213.714
R1152 B.n316 B.n35 213.714
R1153 B.n316 B.n39 213.714
R1154 B.n310 B.n39 213.714
R1155 B.n310 B.n43 213.714
R1156 B.n304 B.n43 213.714
R1157 B.n304 B.n47 213.714
R1158 B.n298 B.n47 213.714
R1159 B.n298 B.n51 213.714
R1160 B.n292 B.n51 213.714
R1161 B.n292 B.n55 213.714
R1162 B.n286 B.n55 213.714
R1163 B.n286 B.n59 213.714
R1164 B.n280 B.n59 213.714
R1165 B.n280 B.n63 213.714
R1166 B.n274 B.n63 213.714
R1167 B.n274 B.n67 213.714
R1168 B.n268 B.n67 213.714
R1169 B.n268 B.n70 213.714
R1170 B.n262 B.n70 213.714
R1171 B.n262 B.n74 213.714
R1172 B.n255 B.n74 213.714
R1173 B.n255 B.n78 213.714
R1174 B.n249 B.n78 213.714
R1175 B.n249 B.n82 213.714
R1176 B.n243 B.n82 213.714
R1177 B.n243 B.n86 213.714
R1178 B.n237 B.n86 213.714
R1179 B.n237 B.n90 213.714
R1180 B.n231 B.n90 213.714
R1181 B.n231 B.n94 213.714
R1182 B.n225 B.n94 213.714
R1183 B.n225 B.n98 213.714
R1184 B.n219 B.n98 213.714
R1185 B.n219 B.n102 213.714
R1186 B.n213 B.n102 213.714
R1187 B.n213 B.n106 213.714
R1188 B.n207 B.n106 213.714
R1189 B.n207 B.n110 213.714
R1190 B.n201 B.n110 213.714
R1191 B.n201 B.n114 213.714
R1192 B.n195 B.n114 213.714
R1193 B.n195 B.n118 213.714
R1194 B.n189 B.n118 213.714
R1195 B.n189 B.n122 213.714
R1196 B.n183 B.n122 213.714
R1197 B.n183 B.n126 213.714
R1198 B.n177 B.n126 213.714
R1199 B.n177 B.n130 213.714
R1200 B.n9 B.n8 147.374
R1201 B.n352 B.n7 147.374
R1202 B.n356 B.n6 147.374
R1203 B.n360 B.n5 147.374
R1204 B.n364 B.n4 147.374
R1205 B.n368 B.n3 147.374
R1206 B.n372 B.n2 147.374
R1207 B.n376 B.n1 147.374
R1208 B.n146 B.n134 147.374
R1209 B.n147 B.n135 147.374
R1210 B.n152 B.n137 147.374
R1211 B.n156 B.n138 147.374
R1212 B.n160 B.n139 147.374
R1213 B.n165 B.n141 147.374
R1214 B.n170 B.n169 147.374
R1215 B.n170 B.n133 147.374
R1216 B.n142 B.n141 147.374
R1217 B.n162 B.n139 147.374
R1218 B.n159 B.n138 147.374
R1219 B.n155 B.n137 147.374
R1220 B.n149 B.n135 147.374
R1221 B.n143 B.n134 147.374
R1222 B.n351 B.n8 147.374
R1223 B.n355 B.n7 147.374
R1224 B.n359 B.n6 147.374
R1225 B.n363 B.n5 147.374
R1226 B.n367 B.n4 147.374
R1227 B.n371 B.n3 147.374
R1228 B.n375 B.n2 147.374
R1229 B.n378 B.n1 147.374
R1230 B B.n389 135.143
R1231 B.n387 B.n386 74.9181
R1232 B.n380 B.n379 74.9181
R1233 B.n174 B.n173 74.9181
R1234 B.n144 B.n128 74.9181
R1235 B.n386 B.n385 25.6005
R1236 B.n385 B.n12 25.6005
R1237 B.n344 B.n12 25.6005
R1238 B.n344 B.n343 25.6005
R1239 B.n343 B.n342 25.6005
R1240 B.n342 B.n21 25.6005
R1241 B.n332 B.n21 25.6005
R1242 B.n332 B.n331 25.6005
R1243 B.n331 B.n330 25.6005
R1244 B.n330 B.n29 25.6005
R1245 B.n320 B.n29 25.6005
R1246 B.n320 B.n319 25.6005
R1247 B.n319 B.n318 25.6005
R1248 B.n318 B.n37 25.6005
R1249 B.n308 B.n37 25.6005
R1250 B.n308 B.n307 25.6005
R1251 B.n307 B.n306 25.6005
R1252 B.n306 B.n45 25.6005
R1253 B.n296 B.n45 25.6005
R1254 B.n296 B.n295 25.6005
R1255 B.n295 B.n294 25.6005
R1256 B.n294 B.n53 25.6005
R1257 B.n284 B.n53 25.6005
R1258 B.n284 B.n283 25.6005
R1259 B.n283 B.n282 25.6005
R1260 B.n282 B.n61 25.6005
R1261 B.n272 B.n61 25.6005
R1262 B.n272 B.n271 25.6005
R1263 B.n271 B.n270 25.6005
R1264 B.n260 B.n259 25.6005
R1265 B.n260 B.n258 25.6005
R1266 B.n258 B.n257 25.6005
R1267 B.n257 B.n76 25.6005
R1268 B.n247 B.n76 25.6005
R1269 B.n247 B.n246 25.6005
R1270 B.n246 B.n245 25.6005
R1271 B.n245 B.n84 25.6005
R1272 B.n235 B.n84 25.6005
R1273 B.n235 B.n234 25.6005
R1274 B.n234 B.n233 25.6005
R1275 B.n233 B.n92 25.6005
R1276 B.n223 B.n92 25.6005
R1277 B.n223 B.n222 25.6005
R1278 B.n222 B.n221 25.6005
R1279 B.n221 B.n100 25.6005
R1280 B.n211 B.n100 25.6005
R1281 B.n211 B.n210 25.6005
R1282 B.n210 B.n209 25.6005
R1283 B.n209 B.n108 25.6005
R1284 B.n199 B.n108 25.6005
R1285 B.n199 B.n198 25.6005
R1286 B.n198 B.n197 25.6005
R1287 B.n197 B.n116 25.6005
R1288 B.n187 B.n116 25.6005
R1289 B.n187 B.n186 25.6005
R1290 B.n186 B.n185 25.6005
R1291 B.n185 B.n124 25.6005
R1292 B.n175 B.n124 25.6005
R1293 B.n175 B.n174 25.6005
R1294 B.n387 B.n11 25.6005
R1295 B.n350 B.n11 25.6005
R1296 B.n353 B.n350 25.6005
R1297 B.n354 B.n353 25.6005
R1298 B.n357 B.n354 25.6005
R1299 B.n358 B.n357 25.6005
R1300 B.n361 B.n358 25.6005
R1301 B.n362 B.n361 25.6005
R1302 B.n365 B.n362 25.6005
R1303 B.n366 B.n365 25.6005
R1304 B.n369 B.n366 25.6005
R1305 B.n370 B.n369 25.6005
R1306 B.n373 B.n370 25.6005
R1307 B.n374 B.n373 25.6005
R1308 B.n377 B.n374 25.6005
R1309 B.n379 B.n377 25.6005
R1310 B.n381 B.n380 25.6005
R1311 B.n381 B.n349 25.6005
R1312 B.n349 B.n348 25.6005
R1313 B.n348 B.n17 25.6005
R1314 B.n338 B.n17 25.6005
R1315 B.n338 B.n337 25.6005
R1316 B.n337 B.n336 25.6005
R1317 B.n336 B.n25 25.6005
R1318 B.n326 B.n25 25.6005
R1319 B.n326 B.n325 25.6005
R1320 B.n325 B.n324 25.6005
R1321 B.n324 B.n33 25.6005
R1322 B.n314 B.n33 25.6005
R1323 B.n314 B.n313 25.6005
R1324 B.n313 B.n312 25.6005
R1325 B.n312 B.n41 25.6005
R1326 B.n302 B.n41 25.6005
R1327 B.n302 B.n301 25.6005
R1328 B.n301 B.n300 25.6005
R1329 B.n300 B.n49 25.6005
R1330 B.n290 B.n49 25.6005
R1331 B.n290 B.n289 25.6005
R1332 B.n289 B.n288 25.6005
R1333 B.n288 B.n57 25.6005
R1334 B.n278 B.n57 25.6005
R1335 B.n278 B.n277 25.6005
R1336 B.n277 B.n276 25.6005
R1337 B.n276 B.n65 25.6005
R1338 B.n266 B.n65 25.6005
R1339 B.n266 B.n265 25.6005
R1340 B.n265 B.n264 25.6005
R1341 B.n264 B.n72 25.6005
R1342 B.n253 B.n72 25.6005
R1343 B.n253 B.n252 25.6005
R1344 B.n252 B.n251 25.6005
R1345 B.n251 B.n80 25.6005
R1346 B.n241 B.n80 25.6005
R1347 B.n241 B.n240 25.6005
R1348 B.n240 B.n239 25.6005
R1349 B.n239 B.n88 25.6005
R1350 B.n229 B.n88 25.6005
R1351 B.n229 B.n228 25.6005
R1352 B.n228 B.n227 25.6005
R1353 B.n227 B.n96 25.6005
R1354 B.n217 B.n96 25.6005
R1355 B.n217 B.n216 25.6005
R1356 B.n216 B.n215 25.6005
R1357 B.n215 B.n104 25.6005
R1358 B.n205 B.n104 25.6005
R1359 B.n205 B.n204 25.6005
R1360 B.n204 B.n203 25.6005
R1361 B.n203 B.n112 25.6005
R1362 B.n193 B.n112 25.6005
R1363 B.n193 B.n192 25.6005
R1364 B.n192 B.n191 25.6005
R1365 B.n191 B.n120 25.6005
R1366 B.n181 B.n120 25.6005
R1367 B.n181 B.n180 25.6005
R1368 B.n180 B.n179 25.6005
R1369 B.n179 B.n128 25.6005
R1370 B.n173 B.n132 25.6005
R1371 B.n168 B.n132 25.6005
R1372 B.n168 B.n167 25.6005
R1373 B.n167 B.n166 25.6005
R1374 B.n166 B.n164 25.6005
R1375 B.n164 B.n163 25.6005
R1376 B.n163 B.n161 25.6005
R1377 B.n161 B.n158 25.6005
R1378 B.n158 B.n157 25.6005
R1379 B.n157 B.n154 25.6005
R1380 B.n154 B.n153 25.6005
R1381 B.n153 B.n151 25.6005
R1382 B.n151 B.n150 25.6005
R1383 B.n150 B.n148 25.6005
R1384 B.n148 B.n145 25.6005
R1385 B.n145 B.n144 25.6005
R1386 B.n270 B 19.2005
R1387 B.n259 B 6.4005
R1388 w_n43_n43.n324 w_n43_n43.n261 1153.03
R1389 w_n43_n43.n109 w_n43_n43.n67 1153.03
R1390 w_n43_n43.n327 w_n43_n43.n250 1153.03
R1391 w_n43_n43.n106 w_n43_n43.n65 1153.03
R1392 w_n43_n43.n250 w_n43_n43.n249 585
R1393 w_n43_n43.n329 w_n43_n43.n250 585
R1394 w_n43_n43.n332 w_n43_n43.n331 585
R1395 w_n43_n43.n331 w_n43_n43.n330 585
R1396 w_n43_n43.n333 w_n43_n43.n245 585
R1397 w_n43_n43.n245 w_n43_n43.n244 585
R1398 w_n43_n43.n335 w_n43_n43.n334 585
R1399 w_n43_n43.n336 w_n43_n43.n335 585
R1400 w_n43_n43.n243 w_n43_n43.n242 585
R1401 w_n43_n43.n337 w_n43_n43.n243 585
R1402 w_n43_n43.n340 w_n43_n43.n339 585
R1403 w_n43_n43.n339 w_n43_n43.n338 585
R1404 w_n43_n43.n341 w_n43_n43.n238 585
R1405 w_n43_n43.n238 w_n43_n43.n237 585
R1406 w_n43_n43.n343 w_n43_n43.n342 585
R1407 w_n43_n43.n344 w_n43_n43.n343 585
R1408 w_n43_n43.n236 w_n43_n43.n235 585
R1409 w_n43_n43.n345 w_n43_n43.n236 585
R1410 w_n43_n43.n348 w_n43_n43.n347 585
R1411 w_n43_n43.n347 w_n43_n43.n346 585
R1412 w_n43_n43.n349 w_n43_n43.n231 585
R1413 w_n43_n43.n231 w_n43_n43.n230 585
R1414 w_n43_n43.n351 w_n43_n43.n350 585
R1415 w_n43_n43.n352 w_n43_n43.n351 585
R1416 w_n43_n43.n229 w_n43_n43.n228 585
R1417 w_n43_n43.n353 w_n43_n43.n229 585
R1418 w_n43_n43.n356 w_n43_n43.n355 585
R1419 w_n43_n43.n355 w_n43_n43.n354 585
R1420 w_n43_n43.n357 w_n43_n43.n224 585
R1421 w_n43_n43.n224 w_n43_n43.n223 585
R1422 w_n43_n43.n359 w_n43_n43.n358 585
R1423 w_n43_n43.n360 w_n43_n43.n359 585
R1424 w_n43_n43.n222 w_n43_n43.n221 585
R1425 w_n43_n43.n361 w_n43_n43.n222 585
R1426 w_n43_n43.n364 w_n43_n43.n363 585
R1427 w_n43_n43.n363 w_n43_n43.n362 585
R1428 w_n43_n43.n365 w_n43_n43.n217 585
R1429 w_n43_n43.n217 w_n43_n43.n216 585
R1430 w_n43_n43.n367 w_n43_n43.n366 585
R1431 w_n43_n43.n368 w_n43_n43.n367 585
R1432 w_n43_n43.n215 w_n43_n43.n214 585
R1433 w_n43_n43.n369 w_n43_n43.n215 585
R1434 w_n43_n43.n372 w_n43_n43.n371 585
R1435 w_n43_n43.n371 w_n43_n43.n370 585
R1436 w_n43_n43.n373 w_n43_n43.n210 585
R1437 w_n43_n43.n210 w_n43_n43.n209 585
R1438 w_n43_n43.n375 w_n43_n43.n374 585
R1439 w_n43_n43.n376 w_n43_n43.n375 585
R1440 w_n43_n43.n208 w_n43_n43.n207 585
R1441 w_n43_n43.n377 w_n43_n43.n208 585
R1442 w_n43_n43.n380 w_n43_n43.n379 585
R1443 w_n43_n43.n379 w_n43_n43.n378 585
R1444 w_n43_n43.n381 w_n43_n43.n203 585
R1445 w_n43_n43.n203 w_n43_n43.n202 585
R1446 w_n43_n43.n383 w_n43_n43.n382 585
R1447 w_n43_n43.n384 w_n43_n43.n383 585
R1448 w_n43_n43.n7 w_n43_n43.n5 585
R1449 w_n43_n43.n385 w_n43_n43.n7 585
R1450 w_n43_n43.n388 w_n43_n43.n387 585
R1451 w_n43_n43.n387 w_n43_n43.n386 585
R1452 w_n43_n43.n6 w_n43_n43.n4 585
R1453 w_n43_n43.n201 w_n43_n43.n6 585
R1454 w_n43_n43.n199 w_n43_n43.n198 585
R1455 w_n43_n43.n200 w_n43_n43.n199 585
R1456 w_n43_n43.n10 w_n43_n43.n9 585
R1457 w_n43_n43.n9 w_n43_n43.n8 585
R1458 w_n43_n43.n192 w_n43_n43.n191 585
R1459 w_n43_n43.n191 w_n43_n43.n190 585
R1460 w_n43_n43.n15 w_n43_n43.n14 585
R1461 w_n43_n43.n189 w_n43_n43.n15 585
R1462 w_n43_n43.n187 w_n43_n43.n186 585
R1463 w_n43_n43.n188 w_n43_n43.n187 585
R1464 w_n43_n43.n18 w_n43_n43.n17 585
R1465 w_n43_n43.n17 w_n43_n43.n16 585
R1466 w_n43_n43.n180 w_n43_n43.n179 585
R1467 w_n43_n43.n179 w_n43_n43.n178 585
R1468 w_n43_n43.n23 w_n43_n43.n22 585
R1469 w_n43_n43.n177 w_n43_n43.n23 585
R1470 w_n43_n43.n175 w_n43_n43.n174 585
R1471 w_n43_n43.n176 w_n43_n43.n175 585
R1472 w_n43_n43.n26 w_n43_n43.n25 585
R1473 w_n43_n43.n25 w_n43_n43.n24 585
R1474 w_n43_n43.n168 w_n43_n43.n167 585
R1475 w_n43_n43.n167 w_n43_n43.n166 585
R1476 w_n43_n43.n31 w_n43_n43.n30 585
R1477 w_n43_n43.n165 w_n43_n43.n31 585
R1478 w_n43_n43.n163 w_n43_n43.n162 585
R1479 w_n43_n43.n164 w_n43_n43.n163 585
R1480 w_n43_n43.n34 w_n43_n43.n33 585
R1481 w_n43_n43.n33 w_n43_n43.n32 585
R1482 w_n43_n43.n156 w_n43_n43.n155 585
R1483 w_n43_n43.n155 w_n43_n43.n154 585
R1484 w_n43_n43.n39 w_n43_n43.n38 585
R1485 w_n43_n43.n153 w_n43_n43.n39 585
R1486 w_n43_n43.n151 w_n43_n43.n150 585
R1487 w_n43_n43.n152 w_n43_n43.n151 585
R1488 w_n43_n43.n42 w_n43_n43.n41 585
R1489 w_n43_n43.n41 w_n43_n43.n40 585
R1490 w_n43_n43.n144 w_n43_n43.n143 585
R1491 w_n43_n43.n143 w_n43_n43.n142 585
R1492 w_n43_n43.n47 w_n43_n43.n46 585
R1493 w_n43_n43.n141 w_n43_n43.n47 585
R1494 w_n43_n43.n139 w_n43_n43.n138 585
R1495 w_n43_n43.n140 w_n43_n43.n139 585
R1496 w_n43_n43.n50 w_n43_n43.n49 585
R1497 w_n43_n43.n49 w_n43_n43.n48 585
R1498 w_n43_n43.n132 w_n43_n43.n131 585
R1499 w_n43_n43.n131 w_n43_n43.n130 585
R1500 w_n43_n43.n55 w_n43_n43.n54 585
R1501 w_n43_n43.n129 w_n43_n43.n55 585
R1502 w_n43_n43.n127 w_n43_n43.n126 585
R1503 w_n43_n43.n128 w_n43_n43.n127 585
R1504 w_n43_n43.n58 w_n43_n43.n57 585
R1505 w_n43_n43.n57 w_n43_n43.n56 585
R1506 w_n43_n43.n120 w_n43_n43.n119 585
R1507 w_n43_n43.n119 w_n43_n43.n118 585
R1508 w_n43_n43.n63 w_n43_n43.n62 585
R1509 w_n43_n43.n117 w_n43_n43.n63 585
R1510 w_n43_n43.n115 w_n43_n43.n114 585
R1511 w_n43_n43.n116 w_n43_n43.n115 585
R1512 w_n43_n43.n66 w_n43_n43.n65 585
R1513 w_n43_n43.n65 w_n43_n43.n64 585
R1514 w_n43_n43.n107 w_n43_n43.n106 585
R1515 w_n43_n43.n106 w_n43_n43.n105 585
R1516 w_n43_n43.n104 w_n43_n43.n77 585
R1517 w_n43_n43.n103 w_n43_n43.n102 585
R1518 w_n43_n43.n101 w_n43_n43.n100 585
R1519 w_n43_n43.n99 w_n43_n43.n98 585
R1520 w_n43_n43.n97 w_n43_n43.n96 585
R1521 w_n43_n43.n95 w_n43_n43.n94 585
R1522 w_n43_n43.n93 w_n43_n43.n92 585
R1523 w_n43_n43.n91 w_n43_n43.n90 585
R1524 w_n43_n43.n89 w_n43_n43.n88 585
R1525 w_n43_n43.n87 w_n43_n43.n86 585
R1526 w_n43_n43.n85 w_n43_n43.n84 585
R1527 w_n43_n43.n83 w_n43_n43.n82 585
R1528 w_n43_n43.n81 w_n43_n43.n80 585
R1529 w_n43_n43.n79 w_n43_n43.n78 585
R1530 w_n43_n43.n69 w_n43_n43.n68 585
R1531 w_n43_n43.n110 w_n43_n43.n109 585
R1532 w_n43_n43.n67 w_n43_n43.n66 585
R1533 w_n43_n43.n111 w_n43_n43.n67 585
R1534 w_n43_n43.n114 w_n43_n43.n113 585
R1535 w_n43_n43.n113 w_n43_n43.n112 585
R1536 w_n43_n43.n62 w_n43_n43.n61 585
R1537 w_n43_n43.n61 w_n43_n43.n60 585
R1538 w_n43_n43.n121 w_n43_n43.n120 585
R1539 w_n43_n43.n122 w_n43_n43.n121 585
R1540 w_n43_n43.n59 w_n43_n43.n58 585
R1541 w_n43_n43.n123 w_n43_n43.n59 585
R1542 w_n43_n43.n126 w_n43_n43.n125 585
R1543 w_n43_n43.n125 w_n43_n43.n124 585
R1544 w_n43_n43.n54 w_n43_n43.n53 585
R1545 w_n43_n43.n53 w_n43_n43.n52 585
R1546 w_n43_n43.n133 w_n43_n43.n132 585
R1547 w_n43_n43.n134 w_n43_n43.n133 585
R1548 w_n43_n43.n51 w_n43_n43.n50 585
R1549 w_n43_n43.n135 w_n43_n43.n51 585
R1550 w_n43_n43.n138 w_n43_n43.n137 585
R1551 w_n43_n43.n137 w_n43_n43.n136 585
R1552 w_n43_n43.n46 w_n43_n43.n45 585
R1553 w_n43_n43.n45 w_n43_n43.n44 585
R1554 w_n43_n43.n145 w_n43_n43.n144 585
R1555 w_n43_n43.n146 w_n43_n43.n145 585
R1556 w_n43_n43.n43 w_n43_n43.n42 585
R1557 w_n43_n43.n147 w_n43_n43.n43 585
R1558 w_n43_n43.n150 w_n43_n43.n149 585
R1559 w_n43_n43.n149 w_n43_n43.n148 585
R1560 w_n43_n43.n38 w_n43_n43.n37 585
R1561 w_n43_n43.n37 w_n43_n43.n36 585
R1562 w_n43_n43.n157 w_n43_n43.n156 585
R1563 w_n43_n43.n158 w_n43_n43.n157 585
R1564 w_n43_n43.n35 w_n43_n43.n34 585
R1565 w_n43_n43.n159 w_n43_n43.n35 585
R1566 w_n43_n43.n162 w_n43_n43.n161 585
R1567 w_n43_n43.n161 w_n43_n43.n160 585
R1568 w_n43_n43.n30 w_n43_n43.n29 585
R1569 w_n43_n43.n29 w_n43_n43.n28 585
R1570 w_n43_n43.n169 w_n43_n43.n168 585
R1571 w_n43_n43.n170 w_n43_n43.n169 585
R1572 w_n43_n43.n27 w_n43_n43.n26 585
R1573 w_n43_n43.n171 w_n43_n43.n27 585
R1574 w_n43_n43.n174 w_n43_n43.n173 585
R1575 w_n43_n43.n173 w_n43_n43.n172 585
R1576 w_n43_n43.n22 w_n43_n43.n21 585
R1577 w_n43_n43.n21 w_n43_n43.n20 585
R1578 w_n43_n43.n181 w_n43_n43.n180 585
R1579 w_n43_n43.n182 w_n43_n43.n181 585
R1580 w_n43_n43.n19 w_n43_n43.n18 585
R1581 w_n43_n43.n183 w_n43_n43.n19 585
R1582 w_n43_n43.n186 w_n43_n43.n185 585
R1583 w_n43_n43.n185 w_n43_n43.n184 585
R1584 w_n43_n43.n14 w_n43_n43.n13 585
R1585 w_n43_n43.n13 w_n43_n43.n12 585
R1586 w_n43_n43.n193 w_n43_n43.n192 585
R1587 w_n43_n43.n194 w_n43_n43.n193 585
R1588 w_n43_n43.n11 w_n43_n43.n10 585
R1589 w_n43_n43.n195 w_n43_n43.n11 585
R1590 w_n43_n43.n198 w_n43_n43.n197 585
R1591 w_n43_n43.n197 w_n43_n43.n196 585
R1592 w_n43_n43.n4 w_n43_n43.n2 585
R1593 w_n43_n43.n2 w_n43_n43.n0 585
R1594 w_n43_n43.n389 w_n43_n43.n388 585
R1595 w_n43_n43.n390 w_n43_n43.n389 585
R1596 w_n43_n43.n5 w_n43_n43.n3 585
R1597 w_n43_n43.n3 w_n43_n43.n1 585
R1598 w_n43_n43.n382 w_n43_n43.n204 585
R1599 w_n43_n43.n289 w_n43_n43.n204 585
R1600 w_n43_n43.n381 w_n43_n43.n205 585
R1601 w_n43_n43.n290 w_n43_n43.n205 585
R1602 w_n43_n43.n380 w_n43_n43.n206 585
R1603 w_n43_n43.n291 w_n43_n43.n206 585
R1604 w_n43_n43.n292 w_n43_n43.n207 585
R1605 w_n43_n43.n293 w_n43_n43.n292 585
R1606 w_n43_n43.n374 w_n43_n43.n211 585
R1607 w_n43_n43.n294 w_n43_n43.n211 585
R1608 w_n43_n43.n373 w_n43_n43.n212 585
R1609 w_n43_n43.n295 w_n43_n43.n212 585
R1610 w_n43_n43.n372 w_n43_n43.n213 585
R1611 w_n43_n43.n296 w_n43_n43.n213 585
R1612 w_n43_n43.n297 w_n43_n43.n214 585
R1613 w_n43_n43.n298 w_n43_n43.n297 585
R1614 w_n43_n43.n366 w_n43_n43.n218 585
R1615 w_n43_n43.n299 w_n43_n43.n218 585
R1616 w_n43_n43.n365 w_n43_n43.n219 585
R1617 w_n43_n43.n300 w_n43_n43.n219 585
R1618 w_n43_n43.n364 w_n43_n43.n220 585
R1619 w_n43_n43.n301 w_n43_n43.n220 585
R1620 w_n43_n43.n302 w_n43_n43.n221 585
R1621 w_n43_n43.n303 w_n43_n43.n302 585
R1622 w_n43_n43.n358 w_n43_n43.n225 585
R1623 w_n43_n43.n304 w_n43_n43.n225 585
R1624 w_n43_n43.n357 w_n43_n43.n226 585
R1625 w_n43_n43.n305 w_n43_n43.n226 585
R1626 w_n43_n43.n356 w_n43_n43.n227 585
R1627 w_n43_n43.n306 w_n43_n43.n227 585
R1628 w_n43_n43.n307 w_n43_n43.n228 585
R1629 w_n43_n43.n308 w_n43_n43.n307 585
R1630 w_n43_n43.n350 w_n43_n43.n232 585
R1631 w_n43_n43.n309 w_n43_n43.n232 585
R1632 w_n43_n43.n349 w_n43_n43.n233 585
R1633 w_n43_n43.n310 w_n43_n43.n233 585
R1634 w_n43_n43.n348 w_n43_n43.n234 585
R1635 w_n43_n43.n311 w_n43_n43.n234 585
R1636 w_n43_n43.n312 w_n43_n43.n235 585
R1637 w_n43_n43.n313 w_n43_n43.n312 585
R1638 w_n43_n43.n342 w_n43_n43.n239 585
R1639 w_n43_n43.n314 w_n43_n43.n239 585
R1640 w_n43_n43.n341 w_n43_n43.n240 585
R1641 w_n43_n43.n315 w_n43_n43.n240 585
R1642 w_n43_n43.n340 w_n43_n43.n241 585
R1643 w_n43_n43.n316 w_n43_n43.n241 585
R1644 w_n43_n43.n317 w_n43_n43.n242 585
R1645 w_n43_n43.n318 w_n43_n43.n317 585
R1646 w_n43_n43.n334 w_n43_n43.n246 585
R1647 w_n43_n43.n319 w_n43_n43.n246 585
R1648 w_n43_n43.n333 w_n43_n43.n247 585
R1649 w_n43_n43.n320 w_n43_n43.n247 585
R1650 w_n43_n43.n332 w_n43_n43.n248 585
R1651 w_n43_n43.n321 w_n43_n43.n248 585
R1652 w_n43_n43.n261 w_n43_n43.n249 585
R1653 w_n43_n43.n322 w_n43_n43.n261 585
R1654 w_n43_n43.n325 w_n43_n43.n324 585
R1655 w_n43_n43.n324 w_n43_n43.n323 585
R1656 w_n43_n43.n288 w_n43_n43.n260 585
R1657 w_n43_n43.n287 w_n43_n43.n286 585
R1658 w_n43_n43.n285 w_n43_n43.n284 585
R1659 w_n43_n43.n283 w_n43_n43.n282 585
R1660 w_n43_n43.n281 w_n43_n43.n280 585
R1661 w_n43_n43.n279 w_n43_n43.n278 585
R1662 w_n43_n43.n277 w_n43_n43.n276 585
R1663 w_n43_n43.n275 w_n43_n43.n274 585
R1664 w_n43_n43.n273 w_n43_n43.n272 585
R1665 w_n43_n43.n271 w_n43_n43.n270 585
R1666 w_n43_n43.n269 w_n43_n43.n268 585
R1667 w_n43_n43.n267 w_n43_n43.n266 585
R1668 w_n43_n43.n265 w_n43_n43.n264 585
R1669 w_n43_n43.n263 w_n43_n43.n262 585
R1670 w_n43_n43.n252 w_n43_n43.n251 585
R1671 w_n43_n43.n328 w_n43_n43.n327 585
R1672 w_n43_n43.n324 w_n43_n43.n260 394
R1673 w_n43_n43.n286 w_n43_n43.n285 394
R1674 w_n43_n43.n282 w_n43_n43.n281 394
R1675 w_n43_n43.n278 w_n43_n43.n277 394
R1676 w_n43_n43.n274 w_n43_n43.n273 394
R1677 w_n43_n43.n270 w_n43_n43.n269 394
R1678 w_n43_n43.n266 w_n43_n43.n265 394
R1679 w_n43_n43.n262 w_n43_n43.n252 394
R1680 w_n43_n43.n261 w_n43_n43.n248 394
R1681 w_n43_n43.n248 w_n43_n43.n247 394
R1682 w_n43_n43.n247 w_n43_n43.n246 394
R1683 w_n43_n43.n317 w_n43_n43.n246 394
R1684 w_n43_n43.n317 w_n43_n43.n241 394
R1685 w_n43_n43.n241 w_n43_n43.n240 394
R1686 w_n43_n43.n240 w_n43_n43.n239 394
R1687 w_n43_n43.n312 w_n43_n43.n239 394
R1688 w_n43_n43.n312 w_n43_n43.n234 394
R1689 w_n43_n43.n234 w_n43_n43.n233 394
R1690 w_n43_n43.n233 w_n43_n43.n232 394
R1691 w_n43_n43.n307 w_n43_n43.n232 394
R1692 w_n43_n43.n307 w_n43_n43.n227 394
R1693 w_n43_n43.n227 w_n43_n43.n226 394
R1694 w_n43_n43.n226 w_n43_n43.n225 394
R1695 w_n43_n43.n302 w_n43_n43.n225 394
R1696 w_n43_n43.n302 w_n43_n43.n220 394
R1697 w_n43_n43.n220 w_n43_n43.n219 394
R1698 w_n43_n43.n219 w_n43_n43.n218 394
R1699 w_n43_n43.n297 w_n43_n43.n218 394
R1700 w_n43_n43.n297 w_n43_n43.n213 394
R1701 w_n43_n43.n213 w_n43_n43.n212 394
R1702 w_n43_n43.n212 w_n43_n43.n211 394
R1703 w_n43_n43.n292 w_n43_n43.n211 394
R1704 w_n43_n43.n292 w_n43_n43.n206 394
R1705 w_n43_n43.n206 w_n43_n43.n205 394
R1706 w_n43_n43.n205 w_n43_n43.n204 394
R1707 w_n43_n43.n204 w_n43_n43.n3 394
R1708 w_n43_n43.n389 w_n43_n43.n3 394
R1709 w_n43_n43.n389 w_n43_n43.n2 394
R1710 w_n43_n43.n197 w_n43_n43.n2 394
R1711 w_n43_n43.n197 w_n43_n43.n11 394
R1712 w_n43_n43.n193 w_n43_n43.n11 394
R1713 w_n43_n43.n193 w_n43_n43.n13 394
R1714 w_n43_n43.n185 w_n43_n43.n13 394
R1715 w_n43_n43.n185 w_n43_n43.n19 394
R1716 w_n43_n43.n181 w_n43_n43.n19 394
R1717 w_n43_n43.n181 w_n43_n43.n21 394
R1718 w_n43_n43.n173 w_n43_n43.n21 394
R1719 w_n43_n43.n173 w_n43_n43.n27 394
R1720 w_n43_n43.n169 w_n43_n43.n27 394
R1721 w_n43_n43.n169 w_n43_n43.n29 394
R1722 w_n43_n43.n161 w_n43_n43.n29 394
R1723 w_n43_n43.n161 w_n43_n43.n35 394
R1724 w_n43_n43.n157 w_n43_n43.n35 394
R1725 w_n43_n43.n157 w_n43_n43.n37 394
R1726 w_n43_n43.n149 w_n43_n43.n37 394
R1727 w_n43_n43.n149 w_n43_n43.n43 394
R1728 w_n43_n43.n145 w_n43_n43.n43 394
R1729 w_n43_n43.n145 w_n43_n43.n45 394
R1730 w_n43_n43.n137 w_n43_n43.n45 394
R1731 w_n43_n43.n137 w_n43_n43.n51 394
R1732 w_n43_n43.n133 w_n43_n43.n51 394
R1733 w_n43_n43.n133 w_n43_n43.n53 394
R1734 w_n43_n43.n125 w_n43_n43.n53 394
R1735 w_n43_n43.n125 w_n43_n43.n59 394
R1736 w_n43_n43.n121 w_n43_n43.n59 394
R1737 w_n43_n43.n121 w_n43_n43.n61 394
R1738 w_n43_n43.n113 w_n43_n43.n61 394
R1739 w_n43_n43.n113 w_n43_n43.n67 394
R1740 w_n43_n43.n78 w_n43_n43.n69 394
R1741 w_n43_n43.n82 w_n43_n43.n81 394
R1742 w_n43_n43.n86 w_n43_n43.n85 394
R1743 w_n43_n43.n90 w_n43_n43.n89 394
R1744 w_n43_n43.n94 w_n43_n43.n93 394
R1745 w_n43_n43.n98 w_n43_n43.n97 394
R1746 w_n43_n43.n102 w_n43_n43.n101 394
R1747 w_n43_n43.n106 w_n43_n43.n77 394
R1748 w_n43_n43.n331 w_n43_n43.n250 394
R1749 w_n43_n43.n331 w_n43_n43.n245 394
R1750 w_n43_n43.n335 w_n43_n43.n245 394
R1751 w_n43_n43.n335 w_n43_n43.n243 394
R1752 w_n43_n43.n339 w_n43_n43.n243 394
R1753 w_n43_n43.n339 w_n43_n43.n238 394
R1754 w_n43_n43.n343 w_n43_n43.n238 394
R1755 w_n43_n43.n343 w_n43_n43.n236 394
R1756 w_n43_n43.n347 w_n43_n43.n236 394
R1757 w_n43_n43.n347 w_n43_n43.n231 394
R1758 w_n43_n43.n351 w_n43_n43.n231 394
R1759 w_n43_n43.n351 w_n43_n43.n229 394
R1760 w_n43_n43.n355 w_n43_n43.n229 394
R1761 w_n43_n43.n355 w_n43_n43.n224 394
R1762 w_n43_n43.n359 w_n43_n43.n224 394
R1763 w_n43_n43.n359 w_n43_n43.n222 394
R1764 w_n43_n43.n363 w_n43_n43.n222 394
R1765 w_n43_n43.n363 w_n43_n43.n217 394
R1766 w_n43_n43.n367 w_n43_n43.n217 394
R1767 w_n43_n43.n367 w_n43_n43.n215 394
R1768 w_n43_n43.n371 w_n43_n43.n215 394
R1769 w_n43_n43.n371 w_n43_n43.n210 394
R1770 w_n43_n43.n375 w_n43_n43.n210 394
R1771 w_n43_n43.n375 w_n43_n43.n208 394
R1772 w_n43_n43.n379 w_n43_n43.n208 394
R1773 w_n43_n43.n379 w_n43_n43.n203 394
R1774 w_n43_n43.n383 w_n43_n43.n203 394
R1775 w_n43_n43.n383 w_n43_n43.n7 394
R1776 w_n43_n43.n387 w_n43_n43.n7 394
R1777 w_n43_n43.n387 w_n43_n43.n6 394
R1778 w_n43_n43.n199 w_n43_n43.n6 394
R1779 w_n43_n43.n199 w_n43_n43.n9 394
R1780 w_n43_n43.n191 w_n43_n43.n9 394
R1781 w_n43_n43.n191 w_n43_n43.n15 394
R1782 w_n43_n43.n187 w_n43_n43.n15 394
R1783 w_n43_n43.n187 w_n43_n43.n17 394
R1784 w_n43_n43.n179 w_n43_n43.n17 394
R1785 w_n43_n43.n179 w_n43_n43.n23 394
R1786 w_n43_n43.n175 w_n43_n43.n23 394
R1787 w_n43_n43.n175 w_n43_n43.n25 394
R1788 w_n43_n43.n167 w_n43_n43.n25 394
R1789 w_n43_n43.n167 w_n43_n43.n31 394
R1790 w_n43_n43.n163 w_n43_n43.n31 394
R1791 w_n43_n43.n163 w_n43_n43.n33 394
R1792 w_n43_n43.n155 w_n43_n43.n33 394
R1793 w_n43_n43.n155 w_n43_n43.n39 394
R1794 w_n43_n43.n151 w_n43_n43.n39 394
R1795 w_n43_n43.n151 w_n43_n43.n41 394
R1796 w_n43_n43.n143 w_n43_n43.n41 394
R1797 w_n43_n43.n143 w_n43_n43.n47 394
R1798 w_n43_n43.n139 w_n43_n43.n47 394
R1799 w_n43_n43.n139 w_n43_n43.n49 394
R1800 w_n43_n43.n131 w_n43_n43.n49 394
R1801 w_n43_n43.n131 w_n43_n43.n55 394
R1802 w_n43_n43.n127 w_n43_n43.n55 394
R1803 w_n43_n43.n127 w_n43_n43.n57 394
R1804 w_n43_n43.n119 w_n43_n43.n57 394
R1805 w_n43_n43.n119 w_n43_n43.n63 394
R1806 w_n43_n43.n115 w_n43_n43.n63 394
R1807 w_n43_n43.n115 w_n43_n43.n65 394
R1808 w_n43_n43.n325 w_n43_n43.n249 323.714
R1809 w_n43_n43.n107 w_n43_n43.n66 323.714
R1810 w_n43_n43.n107 w_n43_n43.n76 218.815
R1811 w_n43_n43.n107 w_n43_n43.n75 218.815
R1812 w_n43_n43.n107 w_n43_n43.n74 218.815
R1813 w_n43_n43.n107 w_n43_n43.n73 218.815
R1814 w_n43_n43.n107 w_n43_n43.n72 218.815
R1815 w_n43_n43.n107 w_n43_n43.n71 218.815
R1816 w_n43_n43.n107 w_n43_n43.n70 218.815
R1817 w_n43_n43.n108 w_n43_n43.n107 218.815
R1818 w_n43_n43.n325 w_n43_n43.n259 218.815
R1819 w_n43_n43.n325 w_n43_n43.n258 218.815
R1820 w_n43_n43.n325 w_n43_n43.n257 218.815
R1821 w_n43_n43.n325 w_n43_n43.n256 218.815
R1822 w_n43_n43.n325 w_n43_n43.n255 218.815
R1823 w_n43_n43.n325 w_n43_n43.n254 218.815
R1824 w_n43_n43.n325 w_n43_n43.n253 218.815
R1825 w_n43_n43.n326 w_n43_n43.n325 218.815
R1826 w_n43_n43.n332 w_n43_n43.n249 213.714
R1827 w_n43_n43.n333 w_n43_n43.n332 213.714
R1828 w_n43_n43.n334 w_n43_n43.n333 213.714
R1829 w_n43_n43.n334 w_n43_n43.n242 213.714
R1830 w_n43_n43.n340 w_n43_n43.n242 213.714
R1831 w_n43_n43.n341 w_n43_n43.n340 213.714
R1832 w_n43_n43.n342 w_n43_n43.n341 213.714
R1833 w_n43_n43.n342 w_n43_n43.n235 213.714
R1834 w_n43_n43.n348 w_n43_n43.n235 213.714
R1835 w_n43_n43.n349 w_n43_n43.n348 213.714
R1836 w_n43_n43.n350 w_n43_n43.n349 213.714
R1837 w_n43_n43.n350 w_n43_n43.n228 213.714
R1838 w_n43_n43.n356 w_n43_n43.n228 213.714
R1839 w_n43_n43.n357 w_n43_n43.n356 213.714
R1840 w_n43_n43.n358 w_n43_n43.n357 213.714
R1841 w_n43_n43.n358 w_n43_n43.n221 213.714
R1842 w_n43_n43.n364 w_n43_n43.n221 213.714
R1843 w_n43_n43.n365 w_n43_n43.n364 213.714
R1844 w_n43_n43.n366 w_n43_n43.n365 213.714
R1845 w_n43_n43.n366 w_n43_n43.n214 213.714
R1846 w_n43_n43.n372 w_n43_n43.n214 213.714
R1847 w_n43_n43.n373 w_n43_n43.n372 213.714
R1848 w_n43_n43.n374 w_n43_n43.n373 213.714
R1849 w_n43_n43.n374 w_n43_n43.n207 213.714
R1850 w_n43_n43.n380 w_n43_n43.n207 213.714
R1851 w_n43_n43.n381 w_n43_n43.n380 213.714
R1852 w_n43_n43.n382 w_n43_n43.n381 213.714
R1853 w_n43_n43.n382 w_n43_n43.n5 213.714
R1854 w_n43_n43.n388 w_n43_n43.n5 213.714
R1855 w_n43_n43.n388 w_n43_n43.n4 213.714
R1856 w_n43_n43.n198 w_n43_n43.n4 213.714
R1857 w_n43_n43.n198 w_n43_n43.n10 213.714
R1858 w_n43_n43.n192 w_n43_n43.n10 213.714
R1859 w_n43_n43.n192 w_n43_n43.n14 213.714
R1860 w_n43_n43.n186 w_n43_n43.n14 213.714
R1861 w_n43_n43.n186 w_n43_n43.n18 213.714
R1862 w_n43_n43.n180 w_n43_n43.n18 213.714
R1863 w_n43_n43.n180 w_n43_n43.n22 213.714
R1864 w_n43_n43.n174 w_n43_n43.n22 213.714
R1865 w_n43_n43.n174 w_n43_n43.n26 213.714
R1866 w_n43_n43.n168 w_n43_n43.n26 213.714
R1867 w_n43_n43.n168 w_n43_n43.n30 213.714
R1868 w_n43_n43.n162 w_n43_n43.n30 213.714
R1869 w_n43_n43.n162 w_n43_n43.n34 213.714
R1870 w_n43_n43.n156 w_n43_n43.n34 213.714
R1871 w_n43_n43.n156 w_n43_n43.n38 213.714
R1872 w_n43_n43.n150 w_n43_n43.n38 213.714
R1873 w_n43_n43.n150 w_n43_n43.n42 213.714
R1874 w_n43_n43.n144 w_n43_n43.n42 213.714
R1875 w_n43_n43.n144 w_n43_n43.n46 213.714
R1876 w_n43_n43.n138 w_n43_n43.n46 213.714
R1877 w_n43_n43.n138 w_n43_n43.n50 213.714
R1878 w_n43_n43.n132 w_n43_n43.n50 213.714
R1879 w_n43_n43.n132 w_n43_n43.n54 213.714
R1880 w_n43_n43.n126 w_n43_n43.n54 213.714
R1881 w_n43_n43.n126 w_n43_n43.n58 213.714
R1882 w_n43_n43.n120 w_n43_n43.n58 213.714
R1883 w_n43_n43.n120 w_n43_n43.n62 213.714
R1884 w_n43_n43.n114 w_n43_n43.n62 213.714
R1885 w_n43_n43.n114 w_n43_n43.n66 213.714
R1886 w_n43_n43.n77 w_n43_n43.n76 147.374
R1887 w_n43_n43.n101 w_n43_n43.n75 147.374
R1888 w_n43_n43.n97 w_n43_n43.n74 147.374
R1889 w_n43_n43.n93 w_n43_n43.n73 147.374
R1890 w_n43_n43.n89 w_n43_n43.n72 147.374
R1891 w_n43_n43.n85 w_n43_n43.n71 147.374
R1892 w_n43_n43.n81 w_n43_n43.n70 147.374
R1893 w_n43_n43.n108 w_n43_n43.n69 147.374
R1894 w_n43_n43.n260 w_n43_n43.n259 147.374
R1895 w_n43_n43.n285 w_n43_n43.n258 147.374
R1896 w_n43_n43.n281 w_n43_n43.n257 147.374
R1897 w_n43_n43.n277 w_n43_n43.n256 147.374
R1898 w_n43_n43.n273 w_n43_n43.n255 147.374
R1899 w_n43_n43.n269 w_n43_n43.n254 147.374
R1900 w_n43_n43.n265 w_n43_n43.n253 147.374
R1901 w_n43_n43.n326 w_n43_n43.n252 147.374
R1902 w_n43_n43.n286 w_n43_n43.n259 147.374
R1903 w_n43_n43.n282 w_n43_n43.n258 147.374
R1904 w_n43_n43.n278 w_n43_n43.n257 147.374
R1905 w_n43_n43.n274 w_n43_n43.n256 147.374
R1906 w_n43_n43.n270 w_n43_n43.n255 147.374
R1907 w_n43_n43.n266 w_n43_n43.n254 147.374
R1908 w_n43_n43.n262 w_n43_n43.n253 147.374
R1909 w_n43_n43.n327 w_n43_n43.n326 147.374
R1910 w_n43_n43.n109 w_n43_n43.n108 147.374
R1911 w_n43_n43.n78 w_n43_n43.n70 147.374
R1912 w_n43_n43.n82 w_n43_n43.n71 147.374
R1913 w_n43_n43.n86 w_n43_n43.n72 147.374
R1914 w_n43_n43.n90 w_n43_n43.n73 147.374
R1915 w_n43_n43.n94 w_n43_n43.n74 147.374
R1916 w_n43_n43.n98 w_n43_n43.n75 147.374
R1917 w_n43_n43.n102 w_n43_n43.n76 147.374
R1918 w_n43_n43.n325 B 135.143
R1919 w_n43_n43.n323 w_n43_n43.n322 74.9181
R1920 w_n43_n43.n111 w_n43_n43.n110 74.9181
R1921 w_n43_n43.n329 w_n43_n43.n328 74.9181
R1922 w_n43_n43.n105 w_n43_n43.n64 74.9181
R1923 w_n43_n43.n323 w_n43_n43.n288 25.6005
R1924 w_n43_n43.n288 w_n43_n43.n287 25.6005
R1925 w_n43_n43.n287 w_n43_n43.n284 25.6005
R1926 w_n43_n43.n284 w_n43_n43.n283 25.6005
R1927 w_n43_n43.n283 w_n43_n43.n280 25.6005
R1928 w_n43_n43.n280 w_n43_n43.n279 25.6005
R1929 w_n43_n43.n279 w_n43_n43.n276 25.6005
R1930 w_n43_n43.n276 w_n43_n43.n275 25.6005
R1931 w_n43_n43.n275 w_n43_n43.n272 25.6005
R1932 w_n43_n43.n272 w_n43_n43.n271 25.6005
R1933 w_n43_n43.n271 w_n43_n43.n268 25.6005
R1934 w_n43_n43.n268 w_n43_n43.n267 25.6005
R1935 w_n43_n43.n267 w_n43_n43.n264 25.6005
R1936 w_n43_n43.n264 w_n43_n43.n263 25.6005
R1937 w_n43_n43.n263 w_n43_n43.n251 25.6005
R1938 w_n43_n43.n328 w_n43_n43.n251 25.6005
R1939 w_n43_n43.n322 w_n43_n43.n321 25.6005
R1940 w_n43_n43.n321 w_n43_n43.n320 25.6005
R1941 w_n43_n43.n320 w_n43_n43.n319 25.6005
R1942 w_n43_n43.n319 w_n43_n43.n318 25.6005
R1943 w_n43_n43.n318 w_n43_n43.n316 25.6005
R1944 w_n43_n43.n316 w_n43_n43.n315 25.6005
R1945 w_n43_n43.n315 w_n43_n43.n314 25.6005
R1946 w_n43_n43.n314 w_n43_n43.n313 25.6005
R1947 w_n43_n43.n313 w_n43_n43.n311 25.6005
R1948 w_n43_n43.n311 w_n43_n43.n310 25.6005
R1949 w_n43_n43.n310 w_n43_n43.n309 25.6005
R1950 w_n43_n43.n309 w_n43_n43.n308 25.6005
R1951 w_n43_n43.n308 w_n43_n43.n306 25.6005
R1952 w_n43_n43.n306 w_n43_n43.n305 25.6005
R1953 w_n43_n43.n305 w_n43_n43.n304 25.6005
R1954 w_n43_n43.n304 w_n43_n43.n303 25.6005
R1955 w_n43_n43.n303 w_n43_n43.n301 25.6005
R1956 w_n43_n43.n301 w_n43_n43.n300 25.6005
R1957 w_n43_n43.n300 w_n43_n43.n299 25.6005
R1958 w_n43_n43.n299 w_n43_n43.n298 25.6005
R1959 w_n43_n43.n298 w_n43_n43.n296 25.6005
R1960 w_n43_n43.n296 w_n43_n43.n295 25.6005
R1961 w_n43_n43.n295 w_n43_n43.n294 25.6005
R1962 w_n43_n43.n294 w_n43_n43.n293 25.6005
R1963 w_n43_n43.n293 w_n43_n43.n291 25.6005
R1964 w_n43_n43.n291 w_n43_n43.n290 25.6005
R1965 w_n43_n43.n290 w_n43_n43.n289 25.6005
R1966 w_n43_n43.n289 w_n43_n43.n1 25.6005
R1967 w_n43_n43.n390 w_n43_n43.n1 25.6005
R1968 w_n43_n43.n196 w_n43_n43.n0 25.6005
R1969 w_n43_n43.n196 w_n43_n43.n195 25.6005
R1970 w_n43_n43.n195 w_n43_n43.n194 25.6005
R1971 w_n43_n43.n194 w_n43_n43.n12 25.6005
R1972 w_n43_n43.n184 w_n43_n43.n12 25.6005
R1973 w_n43_n43.n184 w_n43_n43.n183 25.6005
R1974 w_n43_n43.n183 w_n43_n43.n182 25.6005
R1975 w_n43_n43.n182 w_n43_n43.n20 25.6005
R1976 w_n43_n43.n172 w_n43_n43.n20 25.6005
R1977 w_n43_n43.n172 w_n43_n43.n171 25.6005
R1978 w_n43_n43.n171 w_n43_n43.n170 25.6005
R1979 w_n43_n43.n170 w_n43_n43.n28 25.6005
R1980 w_n43_n43.n160 w_n43_n43.n28 25.6005
R1981 w_n43_n43.n160 w_n43_n43.n159 25.6005
R1982 w_n43_n43.n159 w_n43_n43.n158 25.6005
R1983 w_n43_n43.n158 w_n43_n43.n36 25.6005
R1984 w_n43_n43.n148 w_n43_n43.n36 25.6005
R1985 w_n43_n43.n148 w_n43_n43.n147 25.6005
R1986 w_n43_n43.n147 w_n43_n43.n146 25.6005
R1987 w_n43_n43.n146 w_n43_n43.n44 25.6005
R1988 w_n43_n43.n136 w_n43_n43.n44 25.6005
R1989 w_n43_n43.n136 w_n43_n43.n135 25.6005
R1990 w_n43_n43.n135 w_n43_n43.n134 25.6005
R1991 w_n43_n43.n134 w_n43_n43.n52 25.6005
R1992 w_n43_n43.n124 w_n43_n43.n52 25.6005
R1993 w_n43_n43.n124 w_n43_n43.n123 25.6005
R1994 w_n43_n43.n123 w_n43_n43.n122 25.6005
R1995 w_n43_n43.n122 w_n43_n43.n60 25.6005
R1996 w_n43_n43.n112 w_n43_n43.n60 25.6005
R1997 w_n43_n43.n112 w_n43_n43.n111 25.6005
R1998 w_n43_n43.n110 w_n43_n43.n68 25.6005
R1999 w_n43_n43.n79 w_n43_n43.n68 25.6005
R2000 w_n43_n43.n80 w_n43_n43.n79 25.6005
R2001 w_n43_n43.n83 w_n43_n43.n80 25.6005
R2002 w_n43_n43.n84 w_n43_n43.n83 25.6005
R2003 w_n43_n43.n87 w_n43_n43.n84 25.6005
R2004 w_n43_n43.n88 w_n43_n43.n87 25.6005
R2005 w_n43_n43.n91 w_n43_n43.n88 25.6005
R2006 w_n43_n43.n92 w_n43_n43.n91 25.6005
R2007 w_n43_n43.n95 w_n43_n43.n92 25.6005
R2008 w_n43_n43.n96 w_n43_n43.n95 25.6005
R2009 w_n43_n43.n99 w_n43_n43.n96 25.6005
R2010 w_n43_n43.n100 w_n43_n43.n99 25.6005
R2011 w_n43_n43.n103 w_n43_n43.n100 25.6005
R2012 w_n43_n43.n104 w_n43_n43.n103 25.6005
R2013 w_n43_n43.n105 w_n43_n43.n104 25.6005
R2014 w_n43_n43.n330 w_n43_n43.n329 25.6005
R2015 w_n43_n43.n330 w_n43_n43.n244 25.6005
R2016 w_n43_n43.n336 w_n43_n43.n244 25.6005
R2017 w_n43_n43.n337 w_n43_n43.n336 25.6005
R2018 w_n43_n43.n338 w_n43_n43.n337 25.6005
R2019 w_n43_n43.n338 w_n43_n43.n237 25.6005
R2020 w_n43_n43.n344 w_n43_n43.n237 25.6005
R2021 w_n43_n43.n345 w_n43_n43.n344 25.6005
R2022 w_n43_n43.n346 w_n43_n43.n345 25.6005
R2023 w_n43_n43.n346 w_n43_n43.n230 25.6005
R2024 w_n43_n43.n352 w_n43_n43.n230 25.6005
R2025 w_n43_n43.n353 w_n43_n43.n352 25.6005
R2026 w_n43_n43.n354 w_n43_n43.n353 25.6005
R2027 w_n43_n43.n354 w_n43_n43.n223 25.6005
R2028 w_n43_n43.n360 w_n43_n43.n223 25.6005
R2029 w_n43_n43.n361 w_n43_n43.n360 25.6005
R2030 w_n43_n43.n362 w_n43_n43.n361 25.6005
R2031 w_n43_n43.n362 w_n43_n43.n216 25.6005
R2032 w_n43_n43.n368 w_n43_n43.n216 25.6005
R2033 w_n43_n43.n369 w_n43_n43.n368 25.6005
R2034 w_n43_n43.n370 w_n43_n43.n369 25.6005
R2035 w_n43_n43.n370 w_n43_n43.n209 25.6005
R2036 w_n43_n43.n376 w_n43_n43.n209 25.6005
R2037 w_n43_n43.n377 w_n43_n43.n376 25.6005
R2038 w_n43_n43.n378 w_n43_n43.n377 25.6005
R2039 w_n43_n43.n378 w_n43_n43.n202 25.6005
R2040 w_n43_n43.n384 w_n43_n43.n202 25.6005
R2041 w_n43_n43.n385 w_n43_n43.n384 25.6005
R2042 w_n43_n43.n386 w_n43_n43.n385 25.6005
R2043 w_n43_n43.n386 w_n43_n43.n201 25.6005
R2044 w_n43_n43.n201 w_n43_n43.n200 25.6005
R2045 w_n43_n43.n200 w_n43_n43.n8 25.6005
R2046 w_n43_n43.n190 w_n43_n43.n8 25.6005
R2047 w_n43_n43.n190 w_n43_n43.n189 25.6005
R2048 w_n43_n43.n189 w_n43_n43.n188 25.6005
R2049 w_n43_n43.n188 w_n43_n43.n16 25.6005
R2050 w_n43_n43.n178 w_n43_n43.n16 25.6005
R2051 w_n43_n43.n178 w_n43_n43.n177 25.6005
R2052 w_n43_n43.n177 w_n43_n43.n176 25.6005
R2053 w_n43_n43.n176 w_n43_n43.n24 25.6005
R2054 w_n43_n43.n166 w_n43_n43.n24 25.6005
R2055 w_n43_n43.n166 w_n43_n43.n165 25.6005
R2056 w_n43_n43.n165 w_n43_n43.n164 25.6005
R2057 w_n43_n43.n164 w_n43_n43.n32 25.6005
R2058 w_n43_n43.n154 w_n43_n43.n32 25.6005
R2059 w_n43_n43.n154 w_n43_n43.n153 25.6005
R2060 w_n43_n43.n153 w_n43_n43.n152 25.6005
R2061 w_n43_n43.n152 w_n43_n43.n40 25.6005
R2062 w_n43_n43.n142 w_n43_n43.n40 25.6005
R2063 w_n43_n43.n142 w_n43_n43.n141 25.6005
R2064 w_n43_n43.n141 w_n43_n43.n140 25.6005
R2065 w_n43_n43.n140 w_n43_n43.n48 25.6005
R2066 w_n43_n43.n130 w_n43_n43.n48 25.6005
R2067 w_n43_n43.n130 w_n43_n43.n129 25.6005
R2068 w_n43_n43.n129 w_n43_n43.n128 25.6005
R2069 w_n43_n43.n128 w_n43_n43.n56 25.6005
R2070 w_n43_n43.n118 w_n43_n43.n56 25.6005
R2071 w_n43_n43.n118 w_n43_n43.n117 25.6005
R2072 w_n43_n43.n117 w_n43_n43.n116 25.6005
R2073 w_n43_n43.n116 w_n43_n43.n64 25.6005
R2074 B w_n43_n43.n390 19.2005
R2075 B w_n43_n43.n0 6.4005
C2 B.n0 B 0 ; **FLOATING
C3 B.n9 B 0 ; **FLOATING
C4 B.n10 B 0 ; **FLOATING
C5 B.n11 B 0 ; **FLOATING
C6 B.n12 B 0 ; **FLOATING
C7 B.n13 B 0 ; **FLOATING
C8 B.n14 B 0 ; **FLOATING
C9 B.n15 B 0 ; **FLOATING
C10 B.n16 B 0 ; **FLOATING
C11 B.n17 B 0 ; **FLOATING
C12 B.n18 B 0 ; **FLOATING
C13 B.n19 B 0 ; **FLOATING
C14 B.n20 B 0 ; **FLOATING
C15 B.n21 B 0 ; **FLOATING
C16 B.n22 B 0 ; **FLOATING
C17 B.n23 B 0 ; **FLOATING
C18 B.n24 B 0 ; **FLOATING
C19 B.n25 B 0 ; **FLOATING
C20 B.n26 B 0 ; **FLOATING
C21 B.n27 B 0 ; **FLOATING
C22 B.n28 B 0 ; **FLOATING
C23 B.n29 B 0 ; **FLOATING
C24 B.n30 B 0 ; **FLOATING
C25 B.n31 B 0 ; **FLOATING
C26 B.n32 B 0 ; **FLOATING
C27 B.n33 B 0 ; **FLOATING
C28 B.n34 B 0 ; **FLOATING
C29 B.n35 B 0 ; **FLOATING
C30 B.n36 B 0 ; **FLOATING
C31 B.n37 B 0 ; **FLOATING
C32 B.n38 B 0 ; **FLOATING
C33 B.n39 B 0 ; **FLOATING
C34 B.n40 B 0 ; **FLOATING
C35 B.n41 B 0 ; **FLOATING
C36 B.n42 B 0 ; **FLOATING
C37 B.n43 B 0 ; **FLOATING
C38 B.n44 B 0 ; **FLOATING
C39 B.n45 B 0 ; **FLOATING
C40 B.n46 B 0 ; **FLOATING
C41 B.n47 B 0 ; **FLOATING
C42 B.n48 B 0 ; **FLOATING
C43 B.n49 B 0 ; **FLOATING
C44 B.n50 B 0 ; **FLOATING
C45 B.n51 B 0 ; **FLOATING
C46 B.n52 B 0 ; **FLOATING
C47 B.n53 B 0 ; **FLOATING
C48 B.n54 B 0 ; **FLOATING
C49 B.n55 B 0 ; **FLOATING
C50 B.n56 B 0 ; **FLOATING
C51 B.n57 B 0 ; **FLOATING
C52 B.n58 B 0 ; **FLOATING
C53 B.n59 B 0 ; **FLOATING
C54 B.n60 B 0 ; **FLOATING
C55 B.n61 B 0 ; **FLOATING
C56 B.n62 B 0 ; **FLOATING
C57 B.n63 B 0 ; **FLOATING
C58 B.n64 B 0 ; **FLOATING
C59 B.n65 B 0 ; **FLOATING
C60 B.n66 B 0 ; **FLOATING
C61 B.n67 B 0 ; **FLOATING
C62 B.n68 B 0 ; **FLOATING
C63 B.n69 B 0 ; **FLOATING
C64 B.n70 B 0 ; **FLOATING
C65 B.n71 B 0 ; **FLOATING
C66 B.n72 B 0 ; **FLOATING
C67 B.n73 B 0 ; **FLOATING
C68 B.n74 B 0 ; **FLOATING
C69 B.n75 B 0 ; **FLOATING
C70 B.n76 B 0 ; **FLOATING
C71 B.n77 B 0 ; **FLOATING
C72 B.n78 B 0 ; **FLOATING
C73 B.n79 B 0 ; **FLOATING
C74 B.n80 B 0 ; **FLOATING
C75 B.n81 B 0 ; **FLOATING
C76 B.n82 B 0 ; **FLOATING
C77 B.n83 B 0 ; **FLOATING
C78 B.n84 B 0 ; **FLOATING
C79 B.n85 B 0 ; **FLOATING
C80 B.n86 B 0 ; **FLOATING
C81 B.n87 B 0 ; **FLOATING
C82 B.n88 B 0 ; **FLOATING
C83 B.n89 B 0 ; **FLOATING
C84 B.n90 B 0 ; **FLOATING
C85 B.n91 B 0 ; **FLOATING
C86 B.n92 B 0 ; **FLOATING
C87 B.n93 B 0 ; **FLOATING
C88 B.n94 B 0 ; **FLOATING
C89 B.n95 B 0 ; **FLOATING
C90 B.n96 B 0 ; **FLOATING
C91 B.n97 B 0 ; **FLOATING
C92 B.n98 B 0 ; **FLOATING
C93 B.n99 B 0 ; **FLOATING
C94 B.n100 B 0 ; **FLOATING
C95 B.n101 B 0 ; **FLOATING
C96 B.n102 B 0 ; **FLOATING
C97 B.n103 B 0 ; **FLOATING
C98 B.n104 B 0 ; **FLOATING
C99 B.n105 B 0 ; **FLOATING
C100 B.n106 B 0 ; **FLOATING
C101 B.n107 B 0 ; **FLOATING
C102 B.n108 B 0 ; **FLOATING
C103 B.n109 B 0 ; **FLOATING
C104 B.n110 B 0 ; **FLOATING
C105 B.n111 B 0 ; **FLOATING
C106 B.n112 B 0 ; **FLOATING
C107 B.n113 B 0 ; **FLOATING
C108 B.n114 B 0 ; **FLOATING
C109 B.n115 B 0 ; **FLOATING
C110 B.n116 B 0 ; **FLOATING
C111 B.n117 B 0 ; **FLOATING
C112 B.n118 B 0 ; **FLOATING
C113 B.n119 B 0 ; **FLOATING
C114 B.n120 B 0 ; **FLOATING
C115 B.n121 B 0 ; **FLOATING
C116 B.n122 B 0 ; **FLOATING
C117 B.n123 B 0 ; **FLOATING
C118 B.n124 B 0 ; **FLOATING
C119 B.n125 B 0 ; **FLOATING
C120 B.n126 B 0 ; **FLOATING
C121 B.n127 B 0 ; **FLOATING
C122 B.n128 B 0 ; **FLOATING
C123 B.n129 B 0 ; **FLOATING
C124 B.n130 B 0 ; **FLOATING
C125 B.n131 B 0 ; **FLOATING
C126 B.n132 B 0 ; **FLOATING
C127 B.n133 B 0 ; **FLOATING
C128 B.n136 B 0 ; **FLOATING
C129 B.n140 B 0 ; **FLOATING
C130 B.n142 B 0 ; **FLOATING
C131 B.n143 B 0 ; **FLOATING
C132 B.n144 B 0 ; **FLOATING
C133 B.n145 B 0 ; **FLOATING
C134 B.n146 B 0 ; **FLOATING
C135 B.n147 B 0 ; **FLOATING
C136 B.n148 B 0 ; **FLOATING
C137 B.n149 B 0 ; **FLOATING
C138 B.n150 B 0 ; **FLOATING
C139 B.n151 B 0 ; **FLOATING
C140 B.n152 B 0 ; **FLOATING
C141 B.n153 B 0 ; **FLOATING
C142 B.n154 B 0 ; **FLOATING
C143 B.n155 B 0 ; **FLOATING
C144 B.n156 B 0 ; **FLOATING
C145 B.n157 B 0 ; **FLOATING
C146 B.n158 B 0 ; **FLOATING
C147 B.n159 B 0 ; **FLOATING
C148 B.n160 B 0 ; **FLOATING
C149 B.n161 B 0 ; **FLOATING
C150 B.n162 B 0 ; **FLOATING
C151 B.n163 B 0 ; **FLOATING
C152 B.n164 B 0 ; **FLOATING
C153 B.n165 B 0 ; **FLOATING
C154 B.n166 B 0 ; **FLOATING
C155 B.n167 B 0 ; **FLOATING
C156 B.n168 B 0 ; **FLOATING
C157 B.n169 B 0 ; **FLOATING
C158 B.n171 B 0 ; **FLOATING
C159 B.n172 B 0 ; **FLOATING
C160 B.n173 B 0 ; **FLOATING
C161 B.n174 B 0 ; **FLOATING
C162 B.n175 B 0 ; **FLOATING
C163 B.n176 B 0 ; **FLOATING
C164 B.n177 B 0 ; **FLOATING
C165 B.n178 B 0 ; **FLOATING
C166 B.n179 B 0 ; **FLOATING
C167 B.n180 B 0 ; **FLOATING
C168 B.n181 B 0 ; **FLOATING
C169 B.n182 B 0 ; **FLOATING
C170 B.n183 B 0 ; **FLOATING
C171 B.n184 B 0 ; **FLOATING
C172 B.n185 B 0 ; **FLOATING
C173 B.n186 B 0 ; **FLOATING
C174 B.n187 B 0 ; **FLOATING
C175 B.n188 B 0 ; **FLOATING
C176 B.n189 B 0 ; **FLOATING
C177 B.n190 B 0 ; **FLOATING
C178 B.n191 B 0 ; **FLOATING
C179 B.n192 B 0 ; **FLOATING
C180 B.n193 B 0 ; **FLOATING
C181 B.n194 B 0 ; **FLOATING
C182 B.n195 B 0 ; **FLOATING
C183 B.n196 B 0 ; **FLOATING
C184 B.n197 B 0 ; **FLOATING
C185 B.n198 B 0 ; **FLOATING
C186 B.n199 B 0 ; **FLOATING
C187 B.n200 B 0 ; **FLOATING
C188 B.n201 B 0 ; **FLOATING
C189 B.n202 B 0 ; **FLOATING
C190 B.n203 B 0 ; **FLOATING
C191 B.n204 B 0 ; **FLOATING
C192 B.n205 B 0 ; **FLOATING
C193 B.n206 B 0 ; **FLOATING
C194 B.n207 B 0 ; **FLOATING
C195 B.n208 B 0 ; **FLOATING
C196 B.n209 B 0 ; **FLOATING
C197 B.n210 B 0 ; **FLOATING
C198 B.n211 B 0 ; **FLOATING
C199 B.n212 B 0 ; **FLOATING
C200 B.n213 B 0 ; **FLOATING
C201 B.n214 B 0 ; **FLOATING
C202 B.n215 B 0 ; **FLOATING
C203 B.n216 B 0 ; **FLOATING
C204 B.n217 B 0 ; **FLOATING
C205 B.n218 B 0 ; **FLOATING
C206 B.n219 B 0 ; **FLOATING
C207 B.n220 B 0 ; **FLOATING
C208 B.n221 B 0 ; **FLOATING
C209 B.n222 B 0 ; **FLOATING
C210 B.n223 B 0 ; **FLOATING
C211 B.n224 B 0 ; **FLOATING
C212 B.n225 B 0 ; **FLOATING
C213 B.n226 B 0 ; **FLOATING
C214 B.n227 B 0 ; **FLOATING
C215 B.n228 B 0 ; **FLOATING
C216 B.n229 B 0 ; **FLOATING
C217 B.n230 B 0 ; **FLOATING
C218 B.n231 B 0 ; **FLOATING
C219 B.n232 B 0 ; **FLOATING
C220 B.n233 B 0 ; **FLOATING
C221 B.n234 B 0 ; **FLOATING
C222 B.n235 B 0 ; **FLOATING
C223 B.n236 B 0 ; **FLOATING
C224 B.n237 B 0 ; **FLOATING
C225 B.n238 B 0 ; **FLOATING
C226 B.n239 B 0 ; **FLOATING
C227 B.n240 B 0 ; **FLOATING
C228 B.n241 B 0 ; **FLOATING
C229 B.n242 B 0 ; **FLOATING
C230 B.n243 B 0 ; **FLOATING
C231 B.n244 B 0 ; **FLOATING
C232 B.n245 B 0 ; **FLOATING
C233 B.n246 B 0 ; **FLOATING
C234 B.n247 B 0 ; **FLOATING
C235 B.n248 B 0 ; **FLOATING
C236 B.n249 B 0 ; **FLOATING
C237 B.n250 B 0 ; **FLOATING
C238 B.n251 B 0 ; **FLOATING
C239 B.n252 B 0 ; **FLOATING
C240 B.n253 B 0 ; **FLOATING
C241 B.n254 B 0 ; **FLOATING
C242 B.n255 B 0 ; **FLOATING
C243 B.n256 B 0 ; **FLOATING
C244 B.n257 B 0 ; **FLOATING
C245 B.n258 B 0 ; **FLOATING
C246 B.n259 B 0 ; **FLOATING
C247 B.n260 B 0 ; **FLOATING
C248 B.n261 B 0 ; **FLOATING
C249 B.n262 B 0 ; **FLOATING
C250 B.n263 B 0 ; **FLOATING
C251 B.n264 B 0 ; **FLOATING
C252 B.n265 B 0 ; **FLOATING
C253 B.n266 B 0 ; **FLOATING
C254 B.n267 B 0 ; **FLOATING
C255 B.n268 B 0 ; **FLOATING
C256 B.n269 B 0 ; **FLOATING
C257 B.n270 B 0 ; **FLOATING
C258 B.n271 B 0 ; **FLOATING
C259 B.n272 B 0 ; **FLOATING
C260 B.n273 B 0 ; **FLOATING
C261 B.n274 B 0 ; **FLOATING
C262 B.n275 B 0 ; **FLOATING
C263 B.n276 B 0 ; **FLOATING
C264 B.n277 B 0 ; **FLOATING
C265 B.n278 B 0 ; **FLOATING
C266 B.n279 B 0 ; **FLOATING
C267 B.n280 B 0 ; **FLOATING
C268 B.n281 B 0 ; **FLOATING
C269 B.n282 B 0 ; **FLOATING
C270 B.n283 B 0 ; **FLOATING
C271 B.n284 B 0 ; **FLOATING
C272 B.n285 B 0 ; **FLOATING
C273 B.n286 B 0 ; **FLOATING
C274 B.n287 B 0 ; **FLOATING
C275 B.n288 B 0 ; **FLOATING
C276 B.n289 B 0 ; **FLOATING
C277 B.n290 B 0 ; **FLOATING
C278 B.n291 B 0 ; **FLOATING
C279 B.n292 B 0 ; **FLOATING
C280 B.n293 B 0 ; **FLOATING
C281 B.n294 B 0 ; **FLOATING
C282 B.n295 B 0 ; **FLOATING
C283 B.n296 B 0 ; **FLOATING
C284 B.n297 B 0 ; **FLOATING
C285 B.n298 B 0 ; **FLOATING
C286 B.n299 B 0 ; **FLOATING
C287 B.n300 B 0 ; **FLOATING
C288 B.n301 B 0 ; **FLOATING
C289 B.n302 B 0 ; **FLOATING
C290 B.n303 B 0 ; **FLOATING
C291 B.n304 B 0 ; **FLOATING
C292 B.n305 B 0 ; **FLOATING
C293 B.n306 B 0 ; **FLOATING
C294 B.n307 B 0 ; **FLOATING
C295 B.n308 B 0 ; **FLOATING
C296 B.n309 B 0 ; **FLOATING
C297 B.n310 B 0 ; **FLOATING
C298 B.n311 B 0 ; **FLOATING
C299 B.n312 B 0 ; **FLOATING
C300 B.n313 B 0 ; **FLOATING
C301 B.n314 B 0 ; **FLOATING
C302 B.n315 B 0 ; **FLOATING
C303 B.n316 B 0 ; **FLOATING
C304 B.n317 B 0 ; **FLOATING
C305 B.n318 B 0 ; **FLOATING
C306 B.n319 B 0 ; **FLOATING
C307 B.n320 B 0 ; **FLOATING
C308 B.n321 B 0 ; **FLOATING
C309 B.n322 B 0 ; **FLOATING
C310 B.n323 B 0 ; **FLOATING
C311 B.n324 B 0 ; **FLOATING
C312 B.n325 B 0 ; **FLOATING
C313 B.n326 B 0 ; **FLOATING
C314 B.n327 B 0 ; **FLOATING
C315 B.n328 B 0 ; **FLOATING
C316 B.n329 B 0 ; **FLOATING
C317 B.n330 B 0 ; **FLOATING
C318 B.n331 B 0 ; **FLOATING
C319 B.n332 B 0 ; **FLOATING
C320 B.n333 B 0 ; **FLOATING
C321 B.n334 B 0 ; **FLOATING
C322 B.n335 B 0 ; **FLOATING
C323 B.n336 B 0 ; **FLOATING
C324 B.n337 B 0 ; **FLOATING
C325 B.n338 B 0 ; **FLOATING
C326 B.n339 B 0 ; **FLOATING
C327 B.n340 B 0 ; **FLOATING
C328 B.n341 B 0 ; **FLOATING
C329 B.n342 B 0 ; **FLOATING
C330 B.n343 B 0 ; **FLOATING
C331 B.n344 B 0 ; **FLOATING
C332 B.n345 B 0 ; **FLOATING
C333 B.n346 B 0 ; **FLOATING
C334 B.n347 B 0 ; **FLOATING
C335 B.n348 B 0 ; **FLOATING
C336 B.n349 B 0 ; **FLOATING
C337 B.n350 B 0 ; **FLOATING
C338 B.n351 B 0 ; **FLOATING
C339 B.n352 B 0 ; **FLOATING
C340 B.n353 B 0 ; **FLOATING
C341 B.n354 B 0 ; **FLOATING
C342 B.n355 B 0 ; **FLOATING
C343 B.n356 B 0 ; **FLOATING
C344 B.n357 B 0 ; **FLOATING
C345 B.n358 B 0 ; **FLOATING
C346 B.n359 B 0 ; **FLOATING
C347 B.n360 B 0 ; **FLOATING
C348 B.n361 B 0 ; **FLOATING
C349 B.n362 B 0 ; **FLOATING
C350 B.n363 B 0 ; **FLOATING
C351 B.n364 B 0 ; **FLOATING
C352 B.n365 B 0 ; **FLOATING
C353 B.n366 B 0 ; **FLOATING
C354 B.n367 B 0 ; **FLOATING
C355 B.n368 B 0 ; **FLOATING
C356 B.n369 B 0 ; **FLOATING
C357 B.n370 B 0 ; **FLOATING
C358 B.n371 B 0 ; **FLOATING
C359 B.n372 B 0 ; **FLOATING
C360 B.n373 B 0 ; **FLOATING
C361 B.n374 B 0 ; **FLOATING
C362 B.n375 B 0 ; **FLOATING
C363 B.n376 B 0 ; **FLOATING
C364 B.n377 B 0 ; **FLOATING
C365 B.n378 B 0 ; **FLOATING
C366 B.n379 B 0 ; **FLOATING
C367 B.n380 B 0 ; **FLOATING
C368 B.n381 B 0 ; **FLOATING
C369 B.n382 B 0 ; **FLOATING
C370 B.n383 B 0 ; **FLOATING
C371 B.n384 B 0 ; **FLOATING
C372 B.n385 B 0 ; **FLOATING
C373 B.n386 B 0 ; **FLOATING
C374 B.n387 B 0 ; **FLOATING
C375 B.n388 B 0 ; **FLOATING
C376 B.n389 B 0 ; **FLOATING
C377 S B 0.95483f
C378 D B 0.95483f
C379 G B 8.56948f
C380 nfet_01v8_lvt_W5_L20_m2__nf1_gboth_sdfull_pc/D.n0 B 0.02265f ; **FLOATING
C381 nfet_01v8_lvt_W5_L20_m2__nf1_gboth_sdfull_pc/D.t0 B 0.0298f ; **FLOATING
C382 nfet_01v8_lvt_W5_L20_m2__nf1_gboth_sdfull_pc/D.n1 B 0.02616f ; **FLOATING
C383 nfet_01v8_lvt_W5_L20_m2__nf1_gboth_sdfull_pc/S.n0 B 0.02265f ; **FLOATING
C384 nfet_01v8_lvt_W5_L20_m2__nf1_gboth_sdfull_pc/S.t0 B 0.0298f ; **FLOATING
C385 nfet_01v8_lvt_W5_L20_m2__nf1_gboth_sdfull_pc/S.n1 B 0.02616f ; **FLOATING
