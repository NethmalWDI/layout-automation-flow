* NGSPICE file created from pfet_01v8_lvt_W90p63_L0p74_m1__nf1_gtop_sdfull.ext - technology: sky130A

.subckt sky130_fd_pr__pfet_01v8_lvt_XK4R5N G D B S
X0 S G D B sky130_fd_pr__pfet_01v8_lvt ad=26.2827 pd=181.84 as=26.2827 ps=181.84 w=90.63 l=0.74
.ends

.subckt pfet_01v8_lvt_W90p63_L0p74_m1__nf1_gtop_sdfull D S G B
Xpfet_01v8_lvt_W90p63_L0p74_m1__nf1_gtop_sdfull_pc G D B S sky130_fd_pr__pfet_01v8_lvt_XK4R5N
.ends
