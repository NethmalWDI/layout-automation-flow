* NGSPICE file created from pfet_01v8_lvt_W37p3_L0p74_m1__nf4_gboth_sdhalf_outS_ng.ext - technology: sky130A

.subckt pfet_01v8_lvt_W37p3_L0p74_m1__nf4_gboth_sdhalf_outS_ng S D G B
X0 D G S B sky130_fd_pr__pfet_01v8_lvt ad=1.35285 pd=9.62 as=1.35285 ps=9.62 w=9.33 l=0.74
X1 S G D B sky130_fd_pr__pfet_01v8_lvt ad=1.35285 pd=9.62 as=1.35285 ps=9.62 w=9.33 l=0.74
X2 D G S B sky130_fd_pr__pfet_01v8_lvt ad=1.35285 pd=9.62 as=2.7057 ps=19.24 w=9.33 l=0.74
X3 S G D B sky130_fd_pr__pfet_01v8_lvt ad=2.7057 pd=19.24 as=1.35285 ps=9.62 w=9.33 l=0.74
C0 S B 0.30125f
C1 B G 0.63976f
C2 S G 1.13422f
C3 B D 0.23599f
C4 S D 1.00635f
C5 G D 1.13409f
C6 D VSUBS 0.08361f
C7 S VSUBS 0.75155f
C8 G VSUBS 1.1394f
C9 B VSUBS 5.91289f
.ends
