* NGSPICE file created from pfet_01v8_lvt_W2_L5_m2__nf2_gtop_sdfull_outD_ng.ext - technology: sky130A

.subckt sky130_fd_pr__pfet_01v8_lvt_ZN57UK G w_n1123_n198# D0 a_1029_n136# S1
X0 a_1029_n136# G S1 w_n1123_n198# sky130_fd_pr__pfet_01v8_lvt ad=0.29 pd=2.58 as=0.145 ps=1.29 w=1 l=5
X1 S1 G D0 w_n1123_n198# sky130_fd_pr__pfet_01v8_lvt ad=0.145 pd=1.29 as=0.29 ps=2.58 w=1 l=5
.ends

.subckt pfet_01v8_lvt_W2_L5_m2__nf2_gtop_sdfull_outD_ng S D G B
Xpfet_01v8_lvt_W2_L5_m2__nf2_gtop_sdfull_outD_ng_pc G B D D S sky130_fd_pr__pfet_01v8_lvt_ZN57UK
.ends
