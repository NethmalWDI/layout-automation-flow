* NGSPICE file created from pfet_01v8_lvt_W887p03_L0p74_m1__nf4_gboth_sdfull_outD.ext - technology: sky130A

.subckt pfet_01v8_lvt_W887p03_L0p74_m1__nf4_gboth_sdfull_outD S D G B
X0 D G S B sky130_fd_pr__pfet_01v8_lvt ad=64.3104 pd=444.10001 as=32.1552 ps=222.05 w=221.75999 l=0.74
X1 S G D B sky130_fd_pr__pfet_01v8_lvt ad=32.1552 pd=222.05 as=32.1552 ps=222.05 w=221.75999 l=0.74
X2 S G D B sky130_fd_pr__pfet_01v8_lvt ad=32.1552 pd=222.05 as=64.3104 ps=444.10001 w=221.75999 l=0.74
X3 D G S B sky130_fd_pr__pfet_01v8_lvt ad=32.1552 pd=222.05 as=32.1552 ps=222.05 w=221.75999 l=0.74
C0 B G 1.3134f
C1 S G 41.11219f
C2 G D 41.10715f
C3 S B 9.63089f
C4 B D 30.49232f
C5 S D 33.28658f
C6 S VSUBS 0.15481f
C7 D VSUBS 11.97088f
C8 G VSUBS 0.51681f
C9 B VSUBS 0.17217p
.ends
