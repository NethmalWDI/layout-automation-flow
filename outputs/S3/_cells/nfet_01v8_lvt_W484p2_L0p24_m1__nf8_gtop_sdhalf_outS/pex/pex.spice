* NGSPICE file created from nfet_01v8_lvt_W484p2_L0p24_m1__nf8_gtop_sdhalf_outS.ext - technology: sky130A

.subckt nfet_01v8_lvt_W484p2_L0p24_m1__nf8_gtop_sdhalf_outS S D G B
X0 D G S B sky130_fd_pr__nfet_01v8_lvt ad=8.77685 pd=60.82 as=17.5537 ps=121.64 w=60.53 l=0.24
X1 D G S B sky130_fd_pr__nfet_01v8_lvt ad=8.77685 pd=60.82 as=8.77685 ps=60.82 w=60.53 l=0.24
X2 S G D B sky130_fd_pr__nfet_01v8_lvt ad=8.77685 pd=60.82 as=8.77685 ps=60.82 w=60.53 l=0.24
X3 D G S B sky130_fd_pr__nfet_01v8_lvt ad=8.77685 pd=60.82 as=8.77685 ps=60.82 w=60.53 l=0.24
X4 S G D B sky130_fd_pr__nfet_01v8_lvt ad=8.77685 pd=60.82 as=8.77685 ps=60.82 w=60.53 l=0.24
X5 S G D B sky130_fd_pr__nfet_01v8_lvt ad=17.5537 pd=121.64 as=8.77685 ps=60.82 w=60.53 l=0.24
X6 S G D B sky130_fd_pr__nfet_01v8_lvt ad=8.77685 pd=60.82 as=8.77685 ps=60.82 w=60.53 l=0.24
X7 D G S B sky130_fd_pr__nfet_01v8_lvt ad=8.77685 pd=60.82 as=8.77685 ps=60.82 w=60.53 l=0.24
C0 S G 4.96938f
C1 S D 17.87501f
C2 D G 4.96938f
C3 D B 0.23541f
C4 S B 5.21872f
C5 G B 1.96038f
.ends
