* NGSPICE file created from pfet_01v8_lvt_W6_L1_m2__nf4_gtop_sdfull_outD.ext - technology: sky130A

.subckt sky130_fd_pr__pfet_01v8_lvt_MDF9JX G B D2 D0 a_487_n186# S3 S1
X0 D2 G S1 B sky130_fd_pr__pfet_01v8_lvt ad=0.2175 pd=1.79 as=0.2175 ps=1.79 w=1.5 l=1
X1 S3 G D2 B sky130_fd_pr__pfet_01v8_lvt ad=0.2175 pd=1.79 as=0.2175 ps=1.79 w=1.5 l=1
X2 S1 G D0 B sky130_fd_pr__pfet_01v8_lvt ad=0.2175 pd=1.79 as=0.435 ps=3.58 w=1.5 l=1
X3 a_487_n186# G S3 B sky130_fd_pr__pfet_01v8_lvt ad=0.435 pd=3.58 as=0.2175 ps=1.79 w=1.5 l=1
.ends

.subckt pfet_01v8_lvt_W6_L1_m2__nf4_gtop_sdfull_outD S D G B
Xpfet_01v8_lvt_W6_L1_m2__nf4_gtop_sdfull_outD_pc G B D D D S S sky130_fd_pr__pfet_01v8_lvt_MDF9JX
.ends
