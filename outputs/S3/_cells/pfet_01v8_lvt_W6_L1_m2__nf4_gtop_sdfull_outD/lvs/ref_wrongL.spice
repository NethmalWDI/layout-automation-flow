.subckt pfet_01v8_lvt_W6_L1_m2__nf4_gtop_sdfull_outD D G S B
Xpfet_01v8_lvt_W6_L1_m2__nf4_gtop_sdfull_outD D G S B sky130_fd_pr__pfet_01v8_lvt L=1.1 W=6 nf=4
.ends
