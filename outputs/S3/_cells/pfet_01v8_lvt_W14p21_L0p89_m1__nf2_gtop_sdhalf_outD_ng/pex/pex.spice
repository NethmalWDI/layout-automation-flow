* NGSPICE file created from pfet_01v8_lvt_W14p21_L0p89_m1__nf2_gtop_sdhalf_outD_ng.ext - technology: sky130A

.subckt pfet_01v8_lvt_W14p21_L0p89_m1__nf2_gtop_sdhalf_outD_ng S D G B
X0 S G D B sky130_fd_pr__pfet_01v8_lvt ad=1.03095 pd=7.4 as=2.0619 ps=14.8 w=7.11 l=0.89
X1 D G S B sky130_fd_pr__pfet_01v8_lvt ad=2.0619 pd=14.8 as=1.03095 ps=7.4 w=7.11 l=0.89
C0 S G 0.48989f
C1 S B 0.08341f
C2 D G 0.48421f
C3 D B 0.13437f
C4 D S 0.40966f
C5 B G 0.24161f
C6 S VSUBS 0.0697f
C7 D VSUBS 0.59371f
C8 G VSUBS 0.43922f
C9 B VSUBS 2.8607f
.ends
