* NGSPICE file created from pfet_01v8_lvt_W14p21_L0p89_m1__nf2_gtop_sdhalf_outD_ng.ext - technology: sky130A

.subckt sky130_fd_pr__pfet_01v8_lvt_S9Q5TH G a_207_n747# D0 w_n301_n809# S1
X0 S1 G D0 w_n301_n809# sky130_fd_pr__pfet_01v8_lvt ad=1.03095 pd=7.4 as=2.0619 ps=14.8 w=7.11 l=0.89
X1 a_207_n747# G S1 w_n301_n809# sky130_fd_pr__pfet_01v8_lvt ad=2.0619 pd=14.8 as=1.03095 ps=7.4 w=7.11 l=0.89
.ends

.subckt pfet_01v8_lvt_W14p21_L0p89_m1__nf2_gtop_sdhalf_outD_ng S D G B
Xpfet_01v8_lvt_W14p21_L0p89_m1__nf2_gtop_sdhalf_outD_ng_pc G D D B S sky130_fd_pr__pfet_01v8_lvt_S9Q5TH
.ends
