* NGSPICE file created from pfet_01v8_lvt_W6_L1_m2__nf4_gboth_sdfull_outS_ng.ext - technology: sky130A

.subckt pfet_01v8_lvt_W6_L1_m2__nf4_gboth_sdfull_outS_ng S D G B
X0 D G S B sky130_fd_pr__pfet_01v8_lvt ad=0.2175 pd=1.79 as=0.435 ps=3.58 w=1.5 l=1
X1 S G D B sky130_fd_pr__pfet_01v8_lvt ad=0.435 pd=3.58 as=0.2175 ps=1.79 w=1.5 l=1
X2 S G D B sky130_fd_pr__pfet_01v8_lvt ad=0.2175 pd=1.79 as=0.2175 ps=1.79 w=1.5 l=1
X3 D G S B sky130_fd_pr__pfet_01v8_lvt ad=0.2175 pd=1.79 as=0.2175 ps=1.79 w=1.5 l=1
C0 B S 0.10527f
C1 D G 0.64765f
C2 G S 0.65267f
C3 D S 0.54511f
C4 G B 0.7188f
C5 D B 0.07977f
C6 D VSUBS 0.19258f
C7 S VSUBS 0.43066f
C8 G VSUBS 1.32811f
C9 B VSUBS 1.743f
.ends
