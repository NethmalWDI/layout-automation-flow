* NGSPICE file created from nfet_01v8_W24_L0p5_m1__nf8_gboth_sdfull_outS_ng.ext - technology: sky130A

.subckt nfet_01v8_W24_L0p5_m1__nf8_gboth_sdfull_outS_ng S D G B
X0 S G D B sky130_fd_pr__nfet_01v8 ad=0.435 pd=3.29 as=0.435 ps=3.29 w=3 l=0.5
X1 S G D B sky130_fd_pr__nfet_01v8 ad=0.435 pd=3.29 as=0.435 ps=3.29 w=3 l=0.5
X2 D G S B sky130_fd_pr__nfet_01v8 ad=0.435 pd=3.29 as=0.435 ps=3.29 w=3 l=0.5
X3 D G S B sky130_fd_pr__nfet_01v8 ad=0.435 pd=3.29 as=0.435 ps=3.29 w=3 l=0.5
X4 D G S B sky130_fd_pr__nfet_01v8 ad=0.435 pd=3.29 as=0.87 ps=6.58 w=3 l=0.5
X5 S G D B sky130_fd_pr__nfet_01v8 ad=0.435 pd=3.29 as=0.435 ps=3.29 w=3 l=0.5
X6 S G D B sky130_fd_pr__nfet_01v8 ad=0.87 pd=6.58 as=0.435 ps=3.29 w=3 l=0.5
X7 D G S B sky130_fd_pr__nfet_01v8 ad=0.435 pd=3.29 as=0.435 ps=3.29 w=3 l=0.5
C0 G S 1.37773f
C1 S D 1.66099f
C2 G D 1.3664f
C3 D B 0.22616f
C4 S B 0.72881f
C5 G B 2.28004f
.ends
