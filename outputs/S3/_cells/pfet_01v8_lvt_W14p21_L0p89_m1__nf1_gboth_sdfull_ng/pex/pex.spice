* NGSPICE file created from pfet_01v8_lvt_W14p21_L0p89_m1__nf1_gboth_sdfull_ng.ext - technology: sky130A

.subckt pfet_01v8_lvt_W14p21_L0p89_m1__nf1_gboth_sdfull_ng D S G B
X0 S G D B sky130_fd_pr__pfet_01v8_lvt ad=4.1209 pd=29 as=4.1209 ps=29 w=14.21 l=0.89
C0 G D 0.72641f
C1 S B 0.26592f
C2 S D 0.4612f
C3 S G 0.72641f
C4 D B 0.26592f
C5 G B 0.18681f
C6 S VSUBS 1.02128f
C7 D VSUBS 1.02128f
C8 G VSUBS 0.35644f
C9 B VSUBS 3.0744f
.ends
