* NGSPICE file created from pfet_01v8_lvt_W37p3_L0p74_m1__nf2_gboth_sdhalf_outS_ng.ext - technology: sky130A

.subckt pfet_01v8_lvt_W37p3_L0p74_m1__nf2_gboth_sdhalf_outS_ng S D G B
X0 S G D B sky130_fd_pr__pfet_01v8_lvt ad=5.4085 pd=37.88 as=2.70425 ps=18.94 w=18.65 l=0.74
X1 D G S B sky130_fd_pr__pfet_01v8_lvt ad=2.70425 pd=18.94 as=5.4085 ps=37.88 w=18.65 l=0.74
C0 D B 0.19599f
C1 S B 0.32049f
C2 G B 0.33175f
C3 D S 0.86428f
C4 G D 1.01527f
C5 G S 1.01528f
C6 D VSUBS 0.05686f
C7 S VSUBS 1.37252f
C8 G VSUBS 0.62543f
C9 B VSUBS 4.5528f
.ends
