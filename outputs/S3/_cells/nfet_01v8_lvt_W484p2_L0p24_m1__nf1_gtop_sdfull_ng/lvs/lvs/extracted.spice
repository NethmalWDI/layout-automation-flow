* NGSPICE file created from nfet_01v8_lvt_W484p2_L0p24_m1__nf1_gtop_sdfull_ng.ext - technology: sky130A

.subckt sky130_fd_pr__nfet_01v8_lvt_7KQ7AT G D S VSUBS
X0 S G D VSUBS sky130_fd_pr__nfet_01v8_lvt ad=140.418 pd=968.97998 as=140.418 ps=968.97998 w=484.20001 l=0.24
.ends

.subckt nfet_01v8_lvt_W484p2_L0p24_m1__nf1_gtop_sdfull_ng D S G B
Xnfet_01v8_lvt_W484p2_L0p24_m1__nf1_gtop_sdfull_ng_pc G D S B sky130_fd_pr__nfet_01v8_lvt_7KQ7AT
.ends
