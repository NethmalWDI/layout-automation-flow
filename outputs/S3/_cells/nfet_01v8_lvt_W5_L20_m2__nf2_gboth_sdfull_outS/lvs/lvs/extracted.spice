* NGSPICE file created from nfet_01v8_lvt_W5_L20_m2__nf2_gboth_sdfull_outS.ext - technology: sky130A

.subckt sky130_fd_pr__nfet_01v8_lvt_ZTGVEE G a_4029_n250# B D0 S1
X0 S1 G D0 B sky130_fd_pr__nfet_01v8_lvt ad=0.3625 pd=2.79 as=0.725 ps=5.58 w=2.5 l=20
X1 a_4029_n250# G S1 B sky130_fd_pr__nfet_01v8_lvt ad=0.725 pd=5.58 as=0.3625 ps=2.79 w=2.5 l=20
.ends

.subckt nfet_01v8_lvt_W5_L20_m2__nf2_gboth_sdfull_outS S D G B
Xnfet_01v8_lvt_W5_L20_m2__nf2_gboth_sdfull_outS_pc G S B S D sky130_fd_pr__nfet_01v8_lvt_ZTGVEE
.ends
