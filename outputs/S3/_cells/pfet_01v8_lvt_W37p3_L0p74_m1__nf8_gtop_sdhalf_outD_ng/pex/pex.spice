* NGSPICE file created from pfet_01v8_lvt_W37p3_L0p74_m1__nf8_gtop_sdhalf_outD_ng.ext - technology: sky130A

.subckt pfet_01v8_lvt_W37p3_L0p74_m1__nf8_gtop_sdhalf_outD_ng S D G B
X0 S G D B sky130_fd_pr__pfet_01v8_lvt ad=0.6757 pd=4.95 as=0.6757 ps=4.95 w=4.66 l=0.74
X1 D G S B sky130_fd_pr__pfet_01v8_lvt ad=0.6757 pd=4.95 as=0.6757 ps=4.95 w=4.66 l=0.74
X2 D G S B sky130_fd_pr__pfet_01v8_lvt ad=0.6757 pd=4.95 as=0.6757 ps=4.95 w=4.66 l=0.74
X3 S G D B sky130_fd_pr__pfet_01v8_lvt ad=0.6757 pd=4.95 as=0.6757 ps=4.95 w=4.66 l=0.74
X4 D G S B sky130_fd_pr__pfet_01v8_lvt ad=0.6757 pd=4.95 as=0.6757 ps=4.95 w=4.66 l=0.74
X5 S G D B sky130_fd_pr__pfet_01v8_lvt ad=0.6757 pd=4.95 as=1.3514 ps=9.9 w=4.66 l=0.74
X6 S G D B sky130_fd_pr__pfet_01v8_lvt ad=0.6757 pd=4.95 as=0.6757 ps=4.95 w=4.66 l=0.74
X7 D G S B sky130_fd_pr__pfet_01v8_lvt ad=1.3514 pd=9.9 as=0.6757 ps=4.95 w=4.66 l=0.74
C0 D S 1.30609f
C1 G B 0.82379f
C2 B D 0.31735f
C3 G D 1.2054f
C4 B S 0.27439f
C5 G S 1.23743f
C6 S VSUBS 0.20847f
C7 D VSUBS 0.58184f
C8 G VSUBS 1.37545f
C9 B VSUBS 5.8354f
.ends
