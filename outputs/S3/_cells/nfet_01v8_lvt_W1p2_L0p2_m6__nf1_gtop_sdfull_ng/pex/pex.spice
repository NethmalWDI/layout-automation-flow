* NGSPICE file created from nfet_01v8_lvt_W1p2_L0p2_m6__nf1_gtop_sdfull_ng.ext - technology: sky130A

.subckt nfet_01v8_lvt_W1p2_L0p2_m6__nf1_gtop_sdfull_ng D S G B
X0 S G D B sky130_fd_pr__nfet_01v8_lvt ad=0.348 pd=2.98 as=0.348 ps=2.98 w=1.2 l=0.2
C0 S G 0.02671f
C1 D G 0.02671f
C2 S D 0.09394f
C3 S B 0.12686f
C4 D B 0.12686f
C5 G B 0.1895f
.ends
