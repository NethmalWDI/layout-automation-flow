* NGSPICE file created from nfet_01v8_lvt_W5_L20_m2__nf2_gboth_sdhalf_outD.ext - technology: sky130A

.subckt nfet_01v8_lvt_W5_L20_m2__nf2_gboth_sdhalf_outD S D G B
X0 S G D B sky130_fd_pr__nfet_01v8_lvt ad=0.3625 pd=2.79 as=0.725 ps=5.58 w=2.5 l=20
X1 D G S B sky130_fd_pr__nfet_01v8_lvt ad=0.725 pd=5.58 as=0.3625 ps=2.79 w=2.5 l=20
C0 S G 1.74752f
C1 G D 1.74688f
C2 S D 1.33056f
C3 S B 1.18956f
C4 D B 1.12439f
C5 G B 15.17302f
.ends
