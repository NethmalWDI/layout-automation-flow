.subckt nfet_01v8_lvt_W5_L20_m2__nf2_gboth_sdhalf_outD D G S B
Xnfet_01v8_lvt_W5_L20_m2__nf2_gboth_sdhalf_outD D G S B sky130_fd_pr__nfet_01v8_lvt L=22 W=5 nf=2
.ends
