.subckt nfet_01v8_lvt_W1p4_L0p6_m8__nf1_gtop_sdfull D G S B
Xnfet_01v8_lvt_W1p4_L0p6_m8__nf1_gtop_sdfull D G S B sky130_fd_pr__nfet_01v8_lvt L=0.6 W=1.4 nf=1
.ends
