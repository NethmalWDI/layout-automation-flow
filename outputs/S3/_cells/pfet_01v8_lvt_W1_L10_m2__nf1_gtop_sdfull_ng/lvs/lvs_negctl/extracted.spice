* NGSPICE file created from pfet_01v8_lvt_W1_L10_m2__nf1_gtop_sdfull_ng.ext - technology: sky130A

.subckt sky130_fd_pr__pfet_01v8_lvt_8B8GM3 G D S w_n1094_n198#
X0 S G D w_n1094_n198# sky130_fd_pr__pfet_01v8_lvt ad=0.29 pd=2.58 as=0.29 ps=2.58 w=1 l=10
.ends

.subckt pfet_01v8_lvt_W1_L10_m2__nf1_gtop_sdfull_ng D S G B
Xpfet_01v8_lvt_W1_L10_m2__nf1_gtop_sdfull_ng_pc G D S B sky130_fd_pr__pfet_01v8_lvt_8B8GM3
.ends
