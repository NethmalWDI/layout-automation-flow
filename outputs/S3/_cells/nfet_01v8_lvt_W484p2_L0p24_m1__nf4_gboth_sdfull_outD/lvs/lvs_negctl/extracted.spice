* NGSPICE file created from nfet_01v8_lvt_W484p2_L0p24_m1__nf4_gboth_sdfull_outD.ext - technology: sky130A

.subckt sky130_fd_pr__nfet_01v8_lvt_7NC4BW G B D2 D0 S3 a_183_n12105# S1
X0 a_183_n12105# G S3 B sky130_fd_pr__nfet_01v8_lvt ad=35.1045 pd=242.67999 as=17.55225 ps=121.34 w=121.05 l=0.24
X1 S3 G D2 B sky130_fd_pr__nfet_01v8_lvt ad=17.55225 pd=121.34 as=17.55225 ps=121.34 w=121.05 l=0.24
X2 S1 G D0 B sky130_fd_pr__nfet_01v8_lvt ad=17.55225 pd=121.34 as=35.1045 ps=242.67999 w=121.05 l=0.24
X3 D2 G S1 B sky130_fd_pr__nfet_01v8_lvt ad=17.55225 pd=121.34 as=17.55225 ps=121.34 w=121.05 l=0.24
.ends

.subckt nfet_01v8_lvt_W484p2_L0p24_m1__nf4_gboth_sdfull_outD S D G B
Xnfet_01v8_lvt_W484p2_L0p24_m1__nf4_gboth_sdfull_outD_pc G B D D S D S sky130_fd_pr__nfet_01v8_lvt_7NC4BW
.ends
