* NGSPICE file created from pfet_01v8_lvt_W14p21_L0p89_m1__nf4_gboth_sdfull_outD_ng.ext - technology: sky130A

.subckt pfet_01v8_lvt_W14p21_L0p89_m1__nf4_gboth_sdfull_outD_ng S D G B
X0 S G D B sky130_fd_pr__pfet_01v8_lvt ad=0.51475 pd=3.84 as=0.51475 ps=3.84 w=3.55 l=0.89
X1 D G S B sky130_fd_pr__pfet_01v8_lvt ad=0.51475 pd=3.84 as=0.51475 ps=3.84 w=3.55 l=0.89
X2 S G D B sky130_fd_pr__pfet_01v8_lvt ad=0.51475 pd=3.84 as=1.0295 ps=7.68 w=3.55 l=0.89
X3 D G S B sky130_fd_pr__pfet_01v8_lvt ad=1.0295 pd=7.68 as=0.51475 ps=3.84 w=3.55 l=0.89
C0 S G 1.08017f
C1 G D 1.07513f
C2 S D 0.75531f
C3 G B 0.69148f
C4 S B 0.16967f
C5 B D 0.2233f
C6 S VSUBS 0.16867f
C7 D VSUBS 0.68746f
C8 G VSUBS 1.21843f
C9 B VSUBS 2.93202f
.ends
