* NGSPICE file created from nfet_01v8_lvt_W0p5_L20_m2__nf1_gtop_sdhalf_ng.ext - technology: sky130A

.subckt sky130_fd_pr__nfet_01v8_lvt_UP7MTZ G D S VSUBS
X0 S G D VSUBS sky130_fd_pr__nfet_01v8_lvt ad=0.145 pd=1.58 as=0.145 ps=1.58 w=0.5 l=20
.ends

.subckt nfet_01v8_lvt_W0p5_L20_m2__nf1_gtop_sdhalf_ng D S G B
Xnfet_01v8_lvt_W0p5_L20_m2__nf1_gtop_sdhalf_ng_pc G D S B sky130_fd_pr__nfet_01v8_lvt_UP7MTZ
.ends
