* NGSPICE file created from pfet_01v8_W8_L1_m1__nf4_gboth_sdhalf_outD.ext - technology: sky130A

.subckt sky130_fd_pr__pfet_01v8_685G33 G B D2 D0 a_487_n200# S3 S1
X0 S3 G D2 B sky130_fd_pr__pfet_01v8 ad=0.29 pd=2.29 as=0.29 ps=2.29 w=2 l=1
X1 D2 G S1 B sky130_fd_pr__pfet_01v8 ad=0.29 pd=2.29 as=0.29 ps=2.29 w=2 l=1
X2 S1 G D0 B sky130_fd_pr__pfet_01v8 ad=0.29 pd=2.29 as=0.58 ps=4.58 w=2 l=1
X3 a_487_n200# G S3 B sky130_fd_pr__pfet_01v8 ad=0.58 pd=4.58 as=0.29 ps=2.29 w=2 l=1
.ends

.subckt pfet_01v8_W8_L1_m1__nf4_gboth_sdhalf_outD S D G B
Xpfet_01v8_W8_L1_m1__nf4_gboth_sdhalf_outD_pc G B D D D S S sky130_fd_pr__pfet_01v8_685G33
.ends
