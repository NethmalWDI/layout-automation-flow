* NGSPICE file created from pfet_01v8_lvt_W2_L5_m4__nf1_gboth_sdhalf.ext - technology: sky130A

.subckt sky130_fd_pr__pfet_01v8_lvt_6NAJED G D B S
X0 S G D B sky130_fd_pr__pfet_01v8_lvt ad=0.58 pd=4.58 as=0.58 ps=4.58 w=2 l=5
.ends

.subckt pfet_01v8_lvt_W2_L5_m4__nf1_gboth_sdhalf D S G B
Xpfet_01v8_lvt_W2_L5_m4__nf1_gboth_sdhalf_pc G D B S sky130_fd_pr__pfet_01v8_lvt_6NAJED
.ends
