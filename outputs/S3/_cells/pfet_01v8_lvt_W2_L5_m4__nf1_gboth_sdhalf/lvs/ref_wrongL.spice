.subckt pfet_01v8_lvt_W2_L5_m4__nf1_gboth_sdhalf D G S B
Xpfet_01v8_lvt_W2_L5_m4__nf1_gboth_sdhalf D G S B sky130_fd_pr__pfet_01v8_lvt L=5.5 W=2 nf=1
.ends
