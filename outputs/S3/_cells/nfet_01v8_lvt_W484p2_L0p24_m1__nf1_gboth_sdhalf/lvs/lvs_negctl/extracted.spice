* NGSPICE file created from nfet_01v8_lvt_W484p2_L0p24_m1__nf1_gboth_sdhalf.ext - technology: sky130A

.subckt sky130_fd_pr__nfet_01v8_lvt_3Q8W5Y G D B S
X0 S G D B sky130_fd_pr__nfet_01v8_lvt ad=140.418 pd=968.97998 as=140.418 ps=968.97998 w=484.20001 l=0.24
.ends

.subckt nfet_01v8_lvt_W484p2_L0p24_m1__nf1_gboth_sdhalf D S G B
Xnfet_01v8_lvt_W484p2_L0p24_m1__nf1_gboth_sdhalf_pc G D B S sky130_fd_pr__nfet_01v8_lvt_3Q8W5Y
.ends
