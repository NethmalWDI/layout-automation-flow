* NGSPICE file created from nfet_01v8_lvt_W484p2_L0p24_m1__nf64_gtop_sdfull_outD.ext - technology: sky130A

.subckt nfet_01v8_lvt_W484p2_L0p24_m1__nf64_gtop_sdfull_outD S D G B
X0 D G S B sky130_fd_pr__nfet_01v8_lvt ad=1.09765 pd=7.86 as=1.09765 ps=7.86 w=7.57 l=0.24
X1 S G D B sky130_fd_pr__nfet_01v8_lvt ad=1.09765 pd=7.86 as=1.09765 ps=7.86 w=7.57 l=0.24
X2 S G D B sky130_fd_pr__nfet_01v8_lvt ad=1.09765 pd=7.86 as=1.09765 ps=7.86 w=7.57 l=0.24
X3 S G D B sky130_fd_pr__nfet_01v8_lvt ad=1.09765 pd=7.86 as=1.09765 ps=7.86 w=7.57 l=0.24
X4 S G D B sky130_fd_pr__nfet_01v8_lvt ad=1.09765 pd=7.86 as=1.09765 ps=7.86 w=7.57 l=0.24
X5 D G S B sky130_fd_pr__nfet_01v8_lvt ad=1.09765 pd=7.86 as=1.09765 ps=7.86 w=7.57 l=0.24
X6 S G D B sky130_fd_pr__nfet_01v8_lvt ad=1.09765 pd=7.86 as=1.09765 ps=7.86 w=7.57 l=0.24
X7 D G S B sky130_fd_pr__nfet_01v8_lvt ad=1.09765 pd=7.86 as=1.09765 ps=7.86 w=7.57 l=0.24
X8 S G D B sky130_fd_pr__nfet_01v8_lvt ad=1.09765 pd=7.86 as=1.09765 ps=7.86 w=7.57 l=0.24
X9 S G D B sky130_fd_pr__nfet_01v8_lvt ad=1.09765 pd=7.86 as=1.09765 ps=7.86 w=7.57 l=0.24
X10 D G S B sky130_fd_pr__nfet_01v8_lvt ad=1.09765 pd=7.86 as=1.09765 ps=7.86 w=7.57 l=0.24
X11 S G D B sky130_fd_pr__nfet_01v8_lvt ad=1.09765 pd=7.86 as=1.09765 ps=7.86 w=7.57 l=0.24
X12 S G D B sky130_fd_pr__nfet_01v8_lvt ad=1.09765 pd=7.86 as=1.09765 ps=7.86 w=7.57 l=0.24
X13 S G D B sky130_fd_pr__nfet_01v8_lvt ad=1.09765 pd=7.86 as=1.09765 ps=7.86 w=7.57 l=0.24
X14 S G D B sky130_fd_pr__nfet_01v8_lvt ad=1.09765 pd=7.86 as=1.09765 ps=7.86 w=7.57 l=0.24
X15 S G D B sky130_fd_pr__nfet_01v8_lvt ad=1.09765 pd=7.86 as=1.09765 ps=7.86 w=7.57 l=0.24
X16 S G D B sky130_fd_pr__nfet_01v8_lvt ad=1.09765 pd=7.86 as=1.09765 ps=7.86 w=7.57 l=0.24
X17 D G S B sky130_fd_pr__nfet_01v8_lvt ad=1.09765 pd=7.86 as=1.09765 ps=7.86 w=7.57 l=0.24
X18 S G D B sky130_fd_pr__nfet_01v8_lvt ad=1.09765 pd=7.86 as=1.09765 ps=7.86 w=7.57 l=0.24
X19 D G S B sky130_fd_pr__nfet_01v8_lvt ad=1.09765 pd=7.86 as=1.09765 ps=7.86 w=7.57 l=0.24
X20 D G S B sky130_fd_pr__nfet_01v8_lvt ad=1.09765 pd=7.86 as=1.09765 ps=7.86 w=7.57 l=0.24
X21 S G D B sky130_fd_pr__nfet_01v8_lvt ad=1.09765 pd=7.86 as=1.09765 ps=7.86 w=7.57 l=0.24
X22 S G D B sky130_fd_pr__nfet_01v8_lvt ad=1.09765 pd=7.86 as=1.09765 ps=7.86 w=7.57 l=0.24
X23 D G S B sky130_fd_pr__nfet_01v8_lvt ad=1.09765 pd=7.86 as=1.09765 ps=7.86 w=7.57 l=0.24
X24 D G S B sky130_fd_pr__nfet_01v8_lvt ad=1.09765 pd=7.86 as=1.09765 ps=7.86 w=7.57 l=0.24
X25 S G D B sky130_fd_pr__nfet_01v8_lvt ad=1.09765 pd=7.86 as=1.09765 ps=7.86 w=7.57 l=0.24
X26 D G S B sky130_fd_pr__nfet_01v8_lvt ad=1.09765 pd=7.86 as=1.09765 ps=7.86 w=7.57 l=0.24
X27 S G D B sky130_fd_pr__nfet_01v8_lvt ad=1.09765 pd=7.86 as=1.09765 ps=7.86 w=7.57 l=0.24
X28 D G S B sky130_fd_pr__nfet_01v8_lvt ad=1.09765 pd=7.86 as=1.09765 ps=7.86 w=7.57 l=0.24
X29 D G S B sky130_fd_pr__nfet_01v8_lvt ad=1.09765 pd=7.86 as=1.09765 ps=7.86 w=7.57 l=0.24
X30 D G S B sky130_fd_pr__nfet_01v8_lvt ad=1.09765 pd=7.86 as=1.09765 ps=7.86 w=7.57 l=0.24
X31 S G D B sky130_fd_pr__nfet_01v8_lvt ad=1.09765 pd=7.86 as=1.09765 ps=7.86 w=7.57 l=0.24
X32 S G D B sky130_fd_pr__nfet_01v8_lvt ad=1.09765 pd=7.86 as=1.09765 ps=7.86 w=7.57 l=0.24
X33 D G S B sky130_fd_pr__nfet_01v8_lvt ad=2.1953 pd=15.72 as=1.09765 ps=7.86 w=7.57 l=0.24
X34 D G S B sky130_fd_pr__nfet_01v8_lvt ad=1.09765 pd=7.86 as=1.09765 ps=7.86 w=7.57 l=0.24
X35 S G D B sky130_fd_pr__nfet_01v8_lvt ad=1.09765 pd=7.86 as=1.09765 ps=7.86 w=7.57 l=0.24
X36 D G S B sky130_fd_pr__nfet_01v8_lvt ad=1.09765 pd=7.86 as=1.09765 ps=7.86 w=7.57 l=0.24
X37 D G S B sky130_fd_pr__nfet_01v8_lvt ad=1.09765 pd=7.86 as=1.09765 ps=7.86 w=7.57 l=0.24
X38 D G S B sky130_fd_pr__nfet_01v8_lvt ad=1.09765 pd=7.86 as=1.09765 ps=7.86 w=7.57 l=0.24
X39 S G D B sky130_fd_pr__nfet_01v8_lvt ad=1.09765 pd=7.86 as=1.09765 ps=7.86 w=7.57 l=0.24
X40 S G D B sky130_fd_pr__nfet_01v8_lvt ad=1.09765 pd=7.86 as=1.09765 ps=7.86 w=7.57 l=0.24
X41 D G S B sky130_fd_pr__nfet_01v8_lvt ad=1.09765 pd=7.86 as=1.09765 ps=7.86 w=7.57 l=0.24
X42 D G S B sky130_fd_pr__nfet_01v8_lvt ad=1.09765 pd=7.86 as=1.09765 ps=7.86 w=7.57 l=0.24
X43 S G D B sky130_fd_pr__nfet_01v8_lvt ad=1.09765 pd=7.86 as=1.09765 ps=7.86 w=7.57 l=0.24
X44 S G D B sky130_fd_pr__nfet_01v8_lvt ad=1.09765 pd=7.86 as=1.09765 ps=7.86 w=7.57 l=0.24
X45 D G S B sky130_fd_pr__nfet_01v8_lvt ad=1.09765 pd=7.86 as=1.09765 ps=7.86 w=7.57 l=0.24
X46 S G D B sky130_fd_pr__nfet_01v8_lvt ad=1.09765 pd=7.86 as=2.1953 ps=15.72 w=7.57 l=0.24
X47 S G D B sky130_fd_pr__nfet_01v8_lvt ad=1.09765 pd=7.86 as=1.09765 ps=7.86 w=7.57 l=0.24
X48 D G S B sky130_fd_pr__nfet_01v8_lvt ad=1.09765 pd=7.86 as=1.09765 ps=7.86 w=7.57 l=0.24
X49 S G D B sky130_fd_pr__nfet_01v8_lvt ad=1.09765 pd=7.86 as=1.09765 ps=7.86 w=7.57 l=0.24
X50 D G S B sky130_fd_pr__nfet_01v8_lvt ad=1.09765 pd=7.86 as=1.09765 ps=7.86 w=7.57 l=0.24
X51 D G S B sky130_fd_pr__nfet_01v8_lvt ad=1.09765 pd=7.86 as=1.09765 ps=7.86 w=7.57 l=0.24
X52 D G S B sky130_fd_pr__nfet_01v8_lvt ad=1.09765 pd=7.86 as=1.09765 ps=7.86 w=7.57 l=0.24
X53 D G S B sky130_fd_pr__nfet_01v8_lvt ad=1.09765 pd=7.86 as=1.09765 ps=7.86 w=7.57 l=0.24
X54 S G D B sky130_fd_pr__nfet_01v8_lvt ad=1.09765 pd=7.86 as=1.09765 ps=7.86 w=7.57 l=0.24
X55 S G D B sky130_fd_pr__nfet_01v8_lvt ad=1.09765 pd=7.86 as=1.09765 ps=7.86 w=7.57 l=0.24
X56 S G D B sky130_fd_pr__nfet_01v8_lvt ad=1.09765 pd=7.86 as=1.09765 ps=7.86 w=7.57 l=0.24
X57 D G S B sky130_fd_pr__nfet_01v8_lvt ad=1.09765 pd=7.86 as=1.09765 ps=7.86 w=7.57 l=0.24
X58 D G S B sky130_fd_pr__nfet_01v8_lvt ad=1.09765 pd=7.86 as=1.09765 ps=7.86 w=7.57 l=0.24
X59 D G S B sky130_fd_pr__nfet_01v8_lvt ad=1.09765 pd=7.86 as=1.09765 ps=7.86 w=7.57 l=0.24
X60 D G S B sky130_fd_pr__nfet_01v8_lvt ad=1.09765 pd=7.86 as=1.09765 ps=7.86 w=7.57 l=0.24
X61 D G S B sky130_fd_pr__nfet_01v8_lvt ad=1.09765 pd=7.86 as=1.09765 ps=7.86 w=7.57 l=0.24
X62 S G D B sky130_fd_pr__nfet_01v8_lvt ad=1.09765 pd=7.86 as=1.09765 ps=7.86 w=7.57 l=0.24
X63 D G S B sky130_fd_pr__nfet_01v8_lvt ad=1.09765 pd=7.86 as=1.09765 ps=7.86 w=7.57 l=0.24
C0 S D 37.79915f
C1 G D 11.24421f
C2 S G 12.12368f
C3 S B 1.16369f
C4 D B 2.55359f
C5 G B 9.76806f
.ends
