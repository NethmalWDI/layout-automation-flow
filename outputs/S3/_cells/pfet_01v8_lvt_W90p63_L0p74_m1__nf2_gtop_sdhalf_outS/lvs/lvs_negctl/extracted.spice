* NGSPICE file created from pfet_01v8_lvt_W90p63_L0p74_m1__nf2_gtop_sdhalf_outS.ext - technology: sky130A

.subckt sky130_fd_pr__pfet_01v8_lvt_SQTA6M G a_177_n4568# B D0 S1
X0 a_177_n4568# G S1 B sky130_fd_pr__pfet_01v8_lvt ad=13.1428 pd=91.22 as=6.5714 ps=45.61 w=45.32 l=0.74
X1 S1 G D0 B sky130_fd_pr__pfet_01v8_lvt ad=6.5714 pd=45.61 as=13.1428 ps=91.22 w=45.32 l=0.74
.ends

.subckt pfet_01v8_lvt_W90p63_L0p74_m1__nf2_gtop_sdhalf_outS S D G B
Xpfet_01v8_lvt_W90p63_L0p74_m1__nf2_gtop_sdhalf_outS_pc G S B S D sky130_fd_pr__pfet_01v8_lvt_SQTA6M
.ends
