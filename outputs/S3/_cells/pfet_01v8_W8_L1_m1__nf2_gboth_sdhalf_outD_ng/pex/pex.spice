* NGSPICE file created from pfet_01v8_W8_L1_m1__nf2_gboth_sdhalf_outD_ng.ext - technology: sky130A

.subckt pfet_01v8_W8_L1_m1__nf2_gboth_sdhalf_outD_ng S D G B
X0 S G D B sky130_fd_pr__pfet_01v8 ad=0.58 pd=4.29 as=1.16 ps=8.58 w=4 l=1
X1 D G S B sky130_fd_pr__pfet_01v8 ad=1.16 pd=8.58 as=0.58 ps=4.29 w=4 l=1
C0 S D 0.31207f
C1 S G 0.34999f
C2 D B 0.1074f
C3 G B 0.38249f
C4 G D 0.34969f
C5 S B 0.07468f
C6 S VSUBS 0.09019f
C7 D VSUBS 0.39666f
C8 G VSUBS 0.72345f
C9 B VSUBS 1.938f
.ends
