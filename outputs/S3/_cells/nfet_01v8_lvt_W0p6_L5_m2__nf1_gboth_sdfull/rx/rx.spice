* NGSPICE file created from nfet_01v8_lvt_W0p6_L5_m2__nf1_gboth_sdfull.ext - technology: sky130A

X0 S G D nfet_01v8_lvt_W0p6_L5_m2__nf1_gboth_sdfull_pc/B.t0 sky130_fd_pr__nfet_01v8_lvt ad=0.174 pd=1.78 as=0.174 ps=1.78 w=0.6 l=5
C0 S G 0.05244f
C1 S D 0.00417f
C2 D G 0.05244f
R0 nfet_01v8_lvt_W0p6_L5_m2__nf1_gboth_sdfull_pc/B.n91 nfet_01v8_lvt_W0p6_L5_m2__nf1_gboth_sdfull_pc/B.n8 1141.44
R1 nfet_01v8_lvt_W0p6_L5_m2__nf1_gboth_sdfull_pc/B.n81 nfet_01v8_lvt_W0p6_L5_m2__nf1_gboth_sdfull_pc/B.n13 1141.44
R2 nfet_01v8_lvt_W0p6_L5_m2__nf1_gboth_sdfull_pc/B.n57 nfet_01v8_lvt_W0p6_L5_m2__nf1_gboth_sdfull_pc/B.n17 1141.44
R3 nfet_01v8_lvt_W0p6_L5_m2__nf1_gboth_sdfull_pc/B.n60 nfet_01v8_lvt_W0p6_L5_m2__nf1_gboth_sdfull_pc/B.n15 1141.44
R4 nfet_01v8_lvt_W0p6_L5_m2__nf1_gboth_sdfull_pc/B.n17 nfet_01v8_lvt_W0p6_L5_m2__nf1_gboth_sdfull_pc/B.n16 585
R5 nfet_01v8_lvt_W0p6_L5_m2__nf1_gboth_sdfull_pc/B.n55 nfet_01v8_lvt_W0p6_L5_m2__nf1_gboth_sdfull_pc/B.n17 585
R6 nfet_01v8_lvt_W0p6_L5_m2__nf1_gboth_sdfull_pc/B.n54 nfet_01v8_lvt_W0p6_L5_m2__nf1_gboth_sdfull_pc/B.n53 585
R7 nfet_01v8_lvt_W0p6_L5_m2__nf1_gboth_sdfull_pc/B.n51 nfet_01v8_lvt_W0p6_L5_m2__nf1_gboth_sdfull_pc/B.n18 585
R8 nfet_01v8_lvt_W0p6_L5_m2__nf1_gboth_sdfull_pc/B.n50 nfet_01v8_lvt_W0p6_L5_m2__nf1_gboth_sdfull_pc/B.n16 585
R9 nfet_01v8_lvt_W0p6_L5_m2__nf1_gboth_sdfull_pc/B.n50 nfet_01v8_lvt_W0p6_L5_m2__nf1_gboth_sdfull_pc/B.n49 585
R10 nfet_01v8_lvt_W0p6_L5_m2__nf1_gboth_sdfull_pc/B.n48 nfet_01v8_lvt_W0p6_L5_m2__nf1_gboth_sdfull_pc/B.n19 585
R11 nfet_01v8_lvt_W0p6_L5_m2__nf1_gboth_sdfull_pc/B.n47 nfet_01v8_lvt_W0p6_L5_m2__nf1_gboth_sdfull_pc/B.n46 585
R12 nfet_01v8_lvt_W0p6_L5_m2__nf1_gboth_sdfull_pc/B.n44 nfet_01v8_lvt_W0p6_L5_m2__nf1_gboth_sdfull_pc/B.n20 585
R13 nfet_01v8_lvt_W0p6_L5_m2__nf1_gboth_sdfull_pc/B.n42 nfet_01v8_lvt_W0p6_L5_m2__nf1_gboth_sdfull_pc/B.n41 585
R14 nfet_01v8_lvt_W0p6_L5_m2__nf1_gboth_sdfull_pc/B.n40 nfet_01v8_lvt_W0p6_L5_m2__nf1_gboth_sdfull_pc/B.n21 585
R15 nfet_01v8_lvt_W0p6_L5_m2__nf1_gboth_sdfull_pc/B.n39 nfet_01v8_lvt_W0p6_L5_m2__nf1_gboth_sdfull_pc/B.n38 585
R16 nfet_01v8_lvt_W0p6_L5_m2__nf1_gboth_sdfull_pc/B.n36 nfet_01v8_lvt_W0p6_L5_m2__nf1_gboth_sdfull_pc/B.n22 585
R17 nfet_01v8_lvt_W0p6_L5_m2__nf1_gboth_sdfull_pc/B.n34 nfet_01v8_lvt_W0p6_L5_m2__nf1_gboth_sdfull_pc/B.n33 585
R18 nfet_01v8_lvt_W0p6_L5_m2__nf1_gboth_sdfull_pc/B.n23 nfet_01v8_lvt_W0p6_L5_m2__nf1_gboth_sdfull_pc/B.n16 585
R19 nfet_01v8_lvt_W0p6_L5_m2__nf1_gboth_sdfull_pc/B.n32 nfet_01v8_lvt_W0p6_L5_m2__nf1_gboth_sdfull_pc/B.n23 585
R20 nfet_01v8_lvt_W0p6_L5_m2__nf1_gboth_sdfull_pc/B.n31 nfet_01v8_lvt_W0p6_L5_m2__nf1_gboth_sdfull_pc/B.n30 585
R21 nfet_01v8_lvt_W0p6_L5_m2__nf1_gboth_sdfull_pc/B.n28 nfet_01v8_lvt_W0p6_L5_m2__nf1_gboth_sdfull_pc/B.n24 585
R22 nfet_01v8_lvt_W0p6_L5_m2__nf1_gboth_sdfull_pc/B.n27 nfet_01v8_lvt_W0p6_L5_m2__nf1_gboth_sdfull_pc/B.n25 585
R23 nfet_01v8_lvt_W0p6_L5_m2__nf1_gboth_sdfull_pc/B.n15 nfet_01v8_lvt_W0p6_L5_m2__nf1_gboth_sdfull_pc/B.n14 585
R24 nfet_01v8_lvt_W0p6_L5_m2__nf1_gboth_sdfull_pc/B.n60 nfet_01v8_lvt_W0p6_L5_m2__nf1_gboth_sdfull_pc/B.n59 585
R25 nfet_01v8_lvt_W0p6_L5_m2__nf1_gboth_sdfull_pc/B.n61 nfet_01v8_lvt_W0p6_L5_m2__nf1_gboth_sdfull_pc/B.n60 585
R26 nfet_01v8_lvt_W0p6_L5_m2__nf1_gboth_sdfull_pc/B.n58 nfet_01v8_lvt_W0p6_L5_m2__nf1_gboth_sdfull_pc/B.n12 585
R27 nfet_01v8_lvt_W0p6_L5_m2__nf1_gboth_sdfull_pc/B.n62 nfet_01v8_lvt_W0p6_L5_m2__nf1_gboth_sdfull_pc/B.n12 585
R28 nfet_01v8_lvt_W0p6_L5_m2__nf1_gboth_sdfull_pc/B.n86 nfet_01v8_lvt_W0p6_L5_m2__nf1_gboth_sdfull_pc/B.n85 585
R29 nfet_01v8_lvt_W0p6_L5_m2__nf1_gboth_sdfull_pc/B.n85 nfet_01v8_lvt_W0p6_L5_m2__nf1_gboth_sdfull_pc/B.n84 585
R30 nfet_01v8_lvt_W0p6_L5_m2__nf1_gboth_sdfull_pc/B.n13 nfet_01v8_lvt_W0p6_L5_m2__nf1_gboth_sdfull_pc/B.n11 585
R31 nfet_01v8_lvt_W0p6_L5_m2__nf1_gboth_sdfull_pc/B.n83 nfet_01v8_lvt_W0p6_L5_m2__nf1_gboth_sdfull_pc/B.n13 585
R32 nfet_01v8_lvt_W0p6_L5_m2__nf1_gboth_sdfull_pc/B.n81 nfet_01v8_lvt_W0p6_L5_m2__nf1_gboth_sdfull_pc/B.n3 585
R33 nfet_01v8_lvt_W0p6_L5_m2__nf1_gboth_sdfull_pc/B.n82 nfet_01v8_lvt_W0p6_L5_m2__nf1_gboth_sdfull_pc/B.n81 585
R34 nfet_01v8_lvt_W0p6_L5_m2__nf1_gboth_sdfull_pc/B.n80 nfet_01v8_lvt_W0p6_L5_m2__nf1_gboth_sdfull_pc/B.n63 585
R35 nfet_01v8_lvt_W0p6_L5_m2__nf1_gboth_sdfull_pc/B.n78 nfet_01v8_lvt_W0p6_L5_m2__nf1_gboth_sdfull_pc/B.n77 585
R36 nfet_01v8_lvt_W0p6_L5_m2__nf1_gboth_sdfull_pc/B.n76 nfet_01v8_lvt_W0p6_L5_m2__nf1_gboth_sdfull_pc/B.n64 585
R37 nfet_01v8_lvt_W0p6_L5_m2__nf1_gboth_sdfull_pc/B.n75 nfet_01v8_lvt_W0p6_L5_m2__nf1_gboth_sdfull_pc/B.n74 585
R38 nfet_01v8_lvt_W0p6_L5_m2__nf1_gboth_sdfull_pc/B.n73 nfet_01v8_lvt_W0p6_L5_m2__nf1_gboth_sdfull_pc/B.n65 585
R39 nfet_01v8_lvt_W0p6_L5_m2__nf1_gboth_sdfull_pc/B.n71 nfet_01v8_lvt_W0p6_L5_m2__nf1_gboth_sdfull_pc/B.n70 585
R40 nfet_01v8_lvt_W0p6_L5_m2__nf1_gboth_sdfull_pc/B.n69 nfet_01v8_lvt_W0p6_L5_m2__nf1_gboth_sdfull_pc/B.n68 585
R41 nfet_01v8_lvt_W0p6_L5_m2__nf1_gboth_sdfull_pc/B.n2 nfet_01v8_lvt_W0p6_L5_m2__nf1_gboth_sdfull_pc/B.n0 585
R42 nfet_01v8_lvt_W0p6_L5_m2__nf1_gboth_sdfull_pc/B.n104 nfet_01v8_lvt_W0p6_L5_m2__nf1_gboth_sdfull_pc/B.n103 585
R43 nfet_01v8_lvt_W0p6_L5_m2__nf1_gboth_sdfull_pc/B.n101 nfet_01v8_lvt_W0p6_L5_m2__nf1_gboth_sdfull_pc/B.n1 585
R44 nfet_01v8_lvt_W0p6_L5_m2__nf1_gboth_sdfull_pc/B.n100 nfet_01v8_lvt_W0p6_L5_m2__nf1_gboth_sdfull_pc/B.n4 585
R45 nfet_01v8_lvt_W0p6_L5_m2__nf1_gboth_sdfull_pc/B.n98 nfet_01v8_lvt_W0p6_L5_m2__nf1_gboth_sdfull_pc/B.n97 585
R46 nfet_01v8_lvt_W0p6_L5_m2__nf1_gboth_sdfull_pc/B.n96 nfet_01v8_lvt_W0p6_L5_m2__nf1_gboth_sdfull_pc/B.n5 585
R47 nfet_01v8_lvt_W0p6_L5_m2__nf1_gboth_sdfull_pc/B.n95 nfet_01v8_lvt_W0p6_L5_m2__nf1_gboth_sdfull_pc/B.n94 585
R48 nfet_01v8_lvt_W0p6_L5_m2__nf1_gboth_sdfull_pc/B.n93 nfet_01v8_lvt_W0p6_L5_m2__nf1_gboth_sdfull_pc/B.n6 585
R49 nfet_01v8_lvt_W0p6_L5_m2__nf1_gboth_sdfull_pc/B.n91 nfet_01v8_lvt_W0p6_L5_m2__nf1_gboth_sdfull_pc/B.n90 585
R50 nfet_01v8_lvt_W0p6_L5_m2__nf1_gboth_sdfull_pc/B.n11 nfet_01v8_lvt_W0p6_L5_m2__nf1_gboth_sdfull_pc/B.n8 585
R51 nfet_01v8_lvt_W0p6_L5_m2__nf1_gboth_sdfull_pc/B.n89 nfet_01v8_lvt_W0p6_L5_m2__nf1_gboth_sdfull_pc/B.n8 585
R52 nfet_01v8_lvt_W0p6_L5_m2__nf1_gboth_sdfull_pc/B.n87 nfet_01v8_lvt_W0p6_L5_m2__nf1_gboth_sdfull_pc/B.n86 585
R53 nfet_01v8_lvt_W0p6_L5_m2__nf1_gboth_sdfull_pc/B.n88 nfet_01v8_lvt_W0p6_L5_m2__nf1_gboth_sdfull_pc/B.n87 585
R54 nfet_01v8_lvt_W0p6_L5_m2__nf1_gboth_sdfull_pc/B.n58 nfet_01v8_lvt_W0p6_L5_m2__nf1_gboth_sdfull_pc/B.n10 585
R55 nfet_01v8_lvt_W0p6_L5_m2__nf1_gboth_sdfull_pc/B.n10 nfet_01v8_lvt_W0p6_L5_m2__nf1_gboth_sdfull_pc/B.n9 585
R56 nfet_01v8_lvt_W0p6_L5_m2__nf1_gboth_sdfull_pc/B.n59 nfet_01v8_lvt_W0p6_L5_m2__nf1_gboth_sdfull_pc/B.n57 585
R57 nfet_01v8_lvt_W0p6_L5_m2__nf1_gboth_sdfull_pc/B.n57 nfet_01v8_lvt_W0p6_L5_m2__nf1_gboth_sdfull_pc/B.n56 585
R58 nfet_01v8_lvt_W0p6_L5_m2__nf1_gboth_sdfull_pc/B.n87 nfet_01v8_lvt_W0p6_L5_m2__nf1_gboth_sdfull_pc/B.n8 394
R59 nfet_01v8_lvt_W0p6_L5_m2__nf1_gboth_sdfull_pc/B.n87 nfet_01v8_lvt_W0p6_L5_m2__nf1_gboth_sdfull_pc/B.n10 394
R60 nfet_01v8_lvt_W0p6_L5_m2__nf1_gboth_sdfull_pc/B.n57 nfet_01v8_lvt_W0p6_L5_m2__nf1_gboth_sdfull_pc/B.n10 394
R61 nfet_01v8_lvt_W0p6_L5_m2__nf1_gboth_sdfull_pc/B.n94 nfet_01v8_lvt_W0p6_L5_m2__nf1_gboth_sdfull_pc/B.n93 394
R62 nfet_01v8_lvt_W0p6_L5_m2__nf1_gboth_sdfull_pc/B.n98 nfet_01v8_lvt_W0p6_L5_m2__nf1_gboth_sdfull_pc/B.n5 394
R63 nfet_01v8_lvt_W0p6_L5_m2__nf1_gboth_sdfull_pc/B.n101 nfet_01v8_lvt_W0p6_L5_m2__nf1_gboth_sdfull_pc/B.n100 394
R64 nfet_01v8_lvt_W0p6_L5_m2__nf1_gboth_sdfull_pc/B.n103 nfet_01v8_lvt_W0p6_L5_m2__nf1_gboth_sdfull_pc/B.n2 394
R65 nfet_01v8_lvt_W0p6_L5_m2__nf1_gboth_sdfull_pc/B.n71 nfet_01v8_lvt_W0p6_L5_m2__nf1_gboth_sdfull_pc/B.n68 394
R66 nfet_01v8_lvt_W0p6_L5_m2__nf1_gboth_sdfull_pc/B.n74 nfet_01v8_lvt_W0p6_L5_m2__nf1_gboth_sdfull_pc/B.n73 394
R67 nfet_01v8_lvt_W0p6_L5_m2__nf1_gboth_sdfull_pc/B.n78 nfet_01v8_lvt_W0p6_L5_m2__nf1_gboth_sdfull_pc/B.n64 394
R68 nfet_01v8_lvt_W0p6_L5_m2__nf1_gboth_sdfull_pc/B.n81 nfet_01v8_lvt_W0p6_L5_m2__nf1_gboth_sdfull_pc/B.n80 394
R69 nfet_01v8_lvt_W0p6_L5_m2__nf1_gboth_sdfull_pc/B.n85 nfet_01v8_lvt_W0p6_L5_m2__nf1_gboth_sdfull_pc/B.n13 394
R70 nfet_01v8_lvt_W0p6_L5_m2__nf1_gboth_sdfull_pc/B.n85 nfet_01v8_lvt_W0p6_L5_m2__nf1_gboth_sdfull_pc/B.n12 394
R71 nfet_01v8_lvt_W0p6_L5_m2__nf1_gboth_sdfull_pc/B.n60 nfet_01v8_lvt_W0p6_L5_m2__nf1_gboth_sdfull_pc/B.n12 394
R72 nfet_01v8_lvt_W0p6_L5_m2__nf1_gboth_sdfull_pc/B.n53 nfet_01v8_lvt_W0p6_L5_m2__nf1_gboth_sdfull_pc/B.n17 394
R73 nfet_01v8_lvt_W0p6_L5_m2__nf1_gboth_sdfull_pc/B.n51 nfet_01v8_lvt_W0p6_L5_m2__nf1_gboth_sdfull_pc/B.n50 394
R74 nfet_01v8_lvt_W0p6_L5_m2__nf1_gboth_sdfull_pc/B.n50 nfet_01v8_lvt_W0p6_L5_m2__nf1_gboth_sdfull_pc/B.n19 394
R75 nfet_01v8_lvt_W0p6_L5_m2__nf1_gboth_sdfull_pc/B.n46 nfet_01v8_lvt_W0p6_L5_m2__nf1_gboth_sdfull_pc/B.n44 394
R76 nfet_01v8_lvt_W0p6_L5_m2__nf1_gboth_sdfull_pc/B.n42 nfet_01v8_lvt_W0p6_L5_m2__nf1_gboth_sdfull_pc/B.n21 394
R77 nfet_01v8_lvt_W0p6_L5_m2__nf1_gboth_sdfull_pc/B.n38 nfet_01v8_lvt_W0p6_L5_m2__nf1_gboth_sdfull_pc/B.n36 394
R78 nfet_01v8_lvt_W0p6_L5_m2__nf1_gboth_sdfull_pc/B.n34 nfet_01v8_lvt_W0p6_L5_m2__nf1_gboth_sdfull_pc/B.n23 394
R79 nfet_01v8_lvt_W0p6_L5_m2__nf1_gboth_sdfull_pc/B.n30 nfet_01v8_lvt_W0p6_L5_m2__nf1_gboth_sdfull_pc/B.n23 394
R80 nfet_01v8_lvt_W0p6_L5_m2__nf1_gboth_sdfull_pc/B.n28 nfet_01v8_lvt_W0p6_L5_m2__nf1_gboth_sdfull_pc/B.n27 394
R81 nfet_01v8_lvt_W0p6_L5_m2__nf1_gboth_sdfull_pc/B.n11 nfet_01v8_lvt_W0p6_L5_m2__nf1_gboth_sdfull_pc/B.n3 368.805
R82 nfet_01v8_lvt_W0p6_L5_m2__nf1_gboth_sdfull_pc/B.n59 nfet_01v8_lvt_W0p6_L5_m2__nf1_gboth_sdfull_pc/B.n16 368.805
R83 nfet_01v8_lvt_W0p6_L5_m2__nf1_gboth_sdfull_pc/B.n52 nfet_01v8_lvt_W0p6_L5_m2__nf1_gboth_sdfull_pc/B.n16 218.815
R84 nfet_01v8_lvt_W0p6_L5_m2__nf1_gboth_sdfull_pc/B.n45 nfet_01v8_lvt_W0p6_L5_m2__nf1_gboth_sdfull_pc/B.n16 218.815
R85 nfet_01v8_lvt_W0p6_L5_m2__nf1_gboth_sdfull_pc/B.n43 nfet_01v8_lvt_W0p6_L5_m2__nf1_gboth_sdfull_pc/B.n16 218.815
R86 nfet_01v8_lvt_W0p6_L5_m2__nf1_gboth_sdfull_pc/B.n37 nfet_01v8_lvt_W0p6_L5_m2__nf1_gboth_sdfull_pc/B.n16 218.815
R87 nfet_01v8_lvt_W0p6_L5_m2__nf1_gboth_sdfull_pc/B.n35 nfet_01v8_lvt_W0p6_L5_m2__nf1_gboth_sdfull_pc/B.n16 218.815
R88 nfet_01v8_lvt_W0p6_L5_m2__nf1_gboth_sdfull_pc/B.n29 nfet_01v8_lvt_W0p6_L5_m2__nf1_gboth_sdfull_pc/B.n16 218.815
R89 nfet_01v8_lvt_W0p6_L5_m2__nf1_gboth_sdfull_pc/B.n26 nfet_01v8_lvt_W0p6_L5_m2__nf1_gboth_sdfull_pc/B.n16 218.815
R90 nfet_01v8_lvt_W0p6_L5_m2__nf1_gboth_sdfull_pc/B.n79 nfet_01v8_lvt_W0p6_L5_m2__nf1_gboth_sdfull_pc/B.n3 218.815
R91 nfet_01v8_lvt_W0p6_L5_m2__nf1_gboth_sdfull_pc/B.n66 nfet_01v8_lvt_W0p6_L5_m2__nf1_gboth_sdfull_pc/B.n3 218.815
R92 nfet_01v8_lvt_W0p6_L5_m2__nf1_gboth_sdfull_pc/B.n72 nfet_01v8_lvt_W0p6_L5_m2__nf1_gboth_sdfull_pc/B.n3 218.815
R93 nfet_01v8_lvt_W0p6_L5_m2__nf1_gboth_sdfull_pc/B.n67 nfet_01v8_lvt_W0p6_L5_m2__nf1_gboth_sdfull_pc/B.n3 218.815
R94 nfet_01v8_lvt_W0p6_L5_m2__nf1_gboth_sdfull_pc/B.n102 nfet_01v8_lvt_W0p6_L5_m2__nf1_gboth_sdfull_pc/B.n3 218.815
R95 nfet_01v8_lvt_W0p6_L5_m2__nf1_gboth_sdfull_pc/B.n99 nfet_01v8_lvt_W0p6_L5_m2__nf1_gboth_sdfull_pc/B.n3 218.815
R96 nfet_01v8_lvt_W0p6_L5_m2__nf1_gboth_sdfull_pc/B.n7 nfet_01v8_lvt_W0p6_L5_m2__nf1_gboth_sdfull_pc/B.n3 218.815
R97 nfet_01v8_lvt_W0p6_L5_m2__nf1_gboth_sdfull_pc/B.n92 nfet_01v8_lvt_W0p6_L5_m2__nf1_gboth_sdfull_pc/B.n3 218.815
R98 nfet_01v8_lvt_W0p6_L5_m2__nf1_gboth_sdfull_pc/B.n86 nfet_01v8_lvt_W0p6_L5_m2__nf1_gboth_sdfull_pc/B.n11 218.077
R99 nfet_01v8_lvt_W0p6_L5_m2__nf1_gboth_sdfull_pc/B.n59 nfet_01v8_lvt_W0p6_L5_m2__nf1_gboth_sdfull_pc/B.n58 218.077
R100 nfet_01v8_lvt_W0p6_L5_m2__nf1_gboth_sdfull_pc/B.n52 nfet_01v8_lvt_W0p6_L5_m2__nf1_gboth_sdfull_pc/B.n51 147.374
R101 nfet_01v8_lvt_W0p6_L5_m2__nf1_gboth_sdfull_pc/B.n46 nfet_01v8_lvt_W0p6_L5_m2__nf1_gboth_sdfull_pc/B.n45 147.374
R102 nfet_01v8_lvt_W0p6_L5_m2__nf1_gboth_sdfull_pc/B.n43 nfet_01v8_lvt_W0p6_L5_m2__nf1_gboth_sdfull_pc/B.n42 147.374
R103 nfet_01v8_lvt_W0p6_L5_m2__nf1_gboth_sdfull_pc/B.n37 nfet_01v8_lvt_W0p6_L5_m2__nf1_gboth_sdfull_pc/B.n21 147.374
R104 nfet_01v8_lvt_W0p6_L5_m2__nf1_gboth_sdfull_pc/B.n35 nfet_01v8_lvt_W0p6_L5_m2__nf1_gboth_sdfull_pc/B.n34 147.374
R105 nfet_01v8_lvt_W0p6_L5_m2__nf1_gboth_sdfull_pc/B.n30 nfet_01v8_lvt_W0p6_L5_m2__nf1_gboth_sdfull_pc/B.n29 147.374
R106 nfet_01v8_lvt_W0p6_L5_m2__nf1_gboth_sdfull_pc/B.n27 nfet_01v8_lvt_W0p6_L5_m2__nf1_gboth_sdfull_pc/B.n26 147.374
R107 nfet_01v8_lvt_W0p6_L5_m2__nf1_gboth_sdfull_pc/B.n80 nfet_01v8_lvt_W0p6_L5_m2__nf1_gboth_sdfull_pc/B.n79 147.374
R108 nfet_01v8_lvt_W0p6_L5_m2__nf1_gboth_sdfull_pc/B.n66 nfet_01v8_lvt_W0p6_L5_m2__nf1_gboth_sdfull_pc/B.n64 147.374
R109 nfet_01v8_lvt_W0p6_L5_m2__nf1_gboth_sdfull_pc/B.n73 nfet_01v8_lvt_W0p6_L5_m2__nf1_gboth_sdfull_pc/B.n72 147.374
R110 nfet_01v8_lvt_W0p6_L5_m2__nf1_gboth_sdfull_pc/B.n68 nfet_01v8_lvt_W0p6_L5_m2__nf1_gboth_sdfull_pc/B.n67 147.374
R111 nfet_01v8_lvt_W0p6_L5_m2__nf1_gboth_sdfull_pc/B.n103 nfet_01v8_lvt_W0p6_L5_m2__nf1_gboth_sdfull_pc/B.n102 147.374
R112 nfet_01v8_lvt_W0p6_L5_m2__nf1_gboth_sdfull_pc/B.n100 nfet_01v8_lvt_W0p6_L5_m2__nf1_gboth_sdfull_pc/B.n99 147.374
R113 nfet_01v8_lvt_W0p6_L5_m2__nf1_gboth_sdfull_pc/B.n7 nfet_01v8_lvt_W0p6_L5_m2__nf1_gboth_sdfull_pc/B.n5 147.374
R114 nfet_01v8_lvt_W0p6_L5_m2__nf1_gboth_sdfull_pc/B.n93 nfet_01v8_lvt_W0p6_L5_m2__nf1_gboth_sdfull_pc/B.n92 147.374
R115 nfet_01v8_lvt_W0p6_L5_m2__nf1_gboth_sdfull_pc/B.n92 nfet_01v8_lvt_W0p6_L5_m2__nf1_gboth_sdfull_pc/B.n91 147.374
R116 nfet_01v8_lvt_W0p6_L5_m2__nf1_gboth_sdfull_pc/B.n94 nfet_01v8_lvt_W0p6_L5_m2__nf1_gboth_sdfull_pc/B.n7 147.374
R117 nfet_01v8_lvt_W0p6_L5_m2__nf1_gboth_sdfull_pc/B.n99 nfet_01v8_lvt_W0p6_L5_m2__nf1_gboth_sdfull_pc/B.n98 147.374
R118 nfet_01v8_lvt_W0p6_L5_m2__nf1_gboth_sdfull_pc/B.n102 nfet_01v8_lvt_W0p6_L5_m2__nf1_gboth_sdfull_pc/B.n101 147.374
R119 nfet_01v8_lvt_W0p6_L5_m2__nf1_gboth_sdfull_pc/B.n67 nfet_01v8_lvt_W0p6_L5_m2__nf1_gboth_sdfull_pc/B.n2 147.374
R120 nfet_01v8_lvt_W0p6_L5_m2__nf1_gboth_sdfull_pc/B.n72 nfet_01v8_lvt_W0p6_L5_m2__nf1_gboth_sdfull_pc/B.n71 147.374
R121 nfet_01v8_lvt_W0p6_L5_m2__nf1_gboth_sdfull_pc/B.n74 nfet_01v8_lvt_W0p6_L5_m2__nf1_gboth_sdfull_pc/B.n66 147.374
R122 nfet_01v8_lvt_W0p6_L5_m2__nf1_gboth_sdfull_pc/B.n79 nfet_01v8_lvt_W0p6_L5_m2__nf1_gboth_sdfull_pc/B.n78 147.374
R123 nfet_01v8_lvt_W0p6_L5_m2__nf1_gboth_sdfull_pc/B.n53 nfet_01v8_lvt_W0p6_L5_m2__nf1_gboth_sdfull_pc/B.n52 147.374
R124 nfet_01v8_lvt_W0p6_L5_m2__nf1_gboth_sdfull_pc/B.n45 nfet_01v8_lvt_W0p6_L5_m2__nf1_gboth_sdfull_pc/B.n19 147.374
R125 nfet_01v8_lvt_W0p6_L5_m2__nf1_gboth_sdfull_pc/B.n44 nfet_01v8_lvt_W0p6_L5_m2__nf1_gboth_sdfull_pc/B.n43 147.374
R126 nfet_01v8_lvt_W0p6_L5_m2__nf1_gboth_sdfull_pc/B.n38 nfet_01v8_lvt_W0p6_L5_m2__nf1_gboth_sdfull_pc/B.n37 147.374
R127 nfet_01v8_lvt_W0p6_L5_m2__nf1_gboth_sdfull_pc/B.n36 nfet_01v8_lvt_W0p6_L5_m2__nf1_gboth_sdfull_pc/B.n35 147.374
R128 nfet_01v8_lvt_W0p6_L5_m2__nf1_gboth_sdfull_pc/B.n29 nfet_01v8_lvt_W0p6_L5_m2__nf1_gboth_sdfull_pc/B.n28 147.374
R129 nfet_01v8_lvt_W0p6_L5_m2__nf1_gboth_sdfull_pc/B.n26 nfet_01v8_lvt_W0p6_L5_m2__nf1_gboth_sdfull_pc/B.n15 147.374
R130 nfet_01v8_lvt_W0p6_L5_m2__nf1_gboth_sdfull_pc/B.n3 B 137.901
R131 nfet_01v8_lvt_W0p6_L5_m2__nf1_gboth_sdfull_pc/B.n86 nfet_01v8_lvt_W0p6_L5_m2__nf1_gboth_sdfull_pc/B.t0 109.038
R132 nfet_01v8_lvt_W0p6_L5_m2__nf1_gboth_sdfull_pc/B.n58 nfet_01v8_lvt_W0p6_L5_m2__nf1_gboth_sdfull_pc/B.t0 109.038
R133 nfet_01v8_lvt_W0p6_L5_m2__nf1_gboth_sdfull_pc/B.n90 nfet_01v8_lvt_W0p6_L5_m2__nf1_gboth_sdfull_pc/B.n89 74.1652
R134 nfet_01v8_lvt_W0p6_L5_m2__nf1_gboth_sdfull_pc/B.n83 nfet_01v8_lvt_W0p6_L5_m2__nf1_gboth_sdfull_pc/B.n82 74.1652
R135 nfet_01v8_lvt_W0p6_L5_m2__nf1_gboth_sdfull_pc/B.n56 nfet_01v8_lvt_W0p6_L5_m2__nf1_gboth_sdfull_pc/B.n55 74.1652
R136 nfet_01v8_lvt_W0p6_L5_m2__nf1_gboth_sdfull_pc/B.n61 nfet_01v8_lvt_W0p6_L5_m2__nf1_gboth_sdfull_pc/B.n14 74.1652
R137 nfet_01v8_lvt_W0p6_L5_m2__nf1_gboth_sdfull_pc/B.n89 nfet_01v8_lvt_W0p6_L5_m2__nf1_gboth_sdfull_pc/B.n88 25.6005
R138 nfet_01v8_lvt_W0p6_L5_m2__nf1_gboth_sdfull_pc/B.n88 nfet_01v8_lvt_W0p6_L5_m2__nf1_gboth_sdfull_pc/B.n9 25.6005
R139 nfet_01v8_lvt_W0p6_L5_m2__nf1_gboth_sdfull_pc/B.n56 nfet_01v8_lvt_W0p6_L5_m2__nf1_gboth_sdfull_pc/B.n9 25.6005
R140 nfet_01v8_lvt_W0p6_L5_m2__nf1_gboth_sdfull_pc/B.n90 nfet_01v8_lvt_W0p6_L5_m2__nf1_gboth_sdfull_pc/B.n6 25.6005
R141 nfet_01v8_lvt_W0p6_L5_m2__nf1_gboth_sdfull_pc/B.n95 nfet_01v8_lvt_W0p6_L5_m2__nf1_gboth_sdfull_pc/B.n6 25.6005
R142 nfet_01v8_lvt_W0p6_L5_m2__nf1_gboth_sdfull_pc/B.n96 nfet_01v8_lvt_W0p6_L5_m2__nf1_gboth_sdfull_pc/B.n95 25.6005
R143 nfet_01v8_lvt_W0p6_L5_m2__nf1_gboth_sdfull_pc/B.n97 nfet_01v8_lvt_W0p6_L5_m2__nf1_gboth_sdfull_pc/B.n96 25.6005
R144 nfet_01v8_lvt_W0p6_L5_m2__nf1_gboth_sdfull_pc/B.n97 nfet_01v8_lvt_W0p6_L5_m2__nf1_gboth_sdfull_pc/B.n4 25.6005
R145 nfet_01v8_lvt_W0p6_L5_m2__nf1_gboth_sdfull_pc/B.n4 nfet_01v8_lvt_W0p6_L5_m2__nf1_gboth_sdfull_pc/B.n1 25.6005
R146 nfet_01v8_lvt_W0p6_L5_m2__nf1_gboth_sdfull_pc/B.n104 nfet_01v8_lvt_W0p6_L5_m2__nf1_gboth_sdfull_pc/B.n1 25.6005
R147 nfet_01v8_lvt_W0p6_L5_m2__nf1_gboth_sdfull_pc/B.n69 nfet_01v8_lvt_W0p6_L5_m2__nf1_gboth_sdfull_pc/B.n0 25.6005
R148 nfet_01v8_lvt_W0p6_L5_m2__nf1_gboth_sdfull_pc/B.n70 nfet_01v8_lvt_W0p6_L5_m2__nf1_gboth_sdfull_pc/B.n69 25.6005
R149 nfet_01v8_lvt_W0p6_L5_m2__nf1_gboth_sdfull_pc/B.n70 nfet_01v8_lvt_W0p6_L5_m2__nf1_gboth_sdfull_pc/B.n65 25.6005
R150 nfet_01v8_lvt_W0p6_L5_m2__nf1_gboth_sdfull_pc/B.n75 nfet_01v8_lvt_W0p6_L5_m2__nf1_gboth_sdfull_pc/B.n65 25.6005
R151 nfet_01v8_lvt_W0p6_L5_m2__nf1_gboth_sdfull_pc/B.n76 nfet_01v8_lvt_W0p6_L5_m2__nf1_gboth_sdfull_pc/B.n75 25.6005
R152 nfet_01v8_lvt_W0p6_L5_m2__nf1_gboth_sdfull_pc/B.n77 nfet_01v8_lvt_W0p6_L5_m2__nf1_gboth_sdfull_pc/B.n76 25.6005
R153 nfet_01v8_lvt_W0p6_L5_m2__nf1_gboth_sdfull_pc/B.n77 nfet_01v8_lvt_W0p6_L5_m2__nf1_gboth_sdfull_pc/B.n63 25.6005
R154 nfet_01v8_lvt_W0p6_L5_m2__nf1_gboth_sdfull_pc/B.n82 nfet_01v8_lvt_W0p6_L5_m2__nf1_gboth_sdfull_pc/B.n63 25.6005
R155 nfet_01v8_lvt_W0p6_L5_m2__nf1_gboth_sdfull_pc/B.n84 nfet_01v8_lvt_W0p6_L5_m2__nf1_gboth_sdfull_pc/B.n83 25.6005
R156 nfet_01v8_lvt_W0p6_L5_m2__nf1_gboth_sdfull_pc/B.n84 nfet_01v8_lvt_W0p6_L5_m2__nf1_gboth_sdfull_pc/B.n62 25.6005
R157 nfet_01v8_lvt_W0p6_L5_m2__nf1_gboth_sdfull_pc/B.n62 nfet_01v8_lvt_W0p6_L5_m2__nf1_gboth_sdfull_pc/B.n61 25.6005
R158 nfet_01v8_lvt_W0p6_L5_m2__nf1_gboth_sdfull_pc/B.n55 nfet_01v8_lvt_W0p6_L5_m2__nf1_gboth_sdfull_pc/B.n54 25.6005
R159 nfet_01v8_lvt_W0p6_L5_m2__nf1_gboth_sdfull_pc/B.n54 nfet_01v8_lvt_W0p6_L5_m2__nf1_gboth_sdfull_pc/B.n18 25.6005
R160 nfet_01v8_lvt_W0p6_L5_m2__nf1_gboth_sdfull_pc/B.n49 nfet_01v8_lvt_W0p6_L5_m2__nf1_gboth_sdfull_pc/B.n18 25.6005
R161 nfet_01v8_lvt_W0p6_L5_m2__nf1_gboth_sdfull_pc/B.n49 nfet_01v8_lvt_W0p6_L5_m2__nf1_gboth_sdfull_pc/B.n48 25.6005
R162 nfet_01v8_lvt_W0p6_L5_m2__nf1_gboth_sdfull_pc/B.n48 nfet_01v8_lvt_W0p6_L5_m2__nf1_gboth_sdfull_pc/B.n47 25.6005
R163 nfet_01v8_lvt_W0p6_L5_m2__nf1_gboth_sdfull_pc/B.n47 nfet_01v8_lvt_W0p6_L5_m2__nf1_gboth_sdfull_pc/B.n20 25.6005
R164 nfet_01v8_lvt_W0p6_L5_m2__nf1_gboth_sdfull_pc/B.n41 nfet_01v8_lvt_W0p6_L5_m2__nf1_gboth_sdfull_pc/B.n20 25.6005
R165 nfet_01v8_lvt_W0p6_L5_m2__nf1_gboth_sdfull_pc/B.n41 nfet_01v8_lvt_W0p6_L5_m2__nf1_gboth_sdfull_pc/B.n40 25.6005
R166 nfet_01v8_lvt_W0p6_L5_m2__nf1_gboth_sdfull_pc/B.n40 nfet_01v8_lvt_W0p6_L5_m2__nf1_gboth_sdfull_pc/B.n39 25.6005
R167 nfet_01v8_lvt_W0p6_L5_m2__nf1_gboth_sdfull_pc/B.n39 nfet_01v8_lvt_W0p6_L5_m2__nf1_gboth_sdfull_pc/B.n22 25.6005
R168 nfet_01v8_lvt_W0p6_L5_m2__nf1_gboth_sdfull_pc/B.n33 nfet_01v8_lvt_W0p6_L5_m2__nf1_gboth_sdfull_pc/B.n22 25.6005
R169 nfet_01v8_lvt_W0p6_L5_m2__nf1_gboth_sdfull_pc/B.n33 nfet_01v8_lvt_W0p6_L5_m2__nf1_gboth_sdfull_pc/B.n32 25.6005
R170 nfet_01v8_lvt_W0p6_L5_m2__nf1_gboth_sdfull_pc/B.n32 nfet_01v8_lvt_W0p6_L5_m2__nf1_gboth_sdfull_pc/B.n31 25.6005
R171 nfet_01v8_lvt_W0p6_L5_m2__nf1_gboth_sdfull_pc/B.n31 nfet_01v8_lvt_W0p6_L5_m2__nf1_gboth_sdfull_pc/B.n24 25.6005
R172 nfet_01v8_lvt_W0p6_L5_m2__nf1_gboth_sdfull_pc/B.n25 nfet_01v8_lvt_W0p6_L5_m2__nf1_gboth_sdfull_pc/B.n24 25.6005
R173 nfet_01v8_lvt_W0p6_L5_m2__nf1_gboth_sdfull_pc/B.n25 nfet_01v8_lvt_W0p6_L5_m2__nf1_gboth_sdfull_pc/B.n14 25.6005
R174 B nfet_01v8_lvt_W0p6_L5_m2__nf1_gboth_sdfull_pc/B.n104 19.2005
R175 B nfet_01v8_lvt_W0p6_L5_m2__nf1_gboth_sdfull_pc/B.n0 6.4005
R176 B.n47 B.n37 1141.44
R177 B.n98 B.n97 1141.44
R178 B.n104 B.n3 1141.44
R179 B.n40 B.n35 1141.44
R180 B.n106 B.n0 837.692
R181 B.n45 B.n36 837.692
R182 B.n37 B.n36 585
R183 B.n49 B.n37 585
R184 B.n52 B.n51 585
R185 B.n51 B.n50 585
R186 B.n32 B.n31 585
R187 B.n31 B.n30 585
R188 B.n59 B.n58 585
R189 B.n60 B.n59 585
R190 B.n29 B.n28 585
R191 B.n61 B.n29 585
R192 B.n64 B.n63 585
R193 B.n63 B.n62 585
R194 B.n24 B.n23 585
R195 B.n23 B.n22 585
R196 B.n71 B.n70 585
R197 B.n72 B.n71 585
R198 B.n21 B.n20 585
R199 B.n73 B.n21 585
R200 B.n76 B.n75 585
R201 B.n75 B.n74 585
R202 B.n16 B.n15 585
R203 B.n15 B.n14 585
R204 B.n83 B.n82 585
R205 B.n84 B.n83 585
R206 B.n13 B.n12 585
R207 B.n85 B.n13 585
R208 B.n89 B.n88 585
R209 B.n88 B.n87 585
R210 B.n8 B.n6 585
R211 B.n86 B.n6 585
R212 B.n96 B.n95 585
R213 B.n96 B.n7 585
R214 B.n97 B.n0 585
R215 B.n97 B.n5 585
R216 B.n99 B.n98 585
R217 B.n101 B.n100 585
R218 B.n102 B.n2 585
R219 B.n104 B.n103 585
R220 B.n3 B.n0 585
R221 B.n4 B.n3 585
R222 B.n95 B.n94 585
R223 B.n94 B.n93 585
R224 B.n9 B.n8 585
R225 B.n92 B.n9 585
R226 B.n90 B.n89 585
R227 B.n91 B.n90 585
R228 B.n12 B.n11 585
R229 B.n11 B.n10 585
R230 B.n82 B.n81 585
R231 B.n81 B.n80 585
R232 B.n17 B.n16 585
R233 B.n79 B.n17 585
R234 B.n77 B.n76 585
R235 B.n78 B.n77 585
R236 B.n20 B.n19 585
R237 B.n19 B.n18 585
R238 B.n70 B.n69 585
R239 B.n69 B.n68 585
R240 B.n25 B.n24 585
R241 B.n67 B.n25 585
R242 B.n65 B.n64 585
R243 B.n66 B.n65 585
R244 B.n28 B.n27 585
R245 B.n27 B.n26 585
R246 B.n58 B.n57 585
R247 B.n57 B.n56 585
R248 B.n33 B.n32 585
R249 B.n55 B.n33 585
R250 B.n53 B.n52 585
R251 B.n54 B.n53 585
R252 B.n36 B.n35 585
R253 B.n35 B.n34 585
R254 B.n41 B.n40 585
R255 B.n43 B.n42 585
R256 B.n39 B.n38 585
R257 B.n48 B.n47 585
R258 B.n95 B.n0 575.385
R259 B.n95 B.n8 575.385
R260 B.n89 B.n8 575.385
R261 B.n89 B.n12 575.385
R262 B.n82 B.n12 575.385
R263 B.n82 B.n16 575.385
R264 B.n76 B.n16 575.385
R265 B.n76 B.n20 575.385
R266 B.n70 B.n20 575.385
R267 B.n70 B.n24 575.385
R268 B.n64 B.n24 575.385
R269 B.n64 B.n28 575.385
R270 B.n58 B.n28 575.385
R271 B.n58 B.n32 575.385
R272 B.n52 B.n32 575.385
R273 B.n52 B.n36 575.385
R274 B.n43 B.n39 394
R275 B.n97 B.n96 394
R276 B.n96 B.n6 394
R277 B.n88 B.n6 394
R278 B.n88 B.n13 394
R279 B.n83 B.n13 394
R280 B.n83 B.n15 394
R281 B.n75 B.n15 394
R282 B.n75 B.n21 394
R283 B.n71 B.n21 394
R284 B.n71 B.n23 394
R285 B.n63 B.n23 394
R286 B.n63 B.n29 394
R287 B.n59 B.n29 394
R288 B.n59 B.n31 394
R289 B.n51 B.n31 394
R290 B.n51 B.n37 394
R291 B.n100 B.n2 394
R292 B.n94 B.n3 394
R293 B.n94 B.n9 394
R294 B.n90 B.n9 394
R295 B.n90 B.n11 394
R296 B.n81 B.n11 394
R297 B.n81 B.n17 394
R298 B.n77 B.n17 394
R299 B.n77 B.n19 394
R300 B.n69 B.n19 394
R301 B.n69 B.n25 394
R302 B.n65 B.n25 394
R303 B.n65 B.n27 394
R304 B.n57 B.n27 394
R305 B.n57 B.n33 394
R306 B.n53 B.n33 394
R307 B.n53 B.n35 394
R308 B B.n106 363.846
R309 B.n106 B.n1 218.815
R310 B.n106 B.n105 218.815
R311 B.n45 B.n44 218.815
R312 B.n46 B.n45 218.815
R313 B.n98 B.n1 147.374
R314 B.n105 B.n2 147.374
R315 B.n44 B.n43 147.374
R316 B.n47 B.n46 147.374
R317 B.n46 B.n39 147.374
R318 B.n44 B.n40 147.374
R319 B.n100 B.n1 147.374
R320 B.n105 B.n104 147.374
R321 B.n99 B.n5 74.1652
R322 B.n103 B.n4 74.1652
R323 B.n49 B.n48 74.1652
R324 B.n41 B.n34 74.1652
R325 B.n7 B.n5 25.6005
R326 B.n86 B.n7 25.6005
R327 B.n87 B.n86 25.6005
R328 B.n87 B.n85 25.6005
R329 B.n85 B.n84 25.6005
R330 B.n84 B.n14 25.6005
R331 B.n74 B.n14 25.6005
R332 B.n73 B.n72 25.6005
R333 B.n72 B.n22 25.6005
R334 B.n62 B.n22 25.6005
R335 B.n62 B.n61 25.6005
R336 B.n61 B.n60 25.6005
R337 B.n60 B.n30 25.6005
R338 B.n50 B.n30 25.6005
R339 B.n50 B.n49 25.6005
R340 B.n101 B.n99 25.6005
R341 B.n102 B.n101 25.6005
R342 B.n103 B.n102 25.6005
R343 B.n93 B.n4 25.6005
R344 B.n93 B.n92 25.6005
R345 B.n92 B.n91 25.6005
R346 B.n91 B.n10 25.6005
R347 B.n80 B.n10 25.6005
R348 B.n80 B.n79 25.6005
R349 B.n79 B.n78 25.6005
R350 B.n78 B.n18 25.6005
R351 B.n68 B.n18 25.6005
R352 B.n68 B.n67 25.6005
R353 B.n67 B.n66 25.6005
R354 B.n66 B.n26 25.6005
R355 B.n56 B.n26 25.6005
R356 B.n56 B.n55 25.6005
R357 B.n55 B.n54 25.6005
R358 B.n54 B.n34 25.6005
R359 B.n48 B.n38 25.6005
R360 B.n42 B.n38 25.6005
R361 B.n42 B.n41 25.6005
R362 B.n74 B 19.2005
R363 B B.n73 6.4005
R364 w_n43_n43.n80 w_n43_n43.n70 1141.44
R365 w_n43_n43.n28 w_n43_n43.n21 1141.44
R366 w_n43_n43.n86 w_n43_n43.n68 1141.44
R367 w_n43_n43.n33 w_n43_n43.n23 1141.44
R368 w_n43_n43.n89 w_n43_n43.n88 837.692
R369 w_n43_n43.n25 w_n43_n43.n22 837.692
R370 w_n43_n43.n89 w_n43_n43.n68 585
R371 w_n43_n43.n68 w_n43_n43.n67 585
R372 w_n43_n43.n91 w_n43_n43.n90 585
R373 w_n43_n43.n92 w_n43_n43.n91 585
R374 w_n43_n43.n66 w_n43_n43.n65 585
R375 w_n43_n43.n93 w_n43_n43.n66 585
R376 w_n43_n43.n96 w_n43_n43.n95 585
R377 w_n43_n43.n95 w_n43_n43.n94 585
R378 w_n43_n43.n97 w_n43_n43.n61 585
R379 w_n43_n43.n61 w_n43_n43.n60 585
R380 w_n43_n43.n99 w_n43_n43.n98 585
R381 w_n43_n43.n100 w_n43_n43.n99 585
R382 w_n43_n43.n7 w_n43_n43.n5 585
R383 w_n43_n43.n101 w_n43_n43.n7 585
R384 w_n43_n43.n104 w_n43_n43.n103 585
R385 w_n43_n43.n103 w_n43_n43.n102 585
R386 w_n43_n43.n6 w_n43_n43.n4 585
R387 w_n43_n43.n59 w_n43_n43.n6 585
R388 w_n43_n43.n57 w_n43_n43.n56 585
R389 w_n43_n43.n58 w_n43_n43.n57 585
R390 w_n43_n43.n10 w_n43_n43.n9 585
R391 w_n43_n43.n9 w_n43_n43.n8 585
R392 w_n43_n43.n50 w_n43_n43.n49 585
R393 w_n43_n43.n49 w_n43_n43.n48 585
R394 w_n43_n43.n15 w_n43_n43.n14 585
R395 w_n43_n43.n47 w_n43_n43.n15 585
R396 w_n43_n43.n45 w_n43_n43.n44 585
R397 w_n43_n43.n46 w_n43_n43.n45 585
R398 w_n43_n43.n18 w_n43_n43.n17 585
R399 w_n43_n43.n17 w_n43_n43.n16 585
R400 w_n43_n43.n38 w_n43_n43.n37 585
R401 w_n43_n43.n37 w_n43_n43.n36 585
R402 w_n43_n43.n23 w_n43_n43.n22 585
R403 w_n43_n43.n35 w_n43_n43.n23 585
R404 w_n43_n43.n34 w_n43_n43.n33 585
R405 w_n43_n43.n31 w_n43_n43.n24 585
R406 w_n43_n43.n30 w_n43_n43.n26 585
R407 w_n43_n43.n28 w_n43_n43.n27 585
R408 w_n43_n43.n22 w_n43_n43.n21 585
R409 w_n43_n43.n21 w_n43_n43.n20 585
R410 w_n43_n43.n39 w_n43_n43.n38 585
R411 w_n43_n43.n40 w_n43_n43.n39 585
R412 w_n43_n43.n19 w_n43_n43.n18 585
R413 w_n43_n43.n41 w_n43_n43.n19 585
R414 w_n43_n43.n44 w_n43_n43.n43 585
R415 w_n43_n43.n43 w_n43_n43.n42 585
R416 w_n43_n43.n14 w_n43_n43.n13 585
R417 w_n43_n43.n13 w_n43_n43.n12 585
R418 w_n43_n43.n51 w_n43_n43.n50 585
R419 w_n43_n43.n52 w_n43_n43.n51 585
R420 w_n43_n43.n11 w_n43_n43.n10 585
R421 w_n43_n43.n53 w_n43_n43.n11 585
R422 w_n43_n43.n56 w_n43_n43.n55 585
R423 w_n43_n43.n55 w_n43_n43.n54 585
R424 w_n43_n43.n4 w_n43_n43.n2 585
R425 w_n43_n43.n2 w_n43_n43.n0 585
R426 w_n43_n43.n105 w_n43_n43.n104 585
R427 w_n43_n43.n106 w_n43_n43.n105 585
R428 w_n43_n43.n5 w_n43_n43.n3 585
R429 w_n43_n43.n3 w_n43_n43.n1 585
R430 w_n43_n43.n98 w_n43_n43.n62 585
R431 w_n43_n43.n73 w_n43_n43.n62 585
R432 w_n43_n43.n97 w_n43_n43.n63 585
R433 w_n43_n43.n74 w_n43_n43.n63 585
R434 w_n43_n43.n96 w_n43_n43.n64 585
R435 w_n43_n43.n75 w_n43_n43.n64 585
R436 w_n43_n43.n76 w_n43_n43.n65 585
R437 w_n43_n43.n77 w_n43_n43.n76 585
R438 w_n43_n43.n90 w_n43_n43.n69 585
R439 w_n43_n43.n78 w_n43_n43.n69 585
R440 w_n43_n43.n89 w_n43_n43.n70 585
R441 w_n43_n43.n79 w_n43_n43.n70 585
R442 w_n43_n43.n81 w_n43_n43.n80 585
R443 w_n43_n43.n83 w_n43_n43.n82 585
R444 w_n43_n43.n84 w_n43_n43.n72 585
R445 w_n43_n43.n86 w_n43_n43.n85 585
R446 w_n43_n43.n90 w_n43_n43.n89 575.385
R447 w_n43_n43.n90 w_n43_n43.n65 575.385
R448 w_n43_n43.n96 w_n43_n43.n65 575.385
R449 w_n43_n43.n97 w_n43_n43.n96 575.385
R450 w_n43_n43.n98 w_n43_n43.n97 575.385
R451 w_n43_n43.n98 w_n43_n43.n5 575.385
R452 w_n43_n43.n104 w_n43_n43.n5 575.385
R453 w_n43_n43.n104 w_n43_n43.n4 575.385
R454 w_n43_n43.n56 w_n43_n43.n4 575.385
R455 w_n43_n43.n56 w_n43_n43.n10 575.385
R456 w_n43_n43.n50 w_n43_n43.n10 575.385
R457 w_n43_n43.n50 w_n43_n43.n14 575.385
R458 w_n43_n43.n44 w_n43_n43.n14 575.385
R459 w_n43_n43.n44 w_n43_n43.n18 575.385
R460 w_n43_n43.n38 w_n43_n43.n18 575.385
R461 w_n43_n43.n38 w_n43_n43.n22 575.385
R462 w_n43_n43.n82 w_n43_n43.n72 394
R463 w_n43_n43.n70 w_n43_n43.n69 394
R464 w_n43_n43.n76 w_n43_n43.n69 394
R465 w_n43_n43.n76 w_n43_n43.n64 394
R466 w_n43_n43.n64 w_n43_n43.n63 394
R467 w_n43_n43.n63 w_n43_n43.n62 394
R468 w_n43_n43.n62 w_n43_n43.n3 394
R469 w_n43_n43.n105 w_n43_n43.n3 394
R470 w_n43_n43.n105 w_n43_n43.n2 394
R471 w_n43_n43.n55 w_n43_n43.n2 394
R472 w_n43_n43.n55 w_n43_n43.n11 394
R473 w_n43_n43.n51 w_n43_n43.n11 394
R474 w_n43_n43.n51 w_n43_n43.n13 394
R475 w_n43_n43.n43 w_n43_n43.n13 394
R476 w_n43_n43.n43 w_n43_n43.n19 394
R477 w_n43_n43.n39 w_n43_n43.n19 394
R478 w_n43_n43.n39 w_n43_n43.n21 394
R479 w_n43_n43.n31 w_n43_n43.n30 394
R480 w_n43_n43.n91 w_n43_n43.n68 394
R481 w_n43_n43.n91 w_n43_n43.n66 394
R482 w_n43_n43.n95 w_n43_n43.n66 394
R483 w_n43_n43.n95 w_n43_n43.n61 394
R484 w_n43_n43.n99 w_n43_n43.n61 394
R485 w_n43_n43.n99 w_n43_n43.n7 394
R486 w_n43_n43.n103 w_n43_n43.n7 394
R487 w_n43_n43.n103 w_n43_n43.n6 394
R488 w_n43_n43.n57 w_n43_n43.n6 394
R489 w_n43_n43.n57 w_n43_n43.n9 394
R490 w_n43_n43.n49 w_n43_n43.n9 394
R491 w_n43_n43.n49 w_n43_n43.n15 394
R492 w_n43_n43.n45 w_n43_n43.n15 394
R493 w_n43_n43.n45 w_n43_n43.n17 394
R494 w_n43_n43.n37 w_n43_n43.n17 394
R495 w_n43_n43.n37 w_n43_n43.n23 394
R496 w_n43_n43.n88 B 363.846
R497 w_n43_n43.n32 w_n43_n43.n25 218.815
R498 w_n43_n43.n29 w_n43_n43.n25 218.815
R499 w_n43_n43.n88 w_n43_n43.n71 218.815
R500 w_n43_n43.n88 w_n43_n43.n87 218.815
R501 w_n43_n43.n33 w_n43_n43.n32 147.374
R502 w_n43_n43.n30 w_n43_n43.n29 147.374
R503 w_n43_n43.n80 w_n43_n43.n71 147.374
R504 w_n43_n43.n87 w_n43_n43.n72 147.374
R505 w_n43_n43.n82 w_n43_n43.n71 147.374
R506 w_n43_n43.n87 w_n43_n43.n86 147.374
R507 w_n43_n43.n29 w_n43_n43.n28 147.374
R508 w_n43_n43.n32 w_n43_n43.n31 147.374
R509 w_n43_n43.n81 w_n43_n43.n79 74.1652
R510 w_n43_n43.n27 w_n43_n43.n20 74.1652
R511 w_n43_n43.n85 w_n43_n43.n67 74.1652
R512 w_n43_n43.n35 w_n43_n43.n34 74.1652
R513 w_n43_n43.n83 w_n43_n43.n81 25.6005
R514 w_n43_n43.n84 w_n43_n43.n83 25.6005
R515 w_n43_n43.n85 w_n43_n43.n84 25.6005
R516 w_n43_n43.n79 w_n43_n43.n78 25.6005
R517 w_n43_n43.n78 w_n43_n43.n77 25.6005
R518 w_n43_n43.n77 w_n43_n43.n75 25.6005
R519 w_n43_n43.n75 w_n43_n43.n74 25.6005
R520 w_n43_n43.n74 w_n43_n43.n73 25.6005
R521 w_n43_n43.n73 w_n43_n43.n1 25.6005
R522 w_n43_n43.n106 w_n43_n43.n1 25.6005
R523 w_n43_n43.n54 w_n43_n43.n0 25.6005
R524 w_n43_n43.n54 w_n43_n43.n53 25.6005
R525 w_n43_n43.n53 w_n43_n43.n52 25.6005
R526 w_n43_n43.n52 w_n43_n43.n12 25.6005
R527 w_n43_n43.n42 w_n43_n43.n12 25.6005
R528 w_n43_n43.n42 w_n43_n43.n41 25.6005
R529 w_n43_n43.n41 w_n43_n43.n40 25.6005
R530 w_n43_n43.n40 w_n43_n43.n20 25.6005
R531 w_n43_n43.n27 w_n43_n43.n26 25.6005
R532 w_n43_n43.n26 w_n43_n43.n24 25.6005
R533 w_n43_n43.n34 w_n43_n43.n24 25.6005
R534 w_n43_n43.n92 w_n43_n43.n67 25.6005
R535 w_n43_n43.n93 w_n43_n43.n92 25.6005
R536 w_n43_n43.n94 w_n43_n43.n93 25.6005
R537 w_n43_n43.n94 w_n43_n43.n60 25.6005
R538 w_n43_n43.n100 w_n43_n43.n60 25.6005
R539 w_n43_n43.n101 w_n43_n43.n100 25.6005
R540 w_n43_n43.n102 w_n43_n43.n101 25.6005
R541 w_n43_n43.n102 w_n43_n43.n59 25.6005
R542 w_n43_n43.n59 w_n43_n43.n58 25.6005
R543 w_n43_n43.n58 w_n43_n43.n8 25.6005
R544 w_n43_n43.n48 w_n43_n43.n8 25.6005
R545 w_n43_n43.n48 w_n43_n43.n47 25.6005
R546 w_n43_n43.n47 w_n43_n43.n46 25.6005
R547 w_n43_n43.n46 w_n43_n43.n16 25.6005
R548 w_n43_n43.n36 w_n43_n43.n16 25.6005
R549 w_n43_n43.n36 w_n43_n43.n35 25.6005
R550 B w_n43_n43.n106 19.2005
R551 B w_n43_n43.n0 6.4005
C3 B.n0 B 0 ; **FLOATING
C4 B.n2 B 0 ; **FLOATING
C5 B.n3 B 0 ; **FLOATING
C6 B.n4 B 0 ; **FLOATING
C7 B.n5 B 0 ; **FLOATING
C8 B.n6 B 0 ; **FLOATING
C9 B.n7 B 0 ; **FLOATING
C10 B.n8 B 0 ; **FLOATING
C11 B.n9 B 0 ; **FLOATING
C12 B.n10 B 0 ; **FLOATING
C13 B.n11 B 0 ; **FLOATING
C14 B.n12 B 0 ; **FLOATING
C15 B.n13 B 0 ; **FLOATING
C16 B.n14 B 0 ; **FLOATING
C17 B.n15 B 0 ; **FLOATING
C18 B.n16 B 0 ; **FLOATING
C19 B.n17 B 0 ; **FLOATING
C20 B.n18 B 0 ; **FLOATING
C21 B.n19 B 0 ; **FLOATING
C22 B.n20 B 0 ; **FLOATING
C23 B.n21 B 0 ; **FLOATING
C24 B.n22 B 0 ; **FLOATING
C25 B.n23 B 0 ; **FLOATING
C26 B.n24 B 0 ; **FLOATING
C27 B.n25 B 0 ; **FLOATING
C28 B.n26 B 0 ; **FLOATING
C29 B.n27 B 0 ; **FLOATING
C30 B.n28 B 0 ; **FLOATING
C31 B.n29 B 0 ; **FLOATING
C32 B.n30 B 0 ; **FLOATING
C33 B.n31 B 0 ; **FLOATING
C34 B.n32 B 0 ; **FLOATING
C35 B.n33 B 0 ; **FLOATING
C36 B.n34 B 0 ; **FLOATING
C37 B.n35 B 0 ; **FLOATING
C38 B.n36 B 0 ; **FLOATING
C39 B.n37 B 0 ; **FLOATING
C40 B.n38 B 0 ; **FLOATING
C41 B.n39 B 0 ; **FLOATING
C42 B.n40 B 0 ; **FLOATING
C43 B.n41 B 0 ; **FLOATING
C44 B.n42 B 0 ; **FLOATING
C45 B.n43 B 0 ; **FLOATING
C46 B.n45 B 0 ; **FLOATING
C47 B.n47 B 0 ; **FLOATING
C48 B.n48 B 0 ; **FLOATING
C49 B.n49 B 0 ; **FLOATING
C50 B.n50 B 0 ; **FLOATING
C51 B.n51 B 0 ; **FLOATING
C52 B.n52 B 0 ; **FLOATING
C53 B.n53 B 0 ; **FLOATING
C54 B.n54 B 0 ; **FLOATING
C55 B.n55 B 0 ; **FLOATING
C56 B.n56 B 0 ; **FLOATING
C57 B.n57 B 0 ; **FLOATING
C58 B.n58 B 0 ; **FLOATING
C59 B.n59 B 0 ; **FLOATING
C60 B.n60 B 0 ; **FLOATING
C61 B.n61 B 0 ; **FLOATING
C62 B.n62 B 0 ; **FLOATING
C63 B.n63 B 0 ; **FLOATING
C64 B.n64 B 0 ; **FLOATING
C65 B.n65 B 0 ; **FLOATING
C66 B.n66 B 0 ; **FLOATING
C67 B.n67 B 0 ; **FLOATING
C68 B.n68 B 0 ; **FLOATING
C69 B.n69 B 0 ; **FLOATING
C70 B.n70 B 0 ; **FLOATING
C71 B.n71 B 0 ; **FLOATING
C72 B.n72 B 0 ; **FLOATING
C73 B.n73 B 0 ; **FLOATING
C74 B.n74 B 0 ; **FLOATING
C75 B.n75 B 0 ; **FLOATING
C76 B.n76 B 0 ; **FLOATING
C77 B.n77 B 0 ; **FLOATING
C78 B.n78 B 0 ; **FLOATING
C79 B.n79 B 0 ; **FLOATING
C80 B.n80 B 0 ; **FLOATING
C81 B.n81 B 0 ; **FLOATING
C82 B.n82 B 0 ; **FLOATING
C83 B.n83 B 0 ; **FLOATING
C84 B.n84 B 0 ; **FLOATING
C85 B.n85 B 0 ; **FLOATING
C86 B.n86 B 0 ; **FLOATING
C87 B.n87 B 0 ; **FLOATING
C88 B.n88 B 0 ; **FLOATING
C89 B.n89 B 0 ; **FLOATING
C90 B.n90 B 0 ; **FLOATING
C91 B.n91 B 0 ; **FLOATING
C92 B.n92 B 0 ; **FLOATING
C93 B.n93 B 0 ; **FLOATING
C94 B.n94 B 0 ; **FLOATING
C95 B.n95 B 0 ; **FLOATING
C96 B.n96 B 0 ; **FLOATING
C97 B.n97 B 0 ; **FLOATING
C98 B.n98 B 0 ; **FLOATING
C99 B.n99 B 0 ; **FLOATING
C100 B.n100 B 0 ; **FLOATING
C101 B.n101 B 0 ; **FLOATING
C102 B.n102 B 0 ; **FLOATING
C103 B.n103 B 0 ; **FLOATING
C104 B.n104 B 0 ; **FLOATING
C105 B.n106 B 0 ; **FLOATING
C106 S B 0.08407f
C107 D B 0.08407f
C108 G B 2.14065f
