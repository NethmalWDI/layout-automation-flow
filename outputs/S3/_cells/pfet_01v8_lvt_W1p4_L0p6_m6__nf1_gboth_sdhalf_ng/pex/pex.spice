* NGSPICE file created from pfet_01v8_lvt_W1p4_L0p6_m6__nf1_gboth_sdhalf_ng.ext - technology: sky130A

.subckt pfet_01v8_lvt_W1p4_L0p6_m6__nf1_gboth_sdhalf_ng D S G B
X0 S G D B sky130_fd_pr__pfet_01v8_lvt ad=0.406 pd=3.38 as=0.406 ps=3.38 w=1.4 l=0.6
C0 G S 0.03163f
C1 B G 0.13758f
C2 B S 0.01511f
C3 G D 0.03163f
C4 S D 0.03347f
C5 B D 0.01511f
C6 S VSUBS 0.07814f
C7 D VSUBS 0.07814f
C8 G VSUBS 0.25958f
C9 B VSUBS 0.44352f
.ends
