* NGSPICE file created from pfet_01v8_lvt_W1p5_L10_m2__nf1_gtop_sdfull_ng.ext - technology: sky130A

.subckt sky130_fd_pr__pfet_01v8_lvt_DNY7J4 G D w_n1094_n248# S
X0 S G D w_n1094_n248# sky130_fd_pr__pfet_01v8_lvt ad=0.435 pd=3.58 as=0.435 ps=3.58 w=1.5 l=10
.ends

.subckt pfet_01v8_lvt_W1p5_L10_m2__nf1_gtop_sdfull_ng D S G B
Xpfet_01v8_lvt_W1p5_L10_m2__nf1_gtop_sdfull_ng_pc G D B S sky130_fd_pr__pfet_01v8_lvt_DNY7J4
.ends
