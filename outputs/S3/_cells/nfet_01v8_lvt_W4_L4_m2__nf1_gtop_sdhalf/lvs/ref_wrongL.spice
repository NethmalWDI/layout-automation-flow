.subckt nfet_01v8_lvt_W4_L4_m2__nf1_gtop_sdhalf D G S B
Xnfet_01v8_lvt_W4_L4_m2__nf1_gtop_sdhalf D G S B sky130_fd_pr__nfet_01v8_lvt L=4.4 W=4 nf=1
.ends
