.subckt nfet_01v8_lvt_W484p2_L0p24_m1__nf4_gboth_sdhalf_outS D G S B
Xnfet_01v8_lvt_W484p2_L0p24_m1__nf4_gboth_sdhalf_outS D G S B sky130_fd_pr__nfet_01v8_lvt L=0.34 W=484.2 nf=4
.ends
