* NGSPICE file created from pfet_01v8_lvt_W90p63_L0p74_m1__nf8_gboth_sdfull_outS_ng.ext - technology: sky130A

.subckt pfet_01v8_lvt_W90p63_L0p74_m1__nf8_gboth_sdfull_outS_ng S D G B
X0 D G S B sky130_fd_pr__pfet_01v8_lvt ad=1.64285 pd=11.62 as=1.64285 ps=11.62 w=11.33 l=0.74
X1 S G D B sky130_fd_pr__pfet_01v8_lvt ad=3.2857 pd=23.24 as=1.64285 ps=11.62 w=11.33 l=0.74
X2 S G D B sky130_fd_pr__pfet_01v8_lvt ad=1.64285 pd=11.62 as=1.64285 ps=11.62 w=11.33 l=0.74
X3 S G D B sky130_fd_pr__pfet_01v8_lvt ad=1.64285 pd=11.62 as=1.64285 ps=11.62 w=11.33 l=0.74
X4 D G S B sky130_fd_pr__pfet_01v8_lvt ad=1.64285 pd=11.62 as=3.2857 ps=23.24 w=11.33 l=0.74
X5 S G D B sky130_fd_pr__pfet_01v8_lvt ad=1.64285 pd=11.62 as=1.64285 ps=11.62 w=11.33 l=0.74
X6 D G S B sky130_fd_pr__pfet_01v8_lvt ad=1.64285 pd=11.62 as=1.64285 ps=11.62 w=11.33 l=0.74
X7 D G S B sky130_fd_pr__pfet_01v8_lvt ad=1.64285 pd=11.62 as=1.64285 ps=11.62 w=11.33 l=0.74
C0 B D 1.03461f
C1 D G 4.84687f
C2 B S 1.19086f
C3 S G 4.85693f
C4 D S 3.85483f
C5 B G 1.25407f
C6 D VSUBS 0.32094f
C7 S VSUBS 1.93073f
C8 G VSUBS 2.16994f
C9 B VSUBS 13.1536f
.ends
