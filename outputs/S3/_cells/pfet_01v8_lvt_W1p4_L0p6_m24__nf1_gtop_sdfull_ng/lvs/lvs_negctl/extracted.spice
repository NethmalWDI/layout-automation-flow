* NGSPICE file created from pfet_01v8_lvt_W1p4_L0p6_m24__nf1_gtop_sdfull_ng.ext - technology: sky130A

.subckt sky130_fd_pr__pfet_01v8_lvt_L7GY3J G D w_n154_n238# S
X0 S G D w_n154_n238# sky130_fd_pr__pfet_01v8_lvt ad=0.406 pd=3.38 as=0.406 ps=3.38 w=1.4 l=0.6
.ends

.subckt pfet_01v8_lvt_W1p4_L0p6_m24__nf1_gtop_sdfull_ng D S G B
Xpfet_01v8_lvt_W1p4_L0p6_m24__nf1_gtop_sdfull_ng_pc G D B S sky130_fd_pr__pfet_01v8_lvt_L7GY3J
.ends
