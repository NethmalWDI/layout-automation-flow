* NGSPICE file created from pfet_01v8_lvt_W37p3_L0p74_m1__nf4_gboth_sdfull_outS.ext - technology: sky130A

.subckt sky130_fd_pr__pfet_01v8_lvt_J2DZ28 G B D2 D0 a_383_n933# S3 S1
X0 S3 G D2 B sky130_fd_pr__pfet_01v8_lvt ad=1.35285 pd=9.62 as=1.35285 ps=9.62 w=9.33 l=0.74
X1 D2 G S1 B sky130_fd_pr__pfet_01v8_lvt ad=1.35285 pd=9.62 as=1.35285 ps=9.62 w=9.33 l=0.74
X2 S1 G D0 B sky130_fd_pr__pfet_01v8_lvt ad=1.35285 pd=9.62 as=2.7057 ps=19.24 w=9.33 l=0.74
X3 a_383_n933# G S3 B sky130_fd_pr__pfet_01v8_lvt ad=2.7057 pd=19.24 as=1.35285 ps=9.62 w=9.33 l=0.74
.ends

.subckt pfet_01v8_lvt_W37p3_L0p74_m1__nf4_gboth_sdfull_outS S D G B
Xpfet_01v8_lvt_W37p3_L0p74_m1__nf4_gboth_sdfull_outS_pc G B S S S D D sky130_fd_pr__pfet_01v8_lvt_J2DZ28
.ends
