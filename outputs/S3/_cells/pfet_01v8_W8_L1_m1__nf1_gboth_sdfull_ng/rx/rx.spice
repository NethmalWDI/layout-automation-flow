* NGSPICE file created from pfet_01v8_W8_L1_m1__nf1_gboth_sdfull_ng.ext - technology: sky130A

X0 pfet_01v8_W8_L1_m1__nf1_gboth_sdfull_ng_pc/S.t0 G pfet_01v8_W8_L1_m1__nf1_gboth_sdfull_ng_pc/D.t0 B sky130_fd_pr__pfet_01v8 ad=2.32 pd=16.58 as=2.32 ps=16.58 w=8 l=1
C0 B G 0.19849f
C1 B S 0.15709f
C2 D G 0.43491f
C3 S D 0.23712f
C4 B D 0.15709f
C5 S G 0.43491f
R0 S pfet_01v8_W8_L1_m1__nf1_gboth_sdfull_ng_pc/S.n1 54.4415
R1 pfet_01v8_W8_L1_m1__nf1_gboth_sdfull_ng_pc/S.n1 pfet_01v8_W8_L1_m1__nf1_gboth_sdfull_ng_pc/S.n0 48.279
R2 S pfet_01v8_W8_L1_m1__nf1_gboth_sdfull_ng_pc/S.n0 17.9488
R3 pfet_01v8_W8_L1_m1__nf1_gboth_sdfull_ng_pc/S.n1 pfet_01v8_W8_L1_m1__nf1_gboth_sdfull_ng_pc/S.t0 3.57113
R4 S pfet_01v8_W8_L1_m1__nf1_gboth_sdfull_ng_pc/S.n0 3.09203
R5 pfet_01v8_W8_L1_m1__nf1_gboth_sdfull_ng_pc/D.n0 D 54.4416
R6 pfet_01v8_W8_L1_m1__nf1_gboth_sdfull_ng_pc/D.n1 pfet_01v8_W8_L1_m1__nf1_gboth_sdfull_ng_pc/D.n0 48.279
R7 D pfet_01v8_W8_L1_m1__nf1_gboth_sdfull_ng_pc/D.n1 17.9488
R8 pfet_01v8_W8_L1_m1__nf1_gboth_sdfull_ng_pc/D.n0 pfet_01v8_W8_L1_m1__nf1_gboth_sdfull_ng_pc/D.t0 3.57113
R9 pfet_01v8_W8_L1_m1__nf1_gboth_sdfull_ng_pc/D.n1 D 3.09203
C6 S VSUBS 1.04624f
C7 D VSUBS 1.04624f
C8 G VSUBS 0.38795f
C9 B VSUBS 2.0952f
C10 pfet_01v8_W8_L1_m1__nf1_gboth_sdfull_ng_pc/D.t0 VSUBS 0.08701f ; **FLOATING
C11 pfet_01v8_W8_L1_m1__nf1_gboth_sdfull_ng_pc/D.n0 VSUBS 0.26969f ; **FLOATING
C12 pfet_01v8_W8_L1_m1__nf1_gboth_sdfull_ng_pc/D.n1 VSUBS 0.012f ; **FLOATING
C13 pfet_01v8_W8_L1_m1__nf1_gboth_sdfull_ng_pc/S.n0 VSUBS 0.012f ; **FLOATING
C14 pfet_01v8_W8_L1_m1__nf1_gboth_sdfull_ng_pc/S.t0 VSUBS 0.08701f ; **FLOATING
C15 pfet_01v8_W8_L1_m1__nf1_gboth_sdfull_ng_pc/S.n1 VSUBS 0.26969f ; **FLOATING
