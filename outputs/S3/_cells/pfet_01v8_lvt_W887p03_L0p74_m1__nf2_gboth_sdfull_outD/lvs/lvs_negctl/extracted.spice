* NGSPICE file created from pfet_01v8_lvt_W887p03_L0p74_m1__nf2_gboth_sdfull_outD.ext - technology: sky130A

.subckt sky130_fd_pr__pfet_01v8_lvt_6CX54W G a_177_n44352# B D0 S1
X0 a_177_n44352# G S1 B sky130_fd_pr__pfet_01v8_lvt ad=128.6208 pd=887.62 as=64.3104 ps=443.81 w=443.51999 l=0.74
X1 S1 G D0 B sky130_fd_pr__pfet_01v8_lvt ad=64.3104 pd=443.81 as=128.6208 ps=887.62 w=443.51999 l=0.74
.ends

.subckt pfet_01v8_lvt_W887p03_L0p74_m1__nf2_gboth_sdfull_outD S D G B
Xpfet_01v8_lvt_W887p03_L0p74_m1__nf2_gboth_sdfull_outD_pc G D B D S sky130_fd_pr__pfet_01v8_lvt_6CX54W
.ends
