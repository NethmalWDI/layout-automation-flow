.subckt nfet_01v8_lvt_W66p13_L2p03_m1__nf4_gboth_sdfull_outD D G S B
Xnfet_01v8_lvt_W66p13_L2p03_m1__nf4_gboth_sdfull_outD D G S B sky130_fd_pr__nfet_01v8_lvt L=2.03 W=66.13 nf=4
.ends
