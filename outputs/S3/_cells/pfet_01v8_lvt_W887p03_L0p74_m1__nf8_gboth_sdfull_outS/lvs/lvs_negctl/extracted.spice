* NGSPICE file created from pfet_01v8_lvt_W887p03_L0p74_m1__nf8_gboth_sdfull_outS.ext - technology: sky130A

.subckt sky130_fd_pr__pfet_01v8_lvt_KUAASU G B D6 D4 D2 D0 a_795_n11088# S7 S5 S3
+ S1
X0 S5 G D4 B sky130_fd_pr__pfet_01v8_lvt ad=16.0776 pd=111.17 as=16.0776 ps=111.17 w=110.88 l=0.74
X1 a_795_n11088# G S7 B sky130_fd_pr__pfet_01v8_lvt ad=32.1552 pd=222.34 as=16.0776 ps=111.17 w=110.88 l=0.74
X2 S3 G D2 B sky130_fd_pr__pfet_01v8_lvt ad=16.0776 pd=111.17 as=16.0776 ps=111.17 w=110.88 l=0.74
X3 D4 G S3 B sky130_fd_pr__pfet_01v8_lvt ad=16.0776 pd=111.17 as=16.0776 ps=111.17 w=110.88 l=0.74
X4 S1 G D0 B sky130_fd_pr__pfet_01v8_lvt ad=16.0776 pd=111.17 as=32.1552 ps=222.34 w=110.88 l=0.74
X5 S7 G D6 B sky130_fd_pr__pfet_01v8_lvt ad=16.0776 pd=111.17 as=16.0776 ps=111.17 w=110.88 l=0.74
X6 D2 G S1 B sky130_fd_pr__pfet_01v8_lvt ad=16.0776 pd=111.17 as=16.0776 ps=111.17 w=110.88 l=0.74
X7 D6 G S5 B sky130_fd_pr__pfet_01v8_lvt ad=16.0776 pd=111.17 as=16.0776 ps=111.17 w=110.88 l=0.74
.ends

.subckt pfet_01v8_lvt_W887p03_L0p74_m1__nf8_gboth_sdfull_outS S D G B
Xpfet_01v8_lvt_W887p03_L0p74_m1__nf8_gboth_sdfull_outS_pc G B S S S S S D D D D sky130_fd_pr__pfet_01v8_lvt_KUAASU
.ends
