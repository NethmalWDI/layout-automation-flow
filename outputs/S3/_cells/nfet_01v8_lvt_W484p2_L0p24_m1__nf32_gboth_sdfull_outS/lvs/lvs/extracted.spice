* NGSPICE file created from nfet_01v8_lvt_W484p2_L0p24_m1__nf32_gboth_sdfull_outS.ext - technology: sky130A

.subckt sky130_fd_pr__nfet_01v8_lvt_HR2BRV S27 D22 S17 D10 D20 S15 G D30 S25 S13 S23
+ S11 B S21 S31 D8 a_1667_n1513# D6 D4 D2 D0 S9 S7 D18 D28 S5 D16 D26 S3 D14 D24 S19
+ S1 S29 D12
X0 D2 G S1 B sky130_fd_pr__nfet_01v8_lvt ad=2.19385 pd=15.42 as=2.19385 ps=15.42 w=15.13 l=0.24
X1 D28 G S27 B sky130_fd_pr__nfet_01v8_lvt ad=2.19385 pd=15.42 as=2.19385 ps=15.42 w=15.13 l=0.24
X2 S17 G D16 B sky130_fd_pr__nfet_01v8_lvt ad=2.19385 pd=15.42 as=2.19385 ps=15.42 w=15.13 l=0.24
X3 S1 G D0 B sky130_fd_pr__nfet_01v8_lvt ad=2.19385 pd=15.42 as=4.3877 ps=30.84 w=15.13 l=0.24
X4 S27 G D26 B sky130_fd_pr__nfet_01v8_lvt ad=2.19385 pd=15.42 as=2.19385 ps=15.42 w=15.13 l=0.24
X5 S3 G D2 B sky130_fd_pr__nfet_01v8_lvt ad=2.19385 pd=15.42 as=2.19385 ps=15.42 w=15.13 l=0.24
X6 S31 G D30 B sky130_fd_pr__nfet_01v8_lvt ad=2.19385 pd=15.42 as=2.19385 ps=15.42 w=15.13 l=0.24
X7 S5 G D4 B sky130_fd_pr__nfet_01v8_lvt ad=2.19385 pd=15.42 as=2.19385 ps=15.42 w=15.13 l=0.24
X8 S7 G D6 B sky130_fd_pr__nfet_01v8_lvt ad=2.19385 pd=15.42 as=2.19385 ps=15.42 w=15.13 l=0.24
X9 S13 G D12 B sky130_fd_pr__nfet_01v8_lvt ad=2.19385 pd=15.42 as=2.19385 ps=15.42 w=15.13 l=0.24
X10 S29 G D28 B sky130_fd_pr__nfet_01v8_lvt ad=2.19385 pd=15.42 as=2.19385 ps=15.42 w=15.13 l=0.24
X11 S15 G D14 B sky130_fd_pr__nfet_01v8_lvt ad=2.19385 pd=15.42 as=2.19385 ps=15.42 w=15.13 l=0.24
X12 D24 G S23 B sky130_fd_pr__nfet_01v8_lvt ad=2.19385 pd=15.42 as=2.19385 ps=15.42 w=15.13 l=0.24
X13 D26 G S25 B sky130_fd_pr__nfet_01v8_lvt ad=2.19385 pd=15.42 as=2.19385 ps=15.42 w=15.13 l=0.24
X14 D4 G S3 B sky130_fd_pr__nfet_01v8_lvt ad=2.19385 pd=15.42 as=2.19385 ps=15.42 w=15.13 l=0.24
X15 a_1667_n1513# G S31 B sky130_fd_pr__nfet_01v8_lvt ad=4.3877 pd=30.84 as=2.19385 ps=15.42 w=15.13 l=0.24
X16 D6 G S5 B sky130_fd_pr__nfet_01v8_lvt ad=2.19385 pd=15.42 as=2.19385 ps=15.42 w=15.13 l=0.24
X17 D30 G S29 B sky130_fd_pr__nfet_01v8_lvt ad=2.19385 pd=15.42 as=2.19385 ps=15.42 w=15.13 l=0.24
X18 D8 G S7 B sky130_fd_pr__nfet_01v8_lvt ad=2.19385 pd=15.42 as=2.19385 ps=15.42 w=15.13 l=0.24
X19 D14 G S13 B sky130_fd_pr__nfet_01v8_lvt ad=2.19385 pd=15.42 as=2.19385 ps=15.42 w=15.13 l=0.24
X20 S25 G D24 B sky130_fd_pr__nfet_01v8_lvt ad=2.19385 pd=15.42 as=2.19385 ps=15.42 w=15.13 l=0.24
X21 D10 G S9 B sky130_fd_pr__nfet_01v8_lvt ad=2.19385 pd=15.42 as=2.19385 ps=15.42 w=15.13 l=0.24
X22 S21 G D20 B sky130_fd_pr__nfet_01v8_lvt ad=2.19385 pd=15.42 as=2.19385 ps=15.42 w=15.13 l=0.24
X23 S23 G D22 B sky130_fd_pr__nfet_01v8_lvt ad=2.19385 pd=15.42 as=2.19385 ps=15.42 w=15.13 l=0.24
X24 D12 G S11 B sky130_fd_pr__nfet_01v8_lvt ad=2.19385 pd=15.42 as=2.19385 ps=15.42 w=15.13 l=0.24
X25 S19 G D18 B sky130_fd_pr__nfet_01v8_lvt ad=2.19385 pd=15.42 as=2.19385 ps=15.42 w=15.13 l=0.24
X26 S9 G D8 B sky130_fd_pr__nfet_01v8_lvt ad=2.19385 pd=15.42 as=2.19385 ps=15.42 w=15.13 l=0.24
X27 S11 G D10 B sky130_fd_pr__nfet_01v8_lvt ad=2.19385 pd=15.42 as=2.19385 ps=15.42 w=15.13 l=0.24
X28 D22 G S21 B sky130_fd_pr__nfet_01v8_lvt ad=2.19385 pd=15.42 as=2.19385 ps=15.42 w=15.13 l=0.24
X29 D20 G S19 B sky130_fd_pr__nfet_01v8_lvt ad=2.19385 pd=15.42 as=2.19385 ps=15.42 w=15.13 l=0.24
X30 D18 G S17 B sky130_fd_pr__nfet_01v8_lvt ad=2.19385 pd=15.42 as=2.19385 ps=15.42 w=15.13 l=0.24
X31 D16 G S15 B sky130_fd_pr__nfet_01v8_lvt ad=2.19385 pd=15.42 as=2.19385 ps=15.42 w=15.13 l=0.24
.ends

.subckt nfet_01v8_lvt_W484p2_L0p24_m1__nf32_gboth_sdfull_outS S D G B
Xnfet_01v8_lvt_W484p2_L0p24_m1__nf32_gboth_sdfull_outS_pc D S D S S D G S D D D D
+ B D D S S S S S S D D S S D S S D S S D D D S sky130_fd_pr__nfet_01v8_lvt_HR2BRV
.ends
