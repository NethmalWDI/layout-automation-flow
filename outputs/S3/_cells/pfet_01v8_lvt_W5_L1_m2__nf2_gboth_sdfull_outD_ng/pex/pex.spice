* NGSPICE file created from pfet_01v8_lvt_W5_L1_m2__nf2_gboth_sdfull_outD_ng.ext - technology: sky130A

.subckt pfet_01v8_lvt_W5_L1_m2__nf2_gboth_sdfull_outD_ng S D G B
X0 S G D B sky130_fd_pr__pfet_01v8_lvt ad=0.3625 pd=2.79 as=0.725 ps=5.58 w=2.5 l=1
X1 D G S B sky130_fd_pr__pfet_01v8_lvt ad=0.725 pd=5.58 as=0.3625 ps=2.79 w=2.5 l=1
C0 G D 0.44901f
C1 S B 0.06462f
C2 S D 0.32286f
C3 S G 0.45153f
C4 D B 0.10406f
C5 G B 0.37733f
C6 S VSUBS 0.10953f
C7 D VSUBS 0.48332f
C8 G VSUBS 0.72095f
C9 B VSUBS 1.3566f
.ends
