* NGSPICE file created from pfet_01v8_lvt_W37p3_L0p74_m1__nf8_gboth_sdhalf_outS_ng.ext - technology: sky130A

.subckt pfet_01v8_lvt_W37p3_L0p74_m1__nf8_gboth_sdhalf_outS_ng S D G B
X0 S G D B sky130_fd_pr__pfet_01v8_lvt ad=0.6757 pd=4.95 as=0.6757 ps=4.95 w=4.66 l=0.74
X1 S G D B sky130_fd_pr__pfet_01v8_lvt ad=0.6757 pd=4.95 as=0.6757 ps=4.95 w=4.66 l=0.74
X2 D G S B sky130_fd_pr__pfet_01v8_lvt ad=0.6757 pd=4.95 as=0.6757 ps=4.95 w=4.66 l=0.74
X3 S G D B sky130_fd_pr__pfet_01v8_lvt ad=0.6757 pd=4.95 as=0.6757 ps=4.95 w=4.66 l=0.74
X4 D G S B sky130_fd_pr__pfet_01v8_lvt ad=0.6757 pd=4.95 as=1.3514 ps=9.9 w=4.66 l=0.74
X5 S G D B sky130_fd_pr__pfet_01v8_lvt ad=1.3514 pd=9.9 as=0.6757 ps=4.95 w=4.66 l=0.74
X6 D G S B sky130_fd_pr__pfet_01v8_lvt ad=0.6757 pd=4.95 as=0.6757 ps=4.95 w=4.66 l=0.74
X7 D G S B sky130_fd_pr__pfet_01v8_lvt ad=0.6757 pd=4.95 as=0.6757 ps=4.95 w=4.66 l=0.74
C0 G B 1.24311f
C1 B S 0.30983f
C2 G S 1.31294f
C3 B D 0.27422f
C4 G D 1.31201f
C5 S D 1.30609f
C6 D VSUBS 0.20689f
C7 S VSUBS 0.55908f
C8 G VSUBS 2.01391f
C9 B VSUBS 6.03809f
.ends
