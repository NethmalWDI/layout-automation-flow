* NGSPICE file created from nfet_01v8_lvt_W66p13_L2p03_m1__nf4_gboth_sdhalf_outS_ng.ext - technology: sky130A

.subckt nfet_01v8_lvt_W66p13_L2p03_m1__nf4_gboth_sdhalf_outS_ng S D G B
X0 S G D B sky130_fd_pr__nfet_01v8_lvt ad=4.7937 pd=33.64 as=2.39685 ps=16.82 w=16.53 l=2.03
X1 D G S B sky130_fd_pr__nfet_01v8_lvt ad=2.39685 pd=16.82 as=4.7937 ps=33.64 w=16.53 l=2.03
X2 S G D B sky130_fd_pr__nfet_01v8_lvt ad=2.39685 pd=16.82 as=2.39685 ps=16.82 w=16.53 l=2.03
X3 D G S B sky130_fd_pr__nfet_01v8_lvt ad=2.39685 pd=16.82 as=2.39685 ps=16.82 w=16.53 l=2.03
C0 S G 3.04665f
C1 S D 0.89072f
C2 G D 3.04661f
C3 D B 0.12635f
C4 S B 1.42f
C5 G B 3.60184f
.ends
