* NGSPICE file created from nfet_01v8_lvt_W0p6_L1_m2__nf1_gboth_sdfull.ext - technology: sky130A

X0 S G D nfet_01v8_lvt_W0p6_L1_m2__nf1_gboth_sdfull_pc/B.t0 sky130_fd_pr__nfet_01v8_lvt ad=0.174 pd=1.78 as=0.174 ps=1.78 w=0.6 l=1
C0 S D 0.01816f
C1 S G 0.03401f
C2 G D 0.03401f
R0 nfet_01v8_lvt_W0p6_L1_m2__nf1_gboth_sdfull_pc/B.n42 nfet_01v8_lvt_W0p6_L1_m2__nf1_gboth_sdfull_pc/B.n41 1187.79
R1 nfet_01v8_lvt_W0p6_L1_m2__nf1_gboth_sdfull_pc/B.n39 nfet_01v8_lvt_W0p6_L1_m2__nf1_gboth_sdfull_pc/B.n8 1187.79
R2 nfet_01v8_lvt_W0p6_L1_m2__nf1_gboth_sdfull_pc/B.n24 nfet_01v8_lvt_W0p6_L1_m2__nf1_gboth_sdfull_pc/B.n12 1187.79
R3 nfet_01v8_lvt_W0p6_L1_m2__nf1_gboth_sdfull_pc/B.n20 nfet_01v8_lvt_W0p6_L1_m2__nf1_gboth_sdfull_pc/B.n10 1187.79
R4 nfet_01v8_lvt_W0p6_L1_m2__nf1_gboth_sdfull_pc/B.n40 nfet_01v8_lvt_W0p6_L1_m2__nf1_gboth_sdfull_pc/B.n3 884.615
R5 nfet_01v8_lvt_W0p6_L1_m2__nf1_gboth_sdfull_pc/B.n22 nfet_01v8_lvt_W0p6_L1_m2__nf1_gboth_sdfull_pc/B.n11 884.615
R6 nfet_01v8_lvt_W0p6_L1_m2__nf1_gboth_sdfull_pc/B.n25 nfet_01v8_lvt_W0p6_L1_m2__nf1_gboth_sdfull_pc/B.n24 585
R7 nfet_01v8_lvt_W0p6_L1_m2__nf1_gboth_sdfull_pc/B.n14 nfet_01v8_lvt_W0p6_L1_m2__nf1_gboth_sdfull_pc/B.n13 585
R8 nfet_01v8_lvt_W0p6_L1_m2__nf1_gboth_sdfull_pc/B.n22 nfet_01v8_lvt_W0p6_L1_m2__nf1_gboth_sdfull_pc/B.n15 585
R9 nfet_01v8_lvt_W0p6_L1_m2__nf1_gboth_sdfull_pc/B.n17 nfet_01v8_lvt_W0p6_L1_m2__nf1_gboth_sdfull_pc/B.n15 585
R10 nfet_01v8_lvt_W0p6_L1_m2__nf1_gboth_sdfull_pc/B.n18 nfet_01v8_lvt_W0p6_L1_m2__nf1_gboth_sdfull_pc/B.n16 585
R11 nfet_01v8_lvt_W0p6_L1_m2__nf1_gboth_sdfull_pc/B.n20 nfet_01v8_lvt_W0p6_L1_m2__nf1_gboth_sdfull_pc/B.n19 585
R12 nfet_01v8_lvt_W0p6_L1_m2__nf1_gboth_sdfull_pc/B.n11 nfet_01v8_lvt_W0p6_L1_m2__nf1_gboth_sdfull_pc/B.n10 585
R13 nfet_01v8_lvt_W0p6_L1_m2__nf1_gboth_sdfull_pc/B.n10 nfet_01v8_lvt_W0p6_L1_m2__nf1_gboth_sdfull_pc/B.n9 585
R14 nfet_01v8_lvt_W0p6_L1_m2__nf1_gboth_sdfull_pc/B.n31 nfet_01v8_lvt_W0p6_L1_m2__nf1_gboth_sdfull_pc/B.n30 585
R15 nfet_01v8_lvt_W0p6_L1_m2__nf1_gboth_sdfull_pc/B.n32 nfet_01v8_lvt_W0p6_L1_m2__nf1_gboth_sdfull_pc/B.n31 585
R16 nfet_01v8_lvt_W0p6_L1_m2__nf1_gboth_sdfull_pc/B.n7 nfet_01v8_lvt_W0p6_L1_m2__nf1_gboth_sdfull_pc/B.n6 585
R17 nfet_01v8_lvt_W0p6_L1_m2__nf1_gboth_sdfull_pc/B.n33 nfet_01v8_lvt_W0p6_L1_m2__nf1_gboth_sdfull_pc/B.n7 585
R18 nfet_01v8_lvt_W0p6_L1_m2__nf1_gboth_sdfull_pc/B.n40 nfet_01v8_lvt_W0p6_L1_m2__nf1_gboth_sdfull_pc/B.n39 585
R19 nfet_01v8_lvt_W0p6_L1_m2__nf1_gboth_sdfull_pc/B.n39 nfet_01v8_lvt_W0p6_L1_m2__nf1_gboth_sdfull_pc/B.n38 585
R20 nfet_01v8_lvt_W0p6_L1_m2__nf1_gboth_sdfull_pc/B.n8 nfet_01v8_lvt_W0p6_L1_m2__nf1_gboth_sdfull_pc/B.n3 585
R21 nfet_01v8_lvt_W0p6_L1_m2__nf1_gboth_sdfull_pc/B.n37 nfet_01v8_lvt_W0p6_L1_m2__nf1_gboth_sdfull_pc/B.n8 585
R22 nfet_01v8_lvt_W0p6_L1_m2__nf1_gboth_sdfull_pc/B.n36 nfet_01v8_lvt_W0p6_L1_m2__nf1_gboth_sdfull_pc/B.n35 585
R23 nfet_01v8_lvt_W0p6_L1_m2__nf1_gboth_sdfull_pc/B.n2 nfet_01v8_lvt_W0p6_L1_m2__nf1_gboth_sdfull_pc/B.n0 585
R24 nfet_01v8_lvt_W0p6_L1_m2__nf1_gboth_sdfull_pc/B.n45 nfet_01v8_lvt_W0p6_L1_m2__nf1_gboth_sdfull_pc/B.n44 585
R25 nfet_01v8_lvt_W0p6_L1_m2__nf1_gboth_sdfull_pc/B.n42 nfet_01v8_lvt_W0p6_L1_m2__nf1_gboth_sdfull_pc/B.n1 585
R26 nfet_01v8_lvt_W0p6_L1_m2__nf1_gboth_sdfull_pc/B.n41 nfet_01v8_lvt_W0p6_L1_m2__nf1_gboth_sdfull_pc/B.n40 585
R27 nfet_01v8_lvt_W0p6_L1_m2__nf1_gboth_sdfull_pc/B.n41 nfet_01v8_lvt_W0p6_L1_m2__nf1_gboth_sdfull_pc/B.n5 585
R28 nfet_01v8_lvt_W0p6_L1_m2__nf1_gboth_sdfull_pc/B.n6 nfet_01v8_lvt_W0p6_L1_m2__nf1_gboth_sdfull_pc/B.n4 585
R29 nfet_01v8_lvt_W0p6_L1_m2__nf1_gboth_sdfull_pc/B.n27 nfet_01v8_lvt_W0p6_L1_m2__nf1_gboth_sdfull_pc/B.n4 585
R30 nfet_01v8_lvt_W0p6_L1_m2__nf1_gboth_sdfull_pc/B.n30 nfet_01v8_lvt_W0p6_L1_m2__nf1_gboth_sdfull_pc/B.n29 585
R31 nfet_01v8_lvt_W0p6_L1_m2__nf1_gboth_sdfull_pc/B.n29 nfet_01v8_lvt_W0p6_L1_m2__nf1_gboth_sdfull_pc/B.n28 585
R32 nfet_01v8_lvt_W0p6_L1_m2__nf1_gboth_sdfull_pc/B.n12 nfet_01v8_lvt_W0p6_L1_m2__nf1_gboth_sdfull_pc/B.n11 585
R33 nfet_01v8_lvt_W0p6_L1_m2__nf1_gboth_sdfull_pc/B.n26 nfet_01v8_lvt_W0p6_L1_m2__nf1_gboth_sdfull_pc/B.n12 585
R34 nfet_01v8_lvt_W0p6_L1_m2__nf1_gboth_sdfull_pc/B.n40 nfet_01v8_lvt_W0p6_L1_m2__nf1_gboth_sdfull_pc/B.n6 523.077
R35 nfet_01v8_lvt_W0p6_L1_m2__nf1_gboth_sdfull_pc/B.n30 nfet_01v8_lvt_W0p6_L1_m2__nf1_gboth_sdfull_pc/B.n11 523.077
R36 nfet_01v8_lvt_W0p6_L1_m2__nf1_gboth_sdfull_pc/B.n41 nfet_01v8_lvt_W0p6_L1_m2__nf1_gboth_sdfull_pc/B.n4 394
R37 nfet_01v8_lvt_W0p6_L1_m2__nf1_gboth_sdfull_pc/B.n29 nfet_01v8_lvt_W0p6_L1_m2__nf1_gboth_sdfull_pc/B.n4 394
R38 nfet_01v8_lvt_W0p6_L1_m2__nf1_gboth_sdfull_pc/B.n29 nfet_01v8_lvt_W0p6_L1_m2__nf1_gboth_sdfull_pc/B.n12 394
R39 nfet_01v8_lvt_W0p6_L1_m2__nf1_gboth_sdfull_pc/B.n44 nfet_01v8_lvt_W0p6_L1_m2__nf1_gboth_sdfull_pc/B.n2 394
R40 nfet_01v8_lvt_W0p6_L1_m2__nf1_gboth_sdfull_pc/B.n35 nfet_01v8_lvt_W0p6_L1_m2__nf1_gboth_sdfull_pc/B.n8 394
R41 nfet_01v8_lvt_W0p6_L1_m2__nf1_gboth_sdfull_pc/B.n39 nfet_01v8_lvt_W0p6_L1_m2__nf1_gboth_sdfull_pc/B.n7 394
R42 nfet_01v8_lvt_W0p6_L1_m2__nf1_gboth_sdfull_pc/B.n31 nfet_01v8_lvt_W0p6_L1_m2__nf1_gboth_sdfull_pc/B.n7 394
R43 nfet_01v8_lvt_W0p6_L1_m2__nf1_gboth_sdfull_pc/B.n31 nfet_01v8_lvt_W0p6_L1_m2__nf1_gboth_sdfull_pc/B.n10 394
R44 nfet_01v8_lvt_W0p6_L1_m2__nf1_gboth_sdfull_pc/B.n15 nfet_01v8_lvt_W0p6_L1_m2__nf1_gboth_sdfull_pc/B.n14 394
R45 nfet_01v8_lvt_W0p6_L1_m2__nf1_gboth_sdfull_pc/B.n16 nfet_01v8_lvt_W0p6_L1_m2__nf1_gboth_sdfull_pc/B.n15 394
R46 nfet_01v8_lvt_W0p6_L1_m2__nf1_gboth_sdfull_pc/B.n3 B 330.769
R47 nfet_01v8_lvt_W0p6_L1_m2__nf1_gboth_sdfull_pc/B.t0 nfet_01v8_lvt_W0p6_L1_m2__nf1_gboth_sdfull_pc/B.n6 261.538
R48 nfet_01v8_lvt_W0p6_L1_m2__nf1_gboth_sdfull_pc/B.n30 nfet_01v8_lvt_W0p6_L1_m2__nf1_gboth_sdfull_pc/B.t0 261.538
R49 nfet_01v8_lvt_W0p6_L1_m2__nf1_gboth_sdfull_pc/B.n23 nfet_01v8_lvt_W0p6_L1_m2__nf1_gboth_sdfull_pc/B.n22 218.815
R50 nfet_01v8_lvt_W0p6_L1_m2__nf1_gboth_sdfull_pc/B.n22 nfet_01v8_lvt_W0p6_L1_m2__nf1_gboth_sdfull_pc/B.n21 218.815
R51 nfet_01v8_lvt_W0p6_L1_m2__nf1_gboth_sdfull_pc/B.n34 nfet_01v8_lvt_W0p6_L1_m2__nf1_gboth_sdfull_pc/B.n3 218.815
R52 nfet_01v8_lvt_W0p6_L1_m2__nf1_gboth_sdfull_pc/B.n43 nfet_01v8_lvt_W0p6_L1_m2__nf1_gboth_sdfull_pc/B.n3 218.815
R53 nfet_01v8_lvt_W0p6_L1_m2__nf1_gboth_sdfull_pc/B.n24 nfet_01v8_lvt_W0p6_L1_m2__nf1_gboth_sdfull_pc/B.n23 147.374
R54 nfet_01v8_lvt_W0p6_L1_m2__nf1_gboth_sdfull_pc/B.n21 nfet_01v8_lvt_W0p6_L1_m2__nf1_gboth_sdfull_pc/B.n16 147.374
R55 nfet_01v8_lvt_W0p6_L1_m2__nf1_gboth_sdfull_pc/B.n35 nfet_01v8_lvt_W0p6_L1_m2__nf1_gboth_sdfull_pc/B.n34 147.374
R56 nfet_01v8_lvt_W0p6_L1_m2__nf1_gboth_sdfull_pc/B.n44 nfet_01v8_lvt_W0p6_L1_m2__nf1_gboth_sdfull_pc/B.n43 147.374
R57 nfet_01v8_lvt_W0p6_L1_m2__nf1_gboth_sdfull_pc/B.n43 nfet_01v8_lvt_W0p6_L1_m2__nf1_gboth_sdfull_pc/B.n42 147.374
R58 nfet_01v8_lvt_W0p6_L1_m2__nf1_gboth_sdfull_pc/B.n34 nfet_01v8_lvt_W0p6_L1_m2__nf1_gboth_sdfull_pc/B.n2 147.374
R59 nfet_01v8_lvt_W0p6_L1_m2__nf1_gboth_sdfull_pc/B.n23 nfet_01v8_lvt_W0p6_L1_m2__nf1_gboth_sdfull_pc/B.n14 147.374
R60 nfet_01v8_lvt_W0p6_L1_m2__nf1_gboth_sdfull_pc/B.n21 nfet_01v8_lvt_W0p6_L1_m2__nf1_gboth_sdfull_pc/B.n20 147.374
R61 nfet_01v8_lvt_W0p6_L1_m2__nf1_gboth_sdfull_pc/B.n5 nfet_01v8_lvt_W0p6_L1_m2__nf1_gboth_sdfull_pc/B.n1 77.177
R62 nfet_01v8_lvt_W0p6_L1_m2__nf1_gboth_sdfull_pc/B.n38 nfet_01v8_lvt_W0p6_L1_m2__nf1_gboth_sdfull_pc/B.n37 77.177
R63 nfet_01v8_lvt_W0p6_L1_m2__nf1_gboth_sdfull_pc/B.n26 nfet_01v8_lvt_W0p6_L1_m2__nf1_gboth_sdfull_pc/B.n25 77.177
R64 nfet_01v8_lvt_W0p6_L1_m2__nf1_gboth_sdfull_pc/B.n19 nfet_01v8_lvt_W0p6_L1_m2__nf1_gboth_sdfull_pc/B.n9 77.177
R65 nfet_01v8_lvt_W0p6_L1_m2__nf1_gboth_sdfull_pc/B.n27 nfet_01v8_lvt_W0p6_L1_m2__nf1_gboth_sdfull_pc/B.n5 25.6005
R66 nfet_01v8_lvt_W0p6_L1_m2__nf1_gboth_sdfull_pc/B.n28 nfet_01v8_lvt_W0p6_L1_m2__nf1_gboth_sdfull_pc/B.n27 25.6005
R67 nfet_01v8_lvt_W0p6_L1_m2__nf1_gboth_sdfull_pc/B.n28 nfet_01v8_lvt_W0p6_L1_m2__nf1_gboth_sdfull_pc/B.n26 25.6005
R68 nfet_01v8_lvt_W0p6_L1_m2__nf1_gboth_sdfull_pc/B.n45 nfet_01v8_lvt_W0p6_L1_m2__nf1_gboth_sdfull_pc/B.n1 25.6005
R69 nfet_01v8_lvt_W0p6_L1_m2__nf1_gboth_sdfull_pc/B.n36 nfet_01v8_lvt_W0p6_L1_m2__nf1_gboth_sdfull_pc/B.n0 25.6005
R70 nfet_01v8_lvt_W0p6_L1_m2__nf1_gboth_sdfull_pc/B.n37 nfet_01v8_lvt_W0p6_L1_m2__nf1_gboth_sdfull_pc/B.n36 25.6005
R71 nfet_01v8_lvt_W0p6_L1_m2__nf1_gboth_sdfull_pc/B.n38 nfet_01v8_lvt_W0p6_L1_m2__nf1_gboth_sdfull_pc/B.n33 25.6005
R72 nfet_01v8_lvt_W0p6_L1_m2__nf1_gboth_sdfull_pc/B.n33 nfet_01v8_lvt_W0p6_L1_m2__nf1_gboth_sdfull_pc/B.n32 25.6005
R73 nfet_01v8_lvt_W0p6_L1_m2__nf1_gboth_sdfull_pc/B.n32 nfet_01v8_lvt_W0p6_L1_m2__nf1_gboth_sdfull_pc/B.n9 25.6005
R74 nfet_01v8_lvt_W0p6_L1_m2__nf1_gboth_sdfull_pc/B.n25 nfet_01v8_lvt_W0p6_L1_m2__nf1_gboth_sdfull_pc/B.n13 25.6005
R75 nfet_01v8_lvt_W0p6_L1_m2__nf1_gboth_sdfull_pc/B.n17 nfet_01v8_lvt_W0p6_L1_m2__nf1_gboth_sdfull_pc/B.n13 25.6005
R76 nfet_01v8_lvt_W0p6_L1_m2__nf1_gboth_sdfull_pc/B.n18 nfet_01v8_lvt_W0p6_L1_m2__nf1_gboth_sdfull_pc/B.n17 25.6005
R77 nfet_01v8_lvt_W0p6_L1_m2__nf1_gboth_sdfull_pc/B.n19 nfet_01v8_lvt_W0p6_L1_m2__nf1_gboth_sdfull_pc/B.n18 25.6005
R78 B nfet_01v8_lvt_W0p6_L1_m2__nf1_gboth_sdfull_pc/B.n45 19.2005
R79 B nfet_01v8_lvt_W0p6_L1_m2__nf1_gboth_sdfull_pc/B.n0 6.4005
R80 B.n23 B.n13 1187.79
R81 B.n38 B.n37 1187.79
R82 B.n44 B.n3 1187.79
R83 B.n16 B.n11 1187.79
R84 B.n46 B.n0 905.385
R85 B.n21 B.n12 905.385
R86 B.n13 B.n12 585
R87 B.n25 B.n13 585
R88 B.n29 B.n28 585
R89 B.n28 B.n27 585
R90 B.n8 B.n6 585
R91 B.n26 B.n6 585
R92 B.n36 B.n35 585
R93 B.n36 B.n7 585
R94 B.n37 B.n0 585
R95 B.n37 B.n5 585
R96 B.n39 B.n38 585
R97 B.n41 B.n40 585
R98 B.n42 B.n2 585
R99 B.n44 B.n43 585
R100 B.n3 B.n0 585
R101 B.n4 B.n3 585
R102 B.n35 B.n34 585
R103 B.n34 B.n33 585
R104 B.n9 B.n8 585
R105 B.n32 B.n9 585
R106 B.n30 B.n29 585
R107 B.n31 B.n30 585
R108 B.n12 B.n11 585
R109 B.n11 B.n10 585
R110 B.n17 B.n16 585
R111 B.n19 B.n18 585
R112 B.n15 B.n14 585
R113 B.n24 B.n23 585
R114 B.n35 B.n0 575.385
R115 B.n35 B.n8 575.385
R116 B.n29 B.n8 575.385
R117 B.n29 B.n12 575.385
R118 B.n19 B.n15 394
R119 B.n37 B.n36 394
R120 B.n36 B.n6 394
R121 B.n28 B.n6 394
R122 B.n28 B.n13 394
R123 B.n40 B.n2 394
R124 B.n34 B.n3 394
R125 B.n34 B.n9 394
R126 B.n30 B.n9 394
R127 B.n30 B.n11 394
R128 B B.n46 363.846
R129 B.n46 B.n1 218.815
R130 B.n46 B.n45 218.815
R131 B.n21 B.n20 218.815
R132 B.n22 B.n21 218.815
R133 B.n38 B.n1 147.374
R134 B.n45 B.n2 147.374
R135 B.n20 B.n19 147.374
R136 B.n23 B.n22 147.374
R137 B.n22 B.n15 147.374
R138 B.n20 B.n16 147.374
R139 B.n40 B.n1 147.374
R140 B.n45 B.n44 147.374
R141 B.n39 B.n5 77.177
R142 B.n43 B.n4 77.177
R143 B.n25 B.n24 77.177
R144 B.n17 B.n10 77.177
R145 B.n7 B.n5 25.6005
R146 B.n27 B.n26 25.6005
R147 B.n27 B.n25 25.6005
R148 B.n41 B.n39 25.6005
R149 B.n42 B.n41 25.6005
R150 B.n43 B.n42 25.6005
R151 B.n33 B.n4 25.6005
R152 B.n33 B.n32 25.6005
R153 B.n32 B.n31 25.6005
R154 B.n31 B.n10 25.6005
R155 B.n24 B.n14 25.6005
R156 B.n18 B.n14 25.6005
R157 B.n18 B.n17 25.6005
R158 B B.n7 19.2005
R159 B.n26 B 6.4005
R160 w_n43_n43.n32 w_n43_n43.n3 1187.79
R161 w_n43_n43.n21 w_n43_n43.n11 1187.79
R162 w_n43_n43.n39 w_n43_n43.n7 1187.79
R163 w_n43_n43.n14 w_n43_n43.n9 1187.79
R164 w_n43_n43.n37 w_n43_n43.n5 905.385
R165 w_n43_n43.n19 w_n43_n43.n10 905.385
R166 w_n43_n43.n7 w_n43_n43.n5 585
R167 w_n43_n43.n41 w_n43_n43.n7 585
R168 w_n43_n43.n44 w_n43_n43.n43 585
R169 w_n43_n43.n43 w_n43_n43.n42 585
R170 w_n43_n43.n6 w_n43_n43.n4 585
R171 w_n43_n43.n29 w_n43_n43.n6 585
R172 w_n43_n43.n27 w_n43_n43.n26 585
R173 w_n43_n43.n28 w_n43_n43.n27 585
R174 w_n43_n43.n10 w_n43_n43.n9 585
R175 w_n43_n43.n9 w_n43_n43.n8 585
R176 w_n43_n43.n15 w_n43_n43.n14 585
R177 w_n43_n43.n17 w_n43_n43.n16 585
R178 w_n43_n43.n13 w_n43_n43.n12 585
R179 w_n43_n43.n22 w_n43_n43.n21 585
R180 w_n43_n43.n11 w_n43_n43.n10 585
R181 w_n43_n43.n23 w_n43_n43.n11 585
R182 w_n43_n43.n26 w_n43_n43.n25 585
R183 w_n43_n43.n25 w_n43_n43.n24 585
R184 w_n43_n43.n4 w_n43_n43.n2 585
R185 w_n43_n43.n2 w_n43_n43.n0 585
R186 w_n43_n43.n45 w_n43_n43.n44 585
R187 w_n43_n43.n46 w_n43_n43.n45 585
R188 w_n43_n43.n5 w_n43_n43.n3 585
R189 w_n43_n43.n3 w_n43_n43.n1 585
R190 w_n43_n43.n33 w_n43_n43.n32 585
R191 w_n43_n43.n35 w_n43_n43.n34 585
R192 w_n43_n43.n31 w_n43_n43.n30 585
R193 w_n43_n43.n40 w_n43_n43.n39 585
R194 w_n43_n43.n44 w_n43_n43.n5 575.385
R195 w_n43_n43.n44 w_n43_n43.n4 575.385
R196 w_n43_n43.n26 w_n43_n43.n4 575.385
R197 w_n43_n43.n26 w_n43_n43.n10 575.385
R198 w_n43_n43.n35 w_n43_n43.n31 394
R199 w_n43_n43.n45 w_n43_n43.n3 394
R200 w_n43_n43.n45 w_n43_n43.n2 394
R201 w_n43_n43.n25 w_n43_n43.n2 394
R202 w_n43_n43.n25 w_n43_n43.n11 394
R203 w_n43_n43.n17 w_n43_n43.n13 394
R204 w_n43_n43.n43 w_n43_n43.n7 394
R205 w_n43_n43.n43 w_n43_n43.n6 394
R206 w_n43_n43.n27 w_n43_n43.n6 394
R207 w_n43_n43.n27 w_n43_n43.n9 394
R208 w_n43_n43.n37 B 363.846
R209 w_n43_n43.n19 w_n43_n43.n18 218.815
R210 w_n43_n43.n20 w_n43_n43.n19 218.815
R211 w_n43_n43.n37 w_n43_n43.n36 218.815
R212 w_n43_n43.n38 w_n43_n43.n37 218.815
R213 w_n43_n43.n18 w_n43_n43.n14 147.374
R214 w_n43_n43.n20 w_n43_n43.n13 147.374
R215 w_n43_n43.n36 w_n43_n43.n32 147.374
R216 w_n43_n43.n38 w_n43_n43.n31 147.374
R217 w_n43_n43.n36 w_n43_n43.n35 147.374
R218 w_n43_n43.n39 w_n43_n43.n38 147.374
R219 w_n43_n43.n21 w_n43_n43.n20 147.374
R220 w_n43_n43.n18 w_n43_n43.n17 147.374
R221 w_n43_n43.n33 w_n43_n43.n1 77.177
R222 w_n43_n43.n23 w_n43_n43.n22 77.177
R223 w_n43_n43.n41 w_n43_n43.n40 77.177
R224 w_n43_n43.n15 w_n43_n43.n8 77.177
R225 w_n43_n43.n34 w_n43_n43.n33 25.6005
R226 w_n43_n43.n34 w_n43_n43.n30 25.6005
R227 w_n43_n43.n40 w_n43_n43.n30 25.6005
R228 w_n43_n43.n46 w_n43_n43.n1 25.6005
R229 w_n43_n43.n24 w_n43_n43.n0 25.6005
R230 w_n43_n43.n24 w_n43_n43.n23 25.6005
R231 w_n43_n43.n22 w_n43_n43.n12 25.6005
R232 w_n43_n43.n16 w_n43_n43.n12 25.6005
R233 w_n43_n43.n16 w_n43_n43.n15 25.6005
R234 w_n43_n43.n42 w_n43_n43.n41 25.6005
R235 w_n43_n43.n42 w_n43_n43.n29 25.6005
R236 w_n43_n43.n29 w_n43_n43.n28 25.6005
R237 w_n43_n43.n28 w_n43_n43.n8 25.6005
R238 B w_n43_n43.n46 19.2005
R239 B w_n43_n43.n0 6.4005
C3 B.n0 B 0 ; **FLOATING
C4 B.n2 B 0 ; **FLOATING
C5 B.n3 B 0 ; **FLOATING
C6 B.n4 B 0 ; **FLOATING
C7 B.n5 B 0 ; **FLOATING
C8 B.n6 B 0 ; **FLOATING
C9 B.n7 B 0 ; **FLOATING
C10 B.n8 B 0 ; **FLOATING
C11 B.n9 B 0 ; **FLOATING
C12 B.n10 B 0 ; **FLOATING
C13 B.n11 B 0 ; **FLOATING
C14 B.n12 B 0 ; **FLOATING
C15 B.n13 B 0 ; **FLOATING
C16 B.n14 B 0 ; **FLOATING
C17 B.n15 B 0 ; **FLOATING
C18 B.n16 B 0 ; **FLOATING
C19 B.n17 B 0 ; **FLOATING
C20 B.n18 B 0 ; **FLOATING
C21 B.n19 B 0 ; **FLOATING
C22 B.n21 B 0 ; **FLOATING
C23 B.n23 B 0 ; **FLOATING
C24 B.n24 B 0 ; **FLOATING
C25 B.n25 B 0 ; **FLOATING
C26 B.n26 B 0 ; **FLOATING
C27 B.n27 B 0 ; **FLOATING
C28 B.n28 B 0 ; **FLOATING
C29 B.n29 B 0 ; **FLOATING
C30 B.n30 B 0 ; **FLOATING
C31 B.n31 B 0 ; **FLOATING
C32 B.n32 B 0 ; **FLOATING
C33 B.n33 B 0 ; **FLOATING
C34 B.n34 B 0 ; **FLOATING
C35 B.n35 B 0 ; **FLOATING
C36 B.n36 B 0 ; **FLOATING
C37 B.n37 B 0 ; **FLOATING
C38 B.n38 B 0 ; **FLOATING
C39 B.n39 B 0 ; **FLOATING
C40 B.n40 B 0 ; **FLOATING
C41 B.n41 B 0 ; **FLOATING
C42 B.n42 B 0 ; **FLOATING
C43 B.n43 B 0 ; **FLOATING
C44 B.n44 B 0 ; **FLOATING
C45 B.n46 B 0 ; **FLOATING
C46 S B 0.0808f
C47 D B 0.0808f
C48 G B 0.54976f
