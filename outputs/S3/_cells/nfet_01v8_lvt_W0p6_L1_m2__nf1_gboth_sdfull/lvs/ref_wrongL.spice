.subckt nfet_01v8_lvt_W0p6_L1_m2__nf1_gboth_sdfull D G S B
Xnfet_01v8_lvt_W0p6_L1_m2__nf1_gboth_sdfull D G S B sky130_fd_pr__nfet_01v8_lvt L=1.1 W=0.6 nf=1
.ends
