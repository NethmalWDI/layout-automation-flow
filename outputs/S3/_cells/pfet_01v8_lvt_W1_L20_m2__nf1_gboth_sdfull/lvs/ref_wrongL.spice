.subckt pfet_01v8_lvt_W1_L20_m2__nf1_gboth_sdfull D G S B
Xpfet_01v8_lvt_W1_L20_m2__nf1_gboth_sdfull D G S B sky130_fd_pr__pfet_01v8_lvt L=22 W=1 nf=1
.ends
