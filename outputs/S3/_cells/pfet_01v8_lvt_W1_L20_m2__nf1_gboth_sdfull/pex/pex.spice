* NGSPICE file created from pfet_01v8_lvt_W1_L20_m2__nf1_gboth_sdfull.ext - technology: sky130A

.subckt pfet_01v8_lvt_W1_L20_m2__nf1_gboth_sdfull D S G B
X0 S G D B sky130_fd_pr__pfet_01v8_lvt ad=0.29 pd=2.58 as=0.29 ps=2.58 w=1 l=20
C0 S G 0.08977f
C1 S B 0.09825f
C2 D G 0.08977f
C3 D B 0.09825f
C4 B G 6.28088f
C5 S VSUBS 0.05316f
C6 D VSUBS 0.05316f
C7 G VSUBS 2.04984f
C8 B VSUBS 10.1417f
.ends
