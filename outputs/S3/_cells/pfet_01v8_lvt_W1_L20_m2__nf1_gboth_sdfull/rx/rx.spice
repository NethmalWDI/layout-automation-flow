* NGSPICE file created from pfet_01v8_lvt_W1_L20_m2__nf1_gboth_sdfull.ext - technology: sky130A

X0 S G D pfet_01v8_lvt_W1_L20_m2__nf1_gboth_sdfull_pc/B.t0 sky130_fd_pr__pfet_01v8_lvt ad=0.29 pd=2.58 as=0.29 ps=2.58 w=1 l=20
C0 G S 0.08977f
C1 B D 0.09825f
C2 G B 6.28088f
C3 B S 0.09825f
C4 G D 0.08977f
R0 pfet_01v8_lvt_W1_L20_m2__nf1_gboth_sdfull_pc/B.n277 pfet_01v8_lvt_W1_L20_m2__nf1_gboth_sdfull_pc/B.n29 642.354
R1 pfet_01v8_lvt_W1_L20_m2__nf1_gboth_sdfull_pc/B.n280 pfet_01v8_lvt_W1_L20_m2__nf1_gboth_sdfull_pc/B.n279 642.354
R2 pfet_01v8_lvt_W1_L20_m2__nf1_gboth_sdfull_pc/B.n57 pfet_01v8_lvt_W1_L20_m2__nf1_gboth_sdfull_pc/B.n34 642.354
R3 pfet_01v8_lvt_W1_L20_m2__nf1_gboth_sdfull_pc/B.n186 pfet_01v8_lvt_W1_L20_m2__nf1_gboth_sdfull_pc/B.n37 642.354
R4 pfet_01v8_lvt_W1_L20_m2__nf1_gboth_sdfull_pc/B.n277 pfet_01v8_lvt_W1_L20_m2__nf1_gboth_sdfull_pc/B.n28 240
R5 pfet_01v8_lvt_W1_L20_m2__nf1_gboth_sdfull_pc/B.n199 pfet_01v8_lvt_W1_L20_m2__nf1_gboth_sdfull_pc/B.n28 240
R6 pfet_01v8_lvt_W1_L20_m2__nf1_gboth_sdfull_pc/B.n199 pfet_01v8_lvt_W1_L20_m2__nf1_gboth_sdfull_pc/B.n31 240
R7 pfet_01v8_lvt_W1_L20_m2__nf1_gboth_sdfull_pc/B.n190 pfet_01v8_lvt_W1_L20_m2__nf1_gboth_sdfull_pc/B.n31 240
R8 pfet_01v8_lvt_W1_L20_m2__nf1_gboth_sdfull_pc/B.n190 pfet_01v8_lvt_W1_L20_m2__nf1_gboth_sdfull_pc/B.n37 240
R9 pfet_01v8_lvt_W1_L20_m2__nf1_gboth_sdfull_pc/B.n284 pfet_01v8_lvt_W1_L20_m2__nf1_gboth_sdfull_pc/B.n23 240
R10 pfet_01v8_lvt_W1_L20_m2__nf1_gboth_sdfull_pc/B.n287 pfet_01v8_lvt_W1_L20_m2__nf1_gboth_sdfull_pc/B.n286 240
R11 pfet_01v8_lvt_W1_L20_m2__nf1_gboth_sdfull_pc/B.n291 pfet_01v8_lvt_W1_L20_m2__nf1_gboth_sdfull_pc/B.n20 240
R12 pfet_01v8_lvt_W1_L20_m2__nf1_gboth_sdfull_pc/B.n294 pfet_01v8_lvt_W1_L20_m2__nf1_gboth_sdfull_pc/B.n293 240
R13 pfet_01v8_lvt_W1_L20_m2__nf1_gboth_sdfull_pc/B.n298 pfet_01v8_lvt_W1_L20_m2__nf1_gboth_sdfull_pc/B.n17 240
R14 pfet_01v8_lvt_W1_L20_m2__nf1_gboth_sdfull_pc/B.n301 pfet_01v8_lvt_W1_L20_m2__nf1_gboth_sdfull_pc/B.n300 240
R15 pfet_01v8_lvt_W1_L20_m2__nf1_gboth_sdfull_pc/B.n305 pfet_01v8_lvt_W1_L20_m2__nf1_gboth_sdfull_pc/B.n14 240
R16 pfet_01v8_lvt_W1_L20_m2__nf1_gboth_sdfull_pc/B.n308 pfet_01v8_lvt_W1_L20_m2__nf1_gboth_sdfull_pc/B.n307 240
R17 pfet_01v8_lvt_W1_L20_m2__nf1_gboth_sdfull_pc/B.n312 pfet_01v8_lvt_W1_L20_m2__nf1_gboth_sdfull_pc/B.n11 240
R18 pfet_01v8_lvt_W1_L20_m2__nf1_gboth_sdfull_pc/B.n315 pfet_01v8_lvt_W1_L20_m2__nf1_gboth_sdfull_pc/B.n314 240
R19 pfet_01v8_lvt_W1_L20_m2__nf1_gboth_sdfull_pc/B.n319 pfet_01v8_lvt_W1_L20_m2__nf1_gboth_sdfull_pc/B.n8 240
R20 pfet_01v8_lvt_W1_L20_m2__nf1_gboth_sdfull_pc/B.n322 pfet_01v8_lvt_W1_L20_m2__nf1_gboth_sdfull_pc/B.n321 240
R21 pfet_01v8_lvt_W1_L20_m2__nf1_gboth_sdfull_pc/B.n326 pfet_01v8_lvt_W1_L20_m2__nf1_gboth_sdfull_pc/B.n5 240
R22 pfet_01v8_lvt_W1_L20_m2__nf1_gboth_sdfull_pc/B.n329 pfet_01v8_lvt_W1_L20_m2__nf1_gboth_sdfull_pc/B.n328 240
R23 pfet_01v8_lvt_W1_L20_m2__nf1_gboth_sdfull_pc/B.n331 pfet_01v8_lvt_W1_L20_m2__nf1_gboth_sdfull_pc/B.n2 240
R24 pfet_01v8_lvt_W1_L20_m2__nf1_gboth_sdfull_pc/B.n226 pfet_01v8_lvt_W1_L20_m2__nf1_gboth_sdfull_pc/B.n223 240
R25 pfet_01v8_lvt_W1_L20_m2__nf1_gboth_sdfull_pc/B.n229 pfet_01v8_lvt_W1_L20_m2__nf1_gboth_sdfull_pc/B.n228 240
R26 pfet_01v8_lvt_W1_L20_m2__nf1_gboth_sdfull_pc/B.n233 pfet_01v8_lvt_W1_L20_m2__nf1_gboth_sdfull_pc/B.n219 240
R27 pfet_01v8_lvt_W1_L20_m2__nf1_gboth_sdfull_pc/B.n236 pfet_01v8_lvt_W1_L20_m2__nf1_gboth_sdfull_pc/B.n235 240
R28 pfet_01v8_lvt_W1_L20_m2__nf1_gboth_sdfull_pc/B.n240 pfet_01v8_lvt_W1_L20_m2__nf1_gboth_sdfull_pc/B.n216 240
R29 pfet_01v8_lvt_W1_L20_m2__nf1_gboth_sdfull_pc/B.n243 pfet_01v8_lvt_W1_L20_m2__nf1_gboth_sdfull_pc/B.n242 240
R30 pfet_01v8_lvt_W1_L20_m2__nf1_gboth_sdfull_pc/B.n247 pfet_01v8_lvt_W1_L20_m2__nf1_gboth_sdfull_pc/B.n213 240
R31 pfet_01v8_lvt_W1_L20_m2__nf1_gboth_sdfull_pc/B.n250 pfet_01v8_lvt_W1_L20_m2__nf1_gboth_sdfull_pc/B.n249 240
R32 pfet_01v8_lvt_W1_L20_m2__nf1_gboth_sdfull_pc/B.n254 pfet_01v8_lvt_W1_L20_m2__nf1_gboth_sdfull_pc/B.n210 240
R33 pfet_01v8_lvt_W1_L20_m2__nf1_gboth_sdfull_pc/B.n257 pfet_01v8_lvt_W1_L20_m2__nf1_gboth_sdfull_pc/B.n256 240
R34 pfet_01v8_lvt_W1_L20_m2__nf1_gboth_sdfull_pc/B.n261 pfet_01v8_lvt_W1_L20_m2__nf1_gboth_sdfull_pc/B.n207 240
R35 pfet_01v8_lvt_W1_L20_m2__nf1_gboth_sdfull_pc/B.n264 pfet_01v8_lvt_W1_L20_m2__nf1_gboth_sdfull_pc/B.n263 240
R36 pfet_01v8_lvt_W1_L20_m2__nf1_gboth_sdfull_pc/B.n268 pfet_01v8_lvt_W1_L20_m2__nf1_gboth_sdfull_pc/B.n204 240
R37 pfet_01v8_lvt_W1_L20_m2__nf1_gboth_sdfull_pc/B.n271 pfet_01v8_lvt_W1_L20_m2__nf1_gboth_sdfull_pc/B.n270 240
R38 pfet_01v8_lvt_W1_L20_m2__nf1_gboth_sdfull_pc/B.n273 pfet_01v8_lvt_W1_L20_m2__nf1_gboth_sdfull_pc/B.n29 240
R39 pfet_01v8_lvt_W1_L20_m2__nf1_gboth_sdfull_pc/B.n279 pfet_01v8_lvt_W1_L20_m2__nf1_gboth_sdfull_pc/B.n26 240
R40 pfet_01v8_lvt_W1_L20_m2__nf1_gboth_sdfull_pc/B.n197 pfet_01v8_lvt_W1_L20_m2__nf1_gboth_sdfull_pc/B.n26 240
R41 pfet_01v8_lvt_W1_L20_m2__nf1_gboth_sdfull_pc/B.n197 pfet_01v8_lvt_W1_L20_m2__nf1_gboth_sdfull_pc/B.n32 240
R42 pfet_01v8_lvt_W1_L20_m2__nf1_gboth_sdfull_pc/B.n192 pfet_01v8_lvt_W1_L20_m2__nf1_gboth_sdfull_pc/B.n32 240
R43 pfet_01v8_lvt_W1_L20_m2__nf1_gboth_sdfull_pc/B.n192 pfet_01v8_lvt_W1_L20_m2__nf1_gboth_sdfull_pc/B.n34 240
R44 pfet_01v8_lvt_W1_L20_m2__nf1_gboth_sdfull_pc/B.n86 pfet_01v8_lvt_W1_L20_m2__nf1_gboth_sdfull_pc/B.n57 240
R45 pfet_01v8_lvt_W1_L20_m2__nf1_gboth_sdfull_pc/B.n90 pfet_01v8_lvt_W1_L20_m2__nf1_gboth_sdfull_pc/B.n89 240
R46 pfet_01v8_lvt_W1_L20_m2__nf1_gboth_sdfull_pc/B.n92 pfet_01v8_lvt_W1_L20_m2__nf1_gboth_sdfull_pc/B.n54 240
R47 pfet_01v8_lvt_W1_L20_m2__nf1_gboth_sdfull_pc/B.n95 pfet_01v8_lvt_W1_L20_m2__nf1_gboth_sdfull_pc/B.n54 240
R48 pfet_01v8_lvt_W1_L20_m2__nf1_gboth_sdfull_pc/B.n99 pfet_01v8_lvt_W1_L20_m2__nf1_gboth_sdfull_pc/B.n98 240
R49 pfet_01v8_lvt_W1_L20_m2__nf1_gboth_sdfull_pc/B.n103 pfet_01v8_lvt_W1_L20_m2__nf1_gboth_sdfull_pc/B.n102 240
R50 pfet_01v8_lvt_W1_L20_m2__nf1_gboth_sdfull_pc/B.n107 pfet_01v8_lvt_W1_L20_m2__nf1_gboth_sdfull_pc/B.n106 240
R51 pfet_01v8_lvt_W1_L20_m2__nf1_gboth_sdfull_pc/B.n111 pfet_01v8_lvt_W1_L20_m2__nf1_gboth_sdfull_pc/B.n110 240
R52 pfet_01v8_lvt_W1_L20_m2__nf1_gboth_sdfull_pc/B.n115 pfet_01v8_lvt_W1_L20_m2__nf1_gboth_sdfull_pc/B.n114 240
R53 pfet_01v8_lvt_W1_L20_m2__nf1_gboth_sdfull_pc/B.n119 pfet_01v8_lvt_W1_L20_m2__nf1_gboth_sdfull_pc/B.n118 240
R54 pfet_01v8_lvt_W1_L20_m2__nf1_gboth_sdfull_pc/B.n123 pfet_01v8_lvt_W1_L20_m2__nf1_gboth_sdfull_pc/B.n122 240
R55 pfet_01v8_lvt_W1_L20_m2__nf1_gboth_sdfull_pc/B.n125 pfet_01v8_lvt_W1_L20_m2__nf1_gboth_sdfull_pc/B.n65 240
R56 pfet_01v8_lvt_W1_L20_m2__nf1_gboth_sdfull_pc/B.n128 pfet_01v8_lvt_W1_L20_m2__nf1_gboth_sdfull_pc/B.n65 240
R57 pfet_01v8_lvt_W1_L20_m2__nf1_gboth_sdfull_pc/B.n132 pfet_01v8_lvt_W1_L20_m2__nf1_gboth_sdfull_pc/B.n131 240
R58 pfet_01v8_lvt_W1_L20_m2__nf1_gboth_sdfull_pc/B.n134 pfet_01v8_lvt_W1_L20_m2__nf1_gboth_sdfull_pc/B.n51 240
R59 pfet_01v8_lvt_W1_L20_m2__nf1_gboth_sdfull_pc/B.n137 pfet_01v8_lvt_W1_L20_m2__nf1_gboth_sdfull_pc/B.n51 240
R60 pfet_01v8_lvt_W1_L20_m2__nf1_gboth_sdfull_pc/B.n141 pfet_01v8_lvt_W1_L20_m2__nf1_gboth_sdfull_pc/B.n140 240
R61 pfet_01v8_lvt_W1_L20_m2__nf1_gboth_sdfull_pc/B.n145 pfet_01v8_lvt_W1_L20_m2__nf1_gboth_sdfull_pc/B.n144 240
R62 pfet_01v8_lvt_W1_L20_m2__nf1_gboth_sdfull_pc/B.n147 pfet_01v8_lvt_W1_L20_m2__nf1_gboth_sdfull_pc/B.n69 240
R63 pfet_01v8_lvt_W1_L20_m2__nf1_gboth_sdfull_pc/B.n150 pfet_01v8_lvt_W1_L20_m2__nf1_gboth_sdfull_pc/B.n69 240
R64 pfet_01v8_lvt_W1_L20_m2__nf1_gboth_sdfull_pc/B.n154 pfet_01v8_lvt_W1_L20_m2__nf1_gboth_sdfull_pc/B.n153 240
R65 pfet_01v8_lvt_W1_L20_m2__nf1_gboth_sdfull_pc/B.n158 pfet_01v8_lvt_W1_L20_m2__nf1_gboth_sdfull_pc/B.n157 240
R66 pfet_01v8_lvt_W1_L20_m2__nf1_gboth_sdfull_pc/B.n162 pfet_01v8_lvt_W1_L20_m2__nf1_gboth_sdfull_pc/B.n161 240
R67 pfet_01v8_lvt_W1_L20_m2__nf1_gboth_sdfull_pc/B.n166 pfet_01v8_lvt_W1_L20_m2__nf1_gboth_sdfull_pc/B.n165 240
R68 pfet_01v8_lvt_W1_L20_m2__nf1_gboth_sdfull_pc/B.n170 pfet_01v8_lvt_W1_L20_m2__nf1_gboth_sdfull_pc/B.n169 240
R69 pfet_01v8_lvt_W1_L20_m2__nf1_gboth_sdfull_pc/B.n174 pfet_01v8_lvt_W1_L20_m2__nf1_gboth_sdfull_pc/B.n173 240
R70 pfet_01v8_lvt_W1_L20_m2__nf1_gboth_sdfull_pc/B.n176 pfet_01v8_lvt_W1_L20_m2__nf1_gboth_sdfull_pc/B.n43 240
R71 pfet_01v8_lvt_W1_L20_m2__nf1_gboth_sdfull_pc/B.n179 pfet_01v8_lvt_W1_L20_m2__nf1_gboth_sdfull_pc/B.n43 240
R72 pfet_01v8_lvt_W1_L20_m2__nf1_gboth_sdfull_pc/B.n183 pfet_01v8_lvt_W1_L20_m2__nf1_gboth_sdfull_pc/B.n73 240
R73 pfet_01v8_lvt_W1_L20_m2__nf1_gboth_sdfull_pc/B.n183 pfet_01v8_lvt_W1_L20_m2__nf1_gboth_sdfull_pc/B.n72 240
R74 pfet_01v8_lvt_W1_L20_m2__nf1_gboth_sdfull_pc/B.n82 pfet_01v8_lvt_W1_L20_m2__nf1_gboth_sdfull_pc/B.n81 240
R75 pfet_01v8_lvt_W1_L20_m2__nf1_gboth_sdfull_pc/B.n78 pfet_01v8_lvt_W1_L20_m2__nf1_gboth_sdfull_pc/B.n77 240
R76 pfet_01v8_lvt_W1_L20_m2__nf1_gboth_sdfull_pc/B.n74 pfet_01v8_lvt_W1_L20_m2__nf1_gboth_sdfull_pc/B.n39 240
R77 pfet_01v8_lvt_W1_L20_m2__nf1_gboth_sdfull_pc/B.n29 pfet_01v8_lvt_W1_L20_m2__nf1_gboth_sdfull_pc/B.n3 185
R78 pfet_01v8_lvt_W1_L20_m2__nf1_gboth_sdfull_pc/B.n275 pfet_01v8_lvt_W1_L20_m2__nf1_gboth_sdfull_pc/B.n29 185
R79 pfet_01v8_lvt_W1_L20_m2__nf1_gboth_sdfull_pc/B.n274 pfet_01v8_lvt_W1_L20_m2__nf1_gboth_sdfull_pc/B.n273 185
R80 pfet_01v8_lvt_W1_L20_m2__nf1_gboth_sdfull_pc/B.n271 pfet_01v8_lvt_W1_L20_m2__nf1_gboth_sdfull_pc/B.n202 185
R81 pfet_01v8_lvt_W1_L20_m2__nf1_gboth_sdfull_pc/B.n270 pfet_01v8_lvt_W1_L20_m2__nf1_gboth_sdfull_pc/B.n203 185
R82 pfet_01v8_lvt_W1_L20_m2__nf1_gboth_sdfull_pc/B.n268 pfet_01v8_lvt_W1_L20_m2__nf1_gboth_sdfull_pc/B.n267 185
R83 pfet_01v8_lvt_W1_L20_m2__nf1_gboth_sdfull_pc/B.n266 pfet_01v8_lvt_W1_L20_m2__nf1_gboth_sdfull_pc/B.n204 185
R84 pfet_01v8_lvt_W1_L20_m2__nf1_gboth_sdfull_pc/B.n265 pfet_01v8_lvt_W1_L20_m2__nf1_gboth_sdfull_pc/B.n264 185
R85 pfet_01v8_lvt_W1_L20_m2__nf1_gboth_sdfull_pc/B.n263 pfet_01v8_lvt_W1_L20_m2__nf1_gboth_sdfull_pc/B.n205 185
R86 pfet_01v8_lvt_W1_L20_m2__nf1_gboth_sdfull_pc/B.n261 pfet_01v8_lvt_W1_L20_m2__nf1_gboth_sdfull_pc/B.n260 185
R87 pfet_01v8_lvt_W1_L20_m2__nf1_gboth_sdfull_pc/B.n259 pfet_01v8_lvt_W1_L20_m2__nf1_gboth_sdfull_pc/B.n207 185
R88 pfet_01v8_lvt_W1_L20_m2__nf1_gboth_sdfull_pc/B.n258 pfet_01v8_lvt_W1_L20_m2__nf1_gboth_sdfull_pc/B.n257 185
R89 pfet_01v8_lvt_W1_L20_m2__nf1_gboth_sdfull_pc/B.n256 pfet_01v8_lvt_W1_L20_m2__nf1_gboth_sdfull_pc/B.n208 185
R90 pfet_01v8_lvt_W1_L20_m2__nf1_gboth_sdfull_pc/B.n254 pfet_01v8_lvt_W1_L20_m2__nf1_gboth_sdfull_pc/B.n253 185
R91 pfet_01v8_lvt_W1_L20_m2__nf1_gboth_sdfull_pc/B.n252 pfet_01v8_lvt_W1_L20_m2__nf1_gboth_sdfull_pc/B.n210 185
R92 pfet_01v8_lvt_W1_L20_m2__nf1_gboth_sdfull_pc/B.n251 pfet_01v8_lvt_W1_L20_m2__nf1_gboth_sdfull_pc/B.n250 185
R93 pfet_01v8_lvt_W1_L20_m2__nf1_gboth_sdfull_pc/B.n249 pfet_01v8_lvt_W1_L20_m2__nf1_gboth_sdfull_pc/B.n211 185
R94 pfet_01v8_lvt_W1_L20_m2__nf1_gboth_sdfull_pc/B.n247 pfet_01v8_lvt_W1_L20_m2__nf1_gboth_sdfull_pc/B.n246 185
R95 pfet_01v8_lvt_W1_L20_m2__nf1_gboth_sdfull_pc/B.n245 pfet_01v8_lvt_W1_L20_m2__nf1_gboth_sdfull_pc/B.n213 185
R96 pfet_01v8_lvt_W1_L20_m2__nf1_gboth_sdfull_pc/B.n244 pfet_01v8_lvt_W1_L20_m2__nf1_gboth_sdfull_pc/B.n243 185
R97 pfet_01v8_lvt_W1_L20_m2__nf1_gboth_sdfull_pc/B.n242 pfet_01v8_lvt_W1_L20_m2__nf1_gboth_sdfull_pc/B.n214 185
R98 pfet_01v8_lvt_W1_L20_m2__nf1_gboth_sdfull_pc/B.n240 pfet_01v8_lvt_W1_L20_m2__nf1_gboth_sdfull_pc/B.n239 185
R99 pfet_01v8_lvt_W1_L20_m2__nf1_gboth_sdfull_pc/B.n238 pfet_01v8_lvt_W1_L20_m2__nf1_gboth_sdfull_pc/B.n216 185
R100 pfet_01v8_lvt_W1_L20_m2__nf1_gboth_sdfull_pc/B.n237 pfet_01v8_lvt_W1_L20_m2__nf1_gboth_sdfull_pc/B.n236 185
R101 pfet_01v8_lvt_W1_L20_m2__nf1_gboth_sdfull_pc/B.n235 pfet_01v8_lvt_W1_L20_m2__nf1_gboth_sdfull_pc/B.n217 185
R102 pfet_01v8_lvt_W1_L20_m2__nf1_gboth_sdfull_pc/B.n233 pfet_01v8_lvt_W1_L20_m2__nf1_gboth_sdfull_pc/B.n232 185
R103 pfet_01v8_lvt_W1_L20_m2__nf1_gboth_sdfull_pc/B.n231 pfet_01v8_lvt_W1_L20_m2__nf1_gboth_sdfull_pc/B.n219 185
R104 pfet_01v8_lvt_W1_L20_m2__nf1_gboth_sdfull_pc/B.n230 pfet_01v8_lvt_W1_L20_m2__nf1_gboth_sdfull_pc/B.n229 185
R105 pfet_01v8_lvt_W1_L20_m2__nf1_gboth_sdfull_pc/B.n228 pfet_01v8_lvt_W1_L20_m2__nf1_gboth_sdfull_pc/B.n220 185
R106 pfet_01v8_lvt_W1_L20_m2__nf1_gboth_sdfull_pc/B.n226 pfet_01v8_lvt_W1_L20_m2__nf1_gboth_sdfull_pc/B.n225 185
R107 pfet_01v8_lvt_W1_L20_m2__nf1_gboth_sdfull_pc/B.n224 pfet_01v8_lvt_W1_L20_m2__nf1_gboth_sdfull_pc/B.n223 185
R108 pfet_01v8_lvt_W1_L20_m2__nf1_gboth_sdfull_pc/B.n2 pfet_01v8_lvt_W1_L20_m2__nf1_gboth_sdfull_pc/B.n0 185
R109 pfet_01v8_lvt_W1_L20_m2__nf1_gboth_sdfull_pc/B.n332 pfet_01v8_lvt_W1_L20_m2__nf1_gboth_sdfull_pc/B.n331 185
R110 pfet_01v8_lvt_W1_L20_m2__nf1_gboth_sdfull_pc/B.n329 pfet_01v8_lvt_W1_L20_m2__nf1_gboth_sdfull_pc/B.n1 185
R111 pfet_01v8_lvt_W1_L20_m2__nf1_gboth_sdfull_pc/B.n328 pfet_01v8_lvt_W1_L20_m2__nf1_gboth_sdfull_pc/B.n4 185
R112 pfet_01v8_lvt_W1_L20_m2__nf1_gboth_sdfull_pc/B.n326 pfet_01v8_lvt_W1_L20_m2__nf1_gboth_sdfull_pc/B.n325 185
R113 pfet_01v8_lvt_W1_L20_m2__nf1_gboth_sdfull_pc/B.n324 pfet_01v8_lvt_W1_L20_m2__nf1_gboth_sdfull_pc/B.n5 185
R114 pfet_01v8_lvt_W1_L20_m2__nf1_gboth_sdfull_pc/B.n323 pfet_01v8_lvt_W1_L20_m2__nf1_gboth_sdfull_pc/B.n322 185
R115 pfet_01v8_lvt_W1_L20_m2__nf1_gboth_sdfull_pc/B.n321 pfet_01v8_lvt_W1_L20_m2__nf1_gboth_sdfull_pc/B.n6 185
R116 pfet_01v8_lvt_W1_L20_m2__nf1_gboth_sdfull_pc/B.n319 pfet_01v8_lvt_W1_L20_m2__nf1_gboth_sdfull_pc/B.n318 185
R117 pfet_01v8_lvt_W1_L20_m2__nf1_gboth_sdfull_pc/B.n317 pfet_01v8_lvt_W1_L20_m2__nf1_gboth_sdfull_pc/B.n8 185
R118 pfet_01v8_lvt_W1_L20_m2__nf1_gboth_sdfull_pc/B.n316 pfet_01v8_lvt_W1_L20_m2__nf1_gboth_sdfull_pc/B.n315 185
R119 pfet_01v8_lvt_W1_L20_m2__nf1_gboth_sdfull_pc/B.n314 pfet_01v8_lvt_W1_L20_m2__nf1_gboth_sdfull_pc/B.n9 185
R120 pfet_01v8_lvt_W1_L20_m2__nf1_gboth_sdfull_pc/B.n312 pfet_01v8_lvt_W1_L20_m2__nf1_gboth_sdfull_pc/B.n311 185
R121 pfet_01v8_lvt_W1_L20_m2__nf1_gboth_sdfull_pc/B.n310 pfet_01v8_lvt_W1_L20_m2__nf1_gboth_sdfull_pc/B.n11 185
R122 pfet_01v8_lvt_W1_L20_m2__nf1_gboth_sdfull_pc/B.n309 pfet_01v8_lvt_W1_L20_m2__nf1_gboth_sdfull_pc/B.n308 185
R123 pfet_01v8_lvt_W1_L20_m2__nf1_gboth_sdfull_pc/B.n307 pfet_01v8_lvt_W1_L20_m2__nf1_gboth_sdfull_pc/B.n12 185
R124 pfet_01v8_lvt_W1_L20_m2__nf1_gboth_sdfull_pc/B.n305 pfet_01v8_lvt_W1_L20_m2__nf1_gboth_sdfull_pc/B.n304 185
R125 pfet_01v8_lvt_W1_L20_m2__nf1_gboth_sdfull_pc/B.n303 pfet_01v8_lvt_W1_L20_m2__nf1_gboth_sdfull_pc/B.n14 185
R126 pfet_01v8_lvt_W1_L20_m2__nf1_gboth_sdfull_pc/B.n302 pfet_01v8_lvt_W1_L20_m2__nf1_gboth_sdfull_pc/B.n301 185
R127 pfet_01v8_lvt_W1_L20_m2__nf1_gboth_sdfull_pc/B.n300 pfet_01v8_lvt_W1_L20_m2__nf1_gboth_sdfull_pc/B.n15 185
R128 pfet_01v8_lvt_W1_L20_m2__nf1_gboth_sdfull_pc/B.n298 pfet_01v8_lvt_W1_L20_m2__nf1_gboth_sdfull_pc/B.n297 185
R129 pfet_01v8_lvt_W1_L20_m2__nf1_gboth_sdfull_pc/B.n296 pfet_01v8_lvt_W1_L20_m2__nf1_gboth_sdfull_pc/B.n17 185
R130 pfet_01v8_lvt_W1_L20_m2__nf1_gboth_sdfull_pc/B.n295 pfet_01v8_lvt_W1_L20_m2__nf1_gboth_sdfull_pc/B.n294 185
R131 pfet_01v8_lvt_W1_L20_m2__nf1_gboth_sdfull_pc/B.n293 pfet_01v8_lvt_W1_L20_m2__nf1_gboth_sdfull_pc/B.n18 185
R132 pfet_01v8_lvt_W1_L20_m2__nf1_gboth_sdfull_pc/B.n291 pfet_01v8_lvt_W1_L20_m2__nf1_gboth_sdfull_pc/B.n290 185
R133 pfet_01v8_lvt_W1_L20_m2__nf1_gboth_sdfull_pc/B.n289 pfet_01v8_lvt_W1_L20_m2__nf1_gboth_sdfull_pc/B.n20 185
R134 pfet_01v8_lvt_W1_L20_m2__nf1_gboth_sdfull_pc/B.n288 pfet_01v8_lvt_W1_L20_m2__nf1_gboth_sdfull_pc/B.n287 185
R135 pfet_01v8_lvt_W1_L20_m2__nf1_gboth_sdfull_pc/B.n286 pfet_01v8_lvt_W1_L20_m2__nf1_gboth_sdfull_pc/B.n21 185
R136 pfet_01v8_lvt_W1_L20_m2__nf1_gboth_sdfull_pc/B.n284 pfet_01v8_lvt_W1_L20_m2__nf1_gboth_sdfull_pc/B.n283 185
R137 pfet_01v8_lvt_W1_L20_m2__nf1_gboth_sdfull_pc/B.n282 pfet_01v8_lvt_W1_L20_m2__nf1_gboth_sdfull_pc/B.n23 185
R138 pfet_01v8_lvt_W1_L20_m2__nf1_gboth_sdfull_pc/B.n281 pfet_01v8_lvt_W1_L20_m2__nf1_gboth_sdfull_pc/B.n280 185
R139 pfet_01v8_lvt_W1_L20_m2__nf1_gboth_sdfull_pc/B.n279 pfet_01v8_lvt_W1_L20_m2__nf1_gboth_sdfull_pc/B.n278 185
R140 pfet_01v8_lvt_W1_L20_m2__nf1_gboth_sdfull_pc/B.n279 pfet_01v8_lvt_W1_L20_m2__nf1_gboth_sdfull_pc/B.n24 185
R141 pfet_01v8_lvt_W1_L20_m2__nf1_gboth_sdfull_pc/B.n27 pfet_01v8_lvt_W1_L20_m2__nf1_gboth_sdfull_pc/B.n26 185
R142 pfet_01v8_lvt_W1_L20_m2__nf1_gboth_sdfull_pc/B.n195 pfet_01v8_lvt_W1_L20_m2__nf1_gboth_sdfull_pc/B.n26 185
R143 pfet_01v8_lvt_W1_L20_m2__nf1_gboth_sdfull_pc/B.n198 pfet_01v8_lvt_W1_L20_m2__nf1_gboth_sdfull_pc/B.n197 185
R144 pfet_01v8_lvt_W1_L20_m2__nf1_gboth_sdfull_pc/B.n197 pfet_01v8_lvt_W1_L20_m2__nf1_gboth_sdfull_pc/B.n196 185
R145 pfet_01v8_lvt_W1_L20_m2__nf1_gboth_sdfull_pc/B.n36 pfet_01v8_lvt_W1_L20_m2__nf1_gboth_sdfull_pc/B.n32 185
R146 pfet_01v8_lvt_W1_L20_m2__nf1_gboth_sdfull_pc/B.n194 pfet_01v8_lvt_W1_L20_m2__nf1_gboth_sdfull_pc/B.n32 185
R147 pfet_01v8_lvt_W1_L20_m2__nf1_gboth_sdfull_pc/B.n192 pfet_01v8_lvt_W1_L20_m2__nf1_gboth_sdfull_pc/B.n191 185
R148 pfet_01v8_lvt_W1_L20_m2__nf1_gboth_sdfull_pc/B.n193 pfet_01v8_lvt_W1_L20_m2__nf1_gboth_sdfull_pc/B.n192 185
R149 pfet_01v8_lvt_W1_L20_m2__nf1_gboth_sdfull_pc/B.n35 pfet_01v8_lvt_W1_L20_m2__nf1_gboth_sdfull_pc/B.n34 185
R150 pfet_01v8_lvt_W1_L20_m2__nf1_gboth_sdfull_pc/B.n34 pfet_01v8_lvt_W1_L20_m2__nf1_gboth_sdfull_pc/B.n33 185
R151 pfet_01v8_lvt_W1_L20_m2__nf1_gboth_sdfull_pc/B.n184 pfet_01v8_lvt_W1_L20_m2__nf1_gboth_sdfull_pc/B.n57 185
R152 pfet_01v8_lvt_W1_L20_m2__nf1_gboth_sdfull_pc/B.n85 pfet_01v8_lvt_W1_L20_m2__nf1_gboth_sdfull_pc/B.n57 185
R153 pfet_01v8_lvt_W1_L20_m2__nf1_gboth_sdfull_pc/B.n87 pfet_01v8_lvt_W1_L20_m2__nf1_gboth_sdfull_pc/B.n86 185
R154 pfet_01v8_lvt_W1_L20_m2__nf1_gboth_sdfull_pc/B.n89 pfet_01v8_lvt_W1_L20_m2__nf1_gboth_sdfull_pc/B.n88 185
R155 pfet_01v8_lvt_W1_L20_m2__nf1_gboth_sdfull_pc/B.n91 pfet_01v8_lvt_W1_L20_m2__nf1_gboth_sdfull_pc/B.n90 185
R156 pfet_01v8_lvt_W1_L20_m2__nf1_gboth_sdfull_pc/B.n93 pfet_01v8_lvt_W1_L20_m2__nf1_gboth_sdfull_pc/B.n92 185
R157 pfet_01v8_lvt_W1_L20_m2__nf1_gboth_sdfull_pc/B.n184 pfet_01v8_lvt_W1_L20_m2__nf1_gboth_sdfull_pc/B.n54 185
R158 pfet_01v8_lvt_W1_L20_m2__nf1_gboth_sdfull_pc/B.n94 pfet_01v8_lvt_W1_L20_m2__nf1_gboth_sdfull_pc/B.n54 185
R159 pfet_01v8_lvt_W1_L20_m2__nf1_gboth_sdfull_pc/B.n96 pfet_01v8_lvt_W1_L20_m2__nf1_gboth_sdfull_pc/B.n95 185
R160 pfet_01v8_lvt_W1_L20_m2__nf1_gboth_sdfull_pc/B.n98 pfet_01v8_lvt_W1_L20_m2__nf1_gboth_sdfull_pc/B.n97 185
R161 pfet_01v8_lvt_W1_L20_m2__nf1_gboth_sdfull_pc/B.n100 pfet_01v8_lvt_W1_L20_m2__nf1_gboth_sdfull_pc/B.n99 185
R162 pfet_01v8_lvt_W1_L20_m2__nf1_gboth_sdfull_pc/B.n102 pfet_01v8_lvt_W1_L20_m2__nf1_gboth_sdfull_pc/B.n101 185
R163 pfet_01v8_lvt_W1_L20_m2__nf1_gboth_sdfull_pc/B.n104 pfet_01v8_lvt_W1_L20_m2__nf1_gboth_sdfull_pc/B.n103 185
R164 pfet_01v8_lvt_W1_L20_m2__nf1_gboth_sdfull_pc/B.n106 pfet_01v8_lvt_W1_L20_m2__nf1_gboth_sdfull_pc/B.n105 185
R165 pfet_01v8_lvt_W1_L20_m2__nf1_gboth_sdfull_pc/B.n108 pfet_01v8_lvt_W1_L20_m2__nf1_gboth_sdfull_pc/B.n107 185
R166 pfet_01v8_lvt_W1_L20_m2__nf1_gboth_sdfull_pc/B.n110 pfet_01v8_lvt_W1_L20_m2__nf1_gboth_sdfull_pc/B.n109 185
R167 pfet_01v8_lvt_W1_L20_m2__nf1_gboth_sdfull_pc/B.n112 pfet_01v8_lvt_W1_L20_m2__nf1_gboth_sdfull_pc/B.n111 185
R168 pfet_01v8_lvt_W1_L20_m2__nf1_gboth_sdfull_pc/B.n114 pfet_01v8_lvt_W1_L20_m2__nf1_gboth_sdfull_pc/B.n113 185
R169 pfet_01v8_lvt_W1_L20_m2__nf1_gboth_sdfull_pc/B.n116 pfet_01v8_lvt_W1_L20_m2__nf1_gboth_sdfull_pc/B.n115 185
R170 pfet_01v8_lvt_W1_L20_m2__nf1_gboth_sdfull_pc/B.n118 pfet_01v8_lvt_W1_L20_m2__nf1_gboth_sdfull_pc/B.n117 185
R171 pfet_01v8_lvt_W1_L20_m2__nf1_gboth_sdfull_pc/B.n120 pfet_01v8_lvt_W1_L20_m2__nf1_gboth_sdfull_pc/B.n119 185
R172 pfet_01v8_lvt_W1_L20_m2__nf1_gboth_sdfull_pc/B.n122 pfet_01v8_lvt_W1_L20_m2__nf1_gboth_sdfull_pc/B.n121 185
R173 pfet_01v8_lvt_W1_L20_m2__nf1_gboth_sdfull_pc/B.n124 pfet_01v8_lvt_W1_L20_m2__nf1_gboth_sdfull_pc/B.n123 185
R174 pfet_01v8_lvt_W1_L20_m2__nf1_gboth_sdfull_pc/B.n126 pfet_01v8_lvt_W1_L20_m2__nf1_gboth_sdfull_pc/B.n125 185
R175 pfet_01v8_lvt_W1_L20_m2__nf1_gboth_sdfull_pc/B.n184 pfet_01v8_lvt_W1_L20_m2__nf1_gboth_sdfull_pc/B.n65 185
R176 pfet_01v8_lvt_W1_L20_m2__nf1_gboth_sdfull_pc/B.n127 pfet_01v8_lvt_W1_L20_m2__nf1_gboth_sdfull_pc/B.n65 185
R177 pfet_01v8_lvt_W1_L20_m2__nf1_gboth_sdfull_pc/B.n129 pfet_01v8_lvt_W1_L20_m2__nf1_gboth_sdfull_pc/B.n128 185
R178 pfet_01v8_lvt_W1_L20_m2__nf1_gboth_sdfull_pc/B.n131 pfet_01v8_lvt_W1_L20_m2__nf1_gboth_sdfull_pc/B.n130 185
R179 pfet_01v8_lvt_W1_L20_m2__nf1_gboth_sdfull_pc/B.n133 pfet_01v8_lvt_W1_L20_m2__nf1_gboth_sdfull_pc/B.n132 185
R180 pfet_01v8_lvt_W1_L20_m2__nf1_gboth_sdfull_pc/B.n135 pfet_01v8_lvt_W1_L20_m2__nf1_gboth_sdfull_pc/B.n134 185
R181 pfet_01v8_lvt_W1_L20_m2__nf1_gboth_sdfull_pc/B.n184 pfet_01v8_lvt_W1_L20_m2__nf1_gboth_sdfull_pc/B.n51 185
R182 pfet_01v8_lvt_W1_L20_m2__nf1_gboth_sdfull_pc/B.n136 pfet_01v8_lvt_W1_L20_m2__nf1_gboth_sdfull_pc/B.n51 185
R183 pfet_01v8_lvt_W1_L20_m2__nf1_gboth_sdfull_pc/B.n138 pfet_01v8_lvt_W1_L20_m2__nf1_gboth_sdfull_pc/B.n137 185
R184 pfet_01v8_lvt_W1_L20_m2__nf1_gboth_sdfull_pc/B.n140 pfet_01v8_lvt_W1_L20_m2__nf1_gboth_sdfull_pc/B.n139 185
R185 pfet_01v8_lvt_W1_L20_m2__nf1_gboth_sdfull_pc/B.n142 pfet_01v8_lvt_W1_L20_m2__nf1_gboth_sdfull_pc/B.n141 185
R186 pfet_01v8_lvt_W1_L20_m2__nf1_gboth_sdfull_pc/B.n144 pfet_01v8_lvt_W1_L20_m2__nf1_gboth_sdfull_pc/B.n143 185
R187 pfet_01v8_lvt_W1_L20_m2__nf1_gboth_sdfull_pc/B.n146 pfet_01v8_lvt_W1_L20_m2__nf1_gboth_sdfull_pc/B.n145 185
R188 pfet_01v8_lvt_W1_L20_m2__nf1_gboth_sdfull_pc/B.n148 pfet_01v8_lvt_W1_L20_m2__nf1_gboth_sdfull_pc/B.n147 185
R189 pfet_01v8_lvt_W1_L20_m2__nf1_gboth_sdfull_pc/B.n184 pfet_01v8_lvt_W1_L20_m2__nf1_gboth_sdfull_pc/B.n69 185
R190 pfet_01v8_lvt_W1_L20_m2__nf1_gboth_sdfull_pc/B.n149 pfet_01v8_lvt_W1_L20_m2__nf1_gboth_sdfull_pc/B.n69 185
R191 pfet_01v8_lvt_W1_L20_m2__nf1_gboth_sdfull_pc/B.n151 pfet_01v8_lvt_W1_L20_m2__nf1_gboth_sdfull_pc/B.n150 185
R192 pfet_01v8_lvt_W1_L20_m2__nf1_gboth_sdfull_pc/B.n153 pfet_01v8_lvt_W1_L20_m2__nf1_gboth_sdfull_pc/B.n152 185
R193 pfet_01v8_lvt_W1_L20_m2__nf1_gboth_sdfull_pc/B.n155 pfet_01v8_lvt_W1_L20_m2__nf1_gboth_sdfull_pc/B.n154 185
R194 pfet_01v8_lvt_W1_L20_m2__nf1_gboth_sdfull_pc/B.n157 pfet_01v8_lvt_W1_L20_m2__nf1_gboth_sdfull_pc/B.n156 185
R195 pfet_01v8_lvt_W1_L20_m2__nf1_gboth_sdfull_pc/B.n159 pfet_01v8_lvt_W1_L20_m2__nf1_gboth_sdfull_pc/B.n158 185
R196 pfet_01v8_lvt_W1_L20_m2__nf1_gboth_sdfull_pc/B.n161 pfet_01v8_lvt_W1_L20_m2__nf1_gboth_sdfull_pc/B.n160 185
R197 pfet_01v8_lvt_W1_L20_m2__nf1_gboth_sdfull_pc/B.n163 pfet_01v8_lvt_W1_L20_m2__nf1_gboth_sdfull_pc/B.n162 185
R198 pfet_01v8_lvt_W1_L20_m2__nf1_gboth_sdfull_pc/B.n165 pfet_01v8_lvt_W1_L20_m2__nf1_gboth_sdfull_pc/B.n164 185
R199 pfet_01v8_lvt_W1_L20_m2__nf1_gboth_sdfull_pc/B.n167 pfet_01v8_lvt_W1_L20_m2__nf1_gboth_sdfull_pc/B.n166 185
R200 pfet_01v8_lvt_W1_L20_m2__nf1_gboth_sdfull_pc/B.n169 pfet_01v8_lvt_W1_L20_m2__nf1_gboth_sdfull_pc/B.n168 185
R201 pfet_01v8_lvt_W1_L20_m2__nf1_gboth_sdfull_pc/B.n171 pfet_01v8_lvt_W1_L20_m2__nf1_gboth_sdfull_pc/B.n170 185
R202 pfet_01v8_lvt_W1_L20_m2__nf1_gboth_sdfull_pc/B.n173 pfet_01v8_lvt_W1_L20_m2__nf1_gboth_sdfull_pc/B.n172 185
R203 pfet_01v8_lvt_W1_L20_m2__nf1_gboth_sdfull_pc/B.n175 pfet_01v8_lvt_W1_L20_m2__nf1_gboth_sdfull_pc/B.n174 185
R204 pfet_01v8_lvt_W1_L20_m2__nf1_gboth_sdfull_pc/B.n177 pfet_01v8_lvt_W1_L20_m2__nf1_gboth_sdfull_pc/B.n176 185
R205 pfet_01v8_lvt_W1_L20_m2__nf1_gboth_sdfull_pc/B.n184 pfet_01v8_lvt_W1_L20_m2__nf1_gboth_sdfull_pc/B.n43 185
R206 pfet_01v8_lvt_W1_L20_m2__nf1_gboth_sdfull_pc/B.n178 pfet_01v8_lvt_W1_L20_m2__nf1_gboth_sdfull_pc/B.n43 185
R207 pfet_01v8_lvt_W1_L20_m2__nf1_gboth_sdfull_pc/B.n180 pfet_01v8_lvt_W1_L20_m2__nf1_gboth_sdfull_pc/B.n179 185
R208 pfet_01v8_lvt_W1_L20_m2__nf1_gboth_sdfull_pc/B.n181 pfet_01v8_lvt_W1_L20_m2__nf1_gboth_sdfull_pc/B.n73 185
R209 pfet_01v8_lvt_W1_L20_m2__nf1_gboth_sdfull_pc/B.n184 pfet_01v8_lvt_W1_L20_m2__nf1_gboth_sdfull_pc/B.n183 185
R210 pfet_01v8_lvt_W1_L20_m2__nf1_gboth_sdfull_pc/B.n183 pfet_01v8_lvt_W1_L20_m2__nf1_gboth_sdfull_pc/B.n182 185
R211 pfet_01v8_lvt_W1_L20_m2__nf1_gboth_sdfull_pc/B.n84 pfet_01v8_lvt_W1_L20_m2__nf1_gboth_sdfull_pc/B.n72 185
R212 pfet_01v8_lvt_W1_L20_m2__nf1_gboth_sdfull_pc/B.n83 pfet_01v8_lvt_W1_L20_m2__nf1_gboth_sdfull_pc/B.n82 185
R213 pfet_01v8_lvt_W1_L20_m2__nf1_gboth_sdfull_pc/B.n81 pfet_01v8_lvt_W1_L20_m2__nf1_gboth_sdfull_pc/B.n80 185
R214 pfet_01v8_lvt_W1_L20_m2__nf1_gboth_sdfull_pc/B.n79 pfet_01v8_lvt_W1_L20_m2__nf1_gboth_sdfull_pc/B.n78 185
R215 pfet_01v8_lvt_W1_L20_m2__nf1_gboth_sdfull_pc/B.n77 pfet_01v8_lvt_W1_L20_m2__nf1_gboth_sdfull_pc/B.n76 185
R216 pfet_01v8_lvt_W1_L20_m2__nf1_gboth_sdfull_pc/B.n75 pfet_01v8_lvt_W1_L20_m2__nf1_gboth_sdfull_pc/B.n74 185
R217 pfet_01v8_lvt_W1_L20_m2__nf1_gboth_sdfull_pc/B.n39 pfet_01v8_lvt_W1_L20_m2__nf1_gboth_sdfull_pc/B.n38 185
R218 pfet_01v8_lvt_W1_L20_m2__nf1_gboth_sdfull_pc/B.n187 pfet_01v8_lvt_W1_L20_m2__nf1_gboth_sdfull_pc/B.n186 185
R219 pfet_01v8_lvt_W1_L20_m2__nf1_gboth_sdfull_pc/B.n37 pfet_01v8_lvt_W1_L20_m2__nf1_gboth_sdfull_pc/B.n35 185
R220 pfet_01v8_lvt_W1_L20_m2__nf1_gboth_sdfull_pc/B.n188 pfet_01v8_lvt_W1_L20_m2__nf1_gboth_sdfull_pc/B.n37 185
R221 pfet_01v8_lvt_W1_L20_m2__nf1_gboth_sdfull_pc/B.n191 pfet_01v8_lvt_W1_L20_m2__nf1_gboth_sdfull_pc/B.n190 185
R222 pfet_01v8_lvt_W1_L20_m2__nf1_gboth_sdfull_pc/B.n190 pfet_01v8_lvt_W1_L20_m2__nf1_gboth_sdfull_pc/B.n189 185
R223 pfet_01v8_lvt_W1_L20_m2__nf1_gboth_sdfull_pc/B.n36 pfet_01v8_lvt_W1_L20_m2__nf1_gboth_sdfull_pc/B.n31 185
R224 pfet_01v8_lvt_W1_L20_m2__nf1_gboth_sdfull_pc/B.n31 pfet_01v8_lvt_W1_L20_m2__nf1_gboth_sdfull_pc/B.n30 185
R225 pfet_01v8_lvt_W1_L20_m2__nf1_gboth_sdfull_pc/B.n199 pfet_01v8_lvt_W1_L20_m2__nf1_gboth_sdfull_pc/B.n198 185
R226 pfet_01v8_lvt_W1_L20_m2__nf1_gboth_sdfull_pc/B.n200 pfet_01v8_lvt_W1_L20_m2__nf1_gboth_sdfull_pc/B.n199 185
R227 pfet_01v8_lvt_W1_L20_m2__nf1_gboth_sdfull_pc/B.n28 pfet_01v8_lvt_W1_L20_m2__nf1_gboth_sdfull_pc/B.n27 185
R228 pfet_01v8_lvt_W1_L20_m2__nf1_gboth_sdfull_pc/B.n201 pfet_01v8_lvt_W1_L20_m2__nf1_gboth_sdfull_pc/B.n28 185
R229 pfet_01v8_lvt_W1_L20_m2__nf1_gboth_sdfull_pc/B.n278 pfet_01v8_lvt_W1_L20_m2__nf1_gboth_sdfull_pc/B.n277 185
R230 pfet_01v8_lvt_W1_L20_m2__nf1_gboth_sdfull_pc/B.n277 pfet_01v8_lvt_W1_L20_m2__nf1_gboth_sdfull_pc/B.n276 185
R231 pfet_01v8_lvt_W1_L20_m2__nf1_gboth_sdfull_pc/B.n273 pfet_01v8_lvt_W1_L20_m2__nf1_gboth_sdfull_pc/B.n272 72.7879
R232 pfet_01v8_lvt_W1_L20_m2__nf1_gboth_sdfull_pc/B.n270 pfet_01v8_lvt_W1_L20_m2__nf1_gboth_sdfull_pc/B.n269 72.7879
R233 pfet_01v8_lvt_W1_L20_m2__nf1_gboth_sdfull_pc/B.n206 pfet_01v8_lvt_W1_L20_m2__nf1_gboth_sdfull_pc/B.n204 72.7879
R234 pfet_01v8_lvt_W1_L20_m2__nf1_gboth_sdfull_pc/B.n263 pfet_01v8_lvt_W1_L20_m2__nf1_gboth_sdfull_pc/B.n262 72.7879
R235 pfet_01v8_lvt_W1_L20_m2__nf1_gboth_sdfull_pc/B.n209 pfet_01v8_lvt_W1_L20_m2__nf1_gboth_sdfull_pc/B.n207 72.7879
R236 pfet_01v8_lvt_W1_L20_m2__nf1_gboth_sdfull_pc/B.n256 pfet_01v8_lvt_W1_L20_m2__nf1_gboth_sdfull_pc/B.n255 72.7879
R237 pfet_01v8_lvt_W1_L20_m2__nf1_gboth_sdfull_pc/B.n212 pfet_01v8_lvt_W1_L20_m2__nf1_gboth_sdfull_pc/B.n210 72.7879
R238 pfet_01v8_lvt_W1_L20_m2__nf1_gboth_sdfull_pc/B.n249 pfet_01v8_lvt_W1_L20_m2__nf1_gboth_sdfull_pc/B.n248 72.7879
R239 pfet_01v8_lvt_W1_L20_m2__nf1_gboth_sdfull_pc/B.n215 pfet_01v8_lvt_W1_L20_m2__nf1_gboth_sdfull_pc/B.n213 72.7879
R240 pfet_01v8_lvt_W1_L20_m2__nf1_gboth_sdfull_pc/B.n242 pfet_01v8_lvt_W1_L20_m2__nf1_gboth_sdfull_pc/B.n241 72.7879
R241 pfet_01v8_lvt_W1_L20_m2__nf1_gboth_sdfull_pc/B.n218 pfet_01v8_lvt_W1_L20_m2__nf1_gboth_sdfull_pc/B.n216 72.7879
R242 pfet_01v8_lvt_W1_L20_m2__nf1_gboth_sdfull_pc/B.n235 pfet_01v8_lvt_W1_L20_m2__nf1_gboth_sdfull_pc/B.n234 72.7879
R243 pfet_01v8_lvt_W1_L20_m2__nf1_gboth_sdfull_pc/B.n221 pfet_01v8_lvt_W1_L20_m2__nf1_gboth_sdfull_pc/B.n219 72.7879
R244 pfet_01v8_lvt_W1_L20_m2__nf1_gboth_sdfull_pc/B.n228 pfet_01v8_lvt_W1_L20_m2__nf1_gboth_sdfull_pc/B.n227 72.7879
R245 pfet_01v8_lvt_W1_L20_m2__nf1_gboth_sdfull_pc/B.n223 pfet_01v8_lvt_W1_L20_m2__nf1_gboth_sdfull_pc/B.n222 72.7879
R246 pfet_01v8_lvt_W1_L20_m2__nf1_gboth_sdfull_pc/B.n331 pfet_01v8_lvt_W1_L20_m2__nf1_gboth_sdfull_pc/B.n330 72.7879
R247 pfet_01v8_lvt_W1_L20_m2__nf1_gboth_sdfull_pc/B.n328 pfet_01v8_lvt_W1_L20_m2__nf1_gboth_sdfull_pc/B.n327 72.7879
R248 pfet_01v8_lvt_W1_L20_m2__nf1_gboth_sdfull_pc/B.n7 pfet_01v8_lvt_W1_L20_m2__nf1_gboth_sdfull_pc/B.n5 72.7879
R249 pfet_01v8_lvt_W1_L20_m2__nf1_gboth_sdfull_pc/B.n321 pfet_01v8_lvt_W1_L20_m2__nf1_gboth_sdfull_pc/B.n320 72.7879
R250 pfet_01v8_lvt_W1_L20_m2__nf1_gboth_sdfull_pc/B.n10 pfet_01v8_lvt_W1_L20_m2__nf1_gboth_sdfull_pc/B.n8 72.7879
R251 pfet_01v8_lvt_W1_L20_m2__nf1_gboth_sdfull_pc/B.n314 pfet_01v8_lvt_W1_L20_m2__nf1_gboth_sdfull_pc/B.n313 72.7879
R252 pfet_01v8_lvt_W1_L20_m2__nf1_gboth_sdfull_pc/B.n13 pfet_01v8_lvt_W1_L20_m2__nf1_gboth_sdfull_pc/B.n11 72.7879
R253 pfet_01v8_lvt_W1_L20_m2__nf1_gboth_sdfull_pc/B.n307 pfet_01v8_lvt_W1_L20_m2__nf1_gboth_sdfull_pc/B.n306 72.7879
R254 pfet_01v8_lvt_W1_L20_m2__nf1_gboth_sdfull_pc/B.n16 pfet_01v8_lvt_W1_L20_m2__nf1_gboth_sdfull_pc/B.n14 72.7879
R255 pfet_01v8_lvt_W1_L20_m2__nf1_gboth_sdfull_pc/B.n300 pfet_01v8_lvt_W1_L20_m2__nf1_gboth_sdfull_pc/B.n299 72.7879
R256 pfet_01v8_lvt_W1_L20_m2__nf1_gboth_sdfull_pc/B.n19 pfet_01v8_lvt_W1_L20_m2__nf1_gboth_sdfull_pc/B.n17 72.7879
R257 pfet_01v8_lvt_W1_L20_m2__nf1_gboth_sdfull_pc/B.n293 pfet_01v8_lvt_W1_L20_m2__nf1_gboth_sdfull_pc/B.n292 72.7879
R258 pfet_01v8_lvt_W1_L20_m2__nf1_gboth_sdfull_pc/B.n22 pfet_01v8_lvt_W1_L20_m2__nf1_gboth_sdfull_pc/B.n20 72.7879
R259 pfet_01v8_lvt_W1_L20_m2__nf1_gboth_sdfull_pc/B.n286 pfet_01v8_lvt_W1_L20_m2__nf1_gboth_sdfull_pc/B.n285 72.7879
R260 pfet_01v8_lvt_W1_L20_m2__nf1_gboth_sdfull_pc/B.n25 pfet_01v8_lvt_W1_L20_m2__nf1_gboth_sdfull_pc/B.n23 72.7879
R261 pfet_01v8_lvt_W1_L20_m2__nf1_gboth_sdfull_pc/B.n89 pfet_01v8_lvt_W1_L20_m2__nf1_gboth_sdfull_pc/B.n56 72.7879
R262 pfet_01v8_lvt_W1_L20_m2__nf1_gboth_sdfull_pc/B.n92 pfet_01v8_lvt_W1_L20_m2__nf1_gboth_sdfull_pc/B.n55 72.7879
R263 pfet_01v8_lvt_W1_L20_m2__nf1_gboth_sdfull_pc/B.n98 pfet_01v8_lvt_W1_L20_m2__nf1_gboth_sdfull_pc/B.n58 72.7879
R264 pfet_01v8_lvt_W1_L20_m2__nf1_gboth_sdfull_pc/B.n99 pfet_01v8_lvt_W1_L20_m2__nf1_gboth_sdfull_pc/B.n53 72.7879
R265 pfet_01v8_lvt_W1_L20_m2__nf1_gboth_sdfull_pc/B.n106 pfet_01v8_lvt_W1_L20_m2__nf1_gboth_sdfull_pc/B.n59 72.7879
R266 pfet_01v8_lvt_W1_L20_m2__nf1_gboth_sdfull_pc/B.n110 pfet_01v8_lvt_W1_L20_m2__nf1_gboth_sdfull_pc/B.n60 72.7879
R267 pfet_01v8_lvt_W1_L20_m2__nf1_gboth_sdfull_pc/B.n114 pfet_01v8_lvt_W1_L20_m2__nf1_gboth_sdfull_pc/B.n61 72.7879
R268 pfet_01v8_lvt_W1_L20_m2__nf1_gboth_sdfull_pc/B.n118 pfet_01v8_lvt_W1_L20_m2__nf1_gboth_sdfull_pc/B.n62 72.7879
R269 pfet_01v8_lvt_W1_L20_m2__nf1_gboth_sdfull_pc/B.n122 pfet_01v8_lvt_W1_L20_m2__nf1_gboth_sdfull_pc/B.n63 72.7879
R270 pfet_01v8_lvt_W1_L20_m2__nf1_gboth_sdfull_pc/B.n125 pfet_01v8_lvt_W1_L20_m2__nf1_gboth_sdfull_pc/B.n64 72.7879
R271 pfet_01v8_lvt_W1_L20_m2__nf1_gboth_sdfull_pc/B.n128 pfet_01v8_lvt_W1_L20_m2__nf1_gboth_sdfull_pc/B.n66 72.7879
R272 pfet_01v8_lvt_W1_L20_m2__nf1_gboth_sdfull_pc/B.n134 pfet_01v8_lvt_W1_L20_m2__nf1_gboth_sdfull_pc/B.n52 72.7879
R273 pfet_01v8_lvt_W1_L20_m2__nf1_gboth_sdfull_pc/B.n137 pfet_01v8_lvt_W1_L20_m2__nf1_gboth_sdfull_pc/B.n50 72.7879
R274 pfet_01v8_lvt_W1_L20_m2__nf1_gboth_sdfull_pc/B.n144 pfet_01v8_lvt_W1_L20_m2__nf1_gboth_sdfull_pc/B.n67 72.7879
R275 pfet_01v8_lvt_W1_L20_m2__nf1_gboth_sdfull_pc/B.n147 pfet_01v8_lvt_W1_L20_m2__nf1_gboth_sdfull_pc/B.n68 72.7879
R276 pfet_01v8_lvt_W1_L20_m2__nf1_gboth_sdfull_pc/B.n153 pfet_01v8_lvt_W1_L20_m2__nf1_gboth_sdfull_pc/B.n49 72.7879
R277 pfet_01v8_lvt_W1_L20_m2__nf1_gboth_sdfull_pc/B.n157 pfet_01v8_lvt_W1_L20_m2__nf1_gboth_sdfull_pc/B.n48 72.7879
R278 pfet_01v8_lvt_W1_L20_m2__nf1_gboth_sdfull_pc/B.n161 pfet_01v8_lvt_W1_L20_m2__nf1_gboth_sdfull_pc/B.n47 72.7879
R279 pfet_01v8_lvt_W1_L20_m2__nf1_gboth_sdfull_pc/B.n162 pfet_01v8_lvt_W1_L20_m2__nf1_gboth_sdfull_pc/B.n70 72.7879
R280 pfet_01v8_lvt_W1_L20_m2__nf1_gboth_sdfull_pc/B.n169 pfet_01v8_lvt_W1_L20_m2__nf1_gboth_sdfull_pc/B.n46 72.7879
R281 pfet_01v8_lvt_W1_L20_m2__nf1_gboth_sdfull_pc/B.n173 pfet_01v8_lvt_W1_L20_m2__nf1_gboth_sdfull_pc/B.n45 72.7879
R282 pfet_01v8_lvt_W1_L20_m2__nf1_gboth_sdfull_pc/B.n176 pfet_01v8_lvt_W1_L20_m2__nf1_gboth_sdfull_pc/B.n44 72.7879
R283 pfet_01v8_lvt_W1_L20_m2__nf1_gboth_sdfull_pc/B.n73 pfet_01v8_lvt_W1_L20_m2__nf1_gboth_sdfull_pc/B.n71 72.7879
R284 pfet_01v8_lvt_W1_L20_m2__nf1_gboth_sdfull_pc/B.n82 pfet_01v8_lvt_W1_L20_m2__nf1_gboth_sdfull_pc/B.n42 72.7879
R285 pfet_01v8_lvt_W1_L20_m2__nf1_gboth_sdfull_pc/B.n78 pfet_01v8_lvt_W1_L20_m2__nf1_gboth_sdfull_pc/B.n41 72.7879
R286 pfet_01v8_lvt_W1_L20_m2__nf1_gboth_sdfull_pc/B.n74 pfet_01v8_lvt_W1_L20_m2__nf1_gboth_sdfull_pc/B.n40 72.7879
R287 pfet_01v8_lvt_W1_L20_m2__nf1_gboth_sdfull_pc/B.n185 pfet_01v8_lvt_W1_L20_m2__nf1_gboth_sdfull_pc/B.n39 72.7879
R288 pfet_01v8_lvt_W1_L20_m2__nf1_gboth_sdfull_pc/B.n280 pfet_01v8_lvt_W1_L20_m2__nf1_gboth_sdfull_pc/B.n25 72.7879
R289 pfet_01v8_lvt_W1_L20_m2__nf1_gboth_sdfull_pc/B.n285 pfet_01v8_lvt_W1_L20_m2__nf1_gboth_sdfull_pc/B.n284 72.7879
R290 pfet_01v8_lvt_W1_L20_m2__nf1_gboth_sdfull_pc/B.n287 pfet_01v8_lvt_W1_L20_m2__nf1_gboth_sdfull_pc/B.n22 72.7879
R291 pfet_01v8_lvt_W1_L20_m2__nf1_gboth_sdfull_pc/B.n292 pfet_01v8_lvt_W1_L20_m2__nf1_gboth_sdfull_pc/B.n291 72.7879
R292 pfet_01v8_lvt_W1_L20_m2__nf1_gboth_sdfull_pc/B.n294 pfet_01v8_lvt_W1_L20_m2__nf1_gboth_sdfull_pc/B.n19 72.7879
R293 pfet_01v8_lvt_W1_L20_m2__nf1_gboth_sdfull_pc/B.n299 pfet_01v8_lvt_W1_L20_m2__nf1_gboth_sdfull_pc/B.n298 72.7879
R294 pfet_01v8_lvt_W1_L20_m2__nf1_gboth_sdfull_pc/B.n301 pfet_01v8_lvt_W1_L20_m2__nf1_gboth_sdfull_pc/B.n16 72.7879
R295 pfet_01v8_lvt_W1_L20_m2__nf1_gboth_sdfull_pc/B.n306 pfet_01v8_lvt_W1_L20_m2__nf1_gboth_sdfull_pc/B.n305 72.7879
R296 pfet_01v8_lvt_W1_L20_m2__nf1_gboth_sdfull_pc/B.n308 pfet_01v8_lvt_W1_L20_m2__nf1_gboth_sdfull_pc/B.n13 72.7879
R297 pfet_01v8_lvt_W1_L20_m2__nf1_gboth_sdfull_pc/B.n313 pfet_01v8_lvt_W1_L20_m2__nf1_gboth_sdfull_pc/B.n312 72.7879
R298 pfet_01v8_lvt_W1_L20_m2__nf1_gboth_sdfull_pc/B.n315 pfet_01v8_lvt_W1_L20_m2__nf1_gboth_sdfull_pc/B.n10 72.7879
R299 pfet_01v8_lvt_W1_L20_m2__nf1_gboth_sdfull_pc/B.n320 pfet_01v8_lvt_W1_L20_m2__nf1_gboth_sdfull_pc/B.n319 72.7879
R300 pfet_01v8_lvt_W1_L20_m2__nf1_gboth_sdfull_pc/B.n322 pfet_01v8_lvt_W1_L20_m2__nf1_gboth_sdfull_pc/B.n7 72.7879
R301 pfet_01v8_lvt_W1_L20_m2__nf1_gboth_sdfull_pc/B.n327 pfet_01v8_lvt_W1_L20_m2__nf1_gboth_sdfull_pc/B.n326 72.7879
R302 pfet_01v8_lvt_W1_L20_m2__nf1_gboth_sdfull_pc/B.n330 pfet_01v8_lvt_W1_L20_m2__nf1_gboth_sdfull_pc/B.n329 72.7879
R303 pfet_01v8_lvt_W1_L20_m2__nf1_gboth_sdfull_pc/B.n222 pfet_01v8_lvt_W1_L20_m2__nf1_gboth_sdfull_pc/B.n2 72.7879
R304 pfet_01v8_lvt_W1_L20_m2__nf1_gboth_sdfull_pc/B.n227 pfet_01v8_lvt_W1_L20_m2__nf1_gboth_sdfull_pc/B.n226 72.7879
R305 pfet_01v8_lvt_W1_L20_m2__nf1_gboth_sdfull_pc/B.n229 pfet_01v8_lvt_W1_L20_m2__nf1_gboth_sdfull_pc/B.n221 72.7879
R306 pfet_01v8_lvt_W1_L20_m2__nf1_gboth_sdfull_pc/B.n234 pfet_01v8_lvt_W1_L20_m2__nf1_gboth_sdfull_pc/B.n233 72.7879
R307 pfet_01v8_lvt_W1_L20_m2__nf1_gboth_sdfull_pc/B.n236 pfet_01v8_lvt_W1_L20_m2__nf1_gboth_sdfull_pc/B.n218 72.7879
R308 pfet_01v8_lvt_W1_L20_m2__nf1_gboth_sdfull_pc/B.n241 pfet_01v8_lvt_W1_L20_m2__nf1_gboth_sdfull_pc/B.n240 72.7879
R309 pfet_01v8_lvt_W1_L20_m2__nf1_gboth_sdfull_pc/B.n243 pfet_01v8_lvt_W1_L20_m2__nf1_gboth_sdfull_pc/B.n215 72.7879
R310 pfet_01v8_lvt_W1_L20_m2__nf1_gboth_sdfull_pc/B.n248 pfet_01v8_lvt_W1_L20_m2__nf1_gboth_sdfull_pc/B.n247 72.7879
R311 pfet_01v8_lvt_W1_L20_m2__nf1_gboth_sdfull_pc/B.n250 pfet_01v8_lvt_W1_L20_m2__nf1_gboth_sdfull_pc/B.n212 72.7879
R312 pfet_01v8_lvt_W1_L20_m2__nf1_gboth_sdfull_pc/B.n255 pfet_01v8_lvt_W1_L20_m2__nf1_gboth_sdfull_pc/B.n254 72.7879
R313 pfet_01v8_lvt_W1_L20_m2__nf1_gboth_sdfull_pc/B.n257 pfet_01v8_lvt_W1_L20_m2__nf1_gboth_sdfull_pc/B.n209 72.7879
R314 pfet_01v8_lvt_W1_L20_m2__nf1_gboth_sdfull_pc/B.n262 pfet_01v8_lvt_W1_L20_m2__nf1_gboth_sdfull_pc/B.n261 72.7879
R315 pfet_01v8_lvt_W1_L20_m2__nf1_gboth_sdfull_pc/B.n264 pfet_01v8_lvt_W1_L20_m2__nf1_gboth_sdfull_pc/B.n206 72.7879
R316 pfet_01v8_lvt_W1_L20_m2__nf1_gboth_sdfull_pc/B.n269 pfet_01v8_lvt_W1_L20_m2__nf1_gboth_sdfull_pc/B.n268 72.7879
R317 pfet_01v8_lvt_W1_L20_m2__nf1_gboth_sdfull_pc/B.n272 pfet_01v8_lvt_W1_L20_m2__nf1_gboth_sdfull_pc/B.n271 72.7879
R318 pfet_01v8_lvt_W1_L20_m2__nf1_gboth_sdfull_pc/B.n86 pfet_01v8_lvt_W1_L20_m2__nf1_gboth_sdfull_pc/B.n56 72.7879
R319 pfet_01v8_lvt_W1_L20_m2__nf1_gboth_sdfull_pc/B.n90 pfet_01v8_lvt_W1_L20_m2__nf1_gboth_sdfull_pc/B.n55 72.7879
R320 pfet_01v8_lvt_W1_L20_m2__nf1_gboth_sdfull_pc/B.n95 pfet_01v8_lvt_W1_L20_m2__nf1_gboth_sdfull_pc/B.n58 72.7879
R321 pfet_01v8_lvt_W1_L20_m2__nf1_gboth_sdfull_pc/B.n102 pfet_01v8_lvt_W1_L20_m2__nf1_gboth_sdfull_pc/B.n53 72.7879
R322 pfet_01v8_lvt_W1_L20_m2__nf1_gboth_sdfull_pc/B.n103 pfet_01v8_lvt_W1_L20_m2__nf1_gboth_sdfull_pc/B.n59 72.7879
R323 pfet_01v8_lvt_W1_L20_m2__nf1_gboth_sdfull_pc/B.n107 pfet_01v8_lvt_W1_L20_m2__nf1_gboth_sdfull_pc/B.n60 72.7879
R324 pfet_01v8_lvt_W1_L20_m2__nf1_gboth_sdfull_pc/B.n111 pfet_01v8_lvt_W1_L20_m2__nf1_gboth_sdfull_pc/B.n61 72.7879
R325 pfet_01v8_lvt_W1_L20_m2__nf1_gboth_sdfull_pc/B.n115 pfet_01v8_lvt_W1_L20_m2__nf1_gboth_sdfull_pc/B.n62 72.7879
R326 pfet_01v8_lvt_W1_L20_m2__nf1_gboth_sdfull_pc/B.n119 pfet_01v8_lvt_W1_L20_m2__nf1_gboth_sdfull_pc/B.n63 72.7879
R327 pfet_01v8_lvt_W1_L20_m2__nf1_gboth_sdfull_pc/B.n123 pfet_01v8_lvt_W1_L20_m2__nf1_gboth_sdfull_pc/B.n64 72.7879
R328 pfet_01v8_lvt_W1_L20_m2__nf1_gboth_sdfull_pc/B.n131 pfet_01v8_lvt_W1_L20_m2__nf1_gboth_sdfull_pc/B.n66 72.7879
R329 pfet_01v8_lvt_W1_L20_m2__nf1_gboth_sdfull_pc/B.n132 pfet_01v8_lvt_W1_L20_m2__nf1_gboth_sdfull_pc/B.n52 72.7879
R330 pfet_01v8_lvt_W1_L20_m2__nf1_gboth_sdfull_pc/B.n140 pfet_01v8_lvt_W1_L20_m2__nf1_gboth_sdfull_pc/B.n50 72.7879
R331 pfet_01v8_lvt_W1_L20_m2__nf1_gboth_sdfull_pc/B.n141 pfet_01v8_lvt_W1_L20_m2__nf1_gboth_sdfull_pc/B.n67 72.7879
R332 pfet_01v8_lvt_W1_L20_m2__nf1_gboth_sdfull_pc/B.n145 pfet_01v8_lvt_W1_L20_m2__nf1_gboth_sdfull_pc/B.n68 72.7879
R333 pfet_01v8_lvt_W1_L20_m2__nf1_gboth_sdfull_pc/B.n150 pfet_01v8_lvt_W1_L20_m2__nf1_gboth_sdfull_pc/B.n49 72.7879
R334 pfet_01v8_lvt_W1_L20_m2__nf1_gboth_sdfull_pc/B.n154 pfet_01v8_lvt_W1_L20_m2__nf1_gboth_sdfull_pc/B.n48 72.7879
R335 pfet_01v8_lvt_W1_L20_m2__nf1_gboth_sdfull_pc/B.n158 pfet_01v8_lvt_W1_L20_m2__nf1_gboth_sdfull_pc/B.n47 72.7879
R336 pfet_01v8_lvt_W1_L20_m2__nf1_gboth_sdfull_pc/B.n165 pfet_01v8_lvt_W1_L20_m2__nf1_gboth_sdfull_pc/B.n70 72.7879
R337 pfet_01v8_lvt_W1_L20_m2__nf1_gboth_sdfull_pc/B.n166 pfet_01v8_lvt_W1_L20_m2__nf1_gboth_sdfull_pc/B.n46 72.7879
R338 pfet_01v8_lvt_W1_L20_m2__nf1_gboth_sdfull_pc/B.n170 pfet_01v8_lvt_W1_L20_m2__nf1_gboth_sdfull_pc/B.n45 72.7879
R339 pfet_01v8_lvt_W1_L20_m2__nf1_gboth_sdfull_pc/B.n174 pfet_01v8_lvt_W1_L20_m2__nf1_gboth_sdfull_pc/B.n44 72.7879
R340 pfet_01v8_lvt_W1_L20_m2__nf1_gboth_sdfull_pc/B.n179 pfet_01v8_lvt_W1_L20_m2__nf1_gboth_sdfull_pc/B.n71 72.7879
R341 pfet_01v8_lvt_W1_L20_m2__nf1_gboth_sdfull_pc/B.n72 pfet_01v8_lvt_W1_L20_m2__nf1_gboth_sdfull_pc/B.n42 72.7879
R342 pfet_01v8_lvt_W1_L20_m2__nf1_gboth_sdfull_pc/B.n81 pfet_01v8_lvt_W1_L20_m2__nf1_gboth_sdfull_pc/B.n41 72.7879
R343 pfet_01v8_lvt_W1_L20_m2__nf1_gboth_sdfull_pc/B.n77 pfet_01v8_lvt_W1_L20_m2__nf1_gboth_sdfull_pc/B.n40 72.7879
R344 pfet_01v8_lvt_W1_L20_m2__nf1_gboth_sdfull_pc/B.n186 pfet_01v8_lvt_W1_L20_m2__nf1_gboth_sdfull_pc/B.n185 72.7879
R345 pfet_01v8_lvt_W1_L20_m2__nf1_gboth_sdfull_pc/B.n281 pfet_01v8_lvt_W1_L20_m2__nf1_gboth_sdfull_pc/B.n24 68.5181
R346 pfet_01v8_lvt_W1_L20_m2__nf1_gboth_sdfull_pc/B.n85 pfet_01v8_lvt_W1_L20_m2__nf1_gboth_sdfull_pc/B.n33 68.5181
R347 pfet_01v8_lvt_W1_L20_m2__nf1_gboth_sdfull_pc/B.n276 pfet_01v8_lvt_W1_L20_m2__nf1_gboth_sdfull_pc/B.n275 68.5181
R348 pfet_01v8_lvt_W1_L20_m2__nf1_gboth_sdfull_pc/B.n188 pfet_01v8_lvt_W1_L20_m2__nf1_gboth_sdfull_pc/B.n187 68.5181
R349 pfet_01v8_lvt_W1_L20_m2__nf1_gboth_sdfull_pc/B.n272 pfet_01v8_lvt_W1_L20_m2__nf1_gboth_sdfull_pc/B.n3 56.1076
R350 pfet_01v8_lvt_W1_L20_m2__nf1_gboth_sdfull_pc/B.n269 pfet_01v8_lvt_W1_L20_m2__nf1_gboth_sdfull_pc/B.n3 56.1076
R351 pfet_01v8_lvt_W1_L20_m2__nf1_gboth_sdfull_pc/B.n206 pfet_01v8_lvt_W1_L20_m2__nf1_gboth_sdfull_pc/B.n3 56.1076
R352 pfet_01v8_lvt_W1_L20_m2__nf1_gboth_sdfull_pc/B.n262 pfet_01v8_lvt_W1_L20_m2__nf1_gboth_sdfull_pc/B.n3 56.1076
R353 pfet_01v8_lvt_W1_L20_m2__nf1_gboth_sdfull_pc/B.n209 pfet_01v8_lvt_W1_L20_m2__nf1_gboth_sdfull_pc/B.n3 56.1076
R354 pfet_01v8_lvt_W1_L20_m2__nf1_gboth_sdfull_pc/B.n255 pfet_01v8_lvt_W1_L20_m2__nf1_gboth_sdfull_pc/B.n3 56.1076
R355 pfet_01v8_lvt_W1_L20_m2__nf1_gboth_sdfull_pc/B.n212 pfet_01v8_lvt_W1_L20_m2__nf1_gboth_sdfull_pc/B.n3 56.1076
R356 pfet_01v8_lvt_W1_L20_m2__nf1_gboth_sdfull_pc/B.n248 pfet_01v8_lvt_W1_L20_m2__nf1_gboth_sdfull_pc/B.n3 56.1076
R357 pfet_01v8_lvt_W1_L20_m2__nf1_gboth_sdfull_pc/B.n215 pfet_01v8_lvt_W1_L20_m2__nf1_gboth_sdfull_pc/B.n3 56.1076
R358 pfet_01v8_lvt_W1_L20_m2__nf1_gboth_sdfull_pc/B.n241 pfet_01v8_lvt_W1_L20_m2__nf1_gboth_sdfull_pc/B.n3 56.1076
R359 pfet_01v8_lvt_W1_L20_m2__nf1_gboth_sdfull_pc/B.n218 pfet_01v8_lvt_W1_L20_m2__nf1_gboth_sdfull_pc/B.n3 56.1076
R360 pfet_01v8_lvt_W1_L20_m2__nf1_gboth_sdfull_pc/B.n234 pfet_01v8_lvt_W1_L20_m2__nf1_gboth_sdfull_pc/B.n3 56.1076
R361 pfet_01v8_lvt_W1_L20_m2__nf1_gboth_sdfull_pc/B.n221 pfet_01v8_lvt_W1_L20_m2__nf1_gboth_sdfull_pc/B.n3 56.1076
R362 pfet_01v8_lvt_W1_L20_m2__nf1_gboth_sdfull_pc/B.n227 pfet_01v8_lvt_W1_L20_m2__nf1_gboth_sdfull_pc/B.n3 56.1076
R363 pfet_01v8_lvt_W1_L20_m2__nf1_gboth_sdfull_pc/B.n222 pfet_01v8_lvt_W1_L20_m2__nf1_gboth_sdfull_pc/B.n3 56.1076
R364 pfet_01v8_lvt_W1_L20_m2__nf1_gboth_sdfull_pc/B.n330 pfet_01v8_lvt_W1_L20_m2__nf1_gboth_sdfull_pc/B.n3 56.1076
R365 pfet_01v8_lvt_W1_L20_m2__nf1_gboth_sdfull_pc/B.n327 pfet_01v8_lvt_W1_L20_m2__nf1_gboth_sdfull_pc/B.n3 56.1076
R366 pfet_01v8_lvt_W1_L20_m2__nf1_gboth_sdfull_pc/B.n7 pfet_01v8_lvt_W1_L20_m2__nf1_gboth_sdfull_pc/B.n3 56.1076
R367 pfet_01v8_lvt_W1_L20_m2__nf1_gboth_sdfull_pc/B.n320 pfet_01v8_lvt_W1_L20_m2__nf1_gboth_sdfull_pc/B.n3 56.1076
R368 pfet_01v8_lvt_W1_L20_m2__nf1_gboth_sdfull_pc/B.n10 pfet_01v8_lvt_W1_L20_m2__nf1_gboth_sdfull_pc/B.n3 56.1076
R369 pfet_01v8_lvt_W1_L20_m2__nf1_gboth_sdfull_pc/B.n313 pfet_01v8_lvt_W1_L20_m2__nf1_gboth_sdfull_pc/B.n3 56.1076
R370 pfet_01v8_lvt_W1_L20_m2__nf1_gboth_sdfull_pc/B.n13 pfet_01v8_lvt_W1_L20_m2__nf1_gboth_sdfull_pc/B.n3 56.1076
R371 pfet_01v8_lvt_W1_L20_m2__nf1_gboth_sdfull_pc/B.n306 pfet_01v8_lvt_W1_L20_m2__nf1_gboth_sdfull_pc/B.n3 56.1076
R372 pfet_01v8_lvt_W1_L20_m2__nf1_gboth_sdfull_pc/B.n16 pfet_01v8_lvt_W1_L20_m2__nf1_gboth_sdfull_pc/B.n3 56.1076
R373 pfet_01v8_lvt_W1_L20_m2__nf1_gboth_sdfull_pc/B.n299 pfet_01v8_lvt_W1_L20_m2__nf1_gboth_sdfull_pc/B.n3 56.1076
R374 pfet_01v8_lvt_W1_L20_m2__nf1_gboth_sdfull_pc/B.n19 pfet_01v8_lvt_W1_L20_m2__nf1_gboth_sdfull_pc/B.n3 56.1076
R375 pfet_01v8_lvt_W1_L20_m2__nf1_gboth_sdfull_pc/B.n292 pfet_01v8_lvt_W1_L20_m2__nf1_gboth_sdfull_pc/B.n3 56.1076
R376 pfet_01v8_lvt_W1_L20_m2__nf1_gboth_sdfull_pc/B.n22 pfet_01v8_lvt_W1_L20_m2__nf1_gboth_sdfull_pc/B.n3 56.1076
R377 pfet_01v8_lvt_W1_L20_m2__nf1_gboth_sdfull_pc/B.n285 pfet_01v8_lvt_W1_L20_m2__nf1_gboth_sdfull_pc/B.n3 56.1076
R378 pfet_01v8_lvt_W1_L20_m2__nf1_gboth_sdfull_pc/B.n25 pfet_01v8_lvt_W1_L20_m2__nf1_gboth_sdfull_pc/B.n3 56.1076
R379 pfet_01v8_lvt_W1_L20_m2__nf1_gboth_sdfull_pc/B.n184 pfet_01v8_lvt_W1_L20_m2__nf1_gboth_sdfull_pc/B.n56 56.1076
R380 pfet_01v8_lvt_W1_L20_m2__nf1_gboth_sdfull_pc/B.n184 pfet_01v8_lvt_W1_L20_m2__nf1_gboth_sdfull_pc/B.n55 56.1076
R381 pfet_01v8_lvt_W1_L20_m2__nf1_gboth_sdfull_pc/B.n184 pfet_01v8_lvt_W1_L20_m2__nf1_gboth_sdfull_pc/B.n58 56.1076
R382 pfet_01v8_lvt_W1_L20_m2__nf1_gboth_sdfull_pc/B.n184 pfet_01v8_lvt_W1_L20_m2__nf1_gboth_sdfull_pc/B.n53 56.1076
R383 pfet_01v8_lvt_W1_L20_m2__nf1_gboth_sdfull_pc/B.n184 pfet_01v8_lvt_W1_L20_m2__nf1_gboth_sdfull_pc/B.n59 56.1076
R384 pfet_01v8_lvt_W1_L20_m2__nf1_gboth_sdfull_pc/B.n184 pfet_01v8_lvt_W1_L20_m2__nf1_gboth_sdfull_pc/B.n60 56.1076
R385 pfet_01v8_lvt_W1_L20_m2__nf1_gboth_sdfull_pc/B.n184 pfet_01v8_lvt_W1_L20_m2__nf1_gboth_sdfull_pc/B.n61 56.1076
R386 pfet_01v8_lvt_W1_L20_m2__nf1_gboth_sdfull_pc/B.n184 pfet_01v8_lvt_W1_L20_m2__nf1_gboth_sdfull_pc/B.n62 56.1076
R387 pfet_01v8_lvt_W1_L20_m2__nf1_gboth_sdfull_pc/B.n184 pfet_01v8_lvt_W1_L20_m2__nf1_gboth_sdfull_pc/B.n63 56.1076
R388 pfet_01v8_lvt_W1_L20_m2__nf1_gboth_sdfull_pc/B.n184 pfet_01v8_lvt_W1_L20_m2__nf1_gboth_sdfull_pc/B.n64 56.1076
R389 pfet_01v8_lvt_W1_L20_m2__nf1_gboth_sdfull_pc/B.n184 pfet_01v8_lvt_W1_L20_m2__nf1_gboth_sdfull_pc/B.n66 56.1076
R390 pfet_01v8_lvt_W1_L20_m2__nf1_gboth_sdfull_pc/B.n184 pfet_01v8_lvt_W1_L20_m2__nf1_gboth_sdfull_pc/B.n52 56.1076
R391 pfet_01v8_lvt_W1_L20_m2__nf1_gboth_sdfull_pc/B.n184 pfet_01v8_lvt_W1_L20_m2__nf1_gboth_sdfull_pc/B.n50 56.1076
R392 pfet_01v8_lvt_W1_L20_m2__nf1_gboth_sdfull_pc/B.n184 pfet_01v8_lvt_W1_L20_m2__nf1_gboth_sdfull_pc/B.n67 56.1076
R393 pfet_01v8_lvt_W1_L20_m2__nf1_gboth_sdfull_pc/B.n184 pfet_01v8_lvt_W1_L20_m2__nf1_gboth_sdfull_pc/B.n68 56.1076
R394 pfet_01v8_lvt_W1_L20_m2__nf1_gboth_sdfull_pc/B.n184 pfet_01v8_lvt_W1_L20_m2__nf1_gboth_sdfull_pc/B.n49 56.1076
R395 pfet_01v8_lvt_W1_L20_m2__nf1_gboth_sdfull_pc/B.n184 pfet_01v8_lvt_W1_L20_m2__nf1_gboth_sdfull_pc/B.n48 56.1076
R396 pfet_01v8_lvt_W1_L20_m2__nf1_gboth_sdfull_pc/B.n184 pfet_01v8_lvt_W1_L20_m2__nf1_gboth_sdfull_pc/B.n47 56.1076
R397 pfet_01v8_lvt_W1_L20_m2__nf1_gboth_sdfull_pc/B.n184 pfet_01v8_lvt_W1_L20_m2__nf1_gboth_sdfull_pc/B.n70 56.1076
R398 pfet_01v8_lvt_W1_L20_m2__nf1_gboth_sdfull_pc/B.n184 pfet_01v8_lvt_W1_L20_m2__nf1_gboth_sdfull_pc/B.n46 56.1076
R399 pfet_01v8_lvt_W1_L20_m2__nf1_gboth_sdfull_pc/B.n184 pfet_01v8_lvt_W1_L20_m2__nf1_gboth_sdfull_pc/B.n45 56.1076
R400 pfet_01v8_lvt_W1_L20_m2__nf1_gboth_sdfull_pc/B.n184 pfet_01v8_lvt_W1_L20_m2__nf1_gboth_sdfull_pc/B.n44 56.1076
R401 pfet_01v8_lvt_W1_L20_m2__nf1_gboth_sdfull_pc/B.n184 pfet_01v8_lvt_W1_L20_m2__nf1_gboth_sdfull_pc/B.n71 56.1076
R402 pfet_01v8_lvt_W1_L20_m2__nf1_gboth_sdfull_pc/B.n184 pfet_01v8_lvt_W1_L20_m2__nf1_gboth_sdfull_pc/B.n42 56.1076
R403 pfet_01v8_lvt_W1_L20_m2__nf1_gboth_sdfull_pc/B.n184 pfet_01v8_lvt_W1_L20_m2__nf1_gboth_sdfull_pc/B.n41 56.1076
R404 pfet_01v8_lvt_W1_L20_m2__nf1_gboth_sdfull_pc/B.n184 pfet_01v8_lvt_W1_L20_m2__nf1_gboth_sdfull_pc/B.n40 56.1076
R405 pfet_01v8_lvt_W1_L20_m2__nf1_gboth_sdfull_pc/B.n185 pfet_01v8_lvt_W1_L20_m2__nf1_gboth_sdfull_pc/B.n184 56.1076
R406 pfet_01v8_lvt_W1_L20_m2__nf1_gboth_sdfull_pc/B.n282 pfet_01v8_lvt_W1_L20_m2__nf1_gboth_sdfull_pc/B.n281 25.6005
R407 pfet_01v8_lvt_W1_L20_m2__nf1_gboth_sdfull_pc/B.n283 pfet_01v8_lvt_W1_L20_m2__nf1_gboth_sdfull_pc/B.n282 25.6005
R408 pfet_01v8_lvt_W1_L20_m2__nf1_gboth_sdfull_pc/B.n283 pfet_01v8_lvt_W1_L20_m2__nf1_gboth_sdfull_pc/B.n21 25.6005
R409 pfet_01v8_lvt_W1_L20_m2__nf1_gboth_sdfull_pc/B.n288 pfet_01v8_lvt_W1_L20_m2__nf1_gboth_sdfull_pc/B.n21 25.6005
R410 pfet_01v8_lvt_W1_L20_m2__nf1_gboth_sdfull_pc/B.n289 pfet_01v8_lvt_W1_L20_m2__nf1_gboth_sdfull_pc/B.n288 25.6005
R411 pfet_01v8_lvt_W1_L20_m2__nf1_gboth_sdfull_pc/B.n290 pfet_01v8_lvt_W1_L20_m2__nf1_gboth_sdfull_pc/B.n289 25.6005
R412 pfet_01v8_lvt_W1_L20_m2__nf1_gboth_sdfull_pc/B.n290 pfet_01v8_lvt_W1_L20_m2__nf1_gboth_sdfull_pc/B.n18 25.6005
R413 pfet_01v8_lvt_W1_L20_m2__nf1_gboth_sdfull_pc/B.n295 pfet_01v8_lvt_W1_L20_m2__nf1_gboth_sdfull_pc/B.n18 25.6005
R414 pfet_01v8_lvt_W1_L20_m2__nf1_gboth_sdfull_pc/B.n296 pfet_01v8_lvt_W1_L20_m2__nf1_gboth_sdfull_pc/B.n295 25.6005
R415 pfet_01v8_lvt_W1_L20_m2__nf1_gboth_sdfull_pc/B.n297 pfet_01v8_lvt_W1_L20_m2__nf1_gboth_sdfull_pc/B.n296 25.6005
R416 pfet_01v8_lvt_W1_L20_m2__nf1_gboth_sdfull_pc/B.n297 pfet_01v8_lvt_W1_L20_m2__nf1_gboth_sdfull_pc/B.n15 25.6005
R417 pfet_01v8_lvt_W1_L20_m2__nf1_gboth_sdfull_pc/B.n302 pfet_01v8_lvt_W1_L20_m2__nf1_gboth_sdfull_pc/B.n15 25.6005
R418 pfet_01v8_lvt_W1_L20_m2__nf1_gboth_sdfull_pc/B.n303 pfet_01v8_lvt_W1_L20_m2__nf1_gboth_sdfull_pc/B.n302 25.6005
R419 pfet_01v8_lvt_W1_L20_m2__nf1_gboth_sdfull_pc/B.n304 pfet_01v8_lvt_W1_L20_m2__nf1_gboth_sdfull_pc/B.n303 25.6005
R420 pfet_01v8_lvt_W1_L20_m2__nf1_gboth_sdfull_pc/B.n304 pfet_01v8_lvt_W1_L20_m2__nf1_gboth_sdfull_pc/B.n12 25.6005
R421 pfet_01v8_lvt_W1_L20_m2__nf1_gboth_sdfull_pc/B.n309 pfet_01v8_lvt_W1_L20_m2__nf1_gboth_sdfull_pc/B.n12 25.6005
R422 pfet_01v8_lvt_W1_L20_m2__nf1_gboth_sdfull_pc/B.n310 pfet_01v8_lvt_W1_L20_m2__nf1_gboth_sdfull_pc/B.n309 25.6005
R423 pfet_01v8_lvt_W1_L20_m2__nf1_gboth_sdfull_pc/B.n311 pfet_01v8_lvt_W1_L20_m2__nf1_gboth_sdfull_pc/B.n310 25.6005
R424 pfet_01v8_lvt_W1_L20_m2__nf1_gboth_sdfull_pc/B.n311 pfet_01v8_lvt_W1_L20_m2__nf1_gboth_sdfull_pc/B.n9 25.6005
R425 pfet_01v8_lvt_W1_L20_m2__nf1_gboth_sdfull_pc/B.n316 pfet_01v8_lvt_W1_L20_m2__nf1_gboth_sdfull_pc/B.n9 25.6005
R426 pfet_01v8_lvt_W1_L20_m2__nf1_gboth_sdfull_pc/B.n317 pfet_01v8_lvt_W1_L20_m2__nf1_gboth_sdfull_pc/B.n316 25.6005
R427 pfet_01v8_lvt_W1_L20_m2__nf1_gboth_sdfull_pc/B.n318 pfet_01v8_lvt_W1_L20_m2__nf1_gboth_sdfull_pc/B.n317 25.6005
R428 pfet_01v8_lvt_W1_L20_m2__nf1_gboth_sdfull_pc/B.n318 pfet_01v8_lvt_W1_L20_m2__nf1_gboth_sdfull_pc/B.n6 25.6005
R429 pfet_01v8_lvt_W1_L20_m2__nf1_gboth_sdfull_pc/B.n323 pfet_01v8_lvt_W1_L20_m2__nf1_gboth_sdfull_pc/B.n6 25.6005
R430 pfet_01v8_lvt_W1_L20_m2__nf1_gboth_sdfull_pc/B.n324 pfet_01v8_lvt_W1_L20_m2__nf1_gboth_sdfull_pc/B.n323 25.6005
R431 pfet_01v8_lvt_W1_L20_m2__nf1_gboth_sdfull_pc/B.n325 pfet_01v8_lvt_W1_L20_m2__nf1_gboth_sdfull_pc/B.n324 25.6005
R432 pfet_01v8_lvt_W1_L20_m2__nf1_gboth_sdfull_pc/B.n325 pfet_01v8_lvt_W1_L20_m2__nf1_gboth_sdfull_pc/B.n4 25.6005
R433 pfet_01v8_lvt_W1_L20_m2__nf1_gboth_sdfull_pc/B.n4 pfet_01v8_lvt_W1_L20_m2__nf1_gboth_sdfull_pc/B.n1 25.6005
R434 pfet_01v8_lvt_W1_L20_m2__nf1_gboth_sdfull_pc/B.n332 pfet_01v8_lvt_W1_L20_m2__nf1_gboth_sdfull_pc/B.n1 25.6005
R435 pfet_01v8_lvt_W1_L20_m2__nf1_gboth_sdfull_pc/B.n224 pfet_01v8_lvt_W1_L20_m2__nf1_gboth_sdfull_pc/B.n0 25.6005
R436 pfet_01v8_lvt_W1_L20_m2__nf1_gboth_sdfull_pc/B.n225 pfet_01v8_lvt_W1_L20_m2__nf1_gboth_sdfull_pc/B.n224 25.6005
R437 pfet_01v8_lvt_W1_L20_m2__nf1_gboth_sdfull_pc/B.n225 pfet_01v8_lvt_W1_L20_m2__nf1_gboth_sdfull_pc/B.n220 25.6005
R438 pfet_01v8_lvt_W1_L20_m2__nf1_gboth_sdfull_pc/B.n230 pfet_01v8_lvt_W1_L20_m2__nf1_gboth_sdfull_pc/B.n220 25.6005
R439 pfet_01v8_lvt_W1_L20_m2__nf1_gboth_sdfull_pc/B.n231 pfet_01v8_lvt_W1_L20_m2__nf1_gboth_sdfull_pc/B.n230 25.6005
R440 pfet_01v8_lvt_W1_L20_m2__nf1_gboth_sdfull_pc/B.n232 pfet_01v8_lvt_W1_L20_m2__nf1_gboth_sdfull_pc/B.n231 25.6005
R441 pfet_01v8_lvt_W1_L20_m2__nf1_gboth_sdfull_pc/B.n232 pfet_01v8_lvt_W1_L20_m2__nf1_gboth_sdfull_pc/B.n217 25.6005
R442 pfet_01v8_lvt_W1_L20_m2__nf1_gboth_sdfull_pc/B.n237 pfet_01v8_lvt_W1_L20_m2__nf1_gboth_sdfull_pc/B.n217 25.6005
R443 pfet_01v8_lvt_W1_L20_m2__nf1_gboth_sdfull_pc/B.n238 pfet_01v8_lvt_W1_L20_m2__nf1_gboth_sdfull_pc/B.n237 25.6005
R444 pfet_01v8_lvt_W1_L20_m2__nf1_gboth_sdfull_pc/B.n239 pfet_01v8_lvt_W1_L20_m2__nf1_gboth_sdfull_pc/B.n238 25.6005
R445 pfet_01v8_lvt_W1_L20_m2__nf1_gboth_sdfull_pc/B.n239 pfet_01v8_lvt_W1_L20_m2__nf1_gboth_sdfull_pc/B.n214 25.6005
R446 pfet_01v8_lvt_W1_L20_m2__nf1_gboth_sdfull_pc/B.n244 pfet_01v8_lvt_W1_L20_m2__nf1_gboth_sdfull_pc/B.n214 25.6005
R447 pfet_01v8_lvt_W1_L20_m2__nf1_gboth_sdfull_pc/B.n245 pfet_01v8_lvt_W1_L20_m2__nf1_gboth_sdfull_pc/B.n244 25.6005
R448 pfet_01v8_lvt_W1_L20_m2__nf1_gboth_sdfull_pc/B.n246 pfet_01v8_lvt_W1_L20_m2__nf1_gboth_sdfull_pc/B.n245 25.6005
R449 pfet_01v8_lvt_W1_L20_m2__nf1_gboth_sdfull_pc/B.n246 pfet_01v8_lvt_W1_L20_m2__nf1_gboth_sdfull_pc/B.n211 25.6005
R450 pfet_01v8_lvt_W1_L20_m2__nf1_gboth_sdfull_pc/B.n251 pfet_01v8_lvt_W1_L20_m2__nf1_gboth_sdfull_pc/B.n211 25.6005
R451 pfet_01v8_lvt_W1_L20_m2__nf1_gboth_sdfull_pc/B.n252 pfet_01v8_lvt_W1_L20_m2__nf1_gboth_sdfull_pc/B.n251 25.6005
R452 pfet_01v8_lvt_W1_L20_m2__nf1_gboth_sdfull_pc/B.n253 pfet_01v8_lvt_W1_L20_m2__nf1_gboth_sdfull_pc/B.n252 25.6005
R453 pfet_01v8_lvt_W1_L20_m2__nf1_gboth_sdfull_pc/B.n253 pfet_01v8_lvt_W1_L20_m2__nf1_gboth_sdfull_pc/B.n208 25.6005
R454 pfet_01v8_lvt_W1_L20_m2__nf1_gboth_sdfull_pc/B.n258 pfet_01v8_lvt_W1_L20_m2__nf1_gboth_sdfull_pc/B.n208 25.6005
R455 pfet_01v8_lvt_W1_L20_m2__nf1_gboth_sdfull_pc/B.n259 pfet_01v8_lvt_W1_L20_m2__nf1_gboth_sdfull_pc/B.n258 25.6005
R456 pfet_01v8_lvt_W1_L20_m2__nf1_gboth_sdfull_pc/B.n260 pfet_01v8_lvt_W1_L20_m2__nf1_gboth_sdfull_pc/B.n259 25.6005
R457 pfet_01v8_lvt_W1_L20_m2__nf1_gboth_sdfull_pc/B.n260 pfet_01v8_lvt_W1_L20_m2__nf1_gboth_sdfull_pc/B.n205 25.6005
R458 pfet_01v8_lvt_W1_L20_m2__nf1_gboth_sdfull_pc/B.n265 pfet_01v8_lvt_W1_L20_m2__nf1_gboth_sdfull_pc/B.n205 25.6005
R459 pfet_01v8_lvt_W1_L20_m2__nf1_gboth_sdfull_pc/B.n266 pfet_01v8_lvt_W1_L20_m2__nf1_gboth_sdfull_pc/B.n265 25.6005
R460 pfet_01v8_lvt_W1_L20_m2__nf1_gboth_sdfull_pc/B.n267 pfet_01v8_lvt_W1_L20_m2__nf1_gboth_sdfull_pc/B.n266 25.6005
R461 pfet_01v8_lvt_W1_L20_m2__nf1_gboth_sdfull_pc/B.n267 pfet_01v8_lvt_W1_L20_m2__nf1_gboth_sdfull_pc/B.n203 25.6005
R462 pfet_01v8_lvt_W1_L20_m2__nf1_gboth_sdfull_pc/B.n203 pfet_01v8_lvt_W1_L20_m2__nf1_gboth_sdfull_pc/B.n202 25.6005
R463 pfet_01v8_lvt_W1_L20_m2__nf1_gboth_sdfull_pc/B.n274 pfet_01v8_lvt_W1_L20_m2__nf1_gboth_sdfull_pc/B.n202 25.6005
R464 pfet_01v8_lvt_W1_L20_m2__nf1_gboth_sdfull_pc/B.n275 pfet_01v8_lvt_W1_L20_m2__nf1_gboth_sdfull_pc/B.n274 25.6005
R465 pfet_01v8_lvt_W1_L20_m2__nf1_gboth_sdfull_pc/B.n195 pfet_01v8_lvt_W1_L20_m2__nf1_gboth_sdfull_pc/B.n24 25.6005
R466 pfet_01v8_lvt_W1_L20_m2__nf1_gboth_sdfull_pc/B.n196 pfet_01v8_lvt_W1_L20_m2__nf1_gboth_sdfull_pc/B.n195 25.6005
R467 pfet_01v8_lvt_W1_L20_m2__nf1_gboth_sdfull_pc/B.n196 pfet_01v8_lvt_W1_L20_m2__nf1_gboth_sdfull_pc/B.n194 25.6005
R468 pfet_01v8_lvt_W1_L20_m2__nf1_gboth_sdfull_pc/B.n194 pfet_01v8_lvt_W1_L20_m2__nf1_gboth_sdfull_pc/B.n193 25.6005
R469 pfet_01v8_lvt_W1_L20_m2__nf1_gboth_sdfull_pc/B.n193 pfet_01v8_lvt_W1_L20_m2__nf1_gboth_sdfull_pc/B.n33 25.6005
R470 pfet_01v8_lvt_W1_L20_m2__nf1_gboth_sdfull_pc/B.n87 pfet_01v8_lvt_W1_L20_m2__nf1_gboth_sdfull_pc/B.n85 25.6005
R471 pfet_01v8_lvt_W1_L20_m2__nf1_gboth_sdfull_pc/B.n88 pfet_01v8_lvt_W1_L20_m2__nf1_gboth_sdfull_pc/B.n87 25.6005
R472 pfet_01v8_lvt_W1_L20_m2__nf1_gboth_sdfull_pc/B.n91 pfet_01v8_lvt_W1_L20_m2__nf1_gboth_sdfull_pc/B.n88 25.6005
R473 pfet_01v8_lvt_W1_L20_m2__nf1_gboth_sdfull_pc/B.n93 pfet_01v8_lvt_W1_L20_m2__nf1_gboth_sdfull_pc/B.n91 25.6005
R474 pfet_01v8_lvt_W1_L20_m2__nf1_gboth_sdfull_pc/B.n94 pfet_01v8_lvt_W1_L20_m2__nf1_gboth_sdfull_pc/B.n93 25.6005
R475 pfet_01v8_lvt_W1_L20_m2__nf1_gboth_sdfull_pc/B.n96 pfet_01v8_lvt_W1_L20_m2__nf1_gboth_sdfull_pc/B.n94 25.6005
R476 pfet_01v8_lvt_W1_L20_m2__nf1_gboth_sdfull_pc/B.n97 pfet_01v8_lvt_W1_L20_m2__nf1_gboth_sdfull_pc/B.n96 25.6005
R477 pfet_01v8_lvt_W1_L20_m2__nf1_gboth_sdfull_pc/B.n100 pfet_01v8_lvt_W1_L20_m2__nf1_gboth_sdfull_pc/B.n97 25.6005
R478 pfet_01v8_lvt_W1_L20_m2__nf1_gboth_sdfull_pc/B.n101 pfet_01v8_lvt_W1_L20_m2__nf1_gboth_sdfull_pc/B.n100 25.6005
R479 pfet_01v8_lvt_W1_L20_m2__nf1_gboth_sdfull_pc/B.n104 pfet_01v8_lvt_W1_L20_m2__nf1_gboth_sdfull_pc/B.n101 25.6005
R480 pfet_01v8_lvt_W1_L20_m2__nf1_gboth_sdfull_pc/B.n105 pfet_01v8_lvt_W1_L20_m2__nf1_gboth_sdfull_pc/B.n104 25.6005
R481 pfet_01v8_lvt_W1_L20_m2__nf1_gboth_sdfull_pc/B.n108 pfet_01v8_lvt_W1_L20_m2__nf1_gboth_sdfull_pc/B.n105 25.6005
R482 pfet_01v8_lvt_W1_L20_m2__nf1_gboth_sdfull_pc/B.n109 pfet_01v8_lvt_W1_L20_m2__nf1_gboth_sdfull_pc/B.n108 25.6005
R483 pfet_01v8_lvt_W1_L20_m2__nf1_gboth_sdfull_pc/B.n112 pfet_01v8_lvt_W1_L20_m2__nf1_gboth_sdfull_pc/B.n109 25.6005
R484 pfet_01v8_lvt_W1_L20_m2__nf1_gboth_sdfull_pc/B.n113 pfet_01v8_lvt_W1_L20_m2__nf1_gboth_sdfull_pc/B.n112 25.6005
R485 pfet_01v8_lvt_W1_L20_m2__nf1_gboth_sdfull_pc/B.n116 pfet_01v8_lvt_W1_L20_m2__nf1_gboth_sdfull_pc/B.n113 25.6005
R486 pfet_01v8_lvt_W1_L20_m2__nf1_gboth_sdfull_pc/B.n117 pfet_01v8_lvt_W1_L20_m2__nf1_gboth_sdfull_pc/B.n116 25.6005
R487 pfet_01v8_lvt_W1_L20_m2__nf1_gboth_sdfull_pc/B.n120 pfet_01v8_lvt_W1_L20_m2__nf1_gboth_sdfull_pc/B.n117 25.6005
R488 pfet_01v8_lvt_W1_L20_m2__nf1_gboth_sdfull_pc/B.n121 pfet_01v8_lvt_W1_L20_m2__nf1_gboth_sdfull_pc/B.n120 25.6005
R489 pfet_01v8_lvt_W1_L20_m2__nf1_gboth_sdfull_pc/B.n124 pfet_01v8_lvt_W1_L20_m2__nf1_gboth_sdfull_pc/B.n121 25.6005
R490 pfet_01v8_lvt_W1_L20_m2__nf1_gboth_sdfull_pc/B.n126 pfet_01v8_lvt_W1_L20_m2__nf1_gboth_sdfull_pc/B.n124 25.6005
R491 pfet_01v8_lvt_W1_L20_m2__nf1_gboth_sdfull_pc/B.n127 pfet_01v8_lvt_W1_L20_m2__nf1_gboth_sdfull_pc/B.n126 25.6005
R492 pfet_01v8_lvt_W1_L20_m2__nf1_gboth_sdfull_pc/B.n129 pfet_01v8_lvt_W1_L20_m2__nf1_gboth_sdfull_pc/B.n127 25.6005
R493 pfet_01v8_lvt_W1_L20_m2__nf1_gboth_sdfull_pc/B.n130 pfet_01v8_lvt_W1_L20_m2__nf1_gboth_sdfull_pc/B.n129 25.6005
R494 pfet_01v8_lvt_W1_L20_m2__nf1_gboth_sdfull_pc/B.n133 pfet_01v8_lvt_W1_L20_m2__nf1_gboth_sdfull_pc/B.n130 25.6005
R495 pfet_01v8_lvt_W1_L20_m2__nf1_gboth_sdfull_pc/B.n135 pfet_01v8_lvt_W1_L20_m2__nf1_gboth_sdfull_pc/B.n133 25.6005
R496 pfet_01v8_lvt_W1_L20_m2__nf1_gboth_sdfull_pc/B.n136 pfet_01v8_lvt_W1_L20_m2__nf1_gboth_sdfull_pc/B.n135 25.6005
R497 pfet_01v8_lvt_W1_L20_m2__nf1_gboth_sdfull_pc/B.n138 pfet_01v8_lvt_W1_L20_m2__nf1_gboth_sdfull_pc/B.n136 25.6005
R498 pfet_01v8_lvt_W1_L20_m2__nf1_gboth_sdfull_pc/B.n139 pfet_01v8_lvt_W1_L20_m2__nf1_gboth_sdfull_pc/B.n138 25.6005
R499 pfet_01v8_lvt_W1_L20_m2__nf1_gboth_sdfull_pc/B.n142 pfet_01v8_lvt_W1_L20_m2__nf1_gboth_sdfull_pc/B.n139 25.6005
R500 pfet_01v8_lvt_W1_L20_m2__nf1_gboth_sdfull_pc/B.n143 pfet_01v8_lvt_W1_L20_m2__nf1_gboth_sdfull_pc/B.n142 25.6005
R501 pfet_01v8_lvt_W1_L20_m2__nf1_gboth_sdfull_pc/B.n146 pfet_01v8_lvt_W1_L20_m2__nf1_gboth_sdfull_pc/B.n143 25.6005
R502 pfet_01v8_lvt_W1_L20_m2__nf1_gboth_sdfull_pc/B.n148 pfet_01v8_lvt_W1_L20_m2__nf1_gboth_sdfull_pc/B.n146 25.6005
R503 pfet_01v8_lvt_W1_L20_m2__nf1_gboth_sdfull_pc/B.n149 pfet_01v8_lvt_W1_L20_m2__nf1_gboth_sdfull_pc/B.n148 25.6005
R504 pfet_01v8_lvt_W1_L20_m2__nf1_gboth_sdfull_pc/B.n151 pfet_01v8_lvt_W1_L20_m2__nf1_gboth_sdfull_pc/B.n149 25.6005
R505 pfet_01v8_lvt_W1_L20_m2__nf1_gboth_sdfull_pc/B.n152 pfet_01v8_lvt_W1_L20_m2__nf1_gboth_sdfull_pc/B.n151 25.6005
R506 pfet_01v8_lvt_W1_L20_m2__nf1_gboth_sdfull_pc/B.n155 pfet_01v8_lvt_W1_L20_m2__nf1_gboth_sdfull_pc/B.n152 25.6005
R507 pfet_01v8_lvt_W1_L20_m2__nf1_gboth_sdfull_pc/B.n156 pfet_01v8_lvt_W1_L20_m2__nf1_gboth_sdfull_pc/B.n155 25.6005
R508 pfet_01v8_lvt_W1_L20_m2__nf1_gboth_sdfull_pc/B.n159 pfet_01v8_lvt_W1_L20_m2__nf1_gboth_sdfull_pc/B.n156 25.6005
R509 pfet_01v8_lvt_W1_L20_m2__nf1_gboth_sdfull_pc/B.n160 pfet_01v8_lvt_W1_L20_m2__nf1_gboth_sdfull_pc/B.n159 25.6005
R510 pfet_01v8_lvt_W1_L20_m2__nf1_gboth_sdfull_pc/B.n163 pfet_01v8_lvt_W1_L20_m2__nf1_gboth_sdfull_pc/B.n160 25.6005
R511 pfet_01v8_lvt_W1_L20_m2__nf1_gboth_sdfull_pc/B.n164 pfet_01v8_lvt_W1_L20_m2__nf1_gboth_sdfull_pc/B.n163 25.6005
R512 pfet_01v8_lvt_W1_L20_m2__nf1_gboth_sdfull_pc/B.n167 pfet_01v8_lvt_W1_L20_m2__nf1_gboth_sdfull_pc/B.n164 25.6005
R513 pfet_01v8_lvt_W1_L20_m2__nf1_gboth_sdfull_pc/B.n168 pfet_01v8_lvt_W1_L20_m2__nf1_gboth_sdfull_pc/B.n167 25.6005
R514 pfet_01v8_lvt_W1_L20_m2__nf1_gboth_sdfull_pc/B.n171 pfet_01v8_lvt_W1_L20_m2__nf1_gboth_sdfull_pc/B.n168 25.6005
R515 pfet_01v8_lvt_W1_L20_m2__nf1_gboth_sdfull_pc/B.n172 pfet_01v8_lvt_W1_L20_m2__nf1_gboth_sdfull_pc/B.n171 25.6005
R516 pfet_01v8_lvt_W1_L20_m2__nf1_gboth_sdfull_pc/B.n175 pfet_01v8_lvt_W1_L20_m2__nf1_gboth_sdfull_pc/B.n172 25.6005
R517 pfet_01v8_lvt_W1_L20_m2__nf1_gboth_sdfull_pc/B.n177 pfet_01v8_lvt_W1_L20_m2__nf1_gboth_sdfull_pc/B.n175 25.6005
R518 pfet_01v8_lvt_W1_L20_m2__nf1_gboth_sdfull_pc/B.n178 pfet_01v8_lvt_W1_L20_m2__nf1_gboth_sdfull_pc/B.n177 25.6005
R519 pfet_01v8_lvt_W1_L20_m2__nf1_gboth_sdfull_pc/B.n180 pfet_01v8_lvt_W1_L20_m2__nf1_gboth_sdfull_pc/B.n178 25.6005
R520 pfet_01v8_lvt_W1_L20_m2__nf1_gboth_sdfull_pc/B.n181 pfet_01v8_lvt_W1_L20_m2__nf1_gboth_sdfull_pc/B.n180 25.6005
R521 pfet_01v8_lvt_W1_L20_m2__nf1_gboth_sdfull_pc/B.n182 pfet_01v8_lvt_W1_L20_m2__nf1_gboth_sdfull_pc/B.n181 25.6005
R522 pfet_01v8_lvt_W1_L20_m2__nf1_gboth_sdfull_pc/B.n182 pfet_01v8_lvt_W1_L20_m2__nf1_gboth_sdfull_pc/B.n84 25.6005
R523 pfet_01v8_lvt_W1_L20_m2__nf1_gboth_sdfull_pc/B.n84 pfet_01v8_lvt_W1_L20_m2__nf1_gboth_sdfull_pc/B.n83 25.6005
R524 pfet_01v8_lvt_W1_L20_m2__nf1_gboth_sdfull_pc/B.n83 pfet_01v8_lvt_W1_L20_m2__nf1_gboth_sdfull_pc/B.n80 25.6005
R525 pfet_01v8_lvt_W1_L20_m2__nf1_gboth_sdfull_pc/B.n80 pfet_01v8_lvt_W1_L20_m2__nf1_gboth_sdfull_pc/B.n79 25.6005
R526 pfet_01v8_lvt_W1_L20_m2__nf1_gboth_sdfull_pc/B.n79 pfet_01v8_lvt_W1_L20_m2__nf1_gboth_sdfull_pc/B.n76 25.6005
R527 pfet_01v8_lvt_W1_L20_m2__nf1_gboth_sdfull_pc/B.n76 pfet_01v8_lvt_W1_L20_m2__nf1_gboth_sdfull_pc/B.n75 25.6005
R528 pfet_01v8_lvt_W1_L20_m2__nf1_gboth_sdfull_pc/B.n75 pfet_01v8_lvt_W1_L20_m2__nf1_gboth_sdfull_pc/B.n38 25.6005
R529 pfet_01v8_lvt_W1_L20_m2__nf1_gboth_sdfull_pc/B.n187 pfet_01v8_lvt_W1_L20_m2__nf1_gboth_sdfull_pc/B.n38 25.6005
R530 pfet_01v8_lvt_W1_L20_m2__nf1_gboth_sdfull_pc/B.n276 pfet_01v8_lvt_W1_L20_m2__nf1_gboth_sdfull_pc/B.n201 25.6005
R531 pfet_01v8_lvt_W1_L20_m2__nf1_gboth_sdfull_pc/B.n201 pfet_01v8_lvt_W1_L20_m2__nf1_gboth_sdfull_pc/B.n200 25.6005
R532 pfet_01v8_lvt_W1_L20_m2__nf1_gboth_sdfull_pc/B.n200 pfet_01v8_lvt_W1_L20_m2__nf1_gboth_sdfull_pc/B.n30 25.6005
R533 pfet_01v8_lvt_W1_L20_m2__nf1_gboth_sdfull_pc/B.n189 pfet_01v8_lvt_W1_L20_m2__nf1_gboth_sdfull_pc/B.n30 25.6005
R534 pfet_01v8_lvt_W1_L20_m2__nf1_gboth_sdfull_pc/B.n189 pfet_01v8_lvt_W1_L20_m2__nf1_gboth_sdfull_pc/B.n188 25.6005
R535 pfet_01v8_lvt_W1_L20_m2__nf1_gboth_sdfull_pc/B.n278 pfet_01v8_lvt_W1_L20_m2__nf1_gboth_sdfull_pc/B.n3 20.7655
R536 pfet_01v8_lvt_W1_L20_m2__nf1_gboth_sdfull_pc/B.n184 pfet_01v8_lvt_W1_L20_m2__nf1_gboth_sdfull_pc/B.n35 20.7655
R537 B pfet_01v8_lvt_W1_L20_m2__nf1_gboth_sdfull_pc/B.n332 19.2005
R538 pfet_01v8_lvt_W1_L20_m2__nf1_gboth_sdfull_pc/B.n278 pfet_01v8_lvt_W1_L20_m2__nf1_gboth_sdfull_pc/B.n27 14.7091
R539 pfet_01v8_lvt_W1_L20_m2__nf1_gboth_sdfull_pc/B.n198 pfet_01v8_lvt_W1_L20_m2__nf1_gboth_sdfull_pc/B.n27 14.7091
R540 pfet_01v8_lvt_W1_L20_m2__nf1_gboth_sdfull_pc/B.n191 pfet_01v8_lvt_W1_L20_m2__nf1_gboth_sdfull_pc/B.n36 14.7091
R541 pfet_01v8_lvt_W1_L20_m2__nf1_gboth_sdfull_pc/B.n191 pfet_01v8_lvt_W1_L20_m2__nf1_gboth_sdfull_pc/B.n35 14.7091
R542 pfet_01v8_lvt_W1_L20_m2__nf1_gboth_sdfull_pc/B.n198 pfet_01v8_lvt_W1_L20_m2__nf1_gboth_sdfull_pc/B.t0 7.35478
R543 pfet_01v8_lvt_W1_L20_m2__nf1_gboth_sdfull_pc/B.n36 pfet_01v8_lvt_W1_L20_m2__nf1_gboth_sdfull_pc/B.t0 7.35478
R544 B pfet_01v8_lvt_W1_L20_m2__nf1_gboth_sdfull_pc/B.n0 6.4005
C5 S VSUBS 0.05316f
C6 D VSUBS 0.05316f
C7 G VSUBS 2.04984f
C8 B VSUBS 10.14387f
C9 pfet_01v8_lvt_W1_L20_m2__nf1_gboth_sdfull_pc/B.n0 VSUBS 0.00271f ; **FLOATING
C10 pfet_01v8_lvt_W1_L20_m2__nf1_gboth_sdfull_pc/B.n1 VSUBS 0.00433f ; **FLOATING
C11 pfet_01v8_lvt_W1_L20_m2__nf1_gboth_sdfull_pc/B.n2 VSUBS 0.00433f ; **FLOATING
C12 pfet_01v8_lvt_W1_L20_m2__nf1_gboth_sdfull_pc/B.n3 VSUBS 0.83108f ; **FLOATING
C13 pfet_01v8_lvt_W1_L20_m2__nf1_gboth_sdfull_pc/B.n4 VSUBS 0.00433f ; **FLOATING
C14 pfet_01v8_lvt_W1_L20_m2__nf1_gboth_sdfull_pc/B.n5 VSUBS 0.00433f ; **FLOATING
C15 pfet_01v8_lvt_W1_L20_m2__nf1_gboth_sdfull_pc/B.n6 VSUBS 0.00433f ; **FLOATING
C16 pfet_01v8_lvt_W1_L20_m2__nf1_gboth_sdfull_pc/B.n8 VSUBS 0.00433f ; **FLOATING
C17 pfet_01v8_lvt_W1_L20_m2__nf1_gboth_sdfull_pc/B.n9 VSUBS 0.00433f ; **FLOATING
C18 pfet_01v8_lvt_W1_L20_m2__nf1_gboth_sdfull_pc/B.n11 VSUBS 0.00433f ; **FLOATING
C19 pfet_01v8_lvt_W1_L20_m2__nf1_gboth_sdfull_pc/B.n12 VSUBS 0.00433f ; **FLOATING
C20 pfet_01v8_lvt_W1_L20_m2__nf1_gboth_sdfull_pc/B.n14 VSUBS 0.00433f ; **FLOATING
C21 pfet_01v8_lvt_W1_L20_m2__nf1_gboth_sdfull_pc/B.n15 VSUBS 0.00433f ; **FLOATING
C22 pfet_01v8_lvt_W1_L20_m2__nf1_gboth_sdfull_pc/B.n17 VSUBS 0.00433f ; **FLOATING
C23 pfet_01v8_lvt_W1_L20_m2__nf1_gboth_sdfull_pc/B.n18 VSUBS 0.00433f ; **FLOATING
C24 pfet_01v8_lvt_W1_L20_m2__nf1_gboth_sdfull_pc/B.n20 VSUBS 0.00433f ; **FLOATING
C25 pfet_01v8_lvt_W1_L20_m2__nf1_gboth_sdfull_pc/B.n21 VSUBS 0.00433f ; **FLOATING
C26 pfet_01v8_lvt_W1_L20_m2__nf1_gboth_sdfull_pc/B.n23 VSUBS 0.00433f ; **FLOATING
C27 pfet_01v8_lvt_W1_L20_m2__nf1_gboth_sdfull_pc/B.n24 VSUBS 0.00858f ; **FLOATING
C28 pfet_01v8_lvt_W1_L20_m2__nf1_gboth_sdfull_pc/B.n26 VSUBS 0.00433f ; **FLOATING
C29 pfet_01v8_lvt_W1_L20_m2__nf1_gboth_sdfull_pc/B.n27 VSUBS 0.55954f ; **FLOATING
C30 pfet_01v8_lvt_W1_L20_m2__nf1_gboth_sdfull_pc/B.n28 VSUBS 0.00433f ; **FLOATING
C31 pfet_01v8_lvt_W1_L20_m2__nf1_gboth_sdfull_pc/B.n29 VSUBS 0.00843f ; **FLOATING
C32 pfet_01v8_lvt_W1_L20_m2__nf1_gboth_sdfull_pc/B.n30 VSUBS 0.00433f ; **FLOATING
C33 pfet_01v8_lvt_W1_L20_m2__nf1_gboth_sdfull_pc/B.n31 VSUBS 0.00433f ; **FLOATING
C34 pfet_01v8_lvt_W1_L20_m2__nf1_gboth_sdfull_pc/B.t0 VSUBS 0.27977f ; **FLOATING
C35 pfet_01v8_lvt_W1_L20_m2__nf1_gboth_sdfull_pc/B.n32 VSUBS 0.00433f ; **FLOATING
C36 pfet_01v8_lvt_W1_L20_m2__nf1_gboth_sdfull_pc/B.n33 VSUBS 0.00858f ; **FLOATING
C37 pfet_01v8_lvt_W1_L20_m2__nf1_gboth_sdfull_pc/B.n34 VSUBS 0.00858f ; **FLOATING
C38 pfet_01v8_lvt_W1_L20_m2__nf1_gboth_sdfull_pc/B.n35 VSUBS 0.67474f ; **FLOATING
C39 pfet_01v8_lvt_W1_L20_m2__nf1_gboth_sdfull_pc/B.n36 VSUBS 0.41965f ; **FLOATING
C40 pfet_01v8_lvt_W1_L20_m2__nf1_gboth_sdfull_pc/B.n37 VSUBS 0.00858f ; **FLOATING
C41 pfet_01v8_lvt_W1_L20_m2__nf1_gboth_sdfull_pc/B.n38 VSUBS 0.00433f ; **FLOATING
C42 pfet_01v8_lvt_W1_L20_m2__nf1_gboth_sdfull_pc/B.n39 VSUBS 0.00433f ; **FLOATING
C43 pfet_01v8_lvt_W1_L20_m2__nf1_gboth_sdfull_pc/B.n43 VSUBS 0.00433f ; **FLOATING
C44 pfet_01v8_lvt_W1_L20_m2__nf1_gboth_sdfull_pc/B.n51 VSUBS 0.00433f ; **FLOATING
C45 pfet_01v8_lvt_W1_L20_m2__nf1_gboth_sdfull_pc/B.n54 VSUBS 0.00433f ; **FLOATING
C46 pfet_01v8_lvt_W1_L20_m2__nf1_gboth_sdfull_pc/B.n57 VSUBS 0.00843f ; **FLOATING
C47 pfet_01v8_lvt_W1_L20_m2__nf1_gboth_sdfull_pc/B.n65 VSUBS 0.00433f ; **FLOATING
C48 pfet_01v8_lvt_W1_L20_m2__nf1_gboth_sdfull_pc/B.n69 VSUBS 0.00433f ; **FLOATING
C49 pfet_01v8_lvt_W1_L20_m2__nf1_gboth_sdfull_pc/B.n72 VSUBS 0.00433f ; **FLOATING
C50 pfet_01v8_lvt_W1_L20_m2__nf1_gboth_sdfull_pc/B.n73 VSUBS 0.00433f ; **FLOATING
C51 pfet_01v8_lvt_W1_L20_m2__nf1_gboth_sdfull_pc/B.n74 VSUBS 0.00433f ; **FLOATING
C52 pfet_01v8_lvt_W1_L20_m2__nf1_gboth_sdfull_pc/B.n75 VSUBS 0.00433f ; **FLOATING
C53 pfet_01v8_lvt_W1_L20_m2__nf1_gboth_sdfull_pc/B.n76 VSUBS 0.00433f ; **FLOATING
C54 pfet_01v8_lvt_W1_L20_m2__nf1_gboth_sdfull_pc/B.n77 VSUBS 0.00433f ; **FLOATING
C55 pfet_01v8_lvt_W1_L20_m2__nf1_gboth_sdfull_pc/B.n78 VSUBS 0.00433f ; **FLOATING
C56 pfet_01v8_lvt_W1_L20_m2__nf1_gboth_sdfull_pc/B.n79 VSUBS 0.00433f ; **FLOATING
C57 pfet_01v8_lvt_W1_L20_m2__nf1_gboth_sdfull_pc/B.n80 VSUBS 0.00433f ; **FLOATING
C58 pfet_01v8_lvt_W1_L20_m2__nf1_gboth_sdfull_pc/B.n81 VSUBS 0.00433f ; **FLOATING
C59 pfet_01v8_lvt_W1_L20_m2__nf1_gboth_sdfull_pc/B.n82 VSUBS 0.00433f ; **FLOATING
C60 pfet_01v8_lvt_W1_L20_m2__nf1_gboth_sdfull_pc/B.n83 VSUBS 0.00433f ; **FLOATING
C61 pfet_01v8_lvt_W1_L20_m2__nf1_gboth_sdfull_pc/B.n84 VSUBS 0.00433f ; **FLOATING
C62 pfet_01v8_lvt_W1_L20_m2__nf1_gboth_sdfull_pc/B.n85 VSUBS 0.00843f ; **FLOATING
C63 pfet_01v8_lvt_W1_L20_m2__nf1_gboth_sdfull_pc/B.n86 VSUBS 0.00433f ; **FLOATING
C64 pfet_01v8_lvt_W1_L20_m2__nf1_gboth_sdfull_pc/B.n87 VSUBS 0.00433f ; **FLOATING
C65 pfet_01v8_lvt_W1_L20_m2__nf1_gboth_sdfull_pc/B.n88 VSUBS 0.00433f ; **FLOATING
C66 pfet_01v8_lvt_W1_L20_m2__nf1_gboth_sdfull_pc/B.n89 VSUBS 0.00433f ; **FLOATING
C67 pfet_01v8_lvt_W1_L20_m2__nf1_gboth_sdfull_pc/B.n90 VSUBS 0.00433f ; **FLOATING
C68 pfet_01v8_lvt_W1_L20_m2__nf1_gboth_sdfull_pc/B.n91 VSUBS 0.00433f ; **FLOATING
C69 pfet_01v8_lvt_W1_L20_m2__nf1_gboth_sdfull_pc/B.n92 VSUBS 0.00433f ; **FLOATING
C70 pfet_01v8_lvt_W1_L20_m2__nf1_gboth_sdfull_pc/B.n93 VSUBS 0.00433f ; **FLOATING
C71 pfet_01v8_lvt_W1_L20_m2__nf1_gboth_sdfull_pc/B.n94 VSUBS 0.00433f ; **FLOATING
C72 pfet_01v8_lvt_W1_L20_m2__nf1_gboth_sdfull_pc/B.n95 VSUBS 0.00433f ; **FLOATING
C73 pfet_01v8_lvt_W1_L20_m2__nf1_gboth_sdfull_pc/B.n96 VSUBS 0.00433f ; **FLOATING
C74 pfet_01v8_lvt_W1_L20_m2__nf1_gboth_sdfull_pc/B.n97 VSUBS 0.00433f ; **FLOATING
C75 pfet_01v8_lvt_W1_L20_m2__nf1_gboth_sdfull_pc/B.n98 VSUBS 0.00433f ; **FLOATING
C76 pfet_01v8_lvt_W1_L20_m2__nf1_gboth_sdfull_pc/B.n99 VSUBS 0.00433f ; **FLOATING
C77 pfet_01v8_lvt_W1_L20_m2__nf1_gboth_sdfull_pc/B.n100 VSUBS 0.00433f ; **FLOATING
C78 pfet_01v8_lvt_W1_L20_m2__nf1_gboth_sdfull_pc/B.n101 VSUBS 0.00433f ; **FLOATING
C79 pfet_01v8_lvt_W1_L20_m2__nf1_gboth_sdfull_pc/B.n102 VSUBS 0.00433f ; **FLOATING
C80 pfet_01v8_lvt_W1_L20_m2__nf1_gboth_sdfull_pc/B.n103 VSUBS 0.00433f ; **FLOATING
C81 pfet_01v8_lvt_W1_L20_m2__nf1_gboth_sdfull_pc/B.n104 VSUBS 0.00433f ; **FLOATING
C82 pfet_01v8_lvt_W1_L20_m2__nf1_gboth_sdfull_pc/B.n105 VSUBS 0.00433f ; **FLOATING
C83 pfet_01v8_lvt_W1_L20_m2__nf1_gboth_sdfull_pc/B.n106 VSUBS 0.00433f ; **FLOATING
C84 pfet_01v8_lvt_W1_L20_m2__nf1_gboth_sdfull_pc/B.n107 VSUBS 0.00433f ; **FLOATING
C85 pfet_01v8_lvt_W1_L20_m2__nf1_gboth_sdfull_pc/B.n108 VSUBS 0.00433f ; **FLOATING
C86 pfet_01v8_lvt_W1_L20_m2__nf1_gboth_sdfull_pc/B.n109 VSUBS 0.00433f ; **FLOATING
C87 pfet_01v8_lvt_W1_L20_m2__nf1_gboth_sdfull_pc/B.n110 VSUBS 0.00433f ; **FLOATING
C88 pfet_01v8_lvt_W1_L20_m2__nf1_gboth_sdfull_pc/B.n111 VSUBS 0.00433f ; **FLOATING
C89 pfet_01v8_lvt_W1_L20_m2__nf1_gboth_sdfull_pc/B.n112 VSUBS 0.00433f ; **FLOATING
C90 pfet_01v8_lvt_W1_L20_m2__nf1_gboth_sdfull_pc/B.n113 VSUBS 0.00433f ; **FLOATING
C91 pfet_01v8_lvt_W1_L20_m2__nf1_gboth_sdfull_pc/B.n114 VSUBS 0.00433f ; **FLOATING
C92 pfet_01v8_lvt_W1_L20_m2__nf1_gboth_sdfull_pc/B.n115 VSUBS 0.00433f ; **FLOATING
C93 pfet_01v8_lvt_W1_L20_m2__nf1_gboth_sdfull_pc/B.n116 VSUBS 0.00433f ; **FLOATING
C94 pfet_01v8_lvt_W1_L20_m2__nf1_gboth_sdfull_pc/B.n117 VSUBS 0.00433f ; **FLOATING
C95 pfet_01v8_lvt_W1_L20_m2__nf1_gboth_sdfull_pc/B.n118 VSUBS 0.00433f ; **FLOATING
C96 pfet_01v8_lvt_W1_L20_m2__nf1_gboth_sdfull_pc/B.n119 VSUBS 0.00433f ; **FLOATING
C97 pfet_01v8_lvt_W1_L20_m2__nf1_gboth_sdfull_pc/B.n120 VSUBS 0.00433f ; **FLOATING
C98 pfet_01v8_lvt_W1_L20_m2__nf1_gboth_sdfull_pc/B.n121 VSUBS 0.00433f ; **FLOATING
C99 pfet_01v8_lvt_W1_L20_m2__nf1_gboth_sdfull_pc/B.n122 VSUBS 0.00433f ; **FLOATING
C100 pfet_01v8_lvt_W1_L20_m2__nf1_gboth_sdfull_pc/B.n123 VSUBS 0.00433f ; **FLOATING
C101 pfet_01v8_lvt_W1_L20_m2__nf1_gboth_sdfull_pc/B.n124 VSUBS 0.00433f ; **FLOATING
C102 pfet_01v8_lvt_W1_L20_m2__nf1_gboth_sdfull_pc/B.n125 VSUBS 0.00433f ; **FLOATING
C103 pfet_01v8_lvt_W1_L20_m2__nf1_gboth_sdfull_pc/B.n126 VSUBS 0.00433f ; **FLOATING
C104 pfet_01v8_lvt_W1_L20_m2__nf1_gboth_sdfull_pc/B.n127 VSUBS 0.00433f ; **FLOATING
C105 pfet_01v8_lvt_W1_L20_m2__nf1_gboth_sdfull_pc/B.n128 VSUBS 0.00433f ; **FLOATING
C106 pfet_01v8_lvt_W1_L20_m2__nf1_gboth_sdfull_pc/B.n129 VSUBS 0.00433f ; **FLOATING
C107 pfet_01v8_lvt_W1_L20_m2__nf1_gboth_sdfull_pc/B.n130 VSUBS 0.00433f ; **FLOATING
C108 pfet_01v8_lvt_W1_L20_m2__nf1_gboth_sdfull_pc/B.n131 VSUBS 0.00433f ; **FLOATING
C109 pfet_01v8_lvt_W1_L20_m2__nf1_gboth_sdfull_pc/B.n132 VSUBS 0.00433f ; **FLOATING
C110 pfet_01v8_lvt_W1_L20_m2__nf1_gboth_sdfull_pc/B.n133 VSUBS 0.00433f ; **FLOATING
C111 pfet_01v8_lvt_W1_L20_m2__nf1_gboth_sdfull_pc/B.n134 VSUBS 0.00433f ; **FLOATING
C112 pfet_01v8_lvt_W1_L20_m2__nf1_gboth_sdfull_pc/B.n135 VSUBS 0.00433f ; **FLOATING
C113 pfet_01v8_lvt_W1_L20_m2__nf1_gboth_sdfull_pc/B.n136 VSUBS 0.00433f ; **FLOATING
C114 pfet_01v8_lvt_W1_L20_m2__nf1_gboth_sdfull_pc/B.n137 VSUBS 0.00433f ; **FLOATING
C115 pfet_01v8_lvt_W1_L20_m2__nf1_gboth_sdfull_pc/B.n138 VSUBS 0.00433f ; **FLOATING
C116 pfet_01v8_lvt_W1_L20_m2__nf1_gboth_sdfull_pc/B.n139 VSUBS 0.00433f ; **FLOATING
C117 pfet_01v8_lvt_W1_L20_m2__nf1_gboth_sdfull_pc/B.n140 VSUBS 0.00433f ; **FLOATING
C118 pfet_01v8_lvt_W1_L20_m2__nf1_gboth_sdfull_pc/B.n141 VSUBS 0.00433f ; **FLOATING
C119 pfet_01v8_lvt_W1_L20_m2__nf1_gboth_sdfull_pc/B.n142 VSUBS 0.00433f ; **FLOATING
C120 pfet_01v8_lvt_W1_L20_m2__nf1_gboth_sdfull_pc/B.n143 VSUBS 0.00433f ; **FLOATING
C121 pfet_01v8_lvt_W1_L20_m2__nf1_gboth_sdfull_pc/B.n144 VSUBS 0.00433f ; **FLOATING
C122 pfet_01v8_lvt_W1_L20_m2__nf1_gboth_sdfull_pc/B.n145 VSUBS 0.00433f ; **FLOATING
C123 pfet_01v8_lvt_W1_L20_m2__nf1_gboth_sdfull_pc/B.n146 VSUBS 0.00433f ; **FLOATING
C124 pfet_01v8_lvt_W1_L20_m2__nf1_gboth_sdfull_pc/B.n147 VSUBS 0.00433f ; **FLOATING
C125 pfet_01v8_lvt_W1_L20_m2__nf1_gboth_sdfull_pc/B.n148 VSUBS 0.00433f ; **FLOATING
C126 pfet_01v8_lvt_W1_L20_m2__nf1_gboth_sdfull_pc/B.n149 VSUBS 0.00433f ; **FLOATING
C127 pfet_01v8_lvt_W1_L20_m2__nf1_gboth_sdfull_pc/B.n150 VSUBS 0.00433f ; **FLOATING
C128 pfet_01v8_lvt_W1_L20_m2__nf1_gboth_sdfull_pc/B.n151 VSUBS 0.00433f ; **FLOATING
C129 pfet_01v8_lvt_W1_L20_m2__nf1_gboth_sdfull_pc/B.n152 VSUBS 0.00433f ; **FLOATING
C130 pfet_01v8_lvt_W1_L20_m2__nf1_gboth_sdfull_pc/B.n153 VSUBS 0.00433f ; **FLOATING
C131 pfet_01v8_lvt_W1_L20_m2__nf1_gboth_sdfull_pc/B.n154 VSUBS 0.00433f ; **FLOATING
C132 pfet_01v8_lvt_W1_L20_m2__nf1_gboth_sdfull_pc/B.n155 VSUBS 0.00433f ; **FLOATING
C133 pfet_01v8_lvt_W1_L20_m2__nf1_gboth_sdfull_pc/B.n156 VSUBS 0.00433f ; **FLOATING
C134 pfet_01v8_lvt_W1_L20_m2__nf1_gboth_sdfull_pc/B.n157 VSUBS 0.00433f ; **FLOATING
C135 pfet_01v8_lvt_W1_L20_m2__nf1_gboth_sdfull_pc/B.n158 VSUBS 0.00433f ; **FLOATING
C136 pfet_01v8_lvt_W1_L20_m2__nf1_gboth_sdfull_pc/B.n159 VSUBS 0.00433f ; **FLOATING
C137 pfet_01v8_lvt_W1_L20_m2__nf1_gboth_sdfull_pc/B.n160 VSUBS 0.00433f ; **FLOATING
C138 pfet_01v8_lvt_W1_L20_m2__nf1_gboth_sdfull_pc/B.n161 VSUBS 0.00433f ; **FLOATING
C139 pfet_01v8_lvt_W1_L20_m2__nf1_gboth_sdfull_pc/B.n162 VSUBS 0.00433f ; **FLOATING
C140 pfet_01v8_lvt_W1_L20_m2__nf1_gboth_sdfull_pc/B.n163 VSUBS 0.00433f ; **FLOATING
C141 pfet_01v8_lvt_W1_L20_m2__nf1_gboth_sdfull_pc/B.n164 VSUBS 0.00433f ; **FLOATING
C142 pfet_01v8_lvt_W1_L20_m2__nf1_gboth_sdfull_pc/B.n165 VSUBS 0.00433f ; **FLOATING
C143 pfet_01v8_lvt_W1_L20_m2__nf1_gboth_sdfull_pc/B.n166 VSUBS 0.00433f ; **FLOATING
C144 pfet_01v8_lvt_W1_L20_m2__nf1_gboth_sdfull_pc/B.n167 VSUBS 0.00433f ; **FLOATING
C145 pfet_01v8_lvt_W1_L20_m2__nf1_gboth_sdfull_pc/B.n168 VSUBS 0.00433f ; **FLOATING
C146 pfet_01v8_lvt_W1_L20_m2__nf1_gboth_sdfull_pc/B.n169 VSUBS 0.00433f ; **FLOATING
C147 pfet_01v8_lvt_W1_L20_m2__nf1_gboth_sdfull_pc/B.n170 VSUBS 0.00433f ; **FLOATING
C148 pfet_01v8_lvt_W1_L20_m2__nf1_gboth_sdfull_pc/B.n171 VSUBS 0.00433f ; **FLOATING
C149 pfet_01v8_lvt_W1_L20_m2__nf1_gboth_sdfull_pc/B.n172 VSUBS 0.00433f ; **FLOATING
C150 pfet_01v8_lvt_W1_L20_m2__nf1_gboth_sdfull_pc/B.n173 VSUBS 0.00433f ; **FLOATING
C151 pfet_01v8_lvt_W1_L20_m2__nf1_gboth_sdfull_pc/B.n174 VSUBS 0.00433f ; **FLOATING
C152 pfet_01v8_lvt_W1_L20_m2__nf1_gboth_sdfull_pc/B.n175 VSUBS 0.00433f ; **FLOATING
C153 pfet_01v8_lvt_W1_L20_m2__nf1_gboth_sdfull_pc/B.n176 VSUBS 0.00433f ; **FLOATING
C154 pfet_01v8_lvt_W1_L20_m2__nf1_gboth_sdfull_pc/B.n177 VSUBS 0.00433f ; **FLOATING
C155 pfet_01v8_lvt_W1_L20_m2__nf1_gboth_sdfull_pc/B.n178 VSUBS 0.00433f ; **FLOATING
C156 pfet_01v8_lvt_W1_L20_m2__nf1_gboth_sdfull_pc/B.n179 VSUBS 0.00433f ; **FLOATING
C157 pfet_01v8_lvt_W1_L20_m2__nf1_gboth_sdfull_pc/B.n180 VSUBS 0.00433f ; **FLOATING
C158 pfet_01v8_lvt_W1_L20_m2__nf1_gboth_sdfull_pc/B.n181 VSUBS 0.00433f ; **FLOATING
C159 pfet_01v8_lvt_W1_L20_m2__nf1_gboth_sdfull_pc/B.n182 VSUBS 0.00433f ; **FLOATING
C160 pfet_01v8_lvt_W1_L20_m2__nf1_gboth_sdfull_pc/B.n183 VSUBS 0.00433f ; **FLOATING
C161 pfet_01v8_lvt_W1_L20_m2__nf1_gboth_sdfull_pc/B.n184 VSUBS 0.83108f ; **FLOATING
C162 pfet_01v8_lvt_W1_L20_m2__nf1_gboth_sdfull_pc/B.n186 VSUBS 0.00843f ; **FLOATING
C163 pfet_01v8_lvt_W1_L20_m2__nf1_gboth_sdfull_pc/B.n187 VSUBS 0.00843f ; **FLOATING
C164 pfet_01v8_lvt_W1_L20_m2__nf1_gboth_sdfull_pc/B.n188 VSUBS 0.00858f ; **FLOATING
C165 pfet_01v8_lvt_W1_L20_m2__nf1_gboth_sdfull_pc/B.n189 VSUBS 0.00433f ; **FLOATING
C166 pfet_01v8_lvt_W1_L20_m2__nf1_gboth_sdfull_pc/B.n190 VSUBS 0.00433f ; **FLOATING
C167 pfet_01v8_lvt_W1_L20_m2__nf1_gboth_sdfull_pc/B.n191 VSUBS 0.55954f ; **FLOATING
C168 pfet_01v8_lvt_W1_L20_m2__nf1_gboth_sdfull_pc/B.n192 VSUBS 0.00433f ; **FLOATING
C169 pfet_01v8_lvt_W1_L20_m2__nf1_gboth_sdfull_pc/B.n193 VSUBS 0.00433f ; **FLOATING
C170 pfet_01v8_lvt_W1_L20_m2__nf1_gboth_sdfull_pc/B.n194 VSUBS 0.00433f ; **FLOATING
C171 pfet_01v8_lvt_W1_L20_m2__nf1_gboth_sdfull_pc/B.n195 VSUBS 0.00433f ; **FLOATING
C172 pfet_01v8_lvt_W1_L20_m2__nf1_gboth_sdfull_pc/B.n196 VSUBS 0.00433f ; **FLOATING
C173 pfet_01v8_lvt_W1_L20_m2__nf1_gboth_sdfull_pc/B.n197 VSUBS 0.00433f ; **FLOATING
C174 pfet_01v8_lvt_W1_L20_m2__nf1_gboth_sdfull_pc/B.n198 VSUBS 0.41965f ; **FLOATING
C175 pfet_01v8_lvt_W1_L20_m2__nf1_gboth_sdfull_pc/B.n199 VSUBS 0.00433f ; **FLOATING
C176 pfet_01v8_lvt_W1_L20_m2__nf1_gboth_sdfull_pc/B.n200 VSUBS 0.00433f ; **FLOATING
C177 pfet_01v8_lvt_W1_L20_m2__nf1_gboth_sdfull_pc/B.n201 VSUBS 0.00433f ; **FLOATING
C178 pfet_01v8_lvt_W1_L20_m2__nf1_gboth_sdfull_pc/B.n202 VSUBS 0.00433f ; **FLOATING
C179 pfet_01v8_lvt_W1_L20_m2__nf1_gboth_sdfull_pc/B.n203 VSUBS 0.00433f ; **FLOATING
C180 pfet_01v8_lvt_W1_L20_m2__nf1_gboth_sdfull_pc/B.n204 VSUBS 0.00433f ; **FLOATING
C181 pfet_01v8_lvt_W1_L20_m2__nf1_gboth_sdfull_pc/B.n205 VSUBS 0.00433f ; **FLOATING
C182 pfet_01v8_lvt_W1_L20_m2__nf1_gboth_sdfull_pc/B.n207 VSUBS 0.00433f ; **FLOATING
C183 pfet_01v8_lvt_W1_L20_m2__nf1_gboth_sdfull_pc/B.n208 VSUBS 0.00433f ; **FLOATING
C184 pfet_01v8_lvt_W1_L20_m2__nf1_gboth_sdfull_pc/B.n210 VSUBS 0.00433f ; **FLOATING
C185 pfet_01v8_lvt_W1_L20_m2__nf1_gboth_sdfull_pc/B.n211 VSUBS 0.00433f ; **FLOATING
C186 pfet_01v8_lvt_W1_L20_m2__nf1_gboth_sdfull_pc/B.n213 VSUBS 0.00433f ; **FLOATING
C187 pfet_01v8_lvt_W1_L20_m2__nf1_gboth_sdfull_pc/B.n214 VSUBS 0.00433f ; **FLOATING
C188 pfet_01v8_lvt_W1_L20_m2__nf1_gboth_sdfull_pc/B.n216 VSUBS 0.00433f ; **FLOATING
C189 pfet_01v8_lvt_W1_L20_m2__nf1_gboth_sdfull_pc/B.n217 VSUBS 0.00433f ; **FLOATING
C190 pfet_01v8_lvt_W1_L20_m2__nf1_gboth_sdfull_pc/B.n219 VSUBS 0.00433f ; **FLOATING
C191 pfet_01v8_lvt_W1_L20_m2__nf1_gboth_sdfull_pc/B.n220 VSUBS 0.00433f ; **FLOATING
C192 pfet_01v8_lvt_W1_L20_m2__nf1_gboth_sdfull_pc/B.n223 VSUBS 0.00433f ; **FLOATING
C193 pfet_01v8_lvt_W1_L20_m2__nf1_gboth_sdfull_pc/B.n224 VSUBS 0.00433f ; **FLOATING
C194 pfet_01v8_lvt_W1_L20_m2__nf1_gboth_sdfull_pc/B.n225 VSUBS 0.00433f ; **FLOATING
C195 pfet_01v8_lvt_W1_L20_m2__nf1_gboth_sdfull_pc/B.n226 VSUBS 0.00433f ; **FLOATING
C196 pfet_01v8_lvt_W1_L20_m2__nf1_gboth_sdfull_pc/B.n228 VSUBS 0.00433f ; **FLOATING
C197 pfet_01v8_lvt_W1_L20_m2__nf1_gboth_sdfull_pc/B.n229 VSUBS 0.00433f ; **FLOATING
C198 pfet_01v8_lvt_W1_L20_m2__nf1_gboth_sdfull_pc/B.n230 VSUBS 0.00433f ; **FLOATING
C199 pfet_01v8_lvt_W1_L20_m2__nf1_gboth_sdfull_pc/B.n231 VSUBS 0.00433f ; **FLOATING
C200 pfet_01v8_lvt_W1_L20_m2__nf1_gboth_sdfull_pc/B.n232 VSUBS 0.00433f ; **FLOATING
C201 pfet_01v8_lvt_W1_L20_m2__nf1_gboth_sdfull_pc/B.n233 VSUBS 0.00433f ; **FLOATING
C202 pfet_01v8_lvt_W1_L20_m2__nf1_gboth_sdfull_pc/B.n235 VSUBS 0.00433f ; **FLOATING
C203 pfet_01v8_lvt_W1_L20_m2__nf1_gboth_sdfull_pc/B.n236 VSUBS 0.00433f ; **FLOATING
C204 pfet_01v8_lvt_W1_L20_m2__nf1_gboth_sdfull_pc/B.n237 VSUBS 0.00433f ; **FLOATING
C205 pfet_01v8_lvt_W1_L20_m2__nf1_gboth_sdfull_pc/B.n238 VSUBS 0.00433f ; **FLOATING
C206 pfet_01v8_lvt_W1_L20_m2__nf1_gboth_sdfull_pc/B.n239 VSUBS 0.00433f ; **FLOATING
C207 pfet_01v8_lvt_W1_L20_m2__nf1_gboth_sdfull_pc/B.n240 VSUBS 0.00433f ; **FLOATING
C208 pfet_01v8_lvt_W1_L20_m2__nf1_gboth_sdfull_pc/B.n242 VSUBS 0.00433f ; **FLOATING
C209 pfet_01v8_lvt_W1_L20_m2__nf1_gboth_sdfull_pc/B.n243 VSUBS 0.00433f ; **FLOATING
C210 pfet_01v8_lvt_W1_L20_m2__nf1_gboth_sdfull_pc/B.n244 VSUBS 0.00433f ; **FLOATING
C211 pfet_01v8_lvt_W1_L20_m2__nf1_gboth_sdfull_pc/B.n245 VSUBS 0.00433f ; **FLOATING
C212 pfet_01v8_lvt_W1_L20_m2__nf1_gboth_sdfull_pc/B.n246 VSUBS 0.00433f ; **FLOATING
C213 pfet_01v8_lvt_W1_L20_m2__nf1_gboth_sdfull_pc/B.n247 VSUBS 0.00433f ; **FLOATING
C214 pfet_01v8_lvt_W1_L20_m2__nf1_gboth_sdfull_pc/B.n249 VSUBS 0.00433f ; **FLOATING
C215 pfet_01v8_lvt_W1_L20_m2__nf1_gboth_sdfull_pc/B.n250 VSUBS 0.00433f ; **FLOATING
C216 pfet_01v8_lvt_W1_L20_m2__nf1_gboth_sdfull_pc/B.n251 VSUBS 0.00433f ; **FLOATING
C217 pfet_01v8_lvt_W1_L20_m2__nf1_gboth_sdfull_pc/B.n252 VSUBS 0.00433f ; **FLOATING
C218 pfet_01v8_lvt_W1_L20_m2__nf1_gboth_sdfull_pc/B.n253 VSUBS 0.00433f ; **FLOATING
C219 pfet_01v8_lvt_W1_L20_m2__nf1_gboth_sdfull_pc/B.n254 VSUBS 0.00433f ; **FLOATING
C220 pfet_01v8_lvt_W1_L20_m2__nf1_gboth_sdfull_pc/B.n256 VSUBS 0.00433f ; **FLOATING
C221 pfet_01v8_lvt_W1_L20_m2__nf1_gboth_sdfull_pc/B.n257 VSUBS 0.00433f ; **FLOATING
C222 pfet_01v8_lvt_W1_L20_m2__nf1_gboth_sdfull_pc/B.n258 VSUBS 0.00433f ; **FLOATING
C223 pfet_01v8_lvt_W1_L20_m2__nf1_gboth_sdfull_pc/B.n259 VSUBS 0.00433f ; **FLOATING
C224 pfet_01v8_lvt_W1_L20_m2__nf1_gboth_sdfull_pc/B.n260 VSUBS 0.00433f ; **FLOATING
C225 pfet_01v8_lvt_W1_L20_m2__nf1_gboth_sdfull_pc/B.n261 VSUBS 0.00433f ; **FLOATING
C226 pfet_01v8_lvt_W1_L20_m2__nf1_gboth_sdfull_pc/B.n263 VSUBS 0.00433f ; **FLOATING
C227 pfet_01v8_lvt_W1_L20_m2__nf1_gboth_sdfull_pc/B.n264 VSUBS 0.00433f ; **FLOATING
C228 pfet_01v8_lvt_W1_L20_m2__nf1_gboth_sdfull_pc/B.n265 VSUBS 0.00433f ; **FLOATING
C229 pfet_01v8_lvt_W1_L20_m2__nf1_gboth_sdfull_pc/B.n266 VSUBS 0.00433f ; **FLOATING
C230 pfet_01v8_lvt_W1_L20_m2__nf1_gboth_sdfull_pc/B.n267 VSUBS 0.00433f ; **FLOATING
C231 pfet_01v8_lvt_W1_L20_m2__nf1_gboth_sdfull_pc/B.n268 VSUBS 0.00433f ; **FLOATING
C232 pfet_01v8_lvt_W1_L20_m2__nf1_gboth_sdfull_pc/B.n270 VSUBS 0.00433f ; **FLOATING
C233 pfet_01v8_lvt_W1_L20_m2__nf1_gboth_sdfull_pc/B.n271 VSUBS 0.00433f ; **FLOATING
C234 pfet_01v8_lvt_W1_L20_m2__nf1_gboth_sdfull_pc/B.n273 VSUBS 0.00433f ; **FLOATING
C235 pfet_01v8_lvt_W1_L20_m2__nf1_gboth_sdfull_pc/B.n274 VSUBS 0.00433f ; **FLOATING
C236 pfet_01v8_lvt_W1_L20_m2__nf1_gboth_sdfull_pc/B.n275 VSUBS 0.00843f ; **FLOATING
C237 pfet_01v8_lvt_W1_L20_m2__nf1_gboth_sdfull_pc/B.n276 VSUBS 0.00858f ; **FLOATING
C238 pfet_01v8_lvt_W1_L20_m2__nf1_gboth_sdfull_pc/B.n277 VSUBS 0.00858f ; **FLOATING
C239 pfet_01v8_lvt_W1_L20_m2__nf1_gboth_sdfull_pc/B.n278 VSUBS 0.67474f ; **FLOATING
C240 pfet_01v8_lvt_W1_L20_m2__nf1_gboth_sdfull_pc/B.n279 VSUBS 0.00858f ; **FLOATING
C241 pfet_01v8_lvt_W1_L20_m2__nf1_gboth_sdfull_pc/B.n280 VSUBS 0.00843f ; **FLOATING
C242 pfet_01v8_lvt_W1_L20_m2__nf1_gboth_sdfull_pc/B.n281 VSUBS 0.00843f ; **FLOATING
C243 pfet_01v8_lvt_W1_L20_m2__nf1_gboth_sdfull_pc/B.n282 VSUBS 0.00433f ; **FLOATING
C244 pfet_01v8_lvt_W1_L20_m2__nf1_gboth_sdfull_pc/B.n283 VSUBS 0.00433f ; **FLOATING
C245 pfet_01v8_lvt_W1_L20_m2__nf1_gboth_sdfull_pc/B.n284 VSUBS 0.00433f ; **FLOATING
C246 pfet_01v8_lvt_W1_L20_m2__nf1_gboth_sdfull_pc/B.n286 VSUBS 0.00433f ; **FLOATING
C247 pfet_01v8_lvt_W1_L20_m2__nf1_gboth_sdfull_pc/B.n287 VSUBS 0.00433f ; **FLOATING
C248 pfet_01v8_lvt_W1_L20_m2__nf1_gboth_sdfull_pc/B.n288 VSUBS 0.00433f ; **FLOATING
C249 pfet_01v8_lvt_W1_L20_m2__nf1_gboth_sdfull_pc/B.n289 VSUBS 0.00433f ; **FLOATING
C250 pfet_01v8_lvt_W1_L20_m2__nf1_gboth_sdfull_pc/B.n290 VSUBS 0.00433f ; **FLOATING
C251 pfet_01v8_lvt_W1_L20_m2__nf1_gboth_sdfull_pc/B.n291 VSUBS 0.00433f ; **FLOATING
C252 pfet_01v8_lvt_W1_L20_m2__nf1_gboth_sdfull_pc/B.n293 VSUBS 0.00433f ; **FLOATING
C253 pfet_01v8_lvt_W1_L20_m2__nf1_gboth_sdfull_pc/B.n294 VSUBS 0.00433f ; **FLOATING
C254 pfet_01v8_lvt_W1_L20_m2__nf1_gboth_sdfull_pc/B.n295 VSUBS 0.00433f ; **FLOATING
C255 pfet_01v8_lvt_W1_L20_m2__nf1_gboth_sdfull_pc/B.n296 VSUBS 0.00433f ; **FLOATING
C256 pfet_01v8_lvt_W1_L20_m2__nf1_gboth_sdfull_pc/B.n297 VSUBS 0.00433f ; **FLOATING
C257 pfet_01v8_lvt_W1_L20_m2__nf1_gboth_sdfull_pc/B.n298 VSUBS 0.00433f ; **FLOATING
C258 pfet_01v8_lvt_W1_L20_m2__nf1_gboth_sdfull_pc/B.n300 VSUBS 0.00433f ; **FLOATING
C259 pfet_01v8_lvt_W1_L20_m2__nf1_gboth_sdfull_pc/B.n301 VSUBS 0.00433f ; **FLOATING
C260 pfet_01v8_lvt_W1_L20_m2__nf1_gboth_sdfull_pc/B.n302 VSUBS 0.00433f ; **FLOATING
C261 pfet_01v8_lvt_W1_L20_m2__nf1_gboth_sdfull_pc/B.n303 VSUBS 0.00433f ; **FLOATING
C262 pfet_01v8_lvt_W1_L20_m2__nf1_gboth_sdfull_pc/B.n304 VSUBS 0.00433f ; **FLOATING
C263 pfet_01v8_lvt_W1_L20_m2__nf1_gboth_sdfull_pc/B.n305 VSUBS 0.00433f ; **FLOATING
C264 pfet_01v8_lvt_W1_L20_m2__nf1_gboth_sdfull_pc/B.n307 VSUBS 0.00433f ; **FLOATING
C265 pfet_01v8_lvt_W1_L20_m2__nf1_gboth_sdfull_pc/B.n308 VSUBS 0.00433f ; **FLOATING
C266 pfet_01v8_lvt_W1_L20_m2__nf1_gboth_sdfull_pc/B.n309 VSUBS 0.00433f ; **FLOATING
C267 pfet_01v8_lvt_W1_L20_m2__nf1_gboth_sdfull_pc/B.n310 VSUBS 0.00433f ; **FLOATING
C268 pfet_01v8_lvt_W1_L20_m2__nf1_gboth_sdfull_pc/B.n311 VSUBS 0.00433f ; **FLOATING
C269 pfet_01v8_lvt_W1_L20_m2__nf1_gboth_sdfull_pc/B.n312 VSUBS 0.00433f ; **FLOATING
C270 pfet_01v8_lvt_W1_L20_m2__nf1_gboth_sdfull_pc/B.n314 VSUBS 0.00433f ; **FLOATING
C271 pfet_01v8_lvt_W1_L20_m2__nf1_gboth_sdfull_pc/B.n315 VSUBS 0.00433f ; **FLOATING
C272 pfet_01v8_lvt_W1_L20_m2__nf1_gboth_sdfull_pc/B.n316 VSUBS 0.00433f ; **FLOATING
C273 pfet_01v8_lvt_W1_L20_m2__nf1_gboth_sdfull_pc/B.n317 VSUBS 0.00433f ; **FLOATING
C274 pfet_01v8_lvt_W1_L20_m2__nf1_gboth_sdfull_pc/B.n318 VSUBS 0.00433f ; **FLOATING
C275 pfet_01v8_lvt_W1_L20_m2__nf1_gboth_sdfull_pc/B.n319 VSUBS 0.00433f ; **FLOATING
C276 pfet_01v8_lvt_W1_L20_m2__nf1_gboth_sdfull_pc/B.n321 VSUBS 0.00433f ; **FLOATING
C277 pfet_01v8_lvt_W1_L20_m2__nf1_gboth_sdfull_pc/B.n322 VSUBS 0.00433f ; **FLOATING
C278 pfet_01v8_lvt_W1_L20_m2__nf1_gboth_sdfull_pc/B.n323 VSUBS 0.00433f ; **FLOATING
C279 pfet_01v8_lvt_W1_L20_m2__nf1_gboth_sdfull_pc/B.n324 VSUBS 0.00433f ; **FLOATING
C280 pfet_01v8_lvt_W1_L20_m2__nf1_gboth_sdfull_pc/B.n325 VSUBS 0.00433f ; **FLOATING
C281 pfet_01v8_lvt_W1_L20_m2__nf1_gboth_sdfull_pc/B.n326 VSUBS 0.00433f ; **FLOATING
C282 pfet_01v8_lvt_W1_L20_m2__nf1_gboth_sdfull_pc/B.n328 VSUBS 0.00433f ; **FLOATING
C283 pfet_01v8_lvt_W1_L20_m2__nf1_gboth_sdfull_pc/B.n329 VSUBS 0.00433f ; **FLOATING
C284 pfet_01v8_lvt_W1_L20_m2__nf1_gboth_sdfull_pc/B.n331 VSUBS 0.00433f ; **FLOATING
C285 pfet_01v8_lvt_W1_L20_m2__nf1_gboth_sdfull_pc/B.n332 VSUBS 0.00379f ; **FLOATING
