* NGSPICE file created from pfet_01v8_lvt_W6_L1_m2__nf4_gboth_sdfull_outS.ext - technology: sky130A

.subckt sky130_fd_pr__pfet_01v8_lvt_7FTUU3 G B D2 D0 a_487_n150# S3 S1
X0 S1 G D0 B sky130_fd_pr__pfet_01v8_lvt ad=0.2175 pd=1.79 as=0.435 ps=3.58 w=1.5 l=1
X1 a_487_n150# G S3 B sky130_fd_pr__pfet_01v8_lvt ad=0.435 pd=3.58 as=0.2175 ps=1.79 w=1.5 l=1
X2 D2 G S1 B sky130_fd_pr__pfet_01v8_lvt ad=0.2175 pd=1.79 as=0.2175 ps=1.79 w=1.5 l=1
X3 S3 G D2 B sky130_fd_pr__pfet_01v8_lvt ad=0.2175 pd=1.79 as=0.2175 ps=1.79 w=1.5 l=1
.ends

.subckt pfet_01v8_lvt_W6_L1_m2__nf4_gboth_sdfull_outS S D G B
Xpfet_01v8_lvt_W6_L1_m2__nf4_gboth_sdfull_outS_pc G B S S S D D sky130_fd_pr__pfet_01v8_lvt_7FTUU3
.ends
