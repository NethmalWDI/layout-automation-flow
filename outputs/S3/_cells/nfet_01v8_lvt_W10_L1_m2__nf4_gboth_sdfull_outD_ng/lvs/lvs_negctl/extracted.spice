* NGSPICE file created from nfet_01v8_lvt_W10_L1_m2__nf4_gboth_sdfull_outD_ng.ext - technology: sky130A

.subckt sky130_fd_pr__nfet_01v8_lvt_AYDLZ3 G D2 a_487_n250# D0 S3 S1 VSUBS
X0 a_487_n250# G S3 VSUBS sky130_fd_pr__nfet_01v8_lvt ad=0.725 pd=5.58 as=0.3625 ps=2.79 w=2.5 l=1
X1 S3 G D2 VSUBS sky130_fd_pr__nfet_01v8_lvt ad=0.3625 pd=2.79 as=0.3625 ps=2.79 w=2.5 l=1
X2 D2 G S1 VSUBS sky130_fd_pr__nfet_01v8_lvt ad=0.3625 pd=2.79 as=0.3625 ps=2.79 w=2.5 l=1
X3 S1 G D0 VSUBS sky130_fd_pr__nfet_01v8_lvt ad=0.3625 pd=2.79 as=0.725 ps=5.58 w=2.5 l=1
.ends

.subckt nfet_01v8_lvt_W10_L1_m2__nf4_gboth_sdfull_outD_ng S D G B
Xnfet_01v8_lvt_W10_L1_m2__nf4_gboth_sdfull_outD_ng_pc G D D D S S B sky130_fd_pr__nfet_01v8_lvt_AYDLZ3
.ends
