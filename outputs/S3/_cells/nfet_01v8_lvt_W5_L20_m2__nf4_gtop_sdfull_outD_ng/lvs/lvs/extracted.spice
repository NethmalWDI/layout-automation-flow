* NGSPICE file created from nfet_01v8_lvt_W5_L20_m2__nf4_gtop_sdfull_outD_ng.ext - technology: sky130A

.subckt sky130_fd_pr__nfet_01v8_lvt_PRYHRV G D2 D0 a_8087_n156# S3 S1 VSUBS
X0 D2 G S1 VSUBS sky130_fd_pr__nfet_01v8_lvt ad=0.18125 pd=1.54 as=0.18125 ps=1.54 w=1.25 l=20
X1 S3 G D2 VSUBS sky130_fd_pr__nfet_01v8_lvt ad=0.18125 pd=1.54 as=0.18125 ps=1.54 w=1.25 l=20
X2 S1 G D0 VSUBS sky130_fd_pr__nfet_01v8_lvt ad=0.18125 pd=1.54 as=0.3625 ps=3.08 w=1.25 l=20
X3 a_8087_n156# G S3 VSUBS sky130_fd_pr__nfet_01v8_lvt ad=0.3625 pd=3.08 as=0.18125 ps=1.54 w=1.25 l=20
.ends

.subckt nfet_01v8_lvt_W5_L20_m2__nf4_gtop_sdfull_outD_ng S D G B
Xnfet_01v8_lvt_W5_L20_m2__nf4_gtop_sdfull_outD_ng_pc G D D D S S B sky130_fd_pr__nfet_01v8_lvt_PRYHRV
.ends
