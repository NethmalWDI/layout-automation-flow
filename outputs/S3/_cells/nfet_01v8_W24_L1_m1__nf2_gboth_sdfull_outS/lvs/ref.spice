.subckt nfet_01v8_W24_L1_m1__nf2_gboth_sdfull_outS D G S B
Xnfet_01v8_W24_L1_m1__nf2_gboth_sdfull_outS D G S B sky130_fd_pr__nfet_01v8 L=1 W=24 nf=2
.ends
