* NGSPICE file created from pfet_01v8_lvt_W887p03_L0p74_m1__nf2_gtop_sdfull_outD_ng.ext - technology: sky130A

.subckt pfet_01v8_lvt_W887p03_L0p74_m1__nf2_gtop_sdfull_outD_ng S D G B
X0 S G D B sky130_fd_pr__pfet_01v8_lvt ad=64.3104 pd=443.81 as=128.6208 ps=887.62 w=443.51999 l=0.74
X1 D G S B sky130_fd_pr__pfet_01v8_lvt ad=128.6208 pd=887.62 as=64.3104 ps=443.81 w=443.51999 l=0.74
C0 D G 40.86095f
C1 S G 40.91519f
C2 D B 15.48957f
C3 S B 9.59615f
C4 G B 0.21718f
C5 S D 33.17421f
C6 S VSUBS 0.10598f
C7 D VSUBS 62.37947f
C8 G VSUBS 0.38287f
C9 B VSUBS 0.13926p
.ends
