.subckt nfet_01v8_lvt_W10_L1_m2__nf1_gtop_sdfull D G S B
Xnfet_01v8_lvt_W10_L1_m2__nf1_gtop_sdfull D G S B sky130_fd_pr__nfet_01v8_lvt L=1 W=10 nf=1
.ends
