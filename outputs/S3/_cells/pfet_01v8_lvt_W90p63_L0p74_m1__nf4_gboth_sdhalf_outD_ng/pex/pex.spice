* NGSPICE file created from pfet_01v8_lvt_W90p63_L0p74_m1__nf4_gboth_sdhalf_outD_ng.ext - technology: sky130A

.subckt pfet_01v8_lvt_W90p63_L0p74_m1__nf4_gboth_sdhalf_outD_ng S D G B
X0 D G S B sky130_fd_pr__pfet_01v8_lvt ad=6.5714 pd=45.9 as=3.2857 ps=22.95 w=22.66 l=0.74
X1 S G D B sky130_fd_pr__pfet_01v8_lvt ad=3.2857 pd=22.95 as=6.5714 ps=45.9 w=22.66 l=0.74
X2 S G D B sky130_fd_pr__pfet_01v8_lvt ad=3.2857 pd=22.95 as=3.2857 ps=22.95 w=22.66 l=0.74
X3 D G S B sky130_fd_pr__pfet_01v8_lvt ad=3.2857 pd=22.95 as=3.2857 ps=22.95 w=22.66 l=0.74
C0 D S 1.99241f
C1 B S 0.50876f
C2 G S 2.40332f
C3 B D 0.66105f
C4 D G 2.40329f
C5 B G 0.63976f
C6 S VSUBS 0.07755f
C7 D VSUBS 1.6743f
C8 G VSUBS 1.14051f
C9 B VSUBS 9.5362f
.ends
