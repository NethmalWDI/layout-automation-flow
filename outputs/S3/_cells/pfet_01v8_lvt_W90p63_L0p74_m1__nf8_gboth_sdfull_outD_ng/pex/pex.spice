* NGSPICE file created from pfet_01v8_lvt_W90p63_L0p74_m1__nf8_gboth_sdfull_outD_ng.ext - technology: sky130A

.subckt pfet_01v8_lvt_W90p63_L0p74_m1__nf8_gboth_sdfull_outD_ng S D G B
X0 S G D B sky130_fd_pr__pfet_01v8_lvt ad=1.64285 pd=11.62 as=1.64285 ps=11.62 w=11.33 l=0.74
X1 D G S B sky130_fd_pr__pfet_01v8_lvt ad=3.2857 pd=23.24 as=1.64285 ps=11.62 w=11.33 l=0.74
X2 D G S B sky130_fd_pr__pfet_01v8_lvt ad=1.64285 pd=11.62 as=1.64285 ps=11.62 w=11.33 l=0.74
X3 D G S B sky130_fd_pr__pfet_01v8_lvt ad=1.64285 pd=11.62 as=1.64285 ps=11.62 w=11.33 l=0.74
X4 S G D B sky130_fd_pr__pfet_01v8_lvt ad=1.64285 pd=11.62 as=3.2857 ps=23.24 w=11.33 l=0.74
X5 D G S B sky130_fd_pr__pfet_01v8_lvt ad=1.64285 pd=11.62 as=1.64285 ps=11.62 w=11.33 l=0.74
X6 S G D B sky130_fd_pr__pfet_01v8_lvt ad=1.64285 pd=11.62 as=1.64285 ps=11.62 w=11.33 l=0.74
X7 S G D B sky130_fd_pr__pfet_01v8_lvt ad=1.64285 pd=11.62 as=1.64285 ps=11.62 w=11.33 l=0.74
C0 S D 3.85483f
C1 B G 1.25407f
C2 B S 1.03341f
C3 S G 4.85693f
C4 B D 1.19205f
C5 D G 4.84687f
C6 S VSUBS 0.32094f
C7 D VSUBS 1.93074f
C8 G VSUBS 2.16994f
C9 B VSUBS 13.1536f
.ends
