* NGSPICE file created from nfet_01v8_lvt_W10_L1_m2__nf4_gboth_sdhalf_outD.ext - technology: sky130A

.subckt sky130_fd_pr__nfet_01v8_lvt_Z9KLN2 G B D2 a_487_n250# D0 S3 S1
X0 a_487_n250# G S3 B sky130_fd_pr__nfet_01v8_lvt ad=0.725 pd=5.58 as=0.3625 ps=2.79 w=2.5 l=1
X1 S3 G D2 B sky130_fd_pr__nfet_01v8_lvt ad=0.3625 pd=2.79 as=0.3625 ps=2.79 w=2.5 l=1
X2 D2 G S1 B sky130_fd_pr__nfet_01v8_lvt ad=0.3625 pd=2.79 as=0.3625 ps=2.79 w=2.5 l=1
X3 S1 G D0 B sky130_fd_pr__nfet_01v8_lvt ad=0.3625 pd=2.79 as=0.725 ps=5.58 w=2.5 l=1
.ends

.subckt nfet_01v8_lvt_W10_L1_m2__nf4_gboth_sdhalf_outD S D G B
Xnfet_01v8_lvt_W10_L1_m2__nf4_gboth_sdhalf_outD_pc G B D D D S S sky130_fd_pr__nfet_01v8_lvt_Z9KLN2
.ends
