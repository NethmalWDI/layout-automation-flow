* NGSPICE file created from pfet_01v8_lvt_W887p03_L0p74_m1__nf64_gboth_sdfull_outD.ext - technology: sky130A

.subckt pfet_01v8_lvt_W887p03_L0p74_m1__nf64_gboth_sdfull_outD S D G B
X0 S G D B sky130_fd_pr__pfet_01v8_lvt ad=2.0097 pd=14.15 as=4.0194 ps=28.3 w=13.86 l=0.74
X1 D G S B sky130_fd_pr__pfet_01v8_lvt ad=2.0097 pd=14.15 as=2.0097 ps=14.15 w=13.86 l=0.74
X2 S G D B sky130_fd_pr__pfet_01v8_lvt ad=2.0097 pd=14.15 as=2.0097 ps=14.15 w=13.86 l=0.74
X3 D G S B sky130_fd_pr__pfet_01v8_lvt ad=2.0097 pd=14.15 as=2.0097 ps=14.15 w=13.86 l=0.74
X4 S G D B sky130_fd_pr__pfet_01v8_lvt ad=2.0097 pd=14.15 as=2.0097 ps=14.15 w=13.86 l=0.74
X5 D G S B sky130_fd_pr__pfet_01v8_lvt ad=2.0097 pd=14.15 as=2.0097 ps=14.15 w=13.86 l=0.74
X6 S G D B sky130_fd_pr__pfet_01v8_lvt ad=2.0097 pd=14.15 as=2.0097 ps=14.15 w=13.86 l=0.74
X7 S G D B sky130_fd_pr__pfet_01v8_lvt ad=2.0097 pd=14.15 as=2.0097 ps=14.15 w=13.86 l=0.74
X8 S G D B sky130_fd_pr__pfet_01v8_lvt ad=2.0097 pd=14.15 as=2.0097 ps=14.15 w=13.86 l=0.74
X9 D G S B sky130_fd_pr__pfet_01v8_lvt ad=2.0097 pd=14.15 as=2.0097 ps=14.15 w=13.86 l=0.74
X10 D G S B sky130_fd_pr__pfet_01v8_lvt ad=2.0097 pd=14.15 as=2.0097 ps=14.15 w=13.86 l=0.74
X11 D G S B sky130_fd_pr__pfet_01v8_lvt ad=2.0097 pd=14.15 as=2.0097 ps=14.15 w=13.86 l=0.74
X12 D G S B sky130_fd_pr__pfet_01v8_lvt ad=4.0194 pd=28.3 as=2.0097 ps=14.15 w=13.86 l=0.74
X13 S G D B sky130_fd_pr__pfet_01v8_lvt ad=2.0097 pd=14.15 as=2.0097 ps=14.15 w=13.86 l=0.74
X14 S G D B sky130_fd_pr__pfet_01v8_lvt ad=2.0097 pd=14.15 as=2.0097 ps=14.15 w=13.86 l=0.74
X15 D G S B sky130_fd_pr__pfet_01v8_lvt ad=2.0097 pd=14.15 as=2.0097 ps=14.15 w=13.86 l=0.74
X16 S G D B sky130_fd_pr__pfet_01v8_lvt ad=2.0097 pd=14.15 as=2.0097 ps=14.15 w=13.86 l=0.74
X17 D G S B sky130_fd_pr__pfet_01v8_lvt ad=2.0097 pd=14.15 as=2.0097 ps=14.15 w=13.86 l=0.74
X18 D G S B sky130_fd_pr__pfet_01v8_lvt ad=2.0097 pd=14.15 as=2.0097 ps=14.15 w=13.86 l=0.74
X19 D G S B sky130_fd_pr__pfet_01v8_lvt ad=2.0097 pd=14.15 as=2.0097 ps=14.15 w=13.86 l=0.74
X20 S G D B sky130_fd_pr__pfet_01v8_lvt ad=2.0097 pd=14.15 as=2.0097 ps=14.15 w=13.86 l=0.74
X21 S G D B sky130_fd_pr__pfet_01v8_lvt ad=2.0097 pd=14.15 as=2.0097 ps=14.15 w=13.86 l=0.74
X22 D G S B sky130_fd_pr__pfet_01v8_lvt ad=2.0097 pd=14.15 as=2.0097 ps=14.15 w=13.86 l=0.74
X23 S G D B sky130_fd_pr__pfet_01v8_lvt ad=2.0097 pd=14.15 as=2.0097 ps=14.15 w=13.86 l=0.74
X24 D G S B sky130_fd_pr__pfet_01v8_lvt ad=2.0097 pd=14.15 as=2.0097 ps=14.15 w=13.86 l=0.74
X25 S G D B sky130_fd_pr__pfet_01v8_lvt ad=2.0097 pd=14.15 as=2.0097 ps=14.15 w=13.86 l=0.74
X26 S G D B sky130_fd_pr__pfet_01v8_lvt ad=2.0097 pd=14.15 as=2.0097 ps=14.15 w=13.86 l=0.74
X27 S G D B sky130_fd_pr__pfet_01v8_lvt ad=2.0097 pd=14.15 as=2.0097 ps=14.15 w=13.86 l=0.74
X28 D G S B sky130_fd_pr__pfet_01v8_lvt ad=2.0097 pd=14.15 as=2.0097 ps=14.15 w=13.86 l=0.74
X29 D G S B sky130_fd_pr__pfet_01v8_lvt ad=2.0097 pd=14.15 as=2.0097 ps=14.15 w=13.86 l=0.74
X30 S G D B sky130_fd_pr__pfet_01v8_lvt ad=2.0097 pd=14.15 as=2.0097 ps=14.15 w=13.86 l=0.74
X31 D G S B sky130_fd_pr__pfet_01v8_lvt ad=2.0097 pd=14.15 as=2.0097 ps=14.15 w=13.86 l=0.74
X32 D G S B sky130_fd_pr__pfet_01v8_lvt ad=2.0097 pd=14.15 as=2.0097 ps=14.15 w=13.86 l=0.74
X33 S G D B sky130_fd_pr__pfet_01v8_lvt ad=2.0097 pd=14.15 as=2.0097 ps=14.15 w=13.86 l=0.74
X34 D G S B sky130_fd_pr__pfet_01v8_lvt ad=2.0097 pd=14.15 as=2.0097 ps=14.15 w=13.86 l=0.74
X35 S G D B sky130_fd_pr__pfet_01v8_lvt ad=2.0097 pd=14.15 as=2.0097 ps=14.15 w=13.86 l=0.74
X36 S G D B sky130_fd_pr__pfet_01v8_lvt ad=2.0097 pd=14.15 as=2.0097 ps=14.15 w=13.86 l=0.74
X37 S G D B sky130_fd_pr__pfet_01v8_lvt ad=2.0097 pd=14.15 as=2.0097 ps=14.15 w=13.86 l=0.74
X38 D G S B sky130_fd_pr__pfet_01v8_lvt ad=2.0097 pd=14.15 as=2.0097 ps=14.15 w=13.86 l=0.74
X39 D G S B sky130_fd_pr__pfet_01v8_lvt ad=2.0097 pd=14.15 as=2.0097 ps=14.15 w=13.86 l=0.74
X40 S G D B sky130_fd_pr__pfet_01v8_lvt ad=2.0097 pd=14.15 as=2.0097 ps=14.15 w=13.86 l=0.74
X41 D G S B sky130_fd_pr__pfet_01v8_lvt ad=2.0097 pd=14.15 as=2.0097 ps=14.15 w=13.86 l=0.74
X42 S G D B sky130_fd_pr__pfet_01v8_lvt ad=2.0097 pd=14.15 as=2.0097 ps=14.15 w=13.86 l=0.74
X43 S G D B sky130_fd_pr__pfet_01v8_lvt ad=2.0097 pd=14.15 as=2.0097 ps=14.15 w=13.86 l=0.74
X44 D G S B sky130_fd_pr__pfet_01v8_lvt ad=2.0097 pd=14.15 as=2.0097 ps=14.15 w=13.86 l=0.74
X45 S G D B sky130_fd_pr__pfet_01v8_lvt ad=2.0097 pd=14.15 as=2.0097 ps=14.15 w=13.86 l=0.74
X46 D G S B sky130_fd_pr__pfet_01v8_lvt ad=2.0097 pd=14.15 as=2.0097 ps=14.15 w=13.86 l=0.74
X47 D G S B sky130_fd_pr__pfet_01v8_lvt ad=2.0097 pd=14.15 as=2.0097 ps=14.15 w=13.86 l=0.74
X48 S G D B sky130_fd_pr__pfet_01v8_lvt ad=2.0097 pd=14.15 as=2.0097 ps=14.15 w=13.86 l=0.74
X49 S G D B sky130_fd_pr__pfet_01v8_lvt ad=2.0097 pd=14.15 as=2.0097 ps=14.15 w=13.86 l=0.74
X50 D G S B sky130_fd_pr__pfet_01v8_lvt ad=2.0097 pd=14.15 as=2.0097 ps=14.15 w=13.86 l=0.74
X51 S G D B sky130_fd_pr__pfet_01v8_lvt ad=2.0097 pd=14.15 as=2.0097 ps=14.15 w=13.86 l=0.74
X52 D G S B sky130_fd_pr__pfet_01v8_lvt ad=2.0097 pd=14.15 as=2.0097 ps=14.15 w=13.86 l=0.74
X53 D G S B sky130_fd_pr__pfet_01v8_lvt ad=2.0097 pd=14.15 as=2.0097 ps=14.15 w=13.86 l=0.74
X54 D G S B sky130_fd_pr__pfet_01v8_lvt ad=2.0097 pd=14.15 as=2.0097 ps=14.15 w=13.86 l=0.74
X55 S G D B sky130_fd_pr__pfet_01v8_lvt ad=2.0097 pd=14.15 as=2.0097 ps=14.15 w=13.86 l=0.74
X56 D G S B sky130_fd_pr__pfet_01v8_lvt ad=2.0097 pd=14.15 as=2.0097 ps=14.15 w=13.86 l=0.74
X57 S G D B sky130_fd_pr__pfet_01v8_lvt ad=2.0097 pd=14.15 as=2.0097 ps=14.15 w=13.86 l=0.74
X58 D G S B sky130_fd_pr__pfet_01v8_lvt ad=2.0097 pd=14.15 as=2.0097 ps=14.15 w=13.86 l=0.74
X59 D G S B sky130_fd_pr__pfet_01v8_lvt ad=2.0097 pd=14.15 as=2.0097 ps=14.15 w=13.86 l=0.74
X60 S G D B sky130_fd_pr__pfet_01v8_lvt ad=2.0097 pd=14.15 as=2.0097 ps=14.15 w=13.86 l=0.74
X61 S G D B sky130_fd_pr__pfet_01v8_lvt ad=2.0097 pd=14.15 as=2.0097 ps=14.15 w=13.86 l=0.74
X62 D G S B sky130_fd_pr__pfet_01v8_lvt ad=2.0097 pd=14.15 as=2.0097 ps=14.15 w=13.86 l=0.74
X63 S G D B sky130_fd_pr__pfet_01v8_lvt ad=2.0097 pd=14.15 as=2.0097 ps=14.15 w=13.86 l=0.74
C0 D B 11.23701f
C1 D G 46.2165f
C2 S B 9.89763f
C3 S G 46.29702f
C4 S D 36.66219f
C5 G B 19.56801f
C6 S VSUBS 2.02064f
C7 D VSUBS 2.76177f
C8 G VSUBS 7.39832f
C9 B VSUBS 0.13618p
.ends
