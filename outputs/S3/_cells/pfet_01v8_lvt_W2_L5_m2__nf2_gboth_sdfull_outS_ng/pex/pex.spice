* NGSPICE file created from pfet_01v8_lvt_W2_L5_m2__nf2_gboth_sdfull_outS_ng.ext - technology: sky130A

.subckt pfet_01v8_lvt_W2_L5_m2__nf2_gboth_sdfull_outS_ng S D G B
X0 S G D B sky130_fd_pr__pfet_01v8_lvt ad=0.29 pd=2.58 as=0.145 ps=1.29 w=1 l=5
X1 D G S B sky130_fd_pr__pfet_01v8_lvt ad=0.145 pd=1.29 as=0.29 ps=2.58 w=1 l=5
C0 B G 1.52703f
C1 D G 0.71418f
C2 D B 0.08059f
C3 S G 0.71666f
C4 S B 0.10078f
C5 S D 0.63592f
C6 D VSUBS 0.3787f
C7 S VSUBS 0.55293f
C8 G VSUBS 2.77068f
C9 B VSUBS 2.6952f
.ends
