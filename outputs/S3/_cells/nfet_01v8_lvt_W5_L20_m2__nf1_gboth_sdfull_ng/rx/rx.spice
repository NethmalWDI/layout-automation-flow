* NGSPICE file created from nfet_01v8_lvt_W5_L20_m2__nf1_gboth_sdfull_ng.ext - technology: sky130A

X0 nfet_01v8_lvt_W5_L20_m2__nf1_gboth_sdfull_ng_pc/S.t0 G nfet_01v8_lvt_W5_L20_m2__nf1_gboth_sdfull_ng_pc/D.t0 B sky130_fd_pr__nfet_01v8_lvt ad=1.45 pd=10.58 as=1.45 ps=10.58 w=5 l=20
C0 G S 0.44075f
C1 D G 0.44075f
R0 nfet_01v8_lvt_W5_L20_m2__nf1_gboth_sdfull_ng_pc/S.t0 nfet_01v8_lvt_W5_L20_m2__nf1_gboth_sdfull_ng_pc/S.n0 174.857
R1 nfet_01v8_lvt_W5_L20_m2__nf1_gboth_sdfull_ng_pc/S.n1 nfet_01v8_lvt_W5_L20_m2__nf1_gboth_sdfull_ng_pc/S.t0 174.857
R2 S nfet_01v8_lvt_W5_L20_m2__nf1_gboth_sdfull_ng_pc/S.n0 15.6333
R3 S nfet_01v8_lvt_W5_L20_m2__nf1_gboth_sdfull_ng_pc/S.n1 15.6333
R4 nfet_01v8_lvt_W5_L20_m2__nf1_gboth_sdfull_ng_pc/S.n1 S 5.29315
R5 S nfet_01v8_lvt_W5_L20_m2__nf1_gboth_sdfull_ng_pc/S.n0 5.18989
R6 nfet_01v8_lvt_W5_L20_m2__nf1_gboth_sdfull_ng_pc/D.t0 nfet_01v8_lvt_W5_L20_m2__nf1_gboth_sdfull_ng_pc/D.n0 174.857
R7 nfet_01v8_lvt_W5_L20_m2__nf1_gboth_sdfull_ng_pc/D.n1 nfet_01v8_lvt_W5_L20_m2__nf1_gboth_sdfull_ng_pc/D.t0 174.857
R8 D nfet_01v8_lvt_W5_L20_m2__nf1_gboth_sdfull_ng_pc/D.n0 15.6333
R9 D nfet_01v8_lvt_W5_L20_m2__nf1_gboth_sdfull_ng_pc/D.n1 15.6333
R10 nfet_01v8_lvt_W5_L20_m2__nf1_gboth_sdfull_ng_pc/D.n1 D 5.29315
R11 D nfet_01v8_lvt_W5_L20_m2__nf1_gboth_sdfull_ng_pc/D.n0 5.18989
C2 S B 0.96852f
C3 D B 0.96852f
C4 G B 8.32004f
C5 nfet_01v8_lvt_W5_L20_m2__nf1_gboth_sdfull_ng_pc/D.n0 B 0.02265f ; **FLOATING
C6 nfet_01v8_lvt_W5_L20_m2__nf1_gboth_sdfull_ng_pc/D.t0 B 0.0298f ; **FLOATING
C7 nfet_01v8_lvt_W5_L20_m2__nf1_gboth_sdfull_ng_pc/D.n1 B 0.02616f ; **FLOATING
C8 nfet_01v8_lvt_W5_L20_m2__nf1_gboth_sdfull_ng_pc/S.n0 B 0.02265f ; **FLOATING
C9 nfet_01v8_lvt_W5_L20_m2__nf1_gboth_sdfull_ng_pc/S.t0 B 0.0298f ; **FLOATING
C10 nfet_01v8_lvt_W5_L20_m2__nf1_gboth_sdfull_ng_pc/S.n1 B 0.02616f ; **FLOATING
