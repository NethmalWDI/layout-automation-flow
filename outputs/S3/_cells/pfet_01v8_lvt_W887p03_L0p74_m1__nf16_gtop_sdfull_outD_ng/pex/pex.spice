* NGSPICE file created from pfet_01v8_lvt_W887p03_L0p74_m1__nf16_gtop_sdfull_outD_ng.ext - technology: sky130A

.subckt pfet_01v8_lvt_W887p03_L0p74_m1__nf16_gtop_sdfull_outD_ng S D G B
X0 D G S B sky130_fd_pr__pfet_01v8_lvt ad=16.0776 pd=111.46 as=8.0388 ps=55.73 w=55.44 l=0.74
X1 D G S B sky130_fd_pr__pfet_01v8_lvt ad=8.0388 pd=55.73 as=8.0388 ps=55.73 w=55.44 l=0.74
X2 S G D B sky130_fd_pr__pfet_01v8_lvt ad=8.0388 pd=55.73 as=8.0388 ps=55.73 w=55.44 l=0.74
X3 D G S B sky130_fd_pr__pfet_01v8_lvt ad=8.0388 pd=55.73 as=8.0388 ps=55.73 w=55.44 l=0.74
X4 S G D B sky130_fd_pr__pfet_01v8_lvt ad=8.0388 pd=55.73 as=16.0776 ps=111.46 w=55.44 l=0.74
X5 S G D B sky130_fd_pr__pfet_01v8_lvt ad=8.0388 pd=55.73 as=8.0388 ps=55.73 w=55.44 l=0.74
X6 D G S B sky130_fd_pr__pfet_01v8_lvt ad=8.0388 pd=55.73 as=8.0388 ps=55.73 w=55.44 l=0.74
X7 S G D B sky130_fd_pr__pfet_01v8_lvt ad=8.0388 pd=55.73 as=8.0388 ps=55.73 w=55.44 l=0.74
X8 D G S B sky130_fd_pr__pfet_01v8_lvt ad=8.0388 pd=55.73 as=8.0388 ps=55.73 w=55.44 l=0.74
X9 S G D B sky130_fd_pr__pfet_01v8_lvt ad=8.0388 pd=55.73 as=8.0388 ps=55.73 w=55.44 l=0.74
X10 S G D B sky130_fd_pr__pfet_01v8_lvt ad=8.0388 pd=55.73 as=8.0388 ps=55.73 w=55.44 l=0.74
X11 D G S B sky130_fd_pr__pfet_01v8_lvt ad=8.0388 pd=55.73 as=8.0388 ps=55.73 w=55.44 l=0.74
X12 S G D B sky130_fd_pr__pfet_01v8_lvt ad=8.0388 pd=55.73 as=8.0388 ps=55.73 w=55.44 l=0.74
X13 S G D B sky130_fd_pr__pfet_01v8_lvt ad=8.0388 pd=55.73 as=8.0388 ps=55.73 w=55.44 l=0.74
X14 D G S B sky130_fd_pr__pfet_01v8_lvt ad=8.0388 pd=55.73 as=8.0388 ps=55.73 w=55.44 l=0.74
X15 D G S B sky130_fd_pr__pfet_01v8_lvt ad=8.0388 pd=55.73 as=8.0388 ps=55.73 w=55.44 l=0.74
C0 B S 9.63688f
C1 G S 41.95538f
C2 B D 10.39578f
C3 G D 41.52066f
C4 B G 1.63867f
C5 D S 33.96131f
C6 S VSUBS 0.60754f
C7 D VSUBS 8.20098f
C8 G VSUBS 2.62551f
C9 B VSUBS 78.4066f
.ends
