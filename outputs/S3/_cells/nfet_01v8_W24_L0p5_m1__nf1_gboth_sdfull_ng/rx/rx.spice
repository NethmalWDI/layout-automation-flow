* NGSPICE file created from nfet_01v8_W24_L0p5_m1__nf1_gboth_sdfull_ng.ext - technology: sky130A

X0 nfet_01v8_W24_L0p5_m1__nf1_gboth_sdfull_ng_pc/S.t0 nfet_01v8_W24_L0p5_m1__nf1_gboth_sdfull_ng_pc/G.t0 nfet_01v8_W24_L0p5_m1__nf1_gboth_sdfull_ng_pc/D.t0 B sky130_fd_pr__nfet_01v8 ad=6.96 pd=48.58 as=6.96 ps=48.58 w=24 l=0.5
C0 S D 1.1665f
C1 S G 0.85255f
C2 D G 0.85255f
R0 nfet_01v8_W24_L0p5_m1__nf1_gboth_sdfull_ng_pc/S.t0 nfet_01v8_W24_L0p5_m1__nf1_gboth_sdfull_ng_pc/S.n0 174.852
R1 nfet_01v8_W24_L0p5_m1__nf1_gboth_sdfull_ng_pc/S.n1 nfet_01v8_W24_L0p5_m1__nf1_gboth_sdfull_ng_pc/S.t0 174.852
R2 S nfet_01v8_W24_L0p5_m1__nf1_gboth_sdfull_ng_pc/S.n0 15.6336
R3 S nfet_01v8_W24_L0p5_m1__nf1_gboth_sdfull_ng_pc/S.n1 15.6336
R4 nfet_01v8_W24_L0p5_m1__nf1_gboth_sdfull_ng_pc/S.n1 S 5.29285
R5 S nfet_01v8_W24_L0p5_m1__nf1_gboth_sdfull_ng_pc/S.n0 5.18959
R6 nfet_01v8_W24_L0p5_m1__nf1_gboth_sdfull_ng_pc/D.t0 nfet_01v8_W24_L0p5_m1__nf1_gboth_sdfull_ng_pc/D.n0 174.852
R7 nfet_01v8_W24_L0p5_m1__nf1_gboth_sdfull_ng_pc/D.n1 nfet_01v8_W24_L0p5_m1__nf1_gboth_sdfull_ng_pc/D.t0 174.852
R8 D nfet_01v8_W24_L0p5_m1__nf1_gboth_sdfull_ng_pc/D.n0 15.6336
R9 D nfet_01v8_W24_L0p5_m1__nf1_gboth_sdfull_ng_pc/D.n1 15.6336
R10 nfet_01v8_W24_L0p5_m1__nf1_gboth_sdfull_ng_pc/D.n1 D 5.29285
R11 D nfet_01v8_W24_L0p5_m1__nf1_gboth_sdfull_ng_pc/D.n0 5.18959
R12 G nfet_01v8_W24_L0p5_m1__nf1_gboth_sdfull_ng_pc/G.t0 1344.66
C3 S B 3.99411f
C4 D B 3.99411f
C5 G B 0.75587f
C6 nfet_01v8_W24_L0p5_m1__nf1_gboth_sdfull_ng_pc/G.t0 B 1.31101f ; **FLOATING
C7 nfet_01v8_W24_L0p5_m1__nf1_gboth_sdfull_ng_pc/D.n0 B 0.03718f ; **FLOATING
C8 nfet_01v8_W24_L0p5_m1__nf1_gboth_sdfull_ng_pc/D.t0 B 0.0295f ; **FLOATING
C9 nfet_01v8_W24_L0p5_m1__nf1_gboth_sdfull_ng_pc/D.n1 B 0.05581f ; **FLOATING
C10 nfet_01v8_W24_L0p5_m1__nf1_gboth_sdfull_ng_pc/S.n0 B 0.03718f ; **FLOATING
C11 nfet_01v8_W24_L0p5_m1__nf1_gboth_sdfull_ng_pc/S.t0 B 0.0295f ; **FLOATING
C12 nfet_01v8_W24_L0p5_m1__nf1_gboth_sdfull_ng_pc/S.n1 B 0.05581f ; **FLOATING
