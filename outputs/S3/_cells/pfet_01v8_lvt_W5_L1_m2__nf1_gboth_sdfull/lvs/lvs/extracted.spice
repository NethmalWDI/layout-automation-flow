* NGSPICE file created from pfet_01v8_lvt_W5_L1_m2__nf1_gboth_sdfull.ext - technology: sky130A

.subckt sky130_fd_pr__pfet_01v8_lvt_HH8RBD G D B S
X0 S G D B sky130_fd_pr__pfet_01v8_lvt ad=1.45 pd=10.58 as=1.45 ps=10.58 w=5 l=1
.ends

.subckt pfet_01v8_lvt_W5_L1_m2__nf1_gboth_sdfull D S G B
Xpfet_01v8_lvt_W5_L1_m2__nf1_gboth_sdfull_pc G D B S sky130_fd_pr__pfet_01v8_lvt_HH8RBD
.ends
