* NGSPICE file created from pfet_01v8_lvt_W887p03_L0p74_m1__nf4_gboth_sdfull_outS_ng.ext - technology: sky130A

.subckt pfet_01v8_lvt_W887p03_L0p74_m1__nf4_gboth_sdfull_outS_ng S D G B
X0 S G D B sky130_fd_pr__pfet_01v8_lvt ad=64.3104 pd=444.10001 as=32.1552 ps=222.05 w=221.75999 l=0.74
X1 D G S B sky130_fd_pr__pfet_01v8_lvt ad=32.1552 pd=222.05 as=32.1552 ps=222.05 w=221.75999 l=0.74
X2 D G S B sky130_fd_pr__pfet_01v8_lvt ad=32.1552 pd=222.05 as=64.3104 ps=444.10001 w=221.75999 l=0.74
X3 S G D B sky130_fd_pr__pfet_01v8_lvt ad=32.1552 pd=222.05 as=32.1552 ps=222.05 w=221.75999 l=0.74
C0 B S 12.55034f
C1 S G 41.11219f
C2 D S 33.28658f
C3 B G 0.6389f
C4 B D 9.60132f
C5 D G 41.10715f
C6 S VSUBS 31.31355f
C7 G VSUBS 1.14051f
C8 B VSUBS 0.11829p
.ends
