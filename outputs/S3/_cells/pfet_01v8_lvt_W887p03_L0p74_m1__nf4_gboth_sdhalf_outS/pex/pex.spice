* NGSPICE file created from pfet_01v8_lvt_W887p03_L0p74_m1__nf4_gboth_sdhalf_outS.ext - technology: sky130A

.subckt pfet_01v8_lvt_W887p03_L0p74_m1__nf4_gboth_sdhalf_outS S D G B
X0 S G D B sky130_fd_pr__pfet_01v8_lvt ad=64.3104 pd=444.10001 as=32.1552 ps=222.05 w=221.75999 l=0.74
X1 D G S B sky130_fd_pr__pfet_01v8_lvt ad=32.1552 pd=222.05 as=32.1552 ps=222.05 w=221.75999 l=0.74
X2 D G S B sky130_fd_pr__pfet_01v8_lvt ad=32.1552 pd=222.05 as=64.3104 ps=444.10001 w=221.75999 l=0.74
X3 S G D B sky130_fd_pr__pfet_01v8_lvt ad=32.1552 pd=222.05 as=32.1552 ps=222.05 w=221.75999 l=0.74
C0 G D 20.7063f
C1 D B 5.45276f
C2 D S 16.8247f
C3 G B 4.87716f
C4 G S 20.70632f
C5 B S 17.09706f
C6 S VSUBS 5.97329f
C7 G VSUBS 0.53438f
C8 B VSUBS 0.16639p
.ends
