* NGSPICE file created from nfet_01v8_lvt_W66p13_L2p03_m1__nf2_gboth_sdhalf_outS_ng.ext - technology: sky130A

.subckt nfet_01v8_lvt_W66p13_L2p03_m1__nf2_gboth_sdhalf_outS_ng S D G B
X0 D G S B sky130_fd_pr__nfet_01v8_lvt ad=4.79515 pd=33.36 as=9.5903 ps=66.72 w=33.07 l=2.03
X1 S G D B sky130_fd_pr__nfet_01v8_lvt ad=9.5903 pd=66.72 as=4.79515 ps=33.36 w=33.07 l=2.03
C0 G S 2.71568f
C1 D S 0.7185f
C2 D G 2.71568f
C3 D B 0.09177f
C4 S B 2.66797f
C5 G B 1.87351f
.ends
