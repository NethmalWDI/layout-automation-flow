.subckt nfet_01v8_lvt_W10_L1_m2__nf2_gtop_sdfull_outS D G S B
Xnfet_01v8_lvt_W10_L1_m2__nf2_gtop_sdfull_outS D G S B sky130_fd_pr__nfet_01v8_lvt L=1 W=10 nf=2
.ends
