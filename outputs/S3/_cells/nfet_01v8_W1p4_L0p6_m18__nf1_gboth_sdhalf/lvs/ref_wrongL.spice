.subckt nfet_01v8_W1p4_L0p6_m18__nf1_gboth_sdhalf D G S B
Xnfet_01v8_W1p4_L0p6_m18__nf1_gboth_sdhalf D G S B sky130_fd_pr__nfet_01v8 L=0.7 W=1.4 nf=1
.ends
