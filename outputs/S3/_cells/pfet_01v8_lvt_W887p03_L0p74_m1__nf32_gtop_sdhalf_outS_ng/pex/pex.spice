* NGSPICE file created from pfet_01v8_lvt_W887p03_L0p74_m1__nf32_gtop_sdhalf_outS_ng.ext - technology: sky130A

.subckt pfet_01v8_lvt_W887p03_L0p74_m1__nf32_gtop_sdhalf_outS_ng S D G B
X0 D G S B sky130_fd_pr__pfet_01v8_lvt ad=4.0194 pd=28.01 as=4.0194 ps=28.01 w=27.72 l=0.74
X1 D G S B sky130_fd_pr__pfet_01v8_lvt ad=4.0194 pd=28.01 as=4.0194 ps=28.01 w=27.72 l=0.74
X2 D G S B sky130_fd_pr__pfet_01v8_lvt ad=4.0194 pd=28.01 as=4.0194 ps=28.01 w=27.72 l=0.74
X3 D G S B sky130_fd_pr__pfet_01v8_lvt ad=4.0194 pd=28.01 as=4.0194 ps=28.01 w=27.72 l=0.74
X4 S G D B sky130_fd_pr__pfet_01v8_lvt ad=4.0194 pd=28.01 as=4.0194 ps=28.01 w=27.72 l=0.74
X5 S G D B sky130_fd_pr__pfet_01v8_lvt ad=4.0194 pd=28.01 as=4.0194 ps=28.01 w=27.72 l=0.74
X6 S G D B sky130_fd_pr__pfet_01v8_lvt ad=4.0194 pd=28.01 as=4.0194 ps=28.01 w=27.72 l=0.74
X7 D G S B sky130_fd_pr__pfet_01v8_lvt ad=4.0194 pd=28.01 as=4.0194 ps=28.01 w=27.72 l=0.74
X8 D G S B sky130_fd_pr__pfet_01v8_lvt ad=4.0194 pd=28.01 as=4.0194 ps=28.01 w=27.72 l=0.74
X9 S G D B sky130_fd_pr__pfet_01v8_lvt ad=4.0194 pd=28.01 as=4.0194 ps=28.01 w=27.72 l=0.74
X10 D G S B sky130_fd_pr__pfet_01v8_lvt ad=4.0194 pd=28.01 as=4.0194 ps=28.01 w=27.72 l=0.74
X11 S G D B sky130_fd_pr__pfet_01v8_lvt ad=4.0194 pd=28.01 as=4.0194 ps=28.01 w=27.72 l=0.74
X12 D G S B sky130_fd_pr__pfet_01v8_lvt ad=4.0194 pd=28.01 as=4.0194 ps=28.01 w=27.72 l=0.74
X13 D G S B sky130_fd_pr__pfet_01v8_lvt ad=4.0194 pd=28.01 as=4.0194 ps=28.01 w=27.72 l=0.74
X14 S G D B sky130_fd_pr__pfet_01v8_lvt ad=4.0194 pd=28.01 as=4.0194 ps=28.01 w=27.72 l=0.74
X15 D G S B sky130_fd_pr__pfet_01v8_lvt ad=4.0194 pd=28.01 as=4.0194 ps=28.01 w=27.72 l=0.74
X16 D G S B sky130_fd_pr__pfet_01v8_lvt ad=4.0194 pd=28.01 as=4.0194 ps=28.01 w=27.72 l=0.74
X17 D G S B sky130_fd_pr__pfet_01v8_lvt ad=4.0194 pd=28.01 as=4.0194 ps=28.01 w=27.72 l=0.74
X18 S G D B sky130_fd_pr__pfet_01v8_lvt ad=4.0194 pd=28.01 as=4.0194 ps=28.01 w=27.72 l=0.74
X19 S G D B sky130_fd_pr__pfet_01v8_lvt ad=4.0194 pd=28.01 as=4.0194 ps=28.01 w=27.72 l=0.74
X20 D G S B sky130_fd_pr__pfet_01v8_lvt ad=4.0194 pd=28.01 as=4.0194 ps=28.01 w=27.72 l=0.74
X21 S G D B sky130_fd_pr__pfet_01v8_lvt ad=4.0194 pd=28.01 as=4.0194 ps=28.01 w=27.72 l=0.74
X22 S G D B sky130_fd_pr__pfet_01v8_lvt ad=4.0194 pd=28.01 as=4.0194 ps=28.01 w=27.72 l=0.74
X23 S G D B sky130_fd_pr__pfet_01v8_lvt ad=4.0194 pd=28.01 as=4.0194 ps=28.01 w=27.72 l=0.74
X24 S G D B sky130_fd_pr__pfet_01v8_lvt ad=4.0194 pd=28.01 as=4.0194 ps=28.01 w=27.72 l=0.74
X25 D G S B sky130_fd_pr__pfet_01v8_lvt ad=4.0194 pd=28.01 as=4.0194 ps=28.01 w=27.72 l=0.74
X26 D G S B sky130_fd_pr__pfet_01v8_lvt ad=4.0194 pd=28.01 as=8.0388 ps=56.02 w=27.72 l=0.74
X27 S G D B sky130_fd_pr__pfet_01v8_lvt ad=4.0194 pd=28.01 as=4.0194 ps=28.01 w=27.72 l=0.74
X28 S G D B sky130_fd_pr__pfet_01v8_lvt ad=4.0194 pd=28.01 as=4.0194 ps=28.01 w=27.72 l=0.74
X29 D G S B sky130_fd_pr__pfet_01v8_lvt ad=4.0194 pd=28.01 as=4.0194 ps=28.01 w=27.72 l=0.74
X30 S G D B sky130_fd_pr__pfet_01v8_lvt ad=8.0388 pd=56.02 as=4.0194 ps=28.01 w=27.72 l=0.74
X31 S G D B sky130_fd_pr__pfet_01v8_lvt ad=4.0194 pd=28.01 as=4.0194 ps=28.01 w=27.72 l=0.74
C0 S D 18.71572f
C1 B D 5.00433f
C2 G D 22.64701f
C3 B S 5.18521f
C4 G S 22.65765f
C5 G B 3.26672f
C6 D VSUBS 0.38021f
C7 S VSUBS 2.32332f
C8 G VSUBS 5.18852f
C9 B VSUBS 91.547f
.ends
