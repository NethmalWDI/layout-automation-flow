* NGSPICE file created from nfet_01v8_lvt_W484p2_L0p24_m1__nf64_gtop_sdhalf_outS.ext - technology: sky130A

.subckt sky130_fd_pr__nfet_01v8_lvt_PZSH26 D54 S49 D44 D32 S27 D22 S17 D10 S59 D42
+ S37 D20 S15 G D52 S47 D30 S25 D62 S57 D40 S35 S13 D50 S45 S23 D60 S55 S33 S11 B
+ S43 S21 S63 S53 S41 S31 S51 S61 D8 D6 D4 D2 D0 S9 S7 D18 a_3363_n788# D28 S5 D38
+ D16 D48 D26 S3 D58 D36 D14 D46 D24 S19 S1 D56 S39 D34 S29 D12
X0 D34 G S33 B sky130_fd_pr__nfet_01v8_lvt ad=1.09765 pd=7.86 as=1.09765 ps=7.86 w=7.57 l=0.24
X1 S63 G D62 B sky130_fd_pr__nfet_01v8_lvt ad=1.09765 pd=7.86 as=1.09765 ps=7.86 w=7.57 l=0.24
X2 S3 G D2 B sky130_fd_pr__nfet_01v8_lvt ad=1.09765 pd=7.86 as=1.09765 ps=7.86 w=7.57 l=0.24
X3 S7 G D6 B sky130_fd_pr__nfet_01v8_lvt ad=1.09765 pd=7.86 as=1.09765 ps=7.86 w=7.57 l=0.24
X4 S25 G D24 B sky130_fd_pr__nfet_01v8_lvt ad=1.09765 pd=7.86 as=1.09765 ps=7.86 w=7.57 l=0.24
X5 D58 G S57 B sky130_fd_pr__nfet_01v8_lvt ad=1.09765 pd=7.86 as=1.09765 ps=7.86 w=7.57 l=0.24
X6 S23 G D22 B sky130_fd_pr__nfet_01v8_lvt ad=1.09765 pd=7.86 as=1.09765 ps=7.86 w=7.57 l=0.24
X7 D42 G S41 B sky130_fd_pr__nfet_01v8_lvt ad=1.09765 pd=7.86 as=1.09765 ps=7.86 w=7.57 l=0.24
X8 S51 G D50 B sky130_fd_pr__nfet_01v8_lvt ad=1.09765 pd=7.86 as=1.09765 ps=7.86 w=7.57 l=0.24
X9 S55 G D54 B sky130_fd_pr__nfet_01v8_lvt ad=1.09765 pd=7.86 as=1.09765 ps=7.86 w=7.57 l=0.24
X10 D28 G S27 B sky130_fd_pr__nfet_01v8_lvt ad=1.09765 pd=7.86 as=1.09765 ps=7.86 w=7.57 l=0.24
X11 S53 G D52 B sky130_fd_pr__nfet_01v8_lvt ad=1.09765 pd=7.86 as=1.09765 ps=7.86 w=7.57 l=0.24
X12 S13 G D12 B sky130_fd_pr__nfet_01v8_lvt ad=1.09765 pd=7.86 as=1.09765 ps=7.86 w=7.57 l=0.24
X13 S17 G D16 B sky130_fd_pr__nfet_01v8_lvt ad=1.09765 pd=7.86 as=1.09765 ps=7.86 w=7.57 l=0.24
X14 S31 G D30 B sky130_fd_pr__nfet_01v8_lvt ad=1.09765 pd=7.86 as=1.09765 ps=7.86 w=7.57 l=0.24
X15 S33 G D32 B sky130_fd_pr__nfet_01v8_lvt ad=1.09765 pd=7.86 as=1.09765 ps=7.86 w=7.57 l=0.24
X16 S37 G D36 B sky130_fd_pr__nfet_01v8_lvt ad=1.09765 pd=7.86 as=1.09765 ps=7.86 w=7.57 l=0.24
X17 D46 G S45 B sky130_fd_pr__nfet_01v8_lvt ad=1.09765 pd=7.86 as=1.09765 ps=7.86 w=7.57 l=0.24
X18 S61 G D60 B sky130_fd_pr__nfet_01v8_lvt ad=1.09765 pd=7.86 as=1.09765 ps=7.86 w=7.57 l=0.24
X19 D2 G S1 B sky130_fd_pr__nfet_01v8_lvt ad=1.09765 pd=7.86 as=1.09765 ps=7.86 w=7.57 l=0.24
X20 D22 G S21 B sky130_fd_pr__nfet_01v8_lvt ad=1.09765 pd=7.86 as=1.09765 ps=7.86 w=7.57 l=0.24
X21 S43 G D42 B sky130_fd_pr__nfet_01v8_lvt ad=1.09765 pd=7.86 as=1.09765 ps=7.86 w=7.57 l=0.24
X22 S9 G D8 B sky130_fd_pr__nfet_01v8_lvt ad=1.09765 pd=7.86 as=1.09765 ps=7.86 w=7.57 l=0.24
X23 D56 G S55 B sky130_fd_pr__nfet_01v8_lvt ad=1.09765 pd=7.86 as=1.09765 ps=7.86 w=7.57 l=0.24
X24 D14 G S13 B sky130_fd_pr__nfet_01v8_lvt ad=1.09765 pd=7.86 as=1.09765 ps=7.86 w=7.57 l=0.24
X25 S27 G D26 B sky130_fd_pr__nfet_01v8_lvt ad=1.09765 pd=7.86 as=1.09765 ps=7.86 w=7.57 l=0.24
X26 D40 G S39 B sky130_fd_pr__nfet_01v8_lvt ad=1.09765 pd=7.86 as=1.09765 ps=7.86 w=7.57 l=0.24
X27 S49 G D48 B sky130_fd_pr__nfet_01v8_lvt ad=1.09765 pd=7.86 as=1.09765 ps=7.86 w=7.57 l=0.24
X28 D12 G S11 B sky130_fd_pr__nfet_01v8_lvt ad=1.09765 pd=7.86 as=1.09765 ps=7.86 w=7.57 l=0.24
X29 D30 G S29 B sky130_fd_pr__nfet_01v8_lvt ad=1.09765 pd=7.86 as=1.09765 ps=7.86 w=7.57 l=0.24
X30 D38 G S37 B sky130_fd_pr__nfet_01v8_lvt ad=1.09765 pd=7.86 as=1.09765 ps=7.86 w=7.57 l=0.24
X31 S19 G D18 B sky130_fd_pr__nfet_01v8_lvt ad=1.09765 pd=7.86 as=1.09765 ps=7.86 w=7.57 l=0.24
X32 S35 G D34 B sky130_fd_pr__nfet_01v8_lvt ad=1.09765 pd=7.86 as=1.09765 ps=7.86 w=7.57 l=0.24
X33 a_3363_n788# G S63 B sky130_fd_pr__nfet_01v8_lvt ad=2.1953 pd=15.72 as=1.09765 ps=7.86 w=7.57 l=0.24
X34 D6 G S5 B sky130_fd_pr__nfet_01v8_lvt ad=1.09765 pd=7.86 as=1.09765 ps=7.86 w=7.57 l=0.24
X35 S59 G D58 B sky130_fd_pr__nfet_01v8_lvt ad=1.09765 pd=7.86 as=1.09765 ps=7.86 w=7.57 l=0.24
X36 D24 G S23 B sky130_fd_pr__nfet_01v8_lvt ad=1.09765 pd=7.86 as=1.09765 ps=7.86 w=7.57 l=0.24
X37 D32 G S31 B sky130_fd_pr__nfet_01v8_lvt ad=1.09765 pd=7.86 as=1.09765 ps=7.86 w=7.57 l=0.24
X38 D4 G S3 B sky130_fd_pr__nfet_01v8_lvt ad=1.09765 pd=7.86 as=1.09765 ps=7.86 w=7.57 l=0.24
X39 S41 G D40 B sky130_fd_pr__nfet_01v8_lvt ad=1.09765 pd=7.86 as=1.09765 ps=7.86 w=7.57 l=0.24
X40 S11 G D10 B sky130_fd_pr__nfet_01v8_lvt ad=1.09765 pd=7.86 as=1.09765 ps=7.86 w=7.57 l=0.24
X41 D54 G S53 B sky130_fd_pr__nfet_01v8_lvt ad=1.09765 pd=7.86 as=1.09765 ps=7.86 w=7.57 l=0.24
X42 D16 G S15 B sky130_fd_pr__nfet_01v8_lvt ad=1.09765 pd=7.86 as=1.09765 ps=7.86 w=7.57 l=0.24
X43 S47 G D46 B sky130_fd_pr__nfet_01v8_lvt ad=1.09765 pd=7.86 as=1.09765 ps=7.86 w=7.57 l=0.24
X44 S5 G D4 B sky130_fd_pr__nfet_01v8_lvt ad=1.09765 pd=7.86 as=1.09765 ps=7.86 w=7.57 l=0.24
X45 D36 G S35 B sky130_fd_pr__nfet_01v8_lvt ad=1.09765 pd=7.86 as=1.09765 ps=7.86 w=7.57 l=0.24
X46 S1 G D0 B sky130_fd_pr__nfet_01v8_lvt ad=1.09765 pd=7.86 as=2.1953 ps=15.72 w=7.57 l=0.24
X47 S21 G D20 B sky130_fd_pr__nfet_01v8_lvt ad=1.09765 pd=7.86 as=1.09765 ps=7.86 w=7.57 l=0.24
X48 D44 G S43 B sky130_fd_pr__nfet_01v8_lvt ad=1.09765 pd=7.86 as=1.09765 ps=7.86 w=7.57 l=0.24
X49 S57 G D56 B sky130_fd_pr__nfet_01v8_lvt ad=1.09765 pd=7.86 as=1.09765 ps=7.86 w=7.57 l=0.24
X50 D62 G S61 B sky130_fd_pr__nfet_01v8_lvt ad=1.09765 pd=7.86 as=1.09765 ps=7.86 w=7.57 l=0.24
X51 D8 G S7 B sky130_fd_pr__nfet_01v8_lvt ad=1.09765 pd=7.86 as=1.09765 ps=7.86 w=7.57 l=0.24
X52 D26 G S25 B sky130_fd_pr__nfet_01v8_lvt ad=1.09765 pd=7.86 as=1.09765 ps=7.86 w=7.57 l=0.24
X53 D10 G S9 B sky130_fd_pr__nfet_01v8_lvt ad=1.09765 pd=7.86 as=1.09765 ps=7.86 w=7.57 l=0.24
X54 S15 G D14 B sky130_fd_pr__nfet_01v8_lvt ad=1.09765 pd=7.86 as=1.09765 ps=7.86 w=7.57 l=0.24
X55 S29 G D28 B sky130_fd_pr__nfet_01v8_lvt ad=1.09765 pd=7.86 as=1.09765 ps=7.86 w=7.57 l=0.24
X56 S39 G D38 B sky130_fd_pr__nfet_01v8_lvt ad=1.09765 pd=7.86 as=1.09765 ps=7.86 w=7.57 l=0.24
X57 D50 G S49 B sky130_fd_pr__nfet_01v8_lvt ad=1.09765 pd=7.86 as=1.09765 ps=7.86 w=7.57 l=0.24
X58 D48 G S47 B sky130_fd_pr__nfet_01v8_lvt ad=1.09765 pd=7.86 as=1.09765 ps=7.86 w=7.57 l=0.24
X59 D52 G S51 B sky130_fd_pr__nfet_01v8_lvt ad=1.09765 pd=7.86 as=1.09765 ps=7.86 w=7.57 l=0.24
X60 D18 G S17 B sky130_fd_pr__nfet_01v8_lvt ad=1.09765 pd=7.86 as=1.09765 ps=7.86 w=7.57 l=0.24
X61 D20 G S19 B sky130_fd_pr__nfet_01v8_lvt ad=1.09765 pd=7.86 as=1.09765 ps=7.86 w=7.57 l=0.24
X62 S45 G D44 B sky130_fd_pr__nfet_01v8_lvt ad=1.09765 pd=7.86 as=1.09765 ps=7.86 w=7.57 l=0.24
X63 D60 G S59 B sky130_fd_pr__nfet_01v8_lvt ad=1.09765 pd=7.86 as=1.09765 ps=7.86 w=7.57 l=0.24
.ends

.subckt nfet_01v8_lvt_W484p2_L0p24_m1__nf64_gtop_sdhalf_outS S D G B
Xnfet_01v8_lvt_W484p2_L0p24_m1__nf64_gtop_sdhalf_outS_pc S D S S D S D S D S D S D
+ G S D S D S D S D D S D D S D D D B D D D D D D D D S S S S S D D S S S D S S S
+ S D S S S S S D D S D S D S sky130_fd_pr__nfet_01v8_lvt_PZSH26
.ends
