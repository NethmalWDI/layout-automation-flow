* NGSPICE file created from pfet_01v8_lvt_W1p4_L0p6_m24__nf1_gboth_sdhalf.ext - technology: sky130A

.subckt sky130_fd_pr__pfet_01v8_lvt_MEW9S9 G D B S
X0 S G D B sky130_fd_pr__pfet_01v8_lvt ad=0.406 pd=3.38 as=0.406 ps=3.38 w=1.4 l=0.6
.ends

.subckt pfet_01v8_lvt_W1p4_L0p6_m24__nf1_gboth_sdhalf D S G B
Xpfet_01v8_lvt_W1p4_L0p6_m24__nf1_gboth_sdhalf_pc G D B S sky130_fd_pr__pfet_01v8_lvt_MEW9S9
.ends
