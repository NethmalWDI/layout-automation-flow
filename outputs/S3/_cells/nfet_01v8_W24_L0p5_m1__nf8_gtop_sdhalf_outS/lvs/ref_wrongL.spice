.subckt nfet_01v8_W24_L0p5_m1__nf8_gtop_sdhalf_outS D G S B
Xnfet_01v8_W24_L0p5_m1__nf8_gtop_sdhalf_outS D G S B sky130_fd_pr__nfet_01v8 L=0.6 W=24 nf=8
.ends
