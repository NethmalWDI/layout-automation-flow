* NGSPICE file created from pfet_01v8_lvt_W37p3_L0p74_m1__nf1_gtop_sdfull_ng.ext - technology: sky130A

.subckt pfet_01v8_lvt_W37p3_L0p74_m1__nf1_gtop_sdfull_ng D S G B
X0 S G D B sky130_fd_pr__pfet_01v8_lvt ad=10.817 pd=75.18 as=10.817 ps=75.18 w=37.3 l=0.74
C0 D S 1.38952f
C1 D G 1.71558f
C2 G S 1.71558f
C3 B D 0.65137f
C4 B S 0.65137f
C5 B G 0.11233f
C6 S VSUBS 2.64686f
C7 D VSUBS 2.64686f
C8 G VSUBS 0.19533f
C9 B VSUBS 4.86058f
.ends
