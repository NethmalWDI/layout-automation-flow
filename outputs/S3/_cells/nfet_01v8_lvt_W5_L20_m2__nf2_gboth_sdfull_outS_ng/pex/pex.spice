* NGSPICE file created from nfet_01v8_lvt_W5_L20_m2__nf2_gboth_sdfull_outS_ng.ext - technology: sky130A

.subckt nfet_01v8_lvt_W5_L20_m2__nf2_gboth_sdfull_outS_ng S D G B
X0 D G S B sky130_fd_pr__nfet_01v8_lvt ad=0.3625 pd=2.79 as=0.725 ps=5.58 w=2.5 l=20
X1 S G D B sky130_fd_pr__nfet_01v8_lvt ad=0.725 pd=5.58 as=0.3625 ps=2.79 w=2.5 l=20
C0 D G 3.02267f
C1 S G 3.0255f
C2 S D 0.65937f
C3 D B 1.39396f
C4 S B 1.41053f
C5 G B 14.64217f
.ends
