* NGSPICE file created from nfet_01v8_lvt_W66p13_L2p03_m1__nf4_gtop_sdfull_outD.ext - technology: sky130A

.subckt sky130_fd_pr__nfet_01v8_lvt_XV84G2 a_899_n1684# G B D2 D0 S3 S1
X0 S3 G D2 B sky130_fd_pr__nfet_01v8_lvt ad=2.39685 pd=16.82 as=2.39685 ps=16.82 w=16.53 l=2.03
X1 a_899_n1684# G S3 B sky130_fd_pr__nfet_01v8_lvt ad=4.7937 pd=33.64 as=2.39685 ps=16.82 w=16.53 l=2.03
X2 S1 G D0 B sky130_fd_pr__nfet_01v8_lvt ad=2.39685 pd=16.82 as=4.7937 ps=33.64 w=16.53 l=2.03
X3 D2 G S1 B sky130_fd_pr__nfet_01v8_lvt ad=2.39685 pd=16.82 as=2.39685 ps=16.82 w=16.53 l=2.03
.ends

.subckt nfet_01v8_lvt_W66p13_L2p03_m1__nf4_gtop_sdfull_outD S D G B
Xnfet_01v8_lvt_W66p13_L2p03_m1__nf4_gtop_sdfull_outD_pc D G B D D S S sky130_fd_pr__nfet_01v8_lvt_XV84G2
.ends
