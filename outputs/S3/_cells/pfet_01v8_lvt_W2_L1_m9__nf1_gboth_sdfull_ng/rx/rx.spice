* NGSPICE file created from pfet_01v8_lvt_W2_L1_m9__nf1_gboth_sdfull_ng.ext - technology: sky130A

X0 S G D B sky130_fd_pr__pfet_01v8_lvt ad=0.58 pd=4.58 as=0.58 ps=4.58 w=2 l=1
C0 B S 0.05138f
C1 B G 0.19227f
C2 B D 0.05138f
C3 G S 0.10986f
C4 S D 0.05958f
C5 G D 0.10986f
C6 S VSUBS 0.16817f
C7 D VSUBS 0.16817f
C8 G VSUBS 0.36295f
C9 B VSUBS 0.6984f
