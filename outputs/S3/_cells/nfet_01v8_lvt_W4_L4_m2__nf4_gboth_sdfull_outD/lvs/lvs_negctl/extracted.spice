* NGSPICE file created from nfet_01v8_lvt_W4_L4_m2__nf4_gboth_sdfull_outD.ext - technology: sky130A

.subckt sky130_fd_pr__nfet_01v8_lvt_U4YZBR G B a_1687_n100# D2 D0 S3 S1
X0 S1 G D0 B sky130_fd_pr__nfet_01v8_lvt ad=0.145 pd=1.29 as=0.29 ps=2.58 w=1 l=4
X1 S3 G D2 B sky130_fd_pr__nfet_01v8_lvt ad=0.145 pd=1.29 as=0.145 ps=1.29 w=1 l=4
X2 D2 G S1 B sky130_fd_pr__nfet_01v8_lvt ad=0.145 pd=1.29 as=0.145 ps=1.29 w=1 l=4
X3 a_1687_n100# G S3 B sky130_fd_pr__nfet_01v8_lvt ad=0.29 pd=2.58 as=0.145 ps=1.29 w=1 l=4
.ends

.subckt nfet_01v8_lvt_W4_L4_m2__nf4_gboth_sdfull_outD S D G B
Xnfet_01v8_lvt_W4_L4_m2__nf4_gboth_sdfull_outD_pc G B D D D S S sky130_fd_pr__nfet_01v8_lvt_U4YZBR
.ends
