* NGSPICE file created from pfet_01v8_W8_L1_m1__nf1_gboth_sdfull.ext - technology: sky130A

X0 pfet_01v8_W8_L1_m1__nf1_gboth_sdfull_pc/S.t0 G pfet_01v8_W8_L1_m1__nf1_gboth_sdfull_pc/D.t0 B sky130_fd_pr__pfet_01v8 ad=2.32 pd=16.58 as=2.32 ps=16.58 w=8 l=1
C0 S B 0.49734f
C1 B D 0.49734f
C2 S D 0.23712f
C3 B G 0.4291f
C4 S G 0.43491f
C5 D G 0.43491f
R0 S pfet_01v8_W8_L1_m1__nf1_gboth_sdfull_pc/S.n1 54.4415
R1 pfet_01v8_W8_L1_m1__nf1_gboth_sdfull_pc/S.n1 pfet_01v8_W8_L1_m1__nf1_gboth_sdfull_pc/S.n0 48.279
R2 S pfet_01v8_W8_L1_m1__nf1_gboth_sdfull_pc/S.n0 17.9488
R3 pfet_01v8_W8_L1_m1__nf1_gboth_sdfull_pc/S.n1 pfet_01v8_W8_L1_m1__nf1_gboth_sdfull_pc/S.t0 3.57113
R4 S pfet_01v8_W8_L1_m1__nf1_gboth_sdfull_pc/S.n0 3.09203
R5 pfet_01v8_W8_L1_m1__nf1_gboth_sdfull_pc/D.n0 D 54.4415
R6 pfet_01v8_W8_L1_m1__nf1_gboth_sdfull_pc/D.n1 pfet_01v8_W8_L1_m1__nf1_gboth_sdfull_pc/D.n0 48.279
R7 D pfet_01v8_W8_L1_m1__nf1_gboth_sdfull_pc/D.n1 17.9488
R8 pfet_01v8_W8_L1_m1__nf1_gboth_sdfull_pc/D.n0 pfet_01v8_W8_L1_m1__nf1_gboth_sdfull_pc/D.t0 3.57113
R9 pfet_01v8_W8_L1_m1__nf1_gboth_sdfull_pc/D.n1 D 3.09203
R10 B.n149 B.n8 727.059
R11 B.n152 B.n151 727.059
R12 B.n65 B.n54 727.059
R13 B.n68 B.n56 727.059
R14 B.n149 B.n7 240
R15 B.n141 B.n7 240
R16 B.n141 B.n10 240
R17 B.n132 B.n10 240
R18 B.n132 B.n16 240
R19 B.n128 B.n16 240
R20 B.n128 B.n18 240
R21 B.n120 B.n18 240
R22 B.n120 B.n24 240
R23 B.n116 B.n24 240
R24 B.n116 B.n26 240
R25 B.n108 B.n26 240
R26 B.n108 B.n32 240
R27 B.n104 B.n32 240
R28 B.n104 B.n34 240
R29 B.n96 B.n34 240
R30 B.n96 B.n40 240
R31 B.n92 B.n40 240
R32 B.n92 B.n42 240
R33 B.n84 B.n42 240
R34 B.n84 B.n48 240
R35 B.n80 B.n48 240
R36 B.n80 B.n50 240
R37 B.n72 B.n50 240
R38 B.n72 B.n56 240
R39 B.n154 B.n2 240
R40 B.n145 B.n8 240
R41 B.n151 B.n4 240
R42 B.n139 B.n4 240
R43 B.n139 B.n12 240
R44 B.n134 B.n12 240
R45 B.n134 B.n14 240
R46 B.n126 B.n14 240
R47 B.n126 B.n20 240
R48 B.n122 B.n20 240
R49 B.n122 B.n22 240
R50 B.n114 B.n22 240
R51 B.n114 B.n28 240
R52 B.n110 B.n28 240
R53 B.n110 B.n30 240
R54 B.n102 B.n30 240
R55 B.n102 B.n36 240
R56 B.n98 B.n36 240
R57 B.n98 B.n38 240
R58 B.n90 B.n38 240
R59 B.n90 B.n44 240
R60 B.n86 B.n44 240
R61 B.n86 B.n46 240
R62 B.n78 B.n46 240
R63 B.n78 B.n52 240
R64 B.n74 B.n52 240
R65 B.n74 B.n54 240
R66 B.n65 B.n60 240
R67 B.n61 B.n58 240
R68 B.n150 B.n3 186.149
R69 B.n66 B.n55 186.149
R70 B.n8 B.n3 185
R71 B.n147 B.n8 185
R72 B.n146 B.n145 185
R73 B.n2 B.n0 185
R74 B.n155 B.n154 185
R75 B.n152 B.n1 185
R76 B.n151 B.n150 185
R77 B.n151 B.n5 185
R78 B.n6 B.n4 185
R79 B.n137 B.n4 185
R80 B.n140 B.n139 185
R81 B.n139 B.n138 185
R82 B.n12 B.n11 185
R83 B.n136 B.n12 185
R84 B.n134 B.n133 185
R85 B.n135 B.n134 185
R86 B.n15 B.n14 185
R87 B.n14 B.n13 185
R88 B.n127 B.n126 185
R89 B.n126 B.n125 185
R90 B.n20 B.n19 185
R91 B.n124 B.n20 185
R92 B.n122 B.n121 185
R93 B.n123 B.n122 185
R94 B.n23 B.n22 185
R95 B.n22 B.n21 185
R96 B.n115 B.n114 185
R97 B.n114 B.n113 185
R98 B.n28 B.n27 185
R99 B.n112 B.n28 185
R100 B.n110 B.n109 185
R101 B.n111 B.n110 185
R102 B.n31 B.n30 185
R103 B.n30 B.n29 185
R104 B.n103 B.n102 185
R105 B.n102 B.n101 185
R106 B.n36 B.n35 185
R107 B.n100 B.n36 185
R108 B.n98 B.n97 185
R109 B.n99 B.n98 185
R110 B.n39 B.n38 185
R111 B.n38 B.n37 185
R112 B.n91 B.n90 185
R113 B.n90 B.n89 185
R114 B.n44 B.n43 185
R115 B.n88 B.n44 185
R116 B.n86 B.n85 185
R117 B.n87 B.n86 185
R118 B.n47 B.n46 185
R119 B.n46 B.n45 185
R120 B.n79 B.n78 185
R121 B.n78 B.n77 185
R122 B.n52 B.n51 185
R123 B.n76 B.n52 185
R124 B.n74 B.n73 185
R125 B.n75 B.n74 185
R126 B.n55 B.n54 185
R127 B.n54 B.n53 185
R128 B.n66 B.n65 185
R129 B.n65 B.n64 185
R130 B.n63 B.n60 185
R131 B.n62 B.n61 185
R132 B.n58 B.n57 185
R133 B.n69 B.n68 185
R134 B.n56 B.n55 185
R135 B.n70 B.n56 185
R136 B.n73 B.n72 185
R137 B.n72 B.n71 185
R138 B.n51 B.n50 185
R139 B.n50 B.n49 185
R140 B.n80 B.n79 185
R141 B.n81 B.n80 185
R142 B.n48 B.n47 185
R143 B.n82 B.n48 185
R144 B.n85 B.n84 185
R145 B.n84 B.n83 185
R146 B.n43 B.n42 185
R147 B.n42 B.n41 185
R148 B.n92 B.n91 185
R149 B.n93 B.n92 185
R150 B.n40 B.n39 185
R151 B.n94 B.n40 185
R152 B.n97 B.n96 185
R153 B.n96 B.n95 185
R154 B.n35 B.n34 185
R155 B.n34 B.n33 185
R156 B.n104 B.n103 185
R157 B.n105 B.n104 185
R158 B.n32 B.n31 185
R159 B.n106 B.n32 185
R160 B.n109 B.n108 185
R161 B.n108 B.n107 185
R162 B.n27 B.n26 185
R163 B.n26 B.n25 185
R164 B.n116 B.n115 185
R165 B.n117 B.n116 185
R166 B.n24 B.n23 185
R167 B.n118 B.n24 185
R168 B.n121 B.n120 185
R169 B.n120 B.n119 185
R170 B.n19 B.n18 185
R171 B.n18 B.n17 185
R172 B.n128 B.n127 185
R173 B.n129 B.n128 185
R174 B.n16 B.n15 185
R175 B.n130 B.n16 185
R176 B.n133 B.n132 185
R177 B.n132 B.n131 185
R178 B.n11 B.n10 185
R179 B.n10 B.n9 185
R180 B.n141 B.n140 185
R181 B.n142 B.n141 185
R182 B.n7 B.n6 185
R183 B.n143 B.n7 185
R184 B.n150 B.n149 185
R185 B.n149 B.n148 185
R186 B.n150 B.n6 109.123
R187 B.n140 B.n6 109.123
R188 B.n140 B.n11 109.123
R189 B.n133 B.n11 109.123
R190 B.n133 B.n15 109.123
R191 B.n127 B.n15 109.123
R192 B.n127 B.n19 109.123
R193 B.n121 B.n19 109.123
R194 B.n121 B.n23 109.123
R195 B.n115 B.n23 109.123
R196 B.n115 B.n27 109.123
R197 B.n109 B.n27 109.123
R198 B.n109 B.n31 109.123
R199 B.n103 B.n31 109.123
R200 B.n103 B.n35 109.123
R201 B.n97 B.n35 109.123
R202 B.n97 B.n39 109.123
R203 B.n91 B.n39 109.123
R204 B.n91 B.n43 109.123
R205 B.n85 B.n43 109.123
R206 B.n85 B.n47 109.123
R207 B.n79 B.n47 109.123
R208 B.n79 B.n51 109.123
R209 B.n73 B.n51 109.123
R210 B.n73 B.n55 109.123
R211 B.n5 B.n1 77.5534
R212 B.n64 B.n53 77.5534
R213 B.n148 B.n147 77.5534
R214 B.n70 B.n69 77.5534
R215 B.n145 B.n144 72.7879
R216 B.n154 B.n153 72.7879
R217 B.n60 B.n59 72.7879
R218 B.n67 B.n58 72.7879
R219 B.n153 B.n152 72.7879
R220 B.n144 B.n2 72.7879
R221 B.n61 B.n59 72.7879
R222 B.n68 B.n67 72.7879
R223 B.n144 B.n3 56.1076
R224 B.n153 B.n3 56.1076
R225 B.n66 B.n59 56.1076
R226 B.n67 B.n66 56.1076
R227 B.n155 B.n1 25.6005
R228 B.n146 B.n0 25.6005
R229 B.n147 B.n146 25.6005
R230 B.n137 B.n5 25.6005
R231 B.n138 B.n137 25.6005
R232 B.n138 B.n136 25.6005
R233 B.n136 B.n135 25.6005
R234 B.n135 B.n13 25.6005
R235 B.n125 B.n13 25.6005
R236 B.n125 B.n124 25.6005
R237 B.n124 B.n123 25.6005
R238 B.n123 B.n21 25.6005
R239 B.n113 B.n21 25.6005
R240 B.n113 B.n112 25.6005
R241 B.n112 B.n111 25.6005
R242 B.n111 B.n29 25.6005
R243 B.n101 B.n29 25.6005
R244 B.n101 B.n100 25.6005
R245 B.n100 B.n99 25.6005
R246 B.n99 B.n37 25.6005
R247 B.n89 B.n37 25.6005
R248 B.n89 B.n88 25.6005
R249 B.n88 B.n87 25.6005
R250 B.n87 B.n45 25.6005
R251 B.n77 B.n45 25.6005
R252 B.n77 B.n76 25.6005
R253 B.n76 B.n75 25.6005
R254 B.n75 B.n53 25.6005
R255 B.n64 B.n63 25.6005
R256 B.n63 B.n62 25.6005
R257 B.n62 B.n57 25.6005
R258 B.n69 B.n57 25.6005
R259 B.n148 B.n143 25.6005
R260 B.n143 B.n142 25.6005
R261 B.n142 B.n9 25.6005
R262 B.n131 B.n9 25.6005
R263 B.n131 B.n130 25.6005
R264 B.n130 B.n129 25.6005
R265 B.n129 B.n17 25.6005
R266 B.n119 B.n17 25.6005
R267 B.n119 B.n118 25.6005
R268 B.n118 B.n117 25.6005
R269 B.n117 B.n25 25.6005
R270 B.n107 B.n25 25.6005
R271 B.n107 B.n106 25.6005
R272 B.n106 B.n105 25.6005
R273 B.n105 B.n33 25.6005
R274 B.n95 B.n33 25.6005
R275 B.n95 B.n94 25.6005
R276 B.n94 B.n93 25.6005
R277 B.n93 B.n41 25.6005
R278 B.n83 B.n41 25.6005
R279 B.n83 B.n82 25.6005
R280 B.n82 B.n81 25.6005
R281 B.n81 B.n49 25.6005
R282 B.n71 B.n49 25.6005
R283 B.n71 B.n70 25.6005
R284 B B.n155 19.2005
R285 B B.n0 6.4005
C6 S VSUBS 0.87172f
C7 D VSUBS 0.87172f
C8 G VSUBS 0.18204f
C9 B VSUBS 4.50925f
C10 pfet_01v8_W8_L1_m1__nf1_gboth_sdfull_pc/D.t0 VSUBS 0.12272f ; **FLOATING
C11 pfet_01v8_W8_L1_m1__nf1_gboth_sdfull_pc/D.n0 VSUBS 0.38036f ; **FLOATING
C12 pfet_01v8_W8_L1_m1__nf1_gboth_sdfull_pc/D.n1 VSUBS 0.01692f ; **FLOATING
C13 pfet_01v8_W8_L1_m1__nf1_gboth_sdfull_pc/S.n0 VSUBS 0.01692f ; **FLOATING
C14 pfet_01v8_W8_L1_m1__nf1_gboth_sdfull_pc/S.t0 VSUBS 0.12272f ; **FLOATING
C15 pfet_01v8_W8_L1_m1__nf1_gboth_sdfull_pc/S.n1 VSUBS 0.38036f ; **FLOATING
