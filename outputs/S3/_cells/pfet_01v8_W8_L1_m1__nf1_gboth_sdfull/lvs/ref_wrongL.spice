.subckt pfet_01v8_W8_L1_m1__nf1_gboth_sdfull D G S B
Xpfet_01v8_W8_L1_m1__nf1_gboth_sdfull D G S B sky130_fd_pr__pfet_01v8 L=1.1 W=8 nf=1
.ends
