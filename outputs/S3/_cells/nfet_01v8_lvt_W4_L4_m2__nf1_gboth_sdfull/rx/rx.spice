* NGSPICE file created from nfet_01v8_lvt_W4_L4_m2__nf1_gboth_sdfull.ext - technology: sky130A

X0 S G D nfet_01v8_lvt_W4_L4_m2__nf1_gboth_sdfull_pc/B.t0 sky130_fd_pr__nfet_01v8_lvt ad=1.16 pd=8.58 as=1.16 ps=8.58 w=4 l=4
C0 D G 0.32885f
C1 D S 0.03387f
C2 S G 0.32885f
R0 nfet_01v8_lvt_W4_L4_m2__nf1_gboth_sdfull_pc/B.n99 nfet_01v8_lvt_W4_L4_m2__nf1_gboth_sdfull_pc/B.n84 1153.03
R1 nfet_01v8_lvt_W4_L4_m2__nf1_gboth_sdfull_pc/B.n53 nfet_01v8_lvt_W4_L4_m2__nf1_gboth_sdfull_pc/B.n18 1153.03
R2 nfet_01v8_lvt_W4_L4_m2__nf1_gboth_sdfull_pc/B.n125 nfet_01v8_lvt_W4_L4_m2__nf1_gboth_sdfull_pc/B.n83 1153.03
R3 nfet_01v8_lvt_W4_L4_m2__nf1_gboth_sdfull_pc/B.n27 nfet_01v8_lvt_W4_L4_m2__nf1_gboth_sdfull_pc/B.n16 1153.03
R4 nfet_01v8_lvt_W4_L4_m2__nf1_gboth_sdfull_pc/B.n125 nfet_01v8_lvt_W4_L4_m2__nf1_gboth_sdfull_pc/B.n124 585
R5 nfet_01v8_lvt_W4_L4_m2__nf1_gboth_sdfull_pc/B.n126 nfet_01v8_lvt_W4_L4_m2__nf1_gboth_sdfull_pc/B.n125 585
R6 nfet_01v8_lvt_W4_L4_m2__nf1_gboth_sdfull_pc/B.n81 nfet_01v8_lvt_W4_L4_m2__nf1_gboth_sdfull_pc/B.n80 585
R7 nfet_01v8_lvt_W4_L4_m2__nf1_gboth_sdfull_pc/B.n127 nfet_01v8_lvt_W4_L4_m2__nf1_gboth_sdfull_pc/B.n81 585
R8 nfet_01v8_lvt_W4_L4_m2__nf1_gboth_sdfull_pc/B.n130 nfet_01v8_lvt_W4_L4_m2__nf1_gboth_sdfull_pc/B.n129 585
R9 nfet_01v8_lvt_W4_L4_m2__nf1_gboth_sdfull_pc/B.n129 nfet_01v8_lvt_W4_L4_m2__nf1_gboth_sdfull_pc/B.n128 585
R10 nfet_01v8_lvt_W4_L4_m2__nf1_gboth_sdfull_pc/B.n131 nfet_01v8_lvt_W4_L4_m2__nf1_gboth_sdfull_pc/B.n76 585
R11 nfet_01v8_lvt_W4_L4_m2__nf1_gboth_sdfull_pc/B.n76 nfet_01v8_lvt_W4_L4_m2__nf1_gboth_sdfull_pc/B.n75 585
R12 nfet_01v8_lvt_W4_L4_m2__nf1_gboth_sdfull_pc/B.n133 nfet_01v8_lvt_W4_L4_m2__nf1_gboth_sdfull_pc/B.n132 585
R13 nfet_01v8_lvt_W4_L4_m2__nf1_gboth_sdfull_pc/B.n134 nfet_01v8_lvt_W4_L4_m2__nf1_gboth_sdfull_pc/B.n133 585
R14 nfet_01v8_lvt_W4_L4_m2__nf1_gboth_sdfull_pc/B.n6 nfet_01v8_lvt_W4_L4_m2__nf1_gboth_sdfull_pc/B.n4 585
R15 nfet_01v8_lvt_W4_L4_m2__nf1_gboth_sdfull_pc/B.n135 nfet_01v8_lvt_W4_L4_m2__nf1_gboth_sdfull_pc/B.n6 585
R16 nfet_01v8_lvt_W4_L4_m2__nf1_gboth_sdfull_pc/B.n138 nfet_01v8_lvt_W4_L4_m2__nf1_gboth_sdfull_pc/B.n137 585
R17 nfet_01v8_lvt_W4_L4_m2__nf1_gboth_sdfull_pc/B.n137 nfet_01v8_lvt_W4_L4_m2__nf1_gboth_sdfull_pc/B.n136 585
R18 nfet_01v8_lvt_W4_L4_m2__nf1_gboth_sdfull_pc/B.n70 nfet_01v8_lvt_W4_L4_m2__nf1_gboth_sdfull_pc/B.n5 585
R19 nfet_01v8_lvt_W4_L4_m2__nf1_gboth_sdfull_pc/B.n74 nfet_01v8_lvt_W4_L4_m2__nf1_gboth_sdfull_pc/B.n5 585
R20 nfet_01v8_lvt_W4_L4_m2__nf1_gboth_sdfull_pc/B.n72 nfet_01v8_lvt_W4_L4_m2__nf1_gboth_sdfull_pc/B.n71 585
R21 nfet_01v8_lvt_W4_L4_m2__nf1_gboth_sdfull_pc/B.n73 nfet_01v8_lvt_W4_L4_m2__nf1_gboth_sdfull_pc/B.n72 585
R22 nfet_01v8_lvt_W4_L4_m2__nf1_gboth_sdfull_pc/B.n9 nfet_01v8_lvt_W4_L4_m2__nf1_gboth_sdfull_pc/B.n8 585
R23 nfet_01v8_lvt_W4_L4_m2__nf1_gboth_sdfull_pc/B.n8 nfet_01v8_lvt_W4_L4_m2__nf1_gboth_sdfull_pc/B.n7 585
R24 nfet_01v8_lvt_W4_L4_m2__nf1_gboth_sdfull_pc/B.n64 nfet_01v8_lvt_W4_L4_m2__nf1_gboth_sdfull_pc/B.n63 585
R25 nfet_01v8_lvt_W4_L4_m2__nf1_gboth_sdfull_pc/B.n63 nfet_01v8_lvt_W4_L4_m2__nf1_gboth_sdfull_pc/B.n62 585
R26 nfet_01v8_lvt_W4_L4_m2__nf1_gboth_sdfull_pc/B.n14 nfet_01v8_lvt_W4_L4_m2__nf1_gboth_sdfull_pc/B.n13 585
R27 nfet_01v8_lvt_W4_L4_m2__nf1_gboth_sdfull_pc/B.n61 nfet_01v8_lvt_W4_L4_m2__nf1_gboth_sdfull_pc/B.n14 585
R28 nfet_01v8_lvt_W4_L4_m2__nf1_gboth_sdfull_pc/B.n59 nfet_01v8_lvt_W4_L4_m2__nf1_gboth_sdfull_pc/B.n58 585
R29 nfet_01v8_lvt_W4_L4_m2__nf1_gboth_sdfull_pc/B.n60 nfet_01v8_lvt_W4_L4_m2__nf1_gboth_sdfull_pc/B.n59 585
R30 nfet_01v8_lvt_W4_L4_m2__nf1_gboth_sdfull_pc/B.n17 nfet_01v8_lvt_W4_L4_m2__nf1_gboth_sdfull_pc/B.n16 585
R31 nfet_01v8_lvt_W4_L4_m2__nf1_gboth_sdfull_pc/B.n16 nfet_01v8_lvt_W4_L4_m2__nf1_gboth_sdfull_pc/B.n15 585
R32 nfet_01v8_lvt_W4_L4_m2__nf1_gboth_sdfull_pc/B.n28 nfet_01v8_lvt_W4_L4_m2__nf1_gboth_sdfull_pc/B.n27 585
R33 nfet_01v8_lvt_W4_L4_m2__nf1_gboth_sdfull_pc/B.n30 nfet_01v8_lvt_W4_L4_m2__nf1_gboth_sdfull_pc/B.n29 585
R34 nfet_01v8_lvt_W4_L4_m2__nf1_gboth_sdfull_pc/B.n32 nfet_01v8_lvt_W4_L4_m2__nf1_gboth_sdfull_pc/B.n31 585
R35 nfet_01v8_lvt_W4_L4_m2__nf1_gboth_sdfull_pc/B.n34 nfet_01v8_lvt_W4_L4_m2__nf1_gboth_sdfull_pc/B.n33 585
R36 nfet_01v8_lvt_W4_L4_m2__nf1_gboth_sdfull_pc/B.n36 nfet_01v8_lvt_W4_L4_m2__nf1_gboth_sdfull_pc/B.n35 585
R37 nfet_01v8_lvt_W4_L4_m2__nf1_gboth_sdfull_pc/B.n38 nfet_01v8_lvt_W4_L4_m2__nf1_gboth_sdfull_pc/B.n37 585
R38 nfet_01v8_lvt_W4_L4_m2__nf1_gboth_sdfull_pc/B.n40 nfet_01v8_lvt_W4_L4_m2__nf1_gboth_sdfull_pc/B.n39 585
R39 nfet_01v8_lvt_W4_L4_m2__nf1_gboth_sdfull_pc/B.n42 nfet_01v8_lvt_W4_L4_m2__nf1_gboth_sdfull_pc/B.n41 585
R40 nfet_01v8_lvt_W4_L4_m2__nf1_gboth_sdfull_pc/B.n44 nfet_01v8_lvt_W4_L4_m2__nf1_gboth_sdfull_pc/B.n43 585
R41 nfet_01v8_lvt_W4_L4_m2__nf1_gboth_sdfull_pc/B.n46 nfet_01v8_lvt_W4_L4_m2__nf1_gboth_sdfull_pc/B.n45 585
R42 nfet_01v8_lvt_W4_L4_m2__nf1_gboth_sdfull_pc/B.n47 nfet_01v8_lvt_W4_L4_m2__nf1_gboth_sdfull_pc/B.n26 585
R43 nfet_01v8_lvt_W4_L4_m2__nf1_gboth_sdfull_pc/B.n49 nfet_01v8_lvt_W4_L4_m2__nf1_gboth_sdfull_pc/B.n48 585
R44 nfet_01v8_lvt_W4_L4_m2__nf1_gboth_sdfull_pc/B.n20 nfet_01v8_lvt_W4_L4_m2__nf1_gboth_sdfull_pc/B.n19 585
R45 nfet_01v8_lvt_W4_L4_m2__nf1_gboth_sdfull_pc/B.n54 nfet_01v8_lvt_W4_L4_m2__nf1_gboth_sdfull_pc/B.n53 585
R46 nfet_01v8_lvt_W4_L4_m2__nf1_gboth_sdfull_pc/B.n18 nfet_01v8_lvt_W4_L4_m2__nf1_gboth_sdfull_pc/B.n17 585
R47 nfet_01v8_lvt_W4_L4_m2__nf1_gboth_sdfull_pc/B.n55 nfet_01v8_lvt_W4_L4_m2__nf1_gboth_sdfull_pc/B.n18 585
R48 nfet_01v8_lvt_W4_L4_m2__nf1_gboth_sdfull_pc/B.n58 nfet_01v8_lvt_W4_L4_m2__nf1_gboth_sdfull_pc/B.n57 585
R49 nfet_01v8_lvt_W4_L4_m2__nf1_gboth_sdfull_pc/B.n57 nfet_01v8_lvt_W4_L4_m2__nf1_gboth_sdfull_pc/B.n56 585
R50 nfet_01v8_lvt_W4_L4_m2__nf1_gboth_sdfull_pc/B.n13 nfet_01v8_lvt_W4_L4_m2__nf1_gboth_sdfull_pc/B.n12 585
R51 nfet_01v8_lvt_W4_L4_m2__nf1_gboth_sdfull_pc/B.n12 nfet_01v8_lvt_W4_L4_m2__nf1_gboth_sdfull_pc/B.n11 585
R52 nfet_01v8_lvt_W4_L4_m2__nf1_gboth_sdfull_pc/B.n65 nfet_01v8_lvt_W4_L4_m2__nf1_gboth_sdfull_pc/B.n64 585
R53 nfet_01v8_lvt_W4_L4_m2__nf1_gboth_sdfull_pc/B.n66 nfet_01v8_lvt_W4_L4_m2__nf1_gboth_sdfull_pc/B.n65 585
R54 nfet_01v8_lvt_W4_L4_m2__nf1_gboth_sdfull_pc/B.n10 nfet_01v8_lvt_W4_L4_m2__nf1_gboth_sdfull_pc/B.n9 585
R55 nfet_01v8_lvt_W4_L4_m2__nf1_gboth_sdfull_pc/B.n67 nfet_01v8_lvt_W4_L4_m2__nf1_gboth_sdfull_pc/B.n10 585
R56 nfet_01v8_lvt_W4_L4_m2__nf1_gboth_sdfull_pc/B.n71 nfet_01v8_lvt_W4_L4_m2__nf1_gboth_sdfull_pc/B.n69 585
R57 nfet_01v8_lvt_W4_L4_m2__nf1_gboth_sdfull_pc/B.n69 nfet_01v8_lvt_W4_L4_m2__nf1_gboth_sdfull_pc/B.n68 585
R58 nfet_01v8_lvt_W4_L4_m2__nf1_gboth_sdfull_pc/B.n70 nfet_01v8_lvt_W4_L4_m2__nf1_gboth_sdfull_pc/B.n2 585
R59 nfet_01v8_lvt_W4_L4_m2__nf1_gboth_sdfull_pc/B.n2 nfet_01v8_lvt_W4_L4_m2__nf1_gboth_sdfull_pc/B.n0 585
R60 nfet_01v8_lvt_W4_L4_m2__nf1_gboth_sdfull_pc/B.n139 nfet_01v8_lvt_W4_L4_m2__nf1_gboth_sdfull_pc/B.n138 585
R61 nfet_01v8_lvt_W4_L4_m2__nf1_gboth_sdfull_pc/B.n140 nfet_01v8_lvt_W4_L4_m2__nf1_gboth_sdfull_pc/B.n139 585
R62 nfet_01v8_lvt_W4_L4_m2__nf1_gboth_sdfull_pc/B.n4 nfet_01v8_lvt_W4_L4_m2__nf1_gboth_sdfull_pc/B.n3 585
R63 nfet_01v8_lvt_W4_L4_m2__nf1_gboth_sdfull_pc/B.n3 nfet_01v8_lvt_W4_L4_m2__nf1_gboth_sdfull_pc/B.n1 585
R64 nfet_01v8_lvt_W4_L4_m2__nf1_gboth_sdfull_pc/B.n132 nfet_01v8_lvt_W4_L4_m2__nf1_gboth_sdfull_pc/B.n77 585
R65 nfet_01v8_lvt_W4_L4_m2__nf1_gboth_sdfull_pc/B.n93 nfet_01v8_lvt_W4_L4_m2__nf1_gboth_sdfull_pc/B.n77 585
R66 nfet_01v8_lvt_W4_L4_m2__nf1_gboth_sdfull_pc/B.n131 nfet_01v8_lvt_W4_L4_m2__nf1_gboth_sdfull_pc/B.n78 585
R67 nfet_01v8_lvt_W4_L4_m2__nf1_gboth_sdfull_pc/B.n94 nfet_01v8_lvt_W4_L4_m2__nf1_gboth_sdfull_pc/B.n78 585
R68 nfet_01v8_lvt_W4_L4_m2__nf1_gboth_sdfull_pc/B.n130 nfet_01v8_lvt_W4_L4_m2__nf1_gboth_sdfull_pc/B.n79 585
R69 nfet_01v8_lvt_W4_L4_m2__nf1_gboth_sdfull_pc/B.n95 nfet_01v8_lvt_W4_L4_m2__nf1_gboth_sdfull_pc/B.n79 585
R70 nfet_01v8_lvt_W4_L4_m2__nf1_gboth_sdfull_pc/B.n96 nfet_01v8_lvt_W4_L4_m2__nf1_gboth_sdfull_pc/B.n80 585
R71 nfet_01v8_lvt_W4_L4_m2__nf1_gboth_sdfull_pc/B.n97 nfet_01v8_lvt_W4_L4_m2__nf1_gboth_sdfull_pc/B.n96 585
R72 nfet_01v8_lvt_W4_L4_m2__nf1_gboth_sdfull_pc/B.n124 nfet_01v8_lvt_W4_L4_m2__nf1_gboth_sdfull_pc/B.n84 585
R73 nfet_01v8_lvt_W4_L4_m2__nf1_gboth_sdfull_pc/B.n98 nfet_01v8_lvt_W4_L4_m2__nf1_gboth_sdfull_pc/B.n84 585
R74 nfet_01v8_lvt_W4_L4_m2__nf1_gboth_sdfull_pc/B.n100 nfet_01v8_lvt_W4_L4_m2__nf1_gboth_sdfull_pc/B.n99 585
R75 nfet_01v8_lvt_W4_L4_m2__nf1_gboth_sdfull_pc/B.n102 nfet_01v8_lvt_W4_L4_m2__nf1_gboth_sdfull_pc/B.n101 585
R76 nfet_01v8_lvt_W4_L4_m2__nf1_gboth_sdfull_pc/B.n123 nfet_01v8_lvt_W4_L4_m2__nf1_gboth_sdfull_pc/B.n87 585
R77 nfet_01v8_lvt_W4_L4_m2__nf1_gboth_sdfull_pc/B.n103 nfet_01v8_lvt_W4_L4_m2__nf1_gboth_sdfull_pc/B.n87 585
R78 nfet_01v8_lvt_W4_L4_m2__nf1_gboth_sdfull_pc/B.n105 nfet_01v8_lvt_W4_L4_m2__nf1_gboth_sdfull_pc/B.n104 585
R79 nfet_01v8_lvt_W4_L4_m2__nf1_gboth_sdfull_pc/B.n107 nfet_01v8_lvt_W4_L4_m2__nf1_gboth_sdfull_pc/B.n106 585
R80 nfet_01v8_lvt_W4_L4_m2__nf1_gboth_sdfull_pc/B.n123 nfet_01v8_lvt_W4_L4_m2__nf1_gboth_sdfull_pc/B.n90 585
R81 nfet_01v8_lvt_W4_L4_m2__nf1_gboth_sdfull_pc/B.n108 nfet_01v8_lvt_W4_L4_m2__nf1_gboth_sdfull_pc/B.n90 585
R82 nfet_01v8_lvt_W4_L4_m2__nf1_gboth_sdfull_pc/B.n110 nfet_01v8_lvt_W4_L4_m2__nf1_gboth_sdfull_pc/B.n109 585
R83 nfet_01v8_lvt_W4_L4_m2__nf1_gboth_sdfull_pc/B.n112 nfet_01v8_lvt_W4_L4_m2__nf1_gboth_sdfull_pc/B.n111 585
R84 nfet_01v8_lvt_W4_L4_m2__nf1_gboth_sdfull_pc/B.n114 nfet_01v8_lvt_W4_L4_m2__nf1_gboth_sdfull_pc/B.n113 585
R85 nfet_01v8_lvt_W4_L4_m2__nf1_gboth_sdfull_pc/B.n116 nfet_01v8_lvt_W4_L4_m2__nf1_gboth_sdfull_pc/B.n115 585
R86 nfet_01v8_lvt_W4_L4_m2__nf1_gboth_sdfull_pc/B.n118 nfet_01v8_lvt_W4_L4_m2__nf1_gboth_sdfull_pc/B.n117 585
R87 nfet_01v8_lvt_W4_L4_m2__nf1_gboth_sdfull_pc/B.n119 nfet_01v8_lvt_W4_L4_m2__nf1_gboth_sdfull_pc/B.n92 585
R88 nfet_01v8_lvt_W4_L4_m2__nf1_gboth_sdfull_pc/B.n121 nfet_01v8_lvt_W4_L4_m2__nf1_gboth_sdfull_pc/B.n120 585
R89 nfet_01v8_lvt_W4_L4_m2__nf1_gboth_sdfull_pc/B.n83 nfet_01v8_lvt_W4_L4_m2__nf1_gboth_sdfull_pc/B.n82 585
R90 nfet_01v8_lvt_W4_L4_m2__nf1_gboth_sdfull_pc/B.n101 nfet_01v8_lvt_W4_L4_m2__nf1_gboth_sdfull_pc/B.n87 394
R91 nfet_01v8_lvt_W4_L4_m2__nf1_gboth_sdfull_pc/B.n104 nfet_01v8_lvt_W4_L4_m2__nf1_gboth_sdfull_pc/B.n87 394
R92 nfet_01v8_lvt_W4_L4_m2__nf1_gboth_sdfull_pc/B.n106 nfet_01v8_lvt_W4_L4_m2__nf1_gboth_sdfull_pc/B.n90 394
R93 nfet_01v8_lvt_W4_L4_m2__nf1_gboth_sdfull_pc/B.n109 nfet_01v8_lvt_W4_L4_m2__nf1_gboth_sdfull_pc/B.n90 394
R94 nfet_01v8_lvt_W4_L4_m2__nf1_gboth_sdfull_pc/B.n113 nfet_01v8_lvt_W4_L4_m2__nf1_gboth_sdfull_pc/B.n112 394
R95 nfet_01v8_lvt_W4_L4_m2__nf1_gboth_sdfull_pc/B.n117 nfet_01v8_lvt_W4_L4_m2__nf1_gboth_sdfull_pc/B.n116 394
R96 nfet_01v8_lvt_W4_L4_m2__nf1_gboth_sdfull_pc/B.n121 nfet_01v8_lvt_W4_L4_m2__nf1_gboth_sdfull_pc/B.n92 394
R97 nfet_01v8_lvt_W4_L4_m2__nf1_gboth_sdfull_pc/B.n96 nfet_01v8_lvt_W4_L4_m2__nf1_gboth_sdfull_pc/B.n84 394
R98 nfet_01v8_lvt_W4_L4_m2__nf1_gboth_sdfull_pc/B.n96 nfet_01v8_lvt_W4_L4_m2__nf1_gboth_sdfull_pc/B.n79 394
R99 nfet_01v8_lvt_W4_L4_m2__nf1_gboth_sdfull_pc/B.n79 nfet_01v8_lvt_W4_L4_m2__nf1_gboth_sdfull_pc/B.n78 394
R100 nfet_01v8_lvt_W4_L4_m2__nf1_gboth_sdfull_pc/B.n78 nfet_01v8_lvt_W4_L4_m2__nf1_gboth_sdfull_pc/B.n77 394
R101 nfet_01v8_lvt_W4_L4_m2__nf1_gboth_sdfull_pc/B.n77 nfet_01v8_lvt_W4_L4_m2__nf1_gboth_sdfull_pc/B.n3 394
R102 nfet_01v8_lvt_W4_L4_m2__nf1_gboth_sdfull_pc/B.n139 nfet_01v8_lvt_W4_L4_m2__nf1_gboth_sdfull_pc/B.n3 394
R103 nfet_01v8_lvt_W4_L4_m2__nf1_gboth_sdfull_pc/B.n139 nfet_01v8_lvt_W4_L4_m2__nf1_gboth_sdfull_pc/B.n2 394
R104 nfet_01v8_lvt_W4_L4_m2__nf1_gboth_sdfull_pc/B.n69 nfet_01v8_lvt_W4_L4_m2__nf1_gboth_sdfull_pc/B.n2 394
R105 nfet_01v8_lvt_W4_L4_m2__nf1_gboth_sdfull_pc/B.n69 nfet_01v8_lvt_W4_L4_m2__nf1_gboth_sdfull_pc/B.n10 394
R106 nfet_01v8_lvt_W4_L4_m2__nf1_gboth_sdfull_pc/B.n65 nfet_01v8_lvt_W4_L4_m2__nf1_gboth_sdfull_pc/B.n10 394
R107 nfet_01v8_lvt_W4_L4_m2__nf1_gboth_sdfull_pc/B.n65 nfet_01v8_lvt_W4_L4_m2__nf1_gboth_sdfull_pc/B.n12 394
R108 nfet_01v8_lvt_W4_L4_m2__nf1_gboth_sdfull_pc/B.n57 nfet_01v8_lvt_W4_L4_m2__nf1_gboth_sdfull_pc/B.n12 394
R109 nfet_01v8_lvt_W4_L4_m2__nf1_gboth_sdfull_pc/B.n57 nfet_01v8_lvt_W4_L4_m2__nf1_gboth_sdfull_pc/B.n18 394
R110 nfet_01v8_lvt_W4_L4_m2__nf1_gboth_sdfull_pc/B.n49 nfet_01v8_lvt_W4_L4_m2__nf1_gboth_sdfull_pc/B.n20 394
R111 nfet_01v8_lvt_W4_L4_m2__nf1_gboth_sdfull_pc/B.n45 nfet_01v8_lvt_W4_L4_m2__nf1_gboth_sdfull_pc/B.n26 394
R112 nfet_01v8_lvt_W4_L4_m2__nf1_gboth_sdfull_pc/B.n43 nfet_01v8_lvt_W4_L4_m2__nf1_gboth_sdfull_pc/B.n42 394
R113 nfet_01v8_lvt_W4_L4_m2__nf1_gboth_sdfull_pc/B.n39 nfet_01v8_lvt_W4_L4_m2__nf1_gboth_sdfull_pc/B.n38 394
R114 nfet_01v8_lvt_W4_L4_m2__nf1_gboth_sdfull_pc/B.n35 nfet_01v8_lvt_W4_L4_m2__nf1_gboth_sdfull_pc/B.n34 394
R115 nfet_01v8_lvt_W4_L4_m2__nf1_gboth_sdfull_pc/B.n31 nfet_01v8_lvt_W4_L4_m2__nf1_gboth_sdfull_pc/B.n30 394
R116 nfet_01v8_lvt_W4_L4_m2__nf1_gboth_sdfull_pc/B.n125 nfet_01v8_lvt_W4_L4_m2__nf1_gboth_sdfull_pc/B.n81 394
R117 nfet_01v8_lvt_W4_L4_m2__nf1_gboth_sdfull_pc/B.n129 nfet_01v8_lvt_W4_L4_m2__nf1_gboth_sdfull_pc/B.n81 394
R118 nfet_01v8_lvt_W4_L4_m2__nf1_gboth_sdfull_pc/B.n129 nfet_01v8_lvt_W4_L4_m2__nf1_gboth_sdfull_pc/B.n76 394
R119 nfet_01v8_lvt_W4_L4_m2__nf1_gboth_sdfull_pc/B.n133 nfet_01v8_lvt_W4_L4_m2__nf1_gboth_sdfull_pc/B.n76 394
R120 nfet_01v8_lvt_W4_L4_m2__nf1_gboth_sdfull_pc/B.n133 nfet_01v8_lvt_W4_L4_m2__nf1_gboth_sdfull_pc/B.n6 394
R121 nfet_01v8_lvt_W4_L4_m2__nf1_gboth_sdfull_pc/B.n137 nfet_01v8_lvt_W4_L4_m2__nf1_gboth_sdfull_pc/B.n6 394
R122 nfet_01v8_lvt_W4_L4_m2__nf1_gboth_sdfull_pc/B.n137 nfet_01v8_lvt_W4_L4_m2__nf1_gboth_sdfull_pc/B.n5 394
R123 nfet_01v8_lvt_W4_L4_m2__nf1_gboth_sdfull_pc/B.n72 nfet_01v8_lvt_W4_L4_m2__nf1_gboth_sdfull_pc/B.n5 394
R124 nfet_01v8_lvt_W4_L4_m2__nf1_gboth_sdfull_pc/B.n72 nfet_01v8_lvt_W4_L4_m2__nf1_gboth_sdfull_pc/B.n8 394
R125 nfet_01v8_lvt_W4_L4_m2__nf1_gboth_sdfull_pc/B.n63 nfet_01v8_lvt_W4_L4_m2__nf1_gboth_sdfull_pc/B.n8 394
R126 nfet_01v8_lvt_W4_L4_m2__nf1_gboth_sdfull_pc/B.n63 nfet_01v8_lvt_W4_L4_m2__nf1_gboth_sdfull_pc/B.n14 394
R127 nfet_01v8_lvt_W4_L4_m2__nf1_gboth_sdfull_pc/B.n59 nfet_01v8_lvt_W4_L4_m2__nf1_gboth_sdfull_pc/B.n14 394
R128 nfet_01v8_lvt_W4_L4_m2__nf1_gboth_sdfull_pc/B.n59 nfet_01v8_lvt_W4_L4_m2__nf1_gboth_sdfull_pc/B.n16 394
R129 nfet_01v8_lvt_W4_L4_m2__nf1_gboth_sdfull_pc/B.n124 nfet_01v8_lvt_W4_L4_m2__nf1_gboth_sdfull_pc/B.n123 370.334
R130 nfet_01v8_lvt_W4_L4_m2__nf1_gboth_sdfull_pc/B.n51 nfet_01v8_lvt_W4_L4_m2__nf1_gboth_sdfull_pc/B.n17 370.334
R131 nfet_01v8_lvt_W4_L4_m2__nf1_gboth_sdfull_pc/B.n124 nfet_01v8_lvt_W4_L4_m2__nf1_gboth_sdfull_pc/B.n80 249.333
R132 nfet_01v8_lvt_W4_L4_m2__nf1_gboth_sdfull_pc/B.n130 nfet_01v8_lvt_W4_L4_m2__nf1_gboth_sdfull_pc/B.n80 249.333
R133 nfet_01v8_lvt_W4_L4_m2__nf1_gboth_sdfull_pc/B.n131 nfet_01v8_lvt_W4_L4_m2__nf1_gboth_sdfull_pc/B.n130 249.333
R134 nfet_01v8_lvt_W4_L4_m2__nf1_gboth_sdfull_pc/B.n132 nfet_01v8_lvt_W4_L4_m2__nf1_gboth_sdfull_pc/B.n131 249.333
R135 nfet_01v8_lvt_W4_L4_m2__nf1_gboth_sdfull_pc/B.n132 nfet_01v8_lvt_W4_L4_m2__nf1_gboth_sdfull_pc/B.n4 249.333
R136 nfet_01v8_lvt_W4_L4_m2__nf1_gboth_sdfull_pc/B.n138 nfet_01v8_lvt_W4_L4_m2__nf1_gboth_sdfull_pc/B.n4 249.333
R137 nfet_01v8_lvt_W4_L4_m2__nf1_gboth_sdfull_pc/B.n71 nfet_01v8_lvt_W4_L4_m2__nf1_gboth_sdfull_pc/B.n70 249.333
R138 nfet_01v8_lvt_W4_L4_m2__nf1_gboth_sdfull_pc/B.n71 nfet_01v8_lvt_W4_L4_m2__nf1_gboth_sdfull_pc/B.n9 249.333
R139 nfet_01v8_lvt_W4_L4_m2__nf1_gboth_sdfull_pc/B.n64 nfet_01v8_lvt_W4_L4_m2__nf1_gboth_sdfull_pc/B.n9 249.333
R140 nfet_01v8_lvt_W4_L4_m2__nf1_gboth_sdfull_pc/B.n64 nfet_01v8_lvt_W4_L4_m2__nf1_gboth_sdfull_pc/B.n13 249.333
R141 nfet_01v8_lvt_W4_L4_m2__nf1_gboth_sdfull_pc/B.n58 nfet_01v8_lvt_W4_L4_m2__nf1_gboth_sdfull_pc/B.n13 249.333
R142 nfet_01v8_lvt_W4_L4_m2__nf1_gboth_sdfull_pc/B.n58 nfet_01v8_lvt_W4_L4_m2__nf1_gboth_sdfull_pc/B.n17 249.333
R143 nfet_01v8_lvt_W4_L4_m2__nf1_gboth_sdfull_pc/B.n51 nfet_01v8_lvt_W4_L4_m2__nf1_gboth_sdfull_pc/B.n21 218.815
R144 nfet_01v8_lvt_W4_L4_m2__nf1_gboth_sdfull_pc/B.n51 nfet_01v8_lvt_W4_L4_m2__nf1_gboth_sdfull_pc/B.n22 218.815
R145 nfet_01v8_lvt_W4_L4_m2__nf1_gboth_sdfull_pc/B.n51 nfet_01v8_lvt_W4_L4_m2__nf1_gboth_sdfull_pc/B.n23 218.815
R146 nfet_01v8_lvt_W4_L4_m2__nf1_gboth_sdfull_pc/B.n51 nfet_01v8_lvt_W4_L4_m2__nf1_gboth_sdfull_pc/B.n24 218.815
R147 nfet_01v8_lvt_W4_L4_m2__nf1_gboth_sdfull_pc/B.n51 nfet_01v8_lvt_W4_L4_m2__nf1_gboth_sdfull_pc/B.n25 218.815
R148 nfet_01v8_lvt_W4_L4_m2__nf1_gboth_sdfull_pc/B.n51 nfet_01v8_lvt_W4_L4_m2__nf1_gboth_sdfull_pc/B.n50 218.815
R149 nfet_01v8_lvt_W4_L4_m2__nf1_gboth_sdfull_pc/B.n52 nfet_01v8_lvt_W4_L4_m2__nf1_gboth_sdfull_pc/B.n51 218.815
R150 nfet_01v8_lvt_W4_L4_m2__nf1_gboth_sdfull_pc/B.n123 nfet_01v8_lvt_W4_L4_m2__nf1_gboth_sdfull_pc/B.n88 218.815
R151 nfet_01v8_lvt_W4_L4_m2__nf1_gboth_sdfull_pc/B.n123 nfet_01v8_lvt_W4_L4_m2__nf1_gboth_sdfull_pc/B.n89 218.815
R152 nfet_01v8_lvt_W4_L4_m2__nf1_gboth_sdfull_pc/B.n123 nfet_01v8_lvt_W4_L4_m2__nf1_gboth_sdfull_pc/B.n86 218.815
R153 nfet_01v8_lvt_W4_L4_m2__nf1_gboth_sdfull_pc/B.n123 nfet_01v8_lvt_W4_L4_m2__nf1_gboth_sdfull_pc/B.n85 218.815
R154 nfet_01v8_lvt_W4_L4_m2__nf1_gboth_sdfull_pc/B.n123 nfet_01v8_lvt_W4_L4_m2__nf1_gboth_sdfull_pc/B.n91 218.815
R155 nfet_01v8_lvt_W4_L4_m2__nf1_gboth_sdfull_pc/B.n123 nfet_01v8_lvt_W4_L4_m2__nf1_gboth_sdfull_pc/B.n122 218.815
R156 nfet_01v8_lvt_W4_L4_m2__nf1_gboth_sdfull_pc/B.n123 B 157.667
R157 nfet_01v8_lvt_W4_L4_m2__nf1_gboth_sdfull_pc/B.n27 nfet_01v8_lvt_W4_L4_m2__nf1_gboth_sdfull_pc/B.n21 147.374
R158 nfet_01v8_lvt_W4_L4_m2__nf1_gboth_sdfull_pc/B.n31 nfet_01v8_lvt_W4_L4_m2__nf1_gboth_sdfull_pc/B.n22 147.374
R159 nfet_01v8_lvt_W4_L4_m2__nf1_gboth_sdfull_pc/B.n35 nfet_01v8_lvt_W4_L4_m2__nf1_gboth_sdfull_pc/B.n23 147.374
R160 nfet_01v8_lvt_W4_L4_m2__nf1_gboth_sdfull_pc/B.n39 nfet_01v8_lvt_W4_L4_m2__nf1_gboth_sdfull_pc/B.n24 147.374
R161 nfet_01v8_lvt_W4_L4_m2__nf1_gboth_sdfull_pc/B.n43 nfet_01v8_lvt_W4_L4_m2__nf1_gboth_sdfull_pc/B.n25 147.374
R162 nfet_01v8_lvt_W4_L4_m2__nf1_gboth_sdfull_pc/B.n50 nfet_01v8_lvt_W4_L4_m2__nf1_gboth_sdfull_pc/B.n26 147.374
R163 nfet_01v8_lvt_W4_L4_m2__nf1_gboth_sdfull_pc/B.n52 nfet_01v8_lvt_W4_L4_m2__nf1_gboth_sdfull_pc/B.n20 147.374
R164 nfet_01v8_lvt_W4_L4_m2__nf1_gboth_sdfull_pc/B.n101 nfet_01v8_lvt_W4_L4_m2__nf1_gboth_sdfull_pc/B.n88 147.374
R165 nfet_01v8_lvt_W4_L4_m2__nf1_gboth_sdfull_pc/B.n106 nfet_01v8_lvt_W4_L4_m2__nf1_gboth_sdfull_pc/B.n89 147.374
R166 nfet_01v8_lvt_W4_L4_m2__nf1_gboth_sdfull_pc/B.n112 nfet_01v8_lvt_W4_L4_m2__nf1_gboth_sdfull_pc/B.n86 147.374
R167 nfet_01v8_lvt_W4_L4_m2__nf1_gboth_sdfull_pc/B.n116 nfet_01v8_lvt_W4_L4_m2__nf1_gboth_sdfull_pc/B.n85 147.374
R168 nfet_01v8_lvt_W4_L4_m2__nf1_gboth_sdfull_pc/B.n117 nfet_01v8_lvt_W4_L4_m2__nf1_gboth_sdfull_pc/B.n91 147.374
R169 nfet_01v8_lvt_W4_L4_m2__nf1_gboth_sdfull_pc/B.n122 nfet_01v8_lvt_W4_L4_m2__nf1_gboth_sdfull_pc/B.n121 147.374
R170 nfet_01v8_lvt_W4_L4_m2__nf1_gboth_sdfull_pc/B.n99 nfet_01v8_lvt_W4_L4_m2__nf1_gboth_sdfull_pc/B.n88 147.374
R171 nfet_01v8_lvt_W4_L4_m2__nf1_gboth_sdfull_pc/B.n104 nfet_01v8_lvt_W4_L4_m2__nf1_gboth_sdfull_pc/B.n89 147.374
R172 nfet_01v8_lvt_W4_L4_m2__nf1_gboth_sdfull_pc/B.n109 nfet_01v8_lvt_W4_L4_m2__nf1_gboth_sdfull_pc/B.n86 147.374
R173 nfet_01v8_lvt_W4_L4_m2__nf1_gboth_sdfull_pc/B.n113 nfet_01v8_lvt_W4_L4_m2__nf1_gboth_sdfull_pc/B.n85 147.374
R174 nfet_01v8_lvt_W4_L4_m2__nf1_gboth_sdfull_pc/B.n92 nfet_01v8_lvt_W4_L4_m2__nf1_gboth_sdfull_pc/B.n91 147.374
R175 nfet_01v8_lvt_W4_L4_m2__nf1_gboth_sdfull_pc/B.n122 nfet_01v8_lvt_W4_L4_m2__nf1_gboth_sdfull_pc/B.n83 147.374
R176 nfet_01v8_lvt_W4_L4_m2__nf1_gboth_sdfull_pc/B.n53 nfet_01v8_lvt_W4_L4_m2__nf1_gboth_sdfull_pc/B.n52 147.374
R177 nfet_01v8_lvt_W4_L4_m2__nf1_gboth_sdfull_pc/B.n50 nfet_01v8_lvt_W4_L4_m2__nf1_gboth_sdfull_pc/B.n49 147.374
R178 nfet_01v8_lvt_W4_L4_m2__nf1_gboth_sdfull_pc/B.n45 nfet_01v8_lvt_W4_L4_m2__nf1_gboth_sdfull_pc/B.n25 147.374
R179 nfet_01v8_lvt_W4_L4_m2__nf1_gboth_sdfull_pc/B.n42 nfet_01v8_lvt_W4_L4_m2__nf1_gboth_sdfull_pc/B.n24 147.374
R180 nfet_01v8_lvt_W4_L4_m2__nf1_gboth_sdfull_pc/B.n38 nfet_01v8_lvt_W4_L4_m2__nf1_gboth_sdfull_pc/B.n23 147.374
R181 nfet_01v8_lvt_W4_L4_m2__nf1_gboth_sdfull_pc/B.n34 nfet_01v8_lvt_W4_L4_m2__nf1_gboth_sdfull_pc/B.n22 147.374
R182 nfet_01v8_lvt_W4_L4_m2__nf1_gboth_sdfull_pc/B.n30 nfet_01v8_lvt_W4_L4_m2__nf1_gboth_sdfull_pc/B.n21 147.374
R183 nfet_01v8_lvt_W4_L4_m2__nf1_gboth_sdfull_pc/B.n138 nfet_01v8_lvt_W4_L4_m2__nf1_gboth_sdfull_pc/B.t0 124.668
R184 nfet_01v8_lvt_W4_L4_m2__nf1_gboth_sdfull_pc/B.n70 nfet_01v8_lvt_W4_L4_m2__nf1_gboth_sdfull_pc/B.t0 124.668
R185 nfet_01v8_lvt_W4_L4_m2__nf1_gboth_sdfull_pc/B.n100 nfet_01v8_lvt_W4_L4_m2__nf1_gboth_sdfull_pc/B.n98 74.9181
R186 nfet_01v8_lvt_W4_L4_m2__nf1_gboth_sdfull_pc/B.n55 nfet_01v8_lvt_W4_L4_m2__nf1_gboth_sdfull_pc/B.n54 74.9181
R187 nfet_01v8_lvt_W4_L4_m2__nf1_gboth_sdfull_pc/B.n126 nfet_01v8_lvt_W4_L4_m2__nf1_gboth_sdfull_pc/B.n82 74.9181
R188 nfet_01v8_lvt_W4_L4_m2__nf1_gboth_sdfull_pc/B.n28 nfet_01v8_lvt_W4_L4_m2__nf1_gboth_sdfull_pc/B.n15 74.9181
R189 nfet_01v8_lvt_W4_L4_m2__nf1_gboth_sdfull_pc/B.n102 nfet_01v8_lvt_W4_L4_m2__nf1_gboth_sdfull_pc/B.n100 25.6005
R190 nfet_01v8_lvt_W4_L4_m2__nf1_gboth_sdfull_pc/B.n103 nfet_01v8_lvt_W4_L4_m2__nf1_gboth_sdfull_pc/B.n102 25.6005
R191 nfet_01v8_lvt_W4_L4_m2__nf1_gboth_sdfull_pc/B.n105 nfet_01v8_lvt_W4_L4_m2__nf1_gboth_sdfull_pc/B.n103 25.6005
R192 nfet_01v8_lvt_W4_L4_m2__nf1_gboth_sdfull_pc/B.n107 nfet_01v8_lvt_W4_L4_m2__nf1_gboth_sdfull_pc/B.n105 25.6005
R193 nfet_01v8_lvt_W4_L4_m2__nf1_gboth_sdfull_pc/B.n108 nfet_01v8_lvt_W4_L4_m2__nf1_gboth_sdfull_pc/B.n107 25.6005
R194 nfet_01v8_lvt_W4_L4_m2__nf1_gboth_sdfull_pc/B.n110 nfet_01v8_lvt_W4_L4_m2__nf1_gboth_sdfull_pc/B.n108 25.6005
R195 nfet_01v8_lvt_W4_L4_m2__nf1_gboth_sdfull_pc/B.n111 nfet_01v8_lvt_W4_L4_m2__nf1_gboth_sdfull_pc/B.n110 25.6005
R196 nfet_01v8_lvt_W4_L4_m2__nf1_gboth_sdfull_pc/B.n114 nfet_01v8_lvt_W4_L4_m2__nf1_gboth_sdfull_pc/B.n111 25.6005
R197 nfet_01v8_lvt_W4_L4_m2__nf1_gboth_sdfull_pc/B.n115 nfet_01v8_lvt_W4_L4_m2__nf1_gboth_sdfull_pc/B.n114 25.6005
R198 nfet_01v8_lvt_W4_L4_m2__nf1_gboth_sdfull_pc/B.n118 nfet_01v8_lvt_W4_L4_m2__nf1_gboth_sdfull_pc/B.n115 25.6005
R199 nfet_01v8_lvt_W4_L4_m2__nf1_gboth_sdfull_pc/B.n119 nfet_01v8_lvt_W4_L4_m2__nf1_gboth_sdfull_pc/B.n118 25.6005
R200 nfet_01v8_lvt_W4_L4_m2__nf1_gboth_sdfull_pc/B.n120 nfet_01v8_lvt_W4_L4_m2__nf1_gboth_sdfull_pc/B.n119 25.6005
R201 nfet_01v8_lvt_W4_L4_m2__nf1_gboth_sdfull_pc/B.n120 nfet_01v8_lvt_W4_L4_m2__nf1_gboth_sdfull_pc/B.n82 25.6005
R202 nfet_01v8_lvt_W4_L4_m2__nf1_gboth_sdfull_pc/B.n98 nfet_01v8_lvt_W4_L4_m2__nf1_gboth_sdfull_pc/B.n97 25.6005
R203 nfet_01v8_lvt_W4_L4_m2__nf1_gboth_sdfull_pc/B.n97 nfet_01v8_lvt_W4_L4_m2__nf1_gboth_sdfull_pc/B.n95 25.6005
R204 nfet_01v8_lvt_W4_L4_m2__nf1_gboth_sdfull_pc/B.n95 nfet_01v8_lvt_W4_L4_m2__nf1_gboth_sdfull_pc/B.n94 25.6005
R205 nfet_01v8_lvt_W4_L4_m2__nf1_gboth_sdfull_pc/B.n94 nfet_01v8_lvt_W4_L4_m2__nf1_gboth_sdfull_pc/B.n93 25.6005
R206 nfet_01v8_lvt_W4_L4_m2__nf1_gboth_sdfull_pc/B.n93 nfet_01v8_lvt_W4_L4_m2__nf1_gboth_sdfull_pc/B.n1 25.6005
R207 nfet_01v8_lvt_W4_L4_m2__nf1_gboth_sdfull_pc/B.n140 nfet_01v8_lvt_W4_L4_m2__nf1_gboth_sdfull_pc/B.n1 25.6005
R208 nfet_01v8_lvt_W4_L4_m2__nf1_gboth_sdfull_pc/B.n68 nfet_01v8_lvt_W4_L4_m2__nf1_gboth_sdfull_pc/B.n0 25.6005
R209 nfet_01v8_lvt_W4_L4_m2__nf1_gboth_sdfull_pc/B.n68 nfet_01v8_lvt_W4_L4_m2__nf1_gboth_sdfull_pc/B.n67 25.6005
R210 nfet_01v8_lvt_W4_L4_m2__nf1_gboth_sdfull_pc/B.n67 nfet_01v8_lvt_W4_L4_m2__nf1_gboth_sdfull_pc/B.n66 25.6005
R211 nfet_01v8_lvt_W4_L4_m2__nf1_gboth_sdfull_pc/B.n66 nfet_01v8_lvt_W4_L4_m2__nf1_gboth_sdfull_pc/B.n11 25.6005
R212 nfet_01v8_lvt_W4_L4_m2__nf1_gboth_sdfull_pc/B.n56 nfet_01v8_lvt_W4_L4_m2__nf1_gboth_sdfull_pc/B.n11 25.6005
R213 nfet_01v8_lvt_W4_L4_m2__nf1_gboth_sdfull_pc/B.n56 nfet_01v8_lvt_W4_L4_m2__nf1_gboth_sdfull_pc/B.n55 25.6005
R214 nfet_01v8_lvt_W4_L4_m2__nf1_gboth_sdfull_pc/B.n54 nfet_01v8_lvt_W4_L4_m2__nf1_gboth_sdfull_pc/B.n19 25.6005
R215 nfet_01v8_lvt_W4_L4_m2__nf1_gboth_sdfull_pc/B.n48 nfet_01v8_lvt_W4_L4_m2__nf1_gboth_sdfull_pc/B.n19 25.6005
R216 nfet_01v8_lvt_W4_L4_m2__nf1_gboth_sdfull_pc/B.n48 nfet_01v8_lvt_W4_L4_m2__nf1_gboth_sdfull_pc/B.n47 25.6005
R217 nfet_01v8_lvt_W4_L4_m2__nf1_gboth_sdfull_pc/B.n47 nfet_01v8_lvt_W4_L4_m2__nf1_gboth_sdfull_pc/B.n46 25.6005
R218 nfet_01v8_lvt_W4_L4_m2__nf1_gboth_sdfull_pc/B.n46 nfet_01v8_lvt_W4_L4_m2__nf1_gboth_sdfull_pc/B.n44 25.6005
R219 nfet_01v8_lvt_W4_L4_m2__nf1_gboth_sdfull_pc/B.n44 nfet_01v8_lvt_W4_L4_m2__nf1_gboth_sdfull_pc/B.n41 25.6005
R220 nfet_01v8_lvt_W4_L4_m2__nf1_gboth_sdfull_pc/B.n41 nfet_01v8_lvt_W4_L4_m2__nf1_gboth_sdfull_pc/B.n40 25.6005
R221 nfet_01v8_lvt_W4_L4_m2__nf1_gboth_sdfull_pc/B.n40 nfet_01v8_lvt_W4_L4_m2__nf1_gboth_sdfull_pc/B.n37 25.6005
R222 nfet_01v8_lvt_W4_L4_m2__nf1_gboth_sdfull_pc/B.n37 nfet_01v8_lvt_W4_L4_m2__nf1_gboth_sdfull_pc/B.n36 25.6005
R223 nfet_01v8_lvt_W4_L4_m2__nf1_gboth_sdfull_pc/B.n36 nfet_01v8_lvt_W4_L4_m2__nf1_gboth_sdfull_pc/B.n33 25.6005
R224 nfet_01v8_lvt_W4_L4_m2__nf1_gboth_sdfull_pc/B.n33 nfet_01v8_lvt_W4_L4_m2__nf1_gboth_sdfull_pc/B.n32 25.6005
R225 nfet_01v8_lvt_W4_L4_m2__nf1_gboth_sdfull_pc/B.n32 nfet_01v8_lvt_W4_L4_m2__nf1_gboth_sdfull_pc/B.n29 25.6005
R226 nfet_01v8_lvt_W4_L4_m2__nf1_gboth_sdfull_pc/B.n29 nfet_01v8_lvt_W4_L4_m2__nf1_gboth_sdfull_pc/B.n28 25.6005
R227 nfet_01v8_lvt_W4_L4_m2__nf1_gboth_sdfull_pc/B.n127 nfet_01v8_lvt_W4_L4_m2__nf1_gboth_sdfull_pc/B.n126 25.6005
R228 nfet_01v8_lvt_W4_L4_m2__nf1_gboth_sdfull_pc/B.n128 nfet_01v8_lvt_W4_L4_m2__nf1_gboth_sdfull_pc/B.n127 25.6005
R229 nfet_01v8_lvt_W4_L4_m2__nf1_gboth_sdfull_pc/B.n128 nfet_01v8_lvt_W4_L4_m2__nf1_gboth_sdfull_pc/B.n75 25.6005
R230 nfet_01v8_lvt_W4_L4_m2__nf1_gboth_sdfull_pc/B.n134 nfet_01v8_lvt_W4_L4_m2__nf1_gboth_sdfull_pc/B.n75 25.6005
R231 nfet_01v8_lvt_W4_L4_m2__nf1_gboth_sdfull_pc/B.n135 nfet_01v8_lvt_W4_L4_m2__nf1_gboth_sdfull_pc/B.n134 25.6005
R232 nfet_01v8_lvt_W4_L4_m2__nf1_gboth_sdfull_pc/B.n136 nfet_01v8_lvt_W4_L4_m2__nf1_gboth_sdfull_pc/B.n135 25.6005
R233 nfet_01v8_lvt_W4_L4_m2__nf1_gboth_sdfull_pc/B.n136 nfet_01v8_lvt_W4_L4_m2__nf1_gboth_sdfull_pc/B.n74 25.6005
R234 nfet_01v8_lvt_W4_L4_m2__nf1_gboth_sdfull_pc/B.n74 nfet_01v8_lvt_W4_L4_m2__nf1_gboth_sdfull_pc/B.n73 25.6005
R235 nfet_01v8_lvt_W4_L4_m2__nf1_gboth_sdfull_pc/B.n73 nfet_01v8_lvt_W4_L4_m2__nf1_gboth_sdfull_pc/B.n7 25.6005
R236 nfet_01v8_lvt_W4_L4_m2__nf1_gboth_sdfull_pc/B.n62 nfet_01v8_lvt_W4_L4_m2__nf1_gboth_sdfull_pc/B.n7 25.6005
R237 nfet_01v8_lvt_W4_L4_m2__nf1_gboth_sdfull_pc/B.n62 nfet_01v8_lvt_W4_L4_m2__nf1_gboth_sdfull_pc/B.n61 25.6005
R238 nfet_01v8_lvt_W4_L4_m2__nf1_gboth_sdfull_pc/B.n61 nfet_01v8_lvt_W4_L4_m2__nf1_gboth_sdfull_pc/B.n60 25.6005
R239 nfet_01v8_lvt_W4_L4_m2__nf1_gboth_sdfull_pc/B.n60 nfet_01v8_lvt_W4_L4_m2__nf1_gboth_sdfull_pc/B.n15 25.6005
R240 B nfet_01v8_lvt_W4_L4_m2__nf1_gboth_sdfull_pc/B.n0 19.2005
R241 B nfet_01v8_lvt_W4_L4_m2__nf1_gboth_sdfull_pc/B.n140 6.4005
R242 B.n123 B.n11 1153.03
R243 B.n130 B.n6 1153.03
R244 B.n71 B.n33 1153.03
R245 B.n69 B.n35 1153.03
R246 B.n121 B.n11 585
R247 B.n120 B.n119 585
R248 B.n118 B.n106 585
R249 B.n116 B.n115 585
R250 B.n114 B.n108 585
R251 B.n113 B.n112 585
R252 B.n111 B.n109 585
R253 B.n141 B.n140 585
R254 B.n139 B.n0 585
R255 B.n137 B.n136 585
R256 B.n135 B.n3 585
R257 B.n134 B.n133 585
R258 B.n132 B.n4 585
R259 B.n130 B.n129 585
R260 B.n124 B.n6 585
R261 B.n128 B.n6 585
R262 B.n126 B.n125 585
R263 B.n127 B.n126 585
R264 B.n9 B.n8 585
R265 B.n8 B.n7 585
R266 B.n101 B.n100 585
R267 B.n100 B.n99 585
R268 B.n15 B.n14 585
R269 B.n98 B.n15 585
R270 B.n96 B.n95 585
R271 B.n97 B.n96 585
R272 B.n18 B.n17 585
R273 B.n17 B.n16 585
R274 B.n88 B.n87 585
R275 B.n87 B.n86 585
R276 B.n23 B.n22 585
R277 B.n85 B.n23 585
R278 B.n83 B.n82 585
R279 B.n84 B.n83 585
R280 B.n26 B.n25 585
R281 B.n25 B.n24 585
R282 B.n76 B.n75 585
R283 B.n75 B.n74 585
R284 B.n31 B.n30 585
R285 B.n73 B.n31 585
R286 B.n71 B.n70 585
R287 B.n72 B.n71 585
R288 B.n33 B.n32 585
R289 B.n43 B.n42 585
R290 B.n45 B.n44 585
R291 B.n47 B.n40 585
R292 B.n50 B.n49 585
R293 B.n51 B.n39 585
R294 B.n53 B.n52 585
R295 B.n55 B.n38 585
R296 B.n58 B.n57 585
R297 B.n59 B.n37 585
R298 B.n61 B.n60 585
R299 B.n63 B.n36 585
R300 B.n66 B.n65 585
R301 B.n67 B.n35 585
R302 B.n70 B.n69 585
R303 B.n69 B.n68 585
R304 B.n30 B.n29 585
R305 B.n29 B.n28 585
R306 B.n77 B.n76 585
R307 B.n78 B.n77 585
R308 B.n27 B.n26 585
R309 B.n79 B.n27 585
R310 B.n82 B.n81 585
R311 B.n81 B.n80 585
R312 B.n22 B.n21 585
R313 B.n21 B.n20 585
R314 B.n89 B.n88 585
R315 B.n90 B.n89 585
R316 B.n19 B.n18 585
R317 B.n91 B.n19 585
R318 B.n95 B.n94 585
R319 B.n94 B.n93 585
R320 B.n14 B.n13 585
R321 B.n92 B.n13 585
R322 B.n102 B.n101 585
R323 B.n102 B.n12 585
R324 B.n103 B.n9 585
R325 B.n104 B.n103 585
R326 B.n125 B.n10 585
R327 B.n105 B.n10 585
R328 B.n124 B.n123 585
R329 B.n123 B.n122 585
R330 B.n124 B.n2 431.741
R331 B.n70 B.n34 431.741
R332 B.n123 B.n10 394
R333 B.n103 B.n10 394
R334 B.n103 B.n102 394
R335 B.n102 B.n13 394
R336 B.n94 B.n13 394
R337 B.n94 B.n19 394
R338 B.n89 B.n19 394
R339 B.n89 B.n21 394
R340 B.n81 B.n21 394
R341 B.n81 B.n27 394
R342 B.n77 B.n27 394
R343 B.n77 B.n29 394
R344 B.n69 B.n29 394
R345 B.n133 B.n132 394
R346 B.n137 B.n3 394
R347 B.n140 B.n139 394
R348 B.n112 B.n111 394
R349 B.n116 B.n108 394
R350 B.n119 B.n118 394
R351 B.n126 B.n6 394
R352 B.n126 B.n8 394
R353 B.n100 B.n8 394
R354 B.n100 B.n15 394
R355 B.n96 B.n15 394
R356 B.n96 B.n17 394
R357 B.n87 B.n17 394
R358 B.n87 B.n23 394
R359 B.n83 B.n23 394
R360 B.n83 B.n25 394
R361 B.n75 B.n25 394
R362 B.n75 B.n31 394
R363 B.n71 B.n31 394
R364 B.n45 B.n42 394
R365 B.n49 B.n47 394
R366 B.n53 B.n39 394
R367 B.n57 B.n55 394
R368 B.n61 B.n37 394
R369 B.n65 B.n63 394
R370 B.n125 B.n124 255.291
R371 B.n125 B.n9 255.291
R372 B.n101 B.n9 255.291
R373 B.n101 B.n14 255.291
R374 B.n95 B.n14 255.291
R375 B.n95 B.n18 255.291
R376 B.n88 B.n18 255.291
R377 B.n88 B.n22 255.291
R378 B.n82 B.n22 255.291
R379 B.n82 B.n26 255.291
R380 B.n76 B.n26 255.291
R381 B.n76 B.n30 255.291
R382 B.n70 B.n30 255.291
R383 B.n107 B.n2 218.815
R384 B.n117 B.n2 218.815
R385 B.n110 B.n2 218.815
R386 B.n2 B.n1 218.815
R387 B.n138 B.n2 218.815
R388 B.n5 B.n2 218.815
R389 B.n131 B.n2 218.815
R390 B.n41 B.n34 218.815
R391 B.n46 B.n34 218.815
R392 B.n48 B.n34 218.815
R393 B.n54 B.n34 218.815
R394 B.n56 B.n34 218.815
R395 B.n62 B.n34 218.815
R396 B.n64 B.n34 218.815
R397 B.n2 B 161.434
R398 B.n107 B.n11 147.374
R399 B.n118 B.n117 147.374
R400 B.n110 B.n108 147.374
R401 B.n111 B.n1 147.374
R402 B.n139 B.n138 147.374
R403 B.n5 B.n3 147.374
R404 B.n132 B.n131 147.374
R405 B.n41 B.n33 147.374
R406 B.n46 B.n45 147.374
R407 B.n49 B.n48 147.374
R408 B.n54 B.n53 147.374
R409 B.n57 B.n56 147.374
R410 B.n62 B.n61 147.374
R411 B.n65 B.n64 147.374
R412 B.n131 B.n130 147.374
R413 B.n133 B.n5 147.374
R414 B.n138 B.n137 147.374
R415 B.n140 B.n1 147.374
R416 B.n112 B.n110 147.374
R417 B.n117 B.n116 147.374
R418 B.n119 B.n107 147.374
R419 B.n42 B.n41 147.374
R420 B.n47 B.n46 147.374
R421 B.n48 B.n39 147.374
R422 B.n55 B.n54 147.374
R423 B.n56 B.n37 147.374
R424 B.n63 B.n62 147.374
R425 B.n64 B.n35 147.374
R426 B.n129 B.n128 74.9181
R427 B.n72 B.n32 74.9181
R428 B.n122 B.n121 74.9181
R429 B.n68 B.n67 74.9181
R430 B.n129 B.n4 25.6005
R431 B.n134 B.n4 25.6005
R432 B.n135 B.n134 25.6005
R433 B.n136 B.n135 25.6005
R434 B.n136 B.n0 25.6005
R435 B.n141 B.n0 25.6005
R436 B.n113 B.n109 25.6005
R437 B.n114 B.n113 25.6005
R438 B.n115 B.n114 25.6005
R439 B.n115 B.n106 25.6005
R440 B.n120 B.n106 25.6005
R441 B.n121 B.n120 25.6005
R442 B.n128 B.n127 25.6005
R443 B.n127 B.n7 25.6005
R444 B.n99 B.n7 25.6005
R445 B.n99 B.n98 25.6005
R446 B.n98 B.n97 25.6005
R447 B.n97 B.n16 25.6005
R448 B.n86 B.n16 25.6005
R449 B.n86 B.n85 25.6005
R450 B.n85 B.n84 25.6005
R451 B.n84 B.n24 25.6005
R452 B.n74 B.n24 25.6005
R453 B.n74 B.n73 25.6005
R454 B.n73 B.n72 25.6005
R455 B.n43 B.n32 25.6005
R456 B.n44 B.n43 25.6005
R457 B.n44 B.n40 25.6005
R458 B.n50 B.n40 25.6005
R459 B.n51 B.n50 25.6005
R460 B.n52 B.n51 25.6005
R461 B.n52 B.n38 25.6005
R462 B.n58 B.n38 25.6005
R463 B.n59 B.n58 25.6005
R464 B.n60 B.n59 25.6005
R465 B.n60 B.n36 25.6005
R466 B.n66 B.n36 25.6005
R467 B.n67 B.n66 25.6005
R468 B.n122 B.n105 25.6005
R469 B.n105 B.n104 25.6005
R470 B.n104 B.n12 25.6005
R471 B.n92 B.n12 25.6005
R472 B.n93 B.n92 25.6005
R473 B.n93 B.n91 25.6005
R474 B.n91 B.n90 25.6005
R475 B.n90 B.n20 25.6005
R476 B.n80 B.n20 25.6005
R477 B.n80 B.n79 25.6005
R478 B.n79 B.n78 25.6005
R479 B.n78 B.n28 25.6005
R480 B.n68 B.n28 25.6005
R481 B.n109 B 19.2005
R482 B B.n141 6.4005
R483 w_n43_n43.n130 w_n43_n43.n7 1153.03
R484 w_n43_n43.n120 w_n43_n43.n13 1153.03
R485 w_n43_n43.n73 w_n43_n43.n35 1153.03
R486 w_n43_n43.n71 w_n43_n43.n37 1153.03
R487 w_n43_n43.n35 w_n43_n43.n34 585
R488 w_n43_n43.n45 w_n43_n43.n44 585
R489 w_n43_n43.n47 w_n43_n43.n46 585
R490 w_n43_n43.n49 w_n43_n43.n42 585
R491 w_n43_n43.n52 w_n43_n43.n51 585
R492 w_n43_n43.n53 w_n43_n43.n41 585
R493 w_n43_n43.n55 w_n43_n43.n54 585
R494 w_n43_n43.n57 w_n43_n43.n40 585
R495 w_n43_n43.n60 w_n43_n43.n59 585
R496 w_n43_n43.n61 w_n43_n43.n39 585
R497 w_n43_n43.n63 w_n43_n43.n62 585
R498 w_n43_n43.n65 w_n43_n43.n38 585
R499 w_n43_n43.n68 w_n43_n43.n67 585
R500 w_n43_n43.n69 w_n43_n43.n37 585
R501 w_n43_n43.n72 w_n43_n43.n71 585
R502 w_n43_n43.n71 w_n43_n43.n70 585
R503 w_n43_n43.n32 w_n43_n43.n31 585
R504 w_n43_n43.n31 w_n43_n43.n30 585
R505 w_n43_n43.n79 w_n43_n43.n78 585
R506 w_n43_n43.n80 w_n43_n43.n79 585
R507 w_n43_n43.n29 w_n43_n43.n28 585
R508 w_n43_n43.n81 w_n43_n43.n29 585
R509 w_n43_n43.n84 w_n43_n43.n83 585
R510 w_n43_n43.n83 w_n43_n43.n82 585
R511 w_n43_n43.n24 w_n43_n43.n23 585
R512 w_n43_n43.n23 w_n43_n43.n22 585
R513 w_n43_n43.n91 w_n43_n43.n90 585
R514 w_n43_n43.n92 w_n43_n43.n91 585
R515 w_n43_n43.n21 w_n43_n43.n20 585
R516 w_n43_n43.n93 w_n43_n43.n21 585
R517 w_n43_n43.n96 w_n43_n43.n95 585
R518 w_n43_n43.n95 w_n43_n43.n94 585
R519 w_n43_n43.n16 w_n43_n43.n15 585
R520 w_n43_n43.n15 w_n43_n43.n14 585
R521 w_n43_n43.n103 w_n43_n43.n102 585
R522 w_n43_n43.n104 w_n43_n43.n103 585
R523 w_n43_n43.n12 w_n43_n43.n10 585
R524 w_n43_n43.n105 w_n43_n43.n12 585
R525 w_n43_n43.n125 w_n43_n43.n124 585
R526 w_n43_n43.n124 w_n43_n43.n123 585
R527 w_n43_n43.n13 w_n43_n43.n11 585
R528 w_n43_n43.n122 w_n43_n43.n13 585
R529 w_n43_n43.n121 w_n43_n43.n120 585
R530 w_n43_n43.n118 w_n43_n43.n106 585
R531 w_n43_n43.n117 w_n43_n43.n107 585
R532 w_n43_n43.n115 w_n43_n43.n114 585
R533 w_n43_n43.n113 w_n43_n43.n108 585
R534 w_n43_n43.n112 w_n43_n43.n111 585
R535 w_n43_n43.n110 w_n43_n43.n0 585
R536 w_n43_n43.n141 w_n43_n43.n140 585
R537 w_n43_n43.n139 w_n43_n43.n1 585
R538 w_n43_n43.n137 w_n43_n43.n136 585
R539 w_n43_n43.n135 w_n43_n43.n4 585
R540 w_n43_n43.n134 w_n43_n43.n133 585
R541 w_n43_n43.n132 w_n43_n43.n5 585
R542 w_n43_n43.n130 w_n43_n43.n129 585
R543 w_n43_n43.n11 w_n43_n43.n7 585
R544 w_n43_n43.n128 w_n43_n43.n7 585
R545 w_n43_n43.n126 w_n43_n43.n125 585
R546 w_n43_n43.n127 w_n43_n43.n126 585
R547 w_n43_n43.n10 w_n43_n43.n9 585
R548 w_n43_n43.n9 w_n43_n43.n8 585
R549 w_n43_n43.n102 w_n43_n43.n101 585
R550 w_n43_n43.n101 w_n43_n43.n100 585
R551 w_n43_n43.n17 w_n43_n43.n16 585
R552 w_n43_n43.n99 w_n43_n43.n17 585
R553 w_n43_n43.n97 w_n43_n43.n96 585
R554 w_n43_n43.n98 w_n43_n43.n97 585
R555 w_n43_n43.n20 w_n43_n43.n19 585
R556 w_n43_n43.n19 w_n43_n43.n18 585
R557 w_n43_n43.n90 w_n43_n43.n89 585
R558 w_n43_n43.n89 w_n43_n43.n88 585
R559 w_n43_n43.n25 w_n43_n43.n24 585
R560 w_n43_n43.n87 w_n43_n43.n25 585
R561 w_n43_n43.n85 w_n43_n43.n84 585
R562 w_n43_n43.n86 w_n43_n43.n85 585
R563 w_n43_n43.n28 w_n43_n43.n27 585
R564 w_n43_n43.n27 w_n43_n43.n26 585
R565 w_n43_n43.n78 w_n43_n43.n77 585
R566 w_n43_n43.n77 w_n43_n43.n76 585
R567 w_n43_n43.n33 w_n43_n43.n32 585
R568 w_n43_n43.n75 w_n43_n43.n33 585
R569 w_n43_n43.n73 w_n43_n43.n72 585
R570 w_n43_n43.n74 w_n43_n43.n73 585
R571 w_n43_n43.n11 w_n43_n43.n3 431.741
R572 w_n43_n43.n72 w_n43_n43.n36 431.741
R573 w_n43_n43.n126 w_n43_n43.n7 394
R574 w_n43_n43.n126 w_n43_n43.n9 394
R575 w_n43_n43.n101 w_n43_n43.n9 394
R576 w_n43_n43.n101 w_n43_n43.n17 394
R577 w_n43_n43.n97 w_n43_n43.n17 394
R578 w_n43_n43.n97 w_n43_n43.n19 394
R579 w_n43_n43.n89 w_n43_n43.n19 394
R580 w_n43_n43.n89 w_n43_n43.n25 394
R581 w_n43_n43.n85 w_n43_n43.n25 394
R582 w_n43_n43.n85 w_n43_n43.n27 394
R583 w_n43_n43.n77 w_n43_n43.n27 394
R584 w_n43_n43.n77 w_n43_n43.n33 394
R585 w_n43_n43.n73 w_n43_n43.n33 394
R586 w_n43_n43.n133 w_n43_n43.n132 394
R587 w_n43_n43.n137 w_n43_n43.n4 394
R588 w_n43_n43.n140 w_n43_n43.n139 394
R589 w_n43_n43.n111 w_n43_n43.n110 394
R590 w_n43_n43.n115 w_n43_n43.n108 394
R591 w_n43_n43.n118 w_n43_n43.n117 394
R592 w_n43_n43.n124 w_n43_n43.n13 394
R593 w_n43_n43.n124 w_n43_n43.n12 394
R594 w_n43_n43.n103 w_n43_n43.n12 394
R595 w_n43_n43.n103 w_n43_n43.n15 394
R596 w_n43_n43.n95 w_n43_n43.n15 394
R597 w_n43_n43.n95 w_n43_n43.n21 394
R598 w_n43_n43.n91 w_n43_n43.n21 394
R599 w_n43_n43.n91 w_n43_n43.n23 394
R600 w_n43_n43.n83 w_n43_n43.n23 394
R601 w_n43_n43.n83 w_n43_n43.n29 394
R602 w_n43_n43.n79 w_n43_n43.n29 394
R603 w_n43_n43.n79 w_n43_n43.n31 394
R604 w_n43_n43.n71 w_n43_n43.n31 394
R605 w_n43_n43.n47 w_n43_n43.n44 394
R606 w_n43_n43.n51 w_n43_n43.n49 394
R607 w_n43_n43.n55 w_n43_n43.n41 394
R608 w_n43_n43.n59 w_n43_n43.n57 394
R609 w_n43_n43.n63 w_n43_n43.n39 394
R610 w_n43_n43.n67 w_n43_n43.n65 394
R611 w_n43_n43.n125 w_n43_n43.n11 255.291
R612 w_n43_n43.n125 w_n43_n43.n10 255.291
R613 w_n43_n43.n102 w_n43_n43.n10 255.291
R614 w_n43_n43.n102 w_n43_n43.n16 255.291
R615 w_n43_n43.n96 w_n43_n43.n16 255.291
R616 w_n43_n43.n96 w_n43_n43.n20 255.291
R617 w_n43_n43.n90 w_n43_n43.n20 255.291
R618 w_n43_n43.n90 w_n43_n43.n24 255.291
R619 w_n43_n43.n84 w_n43_n43.n24 255.291
R620 w_n43_n43.n84 w_n43_n43.n28 255.291
R621 w_n43_n43.n78 w_n43_n43.n28 255.291
R622 w_n43_n43.n78 w_n43_n43.n32 255.291
R623 w_n43_n43.n72 w_n43_n43.n32 255.291
R624 w_n43_n43.n43 w_n43_n43.n36 218.815
R625 w_n43_n43.n48 w_n43_n43.n36 218.815
R626 w_n43_n43.n50 w_n43_n43.n36 218.815
R627 w_n43_n43.n56 w_n43_n43.n36 218.815
R628 w_n43_n43.n58 w_n43_n43.n36 218.815
R629 w_n43_n43.n64 w_n43_n43.n36 218.815
R630 w_n43_n43.n66 w_n43_n43.n36 218.815
R631 w_n43_n43.n119 w_n43_n43.n3 218.815
R632 w_n43_n43.n116 w_n43_n43.n3 218.815
R633 w_n43_n43.n109 w_n43_n43.n3 218.815
R634 w_n43_n43.n3 w_n43_n43.n2 218.815
R635 w_n43_n43.n138 w_n43_n43.n3 218.815
R636 w_n43_n43.n6 w_n43_n43.n3 218.815
R637 w_n43_n43.n131 w_n43_n43.n3 218.815
R638 w_n43_n43.n3 B 161.434
R639 w_n43_n43.n43 w_n43_n43.n35 147.374
R640 w_n43_n43.n48 w_n43_n43.n47 147.374
R641 w_n43_n43.n51 w_n43_n43.n50 147.374
R642 w_n43_n43.n56 w_n43_n43.n55 147.374
R643 w_n43_n43.n59 w_n43_n43.n58 147.374
R644 w_n43_n43.n64 w_n43_n43.n63 147.374
R645 w_n43_n43.n67 w_n43_n43.n66 147.374
R646 w_n43_n43.n120 w_n43_n43.n119 147.374
R647 w_n43_n43.n117 w_n43_n43.n116 147.374
R648 w_n43_n43.n109 w_n43_n43.n108 147.374
R649 w_n43_n43.n110 w_n43_n43.n2 147.374
R650 w_n43_n43.n139 w_n43_n43.n138 147.374
R651 w_n43_n43.n6 w_n43_n43.n4 147.374
R652 w_n43_n43.n132 w_n43_n43.n131 147.374
R653 w_n43_n43.n131 w_n43_n43.n130 147.374
R654 w_n43_n43.n133 w_n43_n43.n6 147.374
R655 w_n43_n43.n138 w_n43_n43.n137 147.374
R656 w_n43_n43.n140 w_n43_n43.n2 147.374
R657 w_n43_n43.n111 w_n43_n43.n109 147.374
R658 w_n43_n43.n116 w_n43_n43.n115 147.374
R659 w_n43_n43.n119 w_n43_n43.n118 147.374
R660 w_n43_n43.n44 w_n43_n43.n43 147.374
R661 w_n43_n43.n49 w_n43_n43.n48 147.374
R662 w_n43_n43.n50 w_n43_n43.n41 147.374
R663 w_n43_n43.n57 w_n43_n43.n56 147.374
R664 w_n43_n43.n58 w_n43_n43.n39 147.374
R665 w_n43_n43.n65 w_n43_n43.n64 147.374
R666 w_n43_n43.n66 w_n43_n43.n37 147.374
R667 w_n43_n43.n129 w_n43_n43.n128 74.9181
R668 w_n43_n43.n122 w_n43_n43.n121 74.9181
R669 w_n43_n43.n74 w_n43_n43.n34 74.9181
R670 w_n43_n43.n70 w_n43_n43.n69 74.9181
R671 w_n43_n43.n128 w_n43_n43.n127 25.6005
R672 w_n43_n43.n127 w_n43_n43.n8 25.6005
R673 w_n43_n43.n100 w_n43_n43.n8 25.6005
R674 w_n43_n43.n100 w_n43_n43.n99 25.6005
R675 w_n43_n43.n99 w_n43_n43.n98 25.6005
R676 w_n43_n43.n98 w_n43_n43.n18 25.6005
R677 w_n43_n43.n88 w_n43_n43.n18 25.6005
R678 w_n43_n43.n88 w_n43_n43.n87 25.6005
R679 w_n43_n43.n87 w_n43_n43.n86 25.6005
R680 w_n43_n43.n86 w_n43_n43.n26 25.6005
R681 w_n43_n43.n76 w_n43_n43.n26 25.6005
R682 w_n43_n43.n76 w_n43_n43.n75 25.6005
R683 w_n43_n43.n75 w_n43_n43.n74 25.6005
R684 w_n43_n43.n129 w_n43_n43.n5 25.6005
R685 w_n43_n43.n134 w_n43_n43.n5 25.6005
R686 w_n43_n43.n135 w_n43_n43.n134 25.6005
R687 w_n43_n43.n136 w_n43_n43.n135 25.6005
R688 w_n43_n43.n136 w_n43_n43.n1 25.6005
R689 w_n43_n43.n141 w_n43_n43.n1 25.6005
R690 w_n43_n43.n112 w_n43_n43.n0 25.6005
R691 w_n43_n43.n113 w_n43_n43.n112 25.6005
R692 w_n43_n43.n114 w_n43_n43.n113 25.6005
R693 w_n43_n43.n114 w_n43_n43.n107 25.6005
R694 w_n43_n43.n107 w_n43_n43.n106 25.6005
R695 w_n43_n43.n121 w_n43_n43.n106 25.6005
R696 w_n43_n43.n123 w_n43_n43.n122 25.6005
R697 w_n43_n43.n123 w_n43_n43.n105 25.6005
R698 w_n43_n43.n105 w_n43_n43.n104 25.6005
R699 w_n43_n43.n104 w_n43_n43.n14 25.6005
R700 w_n43_n43.n94 w_n43_n43.n14 25.6005
R701 w_n43_n43.n94 w_n43_n43.n93 25.6005
R702 w_n43_n43.n93 w_n43_n43.n92 25.6005
R703 w_n43_n43.n92 w_n43_n43.n22 25.6005
R704 w_n43_n43.n82 w_n43_n43.n22 25.6005
R705 w_n43_n43.n82 w_n43_n43.n81 25.6005
R706 w_n43_n43.n81 w_n43_n43.n80 25.6005
R707 w_n43_n43.n80 w_n43_n43.n30 25.6005
R708 w_n43_n43.n70 w_n43_n43.n30 25.6005
R709 w_n43_n43.n45 w_n43_n43.n34 25.6005
R710 w_n43_n43.n46 w_n43_n43.n45 25.6005
R711 w_n43_n43.n46 w_n43_n43.n42 25.6005
R712 w_n43_n43.n52 w_n43_n43.n42 25.6005
R713 w_n43_n43.n53 w_n43_n43.n52 25.6005
R714 w_n43_n43.n54 w_n43_n43.n53 25.6005
R715 w_n43_n43.n54 w_n43_n43.n40 25.6005
R716 w_n43_n43.n60 w_n43_n43.n40 25.6005
R717 w_n43_n43.n61 w_n43_n43.n60 25.6005
R718 w_n43_n43.n62 w_n43_n43.n61 25.6005
R719 w_n43_n43.n62 w_n43_n43.n38 25.6005
R720 w_n43_n43.n68 w_n43_n43.n38 25.6005
R721 w_n43_n43.n69 w_n43_n43.n68 25.6005
R722 B w_n43_n43.n0 19.2005
R723 B w_n43_n43.n141 6.4005
C3 B.n0 B 0 ; **FLOATING
C4 B.n2 B 0 ; **FLOATING
C5 B.n3 B 0 ; **FLOATING
C6 B.n4 B 0 ; **FLOATING
C7 B.n6 B 0 ; **FLOATING
C8 B.n7 B 0 ; **FLOATING
C9 B.n8 B 0 ; **FLOATING
C10 B.n9 B 0 ; **FLOATING
C11 B.n10 B 0 ; **FLOATING
C12 B.n11 B 0 ; **FLOATING
C13 B.n12 B 0 ; **FLOATING
C14 B.n13 B 0 ; **FLOATING
C15 B.n14 B 0 ; **FLOATING
C16 B.n15 B 0 ; **FLOATING
C17 B.n16 B 0 ; **FLOATING
C18 B.n17 B 0 ; **FLOATING
C19 B.n18 B 0 ; **FLOATING
C20 B.n19 B 0 ; **FLOATING
C21 B.n20 B 0 ; **FLOATING
C22 B.n21 B 0 ; **FLOATING
C23 B.n22 B 0 ; **FLOATING
C24 B.n23 B 0 ; **FLOATING
C25 B.n24 B 0 ; **FLOATING
C26 B.n25 B 0 ; **FLOATING
C27 B.n26 B 0 ; **FLOATING
C28 B.n27 B 0 ; **FLOATING
C29 B.n28 B 0 ; **FLOATING
C30 B.n29 B 0 ; **FLOATING
C31 B.n30 B 0 ; **FLOATING
C32 B.n31 B 0 ; **FLOATING
C33 B.n32 B 0 ; **FLOATING
C34 B.n33 B 0 ; **FLOATING
C35 B.n34 B 0 ; **FLOATING
C36 B.n35 B 0 ; **FLOATING
C37 B.n36 B 0 ; **FLOATING
C38 B.n37 B 0 ; **FLOATING
C39 B.n38 B 0 ; **FLOATING
C40 B.n39 B 0 ; **FLOATING
C41 B.n40 B 0 ; **FLOATING
C42 B.n42 B 0 ; **FLOATING
C43 B.n43 B 0 ; **FLOATING
C44 B.n44 B 0 ; **FLOATING
C45 B.n45 B 0 ; **FLOATING
C46 B.n47 B 0 ; **FLOATING
C47 B.n49 B 0 ; **FLOATING
C48 B.n50 B 0 ; **FLOATING
C49 B.n51 B 0 ; **FLOATING
C50 B.n52 B 0 ; **FLOATING
C51 B.n53 B 0 ; **FLOATING
C52 B.n55 B 0 ; **FLOATING
C53 B.n57 B 0 ; **FLOATING
C54 B.n58 B 0 ; **FLOATING
C55 B.n59 B 0 ; **FLOATING
C56 B.n60 B 0 ; **FLOATING
C57 B.n61 B 0 ; **FLOATING
C58 B.n63 B 0 ; **FLOATING
C59 B.n65 B 0 ; **FLOATING
C60 B.n66 B 0 ; **FLOATING
C61 B.n67 B 0 ; **FLOATING
C62 B.n68 B 0 ; **FLOATING
C63 B.n69 B 0 ; **FLOATING
C64 B.n70 B 0 ; **FLOATING
C65 B.n71 B 0 ; **FLOATING
C66 B.n72 B 0 ; **FLOATING
C67 B.n73 B 0 ; **FLOATING
C68 B.n74 B 0 ; **FLOATING
C69 B.n75 B 0 ; **FLOATING
C70 B.n76 B 0 ; **FLOATING
C71 B.n77 B 0 ; **FLOATING
C72 B.n78 B 0 ; **FLOATING
C73 B.n79 B 0 ; **FLOATING
C74 B.n80 B 0 ; **FLOATING
C75 B.n81 B 0 ; **FLOATING
C76 B.n82 B 0 ; **FLOATING
C77 B.n83 B 0 ; **FLOATING
C78 B.n84 B 0 ; **FLOATING
C79 B.n85 B 0 ; **FLOATING
C80 B.n86 B 0 ; **FLOATING
C81 B.n87 B 0 ; **FLOATING
C82 B.n88 B 0 ; **FLOATING
C83 B.n89 B 0 ; **FLOATING
C84 B.n90 B 0 ; **FLOATING
C85 B.n91 B 0 ; **FLOATING
C86 B.n92 B 0 ; **FLOATING
C87 B.n93 B 0 ; **FLOATING
C88 B.n94 B 0 ; **FLOATING
C89 B.n95 B 0 ; **FLOATING
C90 B.n96 B 0 ; **FLOATING
C91 B.n97 B 0 ; **FLOATING
C92 B.n98 B 0 ; **FLOATING
C93 B.n99 B 0 ; **FLOATING
C94 B.n100 B 0 ; **FLOATING
C95 B.n101 B 0 ; **FLOATING
C96 B.n102 B 0 ; **FLOATING
C97 B.n103 B 0 ; **FLOATING
C98 B.n104 B 0 ; **FLOATING
C99 B.n105 B 0 ; **FLOATING
C100 B.n106 B 0 ; **FLOATING
C101 B.n108 B 0 ; **FLOATING
C102 B.n109 B 0 ; **FLOATING
C103 B.n111 B 0 ; **FLOATING
C104 B.n112 B 0 ; **FLOATING
C105 B.n113 B 0 ; **FLOATING
C106 B.n114 B 0 ; **FLOATING
C107 B.n115 B 0 ; **FLOATING
C108 B.n116 B 0 ; **FLOATING
C109 B.n118 B 0 ; **FLOATING
C110 B.n119 B 0 ; **FLOATING
C111 B.n120 B 0 ; **FLOATING
C112 B.n121 B 0 ; **FLOATING
C113 B.n122 B 0 ; **FLOATING
C114 B.n123 B 0 ; **FLOATING
C115 B.n124 B 0 ; **FLOATING
C116 B.n125 B 0 ; **FLOATING
C117 B.n126 B 0 ; **FLOATING
C118 B.n127 B 0 ; **FLOATING
C119 B.n128 B 0 ; **FLOATING
C120 B.n129 B 0 ; **FLOATING
C121 B.n130 B 0 ; **FLOATING
C122 B.n132 B 0 ; **FLOATING
C123 B.n133 B 0 ; **FLOATING
C124 B.n134 B 0 ; **FLOATING
C125 B.n135 B 0 ; **FLOATING
C126 B.n136 B 0 ; **FLOATING
C127 B.n137 B 0 ; **FLOATING
C128 B.n139 B 0 ; **FLOATING
C129 B.n140 B 0 ; **FLOATING
C130 B.n141 B 0 ; **FLOATING
C131 S B 0.41311f
C132 D B 0.41311f
C133 G B 1.81657f
