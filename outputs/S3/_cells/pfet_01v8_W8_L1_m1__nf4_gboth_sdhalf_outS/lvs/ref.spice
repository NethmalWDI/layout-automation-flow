.subckt pfet_01v8_W8_L1_m1__nf4_gboth_sdhalf_outS D G S B
Xpfet_01v8_W8_L1_m1__nf4_gboth_sdhalf_outS D G S B sky130_fd_pr__pfet_01v8 L=1 W=8 nf=4
.ends
