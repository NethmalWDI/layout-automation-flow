* NGSPICE file created from pfet_01v8_lvt_W2_L5_m2__nf1_gboth_sdfull.ext - technology: sky130A

X0 S G D B sky130_fd_pr__pfet_01v8_lvt ad=0.58 pd=4.58 as=0.58 ps=4.58 w=2 l=5
C0 B D 0.17609f
C1 D G 0.1702f
C2 S D 0.01368f
C3 B G 1.72808f
C4 B S 0.17609f
C5 S G 0.1702f
C6 S VSUBS 0.06872f
C7 D VSUBS 0.06872f
C8 G VSUBS 0.55883f
C9 B VSUBS 4.22298f
