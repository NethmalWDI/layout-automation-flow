* NGSPICE file created from pfet_01v8_lvt_W5_L1_m2__nf4_gboth_sdfull_outS.ext - technology: sky130A

.subckt sky130_fd_pr__pfet_01v8_lvt_595WRR G B a_487_n125# D2 D0 S3 S1
X0 S1 G D0 B sky130_fd_pr__pfet_01v8_lvt ad=0.18125 pd=1.54 as=0.3625 ps=3.08 w=1.25 l=1
X1 a_487_n125# G S3 B sky130_fd_pr__pfet_01v8_lvt ad=0.3625 pd=3.08 as=0.18125 ps=1.54 w=1.25 l=1
X2 D2 G S1 B sky130_fd_pr__pfet_01v8_lvt ad=0.18125 pd=1.54 as=0.18125 ps=1.54 w=1.25 l=1
X3 S3 G D2 B sky130_fd_pr__pfet_01v8_lvt ad=0.18125 pd=1.54 as=0.18125 ps=1.54 w=1.25 l=1
.ends

.subckt pfet_01v8_lvt_W5_L1_m2__nf4_gboth_sdfull_outS S D G B
Xpfet_01v8_lvt_W5_L1_m2__nf4_gboth_sdfull_outS_pc G B S S S D D sky130_fd_pr__pfet_01v8_lvt_595WRR
.ends
