* NGSPICE file created from pfet_01v8_lvt_W1p5_L10_m2__nf1_gboth_sdhalf_ng.ext - technology: sky130A

.subckt pfet_01v8_lvt_W1p5_L10_m2__nf1_gboth_sdhalf_ng D S G B
X0 S G D B sky130_fd_pr__pfet_01v8_lvt ad=0.435 pd=3.58 as=0.435 ps=3.58 w=1.5 l=10
C0 B G 1.53009f
C1 S G 0.07291f
C2 D G 0.07291f
C3 B S 0.02387f
C4 B D 0.02387f
C5 S VSUBS 0.09196f
C6 D VSUBS 0.09196f
C7 G VSUBS 2.67081f
C8 B VSUBS 3.282f
.ends
