* NGSPICE file created from pfet_01v8_lvt_W887p03_L0p74_m1__nf1_gboth_sdfull_ng.ext - technology: sky130A

.subckt sky130_fd_pr__pfet_01v8_lvt_DWXPTN G D w_n168_n88803# S
X0 S G D w_n168_n88803# sky130_fd_pr__pfet_01v8_lvt ad=257.23871 pd=1.77464k as=257.23871 ps=1.77464k w=887.03003 l=0.74
.ends

.subckt pfet_01v8_lvt_W887p03_L0p74_m1__nf1_gboth_sdfull_ng D S G B
Xpfet_01v8_lvt_W887p03_L0p74_m1__nf1_gboth_sdfull_ng_pc G D B S sky130_fd_pr__pfet_01v8_lvt_DWXPTN
.ends
