* NGSPICE file created from pfet_01v8_lvt_W887p03_L0p74_m1__nf1_gboth_sdfull_ng.ext - technology: sky130A

X0 pfet_01v8_lvt_W887p03_L0p74_m1__nf1_gboth_sdfull_ng_pc/S.t0 pfet_01v8_lvt_W887p03_L0p74_m1__nf1_gboth_sdfull_ng_pc/G.t0 pfet_01v8_lvt_W887p03_L0p74_m1__nf1_gboth_sdfull_ng_pc/D.t0 B sky130_fd_pr__pfet_01v8_lvt ad=257.23871 pd=1.77464k as=257.23871 ps=1.77464k w=887.03003 l=0.74
C0 S D 33.0325f
C1 D G 40.7675f
C2 B D 15.4688f
C3 S G 40.7675f
C4 S B 15.4688f
C5 B G 0.17088f
R0 pfet_01v8_lvt_W887p03_L0p74_m1__nf1_gboth_sdfull_ng_pc/S.t0 S 15.1327
R1 pfet_01v8_lvt_W887p03_L0p74_m1__nf1_gboth_sdfull_ng_pc/D.t0 D 15.1327
R2 pfet_01v8_lvt_W887p03_L0p74_m1__nf1_gboth_sdfull_ng_pc/G.n1 pfet_01v8_lvt_W887p03_L0p74_m1__nf1_gboth_sdfull_ng_pc/G.t0 28888.4
R3 pfet_01v8_lvt_W887p03_L0p74_m1__nf1_gboth_sdfull_ng_pc/G.n1 pfet_01v8_lvt_W887p03_L0p74_m1__nf1_gboth_sdfull_ng_pc/G.n0 168.895
R4 pfet_01v8_lvt_W887p03_L0p74_m1__nf1_gboth_sdfull_ng_pc/G.n2 pfet_01v8_lvt_W887p03_L0p74_m1__nf1_gboth_sdfull_ng_pc/G.n1 168.895
R5 G pfet_01v8_lvt_W887p03_L0p74_m1__nf1_gboth_sdfull_ng_pc/G.n0 12.8005
R6 G pfet_01v8_lvt_W887p03_L0p74_m1__nf1_gboth_sdfull_ng_pc/G.n2 12.8005
R7 G pfet_01v8_lvt_W887p03_L0p74_m1__nf1_gboth_sdfull_ng_pc/G.n0 10.2491
R8 pfet_01v8_lvt_W887p03_L0p74_m1__nf1_gboth_sdfull_ng_pc/G.n2 G 10.0534
C6 S VSUBS 63.03712f
C7 D VSUBS 63.03718f
C8 G VSUBS 0.33749f
C9 B VSUBS 0.17575p
C10 pfet_01v8_lvt_W887p03_L0p74_m1__nf1_gboth_sdfull_ng_pc/G.n0 VSUBS 0.00763f ; **FLOATING
C11 pfet_01v8_lvt_W887p03_L0p74_m1__nf1_gboth_sdfull_ng_pc/G.t0 VSUBS 61.2393f ; **FLOATING
C12 pfet_01v8_lvt_W887p03_L0p74_m1__nf1_gboth_sdfull_ng_pc/G.n1 VSUBS 20.4275f ; **FLOATING
C13 pfet_01v8_lvt_W887p03_L0p74_m1__nf1_gboth_sdfull_ng_pc/G.n2 VSUBS 0.00743f ; **FLOATING
C14 pfet_01v8_lvt_W887p03_L0p74_m1__nf1_gboth_sdfull_ng_pc/D.t0 VSUBS 88.4976f ; **FLOATING
C15 pfet_01v8_lvt_W887p03_L0p74_m1__nf1_gboth_sdfull_ng_pc/S.t0 VSUBS 88.4976f ; **FLOATING
