* NGSPICE file created from nfet_01v8_lvt_W66p13_L2p03_m1__nf1_gtop_sdfull_ng.ext - technology: sky130A

.subckt sky130_fd_pr__nfet_01v8_lvt_5S5VHZ G D S VSUBS
X0 S G D VSUBS sky130_fd_pr__nfet_01v8_lvt ad=19.1777 pd=132.84 as=19.1777 ps=132.84 w=66.13 l=2.03
.ends

.subckt nfet_01v8_lvt_W66p13_L2p03_m1__nf1_gtop_sdfull_ng D S G B
Xnfet_01v8_lvt_W66p13_L2p03_m1__nf1_gtop_sdfull_ng_pc G D S B sky130_fd_pr__nfet_01v8_lvt_5S5VHZ
.ends
