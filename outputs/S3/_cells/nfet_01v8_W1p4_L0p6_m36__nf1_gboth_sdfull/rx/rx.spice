* NGSPICE file created from nfet_01v8_W1p4_L0p6_m36__nf1_gboth_sdfull.ext - technology: sky130A

X0 S G D nfet_01v8_W1p4_L0p6_m36__nf1_gboth_sdfull_pc/B.t0 sky130_fd_pr__nfet_01v8 ad=0.406 pd=3.38 as=0.406 ps=3.38 w=1.4 l=0.6
C0 D S 0.06099f
C1 G S 0.05758f
C2 G D 0.05758f
R0 nfet_01v8_W1p4_L0p6_m36__nf1_gboth_sdfull_pc/B.n33 nfet_01v8_W1p4_L0p6_m36__nf1_gboth_sdfull_pc/B.n3 1222.56
R1 nfet_01v8_W1p4_L0p6_m36__nf1_gboth_sdfull_pc/B.n24 nfet_01v8_W1p4_L0p6_m36__nf1_gboth_sdfull_pc/B.n10 1222.56
R2 nfet_01v8_W1p4_L0p6_m36__nf1_gboth_sdfull_pc/B.n43 nfet_01v8_W1p4_L0p6_m36__nf1_gboth_sdfull_pc/B.n6 1222.56
R3 nfet_01v8_W1p4_L0p6_m36__nf1_gboth_sdfull_pc/B.n27 nfet_01v8_W1p4_L0p6_m36__nf1_gboth_sdfull_pc/B.n8 1222.56
R4 nfet_01v8_W1p4_L0p6_m36__nf1_gboth_sdfull_pc/B.n41 nfet_01v8_W1p4_L0p6_m36__nf1_gboth_sdfull_pc/B.n4 653.529
R5 nfet_01v8_W1p4_L0p6_m36__nf1_gboth_sdfull_pc/B.n26 nfet_01v8_W1p4_L0p6_m36__nf1_gboth_sdfull_pc/B.n9 653.529
R6 nfet_01v8_W1p4_L0p6_m36__nf1_gboth_sdfull_pc/B.n6 nfet_01v8_W1p4_L0p6_m36__nf1_gboth_sdfull_pc/B.n4 585
R7 nfet_01v8_W1p4_L0p6_m36__nf1_gboth_sdfull_pc/B.n45 nfet_01v8_W1p4_L0p6_m36__nf1_gboth_sdfull_pc/B.n6 585
R8 nfet_01v8_W1p4_L0p6_m36__nf1_gboth_sdfull_pc/B.n48 nfet_01v8_W1p4_L0p6_m36__nf1_gboth_sdfull_pc/B.n47 585
R9 nfet_01v8_W1p4_L0p6_m36__nf1_gboth_sdfull_pc/B.n47 nfet_01v8_W1p4_L0p6_m36__nf1_gboth_sdfull_pc/B.n46 585
R10 nfet_01v8_W1p4_L0p6_m36__nf1_gboth_sdfull_pc/B.n25 nfet_01v8_W1p4_L0p6_m36__nf1_gboth_sdfull_pc/B.n5 585
R11 nfet_01v8_W1p4_L0p6_m36__nf1_gboth_sdfull_pc/B.n29 nfet_01v8_W1p4_L0p6_m36__nf1_gboth_sdfull_pc/B.n5 585
R12 nfet_01v8_W1p4_L0p6_m36__nf1_gboth_sdfull_pc/B.n27 nfet_01v8_W1p4_L0p6_m36__nf1_gboth_sdfull_pc/B.n26 585
R13 nfet_01v8_W1p4_L0p6_m36__nf1_gboth_sdfull_pc/B.n28 nfet_01v8_W1p4_L0p6_m36__nf1_gboth_sdfull_pc/B.n27 585
R14 nfet_01v8_W1p4_L0p6_m36__nf1_gboth_sdfull_pc/B.n8 nfet_01v8_W1p4_L0p6_m36__nf1_gboth_sdfull_pc/B.n7 585
R15 nfet_01v8_W1p4_L0p6_m36__nf1_gboth_sdfull_pc/B.n14 nfet_01v8_W1p4_L0p6_m36__nf1_gboth_sdfull_pc/B.n13 585
R16 nfet_01v8_W1p4_L0p6_m36__nf1_gboth_sdfull_pc/B.n16 nfet_01v8_W1p4_L0p6_m36__nf1_gboth_sdfull_pc/B.n15 585
R17 nfet_01v8_W1p4_L0p6_m36__nf1_gboth_sdfull_pc/B.n18 nfet_01v8_W1p4_L0p6_m36__nf1_gboth_sdfull_pc/B.n11 585
R18 nfet_01v8_W1p4_L0p6_m36__nf1_gboth_sdfull_pc/B.n21 nfet_01v8_W1p4_L0p6_m36__nf1_gboth_sdfull_pc/B.n20 585
R19 nfet_01v8_W1p4_L0p6_m36__nf1_gboth_sdfull_pc/B.n22 nfet_01v8_W1p4_L0p6_m36__nf1_gboth_sdfull_pc/B.n10 585
R20 nfet_01v8_W1p4_L0p6_m36__nf1_gboth_sdfull_pc/B.n26 nfet_01v8_W1p4_L0p6_m36__nf1_gboth_sdfull_pc/B.n24 585
R21 nfet_01v8_W1p4_L0p6_m36__nf1_gboth_sdfull_pc/B.n24 nfet_01v8_W1p4_L0p6_m36__nf1_gboth_sdfull_pc/B.n23 585
R22 nfet_01v8_W1p4_L0p6_m36__nf1_gboth_sdfull_pc/B.n25 nfet_01v8_W1p4_L0p6_m36__nf1_gboth_sdfull_pc/B.n2 585
R23 nfet_01v8_W1p4_L0p6_m36__nf1_gboth_sdfull_pc/B.n2 nfet_01v8_W1p4_L0p6_m36__nf1_gboth_sdfull_pc/B.n0 585
R24 nfet_01v8_W1p4_L0p6_m36__nf1_gboth_sdfull_pc/B.n49 nfet_01v8_W1p4_L0p6_m36__nf1_gboth_sdfull_pc/B.n48 585
R25 nfet_01v8_W1p4_L0p6_m36__nf1_gboth_sdfull_pc/B.n50 nfet_01v8_W1p4_L0p6_m36__nf1_gboth_sdfull_pc/B.n49 585
R26 nfet_01v8_W1p4_L0p6_m36__nf1_gboth_sdfull_pc/B.n4 nfet_01v8_W1p4_L0p6_m36__nf1_gboth_sdfull_pc/B.n3 585
R27 nfet_01v8_W1p4_L0p6_m36__nf1_gboth_sdfull_pc/B.n3 nfet_01v8_W1p4_L0p6_m36__nf1_gboth_sdfull_pc/B.n1 585
R28 nfet_01v8_W1p4_L0p6_m36__nf1_gboth_sdfull_pc/B.n41 nfet_01v8_W1p4_L0p6_m36__nf1_gboth_sdfull_pc/B.n33 585
R29 nfet_01v8_W1p4_L0p6_m36__nf1_gboth_sdfull_pc/B.n35 nfet_01v8_W1p4_L0p6_m36__nf1_gboth_sdfull_pc/B.n33 585
R30 nfet_01v8_W1p4_L0p6_m36__nf1_gboth_sdfull_pc/B.n37 nfet_01v8_W1p4_L0p6_m36__nf1_gboth_sdfull_pc/B.n36 585
R31 nfet_01v8_W1p4_L0p6_m36__nf1_gboth_sdfull_pc/B.n38 nfet_01v8_W1p4_L0p6_m36__nf1_gboth_sdfull_pc/B.n34 585
R32 nfet_01v8_W1p4_L0p6_m36__nf1_gboth_sdfull_pc/B.n41 nfet_01v8_W1p4_L0p6_m36__nf1_gboth_sdfull_pc/B.n40 585
R33 nfet_01v8_W1p4_L0p6_m36__nf1_gboth_sdfull_pc/B.n40 nfet_01v8_W1p4_L0p6_m36__nf1_gboth_sdfull_pc/B.n39 585
R34 nfet_01v8_W1p4_L0p6_m36__nf1_gboth_sdfull_pc/B.n31 nfet_01v8_W1p4_L0p6_m36__nf1_gboth_sdfull_pc/B.n30 585
R35 nfet_01v8_W1p4_L0p6_m36__nf1_gboth_sdfull_pc/B.n44 nfet_01v8_W1p4_L0p6_m36__nf1_gboth_sdfull_pc/B.n43 585
R36 nfet_01v8_W1p4_L0p6_m36__nf1_gboth_sdfull_pc/B.n48 nfet_01v8_W1p4_L0p6_m36__nf1_gboth_sdfull_pc/B.n4 440
R37 nfet_01v8_W1p4_L0p6_m36__nf1_gboth_sdfull_pc/B.n26 nfet_01v8_W1p4_L0p6_m36__nf1_gboth_sdfull_pc/B.n25 440
R38 nfet_01v8_W1p4_L0p6_m36__nf1_gboth_sdfull_pc/B.n36 nfet_01v8_W1p4_L0p6_m36__nf1_gboth_sdfull_pc/B.n33 394
R39 nfet_01v8_W1p4_L0p6_m36__nf1_gboth_sdfull_pc/B.n40 nfet_01v8_W1p4_L0p6_m36__nf1_gboth_sdfull_pc/B.n34 394
R40 nfet_01v8_W1p4_L0p6_m36__nf1_gboth_sdfull_pc/B.n40 nfet_01v8_W1p4_L0p6_m36__nf1_gboth_sdfull_pc/B.n31 394
R41 nfet_01v8_W1p4_L0p6_m36__nf1_gboth_sdfull_pc/B.n49 nfet_01v8_W1p4_L0p6_m36__nf1_gboth_sdfull_pc/B.n3 394
R42 nfet_01v8_W1p4_L0p6_m36__nf1_gboth_sdfull_pc/B.n49 nfet_01v8_W1p4_L0p6_m36__nf1_gboth_sdfull_pc/B.n2 394
R43 nfet_01v8_W1p4_L0p6_m36__nf1_gboth_sdfull_pc/B.n24 nfet_01v8_W1p4_L0p6_m36__nf1_gboth_sdfull_pc/B.n2 394
R44 nfet_01v8_W1p4_L0p6_m36__nf1_gboth_sdfull_pc/B.n20 nfet_01v8_W1p4_L0p6_m36__nf1_gboth_sdfull_pc/B.n18 394
R45 nfet_01v8_W1p4_L0p6_m36__nf1_gboth_sdfull_pc/B.n16 nfet_01v8_W1p4_L0p6_m36__nf1_gboth_sdfull_pc/B.n13 394
R46 nfet_01v8_W1p4_L0p6_m36__nf1_gboth_sdfull_pc/B.n47 nfet_01v8_W1p4_L0p6_m36__nf1_gboth_sdfull_pc/B.n6 394
R47 nfet_01v8_W1p4_L0p6_m36__nf1_gboth_sdfull_pc/B.n47 nfet_01v8_W1p4_L0p6_m36__nf1_gboth_sdfull_pc/B.n5 394
R48 nfet_01v8_W1p4_L0p6_m36__nf1_gboth_sdfull_pc/B.n27 nfet_01v8_W1p4_L0p6_m36__nf1_gboth_sdfull_pc/B.n5 394
R49 nfet_01v8_W1p4_L0p6_m36__nf1_gboth_sdfull_pc/B.n41 B 278.236
R50 nfet_01v8_W1p4_L0p6_m36__nf1_gboth_sdfull_pc/B.n48 nfet_01v8_W1p4_L0p6_m36__nf1_gboth_sdfull_pc/B.t0 220
R51 nfet_01v8_W1p4_L0p6_m36__nf1_gboth_sdfull_pc/B.n25 nfet_01v8_W1p4_L0p6_m36__nf1_gboth_sdfull_pc/B.t0 220
R52 nfet_01v8_W1p4_L0p6_m36__nf1_gboth_sdfull_pc/B.n12 nfet_01v8_W1p4_L0p6_m36__nf1_gboth_sdfull_pc/B.n9 218.815
R53 nfet_01v8_W1p4_L0p6_m36__nf1_gboth_sdfull_pc/B.n17 nfet_01v8_W1p4_L0p6_m36__nf1_gboth_sdfull_pc/B.n9 218.815
R54 nfet_01v8_W1p4_L0p6_m36__nf1_gboth_sdfull_pc/B.n19 nfet_01v8_W1p4_L0p6_m36__nf1_gboth_sdfull_pc/B.n9 218.815
R55 nfet_01v8_W1p4_L0p6_m36__nf1_gboth_sdfull_pc/B.n41 nfet_01v8_W1p4_L0p6_m36__nf1_gboth_sdfull_pc/B.n32 218.815
R56 nfet_01v8_W1p4_L0p6_m36__nf1_gboth_sdfull_pc/B.n42 nfet_01v8_W1p4_L0p6_m36__nf1_gboth_sdfull_pc/B.n41 218.815
R57 nfet_01v8_W1p4_L0p6_m36__nf1_gboth_sdfull_pc/B.n12 nfet_01v8_W1p4_L0p6_m36__nf1_gboth_sdfull_pc/B.n8 147.374
R58 nfet_01v8_W1p4_L0p6_m36__nf1_gboth_sdfull_pc/B.n17 nfet_01v8_W1p4_L0p6_m36__nf1_gboth_sdfull_pc/B.n16 147.374
R59 nfet_01v8_W1p4_L0p6_m36__nf1_gboth_sdfull_pc/B.n20 nfet_01v8_W1p4_L0p6_m36__nf1_gboth_sdfull_pc/B.n19 147.374
R60 nfet_01v8_W1p4_L0p6_m36__nf1_gboth_sdfull_pc/B.n36 nfet_01v8_W1p4_L0p6_m36__nf1_gboth_sdfull_pc/B.n32 147.374
R61 nfet_01v8_W1p4_L0p6_m36__nf1_gboth_sdfull_pc/B.n42 nfet_01v8_W1p4_L0p6_m36__nf1_gboth_sdfull_pc/B.n31 147.374
R62 nfet_01v8_W1p4_L0p6_m36__nf1_gboth_sdfull_pc/B.n34 nfet_01v8_W1p4_L0p6_m36__nf1_gboth_sdfull_pc/B.n32 147.374
R63 nfet_01v8_W1p4_L0p6_m36__nf1_gboth_sdfull_pc/B.n43 nfet_01v8_W1p4_L0p6_m36__nf1_gboth_sdfull_pc/B.n42 147.374
R64 nfet_01v8_W1p4_L0p6_m36__nf1_gboth_sdfull_pc/B.n19 nfet_01v8_W1p4_L0p6_m36__nf1_gboth_sdfull_pc/B.n10 147.374
R65 nfet_01v8_W1p4_L0p6_m36__nf1_gboth_sdfull_pc/B.n18 nfet_01v8_W1p4_L0p6_m36__nf1_gboth_sdfull_pc/B.n17 147.374
R66 nfet_01v8_W1p4_L0p6_m36__nf1_gboth_sdfull_pc/B.n13 nfet_01v8_W1p4_L0p6_m36__nf1_gboth_sdfull_pc/B.n12 147.374
R67 nfet_01v8_W1p4_L0p6_m36__nf1_gboth_sdfull_pc/B.n35 nfet_01v8_W1p4_L0p6_m36__nf1_gboth_sdfull_pc/B.n1 79.4358
R68 nfet_01v8_W1p4_L0p6_m36__nf1_gboth_sdfull_pc/B.n23 nfet_01v8_W1p4_L0p6_m36__nf1_gboth_sdfull_pc/B.n22 79.4358
R69 nfet_01v8_W1p4_L0p6_m36__nf1_gboth_sdfull_pc/B.n45 nfet_01v8_W1p4_L0p6_m36__nf1_gboth_sdfull_pc/B.n44 79.4358
R70 nfet_01v8_W1p4_L0p6_m36__nf1_gboth_sdfull_pc/B.n28 nfet_01v8_W1p4_L0p6_m36__nf1_gboth_sdfull_pc/B.n7 79.4358
R71 nfet_01v8_W1p4_L0p6_m36__nf1_gboth_sdfull_pc/B.n37 nfet_01v8_W1p4_L0p6_m36__nf1_gboth_sdfull_pc/B.n35 25.6005
R72 nfet_01v8_W1p4_L0p6_m36__nf1_gboth_sdfull_pc/B.n38 nfet_01v8_W1p4_L0p6_m36__nf1_gboth_sdfull_pc/B.n37 25.6005
R73 nfet_01v8_W1p4_L0p6_m36__nf1_gboth_sdfull_pc/B.n39 nfet_01v8_W1p4_L0p6_m36__nf1_gboth_sdfull_pc/B.n38 25.6005
R74 nfet_01v8_W1p4_L0p6_m36__nf1_gboth_sdfull_pc/B.n39 nfet_01v8_W1p4_L0p6_m36__nf1_gboth_sdfull_pc/B.n30 25.6005
R75 nfet_01v8_W1p4_L0p6_m36__nf1_gboth_sdfull_pc/B.n44 nfet_01v8_W1p4_L0p6_m36__nf1_gboth_sdfull_pc/B.n30 25.6005
R76 nfet_01v8_W1p4_L0p6_m36__nf1_gboth_sdfull_pc/B.n50 nfet_01v8_W1p4_L0p6_m36__nf1_gboth_sdfull_pc/B.n1 25.6005
R77 nfet_01v8_W1p4_L0p6_m36__nf1_gboth_sdfull_pc/B.n23 nfet_01v8_W1p4_L0p6_m36__nf1_gboth_sdfull_pc/B.n0 25.6005
R78 nfet_01v8_W1p4_L0p6_m36__nf1_gboth_sdfull_pc/B.n22 nfet_01v8_W1p4_L0p6_m36__nf1_gboth_sdfull_pc/B.n21 25.6005
R79 nfet_01v8_W1p4_L0p6_m36__nf1_gboth_sdfull_pc/B.n21 nfet_01v8_W1p4_L0p6_m36__nf1_gboth_sdfull_pc/B.n11 25.6005
R80 nfet_01v8_W1p4_L0p6_m36__nf1_gboth_sdfull_pc/B.n15 nfet_01v8_W1p4_L0p6_m36__nf1_gboth_sdfull_pc/B.n11 25.6005
R81 nfet_01v8_W1p4_L0p6_m36__nf1_gboth_sdfull_pc/B.n15 nfet_01v8_W1p4_L0p6_m36__nf1_gboth_sdfull_pc/B.n14 25.6005
R82 nfet_01v8_W1p4_L0p6_m36__nf1_gboth_sdfull_pc/B.n14 nfet_01v8_W1p4_L0p6_m36__nf1_gboth_sdfull_pc/B.n7 25.6005
R83 nfet_01v8_W1p4_L0p6_m36__nf1_gboth_sdfull_pc/B.n46 nfet_01v8_W1p4_L0p6_m36__nf1_gboth_sdfull_pc/B.n45 25.6005
R84 nfet_01v8_W1p4_L0p6_m36__nf1_gboth_sdfull_pc/B.n46 nfet_01v8_W1p4_L0p6_m36__nf1_gboth_sdfull_pc/B.n29 25.6005
R85 nfet_01v8_W1p4_L0p6_m36__nf1_gboth_sdfull_pc/B.n29 nfet_01v8_W1p4_L0p6_m36__nf1_gboth_sdfull_pc/B.n28 25.6005
R86 B nfet_01v8_W1p4_L0p6_m36__nf1_gboth_sdfull_pc/B.n0 19.2005
R87 B nfet_01v8_W1p4_L0p6_m36__nf1_gboth_sdfull_pc/B.n50 6.4005
R88 B.n45 B.n8 1222.56
R89 B.n48 B.n47 1222.56
R90 B.n19 B.n14 1222.56
R91 B.n26 B.n16 1222.56
R92 B.n46 B.n2 1135.77
R93 B.n24 B.n15 1135.77
R94 B.n46 B.n5 608.13
R95 B.n38 B.n5 608.13
R96 B.n38 B.n11 608.13
R97 B.n31 B.n11 608.13
R98 B.n31 B.n15 608.13
R99 B.n43 B.n8 585
R100 B.n42 B.n1 585
R101 B.n51 B.n50 585
R102 B.n48 B.n0 585
R103 B.n47 B.n46 585
R104 B.n47 B.n4 585
R105 B.n5 B.n3 585
R106 B.n35 B.n3 585
R107 B.n38 B.n37 585
R108 B.n37 B.n36 585
R109 B.n12 B.n11 585
R110 B.n34 B.n12 585
R111 B.n32 B.n31 585
R112 B.n33 B.n32 585
R113 B.n15 B.n14 585
R114 B.n14 B.n13 585
R115 B.n20 B.n19 585
R116 B.n22 B.n21 585
R117 B.n18 B.n17 585
R118 B.n27 B.n26 585
R119 B.n16 B.n15 585
R120 B.n28 B.n16 585
R121 B.n31 B.n30 585
R122 B.n30 B.n29 585
R123 B.n11 B.n10 585
R124 B.n10 B.n9 585
R125 B.n39 B.n38 585
R126 B.n40 B.n39 585
R127 B.n6 B.n5 585
R128 B.n41 B.n6 585
R129 B.n46 B.n45 585
R130 B.n45 B.n44 585
R131 B.n45 B.n6 394
R132 B.n39 B.n6 394
R133 B.n39 B.n10 394
R134 B.n30 B.n10 394
R135 B.n30 B.n16 394
R136 B.n50 B.n1 394
R137 B.n47 B.n3 394
R138 B.n37 B.n3 394
R139 B.n37 B.n12 394
R140 B.n32 B.n12 394
R141 B.n32 B.n14 394
R142 B.n22 B.n18 394
R143 B.n2 B 384.553
R144 B.n7 B.n2 218.815
R145 B.n49 B.n2 218.815
R146 B.n24 B.n23 218.815
R147 B.n25 B.n24 218.815
R148 B.n8 B.n7 147.374
R149 B.n50 B.n49 147.374
R150 B.n23 B.n19 147.374
R151 B.n25 B.n18 147.374
R152 B.n49 B.n48 147.374
R153 B.n7 B.n1 147.374
R154 B.n23 B.n22 147.374
R155 B.n26 B.n25 147.374
R156 B.n4 B.n0 79.4358
R157 B.n20 B.n13 79.4358
R158 B.n44 B.n43 79.4358
R159 B.n28 B.n27 79.4358
R160 B.n51 B.n0 25.6005
R161 B.n43 B.n42 25.6005
R162 B.n35 B.n4 25.6005
R163 B.n36 B.n35 25.6005
R164 B.n36 B.n34 25.6005
R165 B.n34 B.n33 25.6005
R166 B.n33 B.n13 25.6005
R167 B.n21 B.n20 25.6005
R168 B.n21 B.n17 25.6005
R169 B.n27 B.n17 25.6005
R170 B.n44 B.n41 25.6005
R171 B.n41 B.n40 25.6005
R172 B.n40 B.n9 25.6005
R173 B.n29 B.n9 25.6005
R174 B.n29 B.n28 25.6005
R175 B.n42 B 19.2005
R176 B B.n51 6.4005
R177 w_n43_n43.n48 w_n43_n43.n47 1222.56
R178 w_n43_n43.n45 w_n43_n43.n9 1222.56
R179 w_n43_n43.n20 w_n43_n43.n15 1222.56
R180 w_n43_n43.n27 w_n43_n43.n17 1222.56
R181 w_n43_n43.n46 w_n43_n43.n3 1135.77
R182 w_n43_n43.n25 w_n43_n43.n16 1135.77
R183 w_n43_n43.n46 w_n43_n43.n6 608.13
R184 w_n43_n43.n39 w_n43_n43.n6 608.13
R185 w_n43_n43.n39 w_n43_n43.n12 608.13
R186 w_n43_n43.n32 w_n43_n43.n12 608.13
R187 w_n43_n43.n32 w_n43_n43.n16 608.13
R188 w_n43_n43.n21 w_n43_n43.n20 585
R189 w_n43_n43.n23 w_n43_n43.n22 585
R190 w_n43_n43.n19 w_n43_n43.n18 585
R191 w_n43_n43.n28 w_n43_n43.n27 585
R192 w_n43_n43.n17 w_n43_n43.n16 585
R193 w_n43_n43.n29 w_n43_n43.n17 585
R194 w_n43_n43.n32 w_n43_n43.n31 585
R195 w_n43_n43.n31 w_n43_n43.n30 585
R196 w_n43_n43.n12 w_n43_n43.n11 585
R197 w_n43_n43.n11 w_n43_n43.n10 585
R198 w_n43_n43.n40 w_n43_n43.n39 585
R199 w_n43_n43.n41 w_n43_n43.n40 585
R200 w_n43_n43.n7 w_n43_n43.n6 585
R201 w_n43_n43.n42 w_n43_n43.n7 585
R202 w_n43_n43.n46 w_n43_n43.n45 585
R203 w_n43_n43.n45 w_n43_n43.n44 585
R204 w_n43_n43.n43 w_n43_n43.n9 585
R205 w_n43_n43.n2 w_n43_n43.n0 585
R206 w_n43_n43.n51 w_n43_n43.n50 585
R207 w_n43_n43.n48 w_n43_n43.n1 585
R208 w_n43_n43.n47 w_n43_n43.n46 585
R209 w_n43_n43.n47 w_n43_n43.n5 585
R210 w_n43_n43.n6 w_n43_n43.n4 585
R211 w_n43_n43.n36 w_n43_n43.n4 585
R212 w_n43_n43.n39 w_n43_n43.n38 585
R213 w_n43_n43.n38 w_n43_n43.n37 585
R214 w_n43_n43.n13 w_n43_n43.n12 585
R215 w_n43_n43.n35 w_n43_n43.n13 585
R216 w_n43_n43.n33 w_n43_n43.n32 585
R217 w_n43_n43.n34 w_n43_n43.n33 585
R218 w_n43_n43.n16 w_n43_n43.n15 585
R219 w_n43_n43.n15 w_n43_n43.n14 585
R220 w_n43_n43.n47 w_n43_n43.n4 394
R221 w_n43_n43.n38 w_n43_n43.n4 394
R222 w_n43_n43.n38 w_n43_n43.n13 394
R223 w_n43_n43.n33 w_n43_n43.n13 394
R224 w_n43_n43.n33 w_n43_n43.n15 394
R225 w_n43_n43.n50 w_n43_n43.n2 394
R226 w_n43_n43.n45 w_n43_n43.n7 394
R227 w_n43_n43.n40 w_n43_n43.n7 394
R228 w_n43_n43.n40 w_n43_n43.n11 394
R229 w_n43_n43.n31 w_n43_n43.n11 394
R230 w_n43_n43.n31 w_n43_n43.n17 394
R231 w_n43_n43.n23 w_n43_n43.n19 394
R232 w_n43_n43.n3 B 384.553
R233 w_n43_n43.n25 w_n43_n43.n24 218.815
R234 w_n43_n43.n26 w_n43_n43.n25 218.815
R235 w_n43_n43.n8 w_n43_n43.n3 218.815
R236 w_n43_n43.n49 w_n43_n43.n3 218.815
R237 w_n43_n43.n24 w_n43_n43.n20 147.374
R238 w_n43_n43.n26 w_n43_n43.n19 147.374
R239 w_n43_n43.n9 w_n43_n43.n8 147.374
R240 w_n43_n43.n50 w_n43_n43.n49 147.374
R241 w_n43_n43.n49 w_n43_n43.n48 147.374
R242 w_n43_n43.n8 w_n43_n43.n2 147.374
R243 w_n43_n43.n24 w_n43_n43.n23 147.374
R244 w_n43_n43.n27 w_n43_n43.n26 147.374
R245 w_n43_n43.n5 w_n43_n43.n1 79.4358
R246 w_n43_n43.n44 w_n43_n43.n43 79.4358
R247 w_n43_n43.n21 w_n43_n43.n14 79.4358
R248 w_n43_n43.n29 w_n43_n43.n28 79.4358
R249 w_n43_n43.n36 w_n43_n43.n5 25.6005
R250 w_n43_n43.n37 w_n43_n43.n36 25.6005
R251 w_n43_n43.n37 w_n43_n43.n35 25.6005
R252 w_n43_n43.n35 w_n43_n43.n34 25.6005
R253 w_n43_n43.n34 w_n43_n43.n14 25.6005
R254 w_n43_n43.n51 w_n43_n43.n1 25.6005
R255 w_n43_n43.n43 w_n43_n43.n0 25.6005
R256 w_n43_n43.n44 w_n43_n43.n42 25.6005
R257 w_n43_n43.n42 w_n43_n43.n41 25.6005
R258 w_n43_n43.n41 w_n43_n43.n10 25.6005
R259 w_n43_n43.n30 w_n43_n43.n10 25.6005
R260 w_n43_n43.n30 w_n43_n43.n29 25.6005
R261 w_n43_n43.n22 w_n43_n43.n21 25.6005
R262 w_n43_n43.n22 w_n43_n43.n18 25.6005
R263 w_n43_n43.n28 w_n43_n43.n18 25.6005
R264 B w_n43_n43.n0 19.2005
R265 B w_n43_n43.n51 6.4005
C3 B.n0 B 0 ; **FLOATING
C4 B.n1 B 0 ; **FLOATING
C5 B.n2 B 0 ; **FLOATING
C6 B.n3 B 0 ; **FLOATING
C7 B.n4 B 0 ; **FLOATING
C8 B.n5 B 0 ; **FLOATING
C9 B.n6 B 0 ; **FLOATING
C10 B.n8 B 0 ; **FLOATING
C11 B.n9 B 0 ; **FLOATING
C12 B.n10 B 0 ; **FLOATING
C13 B.n11 B 0 ; **FLOATING
C14 B.n12 B 0 ; **FLOATING
C15 B.n13 B 0 ; **FLOATING
C16 B.n14 B 0 ; **FLOATING
C17 B.n15 B 0 ; **FLOATING
C18 B.n16 B 0 ; **FLOATING
C19 B.n17 B 0 ; **FLOATING
C20 B.n18 B 0 ; **FLOATING
C21 B.n19 B 0 ; **FLOATING
C22 B.n20 B 0 ; **FLOATING
C23 B.n21 B 0 ; **FLOATING
C24 B.n22 B 0 ; **FLOATING
C25 B.n24 B 0 ; **FLOATING
C26 B.n26 B 0 ; **FLOATING
C27 B.n27 B 0 ; **FLOATING
C28 B.n28 B 0 ; **FLOATING
C29 B.n29 B 0 ; **FLOATING
C30 B.n30 B 0 ; **FLOATING
C31 B.n31 B 0 ; **FLOATING
C32 B.n32 B 0 ; **FLOATING
C33 B.n33 B 0 ; **FLOATING
C34 B.n34 B 0 ; **FLOATING
C35 B.n35 B 0 ; **FLOATING
C36 B.n36 B 0 ; **FLOATING
C37 B.n37 B 0 ; **FLOATING
C38 B.n38 B 0 ; **FLOATING
C39 B.n39 B 0 ; **FLOATING
C40 B.n40 B 0 ; **FLOATING
C41 B.n41 B 0 ; **FLOATING
C42 B.n42 B 0 ; **FLOATING
C43 B.n43 B 0 ; **FLOATING
C44 B.n44 B 0 ; **FLOATING
C45 B.n45 B 0 ; **FLOATING
C46 B.n46 B 0 ; **FLOATING
C47 B.n47 B 0 ; **FLOATING
C48 B.n48 B 0 ; **FLOATING
C49 B.n50 B 0 ; **FLOATING
C50 B.n51 B 0 ; **FLOATING
C51 S B 0.14735f
C52 D B 0.14735f
C53 G B 0.39519f
