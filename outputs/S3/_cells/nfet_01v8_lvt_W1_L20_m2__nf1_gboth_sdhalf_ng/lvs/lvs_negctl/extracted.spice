* NGSPICE file created from nfet_01v8_lvt_W1_L20_m2__nf1_gboth_sdhalf_ng.ext - technology: sky130A

.subckt sky130_fd_pr__nfet_01v8_lvt_Q99JKM G D S VSUBS
X0 S G D VSUBS sky130_fd_pr__nfet_01v8_lvt ad=0.29 pd=2.58 as=0.29 ps=2.58 w=1 l=20
.ends

.subckt nfet_01v8_lvt_W1_L20_m2__nf1_gboth_sdhalf_ng D S G B
Xnfet_01v8_lvt_W1_L20_m2__nf1_gboth_sdhalf_ng_pc G D S B sky130_fd_pr__nfet_01v8_lvt_Q99JKM
.ends
