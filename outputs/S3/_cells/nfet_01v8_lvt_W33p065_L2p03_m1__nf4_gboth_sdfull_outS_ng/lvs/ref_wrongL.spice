.subckt nfet_01v8_lvt_W33p065_L2p03_m1__nf4_gboth_sdfull_outS_ng D G S B
Xnfet_01v8_lvt_W33p065_L2p03_m1__nf4_gboth_sdfull_outS_ng D G S B sky130_fd_pr__nfet_01v8_lvt L=2.233 W=33.065 nf=4
.ends
