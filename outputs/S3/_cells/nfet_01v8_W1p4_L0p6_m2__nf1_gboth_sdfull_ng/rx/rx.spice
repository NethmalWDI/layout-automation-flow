* NGSPICE file created from nfet_01v8_W1p4_L0p6_m2__nf1_gboth_sdfull_ng.ext - technology: sky130A

X0 S G D B sky130_fd_pr__nfet_01v8 ad=0.406 pd=3.38 as=0.406 ps=3.38 w=1.4 l=0.6
C0 D G 0.05758f
C1 D S 0.06099f
C2 G S 0.05758f
C3 S B 0.1516f
C4 D B 0.1516f
C5 G B 0.38126f
