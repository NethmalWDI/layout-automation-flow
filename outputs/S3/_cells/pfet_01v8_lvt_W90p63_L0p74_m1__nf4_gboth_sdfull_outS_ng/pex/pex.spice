* NGSPICE file created from pfet_01v8_lvt_W90p63_L0p74_m1__nf4_gboth_sdfull_outS_ng.ext - technology: sky130A

.subckt pfet_01v8_lvt_W90p63_L0p74_m1__nf4_gboth_sdfull_outS_ng S D G B
X0 S G D B sky130_fd_pr__pfet_01v8_lvt ad=6.5714 pd=45.9 as=3.2857 ps=22.95 w=22.66 l=0.74
X1 D G S B sky130_fd_pr__pfet_01v8_lvt ad=3.2857 pd=22.95 as=6.5714 ps=45.9 w=22.66 l=0.74
X2 D G S B sky130_fd_pr__pfet_01v8_lvt ad=3.2857 pd=22.95 as=3.2857 ps=22.95 w=22.66 l=0.74
X3 S G D B sky130_fd_pr__pfet_01v8_lvt ad=3.2857 pd=22.95 as=3.2857 ps=22.95 w=22.66 l=0.74
C0 S D 3.63006f
C1 B D 0.97874f
C2 G D 4.50625f
C3 B S 1.2848f
C4 S G 4.51127f
C5 B G 0.6389f
C6 D VSUBS 0.17764f
C7 S VSUBS 3.37582f
C8 G VSUBS 1.14051f
C9 B VSUBS 9.5362f
.ends
