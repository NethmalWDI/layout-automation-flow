* NGSPICE file created from pfet_01v8_lvt_W14p21_L0p89_m1__nf4_gboth_sdhalf_outS_ng.ext - technology: sky130A

.subckt sky130_fd_pr__pfet_01v8_lvt_TK8ZRH G D2 D0 S3 a_443_n355# S1 w_n537_n455#
X0 S3 G D2 w_n537_n455# sky130_fd_pr__pfet_01v8_lvt ad=0.51475 pd=3.84 as=0.51475 ps=3.84 w=3.55 l=0.89
X1 D2 G S1 w_n537_n455# sky130_fd_pr__pfet_01v8_lvt ad=0.51475 pd=3.84 as=0.51475 ps=3.84 w=3.55 l=0.89
X2 S1 G D0 w_n537_n455# sky130_fd_pr__pfet_01v8_lvt ad=0.51475 pd=3.84 as=1.0295 ps=7.68 w=3.55 l=0.89
X3 a_443_n355# G S3 w_n537_n455# sky130_fd_pr__pfet_01v8_lvt ad=1.0295 pd=7.68 as=0.51475 ps=3.84 w=3.55 l=0.89
.ends

.subckt pfet_01v8_lvt_W14p21_L0p89_m1__nf4_gboth_sdhalf_outS_ng S D G B
Xpfet_01v8_lvt_W14p21_L0p89_m1__nf4_gboth_sdhalf_outS_ng_pc G S S D S D B sky130_fd_pr__pfet_01v8_lvt_TK8ZRH
.ends
