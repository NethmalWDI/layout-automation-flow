* NGSPICE file created from Diff_Opamp_flat.ext - technology: sky130A

.subckt Diff_Opamp_flat Rgm Vop Vm Vss Vref Vom en_1 Vdd en_2 2stage_op_amp_1/Diff_opamp_ly_0.Vbias3
+ 2stage_op_amp_1/Diff_opamp_ly_0.Vbias2 2stage_op_amp_1/Diff_opamp_ly_0.nmos_cload_01_1.Vbias1
+ 2stage_op_amp_1/switchblock_1.beta 2stage_op_amp_1/bias_dummy_0.PBias 2stage_op_amp_1/bias_dummy_0.Vbias1
+ 2stage_op_amp_1/bias_dummy_0.Vbias2 2stage_op_amp_1/bias_dummy_0.Vbias3 2stage_op_amp_1/bias_dummy_0.Vbias4
X0 a_12205_17226# 2stage_op_amp_1/Diff_opamp_ly_0.Vbias2 a_12906_6188# Vss sky130_fd_pr__nfet_01v8_lvt ad=0.29 pd=2.58 as=0.29 ps=2.58 w=1 l=10
X1 Vdd Vdd Vdd Vdd sky130_fd_pr__pfet_01v8_lvt ad=0.29 pd=2.58 as=266.51001 ps=2.17324k w=1 l=1
X2 Vdd a_19456_19784# a_12205_19284# Vdd sky130_fd_pr__pfet_01v8_lvt ad=0.29 pd=2.58 as=0.29 ps=2.58 w=1 l=5
X3 Vss Vss Vss Vss sky130_fd_pr__nfet_01v8_lvt ad=0.29 pd=2.58 as=182.1084 ps=1.6016k w=1 l=1
X4 a_20243_25373# a_28673_25673# sky130_fd_pr__res_generic_po w=0.5 l=40
X5 Vdd Vdd Vdd Vdd sky130_fd_pr__pfet_01v8_lvt ad=0.29 pd=2.58 as=0 ps=0 w=1 l=1
X6 a_12205_19284# Vm a_12356_8500# Vss sky130_fd_pr__nfet_01v8_lvt ad=0.58 pd=4.58 as=0.58 ps=4.58 w=2 l=10
X7 Vss Vss Vss Vss sky130_fd_pr__nfet_01v8_lvt ad=0.145 pd=1.58 as=0 ps=0 w=0.5 l=10
X8 a_12205_19284# Vm a_12356_8500# Vss sky130_fd_pr__nfet_01v8_lvt ad=0.58 pd=4.58 as=0.58 ps=4.58 w=2 l=10
X9 a_12205_19546# a_n347_21647# sky130_fd_pr__cap_mim_m3_1 l=10 w=10
X10 Vdd Vdd sky130_fd_pr__cap_mim_m3_1 l=10 w=2
X11 Vss Vss Vss Vss sky130_fd_pr__nfet_01v8_lvt ad=0.29 pd=2.58 as=0 ps=0 w=1 l=1
X12 a_12205_21604# a_12179_17284# a_12205_19546# Vdd sky130_fd_pr__pfet_01v8_lvt ad=0.145 pd=1.58 as=0.145 ps=1.58 w=0.5 l=10
X13 a_12205_19284# a_12179_17284# a_12205_17226# Vdd sky130_fd_pr__pfet_01v8_lvt ad=0.145 pd=1.58 as=0.145 ps=1.58 w=0.5 l=10
X14 Vdd a_23489_19515# a_23489_19515# Vdd sky130_fd_pr__pfet_01v8_lvt ad=0.29 pd=2.58 as=0.29 ps=2.58 w=1 l=5
X15 Vdd Vdd Vdd Vdd sky130_fd_pr__pfet_01v8_lvt ad=0.145 pd=1.58 as=0 ps=0 w=0.5 l=0.5
X16 Vss Vss Vss Vss sky130_fd_pr__nfet_01v8_lvt ad=0.29 pd=2.58 as=0 ps=0 w=1 l=1
X17 a_19456_19784# a_12205_19546# sky130_fd_pr__cap_mim_m3_1 l=10 w=10
X18 a_12906_6188# 2stage_op_amp_1/Diff_opamp_ly_0.nmos_cload_01_1.Vbias1 Vss Vss sky130_fd_pr__nfet_01v8_lvt ad=0.145 pd=1.58 as=0.145 ps=1.58 w=0.5 l=10
X19 Vdd Vdd Vdd Vdd sky130_fd_pr__pfet_01v8_lvt ad=0.145 pd=1.58 as=0 ps=0 w=0.5 l=0.5
X20 Vdd Vdd Vdd Vdd sky130_fd_pr__pfet_01v8_lvt ad=0.145 pd=1.58 as=0 ps=0 w=0.5 l=0.5
X21 Vdd Vdd Vdd Vdd sky130_fd_pr__pfet_01v8_lvt ad=0.145 pd=1.58 as=0 ps=0 w=0.5 l=0.5
X22 Vss Vss Vss Vss sky130_fd_pr__nfet_01v8_lvt ad=0.0609 pd=0.71 as=0 ps=0 w=0.42 l=0.15
X23 Vdd 2stage_op_amp_1/bias_dummy_0.PBias a_1785_12473# Vdd sky130_fd_pr__pfet_01v8_lvt ad=1.45 pd=10.58 as=1.45 ps=10.58 w=5 l=2
X24 Vom a_23130_13378# Vss Vss sky130_fd_pr__nfet_01v8_lvt ad=0.29 pd=2.58 as=0.29 ps=2.58 w=1 l=1
X25 a_12356_8500# 2stage_op_amp_1/Diff_opamp_ly_0.Vbias2 a_13686_3858# Vss sky130_fd_pr__nfet_01v8_lvt ad=0.29 pd=2.58 as=0.29 ps=2.58 w=1 l=10
X26 Vdd Vdd Vdd Vdd sky130_fd_pr__pfet_01v8_lvt ad=0.29 pd=2.58 as=0 ps=0 w=1 l=1
X27 Vdd a_12179_17284# a_12179_17284# Vdd sky130_fd_pr__pfet_01v8_lvt ad=0.145 pd=1.58 as=0.145 ps=1.58 w=0.5 l=10
X28 Vdd Vdd Vdd Vdd sky130_fd_pr__pfet_01v8_lvt ad=0.29 pd=2.58 as=0 ps=0 w=1 l=1
X29 Vdd Vdd Vdd Vdd sky130_fd_pr__pfet_01v8_lvt ad=0.29 pd=2.58 as=0 ps=0 w=1 l=5
X30 a_19456_19784# Vref a_14206_3858# Vss sky130_fd_pr__nfet_01v8_lvt ad=0.145 pd=1.58 as=0.145 ps=1.58 w=0.5 l=10
X31 Vss Vss Vss Vss sky130_fd_pr__nfet_01v8_lvt ad=0.145 pd=1.58 as=0 ps=0 w=0.5 l=0.5
X32 Vdd a_12205_19546# Vop Vdd sky130_fd_pr__pfet_01v8_lvt ad=0.58 pd=4.58 as=0.58 ps=4.58 w=2 l=1
X33 Vss Vss Vss Vss sky130_fd_pr__nfet_01v8_lvt ad=0.29 pd=2.58 as=0 ps=0 w=1 l=1
X34 a_12356_8500# 2stage_op_amp_1/Diff_opamp_ly_0.Vbias2 a_13686_3858# Vss sky130_fd_pr__nfet_01v8_lvt ad=0.29 pd=2.58 as=0.29 ps=2.58 w=1 l=10
X35 a_12205_19284# Vm a_12356_8500# Vss sky130_fd_pr__nfet_01v8_lvt ad=0.58 pd=4.58 as=0.58 ps=4.58 w=2 l=10
X36 Vdd Vdd sky130_fd_pr__cap_mim_m3_1 l=2 w=2
X37 Vdd Vdd sky130_fd_pr__cap_mim_m3_1 l=2 w=10
X38 a_12356_8500# 2stage_op_amp_1/Diff_opamp_ly_0.Vbias2 a_13686_6188# Vss sky130_fd_pr__nfet_01v8_lvt ad=0.29 pd=2.58 as=0.29 ps=2.58 w=1 l=10
X39 Vss Vss Vss Vss sky130_fd_pr__nfet_01v8_lvt ad=0.145 pd=1.58 as=0 ps=0 w=0.5 l=0.5
X40 Vss Vss sky130_fd_pr__cap_mim_m3_1 l=2 w=10
X41 a_n1341_21647# Vom sky130_fd_pr__res_generic_po w=0.5 l=40
X42 Vss Vss Vss Vss sky130_fd_pr__nfet_01v8_lvt ad=0.58 pd=4.58 as=0 ps=0 w=2 l=10
X43 Vom a_23130_13378# Vss Vss sky130_fd_pr__nfet_01v8_lvt ad=0.29 pd=2.58 as=0.29 ps=2.58 w=1 l=1
X44 a_19456_19784# Vref a_14206_6188# Vss sky130_fd_pr__nfet_01v8_lvt ad=0.145 pd=1.58 as=0.145 ps=1.58 w=0.5 l=10
X45 Vss Vss Vss Vss sky130_fd_pr__nfet_01v8_lvt ad=0.145 pd=1.58 as=0 ps=0 w=0.5 l=0.5
X46 Vdd Vdd Vdd Vdd sky130_fd_pr__pfet_01v8_lvt ad=0.29 pd=2.58 as=0 ps=0 w=1 l=5
X47 Vdd a_23489_19515# a_23489_19515# Vdd sky130_fd_pr__pfet_01v8_lvt ad=0.29 pd=2.58 as=0.29 ps=2.58 w=1 l=5
X48 Vss Vss sky130_fd_pr__cap_mim_m3_1 l=2 w=2
X49 Vss Vss Vss Vss sky130_fd_pr__nfet_01v8_lvt ad=0.174 pd=1.78 as=0 ps=0 w=0.6 l=1
X50 Vdd Vdd Vdd Vdd sky130_fd_pr__pfet_01v8_lvt ad=0.29 pd=2.58 as=0 ps=0 w=1 l=1
X51 Vdd Vdd Vdd Vdd sky130_fd_pr__pfet_01v8_lvt ad=0.145 pd=1.58 as=0 ps=0 w=0.5 l=10
X52 a_12205_17226# 2stage_op_amp_1/Diff_opamp_ly_0.Vbias2 a_12906_6188# Vss sky130_fd_pr__nfet_01v8_lvt ad=0.29 pd=2.58 as=0.29 ps=2.58 w=1 l=10
X53 a_20243_25823# a_28673_26123# sky130_fd_pr__res_generic_po w=0.5 l=40
X54 Vdd Vdd Vdd Vdd sky130_fd_pr__pfet_01v8_lvt ad=0.29 pd=2.58 as=0 ps=0 w=1 l=5
X55 Vss Vss Vss Vss sky130_fd_pr__nfet_01v8_lvt ad=0.174 pd=1.78 as=0 ps=0 w=0.6 l=1
X56 Vdd Vdd Vdd Vdd sky130_fd_pr__pfet_01v8_lvt ad=0.29 pd=2.58 as=0 ps=0 w=1 l=1
X57 Vop a_23130_13378# Vss Vss sky130_fd_pr__nfet_01v8_lvt ad=0.29 pd=2.58 as=0.29 ps=2.58 w=1 l=1
X58 Vss Vss Vss Vss sky130_fd_pr__nfet_01v8_lvt ad=0.29 pd=2.58 as=0 ps=0 w=1 l=1
X59 Vss Vss Vss Vss sky130_fd_pr__nfet_01v8_lvt ad=0.29 pd=2.58 as=0 ps=0 w=1 l=1
X60 a_12356_8500# 2stage_op_amp_1/Diff_opamp_ly_0.Vbias2 a_13686_6188# Vss sky130_fd_pr__nfet_01v8_lvt ad=0.29 pd=2.58 as=0.29 ps=2.58 w=1 l=10
X61 a_12205_17226# 2stage_op_amp_1/Diff_opamp_ly_0.Vbias2 a_12906_6188# Vss sky130_fd_pr__nfet_01v8_lvt ad=0.29 pd=2.58 as=0.29 ps=2.58 w=1 l=10
X62 a_23130_13378# Vref a_26999_20995# Vdd sky130_fd_pr__pfet_01v8_lvt ad=0.145 pd=1.58 as=0.145 ps=1.58 w=0.5 l=10
X63 Vss Vss Vss Vss sky130_fd_pr__nfet_01v8_lvt ad=0.58 pd=4.58 as=0 ps=0 w=2 l=10
X64 a_12205_17226# a_n205_21647# sky130_fd_pr__cap_mim_m3_1 l=10 w=10
X65 Vss Vss Vss Vss sky130_fd_pr__nfet_01v8_lvt ad=0.145 pd=1.58 as=0 ps=0 w=0.5 l=0.5
X66 a_12356_8500# 2stage_op_amp_1/Diff_opamp_ly_0.Vbias2 a_13686_3858# Vss sky130_fd_pr__nfet_01v8_lvt ad=0.29 pd=2.58 as=0.29 ps=2.58 w=1 l=10
X67 Vss Vss Vss Vss sky130_fd_pr__nfet_01v8_lvt ad=0.29 pd=2.58 as=0 ps=0 w=1 l=1
X68 Vdd Vdd Vdd Vdd sky130_fd_pr__pfet_01v8_lvt ad=0.29 pd=2.58 as=0 ps=0 w=1 l=5
X69 Vss Vss sky130_fd_pr__cap_mim_m3_1 l=10 w=2
X70 a_12356_8500# 2stage_op_amp_1/Diff_opamp_ly_0.Vbias2 a_13686_3858# Vss sky130_fd_pr__nfet_01v8_lvt ad=0.29 pd=2.58 as=0.29 ps=2.58 w=1 l=10
X71 a_12205_19546# 2stage_op_amp_1/Diff_opamp_ly_0.Vbias2 a_12906_3858# Vss sky130_fd_pr__nfet_01v8_lvt ad=0.29 pd=2.58 as=0.29 ps=2.58 w=1 l=10
X72 Vss a_27034_13564# a_23130_13378# Vss sky130_fd_pr__nfet_01v8_lvt ad=0.145 pd=1.58 as=0.145 ps=1.58 w=0.5 l=20
X73 Vdd Vdd Vdd Vdd sky130_fd_pr__pfet_01v8_lvt ad=0.29 pd=2.58 as=0 ps=0 w=1 l=5
X74 Vdd Vdd Vdd Vdd sky130_fd_pr__pfet_01v8_lvt ad=0.29 pd=2.58 as=0 ps=0 w=1 l=5
X75 Vss Vss Vss Vss sky130_fd_pr__nfet_01v8_lvt ad=0.174 pd=1.78 as=0 ps=0 w=0.6 l=1
X76 Vss Vss Vss Vss sky130_fd_pr__nfet_01v8_lvt ad=0.29 pd=2.58 as=0 ps=0 w=1 l=1
X77 a_12906_6188# 2stage_op_amp_1/Diff_opamp_ly_0.nmos_cload_01_1.Vbias1 Vss Vss sky130_fd_pr__nfet_01v8_lvt ad=0.145 pd=1.58 as=0.145 ps=1.58 w=0.5 l=10
X78 a_12205_17226# a_n205_21647# sky130_fd_pr__cap_mim_m3_1 l=10 w=10
X79 Vdd 2stage_op_amp_1/bias_dummy_0.PBias a_1785_12473# Vdd sky130_fd_pr__pfet_01v8_lvt ad=1.45 pd=10.58 as=1.45 ps=10.58 w=5 l=2
X80 Vdd Vdd Vdd Vdd sky130_fd_pr__pfet_01v8_lvt ad=0.29 pd=2.58 as=0 ps=0 w=1 l=1
X81 Vom a_23130_13378# Vss Vss sky130_fd_pr__nfet_01v8_lvt ad=0.29 pd=2.58 as=0.29 ps=2.58 w=1 l=1
X82 Vss Vss Vss Vss sky130_fd_pr__nfet_01v8_lvt ad=0.29 pd=2.58 as=0 ps=0 w=1 l=1
X83 Vdd Vdd Vdd Vdd sky130_fd_pr__pfet_01v8_lvt ad=0.145 pd=1.58 as=0 ps=0 w=0.5 l=0.5
X84 2stage_op_amp_1/Diff_opamp_ly_0.nmos_cload_01_1.Vbias1 2stage_op_amp_1/Diff_opamp_ly_0.nmos_cload_01_1.Vbias1 Vss Vss sky130_fd_pr__nfet_01v8_lvt ad=0.145 pd=1.58 as=0.145 ps=1.58 w=0.5 l=10
X85 Vdd Vdd Vdd Vdd sky130_fd_pr__pfet_01v8_lvt ad=1.45 pd=10.58 as=0 ps=0 w=5 l=1
X86 a_12205_21604# a_12179_17284# a_12205_19546# Vdd sky130_fd_pr__pfet_01v8_lvt ad=0.145 pd=1.58 as=0.145 ps=1.58 w=0.5 l=10
X87 Vdd Vdd Vdd Vdd sky130_fd_pr__pfet_01v8_lvt ad=0.145 pd=1.58 as=0 ps=0 w=0.5 l=10
X88 Vdd Vdd Vdd Vdd sky130_fd_pr__pfet_01v8_lvt ad=0.145 pd=1.58 as=0 ps=0 w=0.5 l=0.5
X89 a_1532_20622# en_2 2stage_op_amp_1/Diff_opamp_ly_0.Vbias2 Vss sky130_fd_pr__nfet_01v8_lvt ad=0.29 pd=2.58 as=0.29 ps=2.58 w=1 l=0.15
X90 Vdd Vdd sky130_fd_pr__cap_mim_m3_1 l=2 w=10
X91 a_12205_17226# 2stage_op_amp_1/Diff_opamp_ly_0.Vbias2 a_12906_6188# Vss sky130_fd_pr__nfet_01v8_lvt ad=0.29 pd=2.58 as=0.29 ps=2.58 w=1 l=10
X92 a_12356_8500# 2stage_op_amp_1/Diff_opamp_ly_0.Vbias2 a_13686_6188# Vss sky130_fd_pr__nfet_01v8_lvt ad=0.29 pd=2.58 as=0.29 ps=2.58 w=1 l=10
X93 a_20243_25973# a_28673_25673# sky130_fd_pr__res_generic_po w=0.5 l=40
X94 Vdd Vdd Vdd Vdd sky130_fd_pr__pfet_01v8_lvt ad=0.145 pd=1.58 as=0 ps=0 w=0.5 l=0.5
X95 Vdd 2stage_op_amp_1/bias_dummy_0.PBias 2stage_op_amp_1/bias_dummy_0.Vbias1 Vdd sky130_fd_pr__pfet_01v8_lvt ad=1.45 pd=10.58 as=1.45 ps=10.58 w=5 l=2
X96 Vss Vss Vss Vss sky130_fd_pr__nfet_01v8_lvt ad=0.58 pd=4.58 as=0 ps=0 w=2 l=1
X97 Vop a_23130_13378# Vss Vss sky130_fd_pr__nfet_01v8_lvt ad=0.29 pd=2.58 as=0.29 ps=2.58 w=1 l=1
X98 Vss Vss sky130_fd_pr__cap_mim_m3_1 l=10 w=2
X99 Vdd Vdd Vdd Vdd sky130_fd_pr__pfet_01v8_lvt ad=0.145 pd=1.58 as=0 ps=0 w=0.5 l=0.5
X100 Vdd Vdd Vdd Vdd sky130_fd_pr__pfet_01v8_lvt ad=0.145 pd=1.58 as=0 ps=0 w=0.5 l=0.5
X101 Vdd Vdd Vdd Vdd sky130_fd_pr__pfet_01v8_lvt ad=1.45 pd=10.58 as=0 ps=0 w=5 l=2
X102 Vss Vss Vss Vss sky130_fd_pr__nfet_01v8_lvt ad=0.58 pd=4.58 as=0 ps=0 w=2 l=1
X103 a_19456_19784# Vref a_14206_3858# Vss sky130_fd_pr__nfet_01v8_lvt ad=0.145 pd=1.58 as=0.145 ps=1.58 w=0.5 l=10
X104 a_12205_21604# a_12179_17284# a_12205_19546# Vdd sky130_fd_pr__pfet_01v8_lvt ad=0.145 pd=1.58 as=0.145 ps=1.58 w=0.5 l=10
X105 Vdd a_23489_19515# a_23489_19515# Vdd sky130_fd_pr__pfet_01v8_lvt ad=0.29 pd=2.58 as=0.29 ps=2.58 w=1 l=5
X106 Vdd a_23489_19515# a_23489_19515# Vdd sky130_fd_pr__pfet_01v8_lvt ad=0.29 pd=2.58 as=0.29 ps=2.58 w=1 l=5
X107 Vss Vss Vss Vss sky130_fd_pr__nfet_01v8_lvt ad=1.45 pd=10.58 as=0 ps=0 w=5 l=2
X108 Vdd Vdd Vdd Vdd sky130_fd_pr__pfet_01v8_lvt ad=0.58 pd=4.58 as=0 ps=0 w=2 l=2
X109 a_12205_17226# a_n205_21647# sky130_fd_pr__cap_mim_m3_1 l=10 w=10
X110 Vss Vss Vss Vss sky130_fd_pr__nfet_01v8_lvt ad=0.145 pd=1.58 as=0 ps=0 w=0.5 l=0.5
X111 Vss Vss Vss Vss sky130_fd_pr__nfet_01v8_lvt ad=0.145 pd=1.58 as=0 ps=0 w=0.5 l=0.5
X112 Vss Vss Vss Vss sky130_fd_pr__nfet_01v8_lvt ad=1.45 pd=10.58 as=0 ps=0 w=5 l=2
X113 a_12205_19284# a_12179_17284# a_12205_17226# Vdd sky130_fd_pr__pfet_01v8_lvt ad=0.145 pd=1.58 as=0.145 ps=1.58 w=0.5 l=10
X114 a_12356_8500# 2stage_op_amp_1/Diff_opamp_ly_0.Vbias2 a_13686_3858# Vss sky130_fd_pr__nfet_01v8_lvt ad=0.29 pd=2.58 as=0.29 ps=2.58 w=1 l=10
X115 Vop a_23130_13378# Vss Vss sky130_fd_pr__nfet_01v8_lvt ad=0.29 pd=2.58 as=0.29 ps=2.58 w=1 l=1
X116 Vdd Vdd sky130_fd_pr__cap_mim_m3_1 l=2 w=10
X117 Vss Vss Vss Vss sky130_fd_pr__nfet_01v8_lvt ad=0.29 pd=2.58 as=0 ps=0 w=1 l=1
X118 Vdd Vdd Vdd Vdd sky130_fd_pr__pfet_01v8_lvt ad=0.29 pd=2.58 as=0 ps=0 w=1 l=1
X119 Vss Vss Vss Vss sky130_fd_pr__nfet_01v8_lvt ad=0.29 pd=2.58 as=0 ps=0 w=1 l=1
X120 Vss Vss Vss Vss sky130_fd_pr__nfet_01v8_lvt ad=0.145 pd=1.58 as=0 ps=0 w=0.5 l=0.5
X121 Vss Vss Vss Vss sky130_fd_pr__nfet_01v8_lvt ad=0.145 pd=1.58 as=0 ps=0 w=0.5 l=0.5
X122 a_20243_28973# Vom sky130_fd_pr__res_generic_po w=0.5 l=40
X123 Vss Vss Vss Vss sky130_fd_pr__nfet_01v8_lvt ad=0.145 pd=1.58 as=0 ps=0 w=0.5 l=0.5
X124 a_13686_6188# 2stage_op_amp_1/Diff_opamp_ly_0.nmos_cload_01_1.Vbias1 Vss Vss sky130_fd_pr__nfet_01v8_lvt ad=0.145 pd=1.58 as=0.145 ps=1.58 w=0.5 l=10
X125 Vss Vss Vss Vss sky130_fd_pr__nfet_01v8_lvt ad=0.145 pd=1.58 as=0 ps=0 w=0.5 l=0.5
X126 Vss Vss Vss Vss sky130_fd_pr__nfet_01v8_lvt ad=0.29 pd=2.58 as=0 ps=0 w=1 l=1
X127 Vom a_23130_13378# Vss Vss sky130_fd_pr__nfet_01v8_lvt ad=0.29 pd=2.58 as=0.29 ps=2.58 w=1 l=1
X128 Vss Vss Vss Vss sky130_fd_pr__nfet_01v8_lvt ad=0.29 pd=2.58 as=0 ps=0 w=1 l=1
X129 Vss Vss Vss Vss sky130_fd_pr__nfet_01v8_lvt ad=0.58 pd=4.58 as=0 ps=0 w=2 l=1
X130 a_12205_19284# Vm a_12356_8500# Vss sky130_fd_pr__nfet_01v8_lvt ad=0.58 pd=4.58 as=0.58 ps=4.58 w=2 l=10
X131 Vss Vss sky130_fd_pr__cap_mim_m3_1 l=2 w=10
X132 a_19456_19784# Vref a_14206_6188# Vss sky130_fd_pr__nfet_01v8_lvt ad=0.145 pd=1.58 as=0.145 ps=1.58 w=0.5 l=10
X133 2stage_op_amp_1/Diff_opamp_ly_0.nmos_cload_01_1.Vbias1 2stage_op_amp_1/Diff_opamp_ly_0.nmos_cload_01_1.Vbias1 Vss Vss sky130_fd_pr__nfet_01v8_lvt ad=0.145 pd=1.58 as=0.145 ps=1.58 w=0.5 l=10
X134 Vss Vss sky130_fd_pr__cap_mim_m3_1 l=2 w=10
X135 a_12356_8500# 2stage_op_amp_1/Diff_opamp_ly_0.Vbias2 a_13686_3858# Vss sky130_fd_pr__nfet_01v8_lvt ad=0.29 pd=2.58 as=0.29 ps=2.58 w=1 l=10
X136 Vdd Vdd Vdd Vdd sky130_fd_pr__pfet_01v8_lvt ad=0.29 pd=2.58 as=0 ps=0 w=1 l=1
X137 2stage_op_amp_1/switchblock_1.beta en_1 Rgm Vss sky130_fd_pr__nfet_01v8_lvt ad=0.29 pd=2.58 as=0.29 ps=2.58 w=1 l=0.15
X138 Vdd a_23489_19515# a_23489_19515# Vdd sky130_fd_pr__pfet_01v8_lvt ad=0.29 pd=2.58 as=0.29 ps=2.58 w=1 l=5
X139 Vdd a_23489_19515# a_26999_20995# Vdd sky130_fd_pr__pfet_01v8_lvt ad=0.29 pd=2.58 as=0.29 ps=2.58 w=1 l=5
X140 Vdd Vdd Vdd Vdd sky130_fd_pr__pfet_01v8_lvt ad=0.29 pd=2.58 as=0 ps=0 w=1 l=1
X141 2stage_op_amp_1/Diff_opamp_ly_0.nmos_cload_01_1.Vbias1 2stage_op_amp_1/Diff_opamp_ly_0.nmos_cload_01_1.Vbias1 Vss Vss sky130_fd_pr__nfet_01v8_lvt ad=0.145 pd=1.58 as=0.145 ps=1.58 w=0.5 l=10
X142 Vdd Vdd Vdd Vdd sky130_fd_pr__pfet_01v8_lvt ad=0.29 pd=2.58 as=0 ps=0 w=1 l=1
X143 Vdd Vdd Vdd Vdd sky130_fd_pr__pfet_01v8_lvt ad=0.58 pd=4.58 as=0 ps=0 w=2 l=2
X144 Vss Vss Vss Vss sky130_fd_pr__nfet_01v8_lvt ad=0.29 pd=2.58 as=0 ps=0 w=1 l=1
X145 Vss Vss Vss Vss sky130_fd_pr__nfet_01v8_lvt ad=0.58 pd=4.58 as=0 ps=0 w=2 l=1
X146 a_12205_17226# 2stage_op_amp_1/Diff_opamp_ly_0.Vbias2 a_12906_6188# Vss sky130_fd_pr__nfet_01v8_lvt ad=0.29 pd=2.58 as=0.29 ps=2.58 w=1 l=10
X147 a_20243_26423# a_28673_26123# sky130_fd_pr__res_generic_po w=0.5 l=40
X148 a_13686_3858# 2stage_op_amp_1/Diff_opamp_ly_0.nmos_cload_01_1.Vbias1 Vss Vss sky130_fd_pr__nfet_01v8_lvt ad=0.145 pd=1.58 as=0.145 ps=1.58 w=0.5 l=10
X149 a_1785_12473# a_1785_12473# 2stage_op_amp_1/switchblock_1.beta Vss sky130_fd_pr__nfet_01v8_lvt ad=1.45 pd=10.58 as=1.45 ps=10.58 w=5 l=2
X150 a_12356_8500# 2stage_op_amp_1/Diff_opamp_ly_0.Vbias2 a_13686_6188# Vss sky130_fd_pr__nfet_01v8_lvt ad=0.29 pd=2.58 as=0.29 ps=2.58 w=1 l=10
X151 a_12205_17226# 2stage_op_amp_1/Diff_opamp_ly_0.Vbias2 a_12906_6188# Vss sky130_fd_pr__nfet_01v8_lvt ad=0.29 pd=2.58 as=0.29 ps=2.58 w=1 l=10
X152 Vdd Vdd Vdd Vdd sky130_fd_pr__pfet_01v8_lvt ad=0.29 pd=2.58 as=0 ps=0 w=1 l=5
X153 Vdd a_23489_19515# a_23489_19515# Vdd sky130_fd_pr__pfet_01v8_lvt ad=0.29 pd=2.58 as=0.29 ps=2.58 w=1 l=5
X154 Vdd 2stage_op_amp_1/bias_dummy_0.PBias 2stage_op_amp_1/bias_dummy_0.Vbias3 Vdd sky130_fd_pr__pfet_01v8_lvt ad=1.45 pd=10.58 as=1.45 ps=10.58 w=5 l=2
X155 Vdd a_2864_12498# 2stage_op_amp_1/bias_dummy_0.PBias Vdd sky130_fd_pr__pfet_01v8_lvt ad=1.45 pd=10.58 as=1.45 ps=10.58 w=5 l=2
X156 Vop a_23130_13378# Vss Vss sky130_fd_pr__nfet_01v8_lvt ad=0.29 pd=2.58 as=0.29 ps=2.58 w=1 l=1
X157 Vss Vss Vss Vss sky130_fd_pr__nfet_01v8_lvt ad=0.174 pd=1.78 as=0 ps=0 w=0.6 l=1
X158 Vdd Vdd Vdd Vdd sky130_fd_pr__pfet_01v8_lvt ad=0.29 pd=2.58 as=0 ps=0 w=1 l=0.5
X159 Vdd a_23489_19515# a_23489_19515# Vdd sky130_fd_pr__pfet_01v8_lvt ad=0.29 pd=2.58 as=0.29 ps=2.58 w=1 l=5
X160 Vss Vss Vss Vss sky130_fd_pr__nfet_01v8_lvt ad=0.29 pd=2.58 as=0 ps=0 w=1 l=1
X161 Vss Vss Vss Vss sky130_fd_pr__nfet_01v8_lvt ad=0.145 pd=1.58 as=0 ps=0 w=0.5 l=10
X162 a_12205_21604# a_12330_8558# a_12356_8500# Vss sky130_fd_pr__nfet_01v8_lvt ad=0.58 pd=4.58 as=0.58 ps=4.58 w=2 l=10
X163 Vss Vss Vss Vss sky130_fd_pr__nfet_01v8_lvt ad=0.0609 pd=0.71 as=0 ps=0 w=0.42 l=0.15
X164 Vdd Vdd Vdd Vdd sky130_fd_pr__pfet_01v8_lvt ad=0.29 pd=2.58 as=0 ps=0 w=1 l=1
X165 Vss a_27034_13564# a_27034_13564# Vss sky130_fd_pr__nfet_01v8_lvt ad=0.145 pd=1.58 as=0.145 ps=1.58 w=0.5 l=20
X166 Vdd a_12205_19546# Vop Vdd sky130_fd_pr__pfet_01v8_lvt ad=0.58 pd=4.58 as=0.58 ps=4.58 w=2 l=1
X167 a_12205_19546# 2stage_op_amp_1/Diff_opamp_ly_0.Vbias2 a_12906_3858# Vss sky130_fd_pr__nfet_01v8_lvt ad=0.29 pd=2.58 as=0.29 ps=2.58 w=1 l=10
X168 a_12356_8500# 2stage_op_amp_1/Diff_opamp_ly_0.Vbias2 a_13686_3858# Vss sky130_fd_pr__nfet_01v8_lvt ad=0.29 pd=2.58 as=0.29 ps=2.58 w=1 l=10
X169 Vss Vss Vss Vss sky130_fd_pr__nfet_01v8_lvt ad=0.58 pd=4.58 as=0 ps=0 w=2 l=1
X170 Vss Vss Vss Vss sky130_fd_pr__nfet_01v8_lvt ad=0.29 pd=2.58 as=0 ps=0 w=1 l=1
X171 a_23130_13378# Vom sky130_fd_pr__cap_mim_m3_1 l=10 w=10
X172 Vss Vss Vss Vss sky130_fd_pr__nfet_01v8_lvt ad=0.145 pd=1.58 as=0 ps=0 w=0.5 l=0.5
X173 Vss Vss Vss Vss sky130_fd_pr__nfet_01v8_lvt ad=0.145 pd=1.58 as=0 ps=0 w=0.5 l=0.5
X174 2stage_op_amp_1/Diff_opamp_ly_0.Vbias2 2stage_op_amp_1/Diff_opamp_ly_0.Vbias2 Vss Vss sky130_fd_pr__nfet_01v8_lvt ad=0.29 pd=2.58 as=0.29 ps=2.58 w=1 l=10
X175 Vdd a_12179_17284# a_12179_17284# Vdd sky130_fd_pr__pfet_01v8_lvt ad=0.145 pd=1.58 as=0.145 ps=1.58 w=0.5 l=10
X176 Vdd Vdd Vdd Vdd sky130_fd_pr__pfet_01v8_lvt ad=0.145 pd=1.58 as=0 ps=0 w=0.5 l=0.5
X177 Vss Vss Vss Vss sky130_fd_pr__nfet_01v8_lvt ad=0.29 pd=2.58 as=0 ps=0 w=1 l=1
X178 Vdd Vdd Vdd Vdd sky130_fd_pr__pfet_01v8_lvt ad=0.145 pd=1.58 as=0 ps=0 w=0.5 l=0.5
X179 Vss Vss Vss Vss sky130_fd_pr__nfet_01v8_lvt ad=0.145 pd=1.58 as=0 ps=0 w=0.5 l=0.5
X180 a_12205_17226# 2stage_op_amp_1/Diff_opamp_ly_0.Vbias2 a_12906_6188# Vss sky130_fd_pr__nfet_01v8_lvt ad=0.29 pd=2.58 as=0.29 ps=2.58 w=1 l=10
X181 Vdd Vdd Vdd Vdd sky130_fd_pr__pfet_01v8_lvt ad=0.145 pd=1.58 as=0 ps=0 w=0.5 l=0.5
X182 Vss Vss Vss Vss sky130_fd_pr__nfet_01v8_lvt ad=0.29 pd=2.58 as=0 ps=0 w=1 l=1
X183 a_12356_8500# 2stage_op_amp_1/Diff_opamp_ly_0.Vbias2 a_13686_6188# Vss sky130_fd_pr__nfet_01v8_lvt ad=0.29 pd=2.58 as=0.29 ps=2.58 w=1 l=10
X184 Vdd a_23489_19515# a_23489_19515# Vdd sky130_fd_pr__pfet_01v8_lvt ad=0.29 pd=2.58 as=0.29 ps=2.58 w=1 l=5
X185 Vss Vss Vss Vss sky130_fd_pr__nfet_01v8_lvt ad=0.145 pd=1.58 as=0 ps=0 w=0.5 l=0.5
X186 a_12205_19284# a_12179_17284# a_12205_17226# Vdd sky130_fd_pr__pfet_01v8_lvt ad=0.145 pd=1.58 as=0.145 ps=1.58 w=0.5 l=10
X187 Vss Vss Vss Vss sky130_fd_pr__nfet_01v8_lvt ad=0.145 pd=1.58 as=0 ps=0 w=0.5 l=0.5
X188 Vss Vss Vss Vss sky130_fd_pr__nfet_01v8_lvt ad=0.145 pd=1.58 as=0 ps=0 w=0.5 l=0.5
X189 a_12205_21604# a_12179_17284# a_12205_19546# Vdd sky130_fd_pr__pfet_01v8_lvt ad=0.145 pd=1.58 as=0.145 ps=1.58 w=0.5 l=10
X190 a_19456_19784# a_12205_17226# sky130_fd_pr__cap_mim_m3_1 l=10 w=10
X191 Vdd Vdd Vdd Vdd sky130_fd_pr__pfet_01v8_lvt ad=0.29 pd=2.58 as=0 ps=0 w=1 l=1
X192 Vdd a_12205_19546# Vop Vdd sky130_fd_pr__pfet_01v8_lvt ad=0.58 pd=4.58 as=0.58 ps=4.58 w=2 l=1
X193 Vdd Vdd Vdd Vdd sky130_fd_pr__pfet_01v8_lvt ad=0.29 pd=2.58 as=0 ps=0 w=1 l=5
X194 Vdd a_23489_19515# a_23489_19515# Vdd sky130_fd_pr__pfet_01v8_lvt ad=0.29 pd=2.58 as=0.29 ps=2.58 w=1 l=5
X195 Vdd Vdd Vdd Vdd sky130_fd_pr__pfet_01v8_lvt ad=0.145 pd=1.58 as=0 ps=0 w=0.5 l=10
X196 Vss Vss Vss Vss sky130_fd_pr__nfet_01v8_lvt ad=0.29 pd=2.58 as=0 ps=0 w=1 l=1
X197 Vdd Vdd Vdd Vdd sky130_fd_pr__pfet_01v8_lvt ad=0.58 pd=4.58 as=0 ps=0 w=2 l=1
X198 Vss Vss Vss Vss sky130_fd_pr__nfet_01v8_lvt ad=0.58 pd=4.58 as=0 ps=0 w=2 l=1
X199 Vss Vss Vss Vss sky130_fd_pr__nfet_01v8_lvt ad=0.174 pd=1.78 as=0 ps=0 w=0.6 l=1
X200 Vss Vss Vss Vss sky130_fd_pr__nfet_01v8_lvt ad=0.174 pd=1.78 as=0 ps=0 w=0.6 l=1
X201 Vss Vss sky130_fd_pr__cap_mim_m3_1 l=2 w=2
X202 a_19456_19784# a_12205_17226# sky130_fd_pr__cap_mim_m3_1 l=10 w=10
X203 Vss Vss sky130_fd_pr__cap_mim_m3_1 l=10 w=2
X204 a_12356_8500# 2stage_op_amp_1/Diff_opamp_ly_0.Vbias2 a_13686_6188# Vss sky130_fd_pr__nfet_01v8_lvt ad=0.29 pd=2.58 as=0.29 ps=2.58 w=1 l=10
X205 a_n347_21647# a_n631_13217# sky130_fd_pr__res_generic_po w=0.5 l=40
X206 Vdd Vdd Vdd Vdd sky130_fd_pr__pfet_01v8_lvt ad=1.45 pd=10.58 as=0 ps=0 w=5 l=2
X207 Vss Vss sky130_fd_pr__cap_mim_m3_1 l=10 w=2
X208 Vdd a_12205_17226# Vom Vdd sky130_fd_pr__pfet_01v8_lvt ad=0.58 pd=4.58 as=0.58 ps=4.58 w=2 l=1
X209 Vss Vss Vss Vss sky130_fd_pr__nfet_01v8_lvt ad=0.29 pd=2.58 as=0 ps=0 w=1 l=1
X210 Vss Vss Vss Vss sky130_fd_pr__nfet_01v8_lvt ad=0.58 pd=4.58 as=0 ps=0 w=2 l=10
X211 Vdd Vdd Vdd Vdd sky130_fd_pr__pfet_01v8_lvt ad=0.29 pd=2.58 as=0 ps=0 w=1 l=1
X212 Vss Vss Vss Vss sky130_fd_pr__nfet_01v8_lvt ad=0.145 pd=1.58 as=0 ps=0 w=0.5 l=0.5
X213 Vdd 2stage_op_amp_1/bias_dummy_0.PBias 2stage_op_amp_1/bias_dummy_0.Vbias2 Vdd sky130_fd_pr__pfet_01v8_lvt ad=1.45 pd=10.58 as=1.45 ps=10.58 w=5 l=2
X214 a_12356_8500# 2stage_op_amp_1/Diff_opamp_ly_0.Vbias2 a_13686_3858# Vss sky130_fd_pr__nfet_01v8_lvt ad=0.29 pd=2.58 as=0.29 ps=2.58 w=1 l=10
X215 Vss Vss Vss Vss sky130_fd_pr__nfet_01v8_lvt ad=0.145 pd=1.58 as=0 ps=0 w=0.5 l=0.5
X216 Vss Vss Vss Vss sky130_fd_pr__nfet_01v8_lvt ad=0.29 pd=2.58 as=0 ps=0 w=1 l=1
X217 Vss Vss Vss Vss sky130_fd_pr__nfet_01v8_lvt ad=0.58 pd=4.58 as=0 ps=0 w=2 l=1
X218 Vss Vss Vss Vss sky130_fd_pr__nfet_01v8_lvt ad=0.174 pd=1.78 as=0 ps=0 w=0.6 l=1
X219 a_12205_17226# a_n205_21647# sky130_fd_pr__cap_mim_m3_1 l=10 w=10
X220 a_20243_26423# a_28673_26723# sky130_fd_pr__res_generic_po w=0.5 l=40
X221 a_1350_9246# a_1332_19196# Vdd Vdd sky130_fd_pr__pfet_01v8_lvt ad=1.45 pd=10.58 as=1.45 ps=10.58 w=5 l=1
X222 a_1950_9246# en_2 2stage_op_amp_1/Diff_opamp_ly_0.Vbias3 Vss sky130_fd_pr__nfet_01v8_lvt ad=0.29 pd=2.58 as=0.29 ps=2.58 w=1 l=0.15
X223 Vdd a_23489_19515# a_23489_19515# Vdd sky130_fd_pr__pfet_01v8_lvt ad=0.29 pd=2.58 as=0.29 ps=2.58 w=1 l=5
X224 Vdd a_2864_12498# 2stage_op_amp_1/bias_dummy_0.PBias Vdd sky130_fd_pr__pfet_01v8_lvt ad=1.45 pd=10.58 as=1.45 ps=10.58 w=5 l=2
X225 Vss en_1 a_1506_10826# Vss sky130_fd_pr__nfet_01v8_lvt ad=0.725 pd=5.29 as=0.725 ps=5.29 w=5 l=0.15
X226 a_12205_17226# 2stage_op_amp_1/Diff_opamp_ly_0.Vbias2 a_12906_6188# Vss sky130_fd_pr__nfet_01v8_lvt ad=0.29 pd=2.58 as=0.29 ps=2.58 w=1 l=10
X227 Vdd Vdd Vdd Vdd sky130_fd_pr__pfet_01v8_lvt ad=0.145 pd=1.58 as=0 ps=0 w=0.5 l=0.5
X228 a_12205_21604# a_12330_8558# a_12356_8500# Vss sky130_fd_pr__nfet_01v8_lvt ad=0.58 pd=4.58 as=0.58 ps=4.58 w=2 l=10
X229 a_20243_25973# a_28673_26273# sky130_fd_pr__res_generic_po w=0.5 l=40
X230 Vss Vss Vss Vss sky130_fd_pr__nfet_01v8_lvt ad=0.58 pd=4.58 as=0 ps=0 w=2 l=2
X231 Vss Vss sky130_fd_pr__cap_mim_m3_1 l=2 w=2
X232 a_12356_8500# 2stage_op_amp_1/Diff_opamp_ly_0.Vbias2 a_13686_3858# Vss sky130_fd_pr__nfet_01v8_lvt ad=0.29 pd=2.58 as=0.29 ps=2.58 w=1 l=10
X233 Vdd Vdd Vdd Vdd sky130_fd_pr__pfet_01v8_lvt ad=0.29 pd=2.58 as=0 ps=0 w=1 l=5
X234 Vdd Vdd Vdd Vdd sky130_fd_pr__pfet_01v8_lvt ad=0.29 pd=2.58 as=0 ps=0 w=1 l=1
X235 a_23130_13378# Vref a_26999_20995# Vdd sky130_fd_pr__pfet_01v8_lvt ad=0.145 pd=1.58 as=0.145 ps=1.58 w=0.5 l=10
X236 Vdd a_19456_19784# a_12205_21604# Vdd sky130_fd_pr__pfet_01v8_lvt ad=0.29 pd=2.58 as=0.29 ps=2.58 w=1 l=5
X237 a_1785_12473# a_1785_12473# 2stage_op_amp_1/switchblock_1.beta Vss sky130_fd_pr__nfet_01v8_lvt ad=1.45 pd=10.58 as=1.45 ps=10.58 w=5 l=2
X238 a_12205_19284# a_12179_17284# a_12205_17226# Vdd sky130_fd_pr__pfet_01v8_lvt ad=0.145 pd=1.58 as=0.145 ps=1.58 w=0.5 l=10
X239 Vss a_27034_13564# a_27034_13564# Vss sky130_fd_pr__nfet_01v8_lvt ad=0.145 pd=1.58 as=0.145 ps=1.58 w=0.5 l=20
X240 a_12205_21604# a_12179_17284# a_12205_19546# Vdd sky130_fd_pr__pfet_01v8_lvt ad=0.145 pd=1.58 as=0.145 ps=1.58 w=0.5 l=10
X241 Vdd a_19456_19784# a_12205_21604# Vdd sky130_fd_pr__pfet_01v8_lvt ad=0.29 pd=2.58 as=0.29 ps=2.58 w=1 l=5
X242 a_12205_19546# 2stage_op_amp_1/Diff_opamp_ly_0.Vbias2 a_12906_3858# Vss sky130_fd_pr__nfet_01v8_lvt ad=0.29 pd=2.58 as=0.29 ps=2.58 w=1 l=10
X243 a_12356_8500# 2stage_op_amp_1/Diff_opamp_ly_0.Vbias2 a_13686_3858# Vss sky130_fd_pr__nfet_01v8_lvt ad=0.29 pd=2.58 as=0.29 ps=2.58 w=1 l=10
X244 a_19456_19784# a_19306_17126# Vdd Vdd sky130_fd_pr__pfet_01v8_lvt ad=0.29 pd=2.58 as=0.29 ps=2.58 w=1 l=10
X245 Vdd Vdd sky130_fd_pr__cap_mim_m3_1 l=2 w=10
X246 Vss Vss Vss Vss sky130_fd_pr__nfet_01v8_lvt ad=0.145 pd=1.58 as=0 ps=0 w=0.5 l=0.5
X247 Vdd Vdd Vdd Vdd sky130_fd_pr__pfet_01v8_lvt ad=1.45 pd=10.58 as=0 ps=0 w=5 l=2
X248 Vss a_3062_9246# a_23489_19515# Vss sky130_fd_pr__nfet_01v8_lvt ad=0.174 pd=1.78 as=0.174 ps=1.78 w=0.6 l=1
X249 a_19456_19784# Vref a_14206_3858# Vss sky130_fd_pr__nfet_01v8_lvt ad=0.145 pd=1.58 as=0.145 ps=1.58 w=0.5 l=10
X250 Vss Vss Vss Vss sky130_fd_pr__nfet_01v8_lvt ad=0.29 pd=2.58 as=0 ps=0 w=1 l=10
X251 Vdd Vdd Vdd Vdd sky130_fd_pr__pfet_01v8_lvt ad=1.45 pd=10.58 as=0 ps=0 w=5 l=1
X252 Vdd Vdd Vdd Vdd sky130_fd_pr__pfet_01v8_lvt ad=0.145 pd=1.58 as=0 ps=0 w=0.5 l=0.5
X253 Vss Vss Vss Vss sky130_fd_pr__nfet_01v8_lvt ad=0.145 pd=1.58 as=0 ps=0 w=0.5 l=0.5
X254 Vss Vss Vss Vss sky130_fd_pr__nfet_01v8_lvt ad=0.145 pd=1.58 as=0 ps=0 w=0.5 l=0.5
X255 Vss Vss Vss Vss sky130_fd_pr__nfet_01v8_lvt ad=0.145 pd=1.58 as=0 ps=0 w=0.5 l=10
X256 Vss Vss Vss Vss sky130_fd_pr__nfet_01v8_lvt ad=0.145 pd=1.58 as=0 ps=0 w=0.5 l=0.5
X257 Vdd Vdd Vdd Vdd sky130_fd_pr__pfet_01v8_lvt ad=0.29 pd=2.58 as=0 ps=0 w=1 l=1
X258 Vss Vss Vss Vss sky130_fd_pr__nfet_01v8_lvt ad=0.29 pd=2.58 as=0 ps=0 w=1 l=1
X259 Vss Vss Vss Vss sky130_fd_pr__nfet_01v8_lvt ad=0.29 pd=2.58 as=0 ps=0 w=1 l=1
X260 a_12205_19284# a_12179_17284# a_12205_17226# Vdd sky130_fd_pr__pfet_01v8_lvt ad=0.145 pd=1.58 as=0.145 ps=1.58 w=0.5 l=10
X261 Vdd Vdd Vdd Vdd sky130_fd_pr__pfet_01v8_lvt ad=0.29 pd=2.58 as=0 ps=0 w=1 l=1
X262 a_12205_21604# a_12330_8558# a_12356_8500# Vss sky130_fd_pr__nfet_01v8_lvt ad=0.58 pd=4.58 as=0.58 ps=4.58 w=2 l=10
X263 a_20243_23423# a_28046_17426# sky130_fd_pr__res_generic_po w=0.5 l=40
X264 Vdd Vdd Vdd Vdd sky130_fd_pr__pfet_01v8_lvt ad=0.145 pd=1.58 as=0 ps=0 w=0.5 l=10
X265 Vdd Vdd Vdd Vdd sky130_fd_pr__pfet_01v8_lvt ad=0.29 pd=2.58 as=0 ps=0 w=1 l=0.5
X266 Vdd a_23489_19515# a_23489_19515# Vdd sky130_fd_pr__pfet_01v8_lvt ad=0.29 pd=2.58 as=0.29 ps=2.58 w=1 l=5
X267 a_2032_20622# en_2 a_3062_9246# Vss sky130_fd_pr__nfet_01v8_lvt ad=0.29 pd=2.58 as=0.29 ps=2.58 w=1 l=0.15
X268 Vss Vss Vss Vss sky130_fd_pr__nfet_01v8_lvt ad=0.145 pd=1.58 as=0 ps=0 w=0.5 l=0.5
X269 Vdd a_19456_19784# a_12205_21604# Vdd sky130_fd_pr__pfet_01v8_lvt ad=0.29 pd=2.58 as=0.29 ps=2.58 w=1 l=5
X270 Vss Vss Vss Vss sky130_fd_pr__nfet_01v8_lvt ad=0.29 pd=2.58 as=0 ps=0 w=1 l=10
X271 a_12205_19546# a_n347_21647# sky130_fd_pr__cap_mim_m3_1 l=10 w=10
X272 a_13686_3858# 2stage_op_amp_1/Diff_opamp_ly_0.nmos_cload_01_1.Vbias1 Vss Vss sky130_fd_pr__nfet_01v8_lvt ad=0.145 pd=1.58 as=0.145 ps=1.58 w=0.5 l=10
X273 Vss Vss Vss Vss sky130_fd_pr__nfet_01v8_lvt ad=0.29 pd=2.58 as=0 ps=0 w=1 l=1
X274 Vdd Vdd Vdd Vdd sky130_fd_pr__pfet_01v8_lvt ad=0.145 pd=1.58 as=0 ps=0 w=0.5 l=10
X275 Vss Vss Vss Vss sky130_fd_pr__nfet_01v8_lvt ad=0.29 pd=2.58 as=0 ps=0 w=1 l=10
X276 Vdd a_23489_19515# a_23489_19515# Vdd sky130_fd_pr__pfet_01v8_lvt ad=0.29 pd=2.58 as=0.29 ps=2.58 w=1 l=5
X277 a_19456_19784# Vref a_14206_6188# Vss sky130_fd_pr__nfet_01v8_lvt ad=0.145 pd=1.58 as=0.145 ps=1.58 w=0.5 l=10
X278 Vss Vss Vss Vss sky130_fd_pr__nfet_01v8_lvt ad=0.174 pd=1.78 as=0 ps=0 w=0.6 l=1
X279 2stage_op_amp_1/Diff_opamp_ly_0.nmos_cload_01_1.Vbias1 2stage_op_amp_1/Diff_opamp_ly_0.nmos_cload_01_1.Vbias1 Vss Vss sky130_fd_pr__nfet_01v8_lvt ad=0.145 pd=1.58 as=0.145 ps=1.58 w=0.5 l=10
X280 a_2032_20622# a_1332_19196# Vdd Vdd sky130_fd_pr__pfet_01v8_lvt ad=1.45 pd=10.58 as=1.45 ps=10.58 w=5 l=1
X281 a_1785_12473# a_1785_12473# 2stage_op_amp_1/switchblock_1.beta Vss sky130_fd_pr__nfet_01v8_lvt ad=1.45 pd=10.58 as=1.45 ps=10.58 w=5 l=2
X282 a_12356_8500# 2stage_op_amp_1/Diff_opamp_ly_0.Vbias2 a_13686_6188# Vss sky130_fd_pr__nfet_01v8_lvt ad=0.29 pd=2.58 as=0.29 ps=2.58 w=1 l=10
X283 2stage_op_amp_1/Diff_opamp_ly_0.nmos_cload_01_1.Vbias1 2stage_op_amp_1/Diff_opamp_ly_0.nmos_cload_01_1.Vbias1 Vss Vss sky130_fd_pr__nfet_01v8_lvt ad=0.145 pd=1.58 as=0.145 ps=1.58 w=0.5 l=10
X284 Vdd a_23489_19515# a_23489_19515# Vdd sky130_fd_pr__pfet_01v8_lvt ad=0.29 pd=2.58 as=0.29 ps=2.58 w=1 l=5
X285 a_13686_6188# 2stage_op_amp_1/Diff_opamp_ly_0.nmos_cload_01_1.Vbias1 Vss Vss sky130_fd_pr__nfet_01v8_lvt ad=0.145 pd=1.58 as=0.145 ps=1.58 w=0.5 l=10
X286 Vss Vss Vss Vss sky130_fd_pr__nfet_01v8_lvt ad=0.145 pd=1.58 as=0 ps=0 w=0.5 l=0.5
X287 Vss Vss Vss Vss sky130_fd_pr__nfet_01v8_lvt ad=0.145 pd=1.58 as=0 ps=0 w=0.5 l=0.5
X288 Vdd Vdd Vdd Vdd sky130_fd_pr__pfet_01v8_lvt ad=1.45 pd=10.58 as=0 ps=0 w=5 l=2
X289 Vdd Vdd sky130_fd_pr__cap_mim_m3_1 l=2 w=10
X290 Vdd Vdd Vdd Vdd sky130_fd_pr__pfet_01v8_lvt ad=0.29 pd=2.58 as=0 ps=0 w=1 l=1
X291 Vdd Vdd Vdd Vdd sky130_fd_pr__pfet_01v8_lvt ad=0.145 pd=1.58 as=0 ps=0 w=0.5 l=0.5
X292 Vss Vss Vss Vss sky130_fd_pr__nfet_01v8_lvt ad=0.174 pd=1.78 as=0 ps=0 w=0.6 l=1
X293 a_12205_19546# 2stage_op_amp_1/Diff_opamp_ly_0.Vbias2 a_12906_3858# Vss sky130_fd_pr__nfet_01v8_lvt ad=0.29 pd=2.58 as=0.29 ps=2.58 w=1 l=10
X294 a_12205_21604# a_12330_8558# a_12356_8500# Vss sky130_fd_pr__nfet_01v8_lvt ad=0.58 pd=4.58 as=0.58 ps=4.58 w=2 l=10
X295 Vss Vss Vss Vss sky130_fd_pr__nfet_01v8_lvt ad=0.145 pd=1.58 as=0 ps=0 w=0.5 l=0.5
X296 Vss Vss sky130_fd_pr__cap_mim_m3_1 l=2 w=10
X297 Vdd Vdd Vdd Vdd sky130_fd_pr__pfet_01v8_lvt ad=0.58 pd=4.58 as=0 ps=0 w=2 l=2
X298 Vss Vss Vss Vss sky130_fd_pr__nfet_01v8_lvt ad=0.29 pd=2.58 as=0 ps=0 w=1 l=1
X299 a_12356_8500# 2stage_op_amp_1/Diff_opamp_ly_0.Vbias2 a_13686_6188# Vss sky130_fd_pr__nfet_01v8_lvt ad=0.29 pd=2.58 as=0.29 ps=2.58 w=1 l=10
X300 Vss Vss Vss Vss sky130_fd_pr__nfet_01v8_lvt ad=0.145 pd=1.58 as=0 ps=0 w=0.5 l=0.5
X301 a_n1341_21647# a_n1057_13217# sky130_fd_pr__res_generic_po w=0.5 l=40
X302 Vdd a_23489_19515# a_23489_19515# Vdd sky130_fd_pr__pfet_01v8_lvt ad=0.29 pd=2.58 as=0.29 ps=2.58 w=1 l=5
X303 Vss Vss Vss Vss sky130_fd_pr__nfet_01v8_lvt ad=0.145 pd=1.58 as=0 ps=0 w=0.5 l=0.5
X304 Vdd Vdd Vdd Vdd sky130_fd_pr__pfet_01v8_lvt ad=0.29 pd=2.58 as=0 ps=0 w=1 l=1
X305 a_12205_17226# 2stage_op_amp_1/Diff_opamp_ly_0.Vbias2 a_12906_6188# Vss sky130_fd_pr__nfet_01v8_lvt ad=0.29 pd=2.58 as=0.29 ps=2.58 w=1 l=10
X306 Vss Vss Vss Vss sky130_fd_pr__nfet_01v8_lvt ad=0.145 pd=1.58 as=0 ps=0 w=0.5 l=0.5
X307 a_n773_21647# a_n1057_13217# sky130_fd_pr__res_generic_po w=0.5 l=40
X308 Vdd a_12205_19546# Vop Vdd sky130_fd_pr__pfet_01v8_lvt ad=0.58 pd=4.58 as=0.58 ps=4.58 w=2 l=1
X309 a_20243_26573# a_28673_26273# sky130_fd_pr__res_generic_po w=0.5 l=40
X310 Vdd 2stage_op_amp_1/bias_dummy_0.PBias 2stage_op_amp_1/bias_dummy_0.Vbias2 Vdd sky130_fd_pr__pfet_01v8_lvt ad=1.45 pd=10.58 as=1.45 ps=10.58 w=5 l=2
X311 a_2865_14979# a_2465_13713# Vss Vss sky130_fd_pr__nfet_01v8_lvt ad=1.45 pd=10.58 as=1.45 ps=10.58 w=5 l=2
X312 a_12205_19284# a_12179_17284# a_12205_17226# Vdd sky130_fd_pr__pfet_01v8_lvt ad=0.145 pd=1.58 as=0.145 ps=1.58 w=0.5 l=10
X313 a_12356_8500# 2stage_op_amp_1/Diff_opamp_ly_0.Vbias2 a_13686_3858# Vss sky130_fd_pr__nfet_01v8_lvt ad=0.29 pd=2.58 as=0.29 ps=2.58 w=1 l=10
X314 2stage_op_amp_1/Diff_opamp_ly_0.nmos_cload_01_1.Vbias1 2stage_op_amp_1/Diff_opamp_ly_0.nmos_cload_01_1.Vbias1 Vss Vss sky130_fd_pr__nfet_01v8_lvt ad=0.145 pd=1.58 as=0.145 ps=1.58 w=0.5 l=10
X315 a_12205_19284# a_12179_17284# a_12205_17226# Vdd sky130_fd_pr__pfet_01v8_lvt ad=0.145 pd=1.58 as=0.145 ps=1.58 w=0.5 l=10
X316 Vss Vss Vss Vss sky130_fd_pr__nfet_01v8_lvt ad=0.145 pd=1.58 as=0 ps=0 w=0.5 l=0.5
X317 Vss Vss Vss Vss sky130_fd_pr__nfet_01v8_lvt ad=0.145 pd=1.58 as=0 ps=0 w=0.5 l=0.5
X318 Vss Vss Vss Vss sky130_fd_pr__nfet_01v8_lvt ad=0.29 pd=2.58 as=0 ps=0 w=1 l=1
X319 Vdd Vdd Vdd Vdd sky130_fd_pr__pfet_01v8_lvt ad=0.145 pd=1.58 as=0 ps=0 w=0.5 l=0.5
X320 Vdd Vdd Vdd Vdd sky130_fd_pr__pfet_01v8_lvt ad=0.145 pd=1.58 as=0 ps=0 w=0.5 l=0.5
X321 Vss Vss Vss Vss sky130_fd_pr__nfet_01v8_lvt ad=0.145 pd=1.58 as=0 ps=0 w=0.5 l=0.5
X322 a_12906_6188# 2stage_op_amp_1/Diff_opamp_ly_0.nmos_cload_01_1.Vbias1 Vss Vss sky130_fd_pr__nfet_01v8_lvt ad=0.145 pd=1.58 as=0.145 ps=1.58 w=0.5 l=10
X323 Vss Vss Vss Vss sky130_fd_pr__nfet_01v8_lvt ad=0.29 pd=2.58 as=0 ps=0 w=1 l=1
X324 Vdd Vdd Vdd Vdd sky130_fd_pr__pfet_01v8_lvt ad=0.58 pd=4.58 as=0 ps=0 w=2 l=1
X325 Vdd Vdd Vdd Vdd sky130_fd_pr__pfet_01v8_lvt ad=0.145 pd=1.58 as=0 ps=0 w=0.5 l=10
X326 a_13686_6188# 2stage_op_amp_1/Diff_opamp_ly_0.nmos_cload_01_1.Vbias1 Vss Vss sky130_fd_pr__nfet_01v8_lvt ad=0.145 pd=1.58 as=0.145 ps=1.58 w=0.5 l=10
X327 Vss Vss Vss Vss sky130_fd_pr__nfet_01v8_lvt ad=0.145 pd=1.58 as=0 ps=0 w=0.5 l=0.5
X328 a_12205_17226# 2stage_op_amp_1/Diff_opamp_ly_0.Vbias2 a_12906_6188# Vss sky130_fd_pr__nfet_01v8_lvt ad=0.29 pd=2.58 as=0.29 ps=2.58 w=1 l=10
X329 Vdd a_23489_19515# a_23489_19515# Vdd sky130_fd_pr__pfet_01v8_lvt ad=0.29 pd=2.58 as=0.29 ps=2.58 w=1 l=5
X330 a_19306_17126# a_12205_19546# a_14206_6188# Vss sky130_fd_pr__nfet_01v8_lvt ad=0.145 pd=1.58 as=0.145 ps=1.58 w=0.5 l=10
X331 Vdd a_23489_19515# a_23489_19515# Vdd sky130_fd_pr__pfet_01v8_lvt ad=0.29 pd=2.58 as=0.29 ps=2.58 w=1 l=5
X332 Vdd Vdd Vdd Vdd sky130_fd_pr__pfet_01v8_lvt ad=0.29 pd=2.58 as=0 ps=0 w=1 l=0.5
X333 2stage_op_amp_1/Diff_opamp_ly_0.nmos_cload_01_1.Vbias1 2stage_op_amp_1/Diff_opamp_ly_0.nmos_cload_01_1.Vbias1 Vss Vss sky130_fd_pr__nfet_01v8_lvt ad=0.145 pd=1.58 as=0.145 ps=1.58 w=0.5 l=10
X334 a_20243_23423# a_28673_23723# sky130_fd_pr__res_generic_po w=0.5 l=40
X335 Vdd Vdd Vdd Vdd sky130_fd_pr__pfet_01v8_lvt ad=0.58 pd=4.58 as=0 ps=0 w=2 l=1
X336 Vss Vss sky130_fd_pr__cap_mim_m3_1 l=10 w=2
X337 Vss Vss Vss Vss sky130_fd_pr__nfet_01v8_lvt ad=0.29 pd=2.58 as=0 ps=0 w=1 l=10
X338 Vdd Vdd Vdd Vdd sky130_fd_pr__pfet_01v8_lvt ad=0.145 pd=1.58 as=0 ps=0 w=0.5 l=0.5
X339 Vss Vss Vss Vss sky130_fd_pr__nfet_01v8_lvt ad=0.0609 pd=0.71 as=0 ps=0 w=0.42 l=0.15
X340 2stage_op_amp_1/Diff_opamp_ly_0.Vbias2 2stage_op_amp_1/Diff_opamp_ly_0.Vbias2 Vss Vss sky130_fd_pr__nfet_01v8_lvt ad=0.29 pd=2.58 as=0.29 ps=2.58 w=1 l=10
X341 Vdd Vdd Vdd Vdd sky130_fd_pr__pfet_01v8_lvt ad=0.29 pd=2.58 as=0 ps=0 w=1 l=0.5
X342 Vss Vss Vss Vss sky130_fd_pr__nfet_01v8_lvt ad=0.29 pd=2.58 as=0 ps=0 w=1 l=1
X343 Vdd Vdd Vdd Vdd sky130_fd_pr__pfet_01v8_lvt ad=0.29 pd=2.58 as=0 ps=0 w=1 l=1
X344 Vdd a_12205_17226# Vom Vdd sky130_fd_pr__pfet_01v8_lvt ad=0.58 pd=4.58 as=0.58 ps=4.58 w=2 l=1
X345 Vss Vss Vss Vss sky130_fd_pr__nfet_01v8_lvt ad=0.58 pd=4.58 as=0 ps=0 w=2 l=1
X346 Vss Vss Vss Vss sky130_fd_pr__nfet_01v8_lvt ad=0.145 pd=1.58 as=0 ps=0 w=0.5 l=0.5
X347 a_20243_27023# a_28673_26723# sky130_fd_pr__res_generic_po w=0.5 l=40
X348 Vdd Vdd Vdd Vdd sky130_fd_pr__pfet_01v8_lvt ad=0.29 pd=2.58 as=0 ps=0 w=1 l=1
X349 Vss Vss Vss Vss sky130_fd_pr__nfet_01v8_lvt ad=0.29 pd=2.58 as=0 ps=0 w=1 l=1
X350 Vss en_1 a_1506_10650# Vss sky130_fd_pr__nfet_01v8_lvt ad=0.725 pd=5.29 as=1.45 ps=10.58 w=5 l=0.15
X351 Vss Vss Vss Vss sky130_fd_pr__nfet_01v8_lvt ad=0.29 pd=2.58 as=0 ps=0 w=1 l=10
X352 Vdd 2stage_op_amp_1/bias_dummy_0.PBias 2stage_op_amp_1/bias_dummy_0.Vbias1 Vdd sky130_fd_pr__pfet_01v8_lvt ad=1.45 pd=10.58 as=1.45 ps=10.58 w=5 l=2
X353 Vdd Vdd Vdd Vdd sky130_fd_pr__pfet_01v8_lvt ad=0.145 pd=1.58 as=0 ps=0 w=0.5 l=0.5
X354 Vss Vss Vss Vss sky130_fd_pr__nfet_01v8_lvt ad=0.58 pd=4.58 as=0 ps=0 w=2 l=1
X355 Vdd Vdd Vdd Vdd sky130_fd_pr__pfet_01v8_lvt ad=0.29 pd=2.58 as=0 ps=0 w=1 l=10
X356 Vdd Vdd Vdd Vdd sky130_fd_pr__pfet_01v8_lvt ad=0.29 pd=2.58 as=0 ps=0 w=1 l=1
X357 Vss Vss Vss Vss sky130_fd_pr__nfet_01v8_lvt ad=0.1218 pd=1.42 as=0 ps=0 w=0.42 l=0.15
X358 Vss Vss Vss Vss sky130_fd_pr__nfet_01v8_lvt ad=0.1218 pd=1.42 as=0 ps=0 w=0.42 l=0.15
X359 Vss Vss Vss Vss sky130_fd_pr__nfet_01v8_lvt ad=0.29 pd=2.58 as=0 ps=0 w=1 l=1
X360 Vss Vss sky130_fd_pr__cap_mim_m3_1 l=10 w=2
X361 a_12205_19546# 2stage_op_amp_1/Diff_opamp_ly_0.Vbias2 a_12906_3858# Vss sky130_fd_pr__nfet_01v8_lvt ad=0.29 pd=2.58 as=0.29 ps=2.58 w=1 l=10
X362 Vdd 2stage_op_amp_1/bias_dummy_0.PBias 2stage_op_amp_1/bias_dummy_0.Vbias3 Vdd sky130_fd_pr__pfet_01v8_lvt ad=1.45 pd=10.58 as=1.45 ps=10.58 w=5 l=2
X363 Vss Vss Vss Vss sky130_fd_pr__nfet_01v8_lvt ad=0.58 pd=4.58 as=0 ps=0 w=2 l=1
X364 Vss a_27034_13564# a_23130_13378# Vss sky130_fd_pr__nfet_01v8_lvt ad=0.145 pd=1.58 as=0.145 ps=1.58 w=0.5 l=20
X365 Vdd Vdd Vdd Vdd sky130_fd_pr__pfet_01v8_lvt ad=1.45 pd=10.58 as=0 ps=0 w=5 l=1
X366 a_12356_8500# 2stage_op_amp_1/Diff_opamp_ly_0.Vbias2 a_13686_6188# Vss sky130_fd_pr__nfet_01v8_lvt ad=0.29 pd=2.58 as=0.29 ps=2.58 w=1 l=10
X367 Vdd Vdd Vdd Vdd sky130_fd_pr__pfet_01v8_lvt ad=0.29 pd=2.58 as=0 ps=0 w=1 l=0.5
X368 Vdd Vdd Vdd Vdd sky130_fd_pr__pfet_01v8_lvt ad=0.29 pd=2.58 as=0 ps=0 w=1 l=1
X369 a_12205_21604# a_12179_17284# a_12205_19546# Vdd sky130_fd_pr__pfet_01v8_lvt ad=0.145 pd=1.58 as=0.145 ps=1.58 w=0.5 l=10
X370 Vdd Vdd Vdd Vdd sky130_fd_pr__pfet_01v8_lvt ad=0.29 pd=2.58 as=0 ps=0 w=1 l=5
X371 2stage_op_amp_1/bias_dummy_0.Vbias2 en_1 2stage_op_amp_1/Diff_opamp_ly_0.Vbias2 Vss sky130_fd_pr__nfet_01v8_lvt ad=0.29 pd=2.58 as=0.29 ps=2.58 w=1 l=0.15
X372 Vdd Vdd sky130_fd_pr__cap_mim_m3_1 l=2 w=2
X373 Vss Vss Vss Vss sky130_fd_pr__nfet_01v8_lvt ad=0.145 pd=1.58 as=0 ps=0 w=0.5 l=0.5
X374 a_19306_17126# a_12205_17226# a_14206_3858# Vss sky130_fd_pr__nfet_01v8_lvt ad=0.145 pd=1.58 as=0.145 ps=1.58 w=0.5 l=10
X375 a_20243_26573# a_28673_26873# sky130_fd_pr__res_generic_po w=0.5 l=40
X376 Vdd Vdd Vdd Vdd sky130_fd_pr__pfet_01v8_lvt ad=0.29 pd=2.58 as=0 ps=0 w=1 l=5
X377 Vss Vss Vss Vss sky130_fd_pr__nfet_01v8_lvt ad=0.174 pd=1.78 as=0 ps=0 w=0.6 l=1
X378 Vss Vss Vss Vss sky130_fd_pr__nfet_01v8_lvt ad=0.145 pd=1.58 as=0 ps=0 w=0.5 l=0.5
X379 Vss Vss Vss Vss sky130_fd_pr__nfet_01v8_lvt ad=0.145 pd=1.58 as=0 ps=0 w=0.5 l=10
X380 Vdd Vdd Vdd Vdd sky130_fd_pr__pfet_01v8_lvt ad=0.145 pd=1.58 as=0 ps=0 w=0.5 l=0.5
X381 Vdd Vdd Vdd Vdd sky130_fd_pr__pfet_01v8_lvt ad=0.145 pd=1.58 as=0 ps=0 w=0.5 l=0.5
X382 a_12205_19546# a_n347_21647# sky130_fd_pr__cap_mim_m3_1 l=10 w=10
X383 a_19456_19784# a_12205_19546# sky130_fd_pr__cap_mim_m3_1 l=10 w=10
X384 a_12205_19546# 2stage_op_amp_1/Diff_opamp_ly_0.Vbias2 a_12906_3858# Vss sky130_fd_pr__nfet_01v8_lvt ad=0.29 pd=2.58 as=0.29 ps=2.58 w=1 l=10
X385 Vss Vss sky130_fd_pr__cap_mim_m3_1 l=10 w=2
X386 Vdd a_23489_19515# a_23489_19515# Vdd sky130_fd_pr__pfet_01v8_lvt ad=0.29 pd=2.58 as=0.29 ps=2.58 w=1 l=5
X387 Vss Vss Vss Vss sky130_fd_pr__nfet_01v8_lvt ad=0.58 pd=4.58 as=0 ps=0 w=2 l=1
X388 a_19306_17126# a_12205_17226# a_14206_3858# Vss sky130_fd_pr__nfet_01v8_lvt ad=0.145 pd=1.58 as=0.145 ps=1.58 w=0.5 l=10
X389 a_12205_19546# 2stage_op_amp_1/Diff_opamp_ly_0.Vbias2 a_12906_3858# Vss sky130_fd_pr__nfet_01v8_lvt ad=0.29 pd=2.58 as=0.29 ps=2.58 w=1 l=10
X390 a_12205_21604# a_12179_17284# a_12205_19546# Vdd sky130_fd_pr__pfet_01v8_lvt ad=0.145 pd=1.58 as=0.145 ps=1.58 w=0.5 l=10
X391 a_12205_19284# a_12179_17284# a_12205_17226# Vdd sky130_fd_pr__pfet_01v8_lvt ad=0.145 pd=1.58 as=0.145 ps=1.58 w=0.5 l=10
X392 Vdd Vdd Vdd Vdd sky130_fd_pr__pfet_01v8_lvt ad=1.45 pd=10.58 as=0 ps=0 w=5 l=1
X393 Vdd a_19456_19784# a_12205_21604# Vdd sky130_fd_pr__pfet_01v8_lvt ad=0.29 pd=2.58 as=0.29 ps=2.58 w=1 l=5
X394 Vdd a_12205_17226# Vom Vdd sky130_fd_pr__pfet_01v8_lvt ad=0.58 pd=4.58 as=0.58 ps=4.58 w=2 l=1
X395 Vdd Vdd Vdd Vdd sky130_fd_pr__pfet_01v8_lvt ad=0.29 pd=2.58 as=0 ps=0 w=1 l=1
X396 Vdd Vdd Vdd Vdd sky130_fd_pr__pfet_01v8_lvt ad=0.58 pd=4.58 as=0 ps=0 w=2 l=1
X397 a_12205_17226# 2stage_op_amp_1/Diff_opamp_ly_0.Vbias2 a_12906_6188# Vss sky130_fd_pr__nfet_01v8_lvt ad=0.29 pd=2.58 as=0.29 ps=2.58 w=1 l=10
X398 a_n1483_21647# Vop sky130_fd_pr__res_generic_po w=0.5 l=40
X399 a_12205_17226# a_n205_21647# sky130_fd_pr__cap_mim_m3_1 l=10 w=10
X400 Vdd a_23489_19515# a_23489_19515# Vdd sky130_fd_pr__pfet_01v8_lvt ad=0.29 pd=2.58 as=0.29 ps=2.58 w=1 l=5
X401 Vss Vss Vss Vss sky130_fd_pr__nfet_01v8_lvt ad=0.145 pd=1.58 as=0 ps=0 w=0.5 l=0.5
X402 a_2865_14979# a_2865_14979# Vdd Vdd sky130_fd_pr__pfet_01v8_lvt ad=0.29 pd=2.58 as=0.29 ps=2.58 w=1 l=20
X403 Vdd Vdd sky130_fd_pr__cap_mim_m3_1 l=2 w=10
X404 Vss Vss Vss Vss sky130_fd_pr__nfet_01v8_lvt ad=0.1218 pd=1.42 as=0 ps=0 w=0.42 l=0.15
X405 Vdd Vdd sky130_fd_pr__cap_mim_m3_1 l=2 w=10
X406 Vss Vss Vss Vss sky130_fd_pr__nfet_01v8_lvt ad=0.145 pd=1.58 as=0 ps=0 w=0.5 l=0.5
X407 a_20243_23573# a_28046_17426# sky130_fd_pr__res_generic_po w=0.5 l=40
X408 a_2032_20622# a_1332_19196# Vdd Vdd sky130_fd_pr__pfet_01v8_lvt ad=1.45 pd=10.58 as=1.45 ps=10.58 w=5 l=1
X409 Vdd Vdd Vdd Vdd sky130_fd_pr__pfet_01v8_lvt ad=0.29 pd=2.58 as=0 ps=0 w=1 l=1
X410 Vdd Vdd Vdd Vdd sky130_fd_pr__pfet_01v8_lvt ad=0.29 pd=2.58 as=0 ps=0 w=1 l=0.5
X411 Vdd Vdd Vdd Vdd sky130_fd_pr__pfet_01v8_lvt ad=0.29 pd=2.58 as=0 ps=0 w=1 l=1
X412 Vss Vss Vss Vss sky130_fd_pr__nfet_01v8_lvt ad=0.174 pd=1.78 as=0 ps=0 w=0.6 l=1
X413 Vdd Vdd Vdd Vdd sky130_fd_pr__pfet_01v8_lvt ad=0.29 pd=2.58 as=0 ps=0 w=1 l=1
X414 Vss Vss Vss Vss sky130_fd_pr__nfet_01v8_lvt ad=0.145 pd=1.58 as=0 ps=0 w=0.5 l=0.5
X415 Vdd Vdd Vdd Vdd sky130_fd_pr__pfet_01v8_lvt ad=0.29 pd=2.58 as=0 ps=0 w=1 l=5
X416 a_27034_13564# a_28046_17426# a_26999_20995# Vdd sky130_fd_pr__pfet_01v8_lvt ad=0.145 pd=1.58 as=0.145 ps=1.58 w=0.5 l=10
X417 a_20243_27023# a_28673_27323# sky130_fd_pr__res_generic_po w=0.5 l=40
X418 Vdd Vdd Vdd Vdd sky130_fd_pr__pfet_01v8_lvt ad=0.29 pd=2.58 as=0 ps=0 w=1 l=0.5
X419 Vdd Vdd Vdd Vdd sky130_fd_pr__pfet_01v8_lvt ad=0.145 pd=1.58 as=0 ps=0 w=0.5 l=0.5
X420 Vdd a_23489_19515# a_23489_19515# Vdd sky130_fd_pr__pfet_01v8_lvt ad=0.29 pd=2.58 as=0.29 ps=2.58 w=1 l=5
X421 Vdd Vdd Vdd Vdd sky130_fd_pr__pfet_01v8_lvt ad=0.145 pd=1.58 as=0 ps=0 w=0.5 l=0.5
X422 Vdd Vdd Vdd Vdd sky130_fd_pr__pfet_01v8_lvt ad=1.45 pd=10.58 as=0 ps=0 w=5 l=2
X423 a_19306_17126# a_12205_17226# a_14206_3858# Vss sky130_fd_pr__nfet_01v8_lvt ad=0.145 pd=1.58 as=0.145 ps=1.58 w=0.5 l=10
X424 a_14206_3858# 2stage_op_amp_1/Diff_opamp_ly_0.nmos_cload_01_1.Vbias1 Vss Vss sky130_fd_pr__nfet_01v8_lvt ad=0.145 pd=1.58 as=0.145 ps=1.58 w=0.5 l=10
X425 Vss Vss Vss Vss sky130_fd_pr__nfet_01v8_lvt ad=0.145 pd=1.58 as=0 ps=0 w=0.5 l=0.5
X426 a_23130_13378# Vref a_26999_20995# Vdd sky130_fd_pr__pfet_01v8_lvt ad=0.145 pd=1.58 as=0.145 ps=1.58 w=0.5 l=10
X427 Vss Vss Vss Vss sky130_fd_pr__nfet_01v8_lvt ad=0.58 pd=4.58 as=0 ps=0 w=2 l=1
X428 Vdd Vdd sky130_fd_pr__cap_mim_m3_1 l=2 w=10
X429 Vss Vss Vss Vss sky130_fd_pr__nfet_01v8_lvt ad=0.29 pd=2.58 as=0 ps=0 w=1 l=10
X430 Vdd Vdd Vdd Vdd sky130_fd_pr__pfet_01v8_lvt ad=0.29 pd=2.58 as=0 ps=0 w=1 l=10
X431 2stage_op_amp_1/bias_dummy_0.PBias a_2465_13713# a_1506_10826# Vss sky130_fd_pr__nfet_01v8_lvt ad=1.45 pd=10.58 as=1.45 ps=10.58 w=5 l=2
X432 a_12205_21604# a_12330_8558# a_12356_8500# Vss sky130_fd_pr__nfet_01v8_lvt ad=0.58 pd=4.58 as=0.58 ps=4.58 w=2 l=10
X433 Vss Vss Vss Vss sky130_fd_pr__nfet_01v8_lvt ad=0.145 pd=1.58 as=0 ps=0 w=0.5 l=0.5
X434 2stage_op_amp_1/Diff_opamp_ly_0.nmos_cload_01_1.Vbias1 2stage_op_amp_1/Diff_opamp_ly_0.nmos_cload_01_1.Vbias1 Vss Vss sky130_fd_pr__nfet_01v8_lvt ad=0.145 pd=1.58 as=0.145 ps=1.58 w=0.5 l=10
X435 a_19456_19784# a_12205_17226# sky130_fd_pr__cap_mim_m3_1 l=10 w=10
X436 Vss Vss Vss Vss sky130_fd_pr__nfet_01v8_lvt ad=0.145 pd=1.58 as=0 ps=0 w=0.5 l=0.5
X437 Vdd 2stage_op_amp_1/bias_dummy_0.PBias 2stage_op_amp_1/bias_dummy_0.Vbias4 Vdd sky130_fd_pr__pfet_01v8_lvt ad=1.45 pd=10.58 as=1.45 ps=10.58 w=5 l=2
X438 Vdd Vdd sky130_fd_pr__cap_mim_m3_1 l=10 w=2
X439 Vdd Vdd Vdd Vdd sky130_fd_pr__pfet_01v8_lvt ad=1.45 pd=10.58 as=0 ps=0 w=5 l=1
X440 2stage_op_amp_1/Diff_opamp_ly_0.nmos_cload_01_1.Vbias1 2stage_op_amp_1/Diff_opamp_ly_0.nmos_cload_01_1.Vbias1 Vss Vss sky130_fd_pr__nfet_01v8_lvt ad=0.145 pd=1.58 as=0.145 ps=1.58 w=0.5 l=10
X441 Vdd Vdd Vdd Vdd sky130_fd_pr__pfet_01v8_lvt ad=0.58 pd=4.58 as=0 ps=0 w=2 l=2
X442 Vss Vss Vss Vss sky130_fd_pr__nfet_01v8_lvt ad=0.145 pd=1.58 as=0 ps=0 w=0.5 l=20
X443 2stage_op_amp_1/Diff_opamp_ly_0.nmos_cload_01_1.Vbias1 2stage_op_amp_1/Diff_opamp_ly_0.nmos_cload_01_1.Vbias1 Vss Vss sky130_fd_pr__nfet_01v8_lvt ad=0.145 pd=1.58 as=0.145 ps=1.58 w=0.5 l=10
X444 Vdd Vdd Vdd Vdd sky130_fd_pr__pfet_01v8_lvt ad=0.29 pd=2.58 as=0 ps=0 w=1 l=0.5
X445 Vss Vss Vss Vss sky130_fd_pr__nfet_01v8_lvt ad=1.45 pd=10.58 as=0 ps=0 w=5 l=2
X446 Vss Vss Vss Vss sky130_fd_pr__nfet_01v8_lvt ad=0.145 pd=1.58 as=0 ps=0 w=0.5 l=0.5
X447 a_12205_17226# 2stage_op_amp_1/Diff_opamp_ly_0.Vbias2 a_12906_6188# Vss sky130_fd_pr__nfet_01v8_lvt ad=0.29 pd=2.58 as=0.29 ps=2.58 w=1 l=10
X448 a_12906_3858# 2stage_op_amp_1/Diff_opamp_ly_0.nmos_cload_01_1.Vbias1 Vss Vss sky130_fd_pr__nfet_01v8_lvt ad=0.145 pd=1.58 as=0.145 ps=1.58 w=0.5 l=10
X449 Vss Vss Vss Vss sky130_fd_pr__nfet_01v8_lvt ad=1.45 pd=10.58 as=0 ps=0 w=5 l=2
X450 Vdd Vdd Vdd Vdd sky130_fd_pr__pfet_01v8_lvt ad=0.145 pd=1.58 as=0 ps=0 w=0.5 l=0.5
X451 a_20243_24023# a_28673_23723# sky130_fd_pr__res_generic_po w=0.5 l=40
X452 Vdd a_23489_19515# a_23489_19515# Vdd sky130_fd_pr__pfet_01v8_lvt ad=0.29 pd=2.58 as=0.29 ps=2.58 w=1 l=5
X453 a_19456_19784# a_12205_17226# sky130_fd_pr__cap_mim_m3_1 l=10 w=10
X454 a_13686_3858# 2stage_op_amp_1/Diff_opamp_ly_0.nmos_cload_01_1.Vbias1 Vss Vss sky130_fd_pr__nfet_01v8_lvt ad=0.145 pd=1.58 as=0.145 ps=1.58 w=0.5 l=10
X455 Vdd Vdd Vdd Vdd sky130_fd_pr__pfet_01v8_lvt ad=0.58 pd=4.58 as=0 ps=0 w=2 l=1
X456 Vss Vss Vss Vss sky130_fd_pr__nfet_01v8_lvt ad=0.174 pd=1.78 as=0 ps=0 w=0.6 l=1
X457 a_19306_17126# a_12205_19546# a_14206_6188# Vss sky130_fd_pr__nfet_01v8_lvt ad=0.145 pd=1.58 as=0.145 ps=1.58 w=0.5 l=10
X458 a_1350_9246# a_1332_19196# Vdd Vdd sky130_fd_pr__pfet_01v8_lvt ad=1.45 pd=10.58 as=1.45 ps=10.58 w=5 l=1
X459 a_12205_21604# a_12179_17284# a_12205_19546# Vdd sky130_fd_pr__pfet_01v8_lvt ad=0.145 pd=1.58 as=0.145 ps=1.58 w=0.5 l=10
X460 a_12205_21604# a_12179_17284# a_12205_19546# Vdd sky130_fd_pr__pfet_01v8_lvt ad=0.145 pd=1.58 as=0.145 ps=1.58 w=0.5 l=10
X461 a_12205_19546# 2stage_op_amp_1/Diff_opamp_ly_0.Vbias2 a_12906_3858# Vss sky130_fd_pr__nfet_01v8_lvt ad=0.29 pd=2.58 as=0.29 ps=2.58 w=1 l=10
X462 2stage_op_amp_1/Diff_opamp_ly_0.nmos_cload_01_1.Vbias1 2stage_op_amp_1/Diff_opamp_ly_0.nmos_cload_01_1.Vbias1 Vss Vss sky130_fd_pr__nfet_01v8_lvt ad=0.145 pd=1.58 as=0.145 ps=1.58 w=0.5 l=10
X463 Vss Vss sky130_fd_pr__cap_mim_m3_1 l=10 w=2
X464 a_12205_19546# 2stage_op_amp_1/Diff_opamp_ly_0.Vbias2 a_12906_3858# Vss sky130_fd_pr__nfet_01v8_lvt ad=0.29 pd=2.58 as=0.29 ps=2.58 w=1 l=10
X465 Vdd a_19456_19784# a_12205_19284# Vdd sky130_fd_pr__pfet_01v8_lvt ad=0.29 pd=2.58 as=0.29 ps=2.58 w=1 l=5
X466 Vdd Vdd Vdd Vdd sky130_fd_pr__pfet_01v8_lvt ad=0.145 pd=1.58 as=0 ps=0 w=0.5 l=0.5
X467 Vss Vss Vss Vss sky130_fd_pr__nfet_01v8_lvt ad=0.58 pd=4.58 as=0 ps=0 w=2 l=1
X468 a_12205_17226# a_n205_21647# sky130_fd_pr__cap_mim_m3_1 l=10 w=10
X469 Vss Vss Vss Vss sky130_fd_pr__nfet_01v8_lvt ad=0.145 pd=1.58 as=0 ps=0 w=0.5 l=0.5
X470 Vdd Vdd Vdd Vdd sky130_fd_pr__pfet_01v8_lvt ad=0.58 pd=4.58 as=0 ps=0 w=2 l=2
X471 Vdd a_23489_19515# a_23489_19515# Vdd sky130_fd_pr__pfet_01v8_lvt ad=0.29 pd=2.58 as=0.29 ps=2.58 w=1 l=5
X472 Vss Vss Vss Vss sky130_fd_pr__nfet_01v8_lvt ad=0.145 pd=1.58 as=0 ps=0 w=0.5 l=0.5
X473 Vss Vss Vss Vss sky130_fd_pr__nfet_01v8_lvt ad=0.145 pd=1.58 as=0 ps=0 w=0.5 l=0.5
X474 Vss Vss Vss Vss sky130_fd_pr__nfet_01v8_lvt ad=0.58 pd=4.58 as=0 ps=0 w=2 l=2
X475 a_2865_14979# a_2865_14979# Vdd Vdd sky130_fd_pr__pfet_01v8_lvt ad=0.29 pd=2.58 as=0.29 ps=2.58 w=1 l=20
X476 Vss Vss Vss Vss sky130_fd_pr__nfet_01v8_lvt ad=1.45 pd=10.58 as=0 ps=0 w=5 l=2
X477 Vdd a_23489_19515# a_23489_19515# Vdd sky130_fd_pr__pfet_01v8_lvt ad=0.29 pd=2.58 as=0.29 ps=2.58 w=1 l=5
X478 Vss Vss Vss Vss sky130_fd_pr__nfet_01v8_lvt ad=0.145 pd=1.58 as=0 ps=0 w=0.5 l=0.5
X479 Vdd 2stage_op_amp_1/bias_dummy_0.PBias a_1785_12473# Vdd sky130_fd_pr__pfet_01v8_lvt ad=1.45 pd=10.58 as=1.45 ps=10.58 w=5 l=2
X480 a_12356_8500# 2stage_op_amp_1/Diff_opamp_ly_0.Vbias2 a_13686_6188# Vss sky130_fd_pr__nfet_01v8_lvt ad=0.29 pd=2.58 as=0.29 ps=2.58 w=1 l=10
X481 Vss Vss Vss Vss sky130_fd_pr__nfet_01v8_lvt ad=0.58 pd=4.58 as=0 ps=0 w=2 l=10
X482 a_12205_19546# a_n347_21647# sky130_fd_pr__cap_mim_m3_1 l=10 w=10
X483 a_12205_19546# 2stage_op_amp_1/Diff_opamp_ly_0.Vbias2 a_12906_3858# Vss sky130_fd_pr__nfet_01v8_lvt ad=0.29 pd=2.58 as=0.29 ps=2.58 w=1 l=10
X484 Vss Vss Vss Vss sky130_fd_pr__nfet_01v8_lvt ad=0.145 pd=1.58 as=0 ps=0 w=0.5 l=0.5
X485 a_20243_23573# a_28673_23873# sky130_fd_pr__res_generic_po w=0.5 l=40
X486 Vss Vss sky130_fd_pr__cap_mim_m3_1 l=10 w=2
X487 Vdd Vdd Vdd Vdd sky130_fd_pr__pfet_01v8_lvt ad=0.29 pd=2.58 as=0 ps=0 w=1 l=5
X488 Vdd a_23489_19515# a_23489_19515# Vdd sky130_fd_pr__pfet_01v8_lvt ad=0.29 pd=2.58 as=0.29 ps=2.58 w=1 l=5
X489 Vdd Vdd Vdd Vdd sky130_fd_pr__pfet_01v8_lvt ad=0.145 pd=1.58 as=0 ps=0 w=0.5 l=0.5
X490 a_12205_19284# a_12179_17284# a_12205_17226# Vdd sky130_fd_pr__pfet_01v8_lvt ad=0.145 pd=1.58 as=0.145 ps=1.58 w=0.5 l=10
X491 Vdd Vdd Vdd Vdd sky130_fd_pr__pfet_01v8_lvt ad=0.145 pd=1.58 as=0 ps=0 w=0.5 l=0.5
X492 a_20243_27623# a_28673_27323# sky130_fd_pr__res_generic_po w=0.5 l=40
X493 Vdd Vdd Vdd Vdd sky130_fd_pr__pfet_01v8_lvt ad=0.29 pd=2.58 as=0 ps=0 w=1 l=0.5
X494 a_12179_17284# 2stage_op_amp_1/Diff_opamp_ly_0.Vbias3 Vss Vss sky130_fd_pr__nfet_01v8_lvt ad=0.174 pd=1.78 as=0.174 ps=1.78 w=0.6 l=1
X495 Vss Vss Vss Vss sky130_fd_pr__nfet_01v8_lvt ad=0.58 pd=4.58 as=0 ps=0 w=2 l=1
X496 a_23130_13378# Vom sky130_fd_pr__cap_mim_m3_1 l=10 w=10
X497 a_20243_27173# a_28673_26873# sky130_fd_pr__res_generic_po w=0.5 l=40
X498 Vdd Vdd Vdd Vdd sky130_fd_pr__pfet_01v8_lvt ad=0.29 pd=2.58 as=0 ps=0 w=1 l=5
X499 Vss Vss Vss Vss sky130_fd_pr__nfet_01v8_lvt ad=0.29 pd=2.58 as=0 ps=0 w=1 l=1
X500 Vdd Vdd Vdd Vdd sky130_fd_pr__pfet_01v8_lvt ad=0.29 pd=2.58 as=0 ps=0 w=1 l=0.5
X501 Vdd a_12205_17226# Vom Vdd sky130_fd_pr__pfet_01v8_lvt ad=0.58 pd=4.58 as=0.58 ps=4.58 w=2 l=1
X502 Vss Vss Vss Vss sky130_fd_pr__nfet_01v8_lvt ad=0.174 pd=1.78 as=0 ps=0 w=0.6 l=1
X503 Vdd Vdd sky130_fd_pr__cap_mim_m3_1 l=2 w=10
X504 Vss Vss Vss Vss sky130_fd_pr__nfet_01v8_lvt ad=0.29 pd=2.58 as=0 ps=0 w=1 l=1
X505 a_19306_17126# a_12205_17226# a_14206_3858# Vss sky130_fd_pr__nfet_01v8_lvt ad=0.145 pd=1.58 as=0.145 ps=1.58 w=0.5 l=10
X506 Vdd Vdd Vdd Vdd sky130_fd_pr__pfet_01v8_lvt ad=1.45 pd=10.58 as=0 ps=0 w=5 l=2
X507 Vdd Vdd Vdd Vdd sky130_fd_pr__pfet_01v8_lvt ad=1.45 pd=10.58 as=0 ps=0 w=5 l=2
X508 a_12205_21604# a_12330_8558# a_12356_8500# Vss sky130_fd_pr__nfet_01v8_lvt ad=0.58 pd=4.58 as=0.58 ps=4.58 w=2 l=10
X509 Vss Vss Vss Vss sky130_fd_pr__nfet_01v8_lvt ad=0.29 pd=2.58 as=0 ps=0 w=1 l=1
X510 Vdd a_23489_19515# a_23489_19515# Vdd sky130_fd_pr__pfet_01v8_lvt ad=0.29 pd=2.58 as=0.29 ps=2.58 w=1 l=5
X511 a_19306_17126# a_12205_17226# a_14206_3858# Vss sky130_fd_pr__nfet_01v8_lvt ad=0.145 pd=1.58 as=0.145 ps=1.58 w=0.5 l=10
X512 Vdd 2stage_op_amp_1/bias_dummy_0.PBias 2stage_op_amp_1/bias_dummy_0.Vbias1 Vdd sky130_fd_pr__pfet_01v8_lvt ad=1.45 pd=10.58 as=1.45 ps=10.58 w=5 l=2
X513 a_12205_19284# Vm a_12356_8500# Vss sky130_fd_pr__nfet_01v8_lvt ad=0.58 pd=4.58 as=0.58 ps=4.58 w=2 l=10
X514 Vss Vss Vss Vss sky130_fd_pr__nfet_01v8_lvt ad=0.145 pd=1.58 as=0 ps=0 w=0.5 l=10
X515 Vss Vss Vss Vss sky130_fd_pr__nfet_01v8_lvt ad=0.58 pd=4.58 as=0 ps=0 w=2 l=1
X516 a_12205_17226# 2stage_op_amp_1/Diff_opamp_ly_0.Vbias2 a_12906_6188# Vss sky130_fd_pr__nfet_01v8_lvt ad=0.29 pd=2.58 as=0.29 ps=2.58 w=1 l=10
X517 a_12205_19284# a_12179_17284# a_12205_17226# Vdd sky130_fd_pr__pfet_01v8_lvt ad=0.145 pd=1.58 as=0.145 ps=1.58 w=0.5 l=10
X518 a_20243_24023# a_28673_24323# sky130_fd_pr__res_generic_po w=0.5 l=40
X519 Vss Vss Vss Vss sky130_fd_pr__nfet_01v8_lvt ad=0.174 pd=1.78 as=0 ps=0 w=0.6 l=1
X520 a_1332_19196# en_2 Rgm Vss sky130_fd_pr__nfet_01v8_lvt ad=0.29 pd=2.58 as=0.29 ps=2.58 w=1 l=0.15
X521 a_19456_19784# a_12205_19546# sky130_fd_pr__cap_mim_m3_1 l=10 w=10
X522 Vdd a_12205_19546# Vop Vdd sky130_fd_pr__pfet_01v8_lvt ad=0.58 pd=4.58 as=0.58 ps=4.58 w=2 l=1
X523 Vop a_23130_13378# Vss Vss sky130_fd_pr__nfet_01v8_lvt ad=0.29 pd=2.58 as=0.29 ps=2.58 w=1 l=1
X524 Vss Vss Vss Vss sky130_fd_pr__nfet_01v8_lvt ad=0.145 pd=1.58 as=0 ps=0 w=0.5 l=0.5
X525 Vdd 2stage_op_amp_1/bias_dummy_0.PBias a_1785_12473# Vdd sky130_fd_pr__pfet_01v8_lvt ad=1.45 pd=10.58 as=1.45 ps=10.58 w=5 l=2
X526 Vdd Vdd Vdd Vdd sky130_fd_pr__pfet_01v8_lvt ad=0.58 pd=4.58 as=0 ps=0 w=2 l=1
X527 Vss Vss Vss Vss sky130_fd_pr__nfet_01v8_lvt ad=0.29 pd=2.58 as=0 ps=0 w=1 l=10
X528 a_n773_21647# a_n489_13217# sky130_fd_pr__res_generic_po w=0.5 l=40
X529 Vdd Vdd Vdd Vdd sky130_fd_pr__pfet_01v8_lvt ad=0.29 pd=2.58 as=0 ps=0 w=1 l=0.5
X530 Vdd Vdd Vdd Vdd sky130_fd_pr__pfet_01v8_lvt ad=0.58 pd=4.58 as=0 ps=0 w=2 l=2
X531 Vss Vss Vss Vss sky130_fd_pr__nfet_01v8_lvt ad=0.29 pd=2.58 as=0 ps=0 w=1 l=1
X532 Vss Vss Vss Vss sky130_fd_pr__nfet_01v8_lvt ad=0.29 pd=2.58 as=0 ps=0 w=1 l=1
X533 a_12356_8500# 2stage_op_amp_1/Diff_opamp_ly_0.Vbias2 a_13686_3858# Vss sky130_fd_pr__nfet_01v8_lvt ad=0.29 pd=2.58 as=0.29 ps=2.58 w=1 l=10
X534 a_12205_21604# a_12330_8558# a_12356_8500# Vss sky130_fd_pr__nfet_01v8_lvt ad=0.58 pd=4.58 as=0.58 ps=4.58 w=2 l=10
X535 Vdd a_23489_19515# a_23489_19515# Vdd sky130_fd_pr__pfet_01v8_lvt ad=0.29 pd=2.58 as=0.29 ps=2.58 w=1 l=5
X536 a_12205_17226# 2stage_op_amp_1/Diff_opamp_ly_0.Vbias2 a_12906_6188# Vss sky130_fd_pr__nfet_01v8_lvt ad=0.29 pd=2.58 as=0.29 ps=2.58 w=1 l=10
X537 Vdd a_12205_17226# Vom Vdd sky130_fd_pr__pfet_01v8_lvt ad=0.58 pd=4.58 as=0.58 ps=4.58 w=2 l=1
X538 a_1506_10650# en_1 Vss Vss sky130_fd_pr__nfet_01v8_lvt ad=1.45 pd=10.58 as=0.725 ps=5.29 w=5 l=0.15
X539 Vss Vss Vss Vss sky130_fd_pr__nfet_01v8_lvt ad=0.58 pd=4.58 as=0 ps=0 w=2 l=2
X540 Vdd 2stage_op_amp_1/bias_dummy_0.PBias 2stage_op_amp_1/bias_dummy_0.Vbias2 Vdd sky130_fd_pr__pfet_01v8_lvt ad=1.45 pd=10.58 as=1.45 ps=10.58 w=5 l=2
X541 Vss a_3062_9246# a_23489_19515# Vss sky130_fd_pr__nfet_01v8_lvt ad=0.174 pd=1.78 as=0.174 ps=1.78 w=0.6 l=1
X542 Vom a_23130_13378# Vss Vss sky130_fd_pr__nfet_01v8_lvt ad=0.29 pd=2.58 as=0.29 ps=2.58 w=1 l=1
X543 a_19456_19784# a_12205_19546# sky130_fd_pr__cap_mim_m3_1 l=10 w=10
X544 Vss Vss sky130_fd_pr__cap_mim_m3_1 l=2 w=10
X545 Vdd a_19456_19784# a_12205_19284# Vdd sky130_fd_pr__pfet_01v8_lvt ad=0.29 pd=2.58 as=0.29 ps=2.58 w=1 l=5
X546 Vss Vss Vss Vss sky130_fd_pr__nfet_01v8_lvt ad=0.145 pd=1.58 as=0 ps=0 w=0.5 l=10
X547 a_12356_8500# 2stage_op_amp_1/Diff_opamp_ly_0.Vbias2 a_13686_6188# Vss sky130_fd_pr__nfet_01v8_lvt ad=0.29 pd=2.58 as=0.29 ps=2.58 w=1 l=10
X548 a_19306_17126# a_12205_17226# a_14206_3858# Vss sky130_fd_pr__nfet_01v8_lvt ad=0.145 pd=1.58 as=0.145 ps=1.58 w=0.5 l=10
X549 a_14206_6188# 2stage_op_amp_1/Diff_opamp_ly_0.nmos_cload_01_1.Vbias1 Vss Vss sky130_fd_pr__nfet_01v8_lvt ad=0.145 pd=1.58 as=0.145 ps=1.58 w=0.5 l=10
X550 Vdd Vdd Vdd Vdd sky130_fd_pr__pfet_01v8_lvt ad=0.145 pd=1.58 as=0 ps=0 w=0.5 l=10
X551 a_12205_19546# 2stage_op_amp_1/Diff_opamp_ly_0.Vbias2 a_12906_3858# Vss sky130_fd_pr__nfet_01v8_lvt ad=0.29 pd=2.58 as=0.29 ps=2.58 w=1 l=10
X552 Vdd Vdd Vdd Vdd sky130_fd_pr__pfet_01v8_lvt ad=0.145 pd=1.58 as=0 ps=0 w=0.5 l=0.5
X553 Vdd Vdd Vdd Vdd sky130_fd_pr__pfet_01v8_lvt ad=0.145 pd=1.58 as=0 ps=0 w=0.5 l=0.5
X554 Vdd a_23489_19515# a_23489_19515# Vdd sky130_fd_pr__pfet_01v8_lvt ad=0.29 pd=2.58 as=0.29 ps=2.58 w=1 l=5
X555 Vss Vss Vss Vss sky130_fd_pr__nfet_01v8_lvt ad=0.58 pd=4.58 as=0 ps=0 w=2 l=1
X556 Vop a_23130_13378# Vss Vss sky130_fd_pr__nfet_01v8_lvt ad=0.29 pd=2.58 as=0.29 ps=2.58 w=1 l=1
X557 2stage_op_amp_1/Diff_opamp_ly_0.nmos_cload_01_1.Vbias1 2stage_op_amp_1/Diff_opamp_ly_0.nmos_cload_01_1.Vbias1 Vss Vss sky130_fd_pr__nfet_01v8_lvt ad=0.145 pd=1.58 as=0.145 ps=1.58 w=0.5 l=10
X558 Vss Vss Vss Vss sky130_fd_pr__nfet_01v8_lvt ad=0.29 pd=2.58 as=0 ps=0 w=1 l=1
X559 Vdd Vdd Vdd Vdd sky130_fd_pr__pfet_01v8_lvt ad=0.145 pd=1.58 as=0 ps=0 w=0.5 l=0.5
X560 Vom a_23130_13378# Vss Vss sky130_fd_pr__nfet_01v8_lvt ad=0.29 pd=2.58 as=0.29 ps=2.58 w=1 l=1
X561 2stage_op_amp_1/Diff_opamp_ly_0.nmos_cload_01_1.Vbias1 2stage_op_amp_1/Diff_opamp_ly_0.nmos_cload_01_1.Vbias1 Vss Vss sky130_fd_pr__nfet_01v8_lvt ad=0.145 pd=1.58 as=0.145 ps=1.58 w=0.5 l=10
X562 a_20243_27623# a_28673_27923# sky130_fd_pr__res_generic_po w=0.5 l=40
X563 Vdd Vdd Vdd Vdd sky130_fd_pr__pfet_01v8_lvt ad=0.145 pd=1.58 as=0 ps=0 w=0.5 l=0.5
X564 Vss Vss sky130_fd_pr__cap_mim_m3_1 l=10 w=2
X565 Vss Vss Vss Vss sky130_fd_pr__nfet_01v8_lvt ad=0.145 pd=1.58 as=0 ps=0 w=0.5 l=0.5
X566 Vdd Vdd Vdd Vdd sky130_fd_pr__pfet_01v8_lvt ad=0.29 pd=2.58 as=0 ps=0 w=1 l=1
X567 a_2465_13713# a_2465_13713# Vss Vss sky130_fd_pr__nfet_01v8_lvt ad=1.45 pd=10.58 as=1.45 ps=10.58 w=5 l=2
X568 Vdd Vdd Vdd Vdd sky130_fd_pr__pfet_01v8_lvt ad=0.29 pd=2.58 as=0 ps=0 w=1 l=5
X569 Vdd Vdd Vdd Vdd sky130_fd_pr__pfet_01v8_lvt ad=0.29 pd=2.58 as=0 ps=0 w=1 l=1
X570 Vdd Vdd Vdd Vdd sky130_fd_pr__pfet_01v8_lvt ad=0.29 pd=2.58 as=0 ps=0 w=1 l=1
X571 Vdd Vdd Vdd Vdd sky130_fd_pr__pfet_01v8_lvt ad=0.29 pd=2.58 as=0 ps=0 w=1 l=1
X572 Vop a_23130_13378# Vss Vss sky130_fd_pr__nfet_01v8_lvt ad=0.29 pd=2.58 as=0.29 ps=2.58 w=1 l=1
X573 Vss Vss Vss Vss sky130_fd_pr__nfet_01v8_lvt ad=0.145 pd=1.58 as=0 ps=0 w=0.5 l=0.5
X574 a_12356_8500# 2stage_op_amp_1/Diff_opamp_ly_0.Vbias2 a_13686_6188# Vss sky130_fd_pr__nfet_01v8_lvt ad=0.29 pd=2.58 as=0.29 ps=2.58 w=1 l=10
X575 a_20243_27173# a_28673_27473# sky130_fd_pr__res_generic_po w=0.5 l=40
X576 Vdd Vdd Vdd Vdd sky130_fd_pr__pfet_01v8_lvt ad=0.145 pd=1.58 as=0 ps=0 w=0.5 l=0.5
X577 Vss Vss Vss Vss sky130_fd_pr__nfet_01v8_lvt ad=0.145 pd=1.58 as=0 ps=0 w=0.5 l=0.5
X578 Vdd Vdd Vdd Vdd sky130_fd_pr__pfet_01v8_lvt ad=0.29 pd=2.58 as=0 ps=0 w=1 l=0.5
X579 Vdd Vdd Vdd Vdd sky130_fd_pr__pfet_01v8_lvt ad=0.29 pd=2.58 as=0 ps=0 w=1 l=1
X580 Vss Vss Vss Vss sky130_fd_pr__nfet_01v8_lvt ad=0.145 pd=1.58 as=0 ps=0 w=0.5 l=0.5
X581 Vss Vss Vss Vss sky130_fd_pr__nfet_01v8_lvt ad=1.45 pd=10.58 as=0 ps=0 w=5 l=2
X582 Vom a_23130_13378# Vss Vss sky130_fd_pr__nfet_01v8_lvt ad=0.29 pd=2.58 as=0.29 ps=2.58 w=1 l=1
X583 Vdd a_2864_12498# 2stage_op_amp_1/bias_dummy_0.PBias Vdd sky130_fd_pr__pfet_01v8_lvt ad=1.45 pd=10.58 as=1.45 ps=10.58 w=5 l=2
X584 a_19306_17126# a_12205_19546# a_14206_6188# Vss sky130_fd_pr__nfet_01v8_lvt ad=0.145 pd=1.58 as=0.145 ps=1.58 w=0.5 l=10
X585 Vdd a_23489_19515# a_23489_19515# Vdd sky130_fd_pr__pfet_01v8_lvt ad=0.29 pd=2.58 as=0.29 ps=2.58 w=1 l=5
X586 Vop a_23130_13378# Vss Vss sky130_fd_pr__nfet_01v8_lvt ad=0.29 pd=2.58 as=0.29 ps=2.58 w=1 l=1
X587 Vdd a_23489_19515# a_23489_19515# Vdd sky130_fd_pr__pfet_01v8_lvt ad=0.29 pd=2.58 as=0.29 ps=2.58 w=1 l=5
X588 a_19456_19784# a_19306_17126# Vdd Vdd sky130_fd_pr__pfet_01v8_lvt ad=0.29 pd=2.58 as=0.29 ps=2.58 w=1 l=10
X589 Vdd Vdd Vdd Vdd sky130_fd_pr__pfet_01v8_lvt ad=0.29 pd=2.58 as=0 ps=0 w=1 l=1
X590 Vss Vss Vss Vss sky130_fd_pr__nfet_01v8_lvt ad=0.145 pd=1.58 as=0 ps=0 w=0.5 l=0.5
X591 Vss Vss Vss Vss sky130_fd_pr__nfet_01v8_lvt ad=0.145 pd=1.58 as=0 ps=0 w=0.5 l=0.5
X592 Vdd Vdd Vdd Vdd sky130_fd_pr__pfet_01v8_lvt ad=0.29 pd=2.58 as=0 ps=0 w=1 l=1
X593 a_1785_12473# a_1785_12473# 2stage_op_amp_1/switchblock_1.beta Vss sky130_fd_pr__nfet_01v8_lvt ad=1.45 pd=10.58 as=1.45 ps=10.58 w=5 l=2
X594 Vdd a_23489_19515# a_23489_19515# Vdd sky130_fd_pr__pfet_01v8_lvt ad=0.29 pd=2.58 as=0.29 ps=2.58 w=1 l=5
X595 Vss Vss Vss Vss sky130_fd_pr__nfet_01v8_lvt ad=0.58 pd=4.58 as=0 ps=0 w=2 l=1
X596 Vss Vss sky130_fd_pr__cap_mim_m3_1 l=2 w=2
X597 Vdd Vdd Vdd Vdd sky130_fd_pr__pfet_01v8_lvt ad=1.45 pd=10.58 as=0 ps=0 w=5 l=2
X598 Vss Vss Vss Vss sky130_fd_pr__nfet_01v8_lvt ad=0.145 pd=1.58 as=0 ps=0 w=0.5 l=0.5
X599 Vdd Vdd Vdd Vdd sky130_fd_pr__pfet_01v8_lvt ad=0.29 pd=2.58 as=0 ps=0 w=1 l=1
X600 Vdd a_19456_19784# a_12205_21604# Vdd sky130_fd_pr__pfet_01v8_lvt ad=0.29 pd=2.58 as=0.29 ps=2.58 w=1 l=5
X601 Vdd a_12205_19546# Vop Vdd sky130_fd_pr__pfet_01v8_lvt ad=0.58 pd=4.58 as=0.58 ps=4.58 w=2 l=1
X602 Vss Vss Vss Vss sky130_fd_pr__nfet_01v8_lvt ad=0.29 pd=2.58 as=0 ps=0 w=1 l=1
X603 Vss Vss sky130_fd_pr__cap_mim_m3_1 l=10 w=2
X604 Vss Vss Vss Vss sky130_fd_pr__nfet_01v8_lvt ad=0.29 pd=2.58 as=0 ps=0 w=1 l=1
X605 Vss Vss Vss Vss sky130_fd_pr__nfet_01v8_lvt ad=0.174 pd=1.78 as=0 ps=0 w=0.6 l=1
X606 a_20243_24623# a_28673_24323# sky130_fd_pr__res_generic_po w=0.5 l=40
X607 a_14206_6188# 2stage_op_amp_1/Diff_opamp_ly_0.nmos_cload_01_1.Vbias1 Vss Vss sky130_fd_pr__nfet_01v8_lvt ad=0.145 pd=1.58 as=0.145 ps=1.58 w=0.5 l=10
X608 Vss Vss Vss Vss sky130_fd_pr__nfet_01v8_lvt ad=0.145 pd=1.58 as=0 ps=0 w=0.5 l=0.5
X609 Vdd Vdd Vdd Vdd sky130_fd_pr__pfet_01v8_lvt ad=0.29 pd=2.58 as=0 ps=0 w=1 l=5
X610 Vop a_23130_13378# Vss Vss sky130_fd_pr__nfet_01v8_lvt ad=0.29 pd=2.58 as=0.29 ps=2.58 w=1 l=1
X611 Vss Vss sky130_fd_pr__cap_mim_m3_1 l=10 w=2
X612 a_12356_8500# 2stage_op_amp_1/Diff_opamp_ly_0.Vbias2 a_13686_3858# Vss sky130_fd_pr__nfet_01v8_lvt ad=0.29 pd=2.58 as=0.29 ps=2.58 w=1 l=10
X613 Vdd 2stage_op_amp_1/bias_dummy_0.PBias 2stage_op_amp_1/bias_dummy_0.Vbias3 Vdd sky130_fd_pr__pfet_01v8_lvt ad=1.45 pd=10.58 as=1.45 ps=10.58 w=5 l=2
X614 Vdd Vdd sky130_fd_pr__cap_mim_m3_1 l=2 w=2
X615 a_19306_17126# a_12205_19546# a_14206_6188# Vss sky130_fd_pr__nfet_01v8_lvt ad=0.145 pd=1.58 as=0.145 ps=1.58 w=0.5 l=10
X616 2stage_op_amp_1/Diff_opamp_ly_0.nmos_cload_01_1.Vbias1 2stage_op_amp_1/Diff_opamp_ly_0.nmos_cload_01_1.Vbias1 Vss Vss sky130_fd_pr__nfet_01v8_lvt ad=0.145 pd=1.58 as=0.145 ps=1.58 w=0.5 l=10
X617 a_20243_24173# a_28673_23873# sky130_fd_pr__res_generic_po w=0.5 l=40
X618 a_27034_13564# a_28046_17426# a_26999_20995# Vdd sky130_fd_pr__pfet_01v8_lvt ad=0.145 pd=1.58 as=0.145 ps=1.58 w=0.5 l=10
X619 Vss Vss Vss Vss sky130_fd_pr__nfet_01v8_lvt ad=0.29 pd=2.58 as=0 ps=0 w=1 l=10
X620 Vss Vss Vss Vss sky130_fd_pr__nfet_01v8_lvt ad=0.145 pd=1.58 as=0 ps=0 w=0.5 l=0.5
X621 Vdd Vdd Vdd Vdd sky130_fd_pr__pfet_01v8_lvt ad=0.29 pd=2.58 as=0 ps=0 w=1 l=0.5
X622 Vom a_23130_13378# Vss Vss sky130_fd_pr__nfet_01v8_lvt ad=0.29 pd=2.58 as=0.29 ps=2.58 w=1 l=1
X623 Vdd a_23489_19515# a_23489_19515# Vdd sky130_fd_pr__pfet_01v8_lvt ad=0.29 pd=2.58 as=0.29 ps=2.58 w=1 l=5
X624 a_12356_8500# 2stage_op_amp_1/Diff_opamp_ly_0.Vbias2 a_13686_3858# Vss sky130_fd_pr__nfet_01v8_lvt ad=0.29 pd=2.58 as=0.29 ps=2.58 w=1 l=10
X625 Vdd Vdd Vdd Vdd sky130_fd_pr__pfet_01v8_lvt ad=0.29 pd=2.58 as=0 ps=0 w=1 l=1
X626 Vdd Vdd Vdd Vdd sky130_fd_pr__pfet_01v8_lvt ad=0.58 pd=4.58 as=0 ps=0 w=2 l=2
X627 Vdd a_23489_19515# a_23489_19515# Vdd sky130_fd_pr__pfet_01v8_lvt ad=0.29 pd=2.58 as=0.29 ps=2.58 w=1 l=5
X628 a_13686_3858# 2stage_op_amp_1/Diff_opamp_ly_0.nmos_cload_01_1.Vbias1 Vss Vss sky130_fd_pr__nfet_01v8_lvt ad=0.145 pd=1.58 as=0.145 ps=1.58 w=0.5 l=10
X629 Vdd Vdd Vdd Vdd sky130_fd_pr__pfet_01v8_lvt ad=0.29 pd=2.58 as=0 ps=0 w=1 l=1
X630 a_19306_17126# a_12205_19546# a_14206_6188# Vss sky130_fd_pr__nfet_01v8_lvt ad=0.145 pd=1.58 as=0.145 ps=1.58 w=0.5 l=10
X631 Vdd Vdd Vdd Vdd sky130_fd_pr__pfet_01v8_lvt ad=0.29 pd=2.58 as=0 ps=0 w=1 l=1
X632 a_12205_17226# 2stage_op_amp_1/Diff_opamp_ly_0.Vbias2 a_12906_6188# Vss sky130_fd_pr__nfet_01v8_lvt ad=0.29 pd=2.58 as=0.29 ps=2.58 w=1 l=10
X633 a_1785_12473# a_1785_12473# 2stage_op_amp_1/switchblock_1.beta Vss sky130_fd_pr__nfet_01v8_lvt ad=1.45 pd=10.58 as=1.45 ps=10.58 w=5 l=2
X634 Vss Vss Vss Vss sky130_fd_pr__nfet_01v8_lvt ad=0.29 pd=2.58 as=0 ps=0 w=1 l=1
X635 Vss a_3062_9246# a_3062_9246# Vss sky130_fd_pr__nfet_01v8_lvt ad=0.174 pd=1.78 as=0.174 ps=1.78 w=0.6 l=1
X636 a_23130_13378# Vop sky130_fd_pr__cap_mim_m3_1 l=10 w=10
X637 Vss Vss Vss Vss sky130_fd_pr__nfet_01v8_lvt ad=1.45 pd=10.58 as=0 ps=0 w=5 l=2
X638 Vdd a_19456_19784# a_12205_19284# Vdd sky130_fd_pr__pfet_01v8_lvt ad=0.29 pd=2.58 as=0.29 ps=2.58 w=1 l=5
X639 Vss Vss Vss Vss sky130_fd_pr__nfet_01v8_lvt ad=0.58 pd=4.58 as=0 ps=0 w=2 l=1
X640 Vss Vss Vss Vss sky130_fd_pr__nfet_01v8_lvt ad=0.29 pd=2.58 as=0 ps=0 w=1 l=1
X641 Vdd Vdd Vdd Vdd sky130_fd_pr__pfet_01v8_lvt ad=0.145 pd=1.58 as=0 ps=0 w=0.5 l=10
X642 a_12205_21604# a_12179_17284# a_12205_19546# Vdd sky130_fd_pr__pfet_01v8_lvt ad=0.145 pd=1.58 as=0.145 ps=1.58 w=0.5 l=10
X643 Vss Vss Vss Vss sky130_fd_pr__nfet_01v8_lvt ad=0.29 pd=2.58 as=0 ps=0 w=1 l=10
X644 Vdd Vdd Vdd Vdd sky130_fd_pr__pfet_01v8_lvt ad=0.145 pd=1.58 as=0 ps=0 w=0.5 l=0.5
X645 a_19456_19784# a_12205_19546# sky130_fd_pr__cap_mim_m3_1 l=10 w=10
X646 Vdd Vdd Vdd Vdd sky130_fd_pr__pfet_01v8_lvt ad=0.29 pd=2.58 as=0 ps=0 w=1 l=5
X647 Vdd 2stage_op_amp_1/bias_dummy_0.PBias 2stage_op_amp_1/bias_dummy_0.Vbias3 Vdd sky130_fd_pr__pfet_01v8_lvt ad=1.45 pd=10.58 as=1.45 ps=10.58 w=5 l=2
X648 Vdd Vdd Vdd Vdd sky130_fd_pr__pfet_01v8_lvt ad=0.145 pd=1.58 as=0 ps=0 w=0.5 l=0.5
X649 Vss Vss Vss Vss sky130_fd_pr__nfet_01v8_lvt ad=0.29 pd=2.58 as=0 ps=0 w=1 l=1
X650 a_n1483_21647# a_n1199_13217# sky130_fd_pr__res_generic_po w=0.5 l=40
X651 a_12356_8500# 2stage_op_amp_1/Diff_opamp_ly_0.Vbias2 a_13686_3858# Vss sky130_fd_pr__nfet_01v8_lvt ad=0.29 pd=2.58 as=0.29 ps=2.58 w=1 l=10
X652 a_12205_21604# a_12179_17284# a_12205_19546# Vdd sky130_fd_pr__pfet_01v8_lvt ad=0.145 pd=1.58 as=0.145 ps=1.58 w=0.5 l=10
X653 Vdd Vdd Vdd Vdd sky130_fd_pr__pfet_01v8_lvt ad=0.29 pd=2.58 as=0 ps=0 w=1 l=0.5
X654 Vss Vss Vss Vss sky130_fd_pr__nfet_01v8_lvt ad=0.145 pd=1.58 as=0 ps=0 w=0.5 l=0.5
X655 Vdd Vdd Vdd Vdd sky130_fd_pr__pfet_01v8_lvt ad=0.29 pd=2.58 as=0 ps=0 w=1 l=1
X656 Vss Vss Vss Vss sky130_fd_pr__nfet_01v8_lvt ad=0.29 pd=2.58 as=0 ps=0 w=1 l=1
X657 Vdd a_12205_19546# Vop Vdd sky130_fd_pr__pfet_01v8_lvt ad=0.58 pd=4.58 as=0.58 ps=4.58 w=2 l=1
X658 Vdd a_19456_19784# a_12205_19284# Vdd sky130_fd_pr__pfet_01v8_lvt ad=0.29 pd=2.58 as=0.29 ps=2.58 w=1 l=5
X659 Vdd Vdd Vdd Vdd sky130_fd_pr__pfet_01v8_lvt ad=0.145 pd=1.58 as=0 ps=0 w=0.5 l=0.5
X660 a_12356_8500# 2stage_op_amp_1/Diff_opamp_ly_0.Vbias2 a_13686_6188# Vss sky130_fd_pr__nfet_01v8_lvt ad=0.29 pd=2.58 as=0.29 ps=2.58 w=1 l=10
X661 a_2864_12498# a_1785_12473# a_1506_10650# Vss sky130_fd_pr__nfet_01v8_lvt ad=1.45 pd=10.58 as=1.45 ps=10.58 w=5 l=2
X662 a_19456_19784# a_12205_19546# sky130_fd_pr__cap_mim_m3_1 l=10 w=10
X663 a_20243_27773# a_28673_27473# sky130_fd_pr__res_generic_po w=0.5 l=40
X664 a_27034_13564# a_28046_17426# a_26999_20995# Vdd sky130_fd_pr__pfet_01v8_lvt ad=0.145 pd=1.58 as=0.145 ps=1.58 w=0.5 l=10
X665 a_12205_21604# a_12330_8558# a_12356_8500# Vss sky130_fd_pr__nfet_01v8_lvt ad=0.58 pd=4.58 as=0.58 ps=4.58 w=2 l=10
X666 a_19306_17126# a_12205_19546# a_14206_6188# Vss sky130_fd_pr__nfet_01v8_lvt ad=0.145 pd=1.58 as=0.145 ps=1.58 w=0.5 l=10
X667 a_19306_17126# a_12205_19546# a_14206_6188# Vss sky130_fd_pr__nfet_01v8_lvt ad=0.145 pd=1.58 as=0.145 ps=1.58 w=0.5 l=10
X668 Vdd Vdd Vdd Vdd sky130_fd_pr__pfet_01v8_lvt ad=1.45 pd=10.58 as=0 ps=0 w=5 l=1
X669 Vss Vss Vss Vss sky130_fd_pr__nfet_01v8_lvt ad=0.0609 pd=0.71 as=0 ps=0 w=0.42 l=0.15
X670 Vdd Vdd sky130_fd_pr__cap_mim_m3_1 l=2 w=10
X671 Vdd Vdd Vdd Vdd sky130_fd_pr__pfet_01v8_lvt ad=0.58 pd=4.58 as=0 ps=0 w=2 l=1
X672 Vss Vss Vss Vss sky130_fd_pr__nfet_01v8_lvt ad=0.29 pd=2.58 as=0 ps=0 w=1 l=1
X673 Vss Vss Vss Vss sky130_fd_pr__nfet_01v8_lvt ad=0.29 pd=2.58 as=0 ps=0 w=1 l=1
X674 Vdd a_23489_19515# a_23489_19515# Vdd sky130_fd_pr__pfet_01v8_lvt ad=0.29 pd=2.58 as=0.29 ps=2.58 w=1 l=5
X675 Vdd a_23489_19515# a_23489_19515# Vdd sky130_fd_pr__pfet_01v8_lvt ad=0.29 pd=2.58 as=0.29 ps=2.58 w=1 l=5
X676 Vdd a_2864_12498# 2stage_op_amp_1/bias_dummy_0.PBias Vdd sky130_fd_pr__pfet_01v8_lvt ad=1.45 pd=10.58 as=1.45 ps=10.58 w=5 l=2
X677 Vss Vss Vss Vss sky130_fd_pr__nfet_01v8_lvt ad=1.45 pd=10.58 as=0 ps=0 w=5 l=2
X678 Vdd Vdd Vdd Vdd sky130_fd_pr__pfet_01v8_lvt ad=0.29 pd=2.58 as=0 ps=0 w=1 l=1
X679 Vdd a_23489_19515# a_23489_19515# Vdd sky130_fd_pr__pfet_01v8_lvt ad=0.29 pd=2.58 as=0.29 ps=2.58 w=1 l=5
X680 Vss Vss Vss Vss sky130_fd_pr__nfet_01v8_lvt ad=0.29 pd=2.58 as=0 ps=0 w=1 l=1
X681 Vdd Vdd Vdd Vdd sky130_fd_pr__pfet_01v8_lvt ad=1.45 pd=10.58 as=0 ps=0 w=5 l=2
X682 Vdd Vdd sky130_fd_pr__cap_mim_m3_1 l=10 w=2
X683 a_12356_8500# 2stage_op_amp_1/Diff_opamp_ly_0.Vbias2 a_13686_6188# Vss sky130_fd_pr__nfet_01v8_lvt ad=0.29 pd=2.58 as=0.29 ps=2.58 w=1 l=10
X684 Vdd Vdd sky130_fd_pr__cap_mim_m3_1 l=2 w=10
X685 Vdd Vdd Vdd Vdd sky130_fd_pr__pfet_01v8_lvt ad=0.29 pd=2.58 as=0 ps=0 w=1 l=5
X686 Vdd 2stage_op_amp_1/bias_dummy_0.PBias a_2465_13713# Vdd sky130_fd_pr__pfet_01v8_lvt ad=1.45 pd=10.58 as=1.45 ps=10.58 w=5 l=2
X687 Vdd 2stage_op_amp_1/bias_dummy_0.PBias 2stage_op_amp_1/bias_dummy_0.Vbias4 Vdd sky130_fd_pr__pfet_01v8_lvt ad=1.45 pd=10.58 as=1.45 ps=10.58 w=5 l=2
X688 a_20243_24623# a_28673_24923# sky130_fd_pr__res_generic_po w=0.5 l=40
X689 Vdd Vdd Vdd Vdd sky130_fd_pr__pfet_01v8_lvt ad=0.29 pd=2.58 as=0 ps=0 w=1 l=5
X690 Vdd Vdd Vdd Vdd sky130_fd_pr__pfet_01v8_lvt ad=0.29 pd=2.58 as=0 ps=0 w=1 l=0.5
X691 Vss Vss Vss Vss sky130_fd_pr__nfet_01v8_lvt ad=0.58 pd=4.58 as=0 ps=0 w=2 l=2
X692 a_19456_19784# a_12205_17226# sky130_fd_pr__cap_mim_m3_1 l=10 w=10
X693 a_1950_9246# a_1332_19196# Vdd Vdd sky130_fd_pr__pfet_01v8_lvt ad=1.45 pd=10.58 as=1.45 ps=10.58 w=5 l=1
X694 Vss Vss sky130_fd_pr__cap_mim_m3_1 l=2 w=2
X695 a_12356_8500# 2stage_op_amp_1/Diff_opamp_ly_0.Vbias2 a_13686_3858# Vss sky130_fd_pr__nfet_01v8_lvt ad=0.29 pd=2.58 as=0.29 ps=2.58 w=1 l=10
X696 Vdd a_12205_17226# Vom Vdd sky130_fd_pr__pfet_01v8_lvt ad=0.58 pd=4.58 as=0.58 ps=4.58 w=2 l=1
X697 Vdd Vdd Vdd Vdd sky130_fd_pr__pfet_01v8_lvt ad=0.145 pd=1.58 as=0 ps=0 w=0.5 l=0.5
X698 a_1350_9246# en_2 2stage_op_amp_1/Diff_opamp_ly_0.nmos_cload_01_1.Vbias1 Vss sky130_fd_pr__nfet_01v8_lvt ad=0.29 pd=2.58 as=0.29 ps=2.58 w=1 l=0.15
X699 a_12205_21604# a_12330_8558# a_12356_8500# Vss sky130_fd_pr__nfet_01v8_lvt ad=0.58 pd=4.58 as=0.58 ps=4.58 w=2 l=10
X700 a_20243_24173# a_28673_24473# sky130_fd_pr__res_generic_po w=0.5 l=40
X701 Vdd Vdd Vdd Vdd sky130_fd_pr__pfet_01v8_lvt ad=0.29 pd=2.58 as=0 ps=0 w=1 l=1
X702 Vss Vss Vss Vss sky130_fd_pr__nfet_01v8_lvt ad=0.58 pd=4.58 as=0 ps=0 w=2 l=2
X703 a_19456_19784# a_12205_17226# sky130_fd_pr__cap_mim_m3_1 l=10 w=10
X704 a_19306_17126# a_12205_17226# a_14206_3858# Vss sky130_fd_pr__nfet_01v8_lvt ad=0.145 pd=1.58 as=0.145 ps=1.58 w=0.5 l=10
X705 Vdd 2stage_op_amp_1/bias_dummy_0.PBias 2stage_op_amp_1/bias_dummy_0.Vbias2 Vdd sky130_fd_pr__pfet_01v8_lvt ad=1.45 pd=10.58 as=1.45 ps=10.58 w=5 l=2
X706 a_2865_14979# a_2465_13713# Vss Vss sky130_fd_pr__nfet_01v8_lvt ad=1.45 pd=10.58 as=1.45 ps=10.58 w=5 l=2
X707 Vdd Vdd Vdd Vdd sky130_fd_pr__pfet_01v8_lvt ad=1.45 pd=10.58 as=0 ps=0 w=5 l=2
X708 a_20243_28223# a_28673_27923# sky130_fd_pr__res_generic_po w=0.5 l=40
X709 a_12205_19284# a_12179_17284# a_12205_17226# Vdd sky130_fd_pr__pfet_01v8_lvt ad=0.145 pd=1.58 as=0.145 ps=1.58 w=0.5 l=10
X710 a_12205_21604# a_12179_17284# a_12205_19546# Vdd sky130_fd_pr__pfet_01v8_lvt ad=0.145 pd=1.58 as=0.145 ps=1.58 w=0.5 l=10
X711 Vss Vss Vss Vss sky130_fd_pr__nfet_01v8_lvt ad=0.174 pd=1.78 as=0 ps=0 w=0.6 l=1
X712 Vdd Vdd Vdd Vdd sky130_fd_pr__pfet_01v8_lvt ad=0.145 pd=1.58 as=0 ps=0 w=0.5 l=0.5
X713 a_12205_17226# 2stage_op_amp_1/Diff_opamp_ly_0.Vbias2 a_12906_6188# Vss sky130_fd_pr__nfet_01v8_lvt ad=0.29 pd=2.58 as=0.29 ps=2.58 w=1 l=10
X714 a_1332_19196# a_1332_19196# Vdd Vdd sky130_fd_pr__pfet_01v8_lvt ad=1.45 pd=10.58 as=1.45 ps=10.58 w=5 l=1
X715 Vdd Vdd Vdd Vdd sky130_fd_pr__pfet_01v8_lvt ad=0.145 pd=1.58 as=0 ps=0 w=0.5 l=0.5
X716 Vss Vss Vss Vss sky130_fd_pr__nfet_01v8_lvt ad=0.29 pd=2.58 as=0 ps=0 w=1 l=10
X717 a_2864_12498# a_1785_12473# a_1506_10650# Vss sky130_fd_pr__nfet_01v8_lvt ad=1.45 pd=10.58 as=1.45 ps=10.58 w=5 l=2
X718 Vdd Vdd Vdd Vdd sky130_fd_pr__pfet_01v8_lvt ad=0.145 pd=1.58 as=0 ps=0 w=0.5 l=0.5
X719 Vdd a_23489_19515# a_23489_19515# Vdd sky130_fd_pr__pfet_01v8_lvt ad=0.29 pd=2.58 as=0.29 ps=2.58 w=1 l=5
X720 Vdd Vdd Vdd Vdd sky130_fd_pr__pfet_01v8_lvt ad=0.58 pd=4.58 as=0 ps=0 w=2 l=2
X721 a_12356_8500# 2stage_op_amp_1/Diff_opamp_ly_0.Vbias2 a_13686_6188# Vss sky130_fd_pr__nfet_01v8_lvt ad=0.29 pd=2.58 as=0.29 ps=2.58 w=1 l=10
X722 Vdd a_23489_19515# a_23489_19515# Vdd sky130_fd_pr__pfet_01v8_lvt ad=0.29 pd=2.58 as=0.29 ps=2.58 w=1 l=5
X723 Vdd Vdd Vdd Vdd sky130_fd_pr__pfet_01v8_lvt ad=0.29 pd=2.58 as=0 ps=0 w=1 l=1
X724 Vss Vss Vss Vss sky130_fd_pr__nfet_01v8_lvt ad=0.145 pd=1.58 as=0 ps=0 w=0.5 l=0.5
X725 Vdd Vdd Vdd Vdd sky130_fd_pr__pfet_01v8_lvt ad=1.45 pd=10.58 as=0 ps=0 w=5 l=2
X726 Vss Vss sky130_fd_pr__cap_mim_m3_1 l=10 w=2
X727 Vdd a_12179_17284# a_12179_17284# Vdd sky130_fd_pr__pfet_01v8_lvt ad=0.145 pd=1.58 as=0.145 ps=1.58 w=0.5 l=10
X728 Vdd a_23489_19515# a_23489_19515# Vdd sky130_fd_pr__pfet_01v8_lvt ad=0.29 pd=2.58 as=0.29 ps=2.58 w=1 l=5
X729 2stage_op_amp_1/Diff_opamp_ly_0.Vbias3 2stage_op_amp_1/Diff_opamp_ly_0.Vbias3 Vss Vss sky130_fd_pr__nfet_01v8_lvt ad=0.174 pd=1.78 as=0.174 ps=1.78 w=0.6 l=1
X730 a_19456_19784# a_12205_17226# sky130_fd_pr__cap_mim_m3_1 l=10 w=10
X731 Vss Vss sky130_fd_pr__cap_mim_m3_1 l=10 w=2
X732 a_12356_8500# 2stage_op_amp_1/Diff_opamp_ly_0.Vbias2 a_13686_3858# Vss sky130_fd_pr__nfet_01v8_lvt ad=0.29 pd=2.58 as=0.29 ps=2.58 w=1 l=10
X733 Vdd a_12205_19546# Vop Vdd sky130_fd_pr__pfet_01v8_lvt ad=0.58 pd=4.58 as=0.58 ps=4.58 w=2 l=1
X734 Vss Vss Vss Vss sky130_fd_pr__nfet_01v8_lvt ad=0.145 pd=1.58 as=0 ps=0 w=0.5 l=0.5
X735 Vdd Vdd Vdd Vdd sky130_fd_pr__pfet_01v8_lvt ad=0.29 pd=2.58 as=0 ps=0 w=1 l=1
X736 a_12205_19546# a_n347_21647# sky130_fd_pr__cap_mim_m3_1 l=10 w=10
X737 Vdd Vdd Vdd Vdd sky130_fd_pr__pfet_01v8_lvt ad=0.58 pd=4.58 as=0 ps=0 w=2 l=2
X738 Vss Vss Vss Vss sky130_fd_pr__nfet_01v8_lvt ad=0.145 pd=1.58 as=0 ps=0 w=0.5 l=0.5
X739 Vss Vss Vss Vss sky130_fd_pr__nfet_01v8_lvt ad=0.58 pd=4.58 as=0 ps=0 w=2 l=2
X740 Vss Vss Vss Vss sky130_fd_pr__nfet_01v8_lvt ad=0.29 pd=2.58 as=0 ps=0 w=1 l=1
X741 Vss Vss Vss Vss sky130_fd_pr__nfet_01v8_lvt ad=0.58 pd=4.58 as=0 ps=0 w=2 l=2
X742 Vss Vss Vss Vss sky130_fd_pr__nfet_01v8_lvt ad=0.29 pd=2.58 as=0 ps=0 w=1 l=1
X743 a_1532_20622# a_1332_19196# Vdd Vdd sky130_fd_pr__pfet_01v8_lvt ad=1.45 pd=10.58 as=1.45 ps=10.58 w=5 l=1
X744 Vss Vss Vss Vss sky130_fd_pr__nfet_01v8_lvt ad=0.0609 pd=0.71 as=0 ps=0 w=0.42 l=0.15
X745 Vss Vss Vss Vss sky130_fd_pr__nfet_01v8_lvt ad=0.29 pd=2.58 as=0 ps=0 w=1 l=1
X746 Vdd 2stage_op_amp_1/bias_dummy_0.PBias a_2465_13713# Vdd sky130_fd_pr__pfet_01v8_lvt ad=1.45 pd=10.58 as=1.45 ps=10.58 w=5 l=2
X747 Vdd a_23489_19515# a_23489_19515# Vdd sky130_fd_pr__pfet_01v8_lvt ad=0.29 pd=2.58 as=0.29 ps=2.58 w=1 l=5
X748 a_12205_19546# a_n347_21647# sky130_fd_pr__cap_mim_m3_1 l=10 w=10
X749 Vdd 2stage_op_amp_1/bias_dummy_0.PBias a_2465_13713# Vdd sky130_fd_pr__pfet_01v8_lvt ad=1.45 pd=10.58 as=1.45 ps=10.58 w=5 l=2
X750 Vdd a_23489_19515# a_23489_19515# Vdd sky130_fd_pr__pfet_01v8_lvt ad=0.29 pd=2.58 as=0.29 ps=2.58 w=1 l=5
X751 Vdd a_23489_19515# a_23489_19515# Vdd sky130_fd_pr__pfet_01v8_lvt ad=0.29 pd=2.58 as=0.29 ps=2.58 w=1 l=5
X752 Vdd a_12205_17226# Vom Vdd sky130_fd_pr__pfet_01v8_lvt ad=0.58 pd=4.58 as=0.58 ps=4.58 w=2 l=1
X753 Vss Vss Vss Vss sky130_fd_pr__nfet_01v8_lvt ad=0.174 pd=1.78 as=0 ps=0 w=0.6 l=1
X754 a_14206_3858# 2stage_op_amp_1/Diff_opamp_ly_0.nmos_cload_01_1.Vbias1 Vss Vss sky130_fd_pr__nfet_01v8_lvt ad=0.145 pd=1.58 as=0.145 ps=1.58 w=0.5 l=10
X755 a_19306_17126# a_12205_19546# a_14206_6188# Vss sky130_fd_pr__nfet_01v8_lvt ad=0.145 pd=1.58 as=0.145 ps=1.58 w=0.5 l=10
X756 a_12356_8500# 2stage_op_amp_1/Diff_opamp_ly_0.Vbias2 a_13686_6188# Vss sky130_fd_pr__nfet_01v8_lvt ad=0.29 pd=2.58 as=0.29 ps=2.58 w=1 l=10
X757 2stage_op_amp_1/Diff_opamp_ly_0.nmos_cload_01_1.Vbias1 2stage_op_amp_1/Diff_opamp_ly_0.nmos_cload_01_1.Vbias1 Vss Vss sky130_fd_pr__nfet_01v8_lvt ad=0.145 pd=1.58 as=0.145 ps=1.58 w=0.5 l=10
X758 Vss Vss Vss Vss sky130_fd_pr__nfet_01v8_lvt ad=0.1218 pd=1.42 as=0 ps=0 w=0.42 l=0.15
X759 Vdd a_23489_19515# a_23489_19515# Vdd sky130_fd_pr__pfet_01v8_lvt ad=0.29 pd=2.58 as=0.29 ps=2.58 w=1 l=5
X760 Vss Vss Vss Vss sky130_fd_pr__nfet_01v8_lvt ad=0.29 pd=2.58 as=0 ps=0 w=1 l=1
X761 a_19306_17126# a_12205_19546# a_14206_6188# Vss sky130_fd_pr__nfet_01v8_lvt ad=0.145 pd=1.58 as=0.145 ps=1.58 w=0.5 l=10
X762 a_13686_6188# 2stage_op_amp_1/Diff_opamp_ly_0.nmos_cload_01_1.Vbias1 Vss Vss sky130_fd_pr__nfet_01v8_lvt ad=0.145 pd=1.58 as=0.145 ps=1.58 w=0.5 l=10
X763 Vdd Vdd Vdd Vdd sky130_fd_pr__pfet_01v8_lvt ad=1.45 pd=10.58 as=0 ps=0 w=5 l=2
X764 Vdd a_23489_19515# a_23489_19515# Vdd sky130_fd_pr__pfet_01v8_lvt ad=0.29 pd=2.58 as=0.29 ps=2.58 w=1 l=5
X765 Vdd a_12205_17226# Vom Vdd sky130_fd_pr__pfet_01v8_lvt ad=0.58 pd=4.58 as=0.58 ps=4.58 w=2 l=1
X766 Vss Vss Vss Vss sky130_fd_pr__nfet_01v8_lvt ad=0.58 pd=4.58 as=0 ps=0 w=2 l=2
X767 Vdd Vdd Vdd Vdd sky130_fd_pr__pfet_01v8_lvt ad=0.145 pd=1.58 as=0 ps=0 w=0.5 l=0.5
X768 Vss Vss Vss Vss sky130_fd_pr__nfet_01v8_lvt ad=0.145 pd=1.58 as=0 ps=0 w=0.5 l=10
X769 Vss Vss Vss Vss sky130_fd_pr__nfet_01v8_lvt ad=0.145 pd=1.58 as=0 ps=0 w=0.5 l=0.5
X770 Vss Vss Vss Vss sky130_fd_pr__nfet_01v8_lvt ad=0.145 pd=1.58 as=0 ps=0 w=0.5 l=0.5
X771 a_20243_24773# a_28673_24473# sky130_fd_pr__res_generic_po w=0.5 l=40
X772 Vdd a_19456_19784# a_12205_21604# Vdd sky130_fd_pr__pfet_01v8_lvt ad=0.29 pd=2.58 as=0.29 ps=2.58 w=1 l=5
X773 Vdd Vdd Vdd Vdd sky130_fd_pr__pfet_01v8_lvt ad=0.29 pd=2.58 as=0 ps=0 w=1 l=1
X774 Vdd Vdd Vdd Vdd sky130_fd_pr__pfet_01v8_lvt ad=0.29 pd=2.58 as=0 ps=0 w=1 l=0.5
X775 a_12205_19546# 2stage_op_amp_1/Diff_opamp_ly_0.Vbias2 a_12906_3858# Vss sky130_fd_pr__nfet_01v8_lvt ad=0.29 pd=2.58 as=0.29 ps=2.58 w=1 l=10
X776 a_12205_21604# a_12179_17284# a_12205_19546# Vdd sky130_fd_pr__pfet_01v8_lvt ad=0.145 pd=1.58 as=0.145 ps=1.58 w=0.5 l=10
X777 Vdd Vdd Vdd Vdd sky130_fd_pr__pfet_01v8_lvt ad=0.145 pd=1.58 as=0 ps=0 w=0.5 l=0.5
X778 a_12205_19284# a_12179_17284# a_12205_17226# Vdd sky130_fd_pr__pfet_01v8_lvt ad=0.145 pd=1.58 as=0.145 ps=1.58 w=0.5 l=10
X779 Vdd Vdd Vdd Vdd sky130_fd_pr__pfet_01v8_lvt ad=0.145 pd=1.58 as=0 ps=0 w=0.5 l=0.5
X780 Vdd Vdd Vdd Vdd sky130_fd_pr__pfet_01v8_lvt ad=0.29 pd=2.58 as=0 ps=0 w=1 l=1
X781 Vss Vss Vss Vss sky130_fd_pr__nfet_01v8_lvt ad=0.145 pd=1.58 as=0 ps=0 w=0.5 l=0.5
X782 a_20243_28223# a_28673_28523# sky130_fd_pr__res_generic_po w=0.5 l=40
X783 Vdd Vdd Vdd Vdd sky130_fd_pr__pfet_01v8_lvt ad=0.145 pd=1.58 as=0 ps=0 w=0.5 l=0.5
X784 Vdd Vdd Vdd Vdd sky130_fd_pr__pfet_01v8_lvt ad=0.145 pd=1.58 as=0 ps=0 w=0.5 l=0.5
X785 Vss Vss Vss Vss sky130_fd_pr__nfet_01v8_lvt ad=0.29 pd=2.58 as=0 ps=0 w=1 l=1
X786 a_12205_17226# 2stage_op_amp_1/Diff_opamp_ly_0.Vbias2 a_12906_6188# Vss sky130_fd_pr__nfet_01v8_lvt ad=0.29 pd=2.58 as=0.29 ps=2.58 w=1 l=10
X787 Vss Vss Vss Vss sky130_fd_pr__nfet_01v8_lvt ad=0.145 pd=1.58 as=0 ps=0 w=0.5 l=0.5
X788 a_19456_19784# a_12205_19546# sky130_fd_pr__cap_mim_m3_1 l=10 w=10
X789 Vdd Vdd Vdd Vdd sky130_fd_pr__pfet_01v8_lvt ad=0.145 pd=1.58 as=0 ps=0 w=0.5 l=10
X790 a_19306_17126# a_19306_17126# Vdd Vdd sky130_fd_pr__pfet_01v8_lvt ad=0.29 pd=2.58 as=0.29 ps=2.58 w=1 l=10
X791 Vdd Vdd Vdd Vdd sky130_fd_pr__pfet_01v8_lvt ad=0.29 pd=2.58 as=0 ps=0 w=1 l=1
X792 a_20243_27773# a_28673_28073# sky130_fd_pr__res_generic_po w=0.5 l=40
X793 a_12205_19284# a_12179_17284# a_12205_17226# Vdd sky130_fd_pr__pfet_01v8_lvt ad=0.145 pd=1.58 as=0.145 ps=1.58 w=0.5 l=10
X794 Vss Vss Vss Vss sky130_fd_pr__nfet_01v8_lvt ad=0.0609 pd=0.71 as=0 ps=0 w=0.42 l=0.15
X795 a_12356_8500# 2stage_op_amp_1/Diff_opamp_ly_0.Vbias2 a_13686_6188# Vss sky130_fd_pr__nfet_01v8_lvt ad=0.29 pd=2.58 as=0.29 ps=2.58 w=1 l=10
X796 Vdd Vdd Vdd Vdd sky130_fd_pr__pfet_01v8_lvt ad=1.45 pd=10.58 as=0 ps=0 w=5 l=2
X797 Vdd Vdd Vdd Vdd sky130_fd_pr__pfet_01v8_lvt ad=0.29 pd=2.58 as=0 ps=0 w=1 l=1
X798 Vdd a_23489_19515# a_23489_19515# Vdd sky130_fd_pr__pfet_01v8_lvt ad=0.29 pd=2.58 as=0.29 ps=2.58 w=1 l=5
X799 Vdd a_19456_19784# a_12205_21604# Vdd sky130_fd_pr__pfet_01v8_lvt ad=0.29 pd=2.58 as=0.29 ps=2.58 w=1 l=5
X800 Vdd a_23489_19515# a_23489_19515# Vdd sky130_fd_pr__pfet_01v8_lvt ad=0.29 pd=2.58 as=0.29 ps=2.58 w=1 l=5
X801 Vdd Vdd Vdd Vdd sky130_fd_pr__pfet_01v8_lvt ad=0.29 pd=2.58 as=0 ps=0 w=1 l=1
X802 Vss Vss Vss Vss sky130_fd_pr__nfet_01v8_lvt ad=0.145 pd=1.58 as=0 ps=0 w=0.5 l=0.5
X803 Vss Vss Vss Vss sky130_fd_pr__nfet_01v8_lvt ad=0.29 pd=2.58 as=0 ps=0 w=1 l=1
X804 a_12906_6188# 2stage_op_amp_1/Diff_opamp_ly_0.nmos_cload_01_1.Vbias1 Vss Vss sky130_fd_pr__nfet_01v8_lvt ad=0.145 pd=1.58 as=0.145 ps=1.58 w=0.5 l=10
X805 Vdd a_2864_12498# a_2864_12498# Vdd sky130_fd_pr__pfet_01v8_lvt ad=1.45 pd=10.58 as=1.45 ps=10.58 w=5 l=2
X806 a_19306_17126# a_12205_19546# a_14206_6188# Vss sky130_fd_pr__nfet_01v8_lvt ad=0.145 pd=1.58 as=0.145 ps=1.58 w=0.5 l=10
X807 Vss Vss Vss Vss sky130_fd_pr__nfet_01v8_lvt ad=0.145 pd=1.58 as=0 ps=0 w=0.5 l=10
X808 a_19456_19784# Vref a_14206_3858# Vss sky130_fd_pr__nfet_01v8_lvt ad=0.145 pd=1.58 as=0.145 ps=1.58 w=0.5 l=10
X809 Vdd 2stage_op_amp_1/bias_dummy_0.PBias a_2465_13713# Vdd sky130_fd_pr__pfet_01v8_lvt ad=1.45 pd=10.58 as=1.45 ps=10.58 w=5 l=2
X810 Vdd a_23489_19515# a_23489_19515# Vdd sky130_fd_pr__pfet_01v8_lvt ad=0.29 pd=2.58 as=0.29 ps=2.58 w=1 l=5
X811 a_12205_19546# 2stage_op_amp_1/Diff_opamp_ly_0.Vbias2 a_12906_3858# Vss sky130_fd_pr__nfet_01v8_lvt ad=0.29 pd=2.58 as=0.29 ps=2.58 w=1 l=10
X812 Vss Vss Vss Vss sky130_fd_pr__nfet_01v8_lvt ad=0.1218 pd=1.42 as=0 ps=0 w=0.42 l=0.15
X813 Vss Vss Vss Vss sky130_fd_pr__nfet_01v8_lvt ad=0.174 pd=1.78 as=0 ps=0 w=0.6 l=1
X814 Vss Vss Vss Vss sky130_fd_pr__nfet_01v8_lvt ad=0.29 pd=2.58 as=0 ps=0 w=1 l=1
X815 Vdd Vdd sky130_fd_pr__cap_mim_m3_1 l=2 w=10
X816 a_12179_17284# 2stage_op_amp_1/Diff_opamp_ly_0.Vbias3 Vss Vss sky130_fd_pr__nfet_01v8_lvt ad=0.174 pd=1.78 as=0.174 ps=1.78 w=0.6 l=1
X817 Vdd Vdd Vdd Vdd sky130_fd_pr__pfet_01v8_lvt ad=0.58 pd=4.58 as=0 ps=0 w=2 l=1
X818 a_20243_25223# a_28673_24923# sky130_fd_pr__res_generic_po w=0.5 l=40
X819 Vdd Vdd Vdd Vdd sky130_fd_pr__pfet_01v8_lvt ad=0.58 pd=4.58 as=0 ps=0 w=2 l=2
X820 a_12205_19284# Vm a_12356_8500# Vss sky130_fd_pr__nfet_01v8_lvt ad=0.58 pd=4.58 as=0.58 ps=4.58 w=2 l=10
X821 Vdd Vdd sky130_fd_pr__cap_mim_m3_1 l=10 w=2
X822 Vdd a_23489_19515# a_23489_19515# Vdd sky130_fd_pr__pfet_01v8_lvt ad=0.29 pd=2.58 as=0.29 ps=2.58 w=1 l=5
X823 Vdd a_23489_19515# a_23489_19515# Vdd sky130_fd_pr__pfet_01v8_lvt ad=0.29 pd=2.58 as=0.29 ps=2.58 w=1 l=5
X824 a_23130_13378# Vom sky130_fd_pr__cap_mim_m3_1 l=10 w=10
X825 a_19456_19784# Vref a_14206_6188# Vss sky130_fd_pr__nfet_01v8_lvt ad=0.145 pd=1.58 as=0.145 ps=1.58 w=0.5 l=10
X826 Vdd Vdd Vdd Vdd sky130_fd_pr__pfet_01v8_lvt ad=0.29 pd=2.58 as=0 ps=0 w=1 l=0.5
X827 Vss Vss Vss Vss sky130_fd_pr__nfet_01v8_lvt ad=0.145 pd=1.58 as=0 ps=0 w=0.5 l=0.5
X828 Vdd Vdd Vdd Vdd sky130_fd_pr__pfet_01v8_lvt ad=0.145 pd=1.58 as=0 ps=0 w=0.5 l=0.5
X829 a_2465_13713# a_2465_13713# Vss Vss sky130_fd_pr__nfet_01v8_lvt ad=1.45 pd=10.58 as=1.45 ps=10.58 w=5 l=2
X830 Vss Vss Vss Vss sky130_fd_pr__nfet_01v8_lvt ad=0.174 pd=1.78 as=0 ps=0 w=0.6 l=1
X831 Vdd Vdd Vdd Vdd sky130_fd_pr__pfet_01v8_lvt ad=0.29 pd=2.58 as=0 ps=0 w=1 l=5
X832 a_19306_17126# a_12205_17226# a_14206_3858# Vss sky130_fd_pr__nfet_01v8_lvt ad=0.145 pd=1.58 as=0.145 ps=1.58 w=0.5 l=10
X833 Vss Vss Vss Vss sky130_fd_pr__nfet_01v8_lvt ad=0.29 pd=2.58 as=0 ps=0 w=1 l=1
X834 Vdd Vdd sky130_fd_pr__cap_mim_m3_1 l=2 w=2
X835 Vdd a_23489_19515# a_23489_19515# Vdd sky130_fd_pr__pfet_01v8_lvt ad=0.29 pd=2.58 as=0.29 ps=2.58 w=1 l=5
X836 a_12205_21604# a_12330_8558# a_12356_8500# Vss sky130_fd_pr__nfet_01v8_lvt ad=0.58 pd=4.58 as=0.58 ps=4.58 w=2 l=10
X837 Vdd a_19456_19784# a_12205_19284# Vdd sky130_fd_pr__pfet_01v8_lvt ad=0.29 pd=2.58 as=0.29 ps=2.58 w=1 l=5
X838 Vdd a_12179_17284# a_12179_17284# Vdd sky130_fd_pr__pfet_01v8_lvt ad=0.145 pd=1.58 as=0.145 ps=1.58 w=0.5 l=10
X839 Vdd Vdd Vdd Vdd sky130_fd_pr__pfet_01v8_lvt ad=0.145 pd=1.58 as=0 ps=0 w=0.5 l=0.5
X840 a_12205_19546# a_n347_21647# sky130_fd_pr__cap_mim_m3_1 l=10 w=10
X841 Vss Vss Vss Vss sky130_fd_pr__nfet_01v8_lvt ad=0.58 pd=4.58 as=0 ps=0 w=2 l=2
X842 Vdd Vdd Vdd Vdd sky130_fd_pr__pfet_01v8_lvt ad=0.145 pd=1.58 as=0 ps=0 w=0.5 l=0.5
X843 a_12205_19546# 2stage_op_amp_1/Diff_opamp_ly_0.Vbias2 a_12906_3858# Vss sky130_fd_pr__nfet_01v8_lvt ad=0.29 pd=2.58 as=0.29 ps=2.58 w=1 l=10
X844 a_1785_12473# a_1785_12473# 2stage_op_amp_1/switchblock_1.beta Vss sky130_fd_pr__nfet_01v8_lvt ad=1.45 pd=10.58 as=1.45 ps=10.58 w=5 l=2
X845 2stage_op_amp_1/bias_dummy_0.Vbias3 en_1 2stage_op_amp_1/Diff_opamp_ly_0.Vbias3 Vss sky130_fd_pr__nfet_01v8_lvt ad=0.29 pd=2.58 as=0.29 ps=2.58 w=1 l=0.15
X846 Vss Vss sky130_fd_pr__cap_mim_m3_1 l=2 w=2
X847 Vdd Vdd sky130_fd_pr__cap_mim_m3_1 l=2 w=10
X848 Vdd Vdd Vdd Vdd sky130_fd_pr__pfet_01v8_lvt ad=0.145 pd=1.58 as=0 ps=0 w=0.5 l=0.5
X849 Vdd Vdd Vdd Vdd sky130_fd_pr__pfet_01v8_lvt ad=0.145 pd=1.58 as=0 ps=0 w=0.5 l=0.5
X850 a_19456_19784# Vref a_14206_6188# Vss sky130_fd_pr__nfet_01v8_lvt ad=0.145 pd=1.58 as=0.145 ps=1.58 w=0.5 l=10
X851 Vss Vss Vss Vss sky130_fd_pr__nfet_01v8_lvt ad=0.174 pd=1.78 as=0 ps=0 w=0.6 l=1
X852 Vss Vss sky130_fd_pr__cap_mim_m3_1 l=10 w=2
X853 2stage_op_amp_1/Diff_opamp_ly_0.nmos_cload_01_1.Vbias1 2stage_op_amp_1/Diff_opamp_ly_0.nmos_cload_01_1.Vbias1 Vss Vss sky130_fd_pr__nfet_01v8_lvt ad=0.145 pd=1.58 as=0.145 ps=1.58 w=0.5 l=10
X854 a_20243_28823# a_28673_28523# sky130_fd_pr__res_generic_po w=0.5 l=40
X855 Vdd a_2864_12498# a_2864_12498# Vdd sky130_fd_pr__pfet_01v8_lvt ad=1.45 pd=10.58 as=1.45 ps=10.58 w=5 l=2
X856 a_12205_21604# a_12179_17284# a_12205_19546# Vdd sky130_fd_pr__pfet_01v8_lvt ad=0.145 pd=1.58 as=0.145 ps=1.58 w=0.5 l=10
X857 a_27034_13564# a_28046_17426# a_26999_20995# Vdd sky130_fd_pr__pfet_01v8_lvt ad=0.145 pd=1.58 as=0.145 ps=1.58 w=0.5 l=10
X858 Vss Vss Vss Vss sky130_fd_pr__nfet_01v8_lvt ad=0.29 pd=2.58 as=0 ps=0 w=1 l=1
X859 a_12205_19284# a_12179_17284# a_12205_17226# Vdd sky130_fd_pr__pfet_01v8_lvt ad=0.145 pd=1.58 as=0.145 ps=1.58 w=0.5 l=10
X860 Vdd Vdd Vdd Vdd sky130_fd_pr__pfet_01v8_lvt ad=0.29 pd=2.58 as=0 ps=0 w=1 l=1
X861 Vdd Vdd Vdd Vdd sky130_fd_pr__pfet_01v8_lvt ad=0.29 pd=2.58 as=0 ps=0 w=1 l=0.5
X862 Vdd Vdd Vdd Vdd sky130_fd_pr__pfet_01v8_lvt ad=1.45 pd=10.58 as=0 ps=0 w=5 l=2
X863 Vdd a_23489_19515# a_23489_19515# Vdd sky130_fd_pr__pfet_01v8_lvt ad=0.29 pd=2.58 as=0.29 ps=2.58 w=1 l=5
X864 2stage_op_amp_1/Diff_opamp_ly_0.nmos_cload_01_1.Vbias1 2stage_op_amp_1/Diff_opamp_ly_0.nmos_cload_01_1.Vbias1 Vss Vss sky130_fd_pr__nfet_01v8_lvt ad=0.145 pd=1.58 as=0.145 ps=1.58 w=0.5 l=10
X865 Vdd a_12205_17226# Vom Vdd sky130_fd_pr__pfet_01v8_lvt ad=0.58 pd=4.58 as=0.58 ps=4.58 w=2 l=1
X866 a_19456_19784# Vref a_14206_6188# Vss sky130_fd_pr__nfet_01v8_lvt ad=0.145 pd=1.58 as=0.145 ps=1.58 w=0.5 l=10
X867 a_20243_28373# a_28673_28073# sky130_fd_pr__res_generic_po w=0.5 l=40
X868 Vdd Vdd Vdd Vdd sky130_fd_pr__pfet_01v8_lvt ad=0.58 pd=4.58 as=0 ps=0 w=2 l=1
X869 Vss Vss Vss Vss sky130_fd_pr__nfet_01v8_lvt ad=0.145 pd=1.58 as=0 ps=0 w=0.5 l=0.5
X870 a_12205_19546# a_n347_21647# sky130_fd_pr__cap_mim_m3_1 l=10 w=10
X871 Vdd Vdd sky130_fd_pr__cap_mim_m3_1 l=2 w=10
X872 a_19456_19784# Vref a_14206_3858# Vss sky130_fd_pr__nfet_01v8_lvt ad=0.145 pd=1.58 as=0.145 ps=1.58 w=0.5 l=10
X873 a_12205_19546# 2stage_op_amp_1/Diff_opamp_ly_0.Vbias2 a_12906_3858# Vss sky130_fd_pr__nfet_01v8_lvt ad=0.29 pd=2.58 as=0.29 ps=2.58 w=1 l=10
X874 Vss Vss Vss Vss sky130_fd_pr__nfet_01v8_lvt ad=0.58 pd=4.58 as=0 ps=0 w=2 l=2
X875 Vss Vss Vss Vss sky130_fd_pr__nfet_01v8_lvt ad=0.29 pd=2.58 as=0 ps=0 w=1 l=1
X876 a_n205_21647# a_n489_13217# sky130_fd_pr__res_generic_po w=0.5 l=40
X877 Vss Vss Vss Vss sky130_fd_pr__nfet_01v8_lvt ad=0.58 pd=4.58 as=0 ps=0 w=2 l=2
X878 Vdd a_2864_12498# a_2864_12498# Vdd sky130_fd_pr__pfet_01v8_lvt ad=1.45 pd=10.58 as=1.45 ps=10.58 w=5 l=2
X879 Vss Vss sky130_fd_pr__cap_mim_m3_1 l=2 w=10
X880 Vdd Vdd Vdd Vdd sky130_fd_pr__pfet_01v8_lvt ad=0.58 pd=4.58 as=0 ps=0 w=2 l=1
X881 a_23130_13378# Vop sky130_fd_pr__cap_mim_m3_1 l=10 w=10
X882 a_12205_19546# 2stage_op_amp_1/Diff_opamp_ly_0.Vbias2 a_12906_3858# Vss sky130_fd_pr__nfet_01v8_lvt ad=0.29 pd=2.58 as=0.29 ps=2.58 w=1 l=10
X883 Vss Vss Vss Vss sky130_fd_pr__nfet_01v8_lvt ad=0.29 pd=2.58 as=0 ps=0 w=1 l=1
X884 a_19456_19784# Vref a_14206_3858# Vss sky130_fd_pr__nfet_01v8_lvt ad=0.145 pd=1.58 as=0.145 ps=1.58 w=0.5 l=10
X885 Vss Vss sky130_fd_pr__cap_mim_m3_1 l=10 w=2
X886 Vdd Vdd Vdd Vdd sky130_fd_pr__pfet_01v8_lvt ad=0.29 pd=2.58 as=0 ps=0 w=1 l=1
X887 a_19456_19784# a_12205_19546# sky130_fd_pr__cap_mim_m3_1 l=10 w=10
X888 a_20243_25223# a_28673_25523# sky130_fd_pr__res_generic_po w=0.5 l=40
X889 Vdd a_19456_19784# a_12205_21604# Vdd sky130_fd_pr__pfet_01v8_lvt ad=0.29 pd=2.58 as=0.29 ps=2.58 w=1 l=5
X890 Vdd a_23489_19515# a_23489_19515# Vdd sky130_fd_pr__pfet_01v8_lvt ad=0.29 pd=2.58 as=0.29 ps=2.58 w=1 l=5
X891 Vss Vss Vss Vss sky130_fd_pr__nfet_01v8_lvt ad=0.29 pd=2.58 as=0 ps=0 w=1 l=1
X892 Vdd Vdd Vdd Vdd sky130_fd_pr__pfet_01v8_lvt ad=0.58 pd=4.58 as=0 ps=0 w=2 l=2
X893 a_20243_24773# a_28673_25073# sky130_fd_pr__res_generic_po w=0.5 l=40
X894 a_19306_17126# a_12205_17226# a_14206_3858# Vss sky130_fd_pr__nfet_01v8_lvt ad=0.145 pd=1.58 as=0.145 ps=1.58 w=0.5 l=10
X895 a_19456_19784# Vref a_14206_6188# Vss sky130_fd_pr__nfet_01v8_lvt ad=0.145 pd=1.58 as=0.145 ps=1.58 w=0.5 l=10
X896 Vss Vss Vss Vss sky130_fd_pr__nfet_01v8_lvt ad=0.145 pd=1.58 as=0 ps=0 w=0.5 l=0.5
X897 Vdd a_23489_19515# a_23489_19515# Vdd sky130_fd_pr__pfet_01v8_lvt ad=0.29 pd=2.58 as=0.29 ps=2.58 w=1 l=5
X898 Vdd a_12205_19546# Vop Vdd sky130_fd_pr__pfet_01v8_lvt ad=0.58 pd=4.58 as=0.58 ps=4.58 w=2 l=1
X899 a_23130_13378# Vref a_26999_20995# Vdd sky130_fd_pr__pfet_01v8_lvt ad=0.145 pd=1.58 as=0.145 ps=1.58 w=0.5 l=10
X900 Vdd Vdd Vdd Vdd sky130_fd_pr__pfet_01v8_lvt ad=0.29 pd=2.58 as=0 ps=0 w=1 l=1
X901 a_12205_19284# Vm a_12356_8500# Vss sky130_fd_pr__nfet_01v8_lvt ad=0.58 pd=4.58 as=0.58 ps=4.58 w=2 l=10
X902 a_12205_19546# 2stage_op_amp_1/Diff_opamp_ly_0.Vbias2 a_12906_3858# Vss sky130_fd_pr__nfet_01v8_lvt ad=0.29 pd=2.58 as=0.29 ps=2.58 w=1 l=10
X903 Vss Vss Vss Vss sky130_fd_pr__nfet_01v8_lvt ad=0.145 pd=1.58 as=0 ps=0 w=0.5 l=0.5
X904 a_12205_17226# a_n205_21647# sky130_fd_pr__cap_mim_m3_1 l=10 w=10
X905 Vss Vss Vss Vss sky130_fd_pr__nfet_01v8_lvt ad=0.174 pd=1.78 as=0 ps=0 w=0.6 l=1
X906 Vss Vss Vss Vss sky130_fd_pr__nfet_01v8_lvt ad=0.145 pd=1.58 as=0 ps=0 w=0.5 l=0.5
X907 Vdd a_12179_17284# a_12179_17284# Vdd sky130_fd_pr__pfet_01v8_lvt ad=0.145 pd=1.58 as=0.145 ps=1.58 w=0.5 l=10
X908 Vdd Vdd Vdd Vdd sky130_fd_pr__pfet_01v8_lvt ad=0.145 pd=1.58 as=0 ps=0 w=0.5 l=0.5
X909 Vdd Vdd Vdd Vdd sky130_fd_pr__pfet_01v8_lvt ad=0.145 pd=1.58 as=0 ps=0 w=0.5 l=0.5
X910 Vss Vss Vss Vss sky130_fd_pr__nfet_01v8_lvt ad=0.174 pd=1.78 as=0 ps=0 w=0.6 l=1
X911 a_19456_19784# Vref a_14206_3858# Vss sky130_fd_pr__nfet_01v8_lvt ad=0.145 pd=1.58 as=0.145 ps=1.58 w=0.5 l=10
X912 Vss Vss Vss Vss sky130_fd_pr__nfet_01v8_lvt ad=0.29 pd=2.58 as=0 ps=0 w=1 l=1
X913 a_12906_3858# 2stage_op_amp_1/Diff_opamp_ly_0.nmos_cload_01_1.Vbias1 Vss Vss sky130_fd_pr__nfet_01v8_lvt ad=0.145 pd=1.58 as=0.145 ps=1.58 w=0.5 l=10
X914 Vdd Vdd Vdd Vdd sky130_fd_pr__pfet_01v8_lvt ad=0.145 pd=1.58 as=0 ps=0 w=0.5 l=0.5
X915 Vss Vss Vss Vss sky130_fd_pr__nfet_01v8_lvt ad=0.29 pd=2.58 as=0 ps=0 w=1 l=1
X916 Vdd Vdd Vdd Vdd sky130_fd_pr__pfet_01v8_lvt ad=0.29 pd=2.58 as=0 ps=0 w=1 l=5
X917 a_1506_10826# en_1 Vss Vss sky130_fd_pr__nfet_01v8_lvt ad=0.725 pd=5.29 as=0.725 ps=5.29 w=5 l=0.15
X918 a_12205_19284# a_12179_17284# a_12205_17226# Vdd sky130_fd_pr__pfet_01v8_lvt ad=0.145 pd=1.58 as=0.145 ps=1.58 w=0.5 l=10
X919 a_12205_21604# a_12179_17284# a_12205_19546# Vdd sky130_fd_pr__pfet_01v8_lvt ad=0.145 pd=1.58 as=0.145 ps=1.58 w=0.5 l=10
X920 Vss Vss Vss Vss sky130_fd_pr__nfet_01v8_lvt ad=0.29 pd=2.58 as=0 ps=0 w=1 l=1
X921 a_12906_3858# 2stage_op_amp_1/Diff_opamp_ly_0.nmos_cload_01_1.Vbias1 Vss Vss sky130_fd_pr__nfet_01v8_lvt ad=0.145 pd=1.58 as=0.145 ps=1.58 w=0.5 l=10
X922 Vdd Vdd Vdd Vdd sky130_fd_pr__pfet_01v8_lvt ad=0.145 pd=1.58 as=0 ps=0 w=0.5 l=0.5
X923 Vdd 2stage_op_amp_1/bias_dummy_0.PBias 2stage_op_amp_1/bias_dummy_0.Vbias4 Vdd sky130_fd_pr__pfet_01v8_lvt ad=1.45 pd=10.58 as=1.45 ps=10.58 w=5 l=2
X924 a_19456_19784# Vref a_14206_3858# Vss sky130_fd_pr__nfet_01v8_lvt ad=0.145 pd=1.58 as=0.145 ps=1.58 w=0.5 l=10
X925 Vdd a_2864_12498# a_2864_12498# Vdd sky130_fd_pr__pfet_01v8_lvt ad=1.45 pd=10.58 as=1.45 ps=10.58 w=5 l=2
X926 Vdd a_23489_19515# a_23489_19515# Vdd sky130_fd_pr__pfet_01v8_lvt ad=0.29 pd=2.58 as=0.29 ps=2.58 w=1 l=5
X927 a_12205_17226# 2stage_op_amp_1/Diff_opamp_ly_0.Vbias2 a_12906_6188# Vss sky130_fd_pr__nfet_01v8_lvt ad=0.29 pd=2.58 as=0.29 ps=2.58 w=1 l=10
X928 2stage_op_amp_1/Diff_opamp_ly_0.Vbias3 2stage_op_amp_1/Diff_opamp_ly_0.Vbias3 Vss Vss sky130_fd_pr__nfet_01v8_lvt ad=0.174 pd=1.78 as=0.174 ps=1.78 w=0.6 l=1
X929 a_20243_28373# a_28673_28673# sky130_fd_pr__res_generic_po w=0.5 l=40
X930 Vdd Vdd Vdd Vdd sky130_fd_pr__pfet_01v8_lvt ad=0.29 pd=2.58 as=0 ps=0 w=1 l=0.5
X931 Vss Vss Vss Vss sky130_fd_pr__nfet_01v8_lvt ad=1.45 pd=10.58 as=0 ps=0 w=5 l=0.15
X932 Vdd a_23489_19515# a_23489_19515# Vdd sky130_fd_pr__pfet_01v8_lvt ad=0.29 pd=2.58 as=0.29 ps=2.58 w=1 l=5
X933 a_19456_19784# a_12205_17226# sky130_fd_pr__cap_mim_m3_1 l=10 w=10
X934 Vss a_3062_9246# a_3062_9246# Vss sky130_fd_pr__nfet_01v8_lvt ad=0.174 pd=1.78 as=0.174 ps=1.78 w=0.6 l=1
X935 a_12205_19546# 2stage_op_amp_1/Diff_opamp_ly_0.Vbias2 a_12906_3858# Vss sky130_fd_pr__nfet_01v8_lvt ad=0.29 pd=2.58 as=0.29 ps=2.58 w=1 l=10
X936 Vdd Vdd Vdd Vdd sky130_fd_pr__pfet_01v8_lvt ad=1.45 pd=10.58 as=0 ps=0 w=5 l=2
X937 Vss Vss Vss Vss sky130_fd_pr__nfet_01v8_lvt ad=0.145 pd=1.58 as=0 ps=0 w=0.5 l=0.5
X938 a_19456_19784# Vref a_14206_6188# Vss sky130_fd_pr__nfet_01v8_lvt ad=0.145 pd=1.58 as=0.145 ps=1.58 w=0.5 l=10
X939 Vss Vss Vss Vss sky130_fd_pr__nfet_01v8_lvt ad=0.58 pd=4.58 as=0 ps=0 w=2 l=1
X940 Vss Vss Vss Vss sky130_fd_pr__nfet_01v8_lvt ad=0.145 pd=1.58 as=0 ps=0 w=0.5 l=0.5
X941 Vdd Vdd Vdd Vdd sky130_fd_pr__pfet_01v8_lvt ad=0.29 pd=2.58 as=0 ps=0 w=1 l=1
X942 Vdd Vdd Vdd Vdd sky130_fd_pr__pfet_01v8_lvt ad=0.29 pd=2.58 as=0 ps=0 w=1 l=1
X943 Vss Vss sky130_fd_pr__cap_mim_m3_1 l=2 w=10
X944 Vss Vss Vss Vss sky130_fd_pr__nfet_01v8_lvt ad=0.29 pd=2.58 as=0 ps=0 w=1 l=1
X945 Vss Vss Vss Vss sky130_fd_pr__nfet_01v8_lvt ad=0.58 pd=4.58 as=0 ps=0 w=2 l=1
X946 a_20243_25823# a_28673_25523# sky130_fd_pr__res_generic_po w=0.5 l=40
X947 a_12356_8500# 2stage_op_amp_1/Diff_opamp_ly_0.Vbias2 a_13686_6188# Vss sky130_fd_pr__nfet_01v8_lvt ad=0.29 pd=2.58 as=0.29 ps=2.58 w=1 l=10
X948 Vss Vss Vss Vss sky130_fd_pr__nfet_01v8_lvt ad=0.29 pd=2.58 as=0 ps=0 w=1 l=1
X949 Vdd a_23489_19515# a_23489_19515# Vdd sky130_fd_pr__pfet_01v8_lvt ad=0.29 pd=2.58 as=0.29 ps=2.58 w=1 l=5
X950 2stage_op_amp_1/bias_dummy_0.Vbias4 en_1 2stage_op_amp_1/Diff_opamp_ly_0.nmos_cload_01_1.Vbias1 Vss sky130_fd_pr__nfet_01v8_lvt ad=0.29 pd=2.58 as=0.29 ps=2.58 w=1 l=0.15
X951 a_12205_17226# 2stage_op_amp_1/Diff_opamp_ly_0.Vbias2 a_12906_6188# Vss sky130_fd_pr__nfet_01v8_lvt ad=0.29 pd=2.58 as=0.29 ps=2.58 w=1 l=10
X952 a_1785_12473# a_1785_12473# 2stage_op_amp_1/switchblock_1.beta Vss sky130_fd_pr__nfet_01v8_lvt ad=1.45 pd=10.58 as=1.45 ps=10.58 w=5 l=2
X953 a_1785_12473# a_1785_12473# 2stage_op_amp_1/switchblock_1.beta Vss sky130_fd_pr__nfet_01v8_lvt ad=1.45 pd=10.58 as=1.45 ps=10.58 w=5 l=2
X954 Vss Vss Vss Vss sky130_fd_pr__nfet_01v8_lvt ad=0.29 pd=2.58 as=0 ps=0 w=1 l=1
X955 Vss Vss sky130_fd_pr__cap_mim_m3_1 l=10 w=2
X956 Vdd 2stage_op_amp_1/bias_dummy_0.PBias 2stage_op_amp_1/bias_dummy_0.Vbias4 Vdd sky130_fd_pr__pfet_01v8_lvt ad=1.45 pd=10.58 as=1.45 ps=10.58 w=5 l=2
X957 Vss Vss Vss Vss sky130_fd_pr__nfet_01v8_lvt ad=0.174 pd=1.78 as=0 ps=0 w=0.6 l=1
X958 a_20243_25373# a_28673_25073# sky130_fd_pr__res_generic_po w=0.5 l=40
X959 a_1532_20622# a_1332_19196# Vdd Vdd sky130_fd_pr__pfet_01v8_lvt ad=1.45 pd=10.58 as=1.45 ps=10.58 w=5 l=1
X960 Vss Vss Vss Vss sky130_fd_pr__nfet_01v8_lvt ad=0.58 pd=4.58 as=0 ps=0 w=2 l=1
X961 Vdd Vdd sky130_fd_pr__cap_mim_m3_1 l=2 w=10
X962 Vss Vss Vss Vss sky130_fd_pr__nfet_01v8_lvt ad=0.29 pd=2.58 as=0 ps=0 w=1 l=1
X963 a_12906_3858# 2stage_op_amp_1/Diff_opamp_ly_0.nmos_cload_01_1.Vbias1 Vss Vss sky130_fd_pr__nfet_01v8_lvt ad=0.145 pd=1.58 as=0.145 ps=1.58 w=0.5 l=10
X964 Vdd Vdd Vdd Vdd sky130_fd_pr__pfet_01v8_lvt ad=0.29 pd=2.58 as=0 ps=0 w=1 l=5
X965 a_20243_28823# Vop sky130_fd_pr__res_generic_po w=0.5 l=40
X966 a_n915_21647# a_n631_13217# sky130_fd_pr__res_generic_po w=0.5 l=40
X967 a_12205_19284# a_12179_17284# a_12205_17226# Vdd sky130_fd_pr__pfet_01v8_lvt ad=0.145 pd=1.58 as=0.145 ps=1.58 w=0.5 l=10
X968 Vdd a_23489_19515# a_23489_19515# Vdd sky130_fd_pr__pfet_01v8_lvt ad=0.29 pd=2.58 as=0.29 ps=2.58 w=1 l=5
X969 Vdd Vdd Vdd Vdd sky130_fd_pr__pfet_01v8_lvt ad=0.58 pd=4.58 as=0 ps=0 w=2 l=2
X970 Vss Vss Vss Vss sky130_fd_pr__nfet_01v8_lvt ad=0.145 pd=1.58 as=0 ps=0 w=0.5 l=20
X971 Vss Vss sky130_fd_pr__cap_mim_m3_1 l=10 w=2
X972 a_12205_19546# 2stage_op_amp_1/Diff_opamp_ly_0.Vbias2 a_12906_3858# Vss sky130_fd_pr__nfet_01v8_lvt ad=0.29 pd=2.58 as=0.29 ps=2.58 w=1 l=10
X973 a_12205_21604# a_12179_17284# a_12205_19546# Vdd sky130_fd_pr__pfet_01v8_lvt ad=0.145 pd=1.58 as=0.145 ps=1.58 w=0.5 l=10
X974 Vdd Vdd Vdd Vdd sky130_fd_pr__pfet_01v8_lvt ad=0.145 pd=1.58 as=0 ps=0 w=0.5 l=0.5
X975 Vss Vss Vss Vss sky130_fd_pr__nfet_01v8_lvt ad=0.174 pd=1.78 as=0 ps=0 w=0.6 l=1
X976 2stage_op_amp_1/Diff_opamp_ly_0.nmos_cload_01_1.Vbias1 2stage_op_amp_1/Diff_opamp_ly_0.nmos_cload_01_1.Vbias1 Vss Vss sky130_fd_pr__nfet_01v8_lvt ad=0.145 pd=1.58 as=0.145 ps=1.58 w=0.5 l=10
X977 Vss Vss sky130_fd_pr__cap_mim_m3_1 l=2 w=2
X978 Vss Vss sky130_fd_pr__cap_mim_m3_1 l=10 w=2
X979 a_19456_19784# Vref a_14206_6188# Vss sky130_fd_pr__nfet_01v8_lvt ad=0.145 pd=1.58 as=0.145 ps=1.58 w=0.5 l=10
X980 Vss Vss Vss Vss sky130_fd_pr__nfet_01v8_lvt ad=0.145 pd=1.58 as=0 ps=0 w=0.5 l=0.5
X981 Vdd Vdd Vdd Vdd sky130_fd_pr__pfet_01v8_lvt ad=0.145 pd=1.58 as=0 ps=0 w=0.5 l=0.5
X982 a_12205_19284# Vm a_12356_8500# Vss sky130_fd_pr__nfet_01v8_lvt ad=0.58 pd=4.58 as=0.58 ps=4.58 w=2 l=10
X983 Vss Vss Vss Vss sky130_fd_pr__nfet_01v8_lvt ad=0.58 pd=4.58 as=0 ps=0 w=2 l=1
X984 Vss Vss sky130_fd_pr__cap_mim_m3_1 l=2 w=2
X985 2stage_op_amp_1/Diff_opamp_ly_0.nmos_cload_01_1.Vbias1 2stage_op_amp_1/Diff_opamp_ly_0.nmos_cload_01_1.Vbias1 Vss Vss sky130_fd_pr__nfet_01v8_lvt ad=0.145 pd=1.58 as=0.145 ps=1.58 w=0.5 l=10
X986 Vdd a_23489_19515# a_23489_19515# Vdd sky130_fd_pr__pfet_01v8_lvt ad=0.29 pd=2.58 as=0.29 ps=2.58 w=1 l=5
X987 Vss Vss Vss Vss sky130_fd_pr__nfet_01v8_lvt ad=0.1218 pd=1.42 as=0 ps=0 w=0.42 l=0.15
X988 Vss Vss Vss Vss sky130_fd_pr__nfet_01v8_lvt ad=0.145 pd=1.58 as=0 ps=0 w=0.5 l=0.5
X989 Vdd Vdd sky130_fd_pr__cap_mim_m3_1 l=2 w=10
X990 Vss Vss sky130_fd_pr__cap_mim_m3_1 l=2 w=10
X991 Vss Vss sky130_fd_pr__cap_mim_m3_1 l=10 w=2
X992 Vdd a_12179_17284# a_12179_17284# Vdd sky130_fd_pr__pfet_01v8_lvt ad=0.145 pd=1.58 as=0.145 ps=1.58 w=0.5 l=10
X993 Vdd a_23489_19515# a_23489_19515# Vdd sky130_fd_pr__pfet_01v8_lvt ad=0.29 pd=2.58 as=0.29 ps=2.58 w=1 l=5
X994 Vss Vss Vss Vss sky130_fd_pr__nfet_01v8_lvt ad=1.45 pd=10.58 as=0 ps=0 w=5 l=0.15
X995 a_19456_19784# Vref a_14206_6188# Vss sky130_fd_pr__nfet_01v8_lvt ad=0.145 pd=1.58 as=0.145 ps=1.58 w=0.5 l=10
X996 a_12356_8500# 2stage_op_amp_1/Diff_opamp_ly_0.Vbias2 a_13686_3858# Vss sky130_fd_pr__nfet_01v8_lvt ad=0.29 pd=2.58 as=0.29 ps=2.58 w=1 l=10
X997 2stage_op_amp_1/Diff_opamp_ly_0.nmos_cload_01_1.Vbias1 2stage_op_amp_1/Diff_opamp_ly_0.nmos_cload_01_1.Vbias1 Vss Vss sky130_fd_pr__nfet_01v8_lvt ad=0.145 pd=1.58 as=0.145 ps=1.58 w=0.5 l=10
X998 a_n915_21647# a_n1199_13217# sky130_fd_pr__res_generic_po w=0.5 l=40
X999 a_1332_19196# a_1332_19196# Vdd Vdd sky130_fd_pr__pfet_01v8_lvt ad=1.45 pd=10.58 as=1.45 ps=10.58 w=5 l=1
X1000 Vdd Vdd Vdd Vdd sky130_fd_pr__pfet_01v8_lvt ad=0.29 pd=2.58 as=0 ps=0 w=1 l=1
X1001 Vss Vss sky130_fd_pr__cap_mim_m3_1 l=2 w=10
X1002 a_12356_8500# 2stage_op_amp_1/Diff_opamp_ly_0.Vbias2 a_13686_6188# Vss sky130_fd_pr__nfet_01v8_lvt ad=0.29 pd=2.58 as=0.29 ps=2.58 w=1 l=10
X1003 Vdd Vdd Vdd Vdd sky130_fd_pr__pfet_01v8_lvt ad=0.29 pd=2.58 as=0 ps=0 w=1 l=1
X1004 Vss Vss Vss Vss sky130_fd_pr__nfet_01v8_lvt ad=0.58 pd=4.58 as=0 ps=0 w=2 l=2
X1005 2stage_op_amp_1/bias_dummy_0.Vbias1 en_1 a_3062_9246# Vss sky130_fd_pr__nfet_01v8_lvt ad=0.29 pd=2.58 as=0.29 ps=2.58 w=1 l=0.15
X1006 Vss Vss Vss Vss sky130_fd_pr__nfet_01v8_lvt ad=0.58 pd=4.58 as=0 ps=0 w=2 l=1
X1007 Vss Vss Vss Vss sky130_fd_pr__nfet_01v8_lvt ad=0.145 pd=1.58 as=0 ps=0 w=0.5 l=10
X1008 Vdd a_19456_19784# a_12205_19284# Vdd sky130_fd_pr__pfet_01v8_lvt ad=0.29 pd=2.58 as=0.29 ps=2.58 w=1 l=5
X1009 Vdd Vdd Vdd Vdd sky130_fd_pr__pfet_01v8_lvt ad=0.58 pd=4.58 as=0 ps=0 w=2 l=1
X1010 a_19456_19784# Vref a_14206_3858# Vss sky130_fd_pr__nfet_01v8_lvt ad=0.145 pd=1.58 as=0.145 ps=1.58 w=0.5 l=10
X1011 Vdd Vdd Vdd Vdd sky130_fd_pr__pfet_01v8_lvt ad=0.29 pd=2.58 as=0 ps=0 w=1 l=0.5
X1012 a_23130_13378# Vop sky130_fd_pr__cap_mim_m3_1 l=10 w=10
X1013 Vss Vss Vss Vss sky130_fd_pr__nfet_01v8_lvt ad=0.29 pd=2.58 as=0 ps=0 w=1 l=1
X1014 a_12205_17226# 2stage_op_amp_1/Diff_opamp_ly_0.Vbias2 a_12906_6188# Vss sky130_fd_pr__nfet_01v8_lvt ad=0.29 pd=2.58 as=0.29 ps=2.58 w=1 l=10
X1015 Vdd a_23489_19515# a_23489_19515# Vdd sky130_fd_pr__pfet_01v8_lvt ad=0.29 pd=2.58 as=0.29 ps=2.58 w=1 l=5
X1016 Vdd Vdd Vdd Vdd sky130_fd_pr__pfet_01v8_lvt ad=0.145 pd=1.58 as=0 ps=0 w=0.5 l=0.5
X1017 Vss Vss Vss Vss sky130_fd_pr__nfet_01v8_lvt ad=0.145 pd=1.58 as=0 ps=0 w=0.5 l=0.5
X1018 a_12205_19284# Vm a_12356_8500# Vss sky130_fd_pr__nfet_01v8_lvt ad=0.58 pd=4.58 as=0.58 ps=4.58 w=2 l=10
X1019 Vss Vss Vss Vss sky130_fd_pr__nfet_01v8_lvt ad=0.145 pd=1.58 as=0 ps=0 w=0.5 l=0.5
X1020 Vss Vss Vss Vss sky130_fd_pr__nfet_01v8_lvt ad=0.29 pd=2.58 as=0 ps=0 w=1 l=1
X1021 a_20243_28973# a_28673_28673# sky130_fd_pr__res_generic_po w=0.5 l=40
X1022 Vdd a_23489_19515# a_26999_20995# Vdd sky130_fd_pr__pfet_01v8_lvt ad=0.29 pd=2.58 as=0.29 ps=2.58 w=1 l=5
X1023 Vdd Vdd Vdd Vdd sky130_fd_pr__pfet_01v8_lvt ad=0.29 pd=2.58 as=0 ps=0 w=1 l=1
X1024 Vss Vss Vss Vss sky130_fd_pr__nfet_01v8_lvt ad=0.29 pd=2.58 as=0 ps=0 w=1 l=1
X1025 Vss Vss Vss Vss sky130_fd_pr__nfet_01v8_lvt ad=0.174 pd=1.78 as=0 ps=0 w=0.6 l=1
X1026 Vss Vss Vss Vss sky130_fd_pr__nfet_01v8_lvt ad=0.29 pd=2.58 as=0 ps=0 w=1 l=1
X1027 a_19456_19784# Vref a_14206_3858# Vss sky130_fd_pr__nfet_01v8_lvt ad=0.145 pd=1.58 as=0.145 ps=1.58 w=0.5 l=10
X1028 Vdd 2stage_op_amp_1/bias_dummy_0.PBias 2stage_op_amp_1/bias_dummy_0.Vbias1 Vdd sky130_fd_pr__pfet_01v8_lvt ad=1.45 pd=10.58 as=1.45 ps=10.58 w=5 l=2
X1029 Vdd Vdd Vdd Vdd sky130_fd_pr__pfet_01v8_lvt ad=0.58 pd=4.58 as=0 ps=0 w=2 l=1
X1030 Vdd Vdd Vdd Vdd sky130_fd_pr__pfet_01v8_lvt ad=0.145 pd=1.58 as=0 ps=0 w=0.5 l=10
X1031 Vss Vss Vss Vss sky130_fd_pr__nfet_01v8_lvt ad=0.174 pd=1.78 as=0 ps=0 w=0.6 l=1
X1032 Vss Vss Vss Vss sky130_fd_pr__nfet_01v8_lvt ad=0.145 pd=1.58 as=0 ps=0 w=0.5 l=0.5
X1033 Vdd Vdd Vdd Vdd sky130_fd_pr__pfet_01v8_lvt ad=0.29 pd=2.58 as=0 ps=0 w=1 l=1
X1034 a_12205_19284# Vm a_12356_8500# Vss sky130_fd_pr__nfet_01v8_lvt ad=0.58 pd=4.58 as=0.58 ps=4.58 w=2 l=10
X1035 Vss Vss Vss Vss sky130_fd_pr__nfet_01v8_lvt ad=0.58 pd=4.58 as=0 ps=0 w=2 l=1
X1036 Vss Vss Vss Vss sky130_fd_pr__nfet_01v8_lvt ad=0.145 pd=1.58 as=0 ps=0 w=0.5 l=10
X1037 a_1950_9246# a_1332_19196# Vdd Vdd sky130_fd_pr__pfet_01v8_lvt ad=1.45 pd=10.58 as=1.45 ps=10.58 w=5 l=1
X1038 2stage_op_amp_1/bias_dummy_0.PBias a_2465_13713# a_1506_10826# Vss sky130_fd_pr__nfet_01v8_lvt ad=1.45 pd=10.58 as=1.45 ps=10.58 w=5 l=2
X1039 Vss Vss Vss Vss sky130_fd_pr__nfet_01v8_lvt ad=0.174 pd=1.78 as=0 ps=0 w=0.6 l=1
X1040 a_19306_17126# a_19306_17126# Vdd Vdd sky130_fd_pr__pfet_01v8_lvt ad=0.29 pd=2.58 as=0.29 ps=2.58 w=1 l=10
X1041 Vss Vss Vss Vss sky130_fd_pr__nfet_01v8_lvt ad=0.145 pd=1.58 as=0 ps=0 w=0.5 l=0.5
X1042 a_12356_8500# 2stage_op_amp_1/Diff_opamp_ly_0.Vbias2 a_13686_3858# Vss sky130_fd_pr__nfet_01v8_lvt ad=0.29 pd=2.58 as=0.29 ps=2.58 w=1 l=10
X1043 Vdd a_19456_19784# a_12205_19284# Vdd sky130_fd_pr__pfet_01v8_lvt ad=0.29 pd=2.58 as=0.29 ps=2.58 w=1 l=5
X1044 Vdd a_23489_19515# a_23489_19515# Vdd sky130_fd_pr__pfet_01v8_lvt ad=0.29 pd=2.58 as=0.29 ps=2.58 w=1 l=5
X1045 Vss Vss sky130_fd_pr__cap_mim_m3_1 l=2 w=10
X1046 Vdd a_23489_19515# a_23489_19515# Vdd sky130_fd_pr__pfet_01v8_lvt ad=0.29 pd=2.58 as=0.29 ps=2.58 w=1 l=5
X1047 a_19306_17126# a_12205_17226# a_14206_3858# Vss sky130_fd_pr__nfet_01v8_lvt ad=0.145 pd=1.58 as=0.145 ps=1.58 w=0.5 l=10
X1048 Vss Vss Vss Vss sky130_fd_pr__nfet_01v8_lvt ad=0.145 pd=1.58 as=0 ps=0 w=0.5 l=10
X1049 a_12356_8500# 2stage_op_amp_1/Diff_opamp_ly_0.Vbias2 a_13686_3858# Vss sky130_fd_pr__nfet_01v8_lvt ad=0.29 pd=2.58 as=0.29 ps=2.58 w=1 l=10
X1050 a_12205_19546# 2stage_op_amp_1/Diff_opamp_ly_0.Vbias2 a_12906_3858# Vss sky130_fd_pr__nfet_01v8_lvt ad=0.29 pd=2.58 as=0.29 ps=2.58 w=1 l=10
X1051 a_12205_17226# a_n205_21647# sky130_fd_pr__cap_mim_m3_1 l=10 w=10
X1052 2stage_op_amp_1/bias_dummy_0.PBias a_2865_14979# a_2465_13713# Vss sky130_fd_pr__nfet_01v8_lvt ad=0.58 pd=4.58 as=0.58 ps=4.58 w=2 l=1
X1053 Vom a_23130_13378# Vss Vss sky130_fd_pr__nfet_01v8_lvt ad=0.29 pd=2.58 as=0.29 ps=2.58 w=1 l=1
X1054 Vdd Vdd Vdd Vdd sky130_fd_pr__pfet_01v8_lvt ad=1.45 pd=10.58 as=0 ps=0 w=5 l=2
X1055 a_12356_8500# 2stage_op_amp_1/Diff_opamp_ly_0.Vbias2 a_13686_6188# Vss sky130_fd_pr__nfet_01v8_lvt ad=0.29 pd=2.58 as=0.29 ps=2.58 w=1 l=10
X1056 Vdd Vdd Vdd Vdd sky130_fd_pr__pfet_01v8_lvt ad=0.29 pd=2.58 as=0 ps=0 w=1 l=1
X1057 Vss Vss Vss Vss sky130_fd_pr__nfet_01v8_lvt ad=0.174 pd=1.78 as=0 ps=0 w=0.6 l=1
X1058 Vss Vss Vss Vss sky130_fd_pr__nfet_01v8_lvt ad=0.145 pd=1.58 as=0 ps=0 w=0.5 l=10
.ends
