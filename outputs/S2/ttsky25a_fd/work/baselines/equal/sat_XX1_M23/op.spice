* ttsky25a_fd on dido_amp_OP
.lib $PDK_ROOT/sky130A/libs.tech/combined/sky130.lib.spice tt
.param VDD_V=1.8 VCM_V=0.9 CL_F=529f
.temp 27

**.subckt dido_amp_OP
x1 INP INN OUTN VDD 0 OUTP dut_amp
Vsup VDD 0 'VDD_V'
* AC drive through 1 F couplers; DC set by unity feedback through 1 GH chokes (OUTP->INN, OUTN->INP)
Vacp ACP 0 dc 0 ac 0
Vacn ACN 0 dc 0 ac 0
Cinp ACP INP 1
Cinn ACN INN 1
Lfbp OUTP INN 1G
Lfbn OUTN INP 1G
Cloadp OUTP 0 'CL_F'
Cloadn OUTN 0 'CL_F'
.control
set numdgt=12
op
let s1_xm32_id = @m.x1.xdut.xm32.msky130_fd_pr__pfet_01v8_lvt[id]
echo OPV XM32 id $&s1_xm32_id
let s1_xm32_vgs = @m.x1.xdut.xm32.msky130_fd_pr__pfet_01v8_lvt[vgs]
echo OPV XM32 vgs $&s1_xm32_vgs
let s1_xm32_vds = @m.x1.xdut.xm32.msky130_fd_pr__pfet_01v8_lvt[vds]
echo OPV XM32 vds $&s1_xm32_vds
let s1_xm32_vbs = @m.x1.xdut.xm32.msky130_fd_pr__pfet_01v8_lvt[vbs]
echo OPV XM32 vbs $&s1_xm32_vbs
let s1_xm32_vth = @m.x1.xdut.xm32.msky130_fd_pr__pfet_01v8_lvt[vth]
echo OPV XM32 vth $&s1_xm32_vth
let s1_xm32_vdsat = @m.x1.xdut.xm32.msky130_fd_pr__pfet_01v8_lvt[vdsat]
echo OPV XM32 vdsat $&s1_xm32_vdsat
let s1_xm32_gm = @m.x1.xdut.xm32.msky130_fd_pr__pfet_01v8_lvt[gm]
echo OPV XM32 gm $&s1_xm32_gm
let s1_xm32_gds = @m.x1.xdut.xm32.msky130_fd_pr__pfet_01v8_lvt[gds]
echo OPV XM32 gds $&s1_xm32_gds
let s1_xm32_gmbs = @m.x1.xdut.xm32.msky130_fd_pr__pfet_01v8_lvt[gmbs]
echo OPV XM32 gmbs $&s1_xm32_gmbs
let s1_xm32_cgg = @m.x1.xdut.xm32.msky130_fd_pr__pfet_01v8_lvt[cgg]
echo OPV XM32 cgg $&s1_xm32_cgg
let s1_xm32_cgd = @m.x1.xdut.xm32.msky130_fd_pr__pfet_01v8_lvt[cgd]
echo OPV XM32 cgd $&s1_xm32_cgd
let s1_xm32_cgs = @m.x1.xdut.xm32.msky130_fd_pr__pfet_01v8_lvt[cgs]
echo OPV XM32 cgs $&s1_xm32_cgs
let s1_xm32_cgb = @m.x1.xdut.xm32.msky130_fd_pr__pfet_01v8_lvt[cgb]
echo OPV XM32 cgb $&s1_xm32_cgb
let s1_xm32_cdg = @m.x1.xdut.xm32.msky130_fd_pr__pfet_01v8_lvt[cdg]
echo OPV XM32 cdg $&s1_xm32_cdg
let s1_xm32_cdd = @m.x1.xdut.xm32.msky130_fd_pr__pfet_01v8_lvt[cdd]
echo OPV XM32 cdd $&s1_xm32_cdd
let s1_xm32_cds = @m.x1.xdut.xm32.msky130_fd_pr__pfet_01v8_lvt[cds]
echo OPV XM32 cds $&s1_xm32_cds
let s1_xm32_cdb = @m.x1.xdut.xm32.msky130_fd_pr__pfet_01v8_lvt[cdb]
echo OPV XM32 cdb $&s1_xm32_cdb
let s1_xm32_csg = @m.x1.xdut.xm32.msky130_fd_pr__pfet_01v8_lvt[csg]
echo OPV XM32 csg $&s1_xm32_csg
let s1_xm32_csd = @m.x1.xdut.xm32.msky130_fd_pr__pfet_01v8_lvt[csd]
echo OPV XM32 csd $&s1_xm32_csd
let s1_xm32_css = @m.x1.xdut.xm32.msky130_fd_pr__pfet_01v8_lvt[css]
echo OPV XM32 css $&s1_xm32_css
let s1_xm32_csb = @m.x1.xdut.xm32.msky130_fd_pr__pfet_01v8_lvt[csb]
echo OPV XM32 csb $&s1_xm32_csb
let s1_xm32_cbg = @m.x1.xdut.xm32.msky130_fd_pr__pfet_01v8_lvt[cbg]
echo OPV XM32 cbg $&s1_xm32_cbg
let s1_xm32_cbd = @m.x1.xdut.xm32.msky130_fd_pr__pfet_01v8_lvt[cbd]
echo OPV XM32 cbd $&s1_xm32_cbd
let s1_xm32_cbs = @m.x1.xdut.xm32.msky130_fd_pr__pfet_01v8_lvt[cbs]
echo OPV XM32 cbs $&s1_xm32_cbs
let s1_xm32_cbb = @m.x1.xdut.xm32.msky130_fd_pr__pfet_01v8_lvt[cbb]
echo OPV XM32 cbb $&s1_xm32_cbb
let s1_xm32_capbd = @m.x1.xdut.xm32.msky130_fd_pr__pfet_01v8_lvt[capbd]
echo OPV XM32 capbd $&s1_xm32_capbd
let s1_xm32_capbs = @m.x1.xdut.xm32.msky130_fd_pr__pfet_01v8_lvt[capbs]
echo OPV XM32 capbs $&s1_xm32_capbs
let s1_xm32_cgso = @m.x1.xdut.xm32.msky130_fd_pr__pfet_01v8_lvt[cgso]
echo OPV XM32 cgso $&s1_xm32_cgso
let s1_xm32_cgdo = @m.x1.xdut.xm32.msky130_fd_pr__pfet_01v8_lvt[cgdo]
echo OPV XM32 cgdo $&s1_xm32_cgdo
let s1_xm32_cgbo = @m.x1.xdut.xm32.msky130_fd_pr__pfet_01v8_lvt[cgbo]
echo OPV XM32 cgbo $&s1_xm32_cgbo
let s1_xm32_weff = @m.x1.xdut.xm32.msky130_fd_pr__pfet_01v8_lvt[weff]
echo OPV XM32 weff $&s1_xm32_weff
let s1_xm32_leff = @m.x1.xdut.xm32.msky130_fd_pr__pfet_01v8_lvt[leff]
echo OPV XM32 leff $&s1_xm32_leff
let s1_xm33_id = @m.x1.xdut.xm33.msky130_fd_pr__nfet_01v8_lvt[id]
echo OPV XM33 id $&s1_xm33_id
let s1_xm33_vgs = @m.x1.xdut.xm33.msky130_fd_pr__nfet_01v8_lvt[vgs]
echo OPV XM33 vgs $&s1_xm33_vgs
let s1_xm33_vds = @m.x1.xdut.xm33.msky130_fd_pr__nfet_01v8_lvt[vds]
echo OPV XM33 vds $&s1_xm33_vds
let s1_xm33_vbs = @m.x1.xdut.xm33.msky130_fd_pr__nfet_01v8_lvt[vbs]
echo OPV XM33 vbs $&s1_xm33_vbs
let s1_xm33_vth = @m.x1.xdut.xm33.msky130_fd_pr__nfet_01v8_lvt[vth]
echo OPV XM33 vth $&s1_xm33_vth
let s1_xm33_vdsat = @m.x1.xdut.xm33.msky130_fd_pr__nfet_01v8_lvt[vdsat]
echo OPV XM33 vdsat $&s1_xm33_vdsat
let s1_xm33_gm = @m.x1.xdut.xm33.msky130_fd_pr__nfet_01v8_lvt[gm]
echo OPV XM33 gm $&s1_xm33_gm
let s1_xm33_gds = @m.x1.xdut.xm33.msky130_fd_pr__nfet_01v8_lvt[gds]
echo OPV XM33 gds $&s1_xm33_gds
let s1_xm33_gmbs = @m.x1.xdut.xm33.msky130_fd_pr__nfet_01v8_lvt[gmbs]
echo OPV XM33 gmbs $&s1_xm33_gmbs
let s1_xm33_cgg = @m.x1.xdut.xm33.msky130_fd_pr__nfet_01v8_lvt[cgg]
echo OPV XM33 cgg $&s1_xm33_cgg
let s1_xm33_cgd = @m.x1.xdut.xm33.msky130_fd_pr__nfet_01v8_lvt[cgd]
echo OPV XM33 cgd $&s1_xm33_cgd
let s1_xm33_cgs = @m.x1.xdut.xm33.msky130_fd_pr__nfet_01v8_lvt[cgs]
echo OPV XM33 cgs $&s1_xm33_cgs
let s1_xm33_cgb = @m.x1.xdut.xm33.msky130_fd_pr__nfet_01v8_lvt[cgb]
echo OPV XM33 cgb $&s1_xm33_cgb
let s1_xm33_cdg = @m.x1.xdut.xm33.msky130_fd_pr__nfet_01v8_lvt[cdg]
echo OPV XM33 cdg $&s1_xm33_cdg
let s1_xm33_cdd = @m.x1.xdut.xm33.msky130_fd_pr__nfet_01v8_lvt[cdd]
echo OPV XM33 cdd $&s1_xm33_cdd
let s1_xm33_cds = @m.x1.xdut.xm33.msky130_fd_pr__nfet_01v8_lvt[cds]
echo OPV XM33 cds $&s1_xm33_cds
let s1_xm33_cdb = @m.x1.xdut.xm33.msky130_fd_pr__nfet_01v8_lvt[cdb]
echo OPV XM33 cdb $&s1_xm33_cdb
let s1_xm33_csg = @m.x1.xdut.xm33.msky130_fd_pr__nfet_01v8_lvt[csg]
echo OPV XM33 csg $&s1_xm33_csg
let s1_xm33_csd = @m.x1.xdut.xm33.msky130_fd_pr__nfet_01v8_lvt[csd]
echo OPV XM33 csd $&s1_xm33_csd
let s1_xm33_css = @m.x1.xdut.xm33.msky130_fd_pr__nfet_01v8_lvt[css]
echo OPV XM33 css $&s1_xm33_css
let s1_xm33_csb = @m.x1.xdut.xm33.msky130_fd_pr__nfet_01v8_lvt[csb]
echo OPV XM33 csb $&s1_xm33_csb
let s1_xm33_cbg = @m.x1.xdut.xm33.msky130_fd_pr__nfet_01v8_lvt[cbg]
echo OPV XM33 cbg $&s1_xm33_cbg
let s1_xm33_cbd = @m.x1.xdut.xm33.msky130_fd_pr__nfet_01v8_lvt[cbd]
echo OPV XM33 cbd $&s1_xm33_cbd
let s1_xm33_cbs = @m.x1.xdut.xm33.msky130_fd_pr__nfet_01v8_lvt[cbs]
echo OPV XM33 cbs $&s1_xm33_cbs
let s1_xm33_cbb = @m.x1.xdut.xm33.msky130_fd_pr__nfet_01v8_lvt[cbb]
echo OPV XM33 cbb $&s1_xm33_cbb
let s1_xm33_capbd = @m.x1.xdut.xm33.msky130_fd_pr__nfet_01v8_lvt[capbd]
echo OPV XM33 capbd $&s1_xm33_capbd
let s1_xm33_capbs = @m.x1.xdut.xm33.msky130_fd_pr__nfet_01v8_lvt[capbs]
echo OPV XM33 capbs $&s1_xm33_capbs
let s1_xm33_cgso = @m.x1.xdut.xm33.msky130_fd_pr__nfet_01v8_lvt[cgso]
echo OPV XM33 cgso $&s1_xm33_cgso
let s1_xm33_cgdo = @m.x1.xdut.xm33.msky130_fd_pr__nfet_01v8_lvt[cgdo]
echo OPV XM33 cgdo $&s1_xm33_cgdo
let s1_xm33_cgbo = @m.x1.xdut.xm33.msky130_fd_pr__nfet_01v8_lvt[cgbo]
echo OPV XM33 cgbo $&s1_xm33_cgbo
let s1_xm33_weff = @m.x1.xdut.xm33.msky130_fd_pr__nfet_01v8_lvt[weff]
echo OPV XM33 weff $&s1_xm33_weff
let s1_xm33_leff = @m.x1.xdut.xm33.msky130_fd_pr__nfet_01v8_lvt[leff]
echo OPV XM33 leff $&s1_xm33_leff
let s1_xm34_id = @m.x1.xdut.xm34.msky130_fd_pr__pfet_01v8_lvt[id]
echo OPV XM34 id $&s1_xm34_id
let s1_xm34_vgs = @m.x1.xdut.xm34.msky130_fd_pr__pfet_01v8_lvt[vgs]
echo OPV XM34 vgs $&s1_xm34_vgs
let s1_xm34_vds = @m.x1.xdut.xm34.msky130_fd_pr__pfet_01v8_lvt[vds]
echo OPV XM34 vds $&s1_xm34_vds
let s1_xm34_vbs = @m.x1.xdut.xm34.msky130_fd_pr__pfet_01v8_lvt[vbs]
echo OPV XM34 vbs $&s1_xm34_vbs
let s1_xm34_vth = @m.x1.xdut.xm34.msky130_fd_pr__pfet_01v8_lvt[vth]
echo OPV XM34 vth $&s1_xm34_vth
let s1_xm34_vdsat = @m.x1.xdut.xm34.msky130_fd_pr__pfet_01v8_lvt[vdsat]
echo OPV XM34 vdsat $&s1_xm34_vdsat
let s1_xm34_gm = @m.x1.xdut.xm34.msky130_fd_pr__pfet_01v8_lvt[gm]
echo OPV XM34 gm $&s1_xm34_gm
let s1_xm34_gds = @m.x1.xdut.xm34.msky130_fd_pr__pfet_01v8_lvt[gds]
echo OPV XM34 gds $&s1_xm34_gds
let s1_xm34_gmbs = @m.x1.xdut.xm34.msky130_fd_pr__pfet_01v8_lvt[gmbs]
echo OPV XM34 gmbs $&s1_xm34_gmbs
let s1_xm34_cgg = @m.x1.xdut.xm34.msky130_fd_pr__pfet_01v8_lvt[cgg]
echo OPV XM34 cgg $&s1_xm34_cgg
let s1_xm34_cgd = @m.x1.xdut.xm34.msky130_fd_pr__pfet_01v8_lvt[cgd]
echo OPV XM34 cgd $&s1_xm34_cgd
let s1_xm34_cgs = @m.x1.xdut.xm34.msky130_fd_pr__pfet_01v8_lvt[cgs]
echo OPV XM34 cgs $&s1_xm34_cgs
let s1_xm34_cgb = @m.x1.xdut.xm34.msky130_fd_pr__pfet_01v8_lvt[cgb]
echo OPV XM34 cgb $&s1_xm34_cgb
let s1_xm34_cdg = @m.x1.xdut.xm34.msky130_fd_pr__pfet_01v8_lvt[cdg]
echo OPV XM34 cdg $&s1_xm34_cdg
let s1_xm34_cdd = @m.x1.xdut.xm34.msky130_fd_pr__pfet_01v8_lvt[cdd]
echo OPV XM34 cdd $&s1_xm34_cdd
let s1_xm34_cds = @m.x1.xdut.xm34.msky130_fd_pr__pfet_01v8_lvt[cds]
echo OPV XM34 cds $&s1_xm34_cds
let s1_xm34_cdb = @m.x1.xdut.xm34.msky130_fd_pr__pfet_01v8_lvt[cdb]
echo OPV XM34 cdb $&s1_xm34_cdb
let s1_xm34_csg = @m.x1.xdut.xm34.msky130_fd_pr__pfet_01v8_lvt[csg]
echo OPV XM34 csg $&s1_xm34_csg
let s1_xm34_csd = @m.x1.xdut.xm34.msky130_fd_pr__pfet_01v8_lvt[csd]
echo OPV XM34 csd $&s1_xm34_csd
let s1_xm34_css = @m.x1.xdut.xm34.msky130_fd_pr__pfet_01v8_lvt[css]
echo OPV XM34 css $&s1_xm34_css
let s1_xm34_csb = @m.x1.xdut.xm34.msky130_fd_pr__pfet_01v8_lvt[csb]
echo OPV XM34 csb $&s1_xm34_csb
let s1_xm34_cbg = @m.x1.xdut.xm34.msky130_fd_pr__pfet_01v8_lvt[cbg]
echo OPV XM34 cbg $&s1_xm34_cbg
let s1_xm34_cbd = @m.x1.xdut.xm34.msky130_fd_pr__pfet_01v8_lvt[cbd]
echo OPV XM34 cbd $&s1_xm34_cbd
let s1_xm34_cbs = @m.x1.xdut.xm34.msky130_fd_pr__pfet_01v8_lvt[cbs]
echo OPV XM34 cbs $&s1_xm34_cbs
let s1_xm34_cbb = @m.x1.xdut.xm34.msky130_fd_pr__pfet_01v8_lvt[cbb]
echo OPV XM34 cbb $&s1_xm34_cbb
let s1_xm34_capbd = @m.x1.xdut.xm34.msky130_fd_pr__pfet_01v8_lvt[capbd]
echo OPV XM34 capbd $&s1_xm34_capbd
let s1_xm34_capbs = @m.x1.xdut.xm34.msky130_fd_pr__pfet_01v8_lvt[capbs]
echo OPV XM34 capbs $&s1_xm34_capbs
let s1_xm34_cgso = @m.x1.xdut.xm34.msky130_fd_pr__pfet_01v8_lvt[cgso]
echo OPV XM34 cgso $&s1_xm34_cgso
let s1_xm34_cgdo = @m.x1.xdut.xm34.msky130_fd_pr__pfet_01v8_lvt[cgdo]
echo OPV XM34 cgdo $&s1_xm34_cgdo
let s1_xm34_cgbo = @m.x1.xdut.xm34.msky130_fd_pr__pfet_01v8_lvt[cgbo]
echo OPV XM34 cgbo $&s1_xm34_cgbo
let s1_xm34_weff = @m.x1.xdut.xm34.msky130_fd_pr__pfet_01v8_lvt[weff]
echo OPV XM34 weff $&s1_xm34_weff
let s1_xm34_leff = @m.x1.xdut.xm34.msky130_fd_pr__pfet_01v8_lvt[leff]
echo OPV XM34 leff $&s1_xm34_leff
let s1_xm35_id = @m.x1.xdut.xm35.msky130_fd_pr__nfet_01v8_lvt[id]
echo OPV XM35 id $&s1_xm35_id
let s1_xm35_vgs = @m.x1.xdut.xm35.msky130_fd_pr__nfet_01v8_lvt[vgs]
echo OPV XM35 vgs $&s1_xm35_vgs
let s1_xm35_vds = @m.x1.xdut.xm35.msky130_fd_pr__nfet_01v8_lvt[vds]
echo OPV XM35 vds $&s1_xm35_vds
let s1_xm35_vbs = @m.x1.xdut.xm35.msky130_fd_pr__nfet_01v8_lvt[vbs]
echo OPV XM35 vbs $&s1_xm35_vbs
let s1_xm35_vth = @m.x1.xdut.xm35.msky130_fd_pr__nfet_01v8_lvt[vth]
echo OPV XM35 vth $&s1_xm35_vth
let s1_xm35_vdsat = @m.x1.xdut.xm35.msky130_fd_pr__nfet_01v8_lvt[vdsat]
echo OPV XM35 vdsat $&s1_xm35_vdsat
let s1_xm35_gm = @m.x1.xdut.xm35.msky130_fd_pr__nfet_01v8_lvt[gm]
echo OPV XM35 gm $&s1_xm35_gm
let s1_xm35_gds = @m.x1.xdut.xm35.msky130_fd_pr__nfet_01v8_lvt[gds]
echo OPV XM35 gds $&s1_xm35_gds
let s1_xm35_gmbs = @m.x1.xdut.xm35.msky130_fd_pr__nfet_01v8_lvt[gmbs]
echo OPV XM35 gmbs $&s1_xm35_gmbs
let s1_xm35_cgg = @m.x1.xdut.xm35.msky130_fd_pr__nfet_01v8_lvt[cgg]
echo OPV XM35 cgg $&s1_xm35_cgg
let s1_xm35_cgd = @m.x1.xdut.xm35.msky130_fd_pr__nfet_01v8_lvt[cgd]
echo OPV XM35 cgd $&s1_xm35_cgd
let s1_xm35_cgs = @m.x1.xdut.xm35.msky130_fd_pr__nfet_01v8_lvt[cgs]
echo OPV XM35 cgs $&s1_xm35_cgs
let s1_xm35_cgb = @m.x1.xdut.xm35.msky130_fd_pr__nfet_01v8_lvt[cgb]
echo OPV XM35 cgb $&s1_xm35_cgb
let s1_xm35_cdg = @m.x1.xdut.xm35.msky130_fd_pr__nfet_01v8_lvt[cdg]
echo OPV XM35 cdg $&s1_xm35_cdg
let s1_xm35_cdd = @m.x1.xdut.xm35.msky130_fd_pr__nfet_01v8_lvt[cdd]
echo OPV XM35 cdd $&s1_xm35_cdd
let s1_xm35_cds = @m.x1.xdut.xm35.msky130_fd_pr__nfet_01v8_lvt[cds]
echo OPV XM35 cds $&s1_xm35_cds
let s1_xm35_cdb = @m.x1.xdut.xm35.msky130_fd_pr__nfet_01v8_lvt[cdb]
echo OPV XM35 cdb $&s1_xm35_cdb
let s1_xm35_csg = @m.x1.xdut.xm35.msky130_fd_pr__nfet_01v8_lvt[csg]
echo OPV XM35 csg $&s1_xm35_csg
let s1_xm35_csd = @m.x1.xdut.xm35.msky130_fd_pr__nfet_01v8_lvt[csd]
echo OPV XM35 csd $&s1_xm35_csd
let s1_xm35_css = @m.x1.xdut.xm35.msky130_fd_pr__nfet_01v8_lvt[css]
echo OPV XM35 css $&s1_xm35_css
let s1_xm35_csb = @m.x1.xdut.xm35.msky130_fd_pr__nfet_01v8_lvt[csb]
echo OPV XM35 csb $&s1_xm35_csb
let s1_xm35_cbg = @m.x1.xdut.xm35.msky130_fd_pr__nfet_01v8_lvt[cbg]
echo OPV XM35 cbg $&s1_xm35_cbg
let s1_xm35_cbd = @m.x1.xdut.xm35.msky130_fd_pr__nfet_01v8_lvt[cbd]
echo OPV XM35 cbd $&s1_xm35_cbd
let s1_xm35_cbs = @m.x1.xdut.xm35.msky130_fd_pr__nfet_01v8_lvt[cbs]
echo OPV XM35 cbs $&s1_xm35_cbs
let s1_xm35_cbb = @m.x1.xdut.xm35.msky130_fd_pr__nfet_01v8_lvt[cbb]
echo OPV XM35 cbb $&s1_xm35_cbb
let s1_xm35_capbd = @m.x1.xdut.xm35.msky130_fd_pr__nfet_01v8_lvt[capbd]
echo OPV XM35 capbd $&s1_xm35_capbd
let s1_xm35_capbs = @m.x1.xdut.xm35.msky130_fd_pr__nfet_01v8_lvt[capbs]
echo OPV XM35 capbs $&s1_xm35_capbs
let s1_xm35_cgso = @m.x1.xdut.xm35.msky130_fd_pr__nfet_01v8_lvt[cgso]
echo OPV XM35 cgso $&s1_xm35_cgso
let s1_xm35_cgdo = @m.x1.xdut.xm35.msky130_fd_pr__nfet_01v8_lvt[cgdo]
echo OPV XM35 cgdo $&s1_xm35_cgdo
let s1_xm35_cgbo = @m.x1.xdut.xm35.msky130_fd_pr__nfet_01v8_lvt[cgbo]
echo OPV XM35 cgbo $&s1_xm35_cgbo
let s1_xm35_weff = @m.x1.xdut.xm35.msky130_fd_pr__nfet_01v8_lvt[weff]
echo OPV XM35 weff $&s1_xm35_weff
let s1_xm35_leff = @m.x1.xdut.xm35.msky130_fd_pr__nfet_01v8_lvt[leff]
echo OPV XM35 leff $&s1_xm35_leff
let s1_xm36_id = @m.x1.xdut.xm36.msky130_fd_pr__nfet_01v8_lvt[id]
echo OPV XM36 id $&s1_xm36_id
let s1_xm36_vgs = @m.x1.xdut.xm36.msky130_fd_pr__nfet_01v8_lvt[vgs]
echo OPV XM36 vgs $&s1_xm36_vgs
let s1_xm36_vds = @m.x1.xdut.xm36.msky130_fd_pr__nfet_01v8_lvt[vds]
echo OPV XM36 vds $&s1_xm36_vds
let s1_xm36_vbs = @m.x1.xdut.xm36.msky130_fd_pr__nfet_01v8_lvt[vbs]
echo OPV XM36 vbs $&s1_xm36_vbs
let s1_xm36_vth = @m.x1.xdut.xm36.msky130_fd_pr__nfet_01v8_lvt[vth]
echo OPV XM36 vth $&s1_xm36_vth
let s1_xm36_vdsat = @m.x1.xdut.xm36.msky130_fd_pr__nfet_01v8_lvt[vdsat]
echo OPV XM36 vdsat $&s1_xm36_vdsat
let s1_xm36_gm = @m.x1.xdut.xm36.msky130_fd_pr__nfet_01v8_lvt[gm]
echo OPV XM36 gm $&s1_xm36_gm
let s1_xm36_gds = @m.x1.xdut.xm36.msky130_fd_pr__nfet_01v8_lvt[gds]
echo OPV XM36 gds $&s1_xm36_gds
let s1_xm36_gmbs = @m.x1.xdut.xm36.msky130_fd_pr__nfet_01v8_lvt[gmbs]
echo OPV XM36 gmbs $&s1_xm36_gmbs
let s1_xm36_cgg = @m.x1.xdut.xm36.msky130_fd_pr__nfet_01v8_lvt[cgg]
echo OPV XM36 cgg $&s1_xm36_cgg
let s1_xm36_cgd = @m.x1.xdut.xm36.msky130_fd_pr__nfet_01v8_lvt[cgd]
echo OPV XM36 cgd $&s1_xm36_cgd
let s1_xm36_cgs = @m.x1.xdut.xm36.msky130_fd_pr__nfet_01v8_lvt[cgs]
echo OPV XM36 cgs $&s1_xm36_cgs
let s1_xm36_cgb = @m.x1.xdut.xm36.msky130_fd_pr__nfet_01v8_lvt[cgb]
echo OPV XM36 cgb $&s1_xm36_cgb
let s1_xm36_cdg = @m.x1.xdut.xm36.msky130_fd_pr__nfet_01v8_lvt[cdg]
echo OPV XM36 cdg $&s1_xm36_cdg
let s1_xm36_cdd = @m.x1.xdut.xm36.msky130_fd_pr__nfet_01v8_lvt[cdd]
echo OPV XM36 cdd $&s1_xm36_cdd
let s1_xm36_cds = @m.x1.xdut.xm36.msky130_fd_pr__nfet_01v8_lvt[cds]
echo OPV XM36 cds $&s1_xm36_cds
let s1_xm36_cdb = @m.x1.xdut.xm36.msky130_fd_pr__nfet_01v8_lvt[cdb]
echo OPV XM36 cdb $&s1_xm36_cdb
let s1_xm36_csg = @m.x1.xdut.xm36.msky130_fd_pr__nfet_01v8_lvt[csg]
echo OPV XM36 csg $&s1_xm36_csg
let s1_xm36_csd = @m.x1.xdut.xm36.msky130_fd_pr__nfet_01v8_lvt[csd]
echo OPV XM36 csd $&s1_xm36_csd
let s1_xm36_css = @m.x1.xdut.xm36.msky130_fd_pr__nfet_01v8_lvt[css]
echo OPV XM36 css $&s1_xm36_css
let s1_xm36_csb = @m.x1.xdut.xm36.msky130_fd_pr__nfet_01v8_lvt[csb]
echo OPV XM36 csb $&s1_xm36_csb
let s1_xm36_cbg = @m.x1.xdut.xm36.msky130_fd_pr__nfet_01v8_lvt[cbg]
echo OPV XM36 cbg $&s1_xm36_cbg
let s1_xm36_cbd = @m.x1.xdut.xm36.msky130_fd_pr__nfet_01v8_lvt[cbd]
echo OPV XM36 cbd $&s1_xm36_cbd
let s1_xm36_cbs = @m.x1.xdut.xm36.msky130_fd_pr__nfet_01v8_lvt[cbs]
echo OPV XM36 cbs $&s1_xm36_cbs
let s1_xm36_cbb = @m.x1.xdut.xm36.msky130_fd_pr__nfet_01v8_lvt[cbb]
echo OPV XM36 cbb $&s1_xm36_cbb
let s1_xm36_capbd = @m.x1.xdut.xm36.msky130_fd_pr__nfet_01v8_lvt[capbd]
echo OPV XM36 capbd $&s1_xm36_capbd
let s1_xm36_capbs = @m.x1.xdut.xm36.msky130_fd_pr__nfet_01v8_lvt[capbs]
echo OPV XM36 capbs $&s1_xm36_capbs
let s1_xm36_cgso = @m.x1.xdut.xm36.msky130_fd_pr__nfet_01v8_lvt[cgso]
echo OPV XM36 cgso $&s1_xm36_cgso
let s1_xm36_cgdo = @m.x1.xdut.xm36.msky130_fd_pr__nfet_01v8_lvt[cgdo]
echo OPV XM36 cgdo $&s1_xm36_cgdo
let s1_xm36_cgbo = @m.x1.xdut.xm36.msky130_fd_pr__nfet_01v8_lvt[cgbo]
echo OPV XM36 cgbo $&s1_xm36_cgbo
let s1_xm36_weff = @m.x1.xdut.xm36.msky130_fd_pr__nfet_01v8_lvt[weff]
echo OPV XM36 weff $&s1_xm36_weff
let s1_xm36_leff = @m.x1.xdut.xm36.msky130_fd_pr__nfet_01v8_lvt[leff]
echo OPV XM36 leff $&s1_xm36_leff
let s1_xm37_id = @m.x1.xdut.xm37.msky130_fd_pr__nfet_01v8_lvt[id]
echo OPV XM37 id $&s1_xm37_id
let s1_xm37_vgs = @m.x1.xdut.xm37.msky130_fd_pr__nfet_01v8_lvt[vgs]
echo OPV XM37 vgs $&s1_xm37_vgs
let s1_xm37_vds = @m.x1.xdut.xm37.msky130_fd_pr__nfet_01v8_lvt[vds]
echo OPV XM37 vds $&s1_xm37_vds
let s1_xm37_vbs = @m.x1.xdut.xm37.msky130_fd_pr__nfet_01v8_lvt[vbs]
echo OPV XM37 vbs $&s1_xm37_vbs
let s1_xm37_vth = @m.x1.xdut.xm37.msky130_fd_pr__nfet_01v8_lvt[vth]
echo OPV XM37 vth $&s1_xm37_vth
let s1_xm37_vdsat = @m.x1.xdut.xm37.msky130_fd_pr__nfet_01v8_lvt[vdsat]
echo OPV XM37 vdsat $&s1_xm37_vdsat
let s1_xm37_gm = @m.x1.xdut.xm37.msky130_fd_pr__nfet_01v8_lvt[gm]
echo OPV XM37 gm $&s1_xm37_gm
let s1_xm37_gds = @m.x1.xdut.xm37.msky130_fd_pr__nfet_01v8_lvt[gds]
echo OPV XM37 gds $&s1_xm37_gds
let s1_xm37_gmbs = @m.x1.xdut.xm37.msky130_fd_pr__nfet_01v8_lvt[gmbs]
echo OPV XM37 gmbs $&s1_xm37_gmbs
let s1_xm37_cgg = @m.x1.xdut.xm37.msky130_fd_pr__nfet_01v8_lvt[cgg]
echo OPV XM37 cgg $&s1_xm37_cgg
let s1_xm37_cgd = @m.x1.xdut.xm37.msky130_fd_pr__nfet_01v8_lvt[cgd]
echo OPV XM37 cgd $&s1_xm37_cgd
let s1_xm37_cgs = @m.x1.xdut.xm37.msky130_fd_pr__nfet_01v8_lvt[cgs]
echo OPV XM37 cgs $&s1_xm37_cgs
let s1_xm37_cgb = @m.x1.xdut.xm37.msky130_fd_pr__nfet_01v8_lvt[cgb]
echo OPV XM37 cgb $&s1_xm37_cgb
let s1_xm37_cdg = @m.x1.xdut.xm37.msky130_fd_pr__nfet_01v8_lvt[cdg]
echo OPV XM37 cdg $&s1_xm37_cdg
let s1_xm37_cdd = @m.x1.xdut.xm37.msky130_fd_pr__nfet_01v8_lvt[cdd]
echo OPV XM37 cdd $&s1_xm37_cdd
let s1_xm37_cds = @m.x1.xdut.xm37.msky130_fd_pr__nfet_01v8_lvt[cds]
echo OPV XM37 cds $&s1_xm37_cds
let s1_xm37_cdb = @m.x1.xdut.xm37.msky130_fd_pr__nfet_01v8_lvt[cdb]
echo OPV XM37 cdb $&s1_xm37_cdb
let s1_xm37_csg = @m.x1.xdut.xm37.msky130_fd_pr__nfet_01v8_lvt[csg]
echo OPV XM37 csg $&s1_xm37_csg
let s1_xm37_csd = @m.x1.xdut.xm37.msky130_fd_pr__nfet_01v8_lvt[csd]
echo OPV XM37 csd $&s1_xm37_csd
let s1_xm37_css = @m.x1.xdut.xm37.msky130_fd_pr__nfet_01v8_lvt[css]
echo OPV XM37 css $&s1_xm37_css
let s1_xm37_csb = @m.x1.xdut.xm37.msky130_fd_pr__nfet_01v8_lvt[csb]
echo OPV XM37 csb $&s1_xm37_csb
let s1_xm37_cbg = @m.x1.xdut.xm37.msky130_fd_pr__nfet_01v8_lvt[cbg]
echo OPV XM37 cbg $&s1_xm37_cbg
let s1_xm37_cbd = @m.x1.xdut.xm37.msky130_fd_pr__nfet_01v8_lvt[cbd]
echo OPV XM37 cbd $&s1_xm37_cbd
let s1_xm37_cbs = @m.x1.xdut.xm37.msky130_fd_pr__nfet_01v8_lvt[cbs]
echo OPV XM37 cbs $&s1_xm37_cbs
let s1_xm37_cbb = @m.x1.xdut.xm37.msky130_fd_pr__nfet_01v8_lvt[cbb]
echo OPV XM37 cbb $&s1_xm37_cbb
let s1_xm37_capbd = @m.x1.xdut.xm37.msky130_fd_pr__nfet_01v8_lvt[capbd]
echo OPV XM37 capbd $&s1_xm37_capbd
let s1_xm37_capbs = @m.x1.xdut.xm37.msky130_fd_pr__nfet_01v8_lvt[capbs]
echo OPV XM37 capbs $&s1_xm37_capbs
let s1_xm37_cgso = @m.x1.xdut.xm37.msky130_fd_pr__nfet_01v8_lvt[cgso]
echo OPV XM37 cgso $&s1_xm37_cgso
let s1_xm37_cgdo = @m.x1.xdut.xm37.msky130_fd_pr__nfet_01v8_lvt[cgdo]
echo OPV XM37 cgdo $&s1_xm37_cgdo
let s1_xm37_cgbo = @m.x1.xdut.xm37.msky130_fd_pr__nfet_01v8_lvt[cgbo]
echo OPV XM37 cgbo $&s1_xm37_cgbo
let s1_xm37_weff = @m.x1.xdut.xm37.msky130_fd_pr__nfet_01v8_lvt[weff]
echo OPV XM37 weff $&s1_xm37_weff
let s1_xm37_leff = @m.x1.xdut.xm37.msky130_fd_pr__nfet_01v8_lvt[leff]
echo OPV XM37 leff $&s1_xm37_leff
let s1_xm38_id = @m.x1.xdut.xm38.msky130_fd_pr__pfet_01v8_lvt[id]
echo OPV XM38 id $&s1_xm38_id
let s1_xm38_vgs = @m.x1.xdut.xm38.msky130_fd_pr__pfet_01v8_lvt[vgs]
echo OPV XM38 vgs $&s1_xm38_vgs
let s1_xm38_vds = @m.x1.xdut.xm38.msky130_fd_pr__pfet_01v8_lvt[vds]
echo OPV XM38 vds $&s1_xm38_vds
let s1_xm38_vbs = @m.x1.xdut.xm38.msky130_fd_pr__pfet_01v8_lvt[vbs]
echo OPV XM38 vbs $&s1_xm38_vbs
let s1_xm38_vth = @m.x1.xdut.xm38.msky130_fd_pr__pfet_01v8_lvt[vth]
echo OPV XM38 vth $&s1_xm38_vth
let s1_xm38_vdsat = @m.x1.xdut.xm38.msky130_fd_pr__pfet_01v8_lvt[vdsat]
echo OPV XM38 vdsat $&s1_xm38_vdsat
let s1_xm38_gm = @m.x1.xdut.xm38.msky130_fd_pr__pfet_01v8_lvt[gm]
echo OPV XM38 gm $&s1_xm38_gm
let s1_xm38_gds = @m.x1.xdut.xm38.msky130_fd_pr__pfet_01v8_lvt[gds]
echo OPV XM38 gds $&s1_xm38_gds
let s1_xm38_gmbs = @m.x1.xdut.xm38.msky130_fd_pr__pfet_01v8_lvt[gmbs]
echo OPV XM38 gmbs $&s1_xm38_gmbs
let s1_xm38_cgg = @m.x1.xdut.xm38.msky130_fd_pr__pfet_01v8_lvt[cgg]
echo OPV XM38 cgg $&s1_xm38_cgg
let s1_xm38_cgd = @m.x1.xdut.xm38.msky130_fd_pr__pfet_01v8_lvt[cgd]
echo OPV XM38 cgd $&s1_xm38_cgd
let s1_xm38_cgs = @m.x1.xdut.xm38.msky130_fd_pr__pfet_01v8_lvt[cgs]
echo OPV XM38 cgs $&s1_xm38_cgs
let s1_xm38_cgb = @m.x1.xdut.xm38.msky130_fd_pr__pfet_01v8_lvt[cgb]
echo OPV XM38 cgb $&s1_xm38_cgb
let s1_xm38_cdg = @m.x1.xdut.xm38.msky130_fd_pr__pfet_01v8_lvt[cdg]
echo OPV XM38 cdg $&s1_xm38_cdg
let s1_xm38_cdd = @m.x1.xdut.xm38.msky130_fd_pr__pfet_01v8_lvt[cdd]
echo OPV XM38 cdd $&s1_xm38_cdd
let s1_xm38_cds = @m.x1.xdut.xm38.msky130_fd_pr__pfet_01v8_lvt[cds]
echo OPV XM38 cds $&s1_xm38_cds
let s1_xm38_cdb = @m.x1.xdut.xm38.msky130_fd_pr__pfet_01v8_lvt[cdb]
echo OPV XM38 cdb $&s1_xm38_cdb
let s1_xm38_csg = @m.x1.xdut.xm38.msky130_fd_pr__pfet_01v8_lvt[csg]
echo OPV XM38 csg $&s1_xm38_csg
let s1_xm38_csd = @m.x1.xdut.xm38.msky130_fd_pr__pfet_01v8_lvt[csd]
echo OPV XM38 csd $&s1_xm38_csd
let s1_xm38_css = @m.x1.xdut.xm38.msky130_fd_pr__pfet_01v8_lvt[css]
echo OPV XM38 css $&s1_xm38_css
let s1_xm38_csb = @m.x1.xdut.xm38.msky130_fd_pr__pfet_01v8_lvt[csb]
echo OPV XM38 csb $&s1_xm38_csb
let s1_xm38_cbg = @m.x1.xdut.xm38.msky130_fd_pr__pfet_01v8_lvt[cbg]
echo OPV XM38 cbg $&s1_xm38_cbg
let s1_xm38_cbd = @m.x1.xdut.xm38.msky130_fd_pr__pfet_01v8_lvt[cbd]
echo OPV XM38 cbd $&s1_xm38_cbd
let s1_xm38_cbs = @m.x1.xdut.xm38.msky130_fd_pr__pfet_01v8_lvt[cbs]
echo OPV XM38 cbs $&s1_xm38_cbs
let s1_xm38_cbb = @m.x1.xdut.xm38.msky130_fd_pr__pfet_01v8_lvt[cbb]
echo OPV XM38 cbb $&s1_xm38_cbb
let s1_xm38_capbd = @m.x1.xdut.xm38.msky130_fd_pr__pfet_01v8_lvt[capbd]
echo OPV XM38 capbd $&s1_xm38_capbd
let s1_xm38_capbs = @m.x1.xdut.xm38.msky130_fd_pr__pfet_01v8_lvt[capbs]
echo OPV XM38 capbs $&s1_xm38_capbs
let s1_xm38_cgso = @m.x1.xdut.xm38.msky130_fd_pr__pfet_01v8_lvt[cgso]
echo OPV XM38 cgso $&s1_xm38_cgso
let s1_xm38_cgdo = @m.x1.xdut.xm38.msky130_fd_pr__pfet_01v8_lvt[cgdo]
echo OPV XM38 cgdo $&s1_xm38_cgdo
let s1_xm38_cgbo = @m.x1.xdut.xm38.msky130_fd_pr__pfet_01v8_lvt[cgbo]
echo OPV XM38 cgbo $&s1_xm38_cgbo
let s1_xm38_weff = @m.x1.xdut.xm38.msky130_fd_pr__pfet_01v8_lvt[weff]
echo OPV XM38 weff $&s1_xm38_weff
let s1_xm38_leff = @m.x1.xdut.xm38.msky130_fd_pr__pfet_01v8_lvt[leff]
echo OPV XM38 leff $&s1_xm38_leff
let s1_xm39_id = @m.x1.xdut.xm39.msky130_fd_pr__pfet_01v8_lvt[id]
echo OPV XM39 id $&s1_xm39_id
let s1_xm39_vgs = @m.x1.xdut.xm39.msky130_fd_pr__pfet_01v8_lvt[vgs]
echo OPV XM39 vgs $&s1_xm39_vgs
let s1_xm39_vds = @m.x1.xdut.xm39.msky130_fd_pr__pfet_01v8_lvt[vds]
echo OPV XM39 vds $&s1_xm39_vds
let s1_xm39_vbs = @m.x1.xdut.xm39.msky130_fd_pr__pfet_01v8_lvt[vbs]
echo OPV XM39 vbs $&s1_xm39_vbs
let s1_xm39_vth = @m.x1.xdut.xm39.msky130_fd_pr__pfet_01v8_lvt[vth]
echo OPV XM39 vth $&s1_xm39_vth
let s1_xm39_vdsat = @m.x1.xdut.xm39.msky130_fd_pr__pfet_01v8_lvt[vdsat]
echo OPV XM39 vdsat $&s1_xm39_vdsat
let s1_xm39_gm = @m.x1.xdut.xm39.msky130_fd_pr__pfet_01v8_lvt[gm]
echo OPV XM39 gm $&s1_xm39_gm
let s1_xm39_gds = @m.x1.xdut.xm39.msky130_fd_pr__pfet_01v8_lvt[gds]
echo OPV XM39 gds $&s1_xm39_gds
let s1_xm39_gmbs = @m.x1.xdut.xm39.msky130_fd_pr__pfet_01v8_lvt[gmbs]
echo OPV XM39 gmbs $&s1_xm39_gmbs
let s1_xm39_cgg = @m.x1.xdut.xm39.msky130_fd_pr__pfet_01v8_lvt[cgg]
echo OPV XM39 cgg $&s1_xm39_cgg
let s1_xm39_cgd = @m.x1.xdut.xm39.msky130_fd_pr__pfet_01v8_lvt[cgd]
echo OPV XM39 cgd $&s1_xm39_cgd
let s1_xm39_cgs = @m.x1.xdut.xm39.msky130_fd_pr__pfet_01v8_lvt[cgs]
echo OPV XM39 cgs $&s1_xm39_cgs
let s1_xm39_cgb = @m.x1.xdut.xm39.msky130_fd_pr__pfet_01v8_lvt[cgb]
echo OPV XM39 cgb $&s1_xm39_cgb
let s1_xm39_cdg = @m.x1.xdut.xm39.msky130_fd_pr__pfet_01v8_lvt[cdg]
echo OPV XM39 cdg $&s1_xm39_cdg
let s1_xm39_cdd = @m.x1.xdut.xm39.msky130_fd_pr__pfet_01v8_lvt[cdd]
echo OPV XM39 cdd $&s1_xm39_cdd
let s1_xm39_cds = @m.x1.xdut.xm39.msky130_fd_pr__pfet_01v8_lvt[cds]
echo OPV XM39 cds $&s1_xm39_cds
let s1_xm39_cdb = @m.x1.xdut.xm39.msky130_fd_pr__pfet_01v8_lvt[cdb]
echo OPV XM39 cdb $&s1_xm39_cdb
let s1_xm39_csg = @m.x1.xdut.xm39.msky130_fd_pr__pfet_01v8_lvt[csg]
echo OPV XM39 csg $&s1_xm39_csg
let s1_xm39_csd = @m.x1.xdut.xm39.msky130_fd_pr__pfet_01v8_lvt[csd]
echo OPV XM39 csd $&s1_xm39_csd
let s1_xm39_css = @m.x1.xdut.xm39.msky130_fd_pr__pfet_01v8_lvt[css]
echo OPV XM39 css $&s1_xm39_css
let s1_xm39_csb = @m.x1.xdut.xm39.msky130_fd_pr__pfet_01v8_lvt[csb]
echo OPV XM39 csb $&s1_xm39_csb
let s1_xm39_cbg = @m.x1.xdut.xm39.msky130_fd_pr__pfet_01v8_lvt[cbg]
echo OPV XM39 cbg $&s1_xm39_cbg
let s1_xm39_cbd = @m.x1.xdut.xm39.msky130_fd_pr__pfet_01v8_lvt[cbd]
echo OPV XM39 cbd $&s1_xm39_cbd
let s1_xm39_cbs = @m.x1.xdut.xm39.msky130_fd_pr__pfet_01v8_lvt[cbs]
echo OPV XM39 cbs $&s1_xm39_cbs
let s1_xm39_cbb = @m.x1.xdut.xm39.msky130_fd_pr__pfet_01v8_lvt[cbb]
echo OPV XM39 cbb $&s1_xm39_cbb
let s1_xm39_capbd = @m.x1.xdut.xm39.msky130_fd_pr__pfet_01v8_lvt[capbd]
echo OPV XM39 capbd $&s1_xm39_capbd
let s1_xm39_capbs = @m.x1.xdut.xm39.msky130_fd_pr__pfet_01v8_lvt[capbs]
echo OPV XM39 capbs $&s1_xm39_capbs
let s1_xm39_cgso = @m.x1.xdut.xm39.msky130_fd_pr__pfet_01v8_lvt[cgso]
echo OPV XM39 cgso $&s1_xm39_cgso
let s1_xm39_cgdo = @m.x1.xdut.xm39.msky130_fd_pr__pfet_01v8_lvt[cgdo]
echo OPV XM39 cgdo $&s1_xm39_cgdo
let s1_xm39_cgbo = @m.x1.xdut.xm39.msky130_fd_pr__pfet_01v8_lvt[cgbo]
echo OPV XM39 cgbo $&s1_xm39_cgbo
let s1_xm39_weff = @m.x1.xdut.xm39.msky130_fd_pr__pfet_01v8_lvt[weff]
echo OPV XM39 weff $&s1_xm39_weff
let s1_xm39_leff = @m.x1.xdut.xm39.msky130_fd_pr__pfet_01v8_lvt[leff]
echo OPV XM39 leff $&s1_xm39_leff
let s1_xm40_id = @m.x1.xdut.xm40.msky130_fd_pr__nfet_01v8_lvt[id]
echo OPV XM40 id $&s1_xm40_id
let s1_xm40_vgs = @m.x1.xdut.xm40.msky130_fd_pr__nfet_01v8_lvt[vgs]
echo OPV XM40 vgs $&s1_xm40_vgs
let s1_xm40_vds = @m.x1.xdut.xm40.msky130_fd_pr__nfet_01v8_lvt[vds]
echo OPV XM40 vds $&s1_xm40_vds
let s1_xm40_vbs = @m.x1.xdut.xm40.msky130_fd_pr__nfet_01v8_lvt[vbs]
echo OPV XM40 vbs $&s1_xm40_vbs
let s1_xm40_vth = @m.x1.xdut.xm40.msky130_fd_pr__nfet_01v8_lvt[vth]
echo OPV XM40 vth $&s1_xm40_vth
let s1_xm40_vdsat = @m.x1.xdut.xm40.msky130_fd_pr__nfet_01v8_lvt[vdsat]
echo OPV XM40 vdsat $&s1_xm40_vdsat
let s1_xm40_gm = @m.x1.xdut.xm40.msky130_fd_pr__nfet_01v8_lvt[gm]
echo OPV XM40 gm $&s1_xm40_gm
let s1_xm40_gds = @m.x1.xdut.xm40.msky130_fd_pr__nfet_01v8_lvt[gds]
echo OPV XM40 gds $&s1_xm40_gds
let s1_xm40_gmbs = @m.x1.xdut.xm40.msky130_fd_pr__nfet_01v8_lvt[gmbs]
echo OPV XM40 gmbs $&s1_xm40_gmbs
let s1_xm40_cgg = @m.x1.xdut.xm40.msky130_fd_pr__nfet_01v8_lvt[cgg]
echo OPV XM40 cgg $&s1_xm40_cgg
let s1_xm40_cgd = @m.x1.xdut.xm40.msky130_fd_pr__nfet_01v8_lvt[cgd]
echo OPV XM40 cgd $&s1_xm40_cgd
let s1_xm40_cgs = @m.x1.xdut.xm40.msky130_fd_pr__nfet_01v8_lvt[cgs]
echo OPV XM40 cgs $&s1_xm40_cgs
let s1_xm40_cgb = @m.x1.xdut.xm40.msky130_fd_pr__nfet_01v8_lvt[cgb]
echo OPV XM40 cgb $&s1_xm40_cgb
let s1_xm40_cdg = @m.x1.xdut.xm40.msky130_fd_pr__nfet_01v8_lvt[cdg]
echo OPV XM40 cdg $&s1_xm40_cdg
let s1_xm40_cdd = @m.x1.xdut.xm40.msky130_fd_pr__nfet_01v8_lvt[cdd]
echo OPV XM40 cdd $&s1_xm40_cdd
let s1_xm40_cds = @m.x1.xdut.xm40.msky130_fd_pr__nfet_01v8_lvt[cds]
echo OPV XM40 cds $&s1_xm40_cds
let s1_xm40_cdb = @m.x1.xdut.xm40.msky130_fd_pr__nfet_01v8_lvt[cdb]
echo OPV XM40 cdb $&s1_xm40_cdb
let s1_xm40_csg = @m.x1.xdut.xm40.msky130_fd_pr__nfet_01v8_lvt[csg]
echo OPV XM40 csg $&s1_xm40_csg
let s1_xm40_csd = @m.x1.xdut.xm40.msky130_fd_pr__nfet_01v8_lvt[csd]
echo OPV XM40 csd $&s1_xm40_csd
let s1_xm40_css = @m.x1.xdut.xm40.msky130_fd_pr__nfet_01v8_lvt[css]
echo OPV XM40 css $&s1_xm40_css
let s1_xm40_csb = @m.x1.xdut.xm40.msky130_fd_pr__nfet_01v8_lvt[csb]
echo OPV XM40 csb $&s1_xm40_csb
let s1_xm40_cbg = @m.x1.xdut.xm40.msky130_fd_pr__nfet_01v8_lvt[cbg]
echo OPV XM40 cbg $&s1_xm40_cbg
let s1_xm40_cbd = @m.x1.xdut.xm40.msky130_fd_pr__nfet_01v8_lvt[cbd]
echo OPV XM40 cbd $&s1_xm40_cbd
let s1_xm40_cbs = @m.x1.xdut.xm40.msky130_fd_pr__nfet_01v8_lvt[cbs]
echo OPV XM40 cbs $&s1_xm40_cbs
let s1_xm40_cbb = @m.x1.xdut.xm40.msky130_fd_pr__nfet_01v8_lvt[cbb]
echo OPV XM40 cbb $&s1_xm40_cbb
let s1_xm40_capbd = @m.x1.xdut.xm40.msky130_fd_pr__nfet_01v8_lvt[capbd]
echo OPV XM40 capbd $&s1_xm40_capbd
let s1_xm40_capbs = @m.x1.xdut.xm40.msky130_fd_pr__nfet_01v8_lvt[capbs]
echo OPV XM40 capbs $&s1_xm40_capbs
let s1_xm40_cgso = @m.x1.xdut.xm40.msky130_fd_pr__nfet_01v8_lvt[cgso]
echo OPV XM40 cgso $&s1_xm40_cgso
let s1_xm40_cgdo = @m.x1.xdut.xm40.msky130_fd_pr__nfet_01v8_lvt[cgdo]
echo OPV XM40 cgdo $&s1_xm40_cgdo
let s1_xm40_cgbo = @m.x1.xdut.xm40.msky130_fd_pr__nfet_01v8_lvt[cgbo]
echo OPV XM40 cgbo $&s1_xm40_cgbo
let s1_xm40_weff = @m.x1.xdut.xm40.msky130_fd_pr__nfet_01v8_lvt[weff]
echo OPV XM40 weff $&s1_xm40_weff
let s1_xm40_leff = @m.x1.xdut.xm40.msky130_fd_pr__nfet_01v8_lvt[leff]
echo OPV XM40 leff $&s1_xm40_leff
let s1_xm41_id = @m.x1.xdut.xm41.msky130_fd_pr__nfet_01v8_lvt[id]
echo OPV XM41 id $&s1_xm41_id
let s1_xm41_vgs = @m.x1.xdut.xm41.msky130_fd_pr__nfet_01v8_lvt[vgs]
echo OPV XM41 vgs $&s1_xm41_vgs
let s1_xm41_vds = @m.x1.xdut.xm41.msky130_fd_pr__nfet_01v8_lvt[vds]
echo OPV XM41 vds $&s1_xm41_vds
let s1_xm41_vbs = @m.x1.xdut.xm41.msky130_fd_pr__nfet_01v8_lvt[vbs]
echo OPV XM41 vbs $&s1_xm41_vbs
let s1_xm41_vth = @m.x1.xdut.xm41.msky130_fd_pr__nfet_01v8_lvt[vth]
echo OPV XM41 vth $&s1_xm41_vth
let s1_xm41_vdsat = @m.x1.xdut.xm41.msky130_fd_pr__nfet_01v8_lvt[vdsat]
echo OPV XM41 vdsat $&s1_xm41_vdsat
let s1_xm41_gm = @m.x1.xdut.xm41.msky130_fd_pr__nfet_01v8_lvt[gm]
echo OPV XM41 gm $&s1_xm41_gm
let s1_xm41_gds = @m.x1.xdut.xm41.msky130_fd_pr__nfet_01v8_lvt[gds]
echo OPV XM41 gds $&s1_xm41_gds
let s1_xm41_gmbs = @m.x1.xdut.xm41.msky130_fd_pr__nfet_01v8_lvt[gmbs]
echo OPV XM41 gmbs $&s1_xm41_gmbs
let s1_xm41_cgg = @m.x1.xdut.xm41.msky130_fd_pr__nfet_01v8_lvt[cgg]
echo OPV XM41 cgg $&s1_xm41_cgg
let s1_xm41_cgd = @m.x1.xdut.xm41.msky130_fd_pr__nfet_01v8_lvt[cgd]
echo OPV XM41 cgd $&s1_xm41_cgd
let s1_xm41_cgs = @m.x1.xdut.xm41.msky130_fd_pr__nfet_01v8_lvt[cgs]
echo OPV XM41 cgs $&s1_xm41_cgs
let s1_xm41_cgb = @m.x1.xdut.xm41.msky130_fd_pr__nfet_01v8_lvt[cgb]
echo OPV XM41 cgb $&s1_xm41_cgb
let s1_xm41_cdg = @m.x1.xdut.xm41.msky130_fd_pr__nfet_01v8_lvt[cdg]
echo OPV XM41 cdg $&s1_xm41_cdg
let s1_xm41_cdd = @m.x1.xdut.xm41.msky130_fd_pr__nfet_01v8_lvt[cdd]
echo OPV XM41 cdd $&s1_xm41_cdd
let s1_xm41_cds = @m.x1.xdut.xm41.msky130_fd_pr__nfet_01v8_lvt[cds]
echo OPV XM41 cds $&s1_xm41_cds
let s1_xm41_cdb = @m.x1.xdut.xm41.msky130_fd_pr__nfet_01v8_lvt[cdb]
echo OPV XM41 cdb $&s1_xm41_cdb
let s1_xm41_csg = @m.x1.xdut.xm41.msky130_fd_pr__nfet_01v8_lvt[csg]
echo OPV XM41 csg $&s1_xm41_csg
let s1_xm41_csd = @m.x1.xdut.xm41.msky130_fd_pr__nfet_01v8_lvt[csd]
echo OPV XM41 csd $&s1_xm41_csd
let s1_xm41_css = @m.x1.xdut.xm41.msky130_fd_pr__nfet_01v8_lvt[css]
echo OPV XM41 css $&s1_xm41_css
let s1_xm41_csb = @m.x1.xdut.xm41.msky130_fd_pr__nfet_01v8_lvt[csb]
echo OPV XM41 csb $&s1_xm41_csb
let s1_xm41_cbg = @m.x1.xdut.xm41.msky130_fd_pr__nfet_01v8_lvt[cbg]
echo OPV XM41 cbg $&s1_xm41_cbg
let s1_xm41_cbd = @m.x1.xdut.xm41.msky130_fd_pr__nfet_01v8_lvt[cbd]
echo OPV XM41 cbd $&s1_xm41_cbd
let s1_xm41_cbs = @m.x1.xdut.xm41.msky130_fd_pr__nfet_01v8_lvt[cbs]
echo OPV XM41 cbs $&s1_xm41_cbs
let s1_xm41_cbb = @m.x1.xdut.xm41.msky130_fd_pr__nfet_01v8_lvt[cbb]
echo OPV XM41 cbb $&s1_xm41_cbb
let s1_xm41_capbd = @m.x1.xdut.xm41.msky130_fd_pr__nfet_01v8_lvt[capbd]
echo OPV XM41 capbd $&s1_xm41_capbd
let s1_xm41_capbs = @m.x1.xdut.xm41.msky130_fd_pr__nfet_01v8_lvt[capbs]
echo OPV XM41 capbs $&s1_xm41_capbs
let s1_xm41_cgso = @m.x1.xdut.xm41.msky130_fd_pr__nfet_01v8_lvt[cgso]
echo OPV XM41 cgso $&s1_xm41_cgso
let s1_xm41_cgdo = @m.x1.xdut.xm41.msky130_fd_pr__nfet_01v8_lvt[cgdo]
echo OPV XM41 cgdo $&s1_xm41_cgdo
let s1_xm41_cgbo = @m.x1.xdut.xm41.msky130_fd_pr__nfet_01v8_lvt[cgbo]
echo OPV XM41 cgbo $&s1_xm41_cgbo
let s1_xm41_weff = @m.x1.xdut.xm41.msky130_fd_pr__nfet_01v8_lvt[weff]
echo OPV XM41 weff $&s1_xm41_weff
let s1_xm41_leff = @m.x1.xdut.xm41.msky130_fd_pr__nfet_01v8_lvt[leff]
echo OPV XM41 leff $&s1_xm41_leff
let s1_xm42_id = @m.x1.xdut.xm42.msky130_fd_pr__pfet_01v8_lvt[id]
echo OPV XM42 id $&s1_xm42_id
let s1_xm42_vgs = @m.x1.xdut.xm42.msky130_fd_pr__pfet_01v8_lvt[vgs]
echo OPV XM42 vgs $&s1_xm42_vgs
let s1_xm42_vds = @m.x1.xdut.xm42.msky130_fd_pr__pfet_01v8_lvt[vds]
echo OPV XM42 vds $&s1_xm42_vds
let s1_xm42_vbs = @m.x1.xdut.xm42.msky130_fd_pr__pfet_01v8_lvt[vbs]
echo OPV XM42 vbs $&s1_xm42_vbs
let s1_xm42_vth = @m.x1.xdut.xm42.msky130_fd_pr__pfet_01v8_lvt[vth]
echo OPV XM42 vth $&s1_xm42_vth
let s1_xm42_vdsat = @m.x1.xdut.xm42.msky130_fd_pr__pfet_01v8_lvt[vdsat]
echo OPV XM42 vdsat $&s1_xm42_vdsat
let s1_xm42_gm = @m.x1.xdut.xm42.msky130_fd_pr__pfet_01v8_lvt[gm]
echo OPV XM42 gm $&s1_xm42_gm
let s1_xm42_gds = @m.x1.xdut.xm42.msky130_fd_pr__pfet_01v8_lvt[gds]
echo OPV XM42 gds $&s1_xm42_gds
let s1_xm42_gmbs = @m.x1.xdut.xm42.msky130_fd_pr__pfet_01v8_lvt[gmbs]
echo OPV XM42 gmbs $&s1_xm42_gmbs
let s1_xm42_cgg = @m.x1.xdut.xm42.msky130_fd_pr__pfet_01v8_lvt[cgg]
echo OPV XM42 cgg $&s1_xm42_cgg
let s1_xm42_cgd = @m.x1.xdut.xm42.msky130_fd_pr__pfet_01v8_lvt[cgd]
echo OPV XM42 cgd $&s1_xm42_cgd
let s1_xm42_cgs = @m.x1.xdut.xm42.msky130_fd_pr__pfet_01v8_lvt[cgs]
echo OPV XM42 cgs $&s1_xm42_cgs
let s1_xm42_cgb = @m.x1.xdut.xm42.msky130_fd_pr__pfet_01v8_lvt[cgb]
echo OPV XM42 cgb $&s1_xm42_cgb
let s1_xm42_cdg = @m.x1.xdut.xm42.msky130_fd_pr__pfet_01v8_lvt[cdg]
echo OPV XM42 cdg $&s1_xm42_cdg
let s1_xm42_cdd = @m.x1.xdut.xm42.msky130_fd_pr__pfet_01v8_lvt[cdd]
echo OPV XM42 cdd $&s1_xm42_cdd
let s1_xm42_cds = @m.x1.xdut.xm42.msky130_fd_pr__pfet_01v8_lvt[cds]
echo OPV XM42 cds $&s1_xm42_cds
let s1_xm42_cdb = @m.x1.xdut.xm42.msky130_fd_pr__pfet_01v8_lvt[cdb]
echo OPV XM42 cdb $&s1_xm42_cdb
let s1_xm42_csg = @m.x1.xdut.xm42.msky130_fd_pr__pfet_01v8_lvt[csg]
echo OPV XM42 csg $&s1_xm42_csg
let s1_xm42_csd = @m.x1.xdut.xm42.msky130_fd_pr__pfet_01v8_lvt[csd]
echo OPV XM42 csd $&s1_xm42_csd
let s1_xm42_css = @m.x1.xdut.xm42.msky130_fd_pr__pfet_01v8_lvt[css]
echo OPV XM42 css $&s1_xm42_css
let s1_xm42_csb = @m.x1.xdut.xm42.msky130_fd_pr__pfet_01v8_lvt[csb]
echo OPV XM42 csb $&s1_xm42_csb
let s1_xm42_cbg = @m.x1.xdut.xm42.msky130_fd_pr__pfet_01v8_lvt[cbg]
echo OPV XM42 cbg $&s1_xm42_cbg
let s1_xm42_cbd = @m.x1.xdut.xm42.msky130_fd_pr__pfet_01v8_lvt[cbd]
echo OPV XM42 cbd $&s1_xm42_cbd
let s1_xm42_cbs = @m.x1.xdut.xm42.msky130_fd_pr__pfet_01v8_lvt[cbs]
echo OPV XM42 cbs $&s1_xm42_cbs
let s1_xm42_cbb = @m.x1.xdut.xm42.msky130_fd_pr__pfet_01v8_lvt[cbb]
echo OPV XM42 cbb $&s1_xm42_cbb
let s1_xm42_capbd = @m.x1.xdut.xm42.msky130_fd_pr__pfet_01v8_lvt[capbd]
echo OPV XM42 capbd $&s1_xm42_capbd
let s1_xm42_capbs = @m.x1.xdut.xm42.msky130_fd_pr__pfet_01v8_lvt[capbs]
echo OPV XM42 capbs $&s1_xm42_capbs
let s1_xm42_cgso = @m.x1.xdut.xm42.msky130_fd_pr__pfet_01v8_lvt[cgso]
echo OPV XM42 cgso $&s1_xm42_cgso
let s1_xm42_cgdo = @m.x1.xdut.xm42.msky130_fd_pr__pfet_01v8_lvt[cgdo]
echo OPV XM42 cgdo $&s1_xm42_cgdo
let s1_xm42_cgbo = @m.x1.xdut.xm42.msky130_fd_pr__pfet_01v8_lvt[cgbo]
echo OPV XM42 cgbo $&s1_xm42_cgbo
let s1_xm42_weff = @m.x1.xdut.xm42.msky130_fd_pr__pfet_01v8_lvt[weff]
echo OPV XM42 weff $&s1_xm42_weff
let s1_xm42_leff = @m.x1.xdut.xm42.msky130_fd_pr__pfet_01v8_lvt[leff]
echo OPV XM42 leff $&s1_xm42_leff
let s1_xm43_id = @m.x1.xdut.xm43.msky130_fd_pr__pfet_01v8_lvt[id]
echo OPV XM43 id $&s1_xm43_id
let s1_xm43_vgs = @m.x1.xdut.xm43.msky130_fd_pr__pfet_01v8_lvt[vgs]
echo OPV XM43 vgs $&s1_xm43_vgs
let s1_xm43_vds = @m.x1.xdut.xm43.msky130_fd_pr__pfet_01v8_lvt[vds]
echo OPV XM43 vds $&s1_xm43_vds
let s1_xm43_vbs = @m.x1.xdut.xm43.msky130_fd_pr__pfet_01v8_lvt[vbs]
echo OPV XM43 vbs $&s1_xm43_vbs
let s1_xm43_vth = @m.x1.xdut.xm43.msky130_fd_pr__pfet_01v8_lvt[vth]
echo OPV XM43 vth $&s1_xm43_vth
let s1_xm43_vdsat = @m.x1.xdut.xm43.msky130_fd_pr__pfet_01v8_lvt[vdsat]
echo OPV XM43 vdsat $&s1_xm43_vdsat
let s1_xm43_gm = @m.x1.xdut.xm43.msky130_fd_pr__pfet_01v8_lvt[gm]
echo OPV XM43 gm $&s1_xm43_gm
let s1_xm43_gds = @m.x1.xdut.xm43.msky130_fd_pr__pfet_01v8_lvt[gds]
echo OPV XM43 gds $&s1_xm43_gds
let s1_xm43_gmbs = @m.x1.xdut.xm43.msky130_fd_pr__pfet_01v8_lvt[gmbs]
echo OPV XM43 gmbs $&s1_xm43_gmbs
let s1_xm43_cgg = @m.x1.xdut.xm43.msky130_fd_pr__pfet_01v8_lvt[cgg]
echo OPV XM43 cgg $&s1_xm43_cgg
let s1_xm43_cgd = @m.x1.xdut.xm43.msky130_fd_pr__pfet_01v8_lvt[cgd]
echo OPV XM43 cgd $&s1_xm43_cgd
let s1_xm43_cgs = @m.x1.xdut.xm43.msky130_fd_pr__pfet_01v8_lvt[cgs]
echo OPV XM43 cgs $&s1_xm43_cgs
let s1_xm43_cgb = @m.x1.xdut.xm43.msky130_fd_pr__pfet_01v8_lvt[cgb]
echo OPV XM43 cgb $&s1_xm43_cgb
let s1_xm43_cdg = @m.x1.xdut.xm43.msky130_fd_pr__pfet_01v8_lvt[cdg]
echo OPV XM43 cdg $&s1_xm43_cdg
let s1_xm43_cdd = @m.x1.xdut.xm43.msky130_fd_pr__pfet_01v8_lvt[cdd]
echo OPV XM43 cdd $&s1_xm43_cdd
let s1_xm43_cds = @m.x1.xdut.xm43.msky130_fd_pr__pfet_01v8_lvt[cds]
echo OPV XM43 cds $&s1_xm43_cds
let s1_xm43_cdb = @m.x1.xdut.xm43.msky130_fd_pr__pfet_01v8_lvt[cdb]
echo OPV XM43 cdb $&s1_xm43_cdb
let s1_xm43_csg = @m.x1.xdut.xm43.msky130_fd_pr__pfet_01v8_lvt[csg]
echo OPV XM43 csg $&s1_xm43_csg
let s1_xm43_csd = @m.x1.xdut.xm43.msky130_fd_pr__pfet_01v8_lvt[csd]
echo OPV XM43 csd $&s1_xm43_csd
let s1_xm43_css = @m.x1.xdut.xm43.msky130_fd_pr__pfet_01v8_lvt[css]
echo OPV XM43 css $&s1_xm43_css
let s1_xm43_csb = @m.x1.xdut.xm43.msky130_fd_pr__pfet_01v8_lvt[csb]
echo OPV XM43 csb $&s1_xm43_csb
let s1_xm43_cbg = @m.x1.xdut.xm43.msky130_fd_pr__pfet_01v8_lvt[cbg]
echo OPV XM43 cbg $&s1_xm43_cbg
let s1_xm43_cbd = @m.x1.xdut.xm43.msky130_fd_pr__pfet_01v8_lvt[cbd]
echo OPV XM43 cbd $&s1_xm43_cbd
let s1_xm43_cbs = @m.x1.xdut.xm43.msky130_fd_pr__pfet_01v8_lvt[cbs]
echo OPV XM43 cbs $&s1_xm43_cbs
let s1_xm43_cbb = @m.x1.xdut.xm43.msky130_fd_pr__pfet_01v8_lvt[cbb]
echo OPV XM43 cbb $&s1_xm43_cbb
let s1_xm43_capbd = @m.x1.xdut.xm43.msky130_fd_pr__pfet_01v8_lvt[capbd]
echo OPV XM43 capbd $&s1_xm43_capbd
let s1_xm43_capbs = @m.x1.xdut.xm43.msky130_fd_pr__pfet_01v8_lvt[capbs]
echo OPV XM43 capbs $&s1_xm43_capbs
let s1_xm43_cgso = @m.x1.xdut.xm43.msky130_fd_pr__pfet_01v8_lvt[cgso]
echo OPV XM43 cgso $&s1_xm43_cgso
let s1_xm43_cgdo = @m.x1.xdut.xm43.msky130_fd_pr__pfet_01v8_lvt[cgdo]
echo OPV XM43 cgdo $&s1_xm43_cgdo
let s1_xm43_cgbo = @m.x1.xdut.xm43.msky130_fd_pr__pfet_01v8_lvt[cgbo]
echo OPV XM43 cgbo $&s1_xm43_cgbo
let s1_xm43_weff = @m.x1.xdut.xm43.msky130_fd_pr__pfet_01v8_lvt[weff]
echo OPV XM43 weff $&s1_xm43_weff
let s1_xm43_leff = @m.x1.xdut.xm43.msky130_fd_pr__pfet_01v8_lvt[leff]
echo OPV XM43 leff $&s1_xm43_leff
let s1_xm44_id = @m.x1.xdut.xm44.msky130_fd_pr__pfet_01v8_lvt[id]
echo OPV XM44 id $&s1_xm44_id
let s1_xm44_vgs = @m.x1.xdut.xm44.msky130_fd_pr__pfet_01v8_lvt[vgs]
echo OPV XM44 vgs $&s1_xm44_vgs
let s1_xm44_vds = @m.x1.xdut.xm44.msky130_fd_pr__pfet_01v8_lvt[vds]
echo OPV XM44 vds $&s1_xm44_vds
let s1_xm44_vbs = @m.x1.xdut.xm44.msky130_fd_pr__pfet_01v8_lvt[vbs]
echo OPV XM44 vbs $&s1_xm44_vbs
let s1_xm44_vth = @m.x1.xdut.xm44.msky130_fd_pr__pfet_01v8_lvt[vth]
echo OPV XM44 vth $&s1_xm44_vth
let s1_xm44_vdsat = @m.x1.xdut.xm44.msky130_fd_pr__pfet_01v8_lvt[vdsat]
echo OPV XM44 vdsat $&s1_xm44_vdsat
let s1_xm44_gm = @m.x1.xdut.xm44.msky130_fd_pr__pfet_01v8_lvt[gm]
echo OPV XM44 gm $&s1_xm44_gm
let s1_xm44_gds = @m.x1.xdut.xm44.msky130_fd_pr__pfet_01v8_lvt[gds]
echo OPV XM44 gds $&s1_xm44_gds
let s1_xm44_gmbs = @m.x1.xdut.xm44.msky130_fd_pr__pfet_01v8_lvt[gmbs]
echo OPV XM44 gmbs $&s1_xm44_gmbs
let s1_xm44_cgg = @m.x1.xdut.xm44.msky130_fd_pr__pfet_01v8_lvt[cgg]
echo OPV XM44 cgg $&s1_xm44_cgg
let s1_xm44_cgd = @m.x1.xdut.xm44.msky130_fd_pr__pfet_01v8_lvt[cgd]
echo OPV XM44 cgd $&s1_xm44_cgd
let s1_xm44_cgs = @m.x1.xdut.xm44.msky130_fd_pr__pfet_01v8_lvt[cgs]
echo OPV XM44 cgs $&s1_xm44_cgs
let s1_xm44_cgb = @m.x1.xdut.xm44.msky130_fd_pr__pfet_01v8_lvt[cgb]
echo OPV XM44 cgb $&s1_xm44_cgb
let s1_xm44_cdg = @m.x1.xdut.xm44.msky130_fd_pr__pfet_01v8_lvt[cdg]
echo OPV XM44 cdg $&s1_xm44_cdg
let s1_xm44_cdd = @m.x1.xdut.xm44.msky130_fd_pr__pfet_01v8_lvt[cdd]
echo OPV XM44 cdd $&s1_xm44_cdd
let s1_xm44_cds = @m.x1.xdut.xm44.msky130_fd_pr__pfet_01v8_lvt[cds]
echo OPV XM44 cds $&s1_xm44_cds
let s1_xm44_cdb = @m.x1.xdut.xm44.msky130_fd_pr__pfet_01v8_lvt[cdb]
echo OPV XM44 cdb $&s1_xm44_cdb
let s1_xm44_csg = @m.x1.xdut.xm44.msky130_fd_pr__pfet_01v8_lvt[csg]
echo OPV XM44 csg $&s1_xm44_csg
let s1_xm44_csd = @m.x1.xdut.xm44.msky130_fd_pr__pfet_01v8_lvt[csd]
echo OPV XM44 csd $&s1_xm44_csd
let s1_xm44_css = @m.x1.xdut.xm44.msky130_fd_pr__pfet_01v8_lvt[css]
echo OPV XM44 css $&s1_xm44_css
let s1_xm44_csb = @m.x1.xdut.xm44.msky130_fd_pr__pfet_01v8_lvt[csb]
echo OPV XM44 csb $&s1_xm44_csb
let s1_xm44_cbg = @m.x1.xdut.xm44.msky130_fd_pr__pfet_01v8_lvt[cbg]
echo OPV XM44 cbg $&s1_xm44_cbg
let s1_xm44_cbd = @m.x1.xdut.xm44.msky130_fd_pr__pfet_01v8_lvt[cbd]
echo OPV XM44 cbd $&s1_xm44_cbd
let s1_xm44_cbs = @m.x1.xdut.xm44.msky130_fd_pr__pfet_01v8_lvt[cbs]
echo OPV XM44 cbs $&s1_xm44_cbs
let s1_xm44_cbb = @m.x1.xdut.xm44.msky130_fd_pr__pfet_01v8_lvt[cbb]
echo OPV XM44 cbb $&s1_xm44_cbb
let s1_xm44_capbd = @m.x1.xdut.xm44.msky130_fd_pr__pfet_01v8_lvt[capbd]
echo OPV XM44 capbd $&s1_xm44_capbd
let s1_xm44_capbs = @m.x1.xdut.xm44.msky130_fd_pr__pfet_01v8_lvt[capbs]
echo OPV XM44 capbs $&s1_xm44_capbs
let s1_xm44_cgso = @m.x1.xdut.xm44.msky130_fd_pr__pfet_01v8_lvt[cgso]
echo OPV XM44 cgso $&s1_xm44_cgso
let s1_xm44_cgdo = @m.x1.xdut.xm44.msky130_fd_pr__pfet_01v8_lvt[cgdo]
echo OPV XM44 cgdo $&s1_xm44_cgdo
let s1_xm44_cgbo = @m.x1.xdut.xm44.msky130_fd_pr__pfet_01v8_lvt[cgbo]
echo OPV XM44 cgbo $&s1_xm44_cgbo
let s1_xm44_weff = @m.x1.xdut.xm44.msky130_fd_pr__pfet_01v8_lvt[weff]
echo OPV XM44 weff $&s1_xm44_weff
let s1_xm44_leff = @m.x1.xdut.xm44.msky130_fd_pr__pfet_01v8_lvt[leff]
echo OPV XM44 leff $&s1_xm44_leff
let s1_xm45_id = @m.x1.xdut.xm45.msky130_fd_pr__pfet_01v8_lvt[id]
echo OPV XM45 id $&s1_xm45_id
let s1_xm45_vgs = @m.x1.xdut.xm45.msky130_fd_pr__pfet_01v8_lvt[vgs]
echo OPV XM45 vgs $&s1_xm45_vgs
let s1_xm45_vds = @m.x1.xdut.xm45.msky130_fd_pr__pfet_01v8_lvt[vds]
echo OPV XM45 vds $&s1_xm45_vds
let s1_xm45_vbs = @m.x1.xdut.xm45.msky130_fd_pr__pfet_01v8_lvt[vbs]
echo OPV XM45 vbs $&s1_xm45_vbs
let s1_xm45_vth = @m.x1.xdut.xm45.msky130_fd_pr__pfet_01v8_lvt[vth]
echo OPV XM45 vth $&s1_xm45_vth
let s1_xm45_vdsat = @m.x1.xdut.xm45.msky130_fd_pr__pfet_01v8_lvt[vdsat]
echo OPV XM45 vdsat $&s1_xm45_vdsat
let s1_xm45_gm = @m.x1.xdut.xm45.msky130_fd_pr__pfet_01v8_lvt[gm]
echo OPV XM45 gm $&s1_xm45_gm
let s1_xm45_gds = @m.x1.xdut.xm45.msky130_fd_pr__pfet_01v8_lvt[gds]
echo OPV XM45 gds $&s1_xm45_gds
let s1_xm45_gmbs = @m.x1.xdut.xm45.msky130_fd_pr__pfet_01v8_lvt[gmbs]
echo OPV XM45 gmbs $&s1_xm45_gmbs
let s1_xm45_cgg = @m.x1.xdut.xm45.msky130_fd_pr__pfet_01v8_lvt[cgg]
echo OPV XM45 cgg $&s1_xm45_cgg
let s1_xm45_cgd = @m.x1.xdut.xm45.msky130_fd_pr__pfet_01v8_lvt[cgd]
echo OPV XM45 cgd $&s1_xm45_cgd
let s1_xm45_cgs = @m.x1.xdut.xm45.msky130_fd_pr__pfet_01v8_lvt[cgs]
echo OPV XM45 cgs $&s1_xm45_cgs
let s1_xm45_cgb = @m.x1.xdut.xm45.msky130_fd_pr__pfet_01v8_lvt[cgb]
echo OPV XM45 cgb $&s1_xm45_cgb
let s1_xm45_cdg = @m.x1.xdut.xm45.msky130_fd_pr__pfet_01v8_lvt[cdg]
echo OPV XM45 cdg $&s1_xm45_cdg
let s1_xm45_cdd = @m.x1.xdut.xm45.msky130_fd_pr__pfet_01v8_lvt[cdd]
echo OPV XM45 cdd $&s1_xm45_cdd
let s1_xm45_cds = @m.x1.xdut.xm45.msky130_fd_pr__pfet_01v8_lvt[cds]
echo OPV XM45 cds $&s1_xm45_cds
let s1_xm45_cdb = @m.x1.xdut.xm45.msky130_fd_pr__pfet_01v8_lvt[cdb]
echo OPV XM45 cdb $&s1_xm45_cdb
let s1_xm45_csg = @m.x1.xdut.xm45.msky130_fd_pr__pfet_01v8_lvt[csg]
echo OPV XM45 csg $&s1_xm45_csg
let s1_xm45_csd = @m.x1.xdut.xm45.msky130_fd_pr__pfet_01v8_lvt[csd]
echo OPV XM45 csd $&s1_xm45_csd
let s1_xm45_css = @m.x1.xdut.xm45.msky130_fd_pr__pfet_01v8_lvt[css]
echo OPV XM45 css $&s1_xm45_css
let s1_xm45_csb = @m.x1.xdut.xm45.msky130_fd_pr__pfet_01v8_lvt[csb]
echo OPV XM45 csb $&s1_xm45_csb
let s1_xm45_cbg = @m.x1.xdut.xm45.msky130_fd_pr__pfet_01v8_lvt[cbg]
echo OPV XM45 cbg $&s1_xm45_cbg
let s1_xm45_cbd = @m.x1.xdut.xm45.msky130_fd_pr__pfet_01v8_lvt[cbd]
echo OPV XM45 cbd $&s1_xm45_cbd
let s1_xm45_cbs = @m.x1.xdut.xm45.msky130_fd_pr__pfet_01v8_lvt[cbs]
echo OPV XM45 cbs $&s1_xm45_cbs
let s1_xm45_cbb = @m.x1.xdut.xm45.msky130_fd_pr__pfet_01v8_lvt[cbb]
echo OPV XM45 cbb $&s1_xm45_cbb
let s1_xm45_capbd = @m.x1.xdut.xm45.msky130_fd_pr__pfet_01v8_lvt[capbd]
echo OPV XM45 capbd $&s1_xm45_capbd
let s1_xm45_capbs = @m.x1.xdut.xm45.msky130_fd_pr__pfet_01v8_lvt[capbs]
echo OPV XM45 capbs $&s1_xm45_capbs
let s1_xm45_cgso = @m.x1.xdut.xm45.msky130_fd_pr__pfet_01v8_lvt[cgso]
echo OPV XM45 cgso $&s1_xm45_cgso
let s1_xm45_cgdo = @m.x1.xdut.xm45.msky130_fd_pr__pfet_01v8_lvt[cgdo]
echo OPV XM45 cgdo $&s1_xm45_cgdo
let s1_xm45_cgbo = @m.x1.xdut.xm45.msky130_fd_pr__pfet_01v8_lvt[cgbo]
echo OPV XM45 cgbo $&s1_xm45_cgbo
let s1_xm45_weff = @m.x1.xdut.xm45.msky130_fd_pr__pfet_01v8_lvt[weff]
echo OPV XM45 weff $&s1_xm45_weff
let s1_xm45_leff = @m.x1.xdut.xm45.msky130_fd_pr__pfet_01v8_lvt[leff]
echo OPV XM45 leff $&s1_xm45_leff
let s1_xm54_id = @m.x1.xdut.xm54.msky130_fd_pr__pfet_01v8_lvt[id]
echo OPV XM54 id $&s1_xm54_id
let s1_xm54_vgs = @m.x1.xdut.xm54.msky130_fd_pr__pfet_01v8_lvt[vgs]
echo OPV XM54 vgs $&s1_xm54_vgs
let s1_xm54_vds = @m.x1.xdut.xm54.msky130_fd_pr__pfet_01v8_lvt[vds]
echo OPV XM54 vds $&s1_xm54_vds
let s1_xm54_vbs = @m.x1.xdut.xm54.msky130_fd_pr__pfet_01v8_lvt[vbs]
echo OPV XM54 vbs $&s1_xm54_vbs
let s1_xm54_vth = @m.x1.xdut.xm54.msky130_fd_pr__pfet_01v8_lvt[vth]
echo OPV XM54 vth $&s1_xm54_vth
let s1_xm54_vdsat = @m.x1.xdut.xm54.msky130_fd_pr__pfet_01v8_lvt[vdsat]
echo OPV XM54 vdsat $&s1_xm54_vdsat
let s1_xm54_gm = @m.x1.xdut.xm54.msky130_fd_pr__pfet_01v8_lvt[gm]
echo OPV XM54 gm $&s1_xm54_gm
let s1_xm54_gds = @m.x1.xdut.xm54.msky130_fd_pr__pfet_01v8_lvt[gds]
echo OPV XM54 gds $&s1_xm54_gds
let s1_xm54_gmbs = @m.x1.xdut.xm54.msky130_fd_pr__pfet_01v8_lvt[gmbs]
echo OPV XM54 gmbs $&s1_xm54_gmbs
let s1_xm54_cgg = @m.x1.xdut.xm54.msky130_fd_pr__pfet_01v8_lvt[cgg]
echo OPV XM54 cgg $&s1_xm54_cgg
let s1_xm54_cgd = @m.x1.xdut.xm54.msky130_fd_pr__pfet_01v8_lvt[cgd]
echo OPV XM54 cgd $&s1_xm54_cgd
let s1_xm54_cgs = @m.x1.xdut.xm54.msky130_fd_pr__pfet_01v8_lvt[cgs]
echo OPV XM54 cgs $&s1_xm54_cgs
let s1_xm54_cgb = @m.x1.xdut.xm54.msky130_fd_pr__pfet_01v8_lvt[cgb]
echo OPV XM54 cgb $&s1_xm54_cgb
let s1_xm54_cdg = @m.x1.xdut.xm54.msky130_fd_pr__pfet_01v8_lvt[cdg]
echo OPV XM54 cdg $&s1_xm54_cdg
let s1_xm54_cdd = @m.x1.xdut.xm54.msky130_fd_pr__pfet_01v8_lvt[cdd]
echo OPV XM54 cdd $&s1_xm54_cdd
let s1_xm54_cds = @m.x1.xdut.xm54.msky130_fd_pr__pfet_01v8_lvt[cds]
echo OPV XM54 cds $&s1_xm54_cds
let s1_xm54_cdb = @m.x1.xdut.xm54.msky130_fd_pr__pfet_01v8_lvt[cdb]
echo OPV XM54 cdb $&s1_xm54_cdb
let s1_xm54_csg = @m.x1.xdut.xm54.msky130_fd_pr__pfet_01v8_lvt[csg]
echo OPV XM54 csg $&s1_xm54_csg
let s1_xm54_csd = @m.x1.xdut.xm54.msky130_fd_pr__pfet_01v8_lvt[csd]
echo OPV XM54 csd $&s1_xm54_csd
let s1_xm54_css = @m.x1.xdut.xm54.msky130_fd_pr__pfet_01v8_lvt[css]
echo OPV XM54 css $&s1_xm54_css
let s1_xm54_csb = @m.x1.xdut.xm54.msky130_fd_pr__pfet_01v8_lvt[csb]
echo OPV XM54 csb $&s1_xm54_csb
let s1_xm54_cbg = @m.x1.xdut.xm54.msky130_fd_pr__pfet_01v8_lvt[cbg]
echo OPV XM54 cbg $&s1_xm54_cbg
let s1_xm54_cbd = @m.x1.xdut.xm54.msky130_fd_pr__pfet_01v8_lvt[cbd]
echo OPV XM54 cbd $&s1_xm54_cbd
let s1_xm54_cbs = @m.x1.xdut.xm54.msky130_fd_pr__pfet_01v8_lvt[cbs]
echo OPV XM54 cbs $&s1_xm54_cbs
let s1_xm54_cbb = @m.x1.xdut.xm54.msky130_fd_pr__pfet_01v8_lvt[cbb]
echo OPV XM54 cbb $&s1_xm54_cbb
let s1_xm54_capbd = @m.x1.xdut.xm54.msky130_fd_pr__pfet_01v8_lvt[capbd]
echo OPV XM54 capbd $&s1_xm54_capbd
let s1_xm54_capbs = @m.x1.xdut.xm54.msky130_fd_pr__pfet_01v8_lvt[capbs]
echo OPV XM54 capbs $&s1_xm54_capbs
let s1_xm54_cgso = @m.x1.xdut.xm54.msky130_fd_pr__pfet_01v8_lvt[cgso]
echo OPV XM54 cgso $&s1_xm54_cgso
let s1_xm54_cgdo = @m.x1.xdut.xm54.msky130_fd_pr__pfet_01v8_lvt[cgdo]
echo OPV XM54 cgdo $&s1_xm54_cgdo
let s1_xm54_cgbo = @m.x1.xdut.xm54.msky130_fd_pr__pfet_01v8_lvt[cgbo]
echo OPV XM54 cgbo $&s1_xm54_cgbo
let s1_xm54_weff = @m.x1.xdut.xm54.msky130_fd_pr__pfet_01v8_lvt[weff]
echo OPV XM54 weff $&s1_xm54_weff
let s1_xm54_leff = @m.x1.xdut.xm54.msky130_fd_pr__pfet_01v8_lvt[leff]
echo OPV XM54 leff $&s1_xm54_leff
let s1_xx1_m5_id = @m.x1.xdut.xx1_m5.msky130_fd_pr__nfet_01v8_lvt[id]
echo OPV XX1_M5 id $&s1_xx1_m5_id
let s1_xx1_m5_vgs = @m.x1.xdut.xx1_m5.msky130_fd_pr__nfet_01v8_lvt[vgs]
echo OPV XX1_M5 vgs $&s1_xx1_m5_vgs
let s1_xx1_m5_vds = @m.x1.xdut.xx1_m5.msky130_fd_pr__nfet_01v8_lvt[vds]
echo OPV XX1_M5 vds $&s1_xx1_m5_vds
let s1_xx1_m5_vbs = @m.x1.xdut.xx1_m5.msky130_fd_pr__nfet_01v8_lvt[vbs]
echo OPV XX1_M5 vbs $&s1_xx1_m5_vbs
let s1_xx1_m5_vth = @m.x1.xdut.xx1_m5.msky130_fd_pr__nfet_01v8_lvt[vth]
echo OPV XX1_M5 vth $&s1_xx1_m5_vth
let s1_xx1_m5_vdsat = @m.x1.xdut.xx1_m5.msky130_fd_pr__nfet_01v8_lvt[vdsat]
echo OPV XX1_M5 vdsat $&s1_xx1_m5_vdsat
let s1_xx1_m5_gm = @m.x1.xdut.xx1_m5.msky130_fd_pr__nfet_01v8_lvt[gm]
echo OPV XX1_M5 gm $&s1_xx1_m5_gm
let s1_xx1_m5_gds = @m.x1.xdut.xx1_m5.msky130_fd_pr__nfet_01v8_lvt[gds]
echo OPV XX1_M5 gds $&s1_xx1_m5_gds
let s1_xx1_m5_gmbs = @m.x1.xdut.xx1_m5.msky130_fd_pr__nfet_01v8_lvt[gmbs]
echo OPV XX1_M5 gmbs $&s1_xx1_m5_gmbs
let s1_xx1_m5_cgg = @m.x1.xdut.xx1_m5.msky130_fd_pr__nfet_01v8_lvt[cgg]
echo OPV XX1_M5 cgg $&s1_xx1_m5_cgg
let s1_xx1_m5_cgd = @m.x1.xdut.xx1_m5.msky130_fd_pr__nfet_01v8_lvt[cgd]
echo OPV XX1_M5 cgd $&s1_xx1_m5_cgd
let s1_xx1_m5_cgs = @m.x1.xdut.xx1_m5.msky130_fd_pr__nfet_01v8_lvt[cgs]
echo OPV XX1_M5 cgs $&s1_xx1_m5_cgs
let s1_xx1_m5_cgb = @m.x1.xdut.xx1_m5.msky130_fd_pr__nfet_01v8_lvt[cgb]
echo OPV XX1_M5 cgb $&s1_xx1_m5_cgb
let s1_xx1_m5_cdg = @m.x1.xdut.xx1_m5.msky130_fd_pr__nfet_01v8_lvt[cdg]
echo OPV XX1_M5 cdg $&s1_xx1_m5_cdg
let s1_xx1_m5_cdd = @m.x1.xdut.xx1_m5.msky130_fd_pr__nfet_01v8_lvt[cdd]
echo OPV XX1_M5 cdd $&s1_xx1_m5_cdd
let s1_xx1_m5_cds = @m.x1.xdut.xx1_m5.msky130_fd_pr__nfet_01v8_lvt[cds]
echo OPV XX1_M5 cds $&s1_xx1_m5_cds
let s1_xx1_m5_cdb = @m.x1.xdut.xx1_m5.msky130_fd_pr__nfet_01v8_lvt[cdb]
echo OPV XX1_M5 cdb $&s1_xx1_m5_cdb
let s1_xx1_m5_csg = @m.x1.xdut.xx1_m5.msky130_fd_pr__nfet_01v8_lvt[csg]
echo OPV XX1_M5 csg $&s1_xx1_m5_csg
let s1_xx1_m5_csd = @m.x1.xdut.xx1_m5.msky130_fd_pr__nfet_01v8_lvt[csd]
echo OPV XX1_M5 csd $&s1_xx1_m5_csd
let s1_xx1_m5_css = @m.x1.xdut.xx1_m5.msky130_fd_pr__nfet_01v8_lvt[css]
echo OPV XX1_M5 css $&s1_xx1_m5_css
let s1_xx1_m5_csb = @m.x1.xdut.xx1_m5.msky130_fd_pr__nfet_01v8_lvt[csb]
echo OPV XX1_M5 csb $&s1_xx1_m5_csb
let s1_xx1_m5_cbg = @m.x1.xdut.xx1_m5.msky130_fd_pr__nfet_01v8_lvt[cbg]
echo OPV XX1_M5 cbg $&s1_xx1_m5_cbg
let s1_xx1_m5_cbd = @m.x1.xdut.xx1_m5.msky130_fd_pr__nfet_01v8_lvt[cbd]
echo OPV XX1_M5 cbd $&s1_xx1_m5_cbd
let s1_xx1_m5_cbs = @m.x1.xdut.xx1_m5.msky130_fd_pr__nfet_01v8_lvt[cbs]
echo OPV XX1_M5 cbs $&s1_xx1_m5_cbs
let s1_xx1_m5_cbb = @m.x1.xdut.xx1_m5.msky130_fd_pr__nfet_01v8_lvt[cbb]
echo OPV XX1_M5 cbb $&s1_xx1_m5_cbb
let s1_xx1_m5_capbd = @m.x1.xdut.xx1_m5.msky130_fd_pr__nfet_01v8_lvt[capbd]
echo OPV XX1_M5 capbd $&s1_xx1_m5_capbd
let s1_xx1_m5_capbs = @m.x1.xdut.xx1_m5.msky130_fd_pr__nfet_01v8_lvt[capbs]
echo OPV XX1_M5 capbs $&s1_xx1_m5_capbs
let s1_xx1_m5_cgso = @m.x1.xdut.xx1_m5.msky130_fd_pr__nfet_01v8_lvt[cgso]
echo OPV XX1_M5 cgso $&s1_xx1_m5_cgso
let s1_xx1_m5_cgdo = @m.x1.xdut.xx1_m5.msky130_fd_pr__nfet_01v8_lvt[cgdo]
echo OPV XX1_M5 cgdo $&s1_xx1_m5_cgdo
let s1_xx1_m5_cgbo = @m.x1.xdut.xx1_m5.msky130_fd_pr__nfet_01v8_lvt[cgbo]
echo OPV XX1_M5 cgbo $&s1_xx1_m5_cgbo
let s1_xx1_m5_weff = @m.x1.xdut.xx1_m5.msky130_fd_pr__nfet_01v8_lvt[weff]
echo OPV XX1_M5 weff $&s1_xx1_m5_weff
let s1_xx1_m5_leff = @m.x1.xdut.xx1_m5.msky130_fd_pr__nfet_01v8_lvt[leff]
echo OPV XX1_M5 leff $&s1_xx1_m5_leff
let s1_xx1_m6_id = @m.x1.xdut.xx1_m6.msky130_fd_pr__nfet_01v8_lvt[id]
echo OPV XX1_M6 id $&s1_xx1_m6_id
let s1_xx1_m6_vgs = @m.x1.xdut.xx1_m6.msky130_fd_pr__nfet_01v8_lvt[vgs]
echo OPV XX1_M6 vgs $&s1_xx1_m6_vgs
let s1_xx1_m6_vds = @m.x1.xdut.xx1_m6.msky130_fd_pr__nfet_01v8_lvt[vds]
echo OPV XX1_M6 vds $&s1_xx1_m6_vds
let s1_xx1_m6_vbs = @m.x1.xdut.xx1_m6.msky130_fd_pr__nfet_01v8_lvt[vbs]
echo OPV XX1_M6 vbs $&s1_xx1_m6_vbs
let s1_xx1_m6_vth = @m.x1.xdut.xx1_m6.msky130_fd_pr__nfet_01v8_lvt[vth]
echo OPV XX1_M6 vth $&s1_xx1_m6_vth
let s1_xx1_m6_vdsat = @m.x1.xdut.xx1_m6.msky130_fd_pr__nfet_01v8_lvt[vdsat]
echo OPV XX1_M6 vdsat $&s1_xx1_m6_vdsat
let s1_xx1_m6_gm = @m.x1.xdut.xx1_m6.msky130_fd_pr__nfet_01v8_lvt[gm]
echo OPV XX1_M6 gm $&s1_xx1_m6_gm
let s1_xx1_m6_gds = @m.x1.xdut.xx1_m6.msky130_fd_pr__nfet_01v8_lvt[gds]
echo OPV XX1_M6 gds $&s1_xx1_m6_gds
let s1_xx1_m6_gmbs = @m.x1.xdut.xx1_m6.msky130_fd_pr__nfet_01v8_lvt[gmbs]
echo OPV XX1_M6 gmbs $&s1_xx1_m6_gmbs
let s1_xx1_m6_cgg = @m.x1.xdut.xx1_m6.msky130_fd_pr__nfet_01v8_lvt[cgg]
echo OPV XX1_M6 cgg $&s1_xx1_m6_cgg
let s1_xx1_m6_cgd = @m.x1.xdut.xx1_m6.msky130_fd_pr__nfet_01v8_lvt[cgd]
echo OPV XX1_M6 cgd $&s1_xx1_m6_cgd
let s1_xx1_m6_cgs = @m.x1.xdut.xx1_m6.msky130_fd_pr__nfet_01v8_lvt[cgs]
echo OPV XX1_M6 cgs $&s1_xx1_m6_cgs
let s1_xx1_m6_cgb = @m.x1.xdut.xx1_m6.msky130_fd_pr__nfet_01v8_lvt[cgb]
echo OPV XX1_M6 cgb $&s1_xx1_m6_cgb
let s1_xx1_m6_cdg = @m.x1.xdut.xx1_m6.msky130_fd_pr__nfet_01v8_lvt[cdg]
echo OPV XX1_M6 cdg $&s1_xx1_m6_cdg
let s1_xx1_m6_cdd = @m.x1.xdut.xx1_m6.msky130_fd_pr__nfet_01v8_lvt[cdd]
echo OPV XX1_M6 cdd $&s1_xx1_m6_cdd
let s1_xx1_m6_cds = @m.x1.xdut.xx1_m6.msky130_fd_pr__nfet_01v8_lvt[cds]
echo OPV XX1_M6 cds $&s1_xx1_m6_cds
let s1_xx1_m6_cdb = @m.x1.xdut.xx1_m6.msky130_fd_pr__nfet_01v8_lvt[cdb]
echo OPV XX1_M6 cdb $&s1_xx1_m6_cdb
let s1_xx1_m6_csg = @m.x1.xdut.xx1_m6.msky130_fd_pr__nfet_01v8_lvt[csg]
echo OPV XX1_M6 csg $&s1_xx1_m6_csg
let s1_xx1_m6_csd = @m.x1.xdut.xx1_m6.msky130_fd_pr__nfet_01v8_lvt[csd]
echo OPV XX1_M6 csd $&s1_xx1_m6_csd
let s1_xx1_m6_css = @m.x1.xdut.xx1_m6.msky130_fd_pr__nfet_01v8_lvt[css]
echo OPV XX1_M6 css $&s1_xx1_m6_css
let s1_xx1_m6_csb = @m.x1.xdut.xx1_m6.msky130_fd_pr__nfet_01v8_lvt[csb]
echo OPV XX1_M6 csb $&s1_xx1_m6_csb
let s1_xx1_m6_cbg = @m.x1.xdut.xx1_m6.msky130_fd_pr__nfet_01v8_lvt[cbg]
echo OPV XX1_M6 cbg $&s1_xx1_m6_cbg
let s1_xx1_m6_cbd = @m.x1.xdut.xx1_m6.msky130_fd_pr__nfet_01v8_lvt[cbd]
echo OPV XX1_M6 cbd $&s1_xx1_m6_cbd
let s1_xx1_m6_cbs = @m.x1.xdut.xx1_m6.msky130_fd_pr__nfet_01v8_lvt[cbs]
echo OPV XX1_M6 cbs $&s1_xx1_m6_cbs
let s1_xx1_m6_cbb = @m.x1.xdut.xx1_m6.msky130_fd_pr__nfet_01v8_lvt[cbb]
echo OPV XX1_M6 cbb $&s1_xx1_m6_cbb
let s1_xx1_m6_capbd = @m.x1.xdut.xx1_m6.msky130_fd_pr__nfet_01v8_lvt[capbd]
echo OPV XX1_M6 capbd $&s1_xx1_m6_capbd
let s1_xx1_m6_capbs = @m.x1.xdut.xx1_m6.msky130_fd_pr__nfet_01v8_lvt[capbs]
echo OPV XX1_M6 capbs $&s1_xx1_m6_capbs
let s1_xx1_m6_cgso = @m.x1.xdut.xx1_m6.msky130_fd_pr__nfet_01v8_lvt[cgso]
echo OPV XX1_M6 cgso $&s1_xx1_m6_cgso
let s1_xx1_m6_cgdo = @m.x1.xdut.xx1_m6.msky130_fd_pr__nfet_01v8_lvt[cgdo]
echo OPV XX1_M6 cgdo $&s1_xx1_m6_cgdo
let s1_xx1_m6_cgbo = @m.x1.xdut.xx1_m6.msky130_fd_pr__nfet_01v8_lvt[cgbo]
echo OPV XX1_M6 cgbo $&s1_xx1_m6_cgbo
let s1_xx1_m6_weff = @m.x1.xdut.xx1_m6.msky130_fd_pr__nfet_01v8_lvt[weff]
echo OPV XX1_M6 weff $&s1_xx1_m6_weff
let s1_xx1_m6_leff = @m.x1.xdut.xx1_m6.msky130_fd_pr__nfet_01v8_lvt[leff]
echo OPV XX1_M6 leff $&s1_xx1_m6_leff
let s1_xx1_m11_id = @m.x1.xdut.xx1_m11.msky130_fd_pr__pfet_01v8_lvt[id]
echo OPV XX1_M11 id $&s1_xx1_m11_id
let s1_xx1_m11_vgs = @m.x1.xdut.xx1_m11.msky130_fd_pr__pfet_01v8_lvt[vgs]
echo OPV XX1_M11 vgs $&s1_xx1_m11_vgs
let s1_xx1_m11_vds = @m.x1.xdut.xx1_m11.msky130_fd_pr__pfet_01v8_lvt[vds]
echo OPV XX1_M11 vds $&s1_xx1_m11_vds
let s1_xx1_m11_vbs = @m.x1.xdut.xx1_m11.msky130_fd_pr__pfet_01v8_lvt[vbs]
echo OPV XX1_M11 vbs $&s1_xx1_m11_vbs
let s1_xx1_m11_vth = @m.x1.xdut.xx1_m11.msky130_fd_pr__pfet_01v8_lvt[vth]
echo OPV XX1_M11 vth $&s1_xx1_m11_vth
let s1_xx1_m11_vdsat = @m.x1.xdut.xx1_m11.msky130_fd_pr__pfet_01v8_lvt[vdsat]
echo OPV XX1_M11 vdsat $&s1_xx1_m11_vdsat
let s1_xx1_m11_gm = @m.x1.xdut.xx1_m11.msky130_fd_pr__pfet_01v8_lvt[gm]
echo OPV XX1_M11 gm $&s1_xx1_m11_gm
let s1_xx1_m11_gds = @m.x1.xdut.xx1_m11.msky130_fd_pr__pfet_01v8_lvt[gds]
echo OPV XX1_M11 gds $&s1_xx1_m11_gds
let s1_xx1_m11_gmbs = @m.x1.xdut.xx1_m11.msky130_fd_pr__pfet_01v8_lvt[gmbs]
echo OPV XX1_M11 gmbs $&s1_xx1_m11_gmbs
let s1_xx1_m11_cgg = @m.x1.xdut.xx1_m11.msky130_fd_pr__pfet_01v8_lvt[cgg]
echo OPV XX1_M11 cgg $&s1_xx1_m11_cgg
let s1_xx1_m11_cgd = @m.x1.xdut.xx1_m11.msky130_fd_pr__pfet_01v8_lvt[cgd]
echo OPV XX1_M11 cgd $&s1_xx1_m11_cgd
let s1_xx1_m11_cgs = @m.x1.xdut.xx1_m11.msky130_fd_pr__pfet_01v8_lvt[cgs]
echo OPV XX1_M11 cgs $&s1_xx1_m11_cgs
let s1_xx1_m11_cgb = @m.x1.xdut.xx1_m11.msky130_fd_pr__pfet_01v8_lvt[cgb]
echo OPV XX1_M11 cgb $&s1_xx1_m11_cgb
let s1_xx1_m11_cdg = @m.x1.xdut.xx1_m11.msky130_fd_pr__pfet_01v8_lvt[cdg]
echo OPV XX1_M11 cdg $&s1_xx1_m11_cdg
let s1_xx1_m11_cdd = @m.x1.xdut.xx1_m11.msky130_fd_pr__pfet_01v8_lvt[cdd]
echo OPV XX1_M11 cdd $&s1_xx1_m11_cdd
let s1_xx1_m11_cds = @m.x1.xdut.xx1_m11.msky130_fd_pr__pfet_01v8_lvt[cds]
echo OPV XX1_M11 cds $&s1_xx1_m11_cds
let s1_xx1_m11_cdb = @m.x1.xdut.xx1_m11.msky130_fd_pr__pfet_01v8_lvt[cdb]
echo OPV XX1_M11 cdb $&s1_xx1_m11_cdb
let s1_xx1_m11_csg = @m.x1.xdut.xx1_m11.msky130_fd_pr__pfet_01v8_lvt[csg]
echo OPV XX1_M11 csg $&s1_xx1_m11_csg
let s1_xx1_m11_csd = @m.x1.xdut.xx1_m11.msky130_fd_pr__pfet_01v8_lvt[csd]
echo OPV XX1_M11 csd $&s1_xx1_m11_csd
let s1_xx1_m11_css = @m.x1.xdut.xx1_m11.msky130_fd_pr__pfet_01v8_lvt[css]
echo OPV XX1_M11 css $&s1_xx1_m11_css
let s1_xx1_m11_csb = @m.x1.xdut.xx1_m11.msky130_fd_pr__pfet_01v8_lvt[csb]
echo OPV XX1_M11 csb $&s1_xx1_m11_csb
let s1_xx1_m11_cbg = @m.x1.xdut.xx1_m11.msky130_fd_pr__pfet_01v8_lvt[cbg]
echo OPV XX1_M11 cbg $&s1_xx1_m11_cbg
let s1_xx1_m11_cbd = @m.x1.xdut.xx1_m11.msky130_fd_pr__pfet_01v8_lvt[cbd]
echo OPV XX1_M11 cbd $&s1_xx1_m11_cbd
let s1_xx1_m11_cbs = @m.x1.xdut.xx1_m11.msky130_fd_pr__pfet_01v8_lvt[cbs]
echo OPV XX1_M11 cbs $&s1_xx1_m11_cbs
let s1_xx1_m11_cbb = @m.x1.xdut.xx1_m11.msky130_fd_pr__pfet_01v8_lvt[cbb]
echo OPV XX1_M11 cbb $&s1_xx1_m11_cbb
let s1_xx1_m11_capbd = @m.x1.xdut.xx1_m11.msky130_fd_pr__pfet_01v8_lvt[capbd]
echo OPV XX1_M11 capbd $&s1_xx1_m11_capbd
let s1_xx1_m11_capbs = @m.x1.xdut.xx1_m11.msky130_fd_pr__pfet_01v8_lvt[capbs]
echo OPV XX1_M11 capbs $&s1_xx1_m11_capbs
let s1_xx1_m11_cgso = @m.x1.xdut.xx1_m11.msky130_fd_pr__pfet_01v8_lvt[cgso]
echo OPV XX1_M11 cgso $&s1_xx1_m11_cgso
let s1_xx1_m11_cgdo = @m.x1.xdut.xx1_m11.msky130_fd_pr__pfet_01v8_lvt[cgdo]
echo OPV XX1_M11 cgdo $&s1_xx1_m11_cgdo
let s1_xx1_m11_cgbo = @m.x1.xdut.xx1_m11.msky130_fd_pr__pfet_01v8_lvt[cgbo]
echo OPV XX1_M11 cgbo $&s1_xx1_m11_cgbo
let s1_xx1_m11_weff = @m.x1.xdut.xx1_m11.msky130_fd_pr__pfet_01v8_lvt[weff]
echo OPV XX1_M11 weff $&s1_xx1_m11_weff
let s1_xx1_m11_leff = @m.x1.xdut.xx1_m11.msky130_fd_pr__pfet_01v8_lvt[leff]
echo OPV XX1_M11 leff $&s1_xx1_m11_leff
let s1_xx1_m12_id = @m.x1.xdut.xx1_m12.msky130_fd_pr__pfet_01v8_lvt[id]
echo OPV XX1_M12 id $&s1_xx1_m12_id
let s1_xx1_m12_vgs = @m.x1.xdut.xx1_m12.msky130_fd_pr__pfet_01v8_lvt[vgs]
echo OPV XX1_M12 vgs $&s1_xx1_m12_vgs
let s1_xx1_m12_vds = @m.x1.xdut.xx1_m12.msky130_fd_pr__pfet_01v8_lvt[vds]
echo OPV XX1_M12 vds $&s1_xx1_m12_vds
let s1_xx1_m12_vbs = @m.x1.xdut.xx1_m12.msky130_fd_pr__pfet_01v8_lvt[vbs]
echo OPV XX1_M12 vbs $&s1_xx1_m12_vbs
let s1_xx1_m12_vth = @m.x1.xdut.xx1_m12.msky130_fd_pr__pfet_01v8_lvt[vth]
echo OPV XX1_M12 vth $&s1_xx1_m12_vth
let s1_xx1_m12_vdsat = @m.x1.xdut.xx1_m12.msky130_fd_pr__pfet_01v8_lvt[vdsat]
echo OPV XX1_M12 vdsat $&s1_xx1_m12_vdsat
let s1_xx1_m12_gm = @m.x1.xdut.xx1_m12.msky130_fd_pr__pfet_01v8_lvt[gm]
echo OPV XX1_M12 gm $&s1_xx1_m12_gm
let s1_xx1_m12_gds = @m.x1.xdut.xx1_m12.msky130_fd_pr__pfet_01v8_lvt[gds]
echo OPV XX1_M12 gds $&s1_xx1_m12_gds
let s1_xx1_m12_gmbs = @m.x1.xdut.xx1_m12.msky130_fd_pr__pfet_01v8_lvt[gmbs]
echo OPV XX1_M12 gmbs $&s1_xx1_m12_gmbs
let s1_xx1_m12_cgg = @m.x1.xdut.xx1_m12.msky130_fd_pr__pfet_01v8_lvt[cgg]
echo OPV XX1_M12 cgg $&s1_xx1_m12_cgg
let s1_xx1_m12_cgd = @m.x1.xdut.xx1_m12.msky130_fd_pr__pfet_01v8_lvt[cgd]
echo OPV XX1_M12 cgd $&s1_xx1_m12_cgd
let s1_xx1_m12_cgs = @m.x1.xdut.xx1_m12.msky130_fd_pr__pfet_01v8_lvt[cgs]
echo OPV XX1_M12 cgs $&s1_xx1_m12_cgs
let s1_xx1_m12_cgb = @m.x1.xdut.xx1_m12.msky130_fd_pr__pfet_01v8_lvt[cgb]
echo OPV XX1_M12 cgb $&s1_xx1_m12_cgb
let s1_xx1_m12_cdg = @m.x1.xdut.xx1_m12.msky130_fd_pr__pfet_01v8_lvt[cdg]
echo OPV XX1_M12 cdg $&s1_xx1_m12_cdg
let s1_xx1_m12_cdd = @m.x1.xdut.xx1_m12.msky130_fd_pr__pfet_01v8_lvt[cdd]
echo OPV XX1_M12 cdd $&s1_xx1_m12_cdd
let s1_xx1_m12_cds = @m.x1.xdut.xx1_m12.msky130_fd_pr__pfet_01v8_lvt[cds]
echo OPV XX1_M12 cds $&s1_xx1_m12_cds
let s1_xx1_m12_cdb = @m.x1.xdut.xx1_m12.msky130_fd_pr__pfet_01v8_lvt[cdb]
echo OPV XX1_M12 cdb $&s1_xx1_m12_cdb
let s1_xx1_m12_csg = @m.x1.xdut.xx1_m12.msky130_fd_pr__pfet_01v8_lvt[csg]
echo OPV XX1_M12 csg $&s1_xx1_m12_csg
let s1_xx1_m12_csd = @m.x1.xdut.xx1_m12.msky130_fd_pr__pfet_01v8_lvt[csd]
echo OPV XX1_M12 csd $&s1_xx1_m12_csd
let s1_xx1_m12_css = @m.x1.xdut.xx1_m12.msky130_fd_pr__pfet_01v8_lvt[css]
echo OPV XX1_M12 css $&s1_xx1_m12_css
let s1_xx1_m12_csb = @m.x1.xdut.xx1_m12.msky130_fd_pr__pfet_01v8_lvt[csb]
echo OPV XX1_M12 csb $&s1_xx1_m12_csb
let s1_xx1_m12_cbg = @m.x1.xdut.xx1_m12.msky130_fd_pr__pfet_01v8_lvt[cbg]
echo OPV XX1_M12 cbg $&s1_xx1_m12_cbg
let s1_xx1_m12_cbd = @m.x1.xdut.xx1_m12.msky130_fd_pr__pfet_01v8_lvt[cbd]
echo OPV XX1_M12 cbd $&s1_xx1_m12_cbd
let s1_xx1_m12_cbs = @m.x1.xdut.xx1_m12.msky130_fd_pr__pfet_01v8_lvt[cbs]
echo OPV XX1_M12 cbs $&s1_xx1_m12_cbs
let s1_xx1_m12_cbb = @m.x1.xdut.xx1_m12.msky130_fd_pr__pfet_01v8_lvt[cbb]
echo OPV XX1_M12 cbb $&s1_xx1_m12_cbb
let s1_xx1_m12_capbd = @m.x1.xdut.xx1_m12.msky130_fd_pr__pfet_01v8_lvt[capbd]
echo OPV XX1_M12 capbd $&s1_xx1_m12_capbd
let s1_xx1_m12_capbs = @m.x1.xdut.xx1_m12.msky130_fd_pr__pfet_01v8_lvt[capbs]
echo OPV XX1_M12 capbs $&s1_xx1_m12_capbs
let s1_xx1_m12_cgso = @m.x1.xdut.xx1_m12.msky130_fd_pr__pfet_01v8_lvt[cgso]
echo OPV XX1_M12 cgso $&s1_xx1_m12_cgso
let s1_xx1_m12_cgdo = @m.x1.xdut.xx1_m12.msky130_fd_pr__pfet_01v8_lvt[cgdo]
echo OPV XX1_M12 cgdo $&s1_xx1_m12_cgdo
let s1_xx1_m12_cgbo = @m.x1.xdut.xx1_m12.msky130_fd_pr__pfet_01v8_lvt[cgbo]
echo OPV XX1_M12 cgbo $&s1_xx1_m12_cgbo
let s1_xx1_m12_weff = @m.x1.xdut.xx1_m12.msky130_fd_pr__pfet_01v8_lvt[weff]
echo OPV XX1_M12 weff $&s1_xx1_m12_weff
let s1_xx1_m12_leff = @m.x1.xdut.xx1_m12.msky130_fd_pr__pfet_01v8_lvt[leff]
echo OPV XX1_M12 leff $&s1_xx1_m12_leff
let s1_xx1_m13_id = @m.x1.xdut.xx1_m13.msky130_fd_pr__pfet_01v8_lvt[id]
echo OPV XX1_M13 id $&s1_xx1_m13_id
let s1_xx1_m13_vgs = @m.x1.xdut.xx1_m13.msky130_fd_pr__pfet_01v8_lvt[vgs]
echo OPV XX1_M13 vgs $&s1_xx1_m13_vgs
let s1_xx1_m13_vds = @m.x1.xdut.xx1_m13.msky130_fd_pr__pfet_01v8_lvt[vds]
echo OPV XX1_M13 vds $&s1_xx1_m13_vds
let s1_xx1_m13_vbs = @m.x1.xdut.xx1_m13.msky130_fd_pr__pfet_01v8_lvt[vbs]
echo OPV XX1_M13 vbs $&s1_xx1_m13_vbs
let s1_xx1_m13_vth = @m.x1.xdut.xx1_m13.msky130_fd_pr__pfet_01v8_lvt[vth]
echo OPV XX1_M13 vth $&s1_xx1_m13_vth
let s1_xx1_m13_vdsat = @m.x1.xdut.xx1_m13.msky130_fd_pr__pfet_01v8_lvt[vdsat]
echo OPV XX1_M13 vdsat $&s1_xx1_m13_vdsat
let s1_xx1_m13_gm = @m.x1.xdut.xx1_m13.msky130_fd_pr__pfet_01v8_lvt[gm]
echo OPV XX1_M13 gm $&s1_xx1_m13_gm
let s1_xx1_m13_gds = @m.x1.xdut.xx1_m13.msky130_fd_pr__pfet_01v8_lvt[gds]
echo OPV XX1_M13 gds $&s1_xx1_m13_gds
let s1_xx1_m13_gmbs = @m.x1.xdut.xx1_m13.msky130_fd_pr__pfet_01v8_lvt[gmbs]
echo OPV XX1_M13 gmbs $&s1_xx1_m13_gmbs
let s1_xx1_m13_cgg = @m.x1.xdut.xx1_m13.msky130_fd_pr__pfet_01v8_lvt[cgg]
echo OPV XX1_M13 cgg $&s1_xx1_m13_cgg
let s1_xx1_m13_cgd = @m.x1.xdut.xx1_m13.msky130_fd_pr__pfet_01v8_lvt[cgd]
echo OPV XX1_M13 cgd $&s1_xx1_m13_cgd
let s1_xx1_m13_cgs = @m.x1.xdut.xx1_m13.msky130_fd_pr__pfet_01v8_lvt[cgs]
echo OPV XX1_M13 cgs $&s1_xx1_m13_cgs
let s1_xx1_m13_cgb = @m.x1.xdut.xx1_m13.msky130_fd_pr__pfet_01v8_lvt[cgb]
echo OPV XX1_M13 cgb $&s1_xx1_m13_cgb
let s1_xx1_m13_cdg = @m.x1.xdut.xx1_m13.msky130_fd_pr__pfet_01v8_lvt[cdg]
echo OPV XX1_M13 cdg $&s1_xx1_m13_cdg
let s1_xx1_m13_cdd = @m.x1.xdut.xx1_m13.msky130_fd_pr__pfet_01v8_lvt[cdd]
echo OPV XX1_M13 cdd $&s1_xx1_m13_cdd
let s1_xx1_m13_cds = @m.x1.xdut.xx1_m13.msky130_fd_pr__pfet_01v8_lvt[cds]
echo OPV XX1_M13 cds $&s1_xx1_m13_cds
let s1_xx1_m13_cdb = @m.x1.xdut.xx1_m13.msky130_fd_pr__pfet_01v8_lvt[cdb]
echo OPV XX1_M13 cdb $&s1_xx1_m13_cdb
let s1_xx1_m13_csg = @m.x1.xdut.xx1_m13.msky130_fd_pr__pfet_01v8_lvt[csg]
echo OPV XX1_M13 csg $&s1_xx1_m13_csg
let s1_xx1_m13_csd = @m.x1.xdut.xx1_m13.msky130_fd_pr__pfet_01v8_lvt[csd]
echo OPV XX1_M13 csd $&s1_xx1_m13_csd
let s1_xx1_m13_css = @m.x1.xdut.xx1_m13.msky130_fd_pr__pfet_01v8_lvt[css]
echo OPV XX1_M13 css $&s1_xx1_m13_css
let s1_xx1_m13_csb = @m.x1.xdut.xx1_m13.msky130_fd_pr__pfet_01v8_lvt[csb]
echo OPV XX1_M13 csb $&s1_xx1_m13_csb
let s1_xx1_m13_cbg = @m.x1.xdut.xx1_m13.msky130_fd_pr__pfet_01v8_lvt[cbg]
echo OPV XX1_M13 cbg $&s1_xx1_m13_cbg
let s1_xx1_m13_cbd = @m.x1.xdut.xx1_m13.msky130_fd_pr__pfet_01v8_lvt[cbd]
echo OPV XX1_M13 cbd $&s1_xx1_m13_cbd
let s1_xx1_m13_cbs = @m.x1.xdut.xx1_m13.msky130_fd_pr__pfet_01v8_lvt[cbs]
echo OPV XX1_M13 cbs $&s1_xx1_m13_cbs
let s1_xx1_m13_cbb = @m.x1.xdut.xx1_m13.msky130_fd_pr__pfet_01v8_lvt[cbb]
echo OPV XX1_M13 cbb $&s1_xx1_m13_cbb
let s1_xx1_m13_capbd = @m.x1.xdut.xx1_m13.msky130_fd_pr__pfet_01v8_lvt[capbd]
echo OPV XX1_M13 capbd $&s1_xx1_m13_capbd
let s1_xx1_m13_capbs = @m.x1.xdut.xx1_m13.msky130_fd_pr__pfet_01v8_lvt[capbs]
echo OPV XX1_M13 capbs $&s1_xx1_m13_capbs
let s1_xx1_m13_cgso = @m.x1.xdut.xx1_m13.msky130_fd_pr__pfet_01v8_lvt[cgso]
echo OPV XX1_M13 cgso $&s1_xx1_m13_cgso
let s1_xx1_m13_cgdo = @m.x1.xdut.xx1_m13.msky130_fd_pr__pfet_01v8_lvt[cgdo]
echo OPV XX1_M13 cgdo $&s1_xx1_m13_cgdo
let s1_xx1_m13_cgbo = @m.x1.xdut.xx1_m13.msky130_fd_pr__pfet_01v8_lvt[cgbo]
echo OPV XX1_M13 cgbo $&s1_xx1_m13_cgbo
let s1_xx1_m13_weff = @m.x1.xdut.xx1_m13.msky130_fd_pr__pfet_01v8_lvt[weff]
echo OPV XX1_M13 weff $&s1_xx1_m13_weff
let s1_xx1_m13_leff = @m.x1.xdut.xx1_m13.msky130_fd_pr__pfet_01v8_lvt[leff]
echo OPV XX1_M13 leff $&s1_xx1_m13_leff
let s1_xx1_m14_id = @m.x1.xdut.xx1_m14.msky130_fd_pr__pfet_01v8_lvt[id]
echo OPV XX1_M14 id $&s1_xx1_m14_id
let s1_xx1_m14_vgs = @m.x1.xdut.xx1_m14.msky130_fd_pr__pfet_01v8_lvt[vgs]
echo OPV XX1_M14 vgs $&s1_xx1_m14_vgs
let s1_xx1_m14_vds = @m.x1.xdut.xx1_m14.msky130_fd_pr__pfet_01v8_lvt[vds]
echo OPV XX1_M14 vds $&s1_xx1_m14_vds
let s1_xx1_m14_vbs = @m.x1.xdut.xx1_m14.msky130_fd_pr__pfet_01v8_lvt[vbs]
echo OPV XX1_M14 vbs $&s1_xx1_m14_vbs
let s1_xx1_m14_vth = @m.x1.xdut.xx1_m14.msky130_fd_pr__pfet_01v8_lvt[vth]
echo OPV XX1_M14 vth $&s1_xx1_m14_vth
let s1_xx1_m14_vdsat = @m.x1.xdut.xx1_m14.msky130_fd_pr__pfet_01v8_lvt[vdsat]
echo OPV XX1_M14 vdsat $&s1_xx1_m14_vdsat
let s1_xx1_m14_gm = @m.x1.xdut.xx1_m14.msky130_fd_pr__pfet_01v8_lvt[gm]
echo OPV XX1_M14 gm $&s1_xx1_m14_gm
let s1_xx1_m14_gds = @m.x1.xdut.xx1_m14.msky130_fd_pr__pfet_01v8_lvt[gds]
echo OPV XX1_M14 gds $&s1_xx1_m14_gds
let s1_xx1_m14_gmbs = @m.x1.xdut.xx1_m14.msky130_fd_pr__pfet_01v8_lvt[gmbs]
echo OPV XX1_M14 gmbs $&s1_xx1_m14_gmbs
let s1_xx1_m14_cgg = @m.x1.xdut.xx1_m14.msky130_fd_pr__pfet_01v8_lvt[cgg]
echo OPV XX1_M14 cgg $&s1_xx1_m14_cgg
let s1_xx1_m14_cgd = @m.x1.xdut.xx1_m14.msky130_fd_pr__pfet_01v8_lvt[cgd]
echo OPV XX1_M14 cgd $&s1_xx1_m14_cgd
let s1_xx1_m14_cgs = @m.x1.xdut.xx1_m14.msky130_fd_pr__pfet_01v8_lvt[cgs]
echo OPV XX1_M14 cgs $&s1_xx1_m14_cgs
let s1_xx1_m14_cgb = @m.x1.xdut.xx1_m14.msky130_fd_pr__pfet_01v8_lvt[cgb]
echo OPV XX1_M14 cgb $&s1_xx1_m14_cgb
let s1_xx1_m14_cdg = @m.x1.xdut.xx1_m14.msky130_fd_pr__pfet_01v8_lvt[cdg]
echo OPV XX1_M14 cdg $&s1_xx1_m14_cdg
let s1_xx1_m14_cdd = @m.x1.xdut.xx1_m14.msky130_fd_pr__pfet_01v8_lvt[cdd]
echo OPV XX1_M14 cdd $&s1_xx1_m14_cdd
let s1_xx1_m14_cds = @m.x1.xdut.xx1_m14.msky130_fd_pr__pfet_01v8_lvt[cds]
echo OPV XX1_M14 cds $&s1_xx1_m14_cds
let s1_xx1_m14_cdb = @m.x1.xdut.xx1_m14.msky130_fd_pr__pfet_01v8_lvt[cdb]
echo OPV XX1_M14 cdb $&s1_xx1_m14_cdb
let s1_xx1_m14_csg = @m.x1.xdut.xx1_m14.msky130_fd_pr__pfet_01v8_lvt[csg]
echo OPV XX1_M14 csg $&s1_xx1_m14_csg
let s1_xx1_m14_csd = @m.x1.xdut.xx1_m14.msky130_fd_pr__pfet_01v8_lvt[csd]
echo OPV XX1_M14 csd $&s1_xx1_m14_csd
let s1_xx1_m14_css = @m.x1.xdut.xx1_m14.msky130_fd_pr__pfet_01v8_lvt[css]
echo OPV XX1_M14 css $&s1_xx1_m14_css
let s1_xx1_m14_csb = @m.x1.xdut.xx1_m14.msky130_fd_pr__pfet_01v8_lvt[csb]
echo OPV XX1_M14 csb $&s1_xx1_m14_csb
let s1_xx1_m14_cbg = @m.x1.xdut.xx1_m14.msky130_fd_pr__pfet_01v8_lvt[cbg]
echo OPV XX1_M14 cbg $&s1_xx1_m14_cbg
let s1_xx1_m14_cbd = @m.x1.xdut.xx1_m14.msky130_fd_pr__pfet_01v8_lvt[cbd]
echo OPV XX1_M14 cbd $&s1_xx1_m14_cbd
let s1_xx1_m14_cbs = @m.x1.xdut.xx1_m14.msky130_fd_pr__pfet_01v8_lvt[cbs]
echo OPV XX1_M14 cbs $&s1_xx1_m14_cbs
let s1_xx1_m14_cbb = @m.x1.xdut.xx1_m14.msky130_fd_pr__pfet_01v8_lvt[cbb]
echo OPV XX1_M14 cbb $&s1_xx1_m14_cbb
let s1_xx1_m14_capbd = @m.x1.xdut.xx1_m14.msky130_fd_pr__pfet_01v8_lvt[capbd]
echo OPV XX1_M14 capbd $&s1_xx1_m14_capbd
let s1_xx1_m14_capbs = @m.x1.xdut.xx1_m14.msky130_fd_pr__pfet_01v8_lvt[capbs]
echo OPV XX1_M14 capbs $&s1_xx1_m14_capbs
let s1_xx1_m14_cgso = @m.x1.xdut.xx1_m14.msky130_fd_pr__pfet_01v8_lvt[cgso]
echo OPV XX1_M14 cgso $&s1_xx1_m14_cgso
let s1_xx1_m14_cgdo = @m.x1.xdut.xx1_m14.msky130_fd_pr__pfet_01v8_lvt[cgdo]
echo OPV XX1_M14 cgdo $&s1_xx1_m14_cgdo
let s1_xx1_m14_cgbo = @m.x1.xdut.xx1_m14.msky130_fd_pr__pfet_01v8_lvt[cgbo]
echo OPV XX1_M14 cgbo $&s1_xx1_m14_cgbo
let s1_xx1_m14_weff = @m.x1.xdut.xx1_m14.msky130_fd_pr__pfet_01v8_lvt[weff]
echo OPV XX1_M14 weff $&s1_xx1_m14_weff
let s1_xx1_m14_leff = @m.x1.xdut.xx1_m14.msky130_fd_pr__pfet_01v8_lvt[leff]
echo OPV XX1_M14 leff $&s1_xx1_m14_leff
let s1_xx1_m19_id = @m.x1.xdut.xx1_m19.msky130_fd_pr__nfet_01v8_lvt[id]
echo OPV XX1_M19 id $&s1_xx1_m19_id
let s1_xx1_m19_vgs = @m.x1.xdut.xx1_m19.msky130_fd_pr__nfet_01v8_lvt[vgs]
echo OPV XX1_M19 vgs $&s1_xx1_m19_vgs
let s1_xx1_m19_vds = @m.x1.xdut.xx1_m19.msky130_fd_pr__nfet_01v8_lvt[vds]
echo OPV XX1_M19 vds $&s1_xx1_m19_vds
let s1_xx1_m19_vbs = @m.x1.xdut.xx1_m19.msky130_fd_pr__nfet_01v8_lvt[vbs]
echo OPV XX1_M19 vbs $&s1_xx1_m19_vbs
let s1_xx1_m19_vth = @m.x1.xdut.xx1_m19.msky130_fd_pr__nfet_01v8_lvt[vth]
echo OPV XX1_M19 vth $&s1_xx1_m19_vth
let s1_xx1_m19_vdsat = @m.x1.xdut.xx1_m19.msky130_fd_pr__nfet_01v8_lvt[vdsat]
echo OPV XX1_M19 vdsat $&s1_xx1_m19_vdsat
let s1_xx1_m19_gm = @m.x1.xdut.xx1_m19.msky130_fd_pr__nfet_01v8_lvt[gm]
echo OPV XX1_M19 gm $&s1_xx1_m19_gm
let s1_xx1_m19_gds = @m.x1.xdut.xx1_m19.msky130_fd_pr__nfet_01v8_lvt[gds]
echo OPV XX1_M19 gds $&s1_xx1_m19_gds
let s1_xx1_m19_gmbs = @m.x1.xdut.xx1_m19.msky130_fd_pr__nfet_01v8_lvt[gmbs]
echo OPV XX1_M19 gmbs $&s1_xx1_m19_gmbs
let s1_xx1_m19_cgg = @m.x1.xdut.xx1_m19.msky130_fd_pr__nfet_01v8_lvt[cgg]
echo OPV XX1_M19 cgg $&s1_xx1_m19_cgg
let s1_xx1_m19_cgd = @m.x1.xdut.xx1_m19.msky130_fd_pr__nfet_01v8_lvt[cgd]
echo OPV XX1_M19 cgd $&s1_xx1_m19_cgd
let s1_xx1_m19_cgs = @m.x1.xdut.xx1_m19.msky130_fd_pr__nfet_01v8_lvt[cgs]
echo OPV XX1_M19 cgs $&s1_xx1_m19_cgs
let s1_xx1_m19_cgb = @m.x1.xdut.xx1_m19.msky130_fd_pr__nfet_01v8_lvt[cgb]
echo OPV XX1_M19 cgb $&s1_xx1_m19_cgb
let s1_xx1_m19_cdg = @m.x1.xdut.xx1_m19.msky130_fd_pr__nfet_01v8_lvt[cdg]
echo OPV XX1_M19 cdg $&s1_xx1_m19_cdg
let s1_xx1_m19_cdd = @m.x1.xdut.xx1_m19.msky130_fd_pr__nfet_01v8_lvt[cdd]
echo OPV XX1_M19 cdd $&s1_xx1_m19_cdd
let s1_xx1_m19_cds = @m.x1.xdut.xx1_m19.msky130_fd_pr__nfet_01v8_lvt[cds]
echo OPV XX1_M19 cds $&s1_xx1_m19_cds
let s1_xx1_m19_cdb = @m.x1.xdut.xx1_m19.msky130_fd_pr__nfet_01v8_lvt[cdb]
echo OPV XX1_M19 cdb $&s1_xx1_m19_cdb
let s1_xx1_m19_csg = @m.x1.xdut.xx1_m19.msky130_fd_pr__nfet_01v8_lvt[csg]
echo OPV XX1_M19 csg $&s1_xx1_m19_csg
let s1_xx1_m19_csd = @m.x1.xdut.xx1_m19.msky130_fd_pr__nfet_01v8_lvt[csd]
echo OPV XX1_M19 csd $&s1_xx1_m19_csd
let s1_xx1_m19_css = @m.x1.xdut.xx1_m19.msky130_fd_pr__nfet_01v8_lvt[css]
echo OPV XX1_M19 css $&s1_xx1_m19_css
let s1_xx1_m19_csb = @m.x1.xdut.xx1_m19.msky130_fd_pr__nfet_01v8_lvt[csb]
echo OPV XX1_M19 csb $&s1_xx1_m19_csb
let s1_xx1_m19_cbg = @m.x1.xdut.xx1_m19.msky130_fd_pr__nfet_01v8_lvt[cbg]
echo OPV XX1_M19 cbg $&s1_xx1_m19_cbg
let s1_xx1_m19_cbd = @m.x1.xdut.xx1_m19.msky130_fd_pr__nfet_01v8_lvt[cbd]
echo OPV XX1_M19 cbd $&s1_xx1_m19_cbd
let s1_xx1_m19_cbs = @m.x1.xdut.xx1_m19.msky130_fd_pr__nfet_01v8_lvt[cbs]
echo OPV XX1_M19 cbs $&s1_xx1_m19_cbs
let s1_xx1_m19_cbb = @m.x1.xdut.xx1_m19.msky130_fd_pr__nfet_01v8_lvt[cbb]
echo OPV XX1_M19 cbb $&s1_xx1_m19_cbb
let s1_xx1_m19_capbd = @m.x1.xdut.xx1_m19.msky130_fd_pr__nfet_01v8_lvt[capbd]
echo OPV XX1_M19 capbd $&s1_xx1_m19_capbd
let s1_xx1_m19_capbs = @m.x1.xdut.xx1_m19.msky130_fd_pr__nfet_01v8_lvt[capbs]
echo OPV XX1_M19 capbs $&s1_xx1_m19_capbs
let s1_xx1_m19_cgso = @m.x1.xdut.xx1_m19.msky130_fd_pr__nfet_01v8_lvt[cgso]
echo OPV XX1_M19 cgso $&s1_xx1_m19_cgso
let s1_xx1_m19_cgdo = @m.x1.xdut.xx1_m19.msky130_fd_pr__nfet_01v8_lvt[cgdo]
echo OPV XX1_M19 cgdo $&s1_xx1_m19_cgdo
let s1_xx1_m19_cgbo = @m.x1.xdut.xx1_m19.msky130_fd_pr__nfet_01v8_lvt[cgbo]
echo OPV XX1_M19 cgbo $&s1_xx1_m19_cgbo
let s1_xx1_m19_weff = @m.x1.xdut.xx1_m19.msky130_fd_pr__nfet_01v8_lvt[weff]
echo OPV XX1_M19 weff $&s1_xx1_m19_weff
let s1_xx1_m19_leff = @m.x1.xdut.xx1_m19.msky130_fd_pr__nfet_01v8_lvt[leff]
echo OPV XX1_M19 leff $&s1_xx1_m19_leff
let s1_xx1_m1_id = @m.x1.xdut.xx1_m1.msky130_fd_pr__nfet_01v8_lvt[id]
echo OPV XX1_M1 id $&s1_xx1_m1_id
let s1_xx1_m1_vgs = @m.x1.xdut.xx1_m1.msky130_fd_pr__nfet_01v8_lvt[vgs]
echo OPV XX1_M1 vgs $&s1_xx1_m1_vgs
let s1_xx1_m1_vds = @m.x1.xdut.xx1_m1.msky130_fd_pr__nfet_01v8_lvt[vds]
echo OPV XX1_M1 vds $&s1_xx1_m1_vds
let s1_xx1_m1_vbs = @m.x1.xdut.xx1_m1.msky130_fd_pr__nfet_01v8_lvt[vbs]
echo OPV XX1_M1 vbs $&s1_xx1_m1_vbs
let s1_xx1_m1_vth = @m.x1.xdut.xx1_m1.msky130_fd_pr__nfet_01v8_lvt[vth]
echo OPV XX1_M1 vth $&s1_xx1_m1_vth
let s1_xx1_m1_vdsat = @m.x1.xdut.xx1_m1.msky130_fd_pr__nfet_01v8_lvt[vdsat]
echo OPV XX1_M1 vdsat $&s1_xx1_m1_vdsat
let s1_xx1_m1_gm = @m.x1.xdut.xx1_m1.msky130_fd_pr__nfet_01v8_lvt[gm]
echo OPV XX1_M1 gm $&s1_xx1_m1_gm
let s1_xx1_m1_gds = @m.x1.xdut.xx1_m1.msky130_fd_pr__nfet_01v8_lvt[gds]
echo OPV XX1_M1 gds $&s1_xx1_m1_gds
let s1_xx1_m1_gmbs = @m.x1.xdut.xx1_m1.msky130_fd_pr__nfet_01v8_lvt[gmbs]
echo OPV XX1_M1 gmbs $&s1_xx1_m1_gmbs
let s1_xx1_m1_cgg = @m.x1.xdut.xx1_m1.msky130_fd_pr__nfet_01v8_lvt[cgg]
echo OPV XX1_M1 cgg $&s1_xx1_m1_cgg
let s1_xx1_m1_cgd = @m.x1.xdut.xx1_m1.msky130_fd_pr__nfet_01v8_lvt[cgd]
echo OPV XX1_M1 cgd $&s1_xx1_m1_cgd
let s1_xx1_m1_cgs = @m.x1.xdut.xx1_m1.msky130_fd_pr__nfet_01v8_lvt[cgs]
echo OPV XX1_M1 cgs $&s1_xx1_m1_cgs
let s1_xx1_m1_cgb = @m.x1.xdut.xx1_m1.msky130_fd_pr__nfet_01v8_lvt[cgb]
echo OPV XX1_M1 cgb $&s1_xx1_m1_cgb
let s1_xx1_m1_cdg = @m.x1.xdut.xx1_m1.msky130_fd_pr__nfet_01v8_lvt[cdg]
echo OPV XX1_M1 cdg $&s1_xx1_m1_cdg
let s1_xx1_m1_cdd = @m.x1.xdut.xx1_m1.msky130_fd_pr__nfet_01v8_lvt[cdd]
echo OPV XX1_M1 cdd $&s1_xx1_m1_cdd
let s1_xx1_m1_cds = @m.x1.xdut.xx1_m1.msky130_fd_pr__nfet_01v8_lvt[cds]
echo OPV XX1_M1 cds $&s1_xx1_m1_cds
let s1_xx1_m1_cdb = @m.x1.xdut.xx1_m1.msky130_fd_pr__nfet_01v8_lvt[cdb]
echo OPV XX1_M1 cdb $&s1_xx1_m1_cdb
let s1_xx1_m1_csg = @m.x1.xdut.xx1_m1.msky130_fd_pr__nfet_01v8_lvt[csg]
echo OPV XX1_M1 csg $&s1_xx1_m1_csg
let s1_xx1_m1_csd = @m.x1.xdut.xx1_m1.msky130_fd_pr__nfet_01v8_lvt[csd]
echo OPV XX1_M1 csd $&s1_xx1_m1_csd
let s1_xx1_m1_css = @m.x1.xdut.xx1_m1.msky130_fd_pr__nfet_01v8_lvt[css]
echo OPV XX1_M1 css $&s1_xx1_m1_css
let s1_xx1_m1_csb = @m.x1.xdut.xx1_m1.msky130_fd_pr__nfet_01v8_lvt[csb]
echo OPV XX1_M1 csb $&s1_xx1_m1_csb
let s1_xx1_m1_cbg = @m.x1.xdut.xx1_m1.msky130_fd_pr__nfet_01v8_lvt[cbg]
echo OPV XX1_M1 cbg $&s1_xx1_m1_cbg
let s1_xx1_m1_cbd = @m.x1.xdut.xx1_m1.msky130_fd_pr__nfet_01v8_lvt[cbd]
echo OPV XX1_M1 cbd $&s1_xx1_m1_cbd
let s1_xx1_m1_cbs = @m.x1.xdut.xx1_m1.msky130_fd_pr__nfet_01v8_lvt[cbs]
echo OPV XX1_M1 cbs $&s1_xx1_m1_cbs
let s1_xx1_m1_cbb = @m.x1.xdut.xx1_m1.msky130_fd_pr__nfet_01v8_lvt[cbb]
echo OPV XX1_M1 cbb $&s1_xx1_m1_cbb
let s1_xx1_m1_capbd = @m.x1.xdut.xx1_m1.msky130_fd_pr__nfet_01v8_lvt[capbd]
echo OPV XX1_M1 capbd $&s1_xx1_m1_capbd
let s1_xx1_m1_capbs = @m.x1.xdut.xx1_m1.msky130_fd_pr__nfet_01v8_lvt[capbs]
echo OPV XX1_M1 capbs $&s1_xx1_m1_capbs
let s1_xx1_m1_cgso = @m.x1.xdut.xx1_m1.msky130_fd_pr__nfet_01v8_lvt[cgso]
echo OPV XX1_M1 cgso $&s1_xx1_m1_cgso
let s1_xx1_m1_cgdo = @m.x1.xdut.xx1_m1.msky130_fd_pr__nfet_01v8_lvt[cgdo]
echo OPV XX1_M1 cgdo $&s1_xx1_m1_cgdo
let s1_xx1_m1_cgbo = @m.x1.xdut.xx1_m1.msky130_fd_pr__nfet_01v8_lvt[cgbo]
echo OPV XX1_M1 cgbo $&s1_xx1_m1_cgbo
let s1_xx1_m1_weff = @m.x1.xdut.xx1_m1.msky130_fd_pr__nfet_01v8_lvt[weff]
echo OPV XX1_M1 weff $&s1_xx1_m1_weff
let s1_xx1_m1_leff = @m.x1.xdut.xx1_m1.msky130_fd_pr__nfet_01v8_lvt[leff]
echo OPV XX1_M1 leff $&s1_xx1_m1_leff
let s1_xx1_m2_id = @m.x1.xdut.xx1_m2.msky130_fd_pr__nfet_01v8_lvt[id]
echo OPV XX1_M2 id $&s1_xx1_m2_id
let s1_xx1_m2_vgs = @m.x1.xdut.xx1_m2.msky130_fd_pr__nfet_01v8_lvt[vgs]
echo OPV XX1_M2 vgs $&s1_xx1_m2_vgs
let s1_xx1_m2_vds = @m.x1.xdut.xx1_m2.msky130_fd_pr__nfet_01v8_lvt[vds]
echo OPV XX1_M2 vds $&s1_xx1_m2_vds
let s1_xx1_m2_vbs = @m.x1.xdut.xx1_m2.msky130_fd_pr__nfet_01v8_lvt[vbs]
echo OPV XX1_M2 vbs $&s1_xx1_m2_vbs
let s1_xx1_m2_vth = @m.x1.xdut.xx1_m2.msky130_fd_pr__nfet_01v8_lvt[vth]
echo OPV XX1_M2 vth $&s1_xx1_m2_vth
let s1_xx1_m2_vdsat = @m.x1.xdut.xx1_m2.msky130_fd_pr__nfet_01v8_lvt[vdsat]
echo OPV XX1_M2 vdsat $&s1_xx1_m2_vdsat
let s1_xx1_m2_gm = @m.x1.xdut.xx1_m2.msky130_fd_pr__nfet_01v8_lvt[gm]
echo OPV XX1_M2 gm $&s1_xx1_m2_gm
let s1_xx1_m2_gds = @m.x1.xdut.xx1_m2.msky130_fd_pr__nfet_01v8_lvt[gds]
echo OPV XX1_M2 gds $&s1_xx1_m2_gds
let s1_xx1_m2_gmbs = @m.x1.xdut.xx1_m2.msky130_fd_pr__nfet_01v8_lvt[gmbs]
echo OPV XX1_M2 gmbs $&s1_xx1_m2_gmbs
let s1_xx1_m2_cgg = @m.x1.xdut.xx1_m2.msky130_fd_pr__nfet_01v8_lvt[cgg]
echo OPV XX1_M2 cgg $&s1_xx1_m2_cgg
let s1_xx1_m2_cgd = @m.x1.xdut.xx1_m2.msky130_fd_pr__nfet_01v8_lvt[cgd]
echo OPV XX1_M2 cgd $&s1_xx1_m2_cgd
let s1_xx1_m2_cgs = @m.x1.xdut.xx1_m2.msky130_fd_pr__nfet_01v8_lvt[cgs]
echo OPV XX1_M2 cgs $&s1_xx1_m2_cgs
let s1_xx1_m2_cgb = @m.x1.xdut.xx1_m2.msky130_fd_pr__nfet_01v8_lvt[cgb]
echo OPV XX1_M2 cgb $&s1_xx1_m2_cgb
let s1_xx1_m2_cdg = @m.x1.xdut.xx1_m2.msky130_fd_pr__nfet_01v8_lvt[cdg]
echo OPV XX1_M2 cdg $&s1_xx1_m2_cdg
let s1_xx1_m2_cdd = @m.x1.xdut.xx1_m2.msky130_fd_pr__nfet_01v8_lvt[cdd]
echo OPV XX1_M2 cdd $&s1_xx1_m2_cdd
let s1_xx1_m2_cds = @m.x1.xdut.xx1_m2.msky130_fd_pr__nfet_01v8_lvt[cds]
echo OPV XX1_M2 cds $&s1_xx1_m2_cds
let s1_xx1_m2_cdb = @m.x1.xdut.xx1_m2.msky130_fd_pr__nfet_01v8_lvt[cdb]
echo OPV XX1_M2 cdb $&s1_xx1_m2_cdb
let s1_xx1_m2_csg = @m.x1.xdut.xx1_m2.msky130_fd_pr__nfet_01v8_lvt[csg]
echo OPV XX1_M2 csg $&s1_xx1_m2_csg
let s1_xx1_m2_csd = @m.x1.xdut.xx1_m2.msky130_fd_pr__nfet_01v8_lvt[csd]
echo OPV XX1_M2 csd $&s1_xx1_m2_csd
let s1_xx1_m2_css = @m.x1.xdut.xx1_m2.msky130_fd_pr__nfet_01v8_lvt[css]
echo OPV XX1_M2 css $&s1_xx1_m2_css
let s1_xx1_m2_csb = @m.x1.xdut.xx1_m2.msky130_fd_pr__nfet_01v8_lvt[csb]
echo OPV XX1_M2 csb $&s1_xx1_m2_csb
let s1_xx1_m2_cbg = @m.x1.xdut.xx1_m2.msky130_fd_pr__nfet_01v8_lvt[cbg]
echo OPV XX1_M2 cbg $&s1_xx1_m2_cbg
let s1_xx1_m2_cbd = @m.x1.xdut.xx1_m2.msky130_fd_pr__nfet_01v8_lvt[cbd]
echo OPV XX1_M2 cbd $&s1_xx1_m2_cbd
let s1_xx1_m2_cbs = @m.x1.xdut.xx1_m2.msky130_fd_pr__nfet_01v8_lvt[cbs]
echo OPV XX1_M2 cbs $&s1_xx1_m2_cbs
let s1_xx1_m2_cbb = @m.x1.xdut.xx1_m2.msky130_fd_pr__nfet_01v8_lvt[cbb]
echo OPV XX1_M2 cbb $&s1_xx1_m2_cbb
let s1_xx1_m2_capbd = @m.x1.xdut.xx1_m2.msky130_fd_pr__nfet_01v8_lvt[capbd]
echo OPV XX1_M2 capbd $&s1_xx1_m2_capbd
let s1_xx1_m2_capbs = @m.x1.xdut.xx1_m2.msky130_fd_pr__nfet_01v8_lvt[capbs]
echo OPV XX1_M2 capbs $&s1_xx1_m2_capbs
let s1_xx1_m2_cgso = @m.x1.xdut.xx1_m2.msky130_fd_pr__nfet_01v8_lvt[cgso]
echo OPV XX1_M2 cgso $&s1_xx1_m2_cgso
let s1_xx1_m2_cgdo = @m.x1.xdut.xx1_m2.msky130_fd_pr__nfet_01v8_lvt[cgdo]
echo OPV XX1_M2 cgdo $&s1_xx1_m2_cgdo
let s1_xx1_m2_cgbo = @m.x1.xdut.xx1_m2.msky130_fd_pr__nfet_01v8_lvt[cgbo]
echo OPV XX1_M2 cgbo $&s1_xx1_m2_cgbo
let s1_xx1_m2_weff = @m.x1.xdut.xx1_m2.msky130_fd_pr__nfet_01v8_lvt[weff]
echo OPV XX1_M2 weff $&s1_xx1_m2_weff
let s1_xx1_m2_leff = @m.x1.xdut.xx1_m2.msky130_fd_pr__nfet_01v8_lvt[leff]
echo OPV XX1_M2 leff $&s1_xx1_m2_leff
let s1_xx1_m3_id = @m.x1.xdut.xx1_m3.msky130_fd_pr__nfet_01v8_lvt[id]
echo OPV XX1_M3 id $&s1_xx1_m3_id
let s1_xx1_m3_vgs = @m.x1.xdut.xx1_m3.msky130_fd_pr__nfet_01v8_lvt[vgs]
echo OPV XX1_M3 vgs $&s1_xx1_m3_vgs
let s1_xx1_m3_vds = @m.x1.xdut.xx1_m3.msky130_fd_pr__nfet_01v8_lvt[vds]
echo OPV XX1_M3 vds $&s1_xx1_m3_vds
let s1_xx1_m3_vbs = @m.x1.xdut.xx1_m3.msky130_fd_pr__nfet_01v8_lvt[vbs]
echo OPV XX1_M3 vbs $&s1_xx1_m3_vbs
let s1_xx1_m3_vth = @m.x1.xdut.xx1_m3.msky130_fd_pr__nfet_01v8_lvt[vth]
echo OPV XX1_M3 vth $&s1_xx1_m3_vth
let s1_xx1_m3_vdsat = @m.x1.xdut.xx1_m3.msky130_fd_pr__nfet_01v8_lvt[vdsat]
echo OPV XX1_M3 vdsat $&s1_xx1_m3_vdsat
let s1_xx1_m3_gm = @m.x1.xdut.xx1_m3.msky130_fd_pr__nfet_01v8_lvt[gm]
echo OPV XX1_M3 gm $&s1_xx1_m3_gm
let s1_xx1_m3_gds = @m.x1.xdut.xx1_m3.msky130_fd_pr__nfet_01v8_lvt[gds]
echo OPV XX1_M3 gds $&s1_xx1_m3_gds
let s1_xx1_m3_gmbs = @m.x1.xdut.xx1_m3.msky130_fd_pr__nfet_01v8_lvt[gmbs]
echo OPV XX1_M3 gmbs $&s1_xx1_m3_gmbs
let s1_xx1_m3_cgg = @m.x1.xdut.xx1_m3.msky130_fd_pr__nfet_01v8_lvt[cgg]
echo OPV XX1_M3 cgg $&s1_xx1_m3_cgg
let s1_xx1_m3_cgd = @m.x1.xdut.xx1_m3.msky130_fd_pr__nfet_01v8_lvt[cgd]
echo OPV XX1_M3 cgd $&s1_xx1_m3_cgd
let s1_xx1_m3_cgs = @m.x1.xdut.xx1_m3.msky130_fd_pr__nfet_01v8_lvt[cgs]
echo OPV XX1_M3 cgs $&s1_xx1_m3_cgs
let s1_xx1_m3_cgb = @m.x1.xdut.xx1_m3.msky130_fd_pr__nfet_01v8_lvt[cgb]
echo OPV XX1_M3 cgb $&s1_xx1_m3_cgb
let s1_xx1_m3_cdg = @m.x1.xdut.xx1_m3.msky130_fd_pr__nfet_01v8_lvt[cdg]
echo OPV XX1_M3 cdg $&s1_xx1_m3_cdg
let s1_xx1_m3_cdd = @m.x1.xdut.xx1_m3.msky130_fd_pr__nfet_01v8_lvt[cdd]
echo OPV XX1_M3 cdd $&s1_xx1_m3_cdd
let s1_xx1_m3_cds = @m.x1.xdut.xx1_m3.msky130_fd_pr__nfet_01v8_lvt[cds]
echo OPV XX1_M3 cds $&s1_xx1_m3_cds
let s1_xx1_m3_cdb = @m.x1.xdut.xx1_m3.msky130_fd_pr__nfet_01v8_lvt[cdb]
echo OPV XX1_M3 cdb $&s1_xx1_m3_cdb
let s1_xx1_m3_csg = @m.x1.xdut.xx1_m3.msky130_fd_pr__nfet_01v8_lvt[csg]
echo OPV XX1_M3 csg $&s1_xx1_m3_csg
let s1_xx1_m3_csd = @m.x1.xdut.xx1_m3.msky130_fd_pr__nfet_01v8_lvt[csd]
echo OPV XX1_M3 csd $&s1_xx1_m3_csd
let s1_xx1_m3_css = @m.x1.xdut.xx1_m3.msky130_fd_pr__nfet_01v8_lvt[css]
echo OPV XX1_M3 css $&s1_xx1_m3_css
let s1_xx1_m3_csb = @m.x1.xdut.xx1_m3.msky130_fd_pr__nfet_01v8_lvt[csb]
echo OPV XX1_M3 csb $&s1_xx1_m3_csb
let s1_xx1_m3_cbg = @m.x1.xdut.xx1_m3.msky130_fd_pr__nfet_01v8_lvt[cbg]
echo OPV XX1_M3 cbg $&s1_xx1_m3_cbg
let s1_xx1_m3_cbd = @m.x1.xdut.xx1_m3.msky130_fd_pr__nfet_01v8_lvt[cbd]
echo OPV XX1_M3 cbd $&s1_xx1_m3_cbd
let s1_xx1_m3_cbs = @m.x1.xdut.xx1_m3.msky130_fd_pr__nfet_01v8_lvt[cbs]
echo OPV XX1_M3 cbs $&s1_xx1_m3_cbs
let s1_xx1_m3_cbb = @m.x1.xdut.xx1_m3.msky130_fd_pr__nfet_01v8_lvt[cbb]
echo OPV XX1_M3 cbb $&s1_xx1_m3_cbb
let s1_xx1_m3_capbd = @m.x1.xdut.xx1_m3.msky130_fd_pr__nfet_01v8_lvt[capbd]
echo OPV XX1_M3 capbd $&s1_xx1_m3_capbd
let s1_xx1_m3_capbs = @m.x1.xdut.xx1_m3.msky130_fd_pr__nfet_01v8_lvt[capbs]
echo OPV XX1_M3 capbs $&s1_xx1_m3_capbs
let s1_xx1_m3_cgso = @m.x1.xdut.xx1_m3.msky130_fd_pr__nfet_01v8_lvt[cgso]
echo OPV XX1_M3 cgso $&s1_xx1_m3_cgso
let s1_xx1_m3_cgdo = @m.x1.xdut.xx1_m3.msky130_fd_pr__nfet_01v8_lvt[cgdo]
echo OPV XX1_M3 cgdo $&s1_xx1_m3_cgdo
let s1_xx1_m3_cgbo = @m.x1.xdut.xx1_m3.msky130_fd_pr__nfet_01v8_lvt[cgbo]
echo OPV XX1_M3 cgbo $&s1_xx1_m3_cgbo
let s1_xx1_m3_weff = @m.x1.xdut.xx1_m3.msky130_fd_pr__nfet_01v8_lvt[weff]
echo OPV XX1_M3 weff $&s1_xx1_m3_weff
let s1_xx1_m3_leff = @m.x1.xdut.xx1_m3.msky130_fd_pr__nfet_01v8_lvt[leff]
echo OPV XX1_M3 leff $&s1_xx1_m3_leff
let s1_xx1_m4_id = @m.x1.xdut.xx1_m4.msky130_fd_pr__nfet_01v8_lvt[id]
echo OPV XX1_M4 id $&s1_xx1_m4_id
let s1_xx1_m4_vgs = @m.x1.xdut.xx1_m4.msky130_fd_pr__nfet_01v8_lvt[vgs]
echo OPV XX1_M4 vgs $&s1_xx1_m4_vgs
let s1_xx1_m4_vds = @m.x1.xdut.xx1_m4.msky130_fd_pr__nfet_01v8_lvt[vds]
echo OPV XX1_M4 vds $&s1_xx1_m4_vds
let s1_xx1_m4_vbs = @m.x1.xdut.xx1_m4.msky130_fd_pr__nfet_01v8_lvt[vbs]
echo OPV XX1_M4 vbs $&s1_xx1_m4_vbs
let s1_xx1_m4_vth = @m.x1.xdut.xx1_m4.msky130_fd_pr__nfet_01v8_lvt[vth]
echo OPV XX1_M4 vth $&s1_xx1_m4_vth
let s1_xx1_m4_vdsat = @m.x1.xdut.xx1_m4.msky130_fd_pr__nfet_01v8_lvt[vdsat]
echo OPV XX1_M4 vdsat $&s1_xx1_m4_vdsat
let s1_xx1_m4_gm = @m.x1.xdut.xx1_m4.msky130_fd_pr__nfet_01v8_lvt[gm]
echo OPV XX1_M4 gm $&s1_xx1_m4_gm
let s1_xx1_m4_gds = @m.x1.xdut.xx1_m4.msky130_fd_pr__nfet_01v8_lvt[gds]
echo OPV XX1_M4 gds $&s1_xx1_m4_gds
let s1_xx1_m4_gmbs = @m.x1.xdut.xx1_m4.msky130_fd_pr__nfet_01v8_lvt[gmbs]
echo OPV XX1_M4 gmbs $&s1_xx1_m4_gmbs
let s1_xx1_m4_cgg = @m.x1.xdut.xx1_m4.msky130_fd_pr__nfet_01v8_lvt[cgg]
echo OPV XX1_M4 cgg $&s1_xx1_m4_cgg
let s1_xx1_m4_cgd = @m.x1.xdut.xx1_m4.msky130_fd_pr__nfet_01v8_lvt[cgd]
echo OPV XX1_M4 cgd $&s1_xx1_m4_cgd
let s1_xx1_m4_cgs = @m.x1.xdut.xx1_m4.msky130_fd_pr__nfet_01v8_lvt[cgs]
echo OPV XX1_M4 cgs $&s1_xx1_m4_cgs
let s1_xx1_m4_cgb = @m.x1.xdut.xx1_m4.msky130_fd_pr__nfet_01v8_lvt[cgb]
echo OPV XX1_M4 cgb $&s1_xx1_m4_cgb
let s1_xx1_m4_cdg = @m.x1.xdut.xx1_m4.msky130_fd_pr__nfet_01v8_lvt[cdg]
echo OPV XX1_M4 cdg $&s1_xx1_m4_cdg
let s1_xx1_m4_cdd = @m.x1.xdut.xx1_m4.msky130_fd_pr__nfet_01v8_lvt[cdd]
echo OPV XX1_M4 cdd $&s1_xx1_m4_cdd
let s1_xx1_m4_cds = @m.x1.xdut.xx1_m4.msky130_fd_pr__nfet_01v8_lvt[cds]
echo OPV XX1_M4 cds $&s1_xx1_m4_cds
let s1_xx1_m4_cdb = @m.x1.xdut.xx1_m4.msky130_fd_pr__nfet_01v8_lvt[cdb]
echo OPV XX1_M4 cdb $&s1_xx1_m4_cdb
let s1_xx1_m4_csg = @m.x1.xdut.xx1_m4.msky130_fd_pr__nfet_01v8_lvt[csg]
echo OPV XX1_M4 csg $&s1_xx1_m4_csg
let s1_xx1_m4_csd = @m.x1.xdut.xx1_m4.msky130_fd_pr__nfet_01v8_lvt[csd]
echo OPV XX1_M4 csd $&s1_xx1_m4_csd
let s1_xx1_m4_css = @m.x1.xdut.xx1_m4.msky130_fd_pr__nfet_01v8_lvt[css]
echo OPV XX1_M4 css $&s1_xx1_m4_css
let s1_xx1_m4_csb = @m.x1.xdut.xx1_m4.msky130_fd_pr__nfet_01v8_lvt[csb]
echo OPV XX1_M4 csb $&s1_xx1_m4_csb
let s1_xx1_m4_cbg = @m.x1.xdut.xx1_m4.msky130_fd_pr__nfet_01v8_lvt[cbg]
echo OPV XX1_M4 cbg $&s1_xx1_m4_cbg
let s1_xx1_m4_cbd = @m.x1.xdut.xx1_m4.msky130_fd_pr__nfet_01v8_lvt[cbd]
echo OPV XX1_M4 cbd $&s1_xx1_m4_cbd
let s1_xx1_m4_cbs = @m.x1.xdut.xx1_m4.msky130_fd_pr__nfet_01v8_lvt[cbs]
echo OPV XX1_M4 cbs $&s1_xx1_m4_cbs
let s1_xx1_m4_cbb = @m.x1.xdut.xx1_m4.msky130_fd_pr__nfet_01v8_lvt[cbb]
echo OPV XX1_M4 cbb $&s1_xx1_m4_cbb
let s1_xx1_m4_capbd = @m.x1.xdut.xx1_m4.msky130_fd_pr__nfet_01v8_lvt[capbd]
echo OPV XX1_M4 capbd $&s1_xx1_m4_capbd
let s1_xx1_m4_capbs = @m.x1.xdut.xx1_m4.msky130_fd_pr__nfet_01v8_lvt[capbs]
echo OPV XX1_M4 capbs $&s1_xx1_m4_capbs
let s1_xx1_m4_cgso = @m.x1.xdut.xx1_m4.msky130_fd_pr__nfet_01v8_lvt[cgso]
echo OPV XX1_M4 cgso $&s1_xx1_m4_cgso
let s1_xx1_m4_cgdo = @m.x1.xdut.xx1_m4.msky130_fd_pr__nfet_01v8_lvt[cgdo]
echo OPV XX1_M4 cgdo $&s1_xx1_m4_cgdo
let s1_xx1_m4_cgbo = @m.x1.xdut.xx1_m4.msky130_fd_pr__nfet_01v8_lvt[cgbo]
echo OPV XX1_M4 cgbo $&s1_xx1_m4_cgbo
let s1_xx1_m4_weff = @m.x1.xdut.xx1_m4.msky130_fd_pr__nfet_01v8_lvt[weff]
echo OPV XX1_M4 weff $&s1_xx1_m4_weff
let s1_xx1_m4_leff = @m.x1.xdut.xx1_m4.msky130_fd_pr__nfet_01v8_lvt[leff]
echo OPV XX1_M4 leff $&s1_xx1_m4_leff
let s1_xx1_m7_id = @m.x1.xdut.xx1_m7.msky130_fd_pr__nfet_01v8_lvt[id]
echo OPV XX1_M7 id $&s1_xx1_m7_id
let s1_xx1_m7_vgs = @m.x1.xdut.xx1_m7.msky130_fd_pr__nfet_01v8_lvt[vgs]
echo OPV XX1_M7 vgs $&s1_xx1_m7_vgs
let s1_xx1_m7_vds = @m.x1.xdut.xx1_m7.msky130_fd_pr__nfet_01v8_lvt[vds]
echo OPV XX1_M7 vds $&s1_xx1_m7_vds
let s1_xx1_m7_vbs = @m.x1.xdut.xx1_m7.msky130_fd_pr__nfet_01v8_lvt[vbs]
echo OPV XX1_M7 vbs $&s1_xx1_m7_vbs
let s1_xx1_m7_vth = @m.x1.xdut.xx1_m7.msky130_fd_pr__nfet_01v8_lvt[vth]
echo OPV XX1_M7 vth $&s1_xx1_m7_vth
let s1_xx1_m7_vdsat = @m.x1.xdut.xx1_m7.msky130_fd_pr__nfet_01v8_lvt[vdsat]
echo OPV XX1_M7 vdsat $&s1_xx1_m7_vdsat
let s1_xx1_m7_gm = @m.x1.xdut.xx1_m7.msky130_fd_pr__nfet_01v8_lvt[gm]
echo OPV XX1_M7 gm $&s1_xx1_m7_gm
let s1_xx1_m7_gds = @m.x1.xdut.xx1_m7.msky130_fd_pr__nfet_01v8_lvt[gds]
echo OPV XX1_M7 gds $&s1_xx1_m7_gds
let s1_xx1_m7_gmbs = @m.x1.xdut.xx1_m7.msky130_fd_pr__nfet_01v8_lvt[gmbs]
echo OPV XX1_M7 gmbs $&s1_xx1_m7_gmbs
let s1_xx1_m7_cgg = @m.x1.xdut.xx1_m7.msky130_fd_pr__nfet_01v8_lvt[cgg]
echo OPV XX1_M7 cgg $&s1_xx1_m7_cgg
let s1_xx1_m7_cgd = @m.x1.xdut.xx1_m7.msky130_fd_pr__nfet_01v8_lvt[cgd]
echo OPV XX1_M7 cgd $&s1_xx1_m7_cgd
let s1_xx1_m7_cgs = @m.x1.xdut.xx1_m7.msky130_fd_pr__nfet_01v8_lvt[cgs]
echo OPV XX1_M7 cgs $&s1_xx1_m7_cgs
let s1_xx1_m7_cgb = @m.x1.xdut.xx1_m7.msky130_fd_pr__nfet_01v8_lvt[cgb]
echo OPV XX1_M7 cgb $&s1_xx1_m7_cgb
let s1_xx1_m7_cdg = @m.x1.xdut.xx1_m7.msky130_fd_pr__nfet_01v8_lvt[cdg]
echo OPV XX1_M7 cdg $&s1_xx1_m7_cdg
let s1_xx1_m7_cdd = @m.x1.xdut.xx1_m7.msky130_fd_pr__nfet_01v8_lvt[cdd]
echo OPV XX1_M7 cdd $&s1_xx1_m7_cdd
let s1_xx1_m7_cds = @m.x1.xdut.xx1_m7.msky130_fd_pr__nfet_01v8_lvt[cds]
echo OPV XX1_M7 cds $&s1_xx1_m7_cds
let s1_xx1_m7_cdb = @m.x1.xdut.xx1_m7.msky130_fd_pr__nfet_01v8_lvt[cdb]
echo OPV XX1_M7 cdb $&s1_xx1_m7_cdb
let s1_xx1_m7_csg = @m.x1.xdut.xx1_m7.msky130_fd_pr__nfet_01v8_lvt[csg]
echo OPV XX1_M7 csg $&s1_xx1_m7_csg
let s1_xx1_m7_csd = @m.x1.xdut.xx1_m7.msky130_fd_pr__nfet_01v8_lvt[csd]
echo OPV XX1_M7 csd $&s1_xx1_m7_csd
let s1_xx1_m7_css = @m.x1.xdut.xx1_m7.msky130_fd_pr__nfet_01v8_lvt[css]
echo OPV XX1_M7 css $&s1_xx1_m7_css
let s1_xx1_m7_csb = @m.x1.xdut.xx1_m7.msky130_fd_pr__nfet_01v8_lvt[csb]
echo OPV XX1_M7 csb $&s1_xx1_m7_csb
let s1_xx1_m7_cbg = @m.x1.xdut.xx1_m7.msky130_fd_pr__nfet_01v8_lvt[cbg]
echo OPV XX1_M7 cbg $&s1_xx1_m7_cbg
let s1_xx1_m7_cbd = @m.x1.xdut.xx1_m7.msky130_fd_pr__nfet_01v8_lvt[cbd]
echo OPV XX1_M7 cbd $&s1_xx1_m7_cbd
let s1_xx1_m7_cbs = @m.x1.xdut.xx1_m7.msky130_fd_pr__nfet_01v8_lvt[cbs]
echo OPV XX1_M7 cbs $&s1_xx1_m7_cbs
let s1_xx1_m7_cbb = @m.x1.xdut.xx1_m7.msky130_fd_pr__nfet_01v8_lvt[cbb]
echo OPV XX1_M7 cbb $&s1_xx1_m7_cbb
let s1_xx1_m7_capbd = @m.x1.xdut.xx1_m7.msky130_fd_pr__nfet_01v8_lvt[capbd]
echo OPV XX1_M7 capbd $&s1_xx1_m7_capbd
let s1_xx1_m7_capbs = @m.x1.xdut.xx1_m7.msky130_fd_pr__nfet_01v8_lvt[capbs]
echo OPV XX1_M7 capbs $&s1_xx1_m7_capbs
let s1_xx1_m7_cgso = @m.x1.xdut.xx1_m7.msky130_fd_pr__nfet_01v8_lvt[cgso]
echo OPV XX1_M7 cgso $&s1_xx1_m7_cgso
let s1_xx1_m7_cgdo = @m.x1.xdut.xx1_m7.msky130_fd_pr__nfet_01v8_lvt[cgdo]
echo OPV XX1_M7 cgdo $&s1_xx1_m7_cgdo
let s1_xx1_m7_cgbo = @m.x1.xdut.xx1_m7.msky130_fd_pr__nfet_01v8_lvt[cgbo]
echo OPV XX1_M7 cgbo $&s1_xx1_m7_cgbo
let s1_xx1_m7_weff = @m.x1.xdut.xx1_m7.msky130_fd_pr__nfet_01v8_lvt[weff]
echo OPV XX1_M7 weff $&s1_xx1_m7_weff
let s1_xx1_m7_leff = @m.x1.xdut.xx1_m7.msky130_fd_pr__nfet_01v8_lvt[leff]
echo OPV XX1_M7 leff $&s1_xx1_m7_leff
let s1_xx1_m8_id = @m.x1.xdut.xx1_m8.msky130_fd_pr__nfet_01v8_lvt[id]
echo OPV XX1_M8 id $&s1_xx1_m8_id
let s1_xx1_m8_vgs = @m.x1.xdut.xx1_m8.msky130_fd_pr__nfet_01v8_lvt[vgs]
echo OPV XX1_M8 vgs $&s1_xx1_m8_vgs
let s1_xx1_m8_vds = @m.x1.xdut.xx1_m8.msky130_fd_pr__nfet_01v8_lvt[vds]
echo OPV XX1_M8 vds $&s1_xx1_m8_vds
let s1_xx1_m8_vbs = @m.x1.xdut.xx1_m8.msky130_fd_pr__nfet_01v8_lvt[vbs]
echo OPV XX1_M8 vbs $&s1_xx1_m8_vbs
let s1_xx1_m8_vth = @m.x1.xdut.xx1_m8.msky130_fd_pr__nfet_01v8_lvt[vth]
echo OPV XX1_M8 vth $&s1_xx1_m8_vth
let s1_xx1_m8_vdsat = @m.x1.xdut.xx1_m8.msky130_fd_pr__nfet_01v8_lvt[vdsat]
echo OPV XX1_M8 vdsat $&s1_xx1_m8_vdsat
let s1_xx1_m8_gm = @m.x1.xdut.xx1_m8.msky130_fd_pr__nfet_01v8_lvt[gm]
echo OPV XX1_M8 gm $&s1_xx1_m8_gm
let s1_xx1_m8_gds = @m.x1.xdut.xx1_m8.msky130_fd_pr__nfet_01v8_lvt[gds]
echo OPV XX1_M8 gds $&s1_xx1_m8_gds
let s1_xx1_m8_gmbs = @m.x1.xdut.xx1_m8.msky130_fd_pr__nfet_01v8_lvt[gmbs]
echo OPV XX1_M8 gmbs $&s1_xx1_m8_gmbs
let s1_xx1_m8_cgg = @m.x1.xdut.xx1_m8.msky130_fd_pr__nfet_01v8_lvt[cgg]
echo OPV XX1_M8 cgg $&s1_xx1_m8_cgg
let s1_xx1_m8_cgd = @m.x1.xdut.xx1_m8.msky130_fd_pr__nfet_01v8_lvt[cgd]
echo OPV XX1_M8 cgd $&s1_xx1_m8_cgd
let s1_xx1_m8_cgs = @m.x1.xdut.xx1_m8.msky130_fd_pr__nfet_01v8_lvt[cgs]
echo OPV XX1_M8 cgs $&s1_xx1_m8_cgs
let s1_xx1_m8_cgb = @m.x1.xdut.xx1_m8.msky130_fd_pr__nfet_01v8_lvt[cgb]
echo OPV XX1_M8 cgb $&s1_xx1_m8_cgb
let s1_xx1_m8_cdg = @m.x1.xdut.xx1_m8.msky130_fd_pr__nfet_01v8_lvt[cdg]
echo OPV XX1_M8 cdg $&s1_xx1_m8_cdg
let s1_xx1_m8_cdd = @m.x1.xdut.xx1_m8.msky130_fd_pr__nfet_01v8_lvt[cdd]
echo OPV XX1_M8 cdd $&s1_xx1_m8_cdd
let s1_xx1_m8_cds = @m.x1.xdut.xx1_m8.msky130_fd_pr__nfet_01v8_lvt[cds]
echo OPV XX1_M8 cds $&s1_xx1_m8_cds
let s1_xx1_m8_cdb = @m.x1.xdut.xx1_m8.msky130_fd_pr__nfet_01v8_lvt[cdb]
echo OPV XX1_M8 cdb $&s1_xx1_m8_cdb
let s1_xx1_m8_csg = @m.x1.xdut.xx1_m8.msky130_fd_pr__nfet_01v8_lvt[csg]
echo OPV XX1_M8 csg $&s1_xx1_m8_csg
let s1_xx1_m8_csd = @m.x1.xdut.xx1_m8.msky130_fd_pr__nfet_01v8_lvt[csd]
echo OPV XX1_M8 csd $&s1_xx1_m8_csd
let s1_xx1_m8_css = @m.x1.xdut.xx1_m8.msky130_fd_pr__nfet_01v8_lvt[css]
echo OPV XX1_M8 css $&s1_xx1_m8_css
let s1_xx1_m8_csb = @m.x1.xdut.xx1_m8.msky130_fd_pr__nfet_01v8_lvt[csb]
echo OPV XX1_M8 csb $&s1_xx1_m8_csb
let s1_xx1_m8_cbg = @m.x1.xdut.xx1_m8.msky130_fd_pr__nfet_01v8_lvt[cbg]
echo OPV XX1_M8 cbg $&s1_xx1_m8_cbg
let s1_xx1_m8_cbd = @m.x1.xdut.xx1_m8.msky130_fd_pr__nfet_01v8_lvt[cbd]
echo OPV XX1_M8 cbd $&s1_xx1_m8_cbd
let s1_xx1_m8_cbs = @m.x1.xdut.xx1_m8.msky130_fd_pr__nfet_01v8_lvt[cbs]
echo OPV XX1_M8 cbs $&s1_xx1_m8_cbs
let s1_xx1_m8_cbb = @m.x1.xdut.xx1_m8.msky130_fd_pr__nfet_01v8_lvt[cbb]
echo OPV XX1_M8 cbb $&s1_xx1_m8_cbb
let s1_xx1_m8_capbd = @m.x1.xdut.xx1_m8.msky130_fd_pr__nfet_01v8_lvt[capbd]
echo OPV XX1_M8 capbd $&s1_xx1_m8_capbd
let s1_xx1_m8_capbs = @m.x1.xdut.xx1_m8.msky130_fd_pr__nfet_01v8_lvt[capbs]
echo OPV XX1_M8 capbs $&s1_xx1_m8_capbs
let s1_xx1_m8_cgso = @m.x1.xdut.xx1_m8.msky130_fd_pr__nfet_01v8_lvt[cgso]
echo OPV XX1_M8 cgso $&s1_xx1_m8_cgso
let s1_xx1_m8_cgdo = @m.x1.xdut.xx1_m8.msky130_fd_pr__nfet_01v8_lvt[cgdo]
echo OPV XX1_M8 cgdo $&s1_xx1_m8_cgdo
let s1_xx1_m8_cgbo = @m.x1.xdut.xx1_m8.msky130_fd_pr__nfet_01v8_lvt[cgbo]
echo OPV XX1_M8 cgbo $&s1_xx1_m8_cgbo
let s1_xx1_m8_weff = @m.x1.xdut.xx1_m8.msky130_fd_pr__nfet_01v8_lvt[weff]
echo OPV XX1_M8 weff $&s1_xx1_m8_weff
let s1_xx1_m8_leff = @m.x1.xdut.xx1_m8.msky130_fd_pr__nfet_01v8_lvt[leff]
echo OPV XX1_M8 leff $&s1_xx1_m8_leff
let s1_xx1_m9_id = @m.x1.xdut.xx1_m9.msky130_fd_pr__nfet_01v8_lvt[id]
echo OPV XX1_M9 id $&s1_xx1_m9_id
let s1_xx1_m9_vgs = @m.x1.xdut.xx1_m9.msky130_fd_pr__nfet_01v8_lvt[vgs]
echo OPV XX1_M9 vgs $&s1_xx1_m9_vgs
let s1_xx1_m9_vds = @m.x1.xdut.xx1_m9.msky130_fd_pr__nfet_01v8_lvt[vds]
echo OPV XX1_M9 vds $&s1_xx1_m9_vds
let s1_xx1_m9_vbs = @m.x1.xdut.xx1_m9.msky130_fd_pr__nfet_01v8_lvt[vbs]
echo OPV XX1_M9 vbs $&s1_xx1_m9_vbs
let s1_xx1_m9_vth = @m.x1.xdut.xx1_m9.msky130_fd_pr__nfet_01v8_lvt[vth]
echo OPV XX1_M9 vth $&s1_xx1_m9_vth
let s1_xx1_m9_vdsat = @m.x1.xdut.xx1_m9.msky130_fd_pr__nfet_01v8_lvt[vdsat]
echo OPV XX1_M9 vdsat $&s1_xx1_m9_vdsat
let s1_xx1_m9_gm = @m.x1.xdut.xx1_m9.msky130_fd_pr__nfet_01v8_lvt[gm]
echo OPV XX1_M9 gm $&s1_xx1_m9_gm
let s1_xx1_m9_gds = @m.x1.xdut.xx1_m9.msky130_fd_pr__nfet_01v8_lvt[gds]
echo OPV XX1_M9 gds $&s1_xx1_m9_gds
let s1_xx1_m9_gmbs = @m.x1.xdut.xx1_m9.msky130_fd_pr__nfet_01v8_lvt[gmbs]
echo OPV XX1_M9 gmbs $&s1_xx1_m9_gmbs
let s1_xx1_m9_cgg = @m.x1.xdut.xx1_m9.msky130_fd_pr__nfet_01v8_lvt[cgg]
echo OPV XX1_M9 cgg $&s1_xx1_m9_cgg
let s1_xx1_m9_cgd = @m.x1.xdut.xx1_m9.msky130_fd_pr__nfet_01v8_lvt[cgd]
echo OPV XX1_M9 cgd $&s1_xx1_m9_cgd
let s1_xx1_m9_cgs = @m.x1.xdut.xx1_m9.msky130_fd_pr__nfet_01v8_lvt[cgs]
echo OPV XX1_M9 cgs $&s1_xx1_m9_cgs
let s1_xx1_m9_cgb = @m.x1.xdut.xx1_m9.msky130_fd_pr__nfet_01v8_lvt[cgb]
echo OPV XX1_M9 cgb $&s1_xx1_m9_cgb
let s1_xx1_m9_cdg = @m.x1.xdut.xx1_m9.msky130_fd_pr__nfet_01v8_lvt[cdg]
echo OPV XX1_M9 cdg $&s1_xx1_m9_cdg
let s1_xx1_m9_cdd = @m.x1.xdut.xx1_m9.msky130_fd_pr__nfet_01v8_lvt[cdd]
echo OPV XX1_M9 cdd $&s1_xx1_m9_cdd
let s1_xx1_m9_cds = @m.x1.xdut.xx1_m9.msky130_fd_pr__nfet_01v8_lvt[cds]
echo OPV XX1_M9 cds $&s1_xx1_m9_cds
let s1_xx1_m9_cdb = @m.x1.xdut.xx1_m9.msky130_fd_pr__nfet_01v8_lvt[cdb]
echo OPV XX1_M9 cdb $&s1_xx1_m9_cdb
let s1_xx1_m9_csg = @m.x1.xdut.xx1_m9.msky130_fd_pr__nfet_01v8_lvt[csg]
echo OPV XX1_M9 csg $&s1_xx1_m9_csg
let s1_xx1_m9_csd = @m.x1.xdut.xx1_m9.msky130_fd_pr__nfet_01v8_lvt[csd]
echo OPV XX1_M9 csd $&s1_xx1_m9_csd
let s1_xx1_m9_css = @m.x1.xdut.xx1_m9.msky130_fd_pr__nfet_01v8_lvt[css]
echo OPV XX1_M9 css $&s1_xx1_m9_css
let s1_xx1_m9_csb = @m.x1.xdut.xx1_m9.msky130_fd_pr__nfet_01v8_lvt[csb]
echo OPV XX1_M9 csb $&s1_xx1_m9_csb
let s1_xx1_m9_cbg = @m.x1.xdut.xx1_m9.msky130_fd_pr__nfet_01v8_lvt[cbg]
echo OPV XX1_M9 cbg $&s1_xx1_m9_cbg
let s1_xx1_m9_cbd = @m.x1.xdut.xx1_m9.msky130_fd_pr__nfet_01v8_lvt[cbd]
echo OPV XX1_M9 cbd $&s1_xx1_m9_cbd
let s1_xx1_m9_cbs = @m.x1.xdut.xx1_m9.msky130_fd_pr__nfet_01v8_lvt[cbs]
echo OPV XX1_M9 cbs $&s1_xx1_m9_cbs
let s1_xx1_m9_cbb = @m.x1.xdut.xx1_m9.msky130_fd_pr__nfet_01v8_lvt[cbb]
echo OPV XX1_M9 cbb $&s1_xx1_m9_cbb
let s1_xx1_m9_capbd = @m.x1.xdut.xx1_m9.msky130_fd_pr__nfet_01v8_lvt[capbd]
echo OPV XX1_M9 capbd $&s1_xx1_m9_capbd
let s1_xx1_m9_capbs = @m.x1.xdut.xx1_m9.msky130_fd_pr__nfet_01v8_lvt[capbs]
echo OPV XX1_M9 capbs $&s1_xx1_m9_capbs
let s1_xx1_m9_cgso = @m.x1.xdut.xx1_m9.msky130_fd_pr__nfet_01v8_lvt[cgso]
echo OPV XX1_M9 cgso $&s1_xx1_m9_cgso
let s1_xx1_m9_cgdo = @m.x1.xdut.xx1_m9.msky130_fd_pr__nfet_01v8_lvt[cgdo]
echo OPV XX1_M9 cgdo $&s1_xx1_m9_cgdo
let s1_xx1_m9_cgbo = @m.x1.xdut.xx1_m9.msky130_fd_pr__nfet_01v8_lvt[cgbo]
echo OPV XX1_M9 cgbo $&s1_xx1_m9_cgbo
let s1_xx1_m9_weff = @m.x1.xdut.xx1_m9.msky130_fd_pr__nfet_01v8_lvt[weff]
echo OPV XX1_M9 weff $&s1_xx1_m9_weff
let s1_xx1_m9_leff = @m.x1.xdut.xx1_m9.msky130_fd_pr__nfet_01v8_lvt[leff]
echo OPV XX1_M9 leff $&s1_xx1_m9_leff
let s1_xx1_m10_id = @m.x1.xdut.xx1_m10.msky130_fd_pr__nfet_01v8_lvt[id]
echo OPV XX1_M10 id $&s1_xx1_m10_id
let s1_xx1_m10_vgs = @m.x1.xdut.xx1_m10.msky130_fd_pr__nfet_01v8_lvt[vgs]
echo OPV XX1_M10 vgs $&s1_xx1_m10_vgs
let s1_xx1_m10_vds = @m.x1.xdut.xx1_m10.msky130_fd_pr__nfet_01v8_lvt[vds]
echo OPV XX1_M10 vds $&s1_xx1_m10_vds
let s1_xx1_m10_vbs = @m.x1.xdut.xx1_m10.msky130_fd_pr__nfet_01v8_lvt[vbs]
echo OPV XX1_M10 vbs $&s1_xx1_m10_vbs
let s1_xx1_m10_vth = @m.x1.xdut.xx1_m10.msky130_fd_pr__nfet_01v8_lvt[vth]
echo OPV XX1_M10 vth $&s1_xx1_m10_vth
let s1_xx1_m10_vdsat = @m.x1.xdut.xx1_m10.msky130_fd_pr__nfet_01v8_lvt[vdsat]
echo OPV XX1_M10 vdsat $&s1_xx1_m10_vdsat
let s1_xx1_m10_gm = @m.x1.xdut.xx1_m10.msky130_fd_pr__nfet_01v8_lvt[gm]
echo OPV XX1_M10 gm $&s1_xx1_m10_gm
let s1_xx1_m10_gds = @m.x1.xdut.xx1_m10.msky130_fd_pr__nfet_01v8_lvt[gds]
echo OPV XX1_M10 gds $&s1_xx1_m10_gds
let s1_xx1_m10_gmbs = @m.x1.xdut.xx1_m10.msky130_fd_pr__nfet_01v8_lvt[gmbs]
echo OPV XX1_M10 gmbs $&s1_xx1_m10_gmbs
let s1_xx1_m10_cgg = @m.x1.xdut.xx1_m10.msky130_fd_pr__nfet_01v8_lvt[cgg]
echo OPV XX1_M10 cgg $&s1_xx1_m10_cgg
let s1_xx1_m10_cgd = @m.x1.xdut.xx1_m10.msky130_fd_pr__nfet_01v8_lvt[cgd]
echo OPV XX1_M10 cgd $&s1_xx1_m10_cgd
let s1_xx1_m10_cgs = @m.x1.xdut.xx1_m10.msky130_fd_pr__nfet_01v8_lvt[cgs]
echo OPV XX1_M10 cgs $&s1_xx1_m10_cgs
let s1_xx1_m10_cgb = @m.x1.xdut.xx1_m10.msky130_fd_pr__nfet_01v8_lvt[cgb]
echo OPV XX1_M10 cgb $&s1_xx1_m10_cgb
let s1_xx1_m10_cdg = @m.x1.xdut.xx1_m10.msky130_fd_pr__nfet_01v8_lvt[cdg]
echo OPV XX1_M10 cdg $&s1_xx1_m10_cdg
let s1_xx1_m10_cdd = @m.x1.xdut.xx1_m10.msky130_fd_pr__nfet_01v8_lvt[cdd]
echo OPV XX1_M10 cdd $&s1_xx1_m10_cdd
let s1_xx1_m10_cds = @m.x1.xdut.xx1_m10.msky130_fd_pr__nfet_01v8_lvt[cds]
echo OPV XX1_M10 cds $&s1_xx1_m10_cds
let s1_xx1_m10_cdb = @m.x1.xdut.xx1_m10.msky130_fd_pr__nfet_01v8_lvt[cdb]
echo OPV XX1_M10 cdb $&s1_xx1_m10_cdb
let s1_xx1_m10_csg = @m.x1.xdut.xx1_m10.msky130_fd_pr__nfet_01v8_lvt[csg]
echo OPV XX1_M10 csg $&s1_xx1_m10_csg
let s1_xx1_m10_csd = @m.x1.xdut.xx1_m10.msky130_fd_pr__nfet_01v8_lvt[csd]
echo OPV XX1_M10 csd $&s1_xx1_m10_csd
let s1_xx1_m10_css = @m.x1.xdut.xx1_m10.msky130_fd_pr__nfet_01v8_lvt[css]
echo OPV XX1_M10 css $&s1_xx1_m10_css
let s1_xx1_m10_csb = @m.x1.xdut.xx1_m10.msky130_fd_pr__nfet_01v8_lvt[csb]
echo OPV XX1_M10 csb $&s1_xx1_m10_csb
let s1_xx1_m10_cbg = @m.x1.xdut.xx1_m10.msky130_fd_pr__nfet_01v8_lvt[cbg]
echo OPV XX1_M10 cbg $&s1_xx1_m10_cbg
let s1_xx1_m10_cbd = @m.x1.xdut.xx1_m10.msky130_fd_pr__nfet_01v8_lvt[cbd]
echo OPV XX1_M10 cbd $&s1_xx1_m10_cbd
let s1_xx1_m10_cbs = @m.x1.xdut.xx1_m10.msky130_fd_pr__nfet_01v8_lvt[cbs]
echo OPV XX1_M10 cbs $&s1_xx1_m10_cbs
let s1_xx1_m10_cbb = @m.x1.xdut.xx1_m10.msky130_fd_pr__nfet_01v8_lvt[cbb]
echo OPV XX1_M10 cbb $&s1_xx1_m10_cbb
let s1_xx1_m10_capbd = @m.x1.xdut.xx1_m10.msky130_fd_pr__nfet_01v8_lvt[capbd]
echo OPV XX1_M10 capbd $&s1_xx1_m10_capbd
let s1_xx1_m10_capbs = @m.x1.xdut.xx1_m10.msky130_fd_pr__nfet_01v8_lvt[capbs]
echo OPV XX1_M10 capbs $&s1_xx1_m10_capbs
let s1_xx1_m10_cgso = @m.x1.xdut.xx1_m10.msky130_fd_pr__nfet_01v8_lvt[cgso]
echo OPV XX1_M10 cgso $&s1_xx1_m10_cgso
let s1_xx1_m10_cgdo = @m.x1.xdut.xx1_m10.msky130_fd_pr__nfet_01v8_lvt[cgdo]
echo OPV XX1_M10 cgdo $&s1_xx1_m10_cgdo
let s1_xx1_m10_cgbo = @m.x1.xdut.xx1_m10.msky130_fd_pr__nfet_01v8_lvt[cgbo]
echo OPV XX1_M10 cgbo $&s1_xx1_m10_cgbo
let s1_xx1_m10_weff = @m.x1.xdut.xx1_m10.msky130_fd_pr__nfet_01v8_lvt[weff]
echo OPV XX1_M10 weff $&s1_xx1_m10_weff
let s1_xx1_m10_leff = @m.x1.xdut.xx1_m10.msky130_fd_pr__nfet_01v8_lvt[leff]
echo OPV XX1_M10 leff $&s1_xx1_m10_leff
let s1_xx1_m17_id = @m.x1.xdut.xx1_m17.msky130_fd_pr__nfet_01v8_lvt[id]
echo OPV XX1_M17 id $&s1_xx1_m17_id
let s1_xx1_m17_vgs = @m.x1.xdut.xx1_m17.msky130_fd_pr__nfet_01v8_lvt[vgs]
echo OPV XX1_M17 vgs $&s1_xx1_m17_vgs
let s1_xx1_m17_vds = @m.x1.xdut.xx1_m17.msky130_fd_pr__nfet_01v8_lvt[vds]
echo OPV XX1_M17 vds $&s1_xx1_m17_vds
let s1_xx1_m17_vbs = @m.x1.xdut.xx1_m17.msky130_fd_pr__nfet_01v8_lvt[vbs]
echo OPV XX1_M17 vbs $&s1_xx1_m17_vbs
let s1_xx1_m17_vth = @m.x1.xdut.xx1_m17.msky130_fd_pr__nfet_01v8_lvt[vth]
echo OPV XX1_M17 vth $&s1_xx1_m17_vth
let s1_xx1_m17_vdsat = @m.x1.xdut.xx1_m17.msky130_fd_pr__nfet_01v8_lvt[vdsat]
echo OPV XX1_M17 vdsat $&s1_xx1_m17_vdsat
let s1_xx1_m17_gm = @m.x1.xdut.xx1_m17.msky130_fd_pr__nfet_01v8_lvt[gm]
echo OPV XX1_M17 gm $&s1_xx1_m17_gm
let s1_xx1_m17_gds = @m.x1.xdut.xx1_m17.msky130_fd_pr__nfet_01v8_lvt[gds]
echo OPV XX1_M17 gds $&s1_xx1_m17_gds
let s1_xx1_m17_gmbs = @m.x1.xdut.xx1_m17.msky130_fd_pr__nfet_01v8_lvt[gmbs]
echo OPV XX1_M17 gmbs $&s1_xx1_m17_gmbs
let s1_xx1_m17_cgg = @m.x1.xdut.xx1_m17.msky130_fd_pr__nfet_01v8_lvt[cgg]
echo OPV XX1_M17 cgg $&s1_xx1_m17_cgg
let s1_xx1_m17_cgd = @m.x1.xdut.xx1_m17.msky130_fd_pr__nfet_01v8_lvt[cgd]
echo OPV XX1_M17 cgd $&s1_xx1_m17_cgd
let s1_xx1_m17_cgs = @m.x1.xdut.xx1_m17.msky130_fd_pr__nfet_01v8_lvt[cgs]
echo OPV XX1_M17 cgs $&s1_xx1_m17_cgs
let s1_xx1_m17_cgb = @m.x1.xdut.xx1_m17.msky130_fd_pr__nfet_01v8_lvt[cgb]
echo OPV XX1_M17 cgb $&s1_xx1_m17_cgb
let s1_xx1_m17_cdg = @m.x1.xdut.xx1_m17.msky130_fd_pr__nfet_01v8_lvt[cdg]
echo OPV XX1_M17 cdg $&s1_xx1_m17_cdg
let s1_xx1_m17_cdd = @m.x1.xdut.xx1_m17.msky130_fd_pr__nfet_01v8_lvt[cdd]
echo OPV XX1_M17 cdd $&s1_xx1_m17_cdd
let s1_xx1_m17_cds = @m.x1.xdut.xx1_m17.msky130_fd_pr__nfet_01v8_lvt[cds]
echo OPV XX1_M17 cds $&s1_xx1_m17_cds
let s1_xx1_m17_cdb = @m.x1.xdut.xx1_m17.msky130_fd_pr__nfet_01v8_lvt[cdb]
echo OPV XX1_M17 cdb $&s1_xx1_m17_cdb
let s1_xx1_m17_csg = @m.x1.xdut.xx1_m17.msky130_fd_pr__nfet_01v8_lvt[csg]
echo OPV XX1_M17 csg $&s1_xx1_m17_csg
let s1_xx1_m17_csd = @m.x1.xdut.xx1_m17.msky130_fd_pr__nfet_01v8_lvt[csd]
echo OPV XX1_M17 csd $&s1_xx1_m17_csd
let s1_xx1_m17_css = @m.x1.xdut.xx1_m17.msky130_fd_pr__nfet_01v8_lvt[css]
echo OPV XX1_M17 css $&s1_xx1_m17_css
let s1_xx1_m17_csb = @m.x1.xdut.xx1_m17.msky130_fd_pr__nfet_01v8_lvt[csb]
echo OPV XX1_M17 csb $&s1_xx1_m17_csb
let s1_xx1_m17_cbg = @m.x1.xdut.xx1_m17.msky130_fd_pr__nfet_01v8_lvt[cbg]
echo OPV XX1_M17 cbg $&s1_xx1_m17_cbg
let s1_xx1_m17_cbd = @m.x1.xdut.xx1_m17.msky130_fd_pr__nfet_01v8_lvt[cbd]
echo OPV XX1_M17 cbd $&s1_xx1_m17_cbd
let s1_xx1_m17_cbs = @m.x1.xdut.xx1_m17.msky130_fd_pr__nfet_01v8_lvt[cbs]
echo OPV XX1_M17 cbs $&s1_xx1_m17_cbs
let s1_xx1_m17_cbb = @m.x1.xdut.xx1_m17.msky130_fd_pr__nfet_01v8_lvt[cbb]
echo OPV XX1_M17 cbb $&s1_xx1_m17_cbb
let s1_xx1_m17_capbd = @m.x1.xdut.xx1_m17.msky130_fd_pr__nfet_01v8_lvt[capbd]
echo OPV XX1_M17 capbd $&s1_xx1_m17_capbd
let s1_xx1_m17_capbs = @m.x1.xdut.xx1_m17.msky130_fd_pr__nfet_01v8_lvt[capbs]
echo OPV XX1_M17 capbs $&s1_xx1_m17_capbs
let s1_xx1_m17_cgso = @m.x1.xdut.xx1_m17.msky130_fd_pr__nfet_01v8_lvt[cgso]
echo OPV XX1_M17 cgso $&s1_xx1_m17_cgso
let s1_xx1_m17_cgdo = @m.x1.xdut.xx1_m17.msky130_fd_pr__nfet_01v8_lvt[cgdo]
echo OPV XX1_M17 cgdo $&s1_xx1_m17_cgdo
let s1_xx1_m17_cgbo = @m.x1.xdut.xx1_m17.msky130_fd_pr__nfet_01v8_lvt[cgbo]
echo OPV XX1_M17 cgbo $&s1_xx1_m17_cgbo
let s1_xx1_m17_weff = @m.x1.xdut.xx1_m17.msky130_fd_pr__nfet_01v8_lvt[weff]
echo OPV XX1_M17 weff $&s1_xx1_m17_weff
let s1_xx1_m17_leff = @m.x1.xdut.xx1_m17.msky130_fd_pr__nfet_01v8_lvt[leff]
echo OPV XX1_M17 leff $&s1_xx1_m17_leff
let s1_xx1_m18_id = @m.x1.xdut.xx1_m18.msky130_fd_pr__nfet_01v8_lvt[id]
echo OPV XX1_M18 id $&s1_xx1_m18_id
let s1_xx1_m18_vgs = @m.x1.xdut.xx1_m18.msky130_fd_pr__nfet_01v8_lvt[vgs]
echo OPV XX1_M18 vgs $&s1_xx1_m18_vgs
let s1_xx1_m18_vds = @m.x1.xdut.xx1_m18.msky130_fd_pr__nfet_01v8_lvt[vds]
echo OPV XX1_M18 vds $&s1_xx1_m18_vds
let s1_xx1_m18_vbs = @m.x1.xdut.xx1_m18.msky130_fd_pr__nfet_01v8_lvt[vbs]
echo OPV XX1_M18 vbs $&s1_xx1_m18_vbs
let s1_xx1_m18_vth = @m.x1.xdut.xx1_m18.msky130_fd_pr__nfet_01v8_lvt[vth]
echo OPV XX1_M18 vth $&s1_xx1_m18_vth
let s1_xx1_m18_vdsat = @m.x1.xdut.xx1_m18.msky130_fd_pr__nfet_01v8_lvt[vdsat]
echo OPV XX1_M18 vdsat $&s1_xx1_m18_vdsat
let s1_xx1_m18_gm = @m.x1.xdut.xx1_m18.msky130_fd_pr__nfet_01v8_lvt[gm]
echo OPV XX1_M18 gm $&s1_xx1_m18_gm
let s1_xx1_m18_gds = @m.x1.xdut.xx1_m18.msky130_fd_pr__nfet_01v8_lvt[gds]
echo OPV XX1_M18 gds $&s1_xx1_m18_gds
let s1_xx1_m18_gmbs = @m.x1.xdut.xx1_m18.msky130_fd_pr__nfet_01v8_lvt[gmbs]
echo OPV XX1_M18 gmbs $&s1_xx1_m18_gmbs
let s1_xx1_m18_cgg = @m.x1.xdut.xx1_m18.msky130_fd_pr__nfet_01v8_lvt[cgg]
echo OPV XX1_M18 cgg $&s1_xx1_m18_cgg
let s1_xx1_m18_cgd = @m.x1.xdut.xx1_m18.msky130_fd_pr__nfet_01v8_lvt[cgd]
echo OPV XX1_M18 cgd $&s1_xx1_m18_cgd
let s1_xx1_m18_cgs = @m.x1.xdut.xx1_m18.msky130_fd_pr__nfet_01v8_lvt[cgs]
echo OPV XX1_M18 cgs $&s1_xx1_m18_cgs
let s1_xx1_m18_cgb = @m.x1.xdut.xx1_m18.msky130_fd_pr__nfet_01v8_lvt[cgb]
echo OPV XX1_M18 cgb $&s1_xx1_m18_cgb
let s1_xx1_m18_cdg = @m.x1.xdut.xx1_m18.msky130_fd_pr__nfet_01v8_lvt[cdg]
echo OPV XX1_M18 cdg $&s1_xx1_m18_cdg
let s1_xx1_m18_cdd = @m.x1.xdut.xx1_m18.msky130_fd_pr__nfet_01v8_lvt[cdd]
echo OPV XX1_M18 cdd $&s1_xx1_m18_cdd
let s1_xx1_m18_cds = @m.x1.xdut.xx1_m18.msky130_fd_pr__nfet_01v8_lvt[cds]
echo OPV XX1_M18 cds $&s1_xx1_m18_cds
let s1_xx1_m18_cdb = @m.x1.xdut.xx1_m18.msky130_fd_pr__nfet_01v8_lvt[cdb]
echo OPV XX1_M18 cdb $&s1_xx1_m18_cdb
let s1_xx1_m18_csg = @m.x1.xdut.xx1_m18.msky130_fd_pr__nfet_01v8_lvt[csg]
echo OPV XX1_M18 csg $&s1_xx1_m18_csg
let s1_xx1_m18_csd = @m.x1.xdut.xx1_m18.msky130_fd_pr__nfet_01v8_lvt[csd]
echo OPV XX1_M18 csd $&s1_xx1_m18_csd
let s1_xx1_m18_css = @m.x1.xdut.xx1_m18.msky130_fd_pr__nfet_01v8_lvt[css]
echo OPV XX1_M18 css $&s1_xx1_m18_css
let s1_xx1_m18_csb = @m.x1.xdut.xx1_m18.msky130_fd_pr__nfet_01v8_lvt[csb]
echo OPV XX1_M18 csb $&s1_xx1_m18_csb
let s1_xx1_m18_cbg = @m.x1.xdut.xx1_m18.msky130_fd_pr__nfet_01v8_lvt[cbg]
echo OPV XX1_M18 cbg $&s1_xx1_m18_cbg
let s1_xx1_m18_cbd = @m.x1.xdut.xx1_m18.msky130_fd_pr__nfet_01v8_lvt[cbd]
echo OPV XX1_M18 cbd $&s1_xx1_m18_cbd
let s1_xx1_m18_cbs = @m.x1.xdut.xx1_m18.msky130_fd_pr__nfet_01v8_lvt[cbs]
echo OPV XX1_M18 cbs $&s1_xx1_m18_cbs
let s1_xx1_m18_cbb = @m.x1.xdut.xx1_m18.msky130_fd_pr__nfet_01v8_lvt[cbb]
echo OPV XX1_M18 cbb $&s1_xx1_m18_cbb
let s1_xx1_m18_capbd = @m.x1.xdut.xx1_m18.msky130_fd_pr__nfet_01v8_lvt[capbd]
echo OPV XX1_M18 capbd $&s1_xx1_m18_capbd
let s1_xx1_m18_capbs = @m.x1.xdut.xx1_m18.msky130_fd_pr__nfet_01v8_lvt[capbs]
echo OPV XX1_M18 capbs $&s1_xx1_m18_capbs
let s1_xx1_m18_cgso = @m.x1.xdut.xx1_m18.msky130_fd_pr__nfet_01v8_lvt[cgso]
echo OPV XX1_M18 cgso $&s1_xx1_m18_cgso
let s1_xx1_m18_cgdo = @m.x1.xdut.xx1_m18.msky130_fd_pr__nfet_01v8_lvt[cgdo]
echo OPV XX1_M18 cgdo $&s1_xx1_m18_cgdo
let s1_xx1_m18_cgbo = @m.x1.xdut.xx1_m18.msky130_fd_pr__nfet_01v8_lvt[cgbo]
echo OPV XX1_M18 cgbo $&s1_xx1_m18_cgbo
let s1_xx1_m18_weff = @m.x1.xdut.xx1_m18.msky130_fd_pr__nfet_01v8_lvt[weff]
echo OPV XX1_M18 weff $&s1_xx1_m18_weff
let s1_xx1_m18_leff = @m.x1.xdut.xx1_m18.msky130_fd_pr__nfet_01v8_lvt[leff]
echo OPV XX1_M18 leff $&s1_xx1_m18_leff
let s1_xx1_m22_id = @m.x1.xdut.xx1_m22.msky130_fd_pr__nfet_01v8_lvt[id]
echo OPV XX1_M22 id $&s1_xx1_m22_id
let s1_xx1_m22_vgs = @m.x1.xdut.xx1_m22.msky130_fd_pr__nfet_01v8_lvt[vgs]
echo OPV XX1_M22 vgs $&s1_xx1_m22_vgs
let s1_xx1_m22_vds = @m.x1.xdut.xx1_m22.msky130_fd_pr__nfet_01v8_lvt[vds]
echo OPV XX1_M22 vds $&s1_xx1_m22_vds
let s1_xx1_m22_vbs = @m.x1.xdut.xx1_m22.msky130_fd_pr__nfet_01v8_lvt[vbs]
echo OPV XX1_M22 vbs $&s1_xx1_m22_vbs
let s1_xx1_m22_vth = @m.x1.xdut.xx1_m22.msky130_fd_pr__nfet_01v8_lvt[vth]
echo OPV XX1_M22 vth $&s1_xx1_m22_vth
let s1_xx1_m22_vdsat = @m.x1.xdut.xx1_m22.msky130_fd_pr__nfet_01v8_lvt[vdsat]
echo OPV XX1_M22 vdsat $&s1_xx1_m22_vdsat
let s1_xx1_m22_gm = @m.x1.xdut.xx1_m22.msky130_fd_pr__nfet_01v8_lvt[gm]
echo OPV XX1_M22 gm $&s1_xx1_m22_gm
let s1_xx1_m22_gds = @m.x1.xdut.xx1_m22.msky130_fd_pr__nfet_01v8_lvt[gds]
echo OPV XX1_M22 gds $&s1_xx1_m22_gds
let s1_xx1_m22_gmbs = @m.x1.xdut.xx1_m22.msky130_fd_pr__nfet_01v8_lvt[gmbs]
echo OPV XX1_M22 gmbs $&s1_xx1_m22_gmbs
let s1_xx1_m22_cgg = @m.x1.xdut.xx1_m22.msky130_fd_pr__nfet_01v8_lvt[cgg]
echo OPV XX1_M22 cgg $&s1_xx1_m22_cgg
let s1_xx1_m22_cgd = @m.x1.xdut.xx1_m22.msky130_fd_pr__nfet_01v8_lvt[cgd]
echo OPV XX1_M22 cgd $&s1_xx1_m22_cgd
let s1_xx1_m22_cgs = @m.x1.xdut.xx1_m22.msky130_fd_pr__nfet_01v8_lvt[cgs]
echo OPV XX1_M22 cgs $&s1_xx1_m22_cgs
let s1_xx1_m22_cgb = @m.x1.xdut.xx1_m22.msky130_fd_pr__nfet_01v8_lvt[cgb]
echo OPV XX1_M22 cgb $&s1_xx1_m22_cgb
let s1_xx1_m22_cdg = @m.x1.xdut.xx1_m22.msky130_fd_pr__nfet_01v8_lvt[cdg]
echo OPV XX1_M22 cdg $&s1_xx1_m22_cdg
let s1_xx1_m22_cdd = @m.x1.xdut.xx1_m22.msky130_fd_pr__nfet_01v8_lvt[cdd]
echo OPV XX1_M22 cdd $&s1_xx1_m22_cdd
let s1_xx1_m22_cds = @m.x1.xdut.xx1_m22.msky130_fd_pr__nfet_01v8_lvt[cds]
echo OPV XX1_M22 cds $&s1_xx1_m22_cds
let s1_xx1_m22_cdb = @m.x1.xdut.xx1_m22.msky130_fd_pr__nfet_01v8_lvt[cdb]
echo OPV XX1_M22 cdb $&s1_xx1_m22_cdb
let s1_xx1_m22_csg = @m.x1.xdut.xx1_m22.msky130_fd_pr__nfet_01v8_lvt[csg]
echo OPV XX1_M22 csg $&s1_xx1_m22_csg
let s1_xx1_m22_csd = @m.x1.xdut.xx1_m22.msky130_fd_pr__nfet_01v8_lvt[csd]
echo OPV XX1_M22 csd $&s1_xx1_m22_csd
let s1_xx1_m22_css = @m.x1.xdut.xx1_m22.msky130_fd_pr__nfet_01v8_lvt[css]
echo OPV XX1_M22 css $&s1_xx1_m22_css
let s1_xx1_m22_csb = @m.x1.xdut.xx1_m22.msky130_fd_pr__nfet_01v8_lvt[csb]
echo OPV XX1_M22 csb $&s1_xx1_m22_csb
let s1_xx1_m22_cbg = @m.x1.xdut.xx1_m22.msky130_fd_pr__nfet_01v8_lvt[cbg]
echo OPV XX1_M22 cbg $&s1_xx1_m22_cbg
let s1_xx1_m22_cbd = @m.x1.xdut.xx1_m22.msky130_fd_pr__nfet_01v8_lvt[cbd]
echo OPV XX1_M22 cbd $&s1_xx1_m22_cbd
let s1_xx1_m22_cbs = @m.x1.xdut.xx1_m22.msky130_fd_pr__nfet_01v8_lvt[cbs]
echo OPV XX1_M22 cbs $&s1_xx1_m22_cbs
let s1_xx1_m22_cbb = @m.x1.xdut.xx1_m22.msky130_fd_pr__nfet_01v8_lvt[cbb]
echo OPV XX1_M22 cbb $&s1_xx1_m22_cbb
let s1_xx1_m22_capbd = @m.x1.xdut.xx1_m22.msky130_fd_pr__nfet_01v8_lvt[capbd]
echo OPV XX1_M22 capbd $&s1_xx1_m22_capbd
let s1_xx1_m22_capbs = @m.x1.xdut.xx1_m22.msky130_fd_pr__nfet_01v8_lvt[capbs]
echo OPV XX1_M22 capbs $&s1_xx1_m22_capbs
let s1_xx1_m22_cgso = @m.x1.xdut.xx1_m22.msky130_fd_pr__nfet_01v8_lvt[cgso]
echo OPV XX1_M22 cgso $&s1_xx1_m22_cgso
let s1_xx1_m22_cgdo = @m.x1.xdut.xx1_m22.msky130_fd_pr__nfet_01v8_lvt[cgdo]
echo OPV XX1_M22 cgdo $&s1_xx1_m22_cgdo
let s1_xx1_m22_cgbo = @m.x1.xdut.xx1_m22.msky130_fd_pr__nfet_01v8_lvt[cgbo]
echo OPV XX1_M22 cgbo $&s1_xx1_m22_cgbo
let s1_xx1_m22_weff = @m.x1.xdut.xx1_m22.msky130_fd_pr__nfet_01v8_lvt[weff]
echo OPV XX1_M22 weff $&s1_xx1_m22_weff
let s1_xx1_m22_leff = @m.x1.xdut.xx1_m22.msky130_fd_pr__nfet_01v8_lvt[leff]
echo OPV XX1_M22 leff $&s1_xx1_m22_leff
let s1_xx1_m20_id = @m.x1.xdut.xx1_m20.msky130_fd_pr__pfet_01v8_lvt[id]
echo OPV XX1_M20 id $&s1_xx1_m20_id
let s1_xx1_m20_vgs = @m.x1.xdut.xx1_m20.msky130_fd_pr__pfet_01v8_lvt[vgs]
echo OPV XX1_M20 vgs $&s1_xx1_m20_vgs
let s1_xx1_m20_vds = @m.x1.xdut.xx1_m20.msky130_fd_pr__pfet_01v8_lvt[vds]
echo OPV XX1_M20 vds $&s1_xx1_m20_vds
let s1_xx1_m20_vbs = @m.x1.xdut.xx1_m20.msky130_fd_pr__pfet_01v8_lvt[vbs]
echo OPV XX1_M20 vbs $&s1_xx1_m20_vbs
let s1_xx1_m20_vth = @m.x1.xdut.xx1_m20.msky130_fd_pr__pfet_01v8_lvt[vth]
echo OPV XX1_M20 vth $&s1_xx1_m20_vth
let s1_xx1_m20_vdsat = @m.x1.xdut.xx1_m20.msky130_fd_pr__pfet_01v8_lvt[vdsat]
echo OPV XX1_M20 vdsat $&s1_xx1_m20_vdsat
let s1_xx1_m20_gm = @m.x1.xdut.xx1_m20.msky130_fd_pr__pfet_01v8_lvt[gm]
echo OPV XX1_M20 gm $&s1_xx1_m20_gm
let s1_xx1_m20_gds = @m.x1.xdut.xx1_m20.msky130_fd_pr__pfet_01v8_lvt[gds]
echo OPV XX1_M20 gds $&s1_xx1_m20_gds
let s1_xx1_m20_gmbs = @m.x1.xdut.xx1_m20.msky130_fd_pr__pfet_01v8_lvt[gmbs]
echo OPV XX1_M20 gmbs $&s1_xx1_m20_gmbs
let s1_xx1_m20_cgg = @m.x1.xdut.xx1_m20.msky130_fd_pr__pfet_01v8_lvt[cgg]
echo OPV XX1_M20 cgg $&s1_xx1_m20_cgg
let s1_xx1_m20_cgd = @m.x1.xdut.xx1_m20.msky130_fd_pr__pfet_01v8_lvt[cgd]
echo OPV XX1_M20 cgd $&s1_xx1_m20_cgd
let s1_xx1_m20_cgs = @m.x1.xdut.xx1_m20.msky130_fd_pr__pfet_01v8_lvt[cgs]
echo OPV XX1_M20 cgs $&s1_xx1_m20_cgs
let s1_xx1_m20_cgb = @m.x1.xdut.xx1_m20.msky130_fd_pr__pfet_01v8_lvt[cgb]
echo OPV XX1_M20 cgb $&s1_xx1_m20_cgb
let s1_xx1_m20_cdg = @m.x1.xdut.xx1_m20.msky130_fd_pr__pfet_01v8_lvt[cdg]
echo OPV XX1_M20 cdg $&s1_xx1_m20_cdg
let s1_xx1_m20_cdd = @m.x1.xdut.xx1_m20.msky130_fd_pr__pfet_01v8_lvt[cdd]
echo OPV XX1_M20 cdd $&s1_xx1_m20_cdd
let s1_xx1_m20_cds = @m.x1.xdut.xx1_m20.msky130_fd_pr__pfet_01v8_lvt[cds]
echo OPV XX1_M20 cds $&s1_xx1_m20_cds
let s1_xx1_m20_cdb = @m.x1.xdut.xx1_m20.msky130_fd_pr__pfet_01v8_lvt[cdb]
echo OPV XX1_M20 cdb $&s1_xx1_m20_cdb
let s1_xx1_m20_csg = @m.x1.xdut.xx1_m20.msky130_fd_pr__pfet_01v8_lvt[csg]
echo OPV XX1_M20 csg $&s1_xx1_m20_csg
let s1_xx1_m20_csd = @m.x1.xdut.xx1_m20.msky130_fd_pr__pfet_01v8_lvt[csd]
echo OPV XX1_M20 csd $&s1_xx1_m20_csd
let s1_xx1_m20_css = @m.x1.xdut.xx1_m20.msky130_fd_pr__pfet_01v8_lvt[css]
echo OPV XX1_M20 css $&s1_xx1_m20_css
let s1_xx1_m20_csb = @m.x1.xdut.xx1_m20.msky130_fd_pr__pfet_01v8_lvt[csb]
echo OPV XX1_M20 csb $&s1_xx1_m20_csb
let s1_xx1_m20_cbg = @m.x1.xdut.xx1_m20.msky130_fd_pr__pfet_01v8_lvt[cbg]
echo OPV XX1_M20 cbg $&s1_xx1_m20_cbg
let s1_xx1_m20_cbd = @m.x1.xdut.xx1_m20.msky130_fd_pr__pfet_01v8_lvt[cbd]
echo OPV XX1_M20 cbd $&s1_xx1_m20_cbd
let s1_xx1_m20_cbs = @m.x1.xdut.xx1_m20.msky130_fd_pr__pfet_01v8_lvt[cbs]
echo OPV XX1_M20 cbs $&s1_xx1_m20_cbs
let s1_xx1_m20_cbb = @m.x1.xdut.xx1_m20.msky130_fd_pr__pfet_01v8_lvt[cbb]
echo OPV XX1_M20 cbb $&s1_xx1_m20_cbb
let s1_xx1_m20_capbd = @m.x1.xdut.xx1_m20.msky130_fd_pr__pfet_01v8_lvt[capbd]
echo OPV XX1_M20 capbd $&s1_xx1_m20_capbd
let s1_xx1_m20_capbs = @m.x1.xdut.xx1_m20.msky130_fd_pr__pfet_01v8_lvt[capbs]
echo OPV XX1_M20 capbs $&s1_xx1_m20_capbs
let s1_xx1_m20_cgso = @m.x1.xdut.xx1_m20.msky130_fd_pr__pfet_01v8_lvt[cgso]
echo OPV XX1_M20 cgso $&s1_xx1_m20_cgso
let s1_xx1_m20_cgdo = @m.x1.xdut.xx1_m20.msky130_fd_pr__pfet_01v8_lvt[cgdo]
echo OPV XX1_M20 cgdo $&s1_xx1_m20_cgdo
let s1_xx1_m20_cgbo = @m.x1.xdut.xx1_m20.msky130_fd_pr__pfet_01v8_lvt[cgbo]
echo OPV XX1_M20 cgbo $&s1_xx1_m20_cgbo
let s1_xx1_m20_weff = @m.x1.xdut.xx1_m20.msky130_fd_pr__pfet_01v8_lvt[weff]
echo OPV XX1_M20 weff $&s1_xx1_m20_weff
let s1_xx1_m20_leff = @m.x1.xdut.xx1_m20.msky130_fd_pr__pfet_01v8_lvt[leff]
echo OPV XX1_M20 leff $&s1_xx1_m20_leff
let s1_xx1_m21_id = @m.x1.xdut.xx1_m21.msky130_fd_pr__pfet_01v8_lvt[id]
echo OPV XX1_M21 id $&s1_xx1_m21_id
let s1_xx1_m21_vgs = @m.x1.xdut.xx1_m21.msky130_fd_pr__pfet_01v8_lvt[vgs]
echo OPV XX1_M21 vgs $&s1_xx1_m21_vgs
let s1_xx1_m21_vds = @m.x1.xdut.xx1_m21.msky130_fd_pr__pfet_01v8_lvt[vds]
echo OPV XX1_M21 vds $&s1_xx1_m21_vds
let s1_xx1_m21_vbs = @m.x1.xdut.xx1_m21.msky130_fd_pr__pfet_01v8_lvt[vbs]
echo OPV XX1_M21 vbs $&s1_xx1_m21_vbs
let s1_xx1_m21_vth = @m.x1.xdut.xx1_m21.msky130_fd_pr__pfet_01v8_lvt[vth]
echo OPV XX1_M21 vth $&s1_xx1_m21_vth
let s1_xx1_m21_vdsat = @m.x1.xdut.xx1_m21.msky130_fd_pr__pfet_01v8_lvt[vdsat]
echo OPV XX1_M21 vdsat $&s1_xx1_m21_vdsat
let s1_xx1_m21_gm = @m.x1.xdut.xx1_m21.msky130_fd_pr__pfet_01v8_lvt[gm]
echo OPV XX1_M21 gm $&s1_xx1_m21_gm
let s1_xx1_m21_gds = @m.x1.xdut.xx1_m21.msky130_fd_pr__pfet_01v8_lvt[gds]
echo OPV XX1_M21 gds $&s1_xx1_m21_gds
let s1_xx1_m21_gmbs = @m.x1.xdut.xx1_m21.msky130_fd_pr__pfet_01v8_lvt[gmbs]
echo OPV XX1_M21 gmbs $&s1_xx1_m21_gmbs
let s1_xx1_m21_cgg = @m.x1.xdut.xx1_m21.msky130_fd_pr__pfet_01v8_lvt[cgg]
echo OPV XX1_M21 cgg $&s1_xx1_m21_cgg
let s1_xx1_m21_cgd = @m.x1.xdut.xx1_m21.msky130_fd_pr__pfet_01v8_lvt[cgd]
echo OPV XX1_M21 cgd $&s1_xx1_m21_cgd
let s1_xx1_m21_cgs = @m.x1.xdut.xx1_m21.msky130_fd_pr__pfet_01v8_lvt[cgs]
echo OPV XX1_M21 cgs $&s1_xx1_m21_cgs
let s1_xx1_m21_cgb = @m.x1.xdut.xx1_m21.msky130_fd_pr__pfet_01v8_lvt[cgb]
echo OPV XX1_M21 cgb $&s1_xx1_m21_cgb
let s1_xx1_m21_cdg = @m.x1.xdut.xx1_m21.msky130_fd_pr__pfet_01v8_lvt[cdg]
echo OPV XX1_M21 cdg $&s1_xx1_m21_cdg
let s1_xx1_m21_cdd = @m.x1.xdut.xx1_m21.msky130_fd_pr__pfet_01v8_lvt[cdd]
echo OPV XX1_M21 cdd $&s1_xx1_m21_cdd
let s1_xx1_m21_cds = @m.x1.xdut.xx1_m21.msky130_fd_pr__pfet_01v8_lvt[cds]
echo OPV XX1_M21 cds $&s1_xx1_m21_cds
let s1_xx1_m21_cdb = @m.x1.xdut.xx1_m21.msky130_fd_pr__pfet_01v8_lvt[cdb]
echo OPV XX1_M21 cdb $&s1_xx1_m21_cdb
let s1_xx1_m21_csg = @m.x1.xdut.xx1_m21.msky130_fd_pr__pfet_01v8_lvt[csg]
echo OPV XX1_M21 csg $&s1_xx1_m21_csg
let s1_xx1_m21_csd = @m.x1.xdut.xx1_m21.msky130_fd_pr__pfet_01v8_lvt[csd]
echo OPV XX1_M21 csd $&s1_xx1_m21_csd
let s1_xx1_m21_css = @m.x1.xdut.xx1_m21.msky130_fd_pr__pfet_01v8_lvt[css]
echo OPV XX1_M21 css $&s1_xx1_m21_css
let s1_xx1_m21_csb = @m.x1.xdut.xx1_m21.msky130_fd_pr__pfet_01v8_lvt[csb]
echo OPV XX1_M21 csb $&s1_xx1_m21_csb
let s1_xx1_m21_cbg = @m.x1.xdut.xx1_m21.msky130_fd_pr__pfet_01v8_lvt[cbg]
echo OPV XX1_M21 cbg $&s1_xx1_m21_cbg
let s1_xx1_m21_cbd = @m.x1.xdut.xx1_m21.msky130_fd_pr__pfet_01v8_lvt[cbd]
echo OPV XX1_M21 cbd $&s1_xx1_m21_cbd
let s1_xx1_m21_cbs = @m.x1.xdut.xx1_m21.msky130_fd_pr__pfet_01v8_lvt[cbs]
echo OPV XX1_M21 cbs $&s1_xx1_m21_cbs
let s1_xx1_m21_cbb = @m.x1.xdut.xx1_m21.msky130_fd_pr__pfet_01v8_lvt[cbb]
echo OPV XX1_M21 cbb $&s1_xx1_m21_cbb
let s1_xx1_m21_capbd = @m.x1.xdut.xx1_m21.msky130_fd_pr__pfet_01v8_lvt[capbd]
echo OPV XX1_M21 capbd $&s1_xx1_m21_capbd
let s1_xx1_m21_capbs = @m.x1.xdut.xx1_m21.msky130_fd_pr__pfet_01v8_lvt[capbs]
echo OPV XX1_M21 capbs $&s1_xx1_m21_capbs
let s1_xx1_m21_cgso = @m.x1.xdut.xx1_m21.msky130_fd_pr__pfet_01v8_lvt[cgso]
echo OPV XX1_M21 cgso $&s1_xx1_m21_cgso
let s1_xx1_m21_cgdo = @m.x1.xdut.xx1_m21.msky130_fd_pr__pfet_01v8_lvt[cgdo]
echo OPV XX1_M21 cgdo $&s1_xx1_m21_cgdo
let s1_xx1_m21_cgbo = @m.x1.xdut.xx1_m21.msky130_fd_pr__pfet_01v8_lvt[cgbo]
echo OPV XX1_M21 cgbo $&s1_xx1_m21_cgbo
let s1_xx1_m21_weff = @m.x1.xdut.xx1_m21.msky130_fd_pr__pfet_01v8_lvt[weff]
echo OPV XX1_M21 weff $&s1_xx1_m21_weff
let s1_xx1_m21_leff = @m.x1.xdut.xx1_m21.msky130_fd_pr__pfet_01v8_lvt[leff]
echo OPV XX1_M21 leff $&s1_xx1_m21_leff
let s1_xx1_m15_id = @m.x1.xdut.xx1_m15.msky130_fd_pr__nfet_01v8_lvt[id]
echo OPV XX1_M15 id $&s1_xx1_m15_id
let s1_xx1_m15_vgs = @m.x1.xdut.xx1_m15.msky130_fd_pr__nfet_01v8_lvt[vgs]
echo OPV XX1_M15 vgs $&s1_xx1_m15_vgs
let s1_xx1_m15_vds = @m.x1.xdut.xx1_m15.msky130_fd_pr__nfet_01v8_lvt[vds]
echo OPV XX1_M15 vds $&s1_xx1_m15_vds
let s1_xx1_m15_vbs = @m.x1.xdut.xx1_m15.msky130_fd_pr__nfet_01v8_lvt[vbs]
echo OPV XX1_M15 vbs $&s1_xx1_m15_vbs
let s1_xx1_m15_vth = @m.x1.xdut.xx1_m15.msky130_fd_pr__nfet_01v8_lvt[vth]
echo OPV XX1_M15 vth $&s1_xx1_m15_vth
let s1_xx1_m15_vdsat = @m.x1.xdut.xx1_m15.msky130_fd_pr__nfet_01v8_lvt[vdsat]
echo OPV XX1_M15 vdsat $&s1_xx1_m15_vdsat
let s1_xx1_m15_gm = @m.x1.xdut.xx1_m15.msky130_fd_pr__nfet_01v8_lvt[gm]
echo OPV XX1_M15 gm $&s1_xx1_m15_gm
let s1_xx1_m15_gds = @m.x1.xdut.xx1_m15.msky130_fd_pr__nfet_01v8_lvt[gds]
echo OPV XX1_M15 gds $&s1_xx1_m15_gds
let s1_xx1_m15_gmbs = @m.x1.xdut.xx1_m15.msky130_fd_pr__nfet_01v8_lvt[gmbs]
echo OPV XX1_M15 gmbs $&s1_xx1_m15_gmbs
let s1_xx1_m15_cgg = @m.x1.xdut.xx1_m15.msky130_fd_pr__nfet_01v8_lvt[cgg]
echo OPV XX1_M15 cgg $&s1_xx1_m15_cgg
let s1_xx1_m15_cgd = @m.x1.xdut.xx1_m15.msky130_fd_pr__nfet_01v8_lvt[cgd]
echo OPV XX1_M15 cgd $&s1_xx1_m15_cgd
let s1_xx1_m15_cgs = @m.x1.xdut.xx1_m15.msky130_fd_pr__nfet_01v8_lvt[cgs]
echo OPV XX1_M15 cgs $&s1_xx1_m15_cgs
let s1_xx1_m15_cgb = @m.x1.xdut.xx1_m15.msky130_fd_pr__nfet_01v8_lvt[cgb]
echo OPV XX1_M15 cgb $&s1_xx1_m15_cgb
let s1_xx1_m15_cdg = @m.x1.xdut.xx1_m15.msky130_fd_pr__nfet_01v8_lvt[cdg]
echo OPV XX1_M15 cdg $&s1_xx1_m15_cdg
let s1_xx1_m15_cdd = @m.x1.xdut.xx1_m15.msky130_fd_pr__nfet_01v8_lvt[cdd]
echo OPV XX1_M15 cdd $&s1_xx1_m15_cdd
let s1_xx1_m15_cds = @m.x1.xdut.xx1_m15.msky130_fd_pr__nfet_01v8_lvt[cds]
echo OPV XX1_M15 cds $&s1_xx1_m15_cds
let s1_xx1_m15_cdb = @m.x1.xdut.xx1_m15.msky130_fd_pr__nfet_01v8_lvt[cdb]
echo OPV XX1_M15 cdb $&s1_xx1_m15_cdb
let s1_xx1_m15_csg = @m.x1.xdut.xx1_m15.msky130_fd_pr__nfet_01v8_lvt[csg]
echo OPV XX1_M15 csg $&s1_xx1_m15_csg
let s1_xx1_m15_csd = @m.x1.xdut.xx1_m15.msky130_fd_pr__nfet_01v8_lvt[csd]
echo OPV XX1_M15 csd $&s1_xx1_m15_csd
let s1_xx1_m15_css = @m.x1.xdut.xx1_m15.msky130_fd_pr__nfet_01v8_lvt[css]
echo OPV XX1_M15 css $&s1_xx1_m15_css
let s1_xx1_m15_csb = @m.x1.xdut.xx1_m15.msky130_fd_pr__nfet_01v8_lvt[csb]
echo OPV XX1_M15 csb $&s1_xx1_m15_csb
let s1_xx1_m15_cbg = @m.x1.xdut.xx1_m15.msky130_fd_pr__nfet_01v8_lvt[cbg]
echo OPV XX1_M15 cbg $&s1_xx1_m15_cbg
let s1_xx1_m15_cbd = @m.x1.xdut.xx1_m15.msky130_fd_pr__nfet_01v8_lvt[cbd]
echo OPV XX1_M15 cbd $&s1_xx1_m15_cbd
let s1_xx1_m15_cbs = @m.x1.xdut.xx1_m15.msky130_fd_pr__nfet_01v8_lvt[cbs]
echo OPV XX1_M15 cbs $&s1_xx1_m15_cbs
let s1_xx1_m15_cbb = @m.x1.xdut.xx1_m15.msky130_fd_pr__nfet_01v8_lvt[cbb]
echo OPV XX1_M15 cbb $&s1_xx1_m15_cbb
let s1_xx1_m15_capbd = @m.x1.xdut.xx1_m15.msky130_fd_pr__nfet_01v8_lvt[capbd]
echo OPV XX1_M15 capbd $&s1_xx1_m15_capbd
let s1_xx1_m15_capbs = @m.x1.xdut.xx1_m15.msky130_fd_pr__nfet_01v8_lvt[capbs]
echo OPV XX1_M15 capbs $&s1_xx1_m15_capbs
let s1_xx1_m15_cgso = @m.x1.xdut.xx1_m15.msky130_fd_pr__nfet_01v8_lvt[cgso]
echo OPV XX1_M15 cgso $&s1_xx1_m15_cgso
let s1_xx1_m15_cgdo = @m.x1.xdut.xx1_m15.msky130_fd_pr__nfet_01v8_lvt[cgdo]
echo OPV XX1_M15 cgdo $&s1_xx1_m15_cgdo
let s1_xx1_m15_cgbo = @m.x1.xdut.xx1_m15.msky130_fd_pr__nfet_01v8_lvt[cgbo]
echo OPV XX1_M15 cgbo $&s1_xx1_m15_cgbo
let s1_xx1_m15_weff = @m.x1.xdut.xx1_m15.msky130_fd_pr__nfet_01v8_lvt[weff]
echo OPV XX1_M15 weff $&s1_xx1_m15_weff
let s1_xx1_m15_leff = @m.x1.xdut.xx1_m15.msky130_fd_pr__nfet_01v8_lvt[leff]
echo OPV XX1_M15 leff $&s1_xx1_m15_leff
let s1_xx1_m16_id = @m.x1.xdut.xx1_m16.msky130_fd_pr__nfet_01v8_lvt[id]
echo OPV XX1_M16 id $&s1_xx1_m16_id
let s1_xx1_m16_vgs = @m.x1.xdut.xx1_m16.msky130_fd_pr__nfet_01v8_lvt[vgs]
echo OPV XX1_M16 vgs $&s1_xx1_m16_vgs
let s1_xx1_m16_vds = @m.x1.xdut.xx1_m16.msky130_fd_pr__nfet_01v8_lvt[vds]
echo OPV XX1_M16 vds $&s1_xx1_m16_vds
let s1_xx1_m16_vbs = @m.x1.xdut.xx1_m16.msky130_fd_pr__nfet_01v8_lvt[vbs]
echo OPV XX1_M16 vbs $&s1_xx1_m16_vbs
let s1_xx1_m16_vth = @m.x1.xdut.xx1_m16.msky130_fd_pr__nfet_01v8_lvt[vth]
echo OPV XX1_M16 vth $&s1_xx1_m16_vth
let s1_xx1_m16_vdsat = @m.x1.xdut.xx1_m16.msky130_fd_pr__nfet_01v8_lvt[vdsat]
echo OPV XX1_M16 vdsat $&s1_xx1_m16_vdsat
let s1_xx1_m16_gm = @m.x1.xdut.xx1_m16.msky130_fd_pr__nfet_01v8_lvt[gm]
echo OPV XX1_M16 gm $&s1_xx1_m16_gm
let s1_xx1_m16_gds = @m.x1.xdut.xx1_m16.msky130_fd_pr__nfet_01v8_lvt[gds]
echo OPV XX1_M16 gds $&s1_xx1_m16_gds
let s1_xx1_m16_gmbs = @m.x1.xdut.xx1_m16.msky130_fd_pr__nfet_01v8_lvt[gmbs]
echo OPV XX1_M16 gmbs $&s1_xx1_m16_gmbs
let s1_xx1_m16_cgg = @m.x1.xdut.xx1_m16.msky130_fd_pr__nfet_01v8_lvt[cgg]
echo OPV XX1_M16 cgg $&s1_xx1_m16_cgg
let s1_xx1_m16_cgd = @m.x1.xdut.xx1_m16.msky130_fd_pr__nfet_01v8_lvt[cgd]
echo OPV XX1_M16 cgd $&s1_xx1_m16_cgd
let s1_xx1_m16_cgs = @m.x1.xdut.xx1_m16.msky130_fd_pr__nfet_01v8_lvt[cgs]
echo OPV XX1_M16 cgs $&s1_xx1_m16_cgs
let s1_xx1_m16_cgb = @m.x1.xdut.xx1_m16.msky130_fd_pr__nfet_01v8_lvt[cgb]
echo OPV XX1_M16 cgb $&s1_xx1_m16_cgb
let s1_xx1_m16_cdg = @m.x1.xdut.xx1_m16.msky130_fd_pr__nfet_01v8_lvt[cdg]
echo OPV XX1_M16 cdg $&s1_xx1_m16_cdg
let s1_xx1_m16_cdd = @m.x1.xdut.xx1_m16.msky130_fd_pr__nfet_01v8_lvt[cdd]
echo OPV XX1_M16 cdd $&s1_xx1_m16_cdd
let s1_xx1_m16_cds = @m.x1.xdut.xx1_m16.msky130_fd_pr__nfet_01v8_lvt[cds]
echo OPV XX1_M16 cds $&s1_xx1_m16_cds
let s1_xx1_m16_cdb = @m.x1.xdut.xx1_m16.msky130_fd_pr__nfet_01v8_lvt[cdb]
echo OPV XX1_M16 cdb $&s1_xx1_m16_cdb
let s1_xx1_m16_csg = @m.x1.xdut.xx1_m16.msky130_fd_pr__nfet_01v8_lvt[csg]
echo OPV XX1_M16 csg $&s1_xx1_m16_csg
let s1_xx1_m16_csd = @m.x1.xdut.xx1_m16.msky130_fd_pr__nfet_01v8_lvt[csd]
echo OPV XX1_M16 csd $&s1_xx1_m16_csd
let s1_xx1_m16_css = @m.x1.xdut.xx1_m16.msky130_fd_pr__nfet_01v8_lvt[css]
echo OPV XX1_M16 css $&s1_xx1_m16_css
let s1_xx1_m16_csb = @m.x1.xdut.xx1_m16.msky130_fd_pr__nfet_01v8_lvt[csb]
echo OPV XX1_M16 csb $&s1_xx1_m16_csb
let s1_xx1_m16_cbg = @m.x1.xdut.xx1_m16.msky130_fd_pr__nfet_01v8_lvt[cbg]
echo OPV XX1_M16 cbg $&s1_xx1_m16_cbg
let s1_xx1_m16_cbd = @m.x1.xdut.xx1_m16.msky130_fd_pr__nfet_01v8_lvt[cbd]
echo OPV XX1_M16 cbd $&s1_xx1_m16_cbd
let s1_xx1_m16_cbs = @m.x1.xdut.xx1_m16.msky130_fd_pr__nfet_01v8_lvt[cbs]
echo OPV XX1_M16 cbs $&s1_xx1_m16_cbs
let s1_xx1_m16_cbb = @m.x1.xdut.xx1_m16.msky130_fd_pr__nfet_01v8_lvt[cbb]
echo OPV XX1_M16 cbb $&s1_xx1_m16_cbb
let s1_xx1_m16_capbd = @m.x1.xdut.xx1_m16.msky130_fd_pr__nfet_01v8_lvt[capbd]
echo OPV XX1_M16 capbd $&s1_xx1_m16_capbd
let s1_xx1_m16_capbs = @m.x1.xdut.xx1_m16.msky130_fd_pr__nfet_01v8_lvt[capbs]
echo OPV XX1_M16 capbs $&s1_xx1_m16_capbs
let s1_xx1_m16_cgso = @m.x1.xdut.xx1_m16.msky130_fd_pr__nfet_01v8_lvt[cgso]
echo OPV XX1_M16 cgso $&s1_xx1_m16_cgso
let s1_xx1_m16_cgdo = @m.x1.xdut.xx1_m16.msky130_fd_pr__nfet_01v8_lvt[cgdo]
echo OPV XX1_M16 cgdo $&s1_xx1_m16_cgdo
let s1_xx1_m16_cgbo = @m.x1.xdut.xx1_m16.msky130_fd_pr__nfet_01v8_lvt[cgbo]
echo OPV XX1_M16 cgbo $&s1_xx1_m16_cgbo
let s1_xx1_m16_weff = @m.x1.xdut.xx1_m16.msky130_fd_pr__nfet_01v8_lvt[weff]
echo OPV XX1_M16 weff $&s1_xx1_m16_weff
let s1_xx1_m16_leff = @m.x1.xdut.xx1_m16.msky130_fd_pr__nfet_01v8_lvt[leff]
echo OPV XX1_M16 leff $&s1_xx1_m16_leff
let s1_xx1_m46_id = @m.x1.xdut.xx1_m46.msky130_fd_pr__nfet_01v8_lvt[id]
echo OPV XX1_M46 id $&s1_xx1_m46_id
let s1_xx1_m46_vgs = @m.x1.xdut.xx1_m46.msky130_fd_pr__nfet_01v8_lvt[vgs]
echo OPV XX1_M46 vgs $&s1_xx1_m46_vgs
let s1_xx1_m46_vds = @m.x1.xdut.xx1_m46.msky130_fd_pr__nfet_01v8_lvt[vds]
echo OPV XX1_M46 vds $&s1_xx1_m46_vds
let s1_xx1_m46_vbs = @m.x1.xdut.xx1_m46.msky130_fd_pr__nfet_01v8_lvt[vbs]
echo OPV XX1_M46 vbs $&s1_xx1_m46_vbs
let s1_xx1_m46_vth = @m.x1.xdut.xx1_m46.msky130_fd_pr__nfet_01v8_lvt[vth]
echo OPV XX1_M46 vth $&s1_xx1_m46_vth
let s1_xx1_m46_vdsat = @m.x1.xdut.xx1_m46.msky130_fd_pr__nfet_01v8_lvt[vdsat]
echo OPV XX1_M46 vdsat $&s1_xx1_m46_vdsat
let s1_xx1_m46_gm = @m.x1.xdut.xx1_m46.msky130_fd_pr__nfet_01v8_lvt[gm]
echo OPV XX1_M46 gm $&s1_xx1_m46_gm
let s1_xx1_m46_gds = @m.x1.xdut.xx1_m46.msky130_fd_pr__nfet_01v8_lvt[gds]
echo OPV XX1_M46 gds $&s1_xx1_m46_gds
let s1_xx1_m46_gmbs = @m.x1.xdut.xx1_m46.msky130_fd_pr__nfet_01v8_lvt[gmbs]
echo OPV XX1_M46 gmbs $&s1_xx1_m46_gmbs
let s1_xx1_m46_cgg = @m.x1.xdut.xx1_m46.msky130_fd_pr__nfet_01v8_lvt[cgg]
echo OPV XX1_M46 cgg $&s1_xx1_m46_cgg
let s1_xx1_m46_cgd = @m.x1.xdut.xx1_m46.msky130_fd_pr__nfet_01v8_lvt[cgd]
echo OPV XX1_M46 cgd $&s1_xx1_m46_cgd
let s1_xx1_m46_cgs = @m.x1.xdut.xx1_m46.msky130_fd_pr__nfet_01v8_lvt[cgs]
echo OPV XX1_M46 cgs $&s1_xx1_m46_cgs
let s1_xx1_m46_cgb = @m.x1.xdut.xx1_m46.msky130_fd_pr__nfet_01v8_lvt[cgb]
echo OPV XX1_M46 cgb $&s1_xx1_m46_cgb
let s1_xx1_m46_cdg = @m.x1.xdut.xx1_m46.msky130_fd_pr__nfet_01v8_lvt[cdg]
echo OPV XX1_M46 cdg $&s1_xx1_m46_cdg
let s1_xx1_m46_cdd = @m.x1.xdut.xx1_m46.msky130_fd_pr__nfet_01v8_lvt[cdd]
echo OPV XX1_M46 cdd $&s1_xx1_m46_cdd
let s1_xx1_m46_cds = @m.x1.xdut.xx1_m46.msky130_fd_pr__nfet_01v8_lvt[cds]
echo OPV XX1_M46 cds $&s1_xx1_m46_cds
let s1_xx1_m46_cdb = @m.x1.xdut.xx1_m46.msky130_fd_pr__nfet_01v8_lvt[cdb]
echo OPV XX1_M46 cdb $&s1_xx1_m46_cdb
let s1_xx1_m46_csg = @m.x1.xdut.xx1_m46.msky130_fd_pr__nfet_01v8_lvt[csg]
echo OPV XX1_M46 csg $&s1_xx1_m46_csg
let s1_xx1_m46_csd = @m.x1.xdut.xx1_m46.msky130_fd_pr__nfet_01v8_lvt[csd]
echo OPV XX1_M46 csd $&s1_xx1_m46_csd
let s1_xx1_m46_css = @m.x1.xdut.xx1_m46.msky130_fd_pr__nfet_01v8_lvt[css]
echo OPV XX1_M46 css $&s1_xx1_m46_css
let s1_xx1_m46_csb = @m.x1.xdut.xx1_m46.msky130_fd_pr__nfet_01v8_lvt[csb]
echo OPV XX1_M46 csb $&s1_xx1_m46_csb
let s1_xx1_m46_cbg = @m.x1.xdut.xx1_m46.msky130_fd_pr__nfet_01v8_lvt[cbg]
echo OPV XX1_M46 cbg $&s1_xx1_m46_cbg
let s1_xx1_m46_cbd = @m.x1.xdut.xx1_m46.msky130_fd_pr__nfet_01v8_lvt[cbd]
echo OPV XX1_M46 cbd $&s1_xx1_m46_cbd
let s1_xx1_m46_cbs = @m.x1.xdut.xx1_m46.msky130_fd_pr__nfet_01v8_lvt[cbs]
echo OPV XX1_M46 cbs $&s1_xx1_m46_cbs
let s1_xx1_m46_cbb = @m.x1.xdut.xx1_m46.msky130_fd_pr__nfet_01v8_lvt[cbb]
echo OPV XX1_M46 cbb $&s1_xx1_m46_cbb
let s1_xx1_m46_capbd = @m.x1.xdut.xx1_m46.msky130_fd_pr__nfet_01v8_lvt[capbd]
echo OPV XX1_M46 capbd $&s1_xx1_m46_capbd
let s1_xx1_m46_capbs = @m.x1.xdut.xx1_m46.msky130_fd_pr__nfet_01v8_lvt[capbs]
echo OPV XX1_M46 capbs $&s1_xx1_m46_capbs
let s1_xx1_m46_cgso = @m.x1.xdut.xx1_m46.msky130_fd_pr__nfet_01v8_lvt[cgso]
echo OPV XX1_M46 cgso $&s1_xx1_m46_cgso
let s1_xx1_m46_cgdo = @m.x1.xdut.xx1_m46.msky130_fd_pr__nfet_01v8_lvt[cgdo]
echo OPV XX1_M46 cgdo $&s1_xx1_m46_cgdo
let s1_xx1_m46_cgbo = @m.x1.xdut.xx1_m46.msky130_fd_pr__nfet_01v8_lvt[cgbo]
echo OPV XX1_M46 cgbo $&s1_xx1_m46_cgbo
let s1_xx1_m46_weff = @m.x1.xdut.xx1_m46.msky130_fd_pr__nfet_01v8_lvt[weff]
echo OPV XX1_M46 weff $&s1_xx1_m46_weff
let s1_xx1_m46_leff = @m.x1.xdut.xx1_m46.msky130_fd_pr__nfet_01v8_lvt[leff]
echo OPV XX1_M46 leff $&s1_xx1_m46_leff
let s1_xx1_m47_id = @m.x1.xdut.xx1_m47.msky130_fd_pr__nfet_01v8_lvt[id]
echo OPV XX1_M47 id $&s1_xx1_m47_id
let s1_xx1_m47_vgs = @m.x1.xdut.xx1_m47.msky130_fd_pr__nfet_01v8_lvt[vgs]
echo OPV XX1_M47 vgs $&s1_xx1_m47_vgs
let s1_xx1_m47_vds = @m.x1.xdut.xx1_m47.msky130_fd_pr__nfet_01v8_lvt[vds]
echo OPV XX1_M47 vds $&s1_xx1_m47_vds
let s1_xx1_m47_vbs = @m.x1.xdut.xx1_m47.msky130_fd_pr__nfet_01v8_lvt[vbs]
echo OPV XX1_M47 vbs $&s1_xx1_m47_vbs
let s1_xx1_m47_vth = @m.x1.xdut.xx1_m47.msky130_fd_pr__nfet_01v8_lvt[vth]
echo OPV XX1_M47 vth $&s1_xx1_m47_vth
let s1_xx1_m47_vdsat = @m.x1.xdut.xx1_m47.msky130_fd_pr__nfet_01v8_lvt[vdsat]
echo OPV XX1_M47 vdsat $&s1_xx1_m47_vdsat
let s1_xx1_m47_gm = @m.x1.xdut.xx1_m47.msky130_fd_pr__nfet_01v8_lvt[gm]
echo OPV XX1_M47 gm $&s1_xx1_m47_gm
let s1_xx1_m47_gds = @m.x1.xdut.xx1_m47.msky130_fd_pr__nfet_01v8_lvt[gds]
echo OPV XX1_M47 gds $&s1_xx1_m47_gds
let s1_xx1_m47_gmbs = @m.x1.xdut.xx1_m47.msky130_fd_pr__nfet_01v8_lvt[gmbs]
echo OPV XX1_M47 gmbs $&s1_xx1_m47_gmbs
let s1_xx1_m47_cgg = @m.x1.xdut.xx1_m47.msky130_fd_pr__nfet_01v8_lvt[cgg]
echo OPV XX1_M47 cgg $&s1_xx1_m47_cgg
let s1_xx1_m47_cgd = @m.x1.xdut.xx1_m47.msky130_fd_pr__nfet_01v8_lvt[cgd]
echo OPV XX1_M47 cgd $&s1_xx1_m47_cgd
let s1_xx1_m47_cgs = @m.x1.xdut.xx1_m47.msky130_fd_pr__nfet_01v8_lvt[cgs]
echo OPV XX1_M47 cgs $&s1_xx1_m47_cgs
let s1_xx1_m47_cgb = @m.x1.xdut.xx1_m47.msky130_fd_pr__nfet_01v8_lvt[cgb]
echo OPV XX1_M47 cgb $&s1_xx1_m47_cgb
let s1_xx1_m47_cdg = @m.x1.xdut.xx1_m47.msky130_fd_pr__nfet_01v8_lvt[cdg]
echo OPV XX1_M47 cdg $&s1_xx1_m47_cdg
let s1_xx1_m47_cdd = @m.x1.xdut.xx1_m47.msky130_fd_pr__nfet_01v8_lvt[cdd]
echo OPV XX1_M47 cdd $&s1_xx1_m47_cdd
let s1_xx1_m47_cds = @m.x1.xdut.xx1_m47.msky130_fd_pr__nfet_01v8_lvt[cds]
echo OPV XX1_M47 cds $&s1_xx1_m47_cds
let s1_xx1_m47_cdb = @m.x1.xdut.xx1_m47.msky130_fd_pr__nfet_01v8_lvt[cdb]
echo OPV XX1_M47 cdb $&s1_xx1_m47_cdb
let s1_xx1_m47_csg = @m.x1.xdut.xx1_m47.msky130_fd_pr__nfet_01v8_lvt[csg]
echo OPV XX1_M47 csg $&s1_xx1_m47_csg
let s1_xx1_m47_csd = @m.x1.xdut.xx1_m47.msky130_fd_pr__nfet_01v8_lvt[csd]
echo OPV XX1_M47 csd $&s1_xx1_m47_csd
let s1_xx1_m47_css = @m.x1.xdut.xx1_m47.msky130_fd_pr__nfet_01v8_lvt[css]
echo OPV XX1_M47 css $&s1_xx1_m47_css
let s1_xx1_m47_csb = @m.x1.xdut.xx1_m47.msky130_fd_pr__nfet_01v8_lvt[csb]
echo OPV XX1_M47 csb $&s1_xx1_m47_csb
let s1_xx1_m47_cbg = @m.x1.xdut.xx1_m47.msky130_fd_pr__nfet_01v8_lvt[cbg]
echo OPV XX1_M47 cbg $&s1_xx1_m47_cbg
let s1_xx1_m47_cbd = @m.x1.xdut.xx1_m47.msky130_fd_pr__nfet_01v8_lvt[cbd]
echo OPV XX1_M47 cbd $&s1_xx1_m47_cbd
let s1_xx1_m47_cbs = @m.x1.xdut.xx1_m47.msky130_fd_pr__nfet_01v8_lvt[cbs]
echo OPV XX1_M47 cbs $&s1_xx1_m47_cbs
let s1_xx1_m47_cbb = @m.x1.xdut.xx1_m47.msky130_fd_pr__nfet_01v8_lvt[cbb]
echo OPV XX1_M47 cbb $&s1_xx1_m47_cbb
let s1_xx1_m47_capbd = @m.x1.xdut.xx1_m47.msky130_fd_pr__nfet_01v8_lvt[capbd]
echo OPV XX1_M47 capbd $&s1_xx1_m47_capbd
let s1_xx1_m47_capbs = @m.x1.xdut.xx1_m47.msky130_fd_pr__nfet_01v8_lvt[capbs]
echo OPV XX1_M47 capbs $&s1_xx1_m47_capbs
let s1_xx1_m47_cgso = @m.x1.xdut.xx1_m47.msky130_fd_pr__nfet_01v8_lvt[cgso]
echo OPV XX1_M47 cgso $&s1_xx1_m47_cgso
let s1_xx1_m47_cgdo = @m.x1.xdut.xx1_m47.msky130_fd_pr__nfet_01v8_lvt[cgdo]
echo OPV XX1_M47 cgdo $&s1_xx1_m47_cgdo
let s1_xx1_m47_cgbo = @m.x1.xdut.xx1_m47.msky130_fd_pr__nfet_01v8_lvt[cgbo]
echo OPV XX1_M47 cgbo $&s1_xx1_m47_cgbo
let s1_xx1_m47_weff = @m.x1.xdut.xx1_m47.msky130_fd_pr__nfet_01v8_lvt[weff]
echo OPV XX1_M47 weff $&s1_xx1_m47_weff
let s1_xx1_m47_leff = @m.x1.xdut.xx1_m47.msky130_fd_pr__nfet_01v8_lvt[leff]
echo OPV XX1_M47 leff $&s1_xx1_m47_leff
let s1_xx1_m23_id = @m.x1.xdut.xx1_m23.msky130_fd_pr__nfet_01v8_lvt[id]
echo OPV XX1_M23 id $&s1_xx1_m23_id
let s1_xx1_m23_vgs = @m.x1.xdut.xx1_m23.msky130_fd_pr__nfet_01v8_lvt[vgs]
echo OPV XX1_M23 vgs $&s1_xx1_m23_vgs
let s1_xx1_m23_vds = @m.x1.xdut.xx1_m23.msky130_fd_pr__nfet_01v8_lvt[vds]
echo OPV XX1_M23 vds $&s1_xx1_m23_vds
let s1_xx1_m23_vbs = @m.x1.xdut.xx1_m23.msky130_fd_pr__nfet_01v8_lvt[vbs]
echo OPV XX1_M23 vbs $&s1_xx1_m23_vbs
let s1_xx1_m23_vth = @m.x1.xdut.xx1_m23.msky130_fd_pr__nfet_01v8_lvt[vth]
echo OPV XX1_M23 vth $&s1_xx1_m23_vth
let s1_xx1_m23_vdsat = @m.x1.xdut.xx1_m23.msky130_fd_pr__nfet_01v8_lvt[vdsat]
echo OPV XX1_M23 vdsat $&s1_xx1_m23_vdsat
let s1_xx1_m23_gm = @m.x1.xdut.xx1_m23.msky130_fd_pr__nfet_01v8_lvt[gm]
echo OPV XX1_M23 gm $&s1_xx1_m23_gm
let s1_xx1_m23_gds = @m.x1.xdut.xx1_m23.msky130_fd_pr__nfet_01v8_lvt[gds]
echo OPV XX1_M23 gds $&s1_xx1_m23_gds
let s1_xx1_m23_gmbs = @m.x1.xdut.xx1_m23.msky130_fd_pr__nfet_01v8_lvt[gmbs]
echo OPV XX1_M23 gmbs $&s1_xx1_m23_gmbs
let s1_xx1_m23_cgg = @m.x1.xdut.xx1_m23.msky130_fd_pr__nfet_01v8_lvt[cgg]
echo OPV XX1_M23 cgg $&s1_xx1_m23_cgg
let s1_xx1_m23_cgd = @m.x1.xdut.xx1_m23.msky130_fd_pr__nfet_01v8_lvt[cgd]
echo OPV XX1_M23 cgd $&s1_xx1_m23_cgd
let s1_xx1_m23_cgs = @m.x1.xdut.xx1_m23.msky130_fd_pr__nfet_01v8_lvt[cgs]
echo OPV XX1_M23 cgs $&s1_xx1_m23_cgs
let s1_xx1_m23_cgb = @m.x1.xdut.xx1_m23.msky130_fd_pr__nfet_01v8_lvt[cgb]
echo OPV XX1_M23 cgb $&s1_xx1_m23_cgb
let s1_xx1_m23_cdg = @m.x1.xdut.xx1_m23.msky130_fd_pr__nfet_01v8_lvt[cdg]
echo OPV XX1_M23 cdg $&s1_xx1_m23_cdg
let s1_xx1_m23_cdd = @m.x1.xdut.xx1_m23.msky130_fd_pr__nfet_01v8_lvt[cdd]
echo OPV XX1_M23 cdd $&s1_xx1_m23_cdd
let s1_xx1_m23_cds = @m.x1.xdut.xx1_m23.msky130_fd_pr__nfet_01v8_lvt[cds]
echo OPV XX1_M23 cds $&s1_xx1_m23_cds
let s1_xx1_m23_cdb = @m.x1.xdut.xx1_m23.msky130_fd_pr__nfet_01v8_lvt[cdb]
echo OPV XX1_M23 cdb $&s1_xx1_m23_cdb
let s1_xx1_m23_csg = @m.x1.xdut.xx1_m23.msky130_fd_pr__nfet_01v8_lvt[csg]
echo OPV XX1_M23 csg $&s1_xx1_m23_csg
let s1_xx1_m23_csd = @m.x1.xdut.xx1_m23.msky130_fd_pr__nfet_01v8_lvt[csd]
echo OPV XX1_M23 csd $&s1_xx1_m23_csd
let s1_xx1_m23_css = @m.x1.xdut.xx1_m23.msky130_fd_pr__nfet_01v8_lvt[css]
echo OPV XX1_M23 css $&s1_xx1_m23_css
let s1_xx1_m23_csb = @m.x1.xdut.xx1_m23.msky130_fd_pr__nfet_01v8_lvt[csb]
echo OPV XX1_M23 csb $&s1_xx1_m23_csb
let s1_xx1_m23_cbg = @m.x1.xdut.xx1_m23.msky130_fd_pr__nfet_01v8_lvt[cbg]
echo OPV XX1_M23 cbg $&s1_xx1_m23_cbg
let s1_xx1_m23_cbd = @m.x1.xdut.xx1_m23.msky130_fd_pr__nfet_01v8_lvt[cbd]
echo OPV XX1_M23 cbd $&s1_xx1_m23_cbd
let s1_xx1_m23_cbs = @m.x1.xdut.xx1_m23.msky130_fd_pr__nfet_01v8_lvt[cbs]
echo OPV XX1_M23 cbs $&s1_xx1_m23_cbs
let s1_xx1_m23_cbb = @m.x1.xdut.xx1_m23.msky130_fd_pr__nfet_01v8_lvt[cbb]
echo OPV XX1_M23 cbb $&s1_xx1_m23_cbb
let s1_xx1_m23_capbd = @m.x1.xdut.xx1_m23.msky130_fd_pr__nfet_01v8_lvt[capbd]
echo OPV XX1_M23 capbd $&s1_xx1_m23_capbd
let s1_xx1_m23_capbs = @m.x1.xdut.xx1_m23.msky130_fd_pr__nfet_01v8_lvt[capbs]
echo OPV XX1_M23 capbs $&s1_xx1_m23_capbs
let s1_xx1_m23_cgso = @m.x1.xdut.xx1_m23.msky130_fd_pr__nfet_01v8_lvt[cgso]
echo OPV XX1_M23 cgso $&s1_xx1_m23_cgso
let s1_xx1_m23_cgdo = @m.x1.xdut.xx1_m23.msky130_fd_pr__nfet_01v8_lvt[cgdo]
echo OPV XX1_M23 cgdo $&s1_xx1_m23_cgdo
let s1_xx1_m23_cgbo = @m.x1.xdut.xx1_m23.msky130_fd_pr__nfet_01v8_lvt[cgbo]
echo OPV XX1_M23 cgbo $&s1_xx1_m23_cgbo
let s1_xx1_m23_weff = @m.x1.xdut.xx1_m23.msky130_fd_pr__nfet_01v8_lvt[weff]
echo OPV XX1_M23 weff $&s1_xx1_m23_weff
let s1_xx1_m23_leff = @m.x1.xdut.xx1_m23.msky130_fd_pr__nfet_01v8_lvt[leff]
echo OPV XX1_M23 leff $&s1_xx1_m23_leff
let s1_xx1_m24_id = @m.x1.xdut.xx1_m24.msky130_fd_pr__nfet_01v8_lvt[id]
echo OPV XX1_M24 id $&s1_xx1_m24_id
let s1_xx1_m24_vgs = @m.x1.xdut.xx1_m24.msky130_fd_pr__nfet_01v8_lvt[vgs]
echo OPV XX1_M24 vgs $&s1_xx1_m24_vgs
let s1_xx1_m24_vds = @m.x1.xdut.xx1_m24.msky130_fd_pr__nfet_01v8_lvt[vds]
echo OPV XX1_M24 vds $&s1_xx1_m24_vds
let s1_xx1_m24_vbs = @m.x1.xdut.xx1_m24.msky130_fd_pr__nfet_01v8_lvt[vbs]
echo OPV XX1_M24 vbs $&s1_xx1_m24_vbs
let s1_xx1_m24_vth = @m.x1.xdut.xx1_m24.msky130_fd_pr__nfet_01v8_lvt[vth]
echo OPV XX1_M24 vth $&s1_xx1_m24_vth
let s1_xx1_m24_vdsat = @m.x1.xdut.xx1_m24.msky130_fd_pr__nfet_01v8_lvt[vdsat]
echo OPV XX1_M24 vdsat $&s1_xx1_m24_vdsat
let s1_xx1_m24_gm = @m.x1.xdut.xx1_m24.msky130_fd_pr__nfet_01v8_lvt[gm]
echo OPV XX1_M24 gm $&s1_xx1_m24_gm
let s1_xx1_m24_gds = @m.x1.xdut.xx1_m24.msky130_fd_pr__nfet_01v8_lvt[gds]
echo OPV XX1_M24 gds $&s1_xx1_m24_gds
let s1_xx1_m24_gmbs = @m.x1.xdut.xx1_m24.msky130_fd_pr__nfet_01v8_lvt[gmbs]
echo OPV XX1_M24 gmbs $&s1_xx1_m24_gmbs
let s1_xx1_m24_cgg = @m.x1.xdut.xx1_m24.msky130_fd_pr__nfet_01v8_lvt[cgg]
echo OPV XX1_M24 cgg $&s1_xx1_m24_cgg
let s1_xx1_m24_cgd = @m.x1.xdut.xx1_m24.msky130_fd_pr__nfet_01v8_lvt[cgd]
echo OPV XX1_M24 cgd $&s1_xx1_m24_cgd
let s1_xx1_m24_cgs = @m.x1.xdut.xx1_m24.msky130_fd_pr__nfet_01v8_lvt[cgs]
echo OPV XX1_M24 cgs $&s1_xx1_m24_cgs
let s1_xx1_m24_cgb = @m.x1.xdut.xx1_m24.msky130_fd_pr__nfet_01v8_lvt[cgb]
echo OPV XX1_M24 cgb $&s1_xx1_m24_cgb
let s1_xx1_m24_cdg = @m.x1.xdut.xx1_m24.msky130_fd_pr__nfet_01v8_lvt[cdg]
echo OPV XX1_M24 cdg $&s1_xx1_m24_cdg
let s1_xx1_m24_cdd = @m.x1.xdut.xx1_m24.msky130_fd_pr__nfet_01v8_lvt[cdd]
echo OPV XX1_M24 cdd $&s1_xx1_m24_cdd
let s1_xx1_m24_cds = @m.x1.xdut.xx1_m24.msky130_fd_pr__nfet_01v8_lvt[cds]
echo OPV XX1_M24 cds $&s1_xx1_m24_cds
let s1_xx1_m24_cdb = @m.x1.xdut.xx1_m24.msky130_fd_pr__nfet_01v8_lvt[cdb]
echo OPV XX1_M24 cdb $&s1_xx1_m24_cdb
let s1_xx1_m24_csg = @m.x1.xdut.xx1_m24.msky130_fd_pr__nfet_01v8_lvt[csg]
echo OPV XX1_M24 csg $&s1_xx1_m24_csg
let s1_xx1_m24_csd = @m.x1.xdut.xx1_m24.msky130_fd_pr__nfet_01v8_lvt[csd]
echo OPV XX1_M24 csd $&s1_xx1_m24_csd
let s1_xx1_m24_css = @m.x1.xdut.xx1_m24.msky130_fd_pr__nfet_01v8_lvt[css]
echo OPV XX1_M24 css $&s1_xx1_m24_css
let s1_xx1_m24_csb = @m.x1.xdut.xx1_m24.msky130_fd_pr__nfet_01v8_lvt[csb]
echo OPV XX1_M24 csb $&s1_xx1_m24_csb
let s1_xx1_m24_cbg = @m.x1.xdut.xx1_m24.msky130_fd_pr__nfet_01v8_lvt[cbg]
echo OPV XX1_M24 cbg $&s1_xx1_m24_cbg
let s1_xx1_m24_cbd = @m.x1.xdut.xx1_m24.msky130_fd_pr__nfet_01v8_lvt[cbd]
echo OPV XX1_M24 cbd $&s1_xx1_m24_cbd
let s1_xx1_m24_cbs = @m.x1.xdut.xx1_m24.msky130_fd_pr__nfet_01v8_lvt[cbs]
echo OPV XX1_M24 cbs $&s1_xx1_m24_cbs
let s1_xx1_m24_cbb = @m.x1.xdut.xx1_m24.msky130_fd_pr__nfet_01v8_lvt[cbb]
echo OPV XX1_M24 cbb $&s1_xx1_m24_cbb
let s1_xx1_m24_capbd = @m.x1.xdut.xx1_m24.msky130_fd_pr__nfet_01v8_lvt[capbd]
echo OPV XX1_M24 capbd $&s1_xx1_m24_capbd
let s1_xx1_m24_capbs = @m.x1.xdut.xx1_m24.msky130_fd_pr__nfet_01v8_lvt[capbs]
echo OPV XX1_M24 capbs $&s1_xx1_m24_capbs
let s1_xx1_m24_cgso = @m.x1.xdut.xx1_m24.msky130_fd_pr__nfet_01v8_lvt[cgso]
echo OPV XX1_M24 cgso $&s1_xx1_m24_cgso
let s1_xx1_m24_cgdo = @m.x1.xdut.xx1_m24.msky130_fd_pr__nfet_01v8_lvt[cgdo]
echo OPV XX1_M24 cgdo $&s1_xx1_m24_cgdo
let s1_xx1_m24_cgbo = @m.x1.xdut.xx1_m24.msky130_fd_pr__nfet_01v8_lvt[cgbo]
echo OPV XX1_M24 cgbo $&s1_xx1_m24_cgbo
let s1_xx1_m24_weff = @m.x1.xdut.xx1_m24.msky130_fd_pr__nfet_01v8_lvt[weff]
echo OPV XX1_M24 weff $&s1_xx1_m24_weff
let s1_xx1_m24_leff = @m.x1.xdut.xx1_m24.msky130_fd_pr__nfet_01v8_lvt[leff]
echo OPV XX1_M24 leff $&s1_xx1_m24_leff
let s1_xx1_m25_id = @m.x1.xdut.xx1_m25.msky130_fd_pr__pfet_01v8_lvt[id]
echo OPV XX1_M25 id $&s1_xx1_m25_id
let s1_xx1_m25_vgs = @m.x1.xdut.xx1_m25.msky130_fd_pr__pfet_01v8_lvt[vgs]
echo OPV XX1_M25 vgs $&s1_xx1_m25_vgs
let s1_xx1_m25_vds = @m.x1.xdut.xx1_m25.msky130_fd_pr__pfet_01v8_lvt[vds]
echo OPV XX1_M25 vds $&s1_xx1_m25_vds
let s1_xx1_m25_vbs = @m.x1.xdut.xx1_m25.msky130_fd_pr__pfet_01v8_lvt[vbs]
echo OPV XX1_M25 vbs $&s1_xx1_m25_vbs
let s1_xx1_m25_vth = @m.x1.xdut.xx1_m25.msky130_fd_pr__pfet_01v8_lvt[vth]
echo OPV XX1_M25 vth $&s1_xx1_m25_vth
let s1_xx1_m25_vdsat = @m.x1.xdut.xx1_m25.msky130_fd_pr__pfet_01v8_lvt[vdsat]
echo OPV XX1_M25 vdsat $&s1_xx1_m25_vdsat
let s1_xx1_m25_gm = @m.x1.xdut.xx1_m25.msky130_fd_pr__pfet_01v8_lvt[gm]
echo OPV XX1_M25 gm $&s1_xx1_m25_gm
let s1_xx1_m25_gds = @m.x1.xdut.xx1_m25.msky130_fd_pr__pfet_01v8_lvt[gds]
echo OPV XX1_M25 gds $&s1_xx1_m25_gds
let s1_xx1_m25_gmbs = @m.x1.xdut.xx1_m25.msky130_fd_pr__pfet_01v8_lvt[gmbs]
echo OPV XX1_M25 gmbs $&s1_xx1_m25_gmbs
let s1_xx1_m25_cgg = @m.x1.xdut.xx1_m25.msky130_fd_pr__pfet_01v8_lvt[cgg]
echo OPV XX1_M25 cgg $&s1_xx1_m25_cgg
let s1_xx1_m25_cgd = @m.x1.xdut.xx1_m25.msky130_fd_pr__pfet_01v8_lvt[cgd]
echo OPV XX1_M25 cgd $&s1_xx1_m25_cgd
let s1_xx1_m25_cgs = @m.x1.xdut.xx1_m25.msky130_fd_pr__pfet_01v8_lvt[cgs]
echo OPV XX1_M25 cgs $&s1_xx1_m25_cgs
let s1_xx1_m25_cgb = @m.x1.xdut.xx1_m25.msky130_fd_pr__pfet_01v8_lvt[cgb]
echo OPV XX1_M25 cgb $&s1_xx1_m25_cgb
let s1_xx1_m25_cdg = @m.x1.xdut.xx1_m25.msky130_fd_pr__pfet_01v8_lvt[cdg]
echo OPV XX1_M25 cdg $&s1_xx1_m25_cdg
let s1_xx1_m25_cdd = @m.x1.xdut.xx1_m25.msky130_fd_pr__pfet_01v8_lvt[cdd]
echo OPV XX1_M25 cdd $&s1_xx1_m25_cdd
let s1_xx1_m25_cds = @m.x1.xdut.xx1_m25.msky130_fd_pr__pfet_01v8_lvt[cds]
echo OPV XX1_M25 cds $&s1_xx1_m25_cds
let s1_xx1_m25_cdb = @m.x1.xdut.xx1_m25.msky130_fd_pr__pfet_01v8_lvt[cdb]
echo OPV XX1_M25 cdb $&s1_xx1_m25_cdb
let s1_xx1_m25_csg = @m.x1.xdut.xx1_m25.msky130_fd_pr__pfet_01v8_lvt[csg]
echo OPV XX1_M25 csg $&s1_xx1_m25_csg
let s1_xx1_m25_csd = @m.x1.xdut.xx1_m25.msky130_fd_pr__pfet_01v8_lvt[csd]
echo OPV XX1_M25 csd $&s1_xx1_m25_csd
let s1_xx1_m25_css = @m.x1.xdut.xx1_m25.msky130_fd_pr__pfet_01v8_lvt[css]
echo OPV XX1_M25 css $&s1_xx1_m25_css
let s1_xx1_m25_csb = @m.x1.xdut.xx1_m25.msky130_fd_pr__pfet_01v8_lvt[csb]
echo OPV XX1_M25 csb $&s1_xx1_m25_csb
let s1_xx1_m25_cbg = @m.x1.xdut.xx1_m25.msky130_fd_pr__pfet_01v8_lvt[cbg]
echo OPV XX1_M25 cbg $&s1_xx1_m25_cbg
let s1_xx1_m25_cbd = @m.x1.xdut.xx1_m25.msky130_fd_pr__pfet_01v8_lvt[cbd]
echo OPV XX1_M25 cbd $&s1_xx1_m25_cbd
let s1_xx1_m25_cbs = @m.x1.xdut.xx1_m25.msky130_fd_pr__pfet_01v8_lvt[cbs]
echo OPV XX1_M25 cbs $&s1_xx1_m25_cbs
let s1_xx1_m25_cbb = @m.x1.xdut.xx1_m25.msky130_fd_pr__pfet_01v8_lvt[cbb]
echo OPV XX1_M25 cbb $&s1_xx1_m25_cbb
let s1_xx1_m25_capbd = @m.x1.xdut.xx1_m25.msky130_fd_pr__pfet_01v8_lvt[capbd]
echo OPV XX1_M25 capbd $&s1_xx1_m25_capbd
let s1_xx1_m25_capbs = @m.x1.xdut.xx1_m25.msky130_fd_pr__pfet_01v8_lvt[capbs]
echo OPV XX1_M25 capbs $&s1_xx1_m25_capbs
let s1_xx1_m25_cgso = @m.x1.xdut.xx1_m25.msky130_fd_pr__pfet_01v8_lvt[cgso]
echo OPV XX1_M25 cgso $&s1_xx1_m25_cgso
let s1_xx1_m25_cgdo = @m.x1.xdut.xx1_m25.msky130_fd_pr__pfet_01v8_lvt[cgdo]
echo OPV XX1_M25 cgdo $&s1_xx1_m25_cgdo
let s1_xx1_m25_cgbo = @m.x1.xdut.xx1_m25.msky130_fd_pr__pfet_01v8_lvt[cgbo]
echo OPV XX1_M25 cgbo $&s1_xx1_m25_cgbo
let s1_xx1_m25_weff = @m.x1.xdut.xx1_m25.msky130_fd_pr__pfet_01v8_lvt[weff]
echo OPV XX1_M25 weff $&s1_xx1_m25_weff
let s1_xx1_m25_leff = @m.x1.xdut.xx1_m25.msky130_fd_pr__pfet_01v8_lvt[leff]
echo OPV XX1_M25 leff $&s1_xx1_m25_leff
let s1_xx2_m9_id = @m.x1.xdut.xx2_m9.msky130_fd_pr__pfet_01v8_lvt[id]
echo OPV XX2_M9 id $&s1_xx2_m9_id
let s1_xx2_m9_vgs = @m.x1.xdut.xx2_m9.msky130_fd_pr__pfet_01v8_lvt[vgs]
echo OPV XX2_M9 vgs $&s1_xx2_m9_vgs
let s1_xx2_m9_vds = @m.x1.xdut.xx2_m9.msky130_fd_pr__pfet_01v8_lvt[vds]
echo OPV XX2_M9 vds $&s1_xx2_m9_vds
let s1_xx2_m9_vbs = @m.x1.xdut.xx2_m9.msky130_fd_pr__pfet_01v8_lvt[vbs]
echo OPV XX2_M9 vbs $&s1_xx2_m9_vbs
let s1_xx2_m9_vth = @m.x1.xdut.xx2_m9.msky130_fd_pr__pfet_01v8_lvt[vth]
echo OPV XX2_M9 vth $&s1_xx2_m9_vth
let s1_xx2_m9_vdsat = @m.x1.xdut.xx2_m9.msky130_fd_pr__pfet_01v8_lvt[vdsat]
echo OPV XX2_M9 vdsat $&s1_xx2_m9_vdsat
let s1_xx2_m9_gm = @m.x1.xdut.xx2_m9.msky130_fd_pr__pfet_01v8_lvt[gm]
echo OPV XX2_M9 gm $&s1_xx2_m9_gm
let s1_xx2_m9_gds = @m.x1.xdut.xx2_m9.msky130_fd_pr__pfet_01v8_lvt[gds]
echo OPV XX2_M9 gds $&s1_xx2_m9_gds
let s1_xx2_m9_gmbs = @m.x1.xdut.xx2_m9.msky130_fd_pr__pfet_01v8_lvt[gmbs]
echo OPV XX2_M9 gmbs $&s1_xx2_m9_gmbs
let s1_xx2_m9_cgg = @m.x1.xdut.xx2_m9.msky130_fd_pr__pfet_01v8_lvt[cgg]
echo OPV XX2_M9 cgg $&s1_xx2_m9_cgg
let s1_xx2_m9_cgd = @m.x1.xdut.xx2_m9.msky130_fd_pr__pfet_01v8_lvt[cgd]
echo OPV XX2_M9 cgd $&s1_xx2_m9_cgd
let s1_xx2_m9_cgs = @m.x1.xdut.xx2_m9.msky130_fd_pr__pfet_01v8_lvt[cgs]
echo OPV XX2_M9 cgs $&s1_xx2_m9_cgs
let s1_xx2_m9_cgb = @m.x1.xdut.xx2_m9.msky130_fd_pr__pfet_01v8_lvt[cgb]
echo OPV XX2_M9 cgb $&s1_xx2_m9_cgb
let s1_xx2_m9_cdg = @m.x1.xdut.xx2_m9.msky130_fd_pr__pfet_01v8_lvt[cdg]
echo OPV XX2_M9 cdg $&s1_xx2_m9_cdg
let s1_xx2_m9_cdd = @m.x1.xdut.xx2_m9.msky130_fd_pr__pfet_01v8_lvt[cdd]
echo OPV XX2_M9 cdd $&s1_xx2_m9_cdd
let s1_xx2_m9_cds = @m.x1.xdut.xx2_m9.msky130_fd_pr__pfet_01v8_lvt[cds]
echo OPV XX2_M9 cds $&s1_xx2_m9_cds
let s1_xx2_m9_cdb = @m.x1.xdut.xx2_m9.msky130_fd_pr__pfet_01v8_lvt[cdb]
echo OPV XX2_M9 cdb $&s1_xx2_m9_cdb
let s1_xx2_m9_csg = @m.x1.xdut.xx2_m9.msky130_fd_pr__pfet_01v8_lvt[csg]
echo OPV XX2_M9 csg $&s1_xx2_m9_csg
let s1_xx2_m9_csd = @m.x1.xdut.xx2_m9.msky130_fd_pr__pfet_01v8_lvt[csd]
echo OPV XX2_M9 csd $&s1_xx2_m9_csd
let s1_xx2_m9_css = @m.x1.xdut.xx2_m9.msky130_fd_pr__pfet_01v8_lvt[css]
echo OPV XX2_M9 css $&s1_xx2_m9_css
let s1_xx2_m9_csb = @m.x1.xdut.xx2_m9.msky130_fd_pr__pfet_01v8_lvt[csb]
echo OPV XX2_M9 csb $&s1_xx2_m9_csb
let s1_xx2_m9_cbg = @m.x1.xdut.xx2_m9.msky130_fd_pr__pfet_01v8_lvt[cbg]
echo OPV XX2_M9 cbg $&s1_xx2_m9_cbg
let s1_xx2_m9_cbd = @m.x1.xdut.xx2_m9.msky130_fd_pr__pfet_01v8_lvt[cbd]
echo OPV XX2_M9 cbd $&s1_xx2_m9_cbd
let s1_xx2_m9_cbs = @m.x1.xdut.xx2_m9.msky130_fd_pr__pfet_01v8_lvt[cbs]
echo OPV XX2_M9 cbs $&s1_xx2_m9_cbs
let s1_xx2_m9_cbb = @m.x1.xdut.xx2_m9.msky130_fd_pr__pfet_01v8_lvt[cbb]
echo OPV XX2_M9 cbb $&s1_xx2_m9_cbb
let s1_xx2_m9_capbd = @m.x1.xdut.xx2_m9.msky130_fd_pr__pfet_01v8_lvt[capbd]
echo OPV XX2_M9 capbd $&s1_xx2_m9_capbd
let s1_xx2_m9_capbs = @m.x1.xdut.xx2_m9.msky130_fd_pr__pfet_01v8_lvt[capbs]
echo OPV XX2_M9 capbs $&s1_xx2_m9_capbs
let s1_xx2_m9_cgso = @m.x1.xdut.xx2_m9.msky130_fd_pr__pfet_01v8_lvt[cgso]
echo OPV XX2_M9 cgso $&s1_xx2_m9_cgso
let s1_xx2_m9_cgdo = @m.x1.xdut.xx2_m9.msky130_fd_pr__pfet_01v8_lvt[cgdo]
echo OPV XX2_M9 cgdo $&s1_xx2_m9_cgdo
let s1_xx2_m9_cgbo = @m.x1.xdut.xx2_m9.msky130_fd_pr__pfet_01v8_lvt[cgbo]
echo OPV XX2_M9 cgbo $&s1_xx2_m9_cgbo
let s1_xx2_m9_weff = @m.x1.xdut.xx2_m9.msky130_fd_pr__pfet_01v8_lvt[weff]
echo OPV XX2_M9 weff $&s1_xx2_m9_weff
let s1_xx2_m9_leff = @m.x1.xdut.xx2_m9.msky130_fd_pr__pfet_01v8_lvt[leff]
echo OPV XX2_M9 leff $&s1_xx2_m9_leff
let s1_xx2_m4_id = @m.x1.xdut.xx2_m4.msky130_fd_pr__pfet_01v8_lvt[id]
echo OPV XX2_M4 id $&s1_xx2_m4_id
let s1_xx2_m4_vgs = @m.x1.xdut.xx2_m4.msky130_fd_pr__pfet_01v8_lvt[vgs]
echo OPV XX2_M4 vgs $&s1_xx2_m4_vgs
let s1_xx2_m4_vds = @m.x1.xdut.xx2_m4.msky130_fd_pr__pfet_01v8_lvt[vds]
echo OPV XX2_M4 vds $&s1_xx2_m4_vds
let s1_xx2_m4_vbs = @m.x1.xdut.xx2_m4.msky130_fd_pr__pfet_01v8_lvt[vbs]
echo OPV XX2_M4 vbs $&s1_xx2_m4_vbs
let s1_xx2_m4_vth = @m.x1.xdut.xx2_m4.msky130_fd_pr__pfet_01v8_lvt[vth]
echo OPV XX2_M4 vth $&s1_xx2_m4_vth
let s1_xx2_m4_vdsat = @m.x1.xdut.xx2_m4.msky130_fd_pr__pfet_01v8_lvt[vdsat]
echo OPV XX2_M4 vdsat $&s1_xx2_m4_vdsat
let s1_xx2_m4_gm = @m.x1.xdut.xx2_m4.msky130_fd_pr__pfet_01v8_lvt[gm]
echo OPV XX2_M4 gm $&s1_xx2_m4_gm
let s1_xx2_m4_gds = @m.x1.xdut.xx2_m4.msky130_fd_pr__pfet_01v8_lvt[gds]
echo OPV XX2_M4 gds $&s1_xx2_m4_gds
let s1_xx2_m4_gmbs = @m.x1.xdut.xx2_m4.msky130_fd_pr__pfet_01v8_lvt[gmbs]
echo OPV XX2_M4 gmbs $&s1_xx2_m4_gmbs
let s1_xx2_m4_cgg = @m.x1.xdut.xx2_m4.msky130_fd_pr__pfet_01v8_lvt[cgg]
echo OPV XX2_M4 cgg $&s1_xx2_m4_cgg
let s1_xx2_m4_cgd = @m.x1.xdut.xx2_m4.msky130_fd_pr__pfet_01v8_lvt[cgd]
echo OPV XX2_M4 cgd $&s1_xx2_m4_cgd
let s1_xx2_m4_cgs = @m.x1.xdut.xx2_m4.msky130_fd_pr__pfet_01v8_lvt[cgs]
echo OPV XX2_M4 cgs $&s1_xx2_m4_cgs
let s1_xx2_m4_cgb = @m.x1.xdut.xx2_m4.msky130_fd_pr__pfet_01v8_lvt[cgb]
echo OPV XX2_M4 cgb $&s1_xx2_m4_cgb
let s1_xx2_m4_cdg = @m.x1.xdut.xx2_m4.msky130_fd_pr__pfet_01v8_lvt[cdg]
echo OPV XX2_M4 cdg $&s1_xx2_m4_cdg
let s1_xx2_m4_cdd = @m.x1.xdut.xx2_m4.msky130_fd_pr__pfet_01v8_lvt[cdd]
echo OPV XX2_M4 cdd $&s1_xx2_m4_cdd
let s1_xx2_m4_cds = @m.x1.xdut.xx2_m4.msky130_fd_pr__pfet_01v8_lvt[cds]
echo OPV XX2_M4 cds $&s1_xx2_m4_cds
let s1_xx2_m4_cdb = @m.x1.xdut.xx2_m4.msky130_fd_pr__pfet_01v8_lvt[cdb]
echo OPV XX2_M4 cdb $&s1_xx2_m4_cdb
let s1_xx2_m4_csg = @m.x1.xdut.xx2_m4.msky130_fd_pr__pfet_01v8_lvt[csg]
echo OPV XX2_M4 csg $&s1_xx2_m4_csg
let s1_xx2_m4_csd = @m.x1.xdut.xx2_m4.msky130_fd_pr__pfet_01v8_lvt[csd]
echo OPV XX2_M4 csd $&s1_xx2_m4_csd
let s1_xx2_m4_css = @m.x1.xdut.xx2_m4.msky130_fd_pr__pfet_01v8_lvt[css]
echo OPV XX2_M4 css $&s1_xx2_m4_css
let s1_xx2_m4_csb = @m.x1.xdut.xx2_m4.msky130_fd_pr__pfet_01v8_lvt[csb]
echo OPV XX2_M4 csb $&s1_xx2_m4_csb
let s1_xx2_m4_cbg = @m.x1.xdut.xx2_m4.msky130_fd_pr__pfet_01v8_lvt[cbg]
echo OPV XX2_M4 cbg $&s1_xx2_m4_cbg
let s1_xx2_m4_cbd = @m.x1.xdut.xx2_m4.msky130_fd_pr__pfet_01v8_lvt[cbd]
echo OPV XX2_M4 cbd $&s1_xx2_m4_cbd
let s1_xx2_m4_cbs = @m.x1.xdut.xx2_m4.msky130_fd_pr__pfet_01v8_lvt[cbs]
echo OPV XX2_M4 cbs $&s1_xx2_m4_cbs
let s1_xx2_m4_cbb = @m.x1.xdut.xx2_m4.msky130_fd_pr__pfet_01v8_lvt[cbb]
echo OPV XX2_M4 cbb $&s1_xx2_m4_cbb
let s1_xx2_m4_capbd = @m.x1.xdut.xx2_m4.msky130_fd_pr__pfet_01v8_lvt[capbd]
echo OPV XX2_M4 capbd $&s1_xx2_m4_capbd
let s1_xx2_m4_capbs = @m.x1.xdut.xx2_m4.msky130_fd_pr__pfet_01v8_lvt[capbs]
echo OPV XX2_M4 capbs $&s1_xx2_m4_capbs
let s1_xx2_m4_cgso = @m.x1.xdut.xx2_m4.msky130_fd_pr__pfet_01v8_lvt[cgso]
echo OPV XX2_M4 cgso $&s1_xx2_m4_cgso
let s1_xx2_m4_cgdo = @m.x1.xdut.xx2_m4.msky130_fd_pr__pfet_01v8_lvt[cgdo]
echo OPV XX2_M4 cgdo $&s1_xx2_m4_cgdo
let s1_xx2_m4_cgbo = @m.x1.xdut.xx2_m4.msky130_fd_pr__pfet_01v8_lvt[cgbo]
echo OPV XX2_M4 cgbo $&s1_xx2_m4_cgbo
let s1_xx2_m4_weff = @m.x1.xdut.xx2_m4.msky130_fd_pr__pfet_01v8_lvt[weff]
echo OPV XX2_M4 weff $&s1_xx2_m4_weff
let s1_xx2_m4_leff = @m.x1.xdut.xx2_m4.msky130_fd_pr__pfet_01v8_lvt[leff]
echo OPV XX2_M4 leff $&s1_xx2_m4_leff
let s1_xx2_m2_id = @m.x1.xdut.xx2_m2.msky130_fd_pr__nfet_01v8_lvt[id]
echo OPV XX2_M2 id $&s1_xx2_m2_id
let s1_xx2_m2_vgs = @m.x1.xdut.xx2_m2.msky130_fd_pr__nfet_01v8_lvt[vgs]
echo OPV XX2_M2 vgs $&s1_xx2_m2_vgs
let s1_xx2_m2_vds = @m.x1.xdut.xx2_m2.msky130_fd_pr__nfet_01v8_lvt[vds]
echo OPV XX2_M2 vds $&s1_xx2_m2_vds
let s1_xx2_m2_vbs = @m.x1.xdut.xx2_m2.msky130_fd_pr__nfet_01v8_lvt[vbs]
echo OPV XX2_M2 vbs $&s1_xx2_m2_vbs
let s1_xx2_m2_vth = @m.x1.xdut.xx2_m2.msky130_fd_pr__nfet_01v8_lvt[vth]
echo OPV XX2_M2 vth $&s1_xx2_m2_vth
let s1_xx2_m2_vdsat = @m.x1.xdut.xx2_m2.msky130_fd_pr__nfet_01v8_lvt[vdsat]
echo OPV XX2_M2 vdsat $&s1_xx2_m2_vdsat
let s1_xx2_m2_gm = @m.x1.xdut.xx2_m2.msky130_fd_pr__nfet_01v8_lvt[gm]
echo OPV XX2_M2 gm $&s1_xx2_m2_gm
let s1_xx2_m2_gds = @m.x1.xdut.xx2_m2.msky130_fd_pr__nfet_01v8_lvt[gds]
echo OPV XX2_M2 gds $&s1_xx2_m2_gds
let s1_xx2_m2_gmbs = @m.x1.xdut.xx2_m2.msky130_fd_pr__nfet_01v8_lvt[gmbs]
echo OPV XX2_M2 gmbs $&s1_xx2_m2_gmbs
let s1_xx2_m2_cgg = @m.x1.xdut.xx2_m2.msky130_fd_pr__nfet_01v8_lvt[cgg]
echo OPV XX2_M2 cgg $&s1_xx2_m2_cgg
let s1_xx2_m2_cgd = @m.x1.xdut.xx2_m2.msky130_fd_pr__nfet_01v8_lvt[cgd]
echo OPV XX2_M2 cgd $&s1_xx2_m2_cgd
let s1_xx2_m2_cgs = @m.x1.xdut.xx2_m2.msky130_fd_pr__nfet_01v8_lvt[cgs]
echo OPV XX2_M2 cgs $&s1_xx2_m2_cgs
let s1_xx2_m2_cgb = @m.x1.xdut.xx2_m2.msky130_fd_pr__nfet_01v8_lvt[cgb]
echo OPV XX2_M2 cgb $&s1_xx2_m2_cgb
let s1_xx2_m2_cdg = @m.x1.xdut.xx2_m2.msky130_fd_pr__nfet_01v8_lvt[cdg]
echo OPV XX2_M2 cdg $&s1_xx2_m2_cdg
let s1_xx2_m2_cdd = @m.x1.xdut.xx2_m2.msky130_fd_pr__nfet_01v8_lvt[cdd]
echo OPV XX2_M2 cdd $&s1_xx2_m2_cdd
let s1_xx2_m2_cds = @m.x1.xdut.xx2_m2.msky130_fd_pr__nfet_01v8_lvt[cds]
echo OPV XX2_M2 cds $&s1_xx2_m2_cds
let s1_xx2_m2_cdb = @m.x1.xdut.xx2_m2.msky130_fd_pr__nfet_01v8_lvt[cdb]
echo OPV XX2_M2 cdb $&s1_xx2_m2_cdb
let s1_xx2_m2_csg = @m.x1.xdut.xx2_m2.msky130_fd_pr__nfet_01v8_lvt[csg]
echo OPV XX2_M2 csg $&s1_xx2_m2_csg
let s1_xx2_m2_csd = @m.x1.xdut.xx2_m2.msky130_fd_pr__nfet_01v8_lvt[csd]
echo OPV XX2_M2 csd $&s1_xx2_m2_csd
let s1_xx2_m2_css = @m.x1.xdut.xx2_m2.msky130_fd_pr__nfet_01v8_lvt[css]
echo OPV XX2_M2 css $&s1_xx2_m2_css
let s1_xx2_m2_csb = @m.x1.xdut.xx2_m2.msky130_fd_pr__nfet_01v8_lvt[csb]
echo OPV XX2_M2 csb $&s1_xx2_m2_csb
let s1_xx2_m2_cbg = @m.x1.xdut.xx2_m2.msky130_fd_pr__nfet_01v8_lvt[cbg]
echo OPV XX2_M2 cbg $&s1_xx2_m2_cbg
let s1_xx2_m2_cbd = @m.x1.xdut.xx2_m2.msky130_fd_pr__nfet_01v8_lvt[cbd]
echo OPV XX2_M2 cbd $&s1_xx2_m2_cbd
let s1_xx2_m2_cbs = @m.x1.xdut.xx2_m2.msky130_fd_pr__nfet_01v8_lvt[cbs]
echo OPV XX2_M2 cbs $&s1_xx2_m2_cbs
let s1_xx2_m2_cbb = @m.x1.xdut.xx2_m2.msky130_fd_pr__nfet_01v8_lvt[cbb]
echo OPV XX2_M2 cbb $&s1_xx2_m2_cbb
let s1_xx2_m2_capbd = @m.x1.xdut.xx2_m2.msky130_fd_pr__nfet_01v8_lvt[capbd]
echo OPV XX2_M2 capbd $&s1_xx2_m2_capbd
let s1_xx2_m2_capbs = @m.x1.xdut.xx2_m2.msky130_fd_pr__nfet_01v8_lvt[capbs]
echo OPV XX2_M2 capbs $&s1_xx2_m2_capbs
let s1_xx2_m2_cgso = @m.x1.xdut.xx2_m2.msky130_fd_pr__nfet_01v8_lvt[cgso]
echo OPV XX2_M2 cgso $&s1_xx2_m2_cgso
let s1_xx2_m2_cgdo = @m.x1.xdut.xx2_m2.msky130_fd_pr__nfet_01v8_lvt[cgdo]
echo OPV XX2_M2 cgdo $&s1_xx2_m2_cgdo
let s1_xx2_m2_cgbo = @m.x1.xdut.xx2_m2.msky130_fd_pr__nfet_01v8_lvt[cgbo]
echo OPV XX2_M2 cgbo $&s1_xx2_m2_cgbo
let s1_xx2_m2_weff = @m.x1.xdut.xx2_m2.msky130_fd_pr__nfet_01v8_lvt[weff]
echo OPV XX2_M2 weff $&s1_xx2_m2_weff
let s1_xx2_m2_leff = @m.x1.xdut.xx2_m2.msky130_fd_pr__nfet_01v8_lvt[leff]
echo OPV XX2_M2 leff $&s1_xx2_m2_leff
let s1_xx2_m1_id = @m.x1.xdut.xx2_m1.msky130_fd_pr__nfet_01v8_lvt[id]
echo OPV XX2_M1 id $&s1_xx2_m1_id
let s1_xx2_m1_vgs = @m.x1.xdut.xx2_m1.msky130_fd_pr__nfet_01v8_lvt[vgs]
echo OPV XX2_M1 vgs $&s1_xx2_m1_vgs
let s1_xx2_m1_vds = @m.x1.xdut.xx2_m1.msky130_fd_pr__nfet_01v8_lvt[vds]
echo OPV XX2_M1 vds $&s1_xx2_m1_vds
let s1_xx2_m1_vbs = @m.x1.xdut.xx2_m1.msky130_fd_pr__nfet_01v8_lvt[vbs]
echo OPV XX2_M1 vbs $&s1_xx2_m1_vbs
let s1_xx2_m1_vth = @m.x1.xdut.xx2_m1.msky130_fd_pr__nfet_01v8_lvt[vth]
echo OPV XX2_M1 vth $&s1_xx2_m1_vth
let s1_xx2_m1_vdsat = @m.x1.xdut.xx2_m1.msky130_fd_pr__nfet_01v8_lvt[vdsat]
echo OPV XX2_M1 vdsat $&s1_xx2_m1_vdsat
let s1_xx2_m1_gm = @m.x1.xdut.xx2_m1.msky130_fd_pr__nfet_01v8_lvt[gm]
echo OPV XX2_M1 gm $&s1_xx2_m1_gm
let s1_xx2_m1_gds = @m.x1.xdut.xx2_m1.msky130_fd_pr__nfet_01v8_lvt[gds]
echo OPV XX2_M1 gds $&s1_xx2_m1_gds
let s1_xx2_m1_gmbs = @m.x1.xdut.xx2_m1.msky130_fd_pr__nfet_01v8_lvt[gmbs]
echo OPV XX2_M1 gmbs $&s1_xx2_m1_gmbs
let s1_xx2_m1_cgg = @m.x1.xdut.xx2_m1.msky130_fd_pr__nfet_01v8_lvt[cgg]
echo OPV XX2_M1 cgg $&s1_xx2_m1_cgg
let s1_xx2_m1_cgd = @m.x1.xdut.xx2_m1.msky130_fd_pr__nfet_01v8_lvt[cgd]
echo OPV XX2_M1 cgd $&s1_xx2_m1_cgd
let s1_xx2_m1_cgs = @m.x1.xdut.xx2_m1.msky130_fd_pr__nfet_01v8_lvt[cgs]
echo OPV XX2_M1 cgs $&s1_xx2_m1_cgs
let s1_xx2_m1_cgb = @m.x1.xdut.xx2_m1.msky130_fd_pr__nfet_01v8_lvt[cgb]
echo OPV XX2_M1 cgb $&s1_xx2_m1_cgb
let s1_xx2_m1_cdg = @m.x1.xdut.xx2_m1.msky130_fd_pr__nfet_01v8_lvt[cdg]
echo OPV XX2_M1 cdg $&s1_xx2_m1_cdg
let s1_xx2_m1_cdd = @m.x1.xdut.xx2_m1.msky130_fd_pr__nfet_01v8_lvt[cdd]
echo OPV XX2_M1 cdd $&s1_xx2_m1_cdd
let s1_xx2_m1_cds = @m.x1.xdut.xx2_m1.msky130_fd_pr__nfet_01v8_lvt[cds]
echo OPV XX2_M1 cds $&s1_xx2_m1_cds
let s1_xx2_m1_cdb = @m.x1.xdut.xx2_m1.msky130_fd_pr__nfet_01v8_lvt[cdb]
echo OPV XX2_M1 cdb $&s1_xx2_m1_cdb
let s1_xx2_m1_csg = @m.x1.xdut.xx2_m1.msky130_fd_pr__nfet_01v8_lvt[csg]
echo OPV XX2_M1 csg $&s1_xx2_m1_csg
let s1_xx2_m1_csd = @m.x1.xdut.xx2_m1.msky130_fd_pr__nfet_01v8_lvt[csd]
echo OPV XX2_M1 csd $&s1_xx2_m1_csd
let s1_xx2_m1_css = @m.x1.xdut.xx2_m1.msky130_fd_pr__nfet_01v8_lvt[css]
echo OPV XX2_M1 css $&s1_xx2_m1_css
let s1_xx2_m1_csb = @m.x1.xdut.xx2_m1.msky130_fd_pr__nfet_01v8_lvt[csb]
echo OPV XX2_M1 csb $&s1_xx2_m1_csb
let s1_xx2_m1_cbg = @m.x1.xdut.xx2_m1.msky130_fd_pr__nfet_01v8_lvt[cbg]
echo OPV XX2_M1 cbg $&s1_xx2_m1_cbg
let s1_xx2_m1_cbd = @m.x1.xdut.xx2_m1.msky130_fd_pr__nfet_01v8_lvt[cbd]
echo OPV XX2_M1 cbd $&s1_xx2_m1_cbd
let s1_xx2_m1_cbs = @m.x1.xdut.xx2_m1.msky130_fd_pr__nfet_01v8_lvt[cbs]
echo OPV XX2_M1 cbs $&s1_xx2_m1_cbs
let s1_xx2_m1_cbb = @m.x1.xdut.xx2_m1.msky130_fd_pr__nfet_01v8_lvt[cbb]
echo OPV XX2_M1 cbb $&s1_xx2_m1_cbb
let s1_xx2_m1_capbd = @m.x1.xdut.xx2_m1.msky130_fd_pr__nfet_01v8_lvt[capbd]
echo OPV XX2_M1 capbd $&s1_xx2_m1_capbd
let s1_xx2_m1_capbs = @m.x1.xdut.xx2_m1.msky130_fd_pr__nfet_01v8_lvt[capbs]
echo OPV XX2_M1 capbs $&s1_xx2_m1_capbs
let s1_xx2_m1_cgso = @m.x1.xdut.xx2_m1.msky130_fd_pr__nfet_01v8_lvt[cgso]
echo OPV XX2_M1 cgso $&s1_xx2_m1_cgso
let s1_xx2_m1_cgdo = @m.x1.xdut.xx2_m1.msky130_fd_pr__nfet_01v8_lvt[cgdo]
echo OPV XX2_M1 cgdo $&s1_xx2_m1_cgdo
let s1_xx2_m1_cgbo = @m.x1.xdut.xx2_m1.msky130_fd_pr__nfet_01v8_lvt[cgbo]
echo OPV XX2_M1 cgbo $&s1_xx2_m1_cgbo
let s1_xx2_m1_weff = @m.x1.xdut.xx2_m1.msky130_fd_pr__nfet_01v8_lvt[weff]
echo OPV XX2_M1 weff $&s1_xx2_m1_weff
let s1_xx2_m1_leff = @m.x1.xdut.xx2_m1.msky130_fd_pr__nfet_01v8_lvt[leff]
echo OPV XX2_M1 leff $&s1_xx2_m1_leff
let s1_xx2_m3_id = @m.x1.xdut.xx2_m3.msky130_fd_pr__pfet_01v8_lvt[id]
echo OPV XX2_M3 id $&s1_xx2_m3_id
let s1_xx2_m3_vgs = @m.x1.xdut.xx2_m3.msky130_fd_pr__pfet_01v8_lvt[vgs]
echo OPV XX2_M3 vgs $&s1_xx2_m3_vgs
let s1_xx2_m3_vds = @m.x1.xdut.xx2_m3.msky130_fd_pr__pfet_01v8_lvt[vds]
echo OPV XX2_M3 vds $&s1_xx2_m3_vds
let s1_xx2_m3_vbs = @m.x1.xdut.xx2_m3.msky130_fd_pr__pfet_01v8_lvt[vbs]
echo OPV XX2_M3 vbs $&s1_xx2_m3_vbs
let s1_xx2_m3_vth = @m.x1.xdut.xx2_m3.msky130_fd_pr__pfet_01v8_lvt[vth]
echo OPV XX2_M3 vth $&s1_xx2_m3_vth
let s1_xx2_m3_vdsat = @m.x1.xdut.xx2_m3.msky130_fd_pr__pfet_01v8_lvt[vdsat]
echo OPV XX2_M3 vdsat $&s1_xx2_m3_vdsat
let s1_xx2_m3_gm = @m.x1.xdut.xx2_m3.msky130_fd_pr__pfet_01v8_lvt[gm]
echo OPV XX2_M3 gm $&s1_xx2_m3_gm
let s1_xx2_m3_gds = @m.x1.xdut.xx2_m3.msky130_fd_pr__pfet_01v8_lvt[gds]
echo OPV XX2_M3 gds $&s1_xx2_m3_gds
let s1_xx2_m3_gmbs = @m.x1.xdut.xx2_m3.msky130_fd_pr__pfet_01v8_lvt[gmbs]
echo OPV XX2_M3 gmbs $&s1_xx2_m3_gmbs
let s1_xx2_m3_cgg = @m.x1.xdut.xx2_m3.msky130_fd_pr__pfet_01v8_lvt[cgg]
echo OPV XX2_M3 cgg $&s1_xx2_m3_cgg
let s1_xx2_m3_cgd = @m.x1.xdut.xx2_m3.msky130_fd_pr__pfet_01v8_lvt[cgd]
echo OPV XX2_M3 cgd $&s1_xx2_m3_cgd
let s1_xx2_m3_cgs = @m.x1.xdut.xx2_m3.msky130_fd_pr__pfet_01v8_lvt[cgs]
echo OPV XX2_M3 cgs $&s1_xx2_m3_cgs
let s1_xx2_m3_cgb = @m.x1.xdut.xx2_m3.msky130_fd_pr__pfet_01v8_lvt[cgb]
echo OPV XX2_M3 cgb $&s1_xx2_m3_cgb
let s1_xx2_m3_cdg = @m.x1.xdut.xx2_m3.msky130_fd_pr__pfet_01v8_lvt[cdg]
echo OPV XX2_M3 cdg $&s1_xx2_m3_cdg
let s1_xx2_m3_cdd = @m.x1.xdut.xx2_m3.msky130_fd_pr__pfet_01v8_lvt[cdd]
echo OPV XX2_M3 cdd $&s1_xx2_m3_cdd
let s1_xx2_m3_cds = @m.x1.xdut.xx2_m3.msky130_fd_pr__pfet_01v8_lvt[cds]
echo OPV XX2_M3 cds $&s1_xx2_m3_cds
let s1_xx2_m3_cdb = @m.x1.xdut.xx2_m3.msky130_fd_pr__pfet_01v8_lvt[cdb]
echo OPV XX2_M3 cdb $&s1_xx2_m3_cdb
let s1_xx2_m3_csg = @m.x1.xdut.xx2_m3.msky130_fd_pr__pfet_01v8_lvt[csg]
echo OPV XX2_M3 csg $&s1_xx2_m3_csg
let s1_xx2_m3_csd = @m.x1.xdut.xx2_m3.msky130_fd_pr__pfet_01v8_lvt[csd]
echo OPV XX2_M3 csd $&s1_xx2_m3_csd
let s1_xx2_m3_css = @m.x1.xdut.xx2_m3.msky130_fd_pr__pfet_01v8_lvt[css]
echo OPV XX2_M3 css $&s1_xx2_m3_css
let s1_xx2_m3_csb = @m.x1.xdut.xx2_m3.msky130_fd_pr__pfet_01v8_lvt[csb]
echo OPV XX2_M3 csb $&s1_xx2_m3_csb
let s1_xx2_m3_cbg = @m.x1.xdut.xx2_m3.msky130_fd_pr__pfet_01v8_lvt[cbg]
echo OPV XX2_M3 cbg $&s1_xx2_m3_cbg
let s1_xx2_m3_cbd = @m.x1.xdut.xx2_m3.msky130_fd_pr__pfet_01v8_lvt[cbd]
echo OPV XX2_M3 cbd $&s1_xx2_m3_cbd
let s1_xx2_m3_cbs = @m.x1.xdut.xx2_m3.msky130_fd_pr__pfet_01v8_lvt[cbs]
echo OPV XX2_M3 cbs $&s1_xx2_m3_cbs
let s1_xx2_m3_cbb = @m.x1.xdut.xx2_m3.msky130_fd_pr__pfet_01v8_lvt[cbb]
echo OPV XX2_M3 cbb $&s1_xx2_m3_cbb
let s1_xx2_m3_capbd = @m.x1.xdut.xx2_m3.msky130_fd_pr__pfet_01v8_lvt[capbd]
echo OPV XX2_M3 capbd $&s1_xx2_m3_capbd
let s1_xx2_m3_capbs = @m.x1.xdut.xx2_m3.msky130_fd_pr__pfet_01v8_lvt[capbs]
echo OPV XX2_M3 capbs $&s1_xx2_m3_capbs
let s1_xx2_m3_cgso = @m.x1.xdut.xx2_m3.msky130_fd_pr__pfet_01v8_lvt[cgso]
echo OPV XX2_M3 cgso $&s1_xx2_m3_cgso
let s1_xx2_m3_cgdo = @m.x1.xdut.xx2_m3.msky130_fd_pr__pfet_01v8_lvt[cgdo]
echo OPV XX2_M3 cgdo $&s1_xx2_m3_cgdo
let s1_xx2_m3_cgbo = @m.x1.xdut.xx2_m3.msky130_fd_pr__pfet_01v8_lvt[cgbo]
echo OPV XX2_M3 cgbo $&s1_xx2_m3_cgbo
let s1_xx2_m3_weff = @m.x1.xdut.xx2_m3.msky130_fd_pr__pfet_01v8_lvt[weff]
echo OPV XX2_M3 weff $&s1_xx2_m3_weff
let s1_xx2_m3_leff = @m.x1.xdut.xx2_m3.msky130_fd_pr__pfet_01v8_lvt[leff]
echo OPV XX2_M3 leff $&s1_xx2_m3_leff
let s1_xx2_m7_id = @m.x1.xdut.xx2_m7.msky130_fd_pr__pfet_01v8_lvt[id]
echo OPV XX2_M7 id $&s1_xx2_m7_id
let s1_xx2_m7_vgs = @m.x1.xdut.xx2_m7.msky130_fd_pr__pfet_01v8_lvt[vgs]
echo OPV XX2_M7 vgs $&s1_xx2_m7_vgs
let s1_xx2_m7_vds = @m.x1.xdut.xx2_m7.msky130_fd_pr__pfet_01v8_lvt[vds]
echo OPV XX2_M7 vds $&s1_xx2_m7_vds
let s1_xx2_m7_vbs = @m.x1.xdut.xx2_m7.msky130_fd_pr__pfet_01v8_lvt[vbs]
echo OPV XX2_M7 vbs $&s1_xx2_m7_vbs
let s1_xx2_m7_vth = @m.x1.xdut.xx2_m7.msky130_fd_pr__pfet_01v8_lvt[vth]
echo OPV XX2_M7 vth $&s1_xx2_m7_vth
let s1_xx2_m7_vdsat = @m.x1.xdut.xx2_m7.msky130_fd_pr__pfet_01v8_lvt[vdsat]
echo OPV XX2_M7 vdsat $&s1_xx2_m7_vdsat
let s1_xx2_m7_gm = @m.x1.xdut.xx2_m7.msky130_fd_pr__pfet_01v8_lvt[gm]
echo OPV XX2_M7 gm $&s1_xx2_m7_gm
let s1_xx2_m7_gds = @m.x1.xdut.xx2_m7.msky130_fd_pr__pfet_01v8_lvt[gds]
echo OPV XX2_M7 gds $&s1_xx2_m7_gds
let s1_xx2_m7_gmbs = @m.x1.xdut.xx2_m7.msky130_fd_pr__pfet_01v8_lvt[gmbs]
echo OPV XX2_M7 gmbs $&s1_xx2_m7_gmbs
let s1_xx2_m7_cgg = @m.x1.xdut.xx2_m7.msky130_fd_pr__pfet_01v8_lvt[cgg]
echo OPV XX2_M7 cgg $&s1_xx2_m7_cgg
let s1_xx2_m7_cgd = @m.x1.xdut.xx2_m7.msky130_fd_pr__pfet_01v8_lvt[cgd]
echo OPV XX2_M7 cgd $&s1_xx2_m7_cgd
let s1_xx2_m7_cgs = @m.x1.xdut.xx2_m7.msky130_fd_pr__pfet_01v8_lvt[cgs]
echo OPV XX2_M7 cgs $&s1_xx2_m7_cgs
let s1_xx2_m7_cgb = @m.x1.xdut.xx2_m7.msky130_fd_pr__pfet_01v8_lvt[cgb]
echo OPV XX2_M7 cgb $&s1_xx2_m7_cgb
let s1_xx2_m7_cdg = @m.x1.xdut.xx2_m7.msky130_fd_pr__pfet_01v8_lvt[cdg]
echo OPV XX2_M7 cdg $&s1_xx2_m7_cdg
let s1_xx2_m7_cdd = @m.x1.xdut.xx2_m7.msky130_fd_pr__pfet_01v8_lvt[cdd]
echo OPV XX2_M7 cdd $&s1_xx2_m7_cdd
let s1_xx2_m7_cds = @m.x1.xdut.xx2_m7.msky130_fd_pr__pfet_01v8_lvt[cds]
echo OPV XX2_M7 cds $&s1_xx2_m7_cds
let s1_xx2_m7_cdb = @m.x1.xdut.xx2_m7.msky130_fd_pr__pfet_01v8_lvt[cdb]
echo OPV XX2_M7 cdb $&s1_xx2_m7_cdb
let s1_xx2_m7_csg = @m.x1.xdut.xx2_m7.msky130_fd_pr__pfet_01v8_lvt[csg]
echo OPV XX2_M7 csg $&s1_xx2_m7_csg
let s1_xx2_m7_csd = @m.x1.xdut.xx2_m7.msky130_fd_pr__pfet_01v8_lvt[csd]
echo OPV XX2_M7 csd $&s1_xx2_m7_csd
let s1_xx2_m7_css = @m.x1.xdut.xx2_m7.msky130_fd_pr__pfet_01v8_lvt[css]
echo OPV XX2_M7 css $&s1_xx2_m7_css
let s1_xx2_m7_csb = @m.x1.xdut.xx2_m7.msky130_fd_pr__pfet_01v8_lvt[csb]
echo OPV XX2_M7 csb $&s1_xx2_m7_csb
let s1_xx2_m7_cbg = @m.x1.xdut.xx2_m7.msky130_fd_pr__pfet_01v8_lvt[cbg]
echo OPV XX2_M7 cbg $&s1_xx2_m7_cbg
let s1_xx2_m7_cbd = @m.x1.xdut.xx2_m7.msky130_fd_pr__pfet_01v8_lvt[cbd]
echo OPV XX2_M7 cbd $&s1_xx2_m7_cbd
let s1_xx2_m7_cbs = @m.x1.xdut.xx2_m7.msky130_fd_pr__pfet_01v8_lvt[cbs]
echo OPV XX2_M7 cbs $&s1_xx2_m7_cbs
let s1_xx2_m7_cbb = @m.x1.xdut.xx2_m7.msky130_fd_pr__pfet_01v8_lvt[cbb]
echo OPV XX2_M7 cbb $&s1_xx2_m7_cbb
let s1_xx2_m7_capbd = @m.x1.xdut.xx2_m7.msky130_fd_pr__pfet_01v8_lvt[capbd]
echo OPV XX2_M7 capbd $&s1_xx2_m7_capbd
let s1_xx2_m7_capbs = @m.x1.xdut.xx2_m7.msky130_fd_pr__pfet_01v8_lvt[capbs]
echo OPV XX2_M7 capbs $&s1_xx2_m7_capbs
let s1_xx2_m7_cgso = @m.x1.xdut.xx2_m7.msky130_fd_pr__pfet_01v8_lvt[cgso]
echo OPV XX2_M7 cgso $&s1_xx2_m7_cgso
let s1_xx2_m7_cgdo = @m.x1.xdut.xx2_m7.msky130_fd_pr__pfet_01v8_lvt[cgdo]
echo OPV XX2_M7 cgdo $&s1_xx2_m7_cgdo
let s1_xx2_m7_cgbo = @m.x1.xdut.xx2_m7.msky130_fd_pr__pfet_01v8_lvt[cgbo]
echo OPV XX2_M7 cgbo $&s1_xx2_m7_cgbo
let s1_xx2_m7_weff = @m.x1.xdut.xx2_m7.msky130_fd_pr__pfet_01v8_lvt[weff]
echo OPV XX2_M7 weff $&s1_xx2_m7_weff
let s1_xx2_m7_leff = @m.x1.xdut.xx2_m7.msky130_fd_pr__pfet_01v8_lvt[leff]
echo OPV XX2_M7 leff $&s1_xx2_m7_leff
let s1_xx2_m8_id = @m.x1.xdut.xx2_m8.msky130_fd_pr__pfet_01v8_lvt[id]
echo OPV XX2_M8 id $&s1_xx2_m8_id
let s1_xx2_m8_vgs = @m.x1.xdut.xx2_m8.msky130_fd_pr__pfet_01v8_lvt[vgs]
echo OPV XX2_M8 vgs $&s1_xx2_m8_vgs
let s1_xx2_m8_vds = @m.x1.xdut.xx2_m8.msky130_fd_pr__pfet_01v8_lvt[vds]
echo OPV XX2_M8 vds $&s1_xx2_m8_vds
let s1_xx2_m8_vbs = @m.x1.xdut.xx2_m8.msky130_fd_pr__pfet_01v8_lvt[vbs]
echo OPV XX2_M8 vbs $&s1_xx2_m8_vbs
let s1_xx2_m8_vth = @m.x1.xdut.xx2_m8.msky130_fd_pr__pfet_01v8_lvt[vth]
echo OPV XX2_M8 vth $&s1_xx2_m8_vth
let s1_xx2_m8_vdsat = @m.x1.xdut.xx2_m8.msky130_fd_pr__pfet_01v8_lvt[vdsat]
echo OPV XX2_M8 vdsat $&s1_xx2_m8_vdsat
let s1_xx2_m8_gm = @m.x1.xdut.xx2_m8.msky130_fd_pr__pfet_01v8_lvt[gm]
echo OPV XX2_M8 gm $&s1_xx2_m8_gm
let s1_xx2_m8_gds = @m.x1.xdut.xx2_m8.msky130_fd_pr__pfet_01v8_lvt[gds]
echo OPV XX2_M8 gds $&s1_xx2_m8_gds
let s1_xx2_m8_gmbs = @m.x1.xdut.xx2_m8.msky130_fd_pr__pfet_01v8_lvt[gmbs]
echo OPV XX2_M8 gmbs $&s1_xx2_m8_gmbs
let s1_xx2_m8_cgg = @m.x1.xdut.xx2_m8.msky130_fd_pr__pfet_01v8_lvt[cgg]
echo OPV XX2_M8 cgg $&s1_xx2_m8_cgg
let s1_xx2_m8_cgd = @m.x1.xdut.xx2_m8.msky130_fd_pr__pfet_01v8_lvt[cgd]
echo OPV XX2_M8 cgd $&s1_xx2_m8_cgd
let s1_xx2_m8_cgs = @m.x1.xdut.xx2_m8.msky130_fd_pr__pfet_01v8_lvt[cgs]
echo OPV XX2_M8 cgs $&s1_xx2_m8_cgs
let s1_xx2_m8_cgb = @m.x1.xdut.xx2_m8.msky130_fd_pr__pfet_01v8_lvt[cgb]
echo OPV XX2_M8 cgb $&s1_xx2_m8_cgb
let s1_xx2_m8_cdg = @m.x1.xdut.xx2_m8.msky130_fd_pr__pfet_01v8_lvt[cdg]
echo OPV XX2_M8 cdg $&s1_xx2_m8_cdg
let s1_xx2_m8_cdd = @m.x1.xdut.xx2_m8.msky130_fd_pr__pfet_01v8_lvt[cdd]
echo OPV XX2_M8 cdd $&s1_xx2_m8_cdd
let s1_xx2_m8_cds = @m.x1.xdut.xx2_m8.msky130_fd_pr__pfet_01v8_lvt[cds]
echo OPV XX2_M8 cds $&s1_xx2_m8_cds
let s1_xx2_m8_cdb = @m.x1.xdut.xx2_m8.msky130_fd_pr__pfet_01v8_lvt[cdb]
echo OPV XX2_M8 cdb $&s1_xx2_m8_cdb
let s1_xx2_m8_csg = @m.x1.xdut.xx2_m8.msky130_fd_pr__pfet_01v8_lvt[csg]
echo OPV XX2_M8 csg $&s1_xx2_m8_csg
let s1_xx2_m8_csd = @m.x1.xdut.xx2_m8.msky130_fd_pr__pfet_01v8_lvt[csd]
echo OPV XX2_M8 csd $&s1_xx2_m8_csd
let s1_xx2_m8_css = @m.x1.xdut.xx2_m8.msky130_fd_pr__pfet_01v8_lvt[css]
echo OPV XX2_M8 css $&s1_xx2_m8_css
let s1_xx2_m8_csb = @m.x1.xdut.xx2_m8.msky130_fd_pr__pfet_01v8_lvt[csb]
echo OPV XX2_M8 csb $&s1_xx2_m8_csb
let s1_xx2_m8_cbg = @m.x1.xdut.xx2_m8.msky130_fd_pr__pfet_01v8_lvt[cbg]
echo OPV XX2_M8 cbg $&s1_xx2_m8_cbg
let s1_xx2_m8_cbd = @m.x1.xdut.xx2_m8.msky130_fd_pr__pfet_01v8_lvt[cbd]
echo OPV XX2_M8 cbd $&s1_xx2_m8_cbd
let s1_xx2_m8_cbs = @m.x1.xdut.xx2_m8.msky130_fd_pr__pfet_01v8_lvt[cbs]
echo OPV XX2_M8 cbs $&s1_xx2_m8_cbs
let s1_xx2_m8_cbb = @m.x1.xdut.xx2_m8.msky130_fd_pr__pfet_01v8_lvt[cbb]
echo OPV XX2_M8 cbb $&s1_xx2_m8_cbb
let s1_xx2_m8_capbd = @m.x1.xdut.xx2_m8.msky130_fd_pr__pfet_01v8_lvt[capbd]
echo OPV XX2_M8 capbd $&s1_xx2_m8_capbd
let s1_xx2_m8_capbs = @m.x1.xdut.xx2_m8.msky130_fd_pr__pfet_01v8_lvt[capbs]
echo OPV XX2_M8 capbs $&s1_xx2_m8_capbs
let s1_xx2_m8_cgso = @m.x1.xdut.xx2_m8.msky130_fd_pr__pfet_01v8_lvt[cgso]
echo OPV XX2_M8 cgso $&s1_xx2_m8_cgso
let s1_xx2_m8_cgdo = @m.x1.xdut.xx2_m8.msky130_fd_pr__pfet_01v8_lvt[cgdo]
echo OPV XX2_M8 cgdo $&s1_xx2_m8_cgdo
let s1_xx2_m8_cgbo = @m.x1.xdut.xx2_m8.msky130_fd_pr__pfet_01v8_lvt[cgbo]
echo OPV XX2_M8 cgbo $&s1_xx2_m8_cgbo
let s1_xx2_m8_weff = @m.x1.xdut.xx2_m8.msky130_fd_pr__pfet_01v8_lvt[weff]
echo OPV XX2_M8 weff $&s1_xx2_m8_weff
let s1_xx2_m8_leff = @m.x1.xdut.xx2_m8.msky130_fd_pr__pfet_01v8_lvt[leff]
echo OPV XX2_M8 leff $&s1_xx2_m8_leff
let s1_xx2_m5_id = @m.x1.xdut.xx2_m5.msky130_fd_pr__nfet_01v8_lvt[id]
echo OPV XX2_M5 id $&s1_xx2_m5_id
let s1_xx2_m5_vgs = @m.x1.xdut.xx2_m5.msky130_fd_pr__nfet_01v8_lvt[vgs]
echo OPV XX2_M5 vgs $&s1_xx2_m5_vgs
let s1_xx2_m5_vds = @m.x1.xdut.xx2_m5.msky130_fd_pr__nfet_01v8_lvt[vds]
echo OPV XX2_M5 vds $&s1_xx2_m5_vds
let s1_xx2_m5_vbs = @m.x1.xdut.xx2_m5.msky130_fd_pr__nfet_01v8_lvt[vbs]
echo OPV XX2_M5 vbs $&s1_xx2_m5_vbs
let s1_xx2_m5_vth = @m.x1.xdut.xx2_m5.msky130_fd_pr__nfet_01v8_lvt[vth]
echo OPV XX2_M5 vth $&s1_xx2_m5_vth
let s1_xx2_m5_vdsat = @m.x1.xdut.xx2_m5.msky130_fd_pr__nfet_01v8_lvt[vdsat]
echo OPV XX2_M5 vdsat $&s1_xx2_m5_vdsat
let s1_xx2_m5_gm = @m.x1.xdut.xx2_m5.msky130_fd_pr__nfet_01v8_lvt[gm]
echo OPV XX2_M5 gm $&s1_xx2_m5_gm
let s1_xx2_m5_gds = @m.x1.xdut.xx2_m5.msky130_fd_pr__nfet_01v8_lvt[gds]
echo OPV XX2_M5 gds $&s1_xx2_m5_gds
let s1_xx2_m5_gmbs = @m.x1.xdut.xx2_m5.msky130_fd_pr__nfet_01v8_lvt[gmbs]
echo OPV XX2_M5 gmbs $&s1_xx2_m5_gmbs
let s1_xx2_m5_cgg = @m.x1.xdut.xx2_m5.msky130_fd_pr__nfet_01v8_lvt[cgg]
echo OPV XX2_M5 cgg $&s1_xx2_m5_cgg
let s1_xx2_m5_cgd = @m.x1.xdut.xx2_m5.msky130_fd_pr__nfet_01v8_lvt[cgd]
echo OPV XX2_M5 cgd $&s1_xx2_m5_cgd
let s1_xx2_m5_cgs = @m.x1.xdut.xx2_m5.msky130_fd_pr__nfet_01v8_lvt[cgs]
echo OPV XX2_M5 cgs $&s1_xx2_m5_cgs
let s1_xx2_m5_cgb = @m.x1.xdut.xx2_m5.msky130_fd_pr__nfet_01v8_lvt[cgb]
echo OPV XX2_M5 cgb $&s1_xx2_m5_cgb
let s1_xx2_m5_cdg = @m.x1.xdut.xx2_m5.msky130_fd_pr__nfet_01v8_lvt[cdg]
echo OPV XX2_M5 cdg $&s1_xx2_m5_cdg
let s1_xx2_m5_cdd = @m.x1.xdut.xx2_m5.msky130_fd_pr__nfet_01v8_lvt[cdd]
echo OPV XX2_M5 cdd $&s1_xx2_m5_cdd
let s1_xx2_m5_cds = @m.x1.xdut.xx2_m5.msky130_fd_pr__nfet_01v8_lvt[cds]
echo OPV XX2_M5 cds $&s1_xx2_m5_cds
let s1_xx2_m5_cdb = @m.x1.xdut.xx2_m5.msky130_fd_pr__nfet_01v8_lvt[cdb]
echo OPV XX2_M5 cdb $&s1_xx2_m5_cdb
let s1_xx2_m5_csg = @m.x1.xdut.xx2_m5.msky130_fd_pr__nfet_01v8_lvt[csg]
echo OPV XX2_M5 csg $&s1_xx2_m5_csg
let s1_xx2_m5_csd = @m.x1.xdut.xx2_m5.msky130_fd_pr__nfet_01v8_lvt[csd]
echo OPV XX2_M5 csd $&s1_xx2_m5_csd
let s1_xx2_m5_css = @m.x1.xdut.xx2_m5.msky130_fd_pr__nfet_01v8_lvt[css]
echo OPV XX2_M5 css $&s1_xx2_m5_css
let s1_xx2_m5_csb = @m.x1.xdut.xx2_m5.msky130_fd_pr__nfet_01v8_lvt[csb]
echo OPV XX2_M5 csb $&s1_xx2_m5_csb
let s1_xx2_m5_cbg = @m.x1.xdut.xx2_m5.msky130_fd_pr__nfet_01v8_lvt[cbg]
echo OPV XX2_M5 cbg $&s1_xx2_m5_cbg
let s1_xx2_m5_cbd = @m.x1.xdut.xx2_m5.msky130_fd_pr__nfet_01v8_lvt[cbd]
echo OPV XX2_M5 cbd $&s1_xx2_m5_cbd
let s1_xx2_m5_cbs = @m.x1.xdut.xx2_m5.msky130_fd_pr__nfet_01v8_lvt[cbs]
echo OPV XX2_M5 cbs $&s1_xx2_m5_cbs
let s1_xx2_m5_cbb = @m.x1.xdut.xx2_m5.msky130_fd_pr__nfet_01v8_lvt[cbb]
echo OPV XX2_M5 cbb $&s1_xx2_m5_cbb
let s1_xx2_m5_capbd = @m.x1.xdut.xx2_m5.msky130_fd_pr__nfet_01v8_lvt[capbd]
echo OPV XX2_M5 capbd $&s1_xx2_m5_capbd
let s1_xx2_m5_capbs = @m.x1.xdut.xx2_m5.msky130_fd_pr__nfet_01v8_lvt[capbs]
echo OPV XX2_M5 capbs $&s1_xx2_m5_capbs
let s1_xx2_m5_cgso = @m.x1.xdut.xx2_m5.msky130_fd_pr__nfet_01v8_lvt[cgso]
echo OPV XX2_M5 cgso $&s1_xx2_m5_cgso
let s1_xx2_m5_cgdo = @m.x1.xdut.xx2_m5.msky130_fd_pr__nfet_01v8_lvt[cgdo]
echo OPV XX2_M5 cgdo $&s1_xx2_m5_cgdo
let s1_xx2_m5_cgbo = @m.x1.xdut.xx2_m5.msky130_fd_pr__nfet_01v8_lvt[cgbo]
echo OPV XX2_M5 cgbo $&s1_xx2_m5_cgbo
let s1_xx2_m5_weff = @m.x1.xdut.xx2_m5.msky130_fd_pr__nfet_01v8_lvt[weff]
echo OPV XX2_M5 weff $&s1_xx2_m5_weff
let s1_xx2_m5_leff = @m.x1.xdut.xx2_m5.msky130_fd_pr__nfet_01v8_lvt[leff]
echo OPV XX2_M5 leff $&s1_xx2_m5_leff
let s1_xx2_m6_id = @m.x1.xdut.xx2_m6.msky130_fd_pr__nfet_01v8_lvt[id]
echo OPV XX2_M6 id $&s1_xx2_m6_id
let s1_xx2_m6_vgs = @m.x1.xdut.xx2_m6.msky130_fd_pr__nfet_01v8_lvt[vgs]
echo OPV XX2_M6 vgs $&s1_xx2_m6_vgs
let s1_xx2_m6_vds = @m.x1.xdut.xx2_m6.msky130_fd_pr__nfet_01v8_lvt[vds]
echo OPV XX2_M6 vds $&s1_xx2_m6_vds
let s1_xx2_m6_vbs = @m.x1.xdut.xx2_m6.msky130_fd_pr__nfet_01v8_lvt[vbs]
echo OPV XX2_M6 vbs $&s1_xx2_m6_vbs
let s1_xx2_m6_vth = @m.x1.xdut.xx2_m6.msky130_fd_pr__nfet_01v8_lvt[vth]
echo OPV XX2_M6 vth $&s1_xx2_m6_vth
let s1_xx2_m6_vdsat = @m.x1.xdut.xx2_m6.msky130_fd_pr__nfet_01v8_lvt[vdsat]
echo OPV XX2_M6 vdsat $&s1_xx2_m6_vdsat
let s1_xx2_m6_gm = @m.x1.xdut.xx2_m6.msky130_fd_pr__nfet_01v8_lvt[gm]
echo OPV XX2_M6 gm $&s1_xx2_m6_gm
let s1_xx2_m6_gds = @m.x1.xdut.xx2_m6.msky130_fd_pr__nfet_01v8_lvt[gds]
echo OPV XX2_M6 gds $&s1_xx2_m6_gds
let s1_xx2_m6_gmbs = @m.x1.xdut.xx2_m6.msky130_fd_pr__nfet_01v8_lvt[gmbs]
echo OPV XX2_M6 gmbs $&s1_xx2_m6_gmbs
let s1_xx2_m6_cgg = @m.x1.xdut.xx2_m6.msky130_fd_pr__nfet_01v8_lvt[cgg]
echo OPV XX2_M6 cgg $&s1_xx2_m6_cgg
let s1_xx2_m6_cgd = @m.x1.xdut.xx2_m6.msky130_fd_pr__nfet_01v8_lvt[cgd]
echo OPV XX2_M6 cgd $&s1_xx2_m6_cgd
let s1_xx2_m6_cgs = @m.x1.xdut.xx2_m6.msky130_fd_pr__nfet_01v8_lvt[cgs]
echo OPV XX2_M6 cgs $&s1_xx2_m6_cgs
let s1_xx2_m6_cgb = @m.x1.xdut.xx2_m6.msky130_fd_pr__nfet_01v8_lvt[cgb]
echo OPV XX2_M6 cgb $&s1_xx2_m6_cgb
let s1_xx2_m6_cdg = @m.x1.xdut.xx2_m6.msky130_fd_pr__nfet_01v8_lvt[cdg]
echo OPV XX2_M6 cdg $&s1_xx2_m6_cdg
let s1_xx2_m6_cdd = @m.x1.xdut.xx2_m6.msky130_fd_pr__nfet_01v8_lvt[cdd]
echo OPV XX2_M6 cdd $&s1_xx2_m6_cdd
let s1_xx2_m6_cds = @m.x1.xdut.xx2_m6.msky130_fd_pr__nfet_01v8_lvt[cds]
echo OPV XX2_M6 cds $&s1_xx2_m6_cds
let s1_xx2_m6_cdb = @m.x1.xdut.xx2_m6.msky130_fd_pr__nfet_01v8_lvt[cdb]
echo OPV XX2_M6 cdb $&s1_xx2_m6_cdb
let s1_xx2_m6_csg = @m.x1.xdut.xx2_m6.msky130_fd_pr__nfet_01v8_lvt[csg]
echo OPV XX2_M6 csg $&s1_xx2_m6_csg
let s1_xx2_m6_csd = @m.x1.xdut.xx2_m6.msky130_fd_pr__nfet_01v8_lvt[csd]
echo OPV XX2_M6 csd $&s1_xx2_m6_csd
let s1_xx2_m6_css = @m.x1.xdut.xx2_m6.msky130_fd_pr__nfet_01v8_lvt[css]
echo OPV XX2_M6 css $&s1_xx2_m6_css
let s1_xx2_m6_csb = @m.x1.xdut.xx2_m6.msky130_fd_pr__nfet_01v8_lvt[csb]
echo OPV XX2_M6 csb $&s1_xx2_m6_csb
let s1_xx2_m6_cbg = @m.x1.xdut.xx2_m6.msky130_fd_pr__nfet_01v8_lvt[cbg]
echo OPV XX2_M6 cbg $&s1_xx2_m6_cbg
let s1_xx2_m6_cbd = @m.x1.xdut.xx2_m6.msky130_fd_pr__nfet_01v8_lvt[cbd]
echo OPV XX2_M6 cbd $&s1_xx2_m6_cbd
let s1_xx2_m6_cbs = @m.x1.xdut.xx2_m6.msky130_fd_pr__nfet_01v8_lvt[cbs]
echo OPV XX2_M6 cbs $&s1_xx2_m6_cbs
let s1_xx2_m6_cbb = @m.x1.xdut.xx2_m6.msky130_fd_pr__nfet_01v8_lvt[cbb]
echo OPV XX2_M6 cbb $&s1_xx2_m6_cbb
let s1_xx2_m6_capbd = @m.x1.xdut.xx2_m6.msky130_fd_pr__nfet_01v8_lvt[capbd]
echo OPV XX2_M6 capbd $&s1_xx2_m6_capbd
let s1_xx2_m6_capbs = @m.x1.xdut.xx2_m6.msky130_fd_pr__nfet_01v8_lvt[capbs]
echo OPV XX2_M6 capbs $&s1_xx2_m6_capbs
let s1_xx2_m6_cgso = @m.x1.xdut.xx2_m6.msky130_fd_pr__nfet_01v8_lvt[cgso]
echo OPV XX2_M6 cgso $&s1_xx2_m6_cgso
let s1_xx2_m6_cgdo = @m.x1.xdut.xx2_m6.msky130_fd_pr__nfet_01v8_lvt[cgdo]
echo OPV XX2_M6 cgdo $&s1_xx2_m6_cgdo
let s1_xx2_m6_cgbo = @m.x1.xdut.xx2_m6.msky130_fd_pr__nfet_01v8_lvt[cgbo]
echo OPV XX2_M6 cgbo $&s1_xx2_m6_cgbo
let s1_xx2_m6_weff = @m.x1.xdut.xx2_m6.msky130_fd_pr__nfet_01v8_lvt[weff]
echo OPV XX2_M6 weff $&s1_xx2_m6_weff
let s1_xx2_m6_leff = @m.x1.xdut.xx2_m6.msky130_fd_pr__nfet_01v8_lvt[leff]
echo OPV XX2_M6 leff $&s1_xx2_m6_leff
let s1_xx2_m10_id = @m.x1.xdut.xx2_m10.msky130_fd_pr__nfet_01v8_lvt[id]
echo OPV XX2_M10 id $&s1_xx2_m10_id
let s1_xx2_m10_vgs = @m.x1.xdut.xx2_m10.msky130_fd_pr__nfet_01v8_lvt[vgs]
echo OPV XX2_M10 vgs $&s1_xx2_m10_vgs
let s1_xx2_m10_vds = @m.x1.xdut.xx2_m10.msky130_fd_pr__nfet_01v8_lvt[vds]
echo OPV XX2_M10 vds $&s1_xx2_m10_vds
let s1_xx2_m10_vbs = @m.x1.xdut.xx2_m10.msky130_fd_pr__nfet_01v8_lvt[vbs]
echo OPV XX2_M10 vbs $&s1_xx2_m10_vbs
let s1_xx2_m10_vth = @m.x1.xdut.xx2_m10.msky130_fd_pr__nfet_01v8_lvt[vth]
echo OPV XX2_M10 vth $&s1_xx2_m10_vth
let s1_xx2_m10_vdsat = @m.x1.xdut.xx2_m10.msky130_fd_pr__nfet_01v8_lvt[vdsat]
echo OPV XX2_M10 vdsat $&s1_xx2_m10_vdsat
let s1_xx2_m10_gm = @m.x1.xdut.xx2_m10.msky130_fd_pr__nfet_01v8_lvt[gm]
echo OPV XX2_M10 gm $&s1_xx2_m10_gm
let s1_xx2_m10_gds = @m.x1.xdut.xx2_m10.msky130_fd_pr__nfet_01v8_lvt[gds]
echo OPV XX2_M10 gds $&s1_xx2_m10_gds
let s1_xx2_m10_gmbs = @m.x1.xdut.xx2_m10.msky130_fd_pr__nfet_01v8_lvt[gmbs]
echo OPV XX2_M10 gmbs $&s1_xx2_m10_gmbs
let s1_xx2_m10_cgg = @m.x1.xdut.xx2_m10.msky130_fd_pr__nfet_01v8_lvt[cgg]
echo OPV XX2_M10 cgg $&s1_xx2_m10_cgg
let s1_xx2_m10_cgd = @m.x1.xdut.xx2_m10.msky130_fd_pr__nfet_01v8_lvt[cgd]
echo OPV XX2_M10 cgd $&s1_xx2_m10_cgd
let s1_xx2_m10_cgs = @m.x1.xdut.xx2_m10.msky130_fd_pr__nfet_01v8_lvt[cgs]
echo OPV XX2_M10 cgs $&s1_xx2_m10_cgs
let s1_xx2_m10_cgb = @m.x1.xdut.xx2_m10.msky130_fd_pr__nfet_01v8_lvt[cgb]
echo OPV XX2_M10 cgb $&s1_xx2_m10_cgb
let s1_xx2_m10_cdg = @m.x1.xdut.xx2_m10.msky130_fd_pr__nfet_01v8_lvt[cdg]
echo OPV XX2_M10 cdg $&s1_xx2_m10_cdg
let s1_xx2_m10_cdd = @m.x1.xdut.xx2_m10.msky130_fd_pr__nfet_01v8_lvt[cdd]
echo OPV XX2_M10 cdd $&s1_xx2_m10_cdd
let s1_xx2_m10_cds = @m.x1.xdut.xx2_m10.msky130_fd_pr__nfet_01v8_lvt[cds]
echo OPV XX2_M10 cds $&s1_xx2_m10_cds
let s1_xx2_m10_cdb = @m.x1.xdut.xx2_m10.msky130_fd_pr__nfet_01v8_lvt[cdb]
echo OPV XX2_M10 cdb $&s1_xx2_m10_cdb
let s1_xx2_m10_csg = @m.x1.xdut.xx2_m10.msky130_fd_pr__nfet_01v8_lvt[csg]
echo OPV XX2_M10 csg $&s1_xx2_m10_csg
let s1_xx2_m10_csd = @m.x1.xdut.xx2_m10.msky130_fd_pr__nfet_01v8_lvt[csd]
echo OPV XX2_M10 csd $&s1_xx2_m10_csd
let s1_xx2_m10_css = @m.x1.xdut.xx2_m10.msky130_fd_pr__nfet_01v8_lvt[css]
echo OPV XX2_M10 css $&s1_xx2_m10_css
let s1_xx2_m10_csb = @m.x1.xdut.xx2_m10.msky130_fd_pr__nfet_01v8_lvt[csb]
echo OPV XX2_M10 csb $&s1_xx2_m10_csb
let s1_xx2_m10_cbg = @m.x1.xdut.xx2_m10.msky130_fd_pr__nfet_01v8_lvt[cbg]
echo OPV XX2_M10 cbg $&s1_xx2_m10_cbg
let s1_xx2_m10_cbd = @m.x1.xdut.xx2_m10.msky130_fd_pr__nfet_01v8_lvt[cbd]
echo OPV XX2_M10 cbd $&s1_xx2_m10_cbd
let s1_xx2_m10_cbs = @m.x1.xdut.xx2_m10.msky130_fd_pr__nfet_01v8_lvt[cbs]
echo OPV XX2_M10 cbs $&s1_xx2_m10_cbs
let s1_xx2_m10_cbb = @m.x1.xdut.xx2_m10.msky130_fd_pr__nfet_01v8_lvt[cbb]
echo OPV XX2_M10 cbb $&s1_xx2_m10_cbb
let s1_xx2_m10_capbd = @m.x1.xdut.xx2_m10.msky130_fd_pr__nfet_01v8_lvt[capbd]
echo OPV XX2_M10 capbd $&s1_xx2_m10_capbd
let s1_xx2_m10_capbs = @m.x1.xdut.xx2_m10.msky130_fd_pr__nfet_01v8_lvt[capbs]
echo OPV XX2_M10 capbs $&s1_xx2_m10_capbs
let s1_xx2_m10_cgso = @m.x1.xdut.xx2_m10.msky130_fd_pr__nfet_01v8_lvt[cgso]
echo OPV XX2_M10 cgso $&s1_xx2_m10_cgso
let s1_xx2_m10_cgdo = @m.x1.xdut.xx2_m10.msky130_fd_pr__nfet_01v8_lvt[cgdo]
echo OPV XX2_M10 cgdo $&s1_xx2_m10_cgdo
let s1_xx2_m10_cgbo = @m.x1.xdut.xx2_m10.msky130_fd_pr__nfet_01v8_lvt[cgbo]
echo OPV XX2_M10 cgbo $&s1_xx2_m10_cgbo
let s1_xx2_m10_weff = @m.x1.xdut.xx2_m10.msky130_fd_pr__nfet_01v8_lvt[weff]
echo OPV XX2_M10 weff $&s1_xx2_m10_weff
let s1_xx2_m10_leff = @m.x1.xdut.xx2_m10.msky130_fd_pr__nfet_01v8_lvt[leff]
echo OPV XX2_M10 leff $&s1_xx2_m10_leff
let s1_xx2_m11_id = @m.x1.xdut.xx2_m11.msky130_fd_pr__nfet_01v8_lvt[id]
echo OPV XX2_M11 id $&s1_xx2_m11_id
let s1_xx2_m11_vgs = @m.x1.xdut.xx2_m11.msky130_fd_pr__nfet_01v8_lvt[vgs]
echo OPV XX2_M11 vgs $&s1_xx2_m11_vgs
let s1_xx2_m11_vds = @m.x1.xdut.xx2_m11.msky130_fd_pr__nfet_01v8_lvt[vds]
echo OPV XX2_M11 vds $&s1_xx2_m11_vds
let s1_xx2_m11_vbs = @m.x1.xdut.xx2_m11.msky130_fd_pr__nfet_01v8_lvt[vbs]
echo OPV XX2_M11 vbs $&s1_xx2_m11_vbs
let s1_xx2_m11_vth = @m.x1.xdut.xx2_m11.msky130_fd_pr__nfet_01v8_lvt[vth]
echo OPV XX2_M11 vth $&s1_xx2_m11_vth
let s1_xx2_m11_vdsat = @m.x1.xdut.xx2_m11.msky130_fd_pr__nfet_01v8_lvt[vdsat]
echo OPV XX2_M11 vdsat $&s1_xx2_m11_vdsat
let s1_xx2_m11_gm = @m.x1.xdut.xx2_m11.msky130_fd_pr__nfet_01v8_lvt[gm]
echo OPV XX2_M11 gm $&s1_xx2_m11_gm
let s1_xx2_m11_gds = @m.x1.xdut.xx2_m11.msky130_fd_pr__nfet_01v8_lvt[gds]
echo OPV XX2_M11 gds $&s1_xx2_m11_gds
let s1_xx2_m11_gmbs = @m.x1.xdut.xx2_m11.msky130_fd_pr__nfet_01v8_lvt[gmbs]
echo OPV XX2_M11 gmbs $&s1_xx2_m11_gmbs
let s1_xx2_m11_cgg = @m.x1.xdut.xx2_m11.msky130_fd_pr__nfet_01v8_lvt[cgg]
echo OPV XX2_M11 cgg $&s1_xx2_m11_cgg
let s1_xx2_m11_cgd = @m.x1.xdut.xx2_m11.msky130_fd_pr__nfet_01v8_lvt[cgd]
echo OPV XX2_M11 cgd $&s1_xx2_m11_cgd
let s1_xx2_m11_cgs = @m.x1.xdut.xx2_m11.msky130_fd_pr__nfet_01v8_lvt[cgs]
echo OPV XX2_M11 cgs $&s1_xx2_m11_cgs
let s1_xx2_m11_cgb = @m.x1.xdut.xx2_m11.msky130_fd_pr__nfet_01v8_lvt[cgb]
echo OPV XX2_M11 cgb $&s1_xx2_m11_cgb
let s1_xx2_m11_cdg = @m.x1.xdut.xx2_m11.msky130_fd_pr__nfet_01v8_lvt[cdg]
echo OPV XX2_M11 cdg $&s1_xx2_m11_cdg
let s1_xx2_m11_cdd = @m.x1.xdut.xx2_m11.msky130_fd_pr__nfet_01v8_lvt[cdd]
echo OPV XX2_M11 cdd $&s1_xx2_m11_cdd
let s1_xx2_m11_cds = @m.x1.xdut.xx2_m11.msky130_fd_pr__nfet_01v8_lvt[cds]
echo OPV XX2_M11 cds $&s1_xx2_m11_cds
let s1_xx2_m11_cdb = @m.x1.xdut.xx2_m11.msky130_fd_pr__nfet_01v8_lvt[cdb]
echo OPV XX2_M11 cdb $&s1_xx2_m11_cdb
let s1_xx2_m11_csg = @m.x1.xdut.xx2_m11.msky130_fd_pr__nfet_01v8_lvt[csg]
echo OPV XX2_M11 csg $&s1_xx2_m11_csg
let s1_xx2_m11_csd = @m.x1.xdut.xx2_m11.msky130_fd_pr__nfet_01v8_lvt[csd]
echo OPV XX2_M11 csd $&s1_xx2_m11_csd
let s1_xx2_m11_css = @m.x1.xdut.xx2_m11.msky130_fd_pr__nfet_01v8_lvt[css]
echo OPV XX2_M11 css $&s1_xx2_m11_css
let s1_xx2_m11_csb = @m.x1.xdut.xx2_m11.msky130_fd_pr__nfet_01v8_lvt[csb]
echo OPV XX2_M11 csb $&s1_xx2_m11_csb
let s1_xx2_m11_cbg = @m.x1.xdut.xx2_m11.msky130_fd_pr__nfet_01v8_lvt[cbg]
echo OPV XX2_M11 cbg $&s1_xx2_m11_cbg
let s1_xx2_m11_cbd = @m.x1.xdut.xx2_m11.msky130_fd_pr__nfet_01v8_lvt[cbd]
echo OPV XX2_M11 cbd $&s1_xx2_m11_cbd
let s1_xx2_m11_cbs = @m.x1.xdut.xx2_m11.msky130_fd_pr__nfet_01v8_lvt[cbs]
echo OPV XX2_M11 cbs $&s1_xx2_m11_cbs
let s1_xx2_m11_cbb = @m.x1.xdut.xx2_m11.msky130_fd_pr__nfet_01v8_lvt[cbb]
echo OPV XX2_M11 cbb $&s1_xx2_m11_cbb
let s1_xx2_m11_capbd = @m.x1.xdut.xx2_m11.msky130_fd_pr__nfet_01v8_lvt[capbd]
echo OPV XX2_M11 capbd $&s1_xx2_m11_capbd
let s1_xx2_m11_capbs = @m.x1.xdut.xx2_m11.msky130_fd_pr__nfet_01v8_lvt[capbs]
echo OPV XX2_M11 capbs $&s1_xx2_m11_capbs
let s1_xx2_m11_cgso = @m.x1.xdut.xx2_m11.msky130_fd_pr__nfet_01v8_lvt[cgso]
echo OPV XX2_M11 cgso $&s1_xx2_m11_cgso
let s1_xx2_m11_cgdo = @m.x1.xdut.xx2_m11.msky130_fd_pr__nfet_01v8_lvt[cgdo]
echo OPV XX2_M11 cgdo $&s1_xx2_m11_cgdo
let s1_xx2_m11_cgbo = @m.x1.xdut.xx2_m11.msky130_fd_pr__nfet_01v8_lvt[cgbo]
echo OPV XX2_M11 cgbo $&s1_xx2_m11_cgbo
let s1_xx2_m11_weff = @m.x1.xdut.xx2_m11.msky130_fd_pr__nfet_01v8_lvt[weff]
echo OPV XX2_M11 weff $&s1_xx2_m11_weff
let s1_xx2_m11_leff = @m.x1.xdut.xx2_m11.msky130_fd_pr__nfet_01v8_lvt[leff]
echo OPV XX2_M11 leff $&s1_xx2_m11_leff
let s1_xx2_m12_id = @m.x1.xdut.xx2_m12.msky130_fd_pr__pfet_01v8_lvt[id]
echo OPV XX2_M12 id $&s1_xx2_m12_id
let s1_xx2_m12_vgs = @m.x1.xdut.xx2_m12.msky130_fd_pr__pfet_01v8_lvt[vgs]
echo OPV XX2_M12 vgs $&s1_xx2_m12_vgs
let s1_xx2_m12_vds = @m.x1.xdut.xx2_m12.msky130_fd_pr__pfet_01v8_lvt[vds]
echo OPV XX2_M12 vds $&s1_xx2_m12_vds
let s1_xx2_m12_vbs = @m.x1.xdut.xx2_m12.msky130_fd_pr__pfet_01v8_lvt[vbs]
echo OPV XX2_M12 vbs $&s1_xx2_m12_vbs
let s1_xx2_m12_vth = @m.x1.xdut.xx2_m12.msky130_fd_pr__pfet_01v8_lvt[vth]
echo OPV XX2_M12 vth $&s1_xx2_m12_vth
let s1_xx2_m12_vdsat = @m.x1.xdut.xx2_m12.msky130_fd_pr__pfet_01v8_lvt[vdsat]
echo OPV XX2_M12 vdsat $&s1_xx2_m12_vdsat
let s1_xx2_m12_gm = @m.x1.xdut.xx2_m12.msky130_fd_pr__pfet_01v8_lvt[gm]
echo OPV XX2_M12 gm $&s1_xx2_m12_gm
let s1_xx2_m12_gds = @m.x1.xdut.xx2_m12.msky130_fd_pr__pfet_01v8_lvt[gds]
echo OPV XX2_M12 gds $&s1_xx2_m12_gds
let s1_xx2_m12_gmbs = @m.x1.xdut.xx2_m12.msky130_fd_pr__pfet_01v8_lvt[gmbs]
echo OPV XX2_M12 gmbs $&s1_xx2_m12_gmbs
let s1_xx2_m12_cgg = @m.x1.xdut.xx2_m12.msky130_fd_pr__pfet_01v8_lvt[cgg]
echo OPV XX2_M12 cgg $&s1_xx2_m12_cgg
let s1_xx2_m12_cgd = @m.x1.xdut.xx2_m12.msky130_fd_pr__pfet_01v8_lvt[cgd]
echo OPV XX2_M12 cgd $&s1_xx2_m12_cgd
let s1_xx2_m12_cgs = @m.x1.xdut.xx2_m12.msky130_fd_pr__pfet_01v8_lvt[cgs]
echo OPV XX2_M12 cgs $&s1_xx2_m12_cgs
let s1_xx2_m12_cgb = @m.x1.xdut.xx2_m12.msky130_fd_pr__pfet_01v8_lvt[cgb]
echo OPV XX2_M12 cgb $&s1_xx2_m12_cgb
let s1_xx2_m12_cdg = @m.x1.xdut.xx2_m12.msky130_fd_pr__pfet_01v8_lvt[cdg]
echo OPV XX2_M12 cdg $&s1_xx2_m12_cdg
let s1_xx2_m12_cdd = @m.x1.xdut.xx2_m12.msky130_fd_pr__pfet_01v8_lvt[cdd]
echo OPV XX2_M12 cdd $&s1_xx2_m12_cdd
let s1_xx2_m12_cds = @m.x1.xdut.xx2_m12.msky130_fd_pr__pfet_01v8_lvt[cds]
echo OPV XX2_M12 cds $&s1_xx2_m12_cds
let s1_xx2_m12_cdb = @m.x1.xdut.xx2_m12.msky130_fd_pr__pfet_01v8_lvt[cdb]
echo OPV XX2_M12 cdb $&s1_xx2_m12_cdb
let s1_xx2_m12_csg = @m.x1.xdut.xx2_m12.msky130_fd_pr__pfet_01v8_lvt[csg]
echo OPV XX2_M12 csg $&s1_xx2_m12_csg
let s1_xx2_m12_csd = @m.x1.xdut.xx2_m12.msky130_fd_pr__pfet_01v8_lvt[csd]
echo OPV XX2_M12 csd $&s1_xx2_m12_csd
let s1_xx2_m12_css = @m.x1.xdut.xx2_m12.msky130_fd_pr__pfet_01v8_lvt[css]
echo OPV XX2_M12 css $&s1_xx2_m12_css
let s1_xx2_m12_csb = @m.x1.xdut.xx2_m12.msky130_fd_pr__pfet_01v8_lvt[csb]
echo OPV XX2_M12 csb $&s1_xx2_m12_csb
let s1_xx2_m12_cbg = @m.x1.xdut.xx2_m12.msky130_fd_pr__pfet_01v8_lvt[cbg]
echo OPV XX2_M12 cbg $&s1_xx2_m12_cbg
let s1_xx2_m12_cbd = @m.x1.xdut.xx2_m12.msky130_fd_pr__pfet_01v8_lvt[cbd]
echo OPV XX2_M12 cbd $&s1_xx2_m12_cbd
let s1_xx2_m12_cbs = @m.x1.xdut.xx2_m12.msky130_fd_pr__pfet_01v8_lvt[cbs]
echo OPV XX2_M12 cbs $&s1_xx2_m12_cbs
let s1_xx2_m12_cbb = @m.x1.xdut.xx2_m12.msky130_fd_pr__pfet_01v8_lvt[cbb]
echo OPV XX2_M12 cbb $&s1_xx2_m12_cbb
let s1_xx2_m12_capbd = @m.x1.xdut.xx2_m12.msky130_fd_pr__pfet_01v8_lvt[capbd]
echo OPV XX2_M12 capbd $&s1_xx2_m12_capbd
let s1_xx2_m12_capbs = @m.x1.xdut.xx2_m12.msky130_fd_pr__pfet_01v8_lvt[capbs]
echo OPV XX2_M12 capbs $&s1_xx2_m12_capbs
let s1_xx2_m12_cgso = @m.x1.xdut.xx2_m12.msky130_fd_pr__pfet_01v8_lvt[cgso]
echo OPV XX2_M12 cgso $&s1_xx2_m12_cgso
let s1_xx2_m12_cgdo = @m.x1.xdut.xx2_m12.msky130_fd_pr__pfet_01v8_lvt[cgdo]
echo OPV XX2_M12 cgdo $&s1_xx2_m12_cgdo
let s1_xx2_m12_cgbo = @m.x1.xdut.xx2_m12.msky130_fd_pr__pfet_01v8_lvt[cgbo]
echo OPV XX2_M12 cgbo $&s1_xx2_m12_cgbo
let s1_xx2_m12_weff = @m.x1.xdut.xx2_m12.msky130_fd_pr__pfet_01v8_lvt[weff]
echo OPV XX2_M12 weff $&s1_xx2_m12_weff
let s1_xx2_m12_leff = @m.x1.xdut.xx2_m12.msky130_fd_pr__pfet_01v8_lvt[leff]
echo OPV XX2_M12 leff $&s1_xx2_m12_leff
let s1i = i(vsup)
echo OPI isup $&s1i
let s1o = v(OUTP) - v(OUTN)
let s1cm = (v(OUTP) + v(OUTN)) / 2
echo OPI voutcm $&s1cm
echo OPI vout $&s1o
quit 0
.endc
**.ends

.subckt dut_amp INP INN OUTN VDD VSS OUTP
XDUT OUTP INN VDD VSS OUTN INP ttsky25a_fd
.ends

.subckt ttsky25a_fd Vop Vm Vdd Vss Vom Vp
XM32 s1r_XM32_d PBias s1r_XM32_s Vdd sky130_fd_pr__pfet_01v8_lvt L=1 W=5 NF=1 AD=1.45 AS=1.45 PD=10.58 PS=10.58 NRD=0.058 NRS=0.058 SA=0 SB=0 SD=0 MULT=2 M=2
Rpar_s1_XM32_s s1r_XM32_s Vdd 0.0731619
Rpar_s1_XM32_d s1r_XM32_d NBias 4.04132
XM33 s1r_XM33_d NBias Vss Vss sky130_fd_pr__nfet_01v8_lvt L=2 W=5 NF=1 AD=1.45 AS=1.45 PD=10.58 PS=10.58 NRD=0.058 NRS=0.058 SA=0 SB=0 SD=0 MULT=2 M=2
Rpar_s1_XM33_d s1r_XM33_d NBias 28.2893
XM34 net1 PBias Vdd Vdd sky130_fd_pr__pfet_01v8_lvt L=1 W=5 NF=1 AD=1.45 AS=1.45 PD=10.58 PS=10.58 NRD=0.058 NRS=0.058 SA=0 SB=0 SD=0 MULT=2 M=2
XM35 net1 net1 s1r_XM35_s Vss sky130_fd_pr__nfet_01v8_lvt L=1 W=10 NF=1 AD=2.9 AS=2.9 PD=20.58 PS=20.58 NRD=0.029 NRS=0.029 SA=0 SB=0 SD=0 MULT=2 M=2
Rpar_s1_XM35_s s1r_XM35_s Rgm 0.0531088
XM36 s1r_XM36_d net1 Vss Vss sky130_fd_pr__nfet_01v8_lvt L=2 W=5 NF=1 AD=1.45 AS=1.45 PD=10.58 PS=10.58 NRD=0.058 NRS=0.058 SA=0 SB=0 SD=0 MULT=2 M=2
Rpar_s1_XM36_d s1r_XM36_d net2 28.2893
XM37 PBias NBias s1r_XM37_s Vss sky130_fd_pr__nfet_01v8_lvt L=2 W=5 NF=1 AD=1.45 AS=1.45 PD=10.58 PS=10.58 NRD=0.058 NRS=0.058 SA=0 SB=0 SD=0 MULT=2 M=2
Rpar_s1_XM37_s s1r_XM37_s Vss 0.044179
XM38 PBias net2 Vdd Vdd sky130_fd_pr__pfet_01v8_lvt L=1 W=5 NF=1 AD=1.45 AS=1.45 PD=10.58 PS=10.58 NRD=0.058 NRS=0.058 SA=0 SB=0 SD=0 MULT=2 M=2
XM39 net2 net2 Vdd Vdd sky130_fd_pr__pfet_01v8_lvt L=1 W=5 NF=1 AD=1.45 AS=1.45 PD=10.58 PS=10.58 NRD=0.058 NRS=0.058 SA=0 SB=0 SD=0 MULT=2 M=2
XM40 PBias net3 NBias Vss sky130_fd_pr__nfet_01v8_lvt L=1 W=2 NF=1 AD=0.58 AS=0.58 PD=4.58 PS=4.58 NRD=0.145 NRS=0.145 SA=0 SB=0 SD=0 MULT=1
XM41 net3 NBias Vss Vss sky130_fd_pr__nfet_01v8_lvt L=2 W=5 NF=1 AD=1.45 AS=1.45 PD=10.58 PS=10.58 NRD=0.058 NRS=0.058 SA=0 SB=0 SD=0 MULT=2 M=2
XM42 net3 net3 Vdd Vdd sky130_fd_pr__pfet_01v8_lvt L=20 W=1 NF=1 AD=0.29 AS=0.29 PD=2.58 PS=2.58 NRD=0.29 NRS=0.29 SA=0 SB=0 SD=0 MULT=2 M=2
XM43 net4 PBias Vdd Vdd sky130_fd_pr__pfet_01v8_lvt L=1 W=5 NF=1 AD=1.45 AS=1.45 PD=10.58 PS=10.58 NRD=0.058 NRS=0.058 SA=0 SB=0 SD=0 MULT=2 M=2
XM44 net5 PBias Vdd Vdd sky130_fd_pr__pfet_01v8_lvt L=1 W=5 NF=1 AD=1.45 AS=1.45 PD=10.58 PS=10.58 NRD=0.058 NRS=0.058 SA=0 SB=0 SD=0 MULT=2 M=2
XM45 net6 PBias s1r_XM45_s Vdd sky130_fd_pr__pfet_01v8_lvt L=1 W=5 NF=1 AD=1.45 AS=1.45 PD=10.58 PS=10.58 NRD=0.058 NRS=0.058 SA=0 SB=0 SD=0 MULT=2 M=2
Rpar_s1_XM45_s s1r_XM45_s Vdd 0.304186
XM54 net7 PBias Vdd Vdd sky130_fd_pr__pfet_01v8_lvt L=1 W=5 NF=1 AD=1.45 AS=1.45 PD=10.58 PS=10.58 NRD=0.058 NRS=0.058 SA=0 SB=0 SD=0 MULT=2 M=2
XX1_M5 x1_Vtest2 Vm x1_net2 Vss sky130_fd_pr__nfet_01v8_lvt L=4 W=4 NF=1 AD=1.16 AS=1.16 PD=8.58 PS=8.58 NRD=0.0725 NRS=0.0725 SA=0 SB=0 SD=0 MULT=2 M=2
XX1_M6 x1_net1 Vp x1_net2 Vss sky130_fd_pr__nfet_01v8_lvt L=4 W=4 NF=1 AD=1.16 AS=1.16 PD=8.58 PS=8.58 NRD=0.0725 NRS=0.0725 SA=0 SB=0 SD=0 MULT=2 M=2
XX1_M11 Vop1 x1_Vbias x1_Vtest2 Vdd sky130_fd_pr__pfet_01v8_lvt L=5 W=2 NF=1 AD=0.58 AS=0.58 PD=4.58 PS=4.58 NRD=0.145 NRS=0.145 SA=0 SB=0 SD=0 MULT=2 M=2
XX1_M12 Vom1 x1_Vbias x1_net1 Vdd sky130_fd_pr__pfet_01v8_lvt L=5 W=2 NF=1 AD=0.58 AS=0.58 PD=4.58 PS=4.58 NRD=0.145 NRS=0.145 SA=0 SB=0 SD=0 MULT=2 M=2
XX1_M13 x1_Vtest2 x1_Vout Vdd Vdd sky130_fd_pr__pfet_01v8_lvt L=5 W=2 NF=1 AD=0.58 AS=0.58 PD=4.58 PS=4.58 NRD=0.145 NRS=0.145 SA=0 SB=0 SD=0 MULT=4 M=4
XX1_M14 x1_net1 x1_Vout Vdd Vdd sky130_fd_pr__pfet_01v8_lvt L=5 W=2 NF=1 AD=0.58 AS=0.58 PD=4.58 PS=4.58 NRD=0.145 NRS=0.145 SA=0 SB=0 SD=0 MULT=4 M=4
XX1_M19 x1_net2 net5 x1_net3 Vss sky130_fd_pr__nfet_01v8_lvt L=1 W=1 NF=1 AD=0.29 AS=0.29 PD=2.58 PS=2.58 NRD=0.29 NRS=0.29 SA=0 SB=0 SD=0 MULT=2 M=2
XX1_M1 x1_net3 net4 Vss Vss sky130_fd_pr__nfet_01v8_lvt L=10 W=1 NF=1 AD=0.29 AS=0.29 PD=2.58 PS=2.58 NRD=0.29 NRS=0.29 SA=0 SB=0 SD=0 MULT=2 M=2
XX1_M2 x1_net4 net4 Vss Vss sky130_fd_pr__nfet_01v8_lvt L=10 W=1 NF=1 AD=0.29 AS=0.29 PD=2.58 PS=2.58 NRD=0.29 NRS=0.29 SA=0 SB=0 SD=0 MULT=2 M=2
XX1_M3 x1_net2 net5 x1_net4 Vss sky130_fd_pr__nfet_01v8_lvt L=1 W=1 NF=1 AD=0.29 AS=0.29 PD=2.58 PS=2.58 NRD=0.29 NRS=0.29 SA=0 SB=0 SD=0 MULT=2 M=2
XX1_M4 Vop1 net5 x1_net5 Vss sky130_fd_pr__nfet_01v8_lvt L=1 W=1 NF=1 AD=0.29 AS=0.29 PD=2.58 PS=2.58 NRD=0.29 NRS=0.29 SA=0 SB=0 SD=0 MULT=2 M=2
XX1_M7 x1_net5 net4 Vss Vss sky130_fd_pr__nfet_01v8_lvt L=10 W=1 NF=1 AD=0.29 AS=0.29 PD=2.58 PS=2.58 NRD=0.29 NRS=0.29 SA=0 SB=0 SD=0 MULT=2 M=2
XX1_M8 Vom1 net5 x1_net6 Vss sky130_fd_pr__nfet_01v8_lvt L=1 W=1 NF=1 AD=0.29 AS=0.29 PD=2.58 PS=2.58 NRD=0.29 NRS=0.29 SA=0 SB=0 SD=0 MULT=2 M=2
XX1_M9 x1_net6 net4 Vss Vss sky130_fd_pr__nfet_01v8_lvt L=10 W=1 NF=1 AD=0.29 AS=0.29 PD=2.58 PS=2.58 NRD=0.29 NRS=0.29 SA=0 SB=0 SD=0 MULT=2 M=2
XX1_M10 x1_Vout Vref x1_net8 Vss sky130_fd_pr__nfet_01v8_lvt L=20 W=5 NF=1 AD=1.45 AS=1.45 PD=10.58 PS=10.58 NRD=0.058 NRS=0.058 SA=0 SB=0 SD=0 MULT=2 M=2
XX1_M17 x1_net9 Vop1 x1_net8 Vss sky130_fd_pr__nfet_01v8_lvt L=20 W=5 NF=1 AD=1.45 AS=1.45 PD=10.58 PS=10.58 NRD=0.058 NRS=0.058 SA=0 SB=0 SD=0 MULT=2 M=2
XX1_M18 x1_net9 Vom1 x1_net7 Vss sky130_fd_pr__nfet_01v8_lvt L=20 W=5 NF=1 AD=1.45 AS=1.45 PD=10.58 PS=10.58 NRD=0.058 NRS=0.058 SA=0 SB=0 SD=0 MULT=2 M=2
XX1_M22 x1_net7 net4 Vss Vss sky130_fd_pr__nfet_01v8_lvt L=20 W=1 NF=1 AD=0.29 AS=0.29 PD=2.58 PS=2.58 NRD=0.29 NRS=0.29 SA=0 SB=0 SD=0 MULT=2 M=2
XX1_M20 x1_net9 x1_net9 Vdd Vdd sky130_fd_pr__pfet_01v8_lvt L=10 W=1 NF=1 AD=0.29 AS=0.29 PD=2.58 PS=2.58 NRD=0.29 NRS=0.29 SA=0 SB=0 SD=0 MULT=2 M=2
XX1_M21 x1_Vout x1_net9 Vdd Vdd sky130_fd_pr__pfet_01v8_lvt L=10 W=1 NF=1 AD=0.29 AS=0.29 PD=2.58 PS=2.58 NRD=0.29 NRS=0.29 SA=0 SB=0 SD=0 MULT=2 M=2
XX1_M15 x1_net8 net4 Vss Vss sky130_fd_pr__nfet_01v8_lvt L=20 W=1 NF=1 AD=0.29 AS=0.29 PD=2.58 PS=2.58 NRD=0.29 NRS=0.29 SA=0 SB=0 SD=0 MULT=2 M=2
XX1_M16 x1_Vout Vref x1_net7 Vss sky130_fd_pr__nfet_01v8_lvt L=20 W=5 NF=1 AD=1.45 AS=1.45 PD=10.58 PS=10.58 NRD=0.058 NRS=0.058 SA=0 SB=0 SD=0 MULT=2 M=2
XX1_M46 net4 net4 Vss Vss sky130_fd_pr__nfet_01v8_lvt L=2 W=1 NF=1 AD=0.29 AS=0.29 PD=2.58 PS=2.58 NRD=0.29 NRS=0.29 SA=0 SB=0 SD=0 MULT=2 M=2
XX1_M47 net5 net5 Vss Vss sky130_fd_pr__nfet_01v8_lvt L=5 W=0.6 NF=1 AD=0.174 AS=0.174 PD=1.78 PS=1.78 NRD=0.483333 NRS=0.483333 SA=0 SB=0 SD=0 MULT=2 M=2
XX1_M23 s1r_XX1_M23_d net6 Vss Vss sky130_fd_pr__nfet_01v8_lvt L=1 W=0.6 NF=1 AD=0.174 AS=0.174 PD=1.78 PS=1.78 NRD=0.483333 NRS=0.483333 SA=0 SB=0 SD=0 MULT=2 M=2
Rpar_s1_XX1_M23_d s1r_XX1_M23_d net6 1004.3
XX1_M24 s1r_XX1_M24_d net6 Vss Vss sky130_fd_pr__nfet_01v8_lvt L=1 W=0.6 NF=1 AD=0.174 AS=0.174 PD=1.78 PS=1.78 NRD=0.483333 NRS=0.483333 SA=0 SB=0 SD=0 MULT=2 M=2
Rpar_s1_XX1_M24_d s1r_XX1_M24_d x1_Vbias 1004.3
XX1_M25 x1_Vbias x1_Vbias Vdd Vdd sky130_fd_pr__pfet_01v8_lvt L=10 W=1.5 NF=1 AD=0.435 AS=0.435 PD=3.58 PS=3.58 NRD=0.193333 NRS=0.193333 SA=0 SB=0 SD=0 MULT=2 M=2
XX2_M9 Vop Vom1 Vdd Vdd sky130_fd_pr__pfet_01v8_lvt L=1 W=2 NF=1 AD=0.58 AS=0.58 PD=4.58 PS=4.58 NRD=0.145 NRS=0.145 SA=0 SB=0 SD=0 MULT=9 M=9
XX2_M4 Vom Vop1 Vdd Vdd sky130_fd_pr__pfet_01v8_lvt L=1 W=2 NF=1 AD=0.58 AS=0.58 PD=4.58 PS=4.58 NRD=0.145 NRS=0.145 SA=0 SB=0 SD=0 MULT=9 M=9
XX2_M2 Vop x2_Vout Vss Vss sky130_fd_pr__nfet_01v8_lvt L=1 W=1 NF=1 AD=0.29 AS=0.29 PD=2.58 PS=2.58 NRD=0.29 NRS=0.29 SA=0 SB=0 SD=0 MULT=9 M=9
XX2_M1 Vom x2_Vout Vss Vss sky130_fd_pr__nfet_01v8_lvt L=1 W=1 NF=1 AD=0.29 AS=0.29 PD=2.58 PS=2.58 NRD=0.29 NRS=0.29 SA=0 SB=0 SD=0 MULT=9 M=9
XX2_M3 x2_net1 x2_Vbiasp Vdd Vdd sky130_fd_pr__pfet_01v8_lvt L=5 W=1 NF=1 AD=0.29 AS=0.29 PD=2.58 PS=2.58 NRD=0.29 NRS=0.29 SA=0 SB=0 SD=0 MULT=2 M=2
XX2_M7 x2_Vtest x2_Vcm x2_net1 Vdd sky130_fd_pr__pfet_01v8_lvt L=10 W=1 NF=1 AD=0.29 AS=0.29 PD=2.58 PS=2.58 NRD=0.29 NRS=0.29 SA=0 SB=0 SD=0 MULT=2 M=2
XX2_M8 x2_Vout Vref x2_net1 Vdd sky130_fd_pr__pfet_01v8_lvt L=10 W=1 NF=1 AD=0.29 AS=0.29 PD=2.58 PS=2.58 NRD=0.29 NRS=0.29 SA=0 SB=0 SD=0 MULT=2 M=2
XX2_M5 x2_Vtest x2_Vtest Vss Vss sky130_fd_pr__nfet_01v8_lvt L=20 W=0.5 NF=1 AD=0.145 AS=0.145 PD=1.58 PS=1.58 NRD=0.58 NRS=0.58 SA=0 SB=0 SD=0 MULT=2 M=2
XX2_M6 x2_Vout x2_Vtest Vss Vss sky130_fd_pr__nfet_01v8_lvt L=20 W=0.5 NF=1 AD=0.145 AS=0.145 PD=1.58 PS=1.58 NRD=0.58 NRS=0.58 SA=0 SB=0 SD=0 MULT=2 M=2
XX2_M10 net7 net7 Vss Vss sky130_fd_pr__nfet_01v8_lvt L=1 W=0.6 NF=1 AD=0.174 AS=0.174 PD=1.78 PS=1.78 NRD=0.483333 NRS=0.483333 SA=0 SB=0 SD=0 MULT=2 M=2
XX2_M11 x2_Vbiasp net7 Vss Vss sky130_fd_pr__nfet_01v8_lvt L=1 W=0.6 NF=1 AD=0.174 AS=0.174 PD=1.78 PS=1.78 NRD=0.483333 NRS=0.483333 SA=0 SB=0 SD=0 MULT=2 M=2
XX2_M12 x2_Vbiasp x2_Vbiasp Vdd Vdd sky130_fd_pr__pfet_01v8_lvt L=1 W=6 NF=1 AD=1.74 AS=1.74 PD=12.58 PS=12.58 NRD=0.0483333 NRS=0.0483333 SA=0 SB=0 SD=0 MULT=2 M=2
Vref_ext Vref Vss 0.9
XC1 Vop1 Vom sky130_fd_pr__cap_mim_m3_1 W=10 L=10 MF=5 M=5
XC2 Vom1 Vop sky130_fd_pr__cap_mim_m3_1 W=10 L=10 MF=5 M=5
XX2_X1_R1 x2_x1_net4 Vop sky130_fd_pr__res_generic_po W=0.5 L=40
XX2_X1_R2 x2_x1_net5 x2_x1_net4 sky130_fd_pr__res_generic_po W=0.5 L=40
XX2_X1_R3 x2_x1_net6 x2_x1_net5 sky130_fd_pr__res_generic_po W=0.5 L=40
XX2_X1_R4 x2_x1_net7 x2_x1_net6 sky130_fd_pr__res_generic_po W=0.5 L=40
XX2_X1_R5 x2_x1_net1 x2_x1_net7 sky130_fd_pr__res_generic_po W=0.5 L=40
XX2_X1_R6 x2_x1_net8 x2_x1_net2 sky130_fd_pr__res_generic_po W=0.5 L=40
XX2_X1_R7 x2_x1_net9 x2_x1_net8 sky130_fd_pr__res_generic_po W=0.5 L=40
XX2_X1_R8 x2_x1_net10 x2_x1_net9 sky130_fd_pr__res_generic_po W=0.5 L=40
XX2_X1_R9 x2_x1_net11 x2_x1_net10 sky130_fd_pr__res_generic_po W=0.5 L=40
XX2_X1_R10 x2_x1_net1 x2_x1_net11 sky130_fd_pr__res_generic_po W=0.5 L=40
XX2_X1_R11 x2_x1_net12 x2_x1_net2 sky130_fd_pr__res_generic_po W=0.5 L=40
XX2_X1_R12 x2_x1_net13 x2_x1_net12 sky130_fd_pr__res_generic_po W=0.5 L=40
XX2_X1_R13 x2_x1_net14 x2_x1_net13 sky130_fd_pr__res_generic_po W=0.5 L=40
XX2_X1_R14 x2_x1_net15 x2_x1_net14 sky130_fd_pr__res_generic_po W=0.5 L=40
XX2_X1_R16 x2_x1_net16 x2_Vcm sky130_fd_pr__res_generic_po W=0.5 L=40
XX2_X1_R17 x2_x1_net17 x2_x1_net16 sky130_fd_pr__res_generic_po W=0.5 L=40
XX2_X1_R18 x2_x1_net18 x2_x1_net17 sky130_fd_pr__res_generic_po W=0.5 L=40
XX2_X1_R19 x2_x1_net19 x2_x1_net18 sky130_fd_pr__res_generic_po W=0.5 L=40
XX2_X1_R20 x2_x1_net3 x2_x1_net19 sky130_fd_pr__res_generic_po W=0.5 L=40
XX2_X1_R15 x2_x1_net3 x2_x1_net15 sky130_fd_pr__res_generic_po W=0.5 L=40
XX2_X2_R1 x2_x2_net4 x2_Vcm sky130_fd_pr__res_generic_po W=0.5 L=40
XX2_X2_R2 x2_x2_net5 x2_x2_net4 sky130_fd_pr__res_generic_po W=0.5 L=40
XX2_X2_R3 x2_x2_net6 x2_x2_net5 sky130_fd_pr__res_generic_po W=0.5 L=40
XX2_X2_R4 x2_x2_net7 x2_x2_net6 sky130_fd_pr__res_generic_po W=0.5 L=40
XX2_X2_R5 x2_x2_net1 x2_x2_net7 sky130_fd_pr__res_generic_po W=0.5 L=40
XX2_X2_R6 x2_x2_net8 x2_x2_net2 sky130_fd_pr__res_generic_po W=0.5 L=40
XX2_X2_R7 x2_x2_net9 x2_x2_net8 sky130_fd_pr__res_generic_po W=0.5 L=40
XX2_X2_R8 x2_x2_net10 x2_x2_net9 sky130_fd_pr__res_generic_po W=0.5 L=40
XX2_X2_R9 x2_x2_net11 x2_x2_net10 sky130_fd_pr__res_generic_po W=0.5 L=40
XX2_X2_R10 x2_x2_net1 x2_x2_net11 sky130_fd_pr__res_generic_po W=0.5 L=40
XX2_X2_R11 x2_x2_net12 x2_x2_net2 sky130_fd_pr__res_generic_po W=0.5 L=40
XX2_X2_R12 x2_x2_net13 x2_x2_net12 sky130_fd_pr__res_generic_po W=0.5 L=40
XX2_X2_R13 x2_x2_net14 x2_x2_net13 sky130_fd_pr__res_generic_po W=0.5 L=40
XX2_X2_R14 x2_x2_net15 x2_x2_net14 sky130_fd_pr__res_generic_po W=0.5 L=40
XX2_X2_R16 x2_x2_net16 Vom sky130_fd_pr__res_generic_po W=0.5 L=40
XX2_X2_R17 x2_x2_net17 x2_x2_net16 sky130_fd_pr__res_generic_po W=0.5 L=40
XX2_X2_R18 x2_x2_net18 x2_x2_net17 sky130_fd_pr__res_generic_po W=0.5 L=40
XX2_X2_R19 x2_x2_net19 x2_x2_net18 sky130_fd_pr__res_generic_po W=0.5 L=40
XX2_X2_R20 x2_x2_net3 x2_x2_net19 sky130_fd_pr__res_generic_po W=0.5 L=40
XX2_X2_R15 x2_x2_net3 x2_x2_net15 sky130_fd_pr__res_generic_po W=0.5 L=40
Rgm_ext Rgm Vss 12000
.ends ttsky25a_fd
.end
