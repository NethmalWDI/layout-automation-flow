* ttsky25a_fd on dido_amp_AC
.lib $PDK_ROOT/sky130A/libs.tech/combined/sky130.lib.spice sf
.param VDD_V=1.62 VCM_V=0.9 CL_F=529f
.temp 27

**.subckt dido_amp_AC
x1 INP INN OUTN VDD 0 OUTP dut_amp
Vsup VDD 0 'VDD_V'
* AC drive through 1 F couplers; DC set by unity feedback through 1 GH chokes (OUTP->INN, OUTN->INP)
Vacp ACP 0 dc 0 ac 0.5
Vacn ACN 0 dc 0 ac -0.5
Cinp ACP INP 1
Cinn ACN INN 1
Lfbp OUTP INN 1G
Lfbn OUTN INP 1G
Cloadp OUTP 0 'CL_F'
Cloadn OUTN 0 'CL_F'
.control
  save all
  ac dec 40 1 1G
  let hsig = v(OUTP) - v(OUTN)
  let hdb = db(hsig)
  let gph_deg = 180/pi * cph(hsig)
  meas ac gain_db find hdb at=1
  meas ac gbw_hz  when hdb=0
  meas ac ph_dc   find gph_deg at=1
  meas ac ph_ugb  find gph_deg when hdb=0
  let gbw_mhz = gbw_hz / 1e6
  let pm_deg  = 180 + (ph_ugb - ph_dc)
  echo MEAS gain_db $&gain_db
  echo MEAS gbw_mhz $&gbw_mhz
  echo MEAS pm_deg $&pm_deg
  write
  quit 0
.endc
**.ends

.subckt dut_amp INP INN OUTN VDD VSS OUTP
XDUT OUTP INN VDD VSS OUTN INP ttsky25a_fd
.ends

.subckt ttsky25a_fd Vop Vm Vdd Vss Vom Vp
Cbud_s2_0 Vom Vss 0.262743f
Cbud_s2_1 Vom1 Vss 0.173904f
Cbud_s2_2 Vop Vss 0.262743f
Cbud_s2_3 Vop1 Vss 0.173904f
Cbud_s2_4 net5 Vss 127.843f
Cbud_s2_5 x1_Vtest2 Vss 0.0363141f
Cbud_s2_6 x1_net1 Vss 0.0363141f
Cbud_s2_7 x1_net5 Vss 13.9281f
Cbud_s2_8 x1_net6 Vss 13.9281f
Cbud_s2_9 x1_net7 Vss 0.886935f
Cbud_s2_10 x1_net8 Vss 0.886935f
Cbud_s2_11 x2_x1_net1 Vss 0.467098f
Cbud_s2_12 x2_x1_net10 Vss 0.621876f
Cbud_s2_13 x2_x1_net11 Vss 0.536209f
Cbud_s2_14 x2_x1_net12 Vss 1.29749f
Cbud_s2_15 x2_x1_net13 Vss 1.64214f
Cbud_s2_16 x2_x1_net14 Vss 2.14484f
Cbud_s2_17 x2_x1_net15 Vss 2.91936f
Cbud_s2_18 x2_x1_net16 Vss 40.5949f
Cbud_s2_19 x2_x1_net17 Vss 26.2743f
Cbud_s2_20 x2_x1_net18 Vss 11.6774f
Cbud_s2_21 x2_x1_net19 Vss 6.56856f
Cbud_s2_22 x2_x1_net2 Vss 1.05097f
Cbud_s2_23 x2_x1_net3 Vss 4.20388f
Cbud_s2_24 x2_x1_net4 Vss 0.291127f
Cbud_s2_25 x2_x1_net5 Vss 0.324373f
Cbud_s2_26 x2_x1_net6 Vss 0.363657f
Cbud_s2_27 x2_x1_net7 Vss 0.410535f
Cbud_s2_28 x2_x1_net8 Vss 0.86857f
Cbud_s2_29 x2_x1_net9 Vss 0.72984f
Cbud_s2_30 x2_x2_net1 Vss 4.20388f
Cbud_s2_31 x2_x2_net10 Vss 2.14484f
Cbud_s2_32 x2_x2_net11 Vss 2.91936f
Cbud_s2_33 x2_x2_net12 Vss 0.86857f
Cbud_s2_34 x2_x2_net13 Vss 0.72984f
Cbud_s2_35 x2_x2_net14 Vss 0.621876f
Cbud_s2_36 x2_x2_net15 Vss 0.536209f
Cbud_s2_37 x2_x2_net16 Vss 0.291127f
Cbud_s2_38 x2_x2_net17 Vss 0.324373f
Cbud_s2_39 x2_x2_net18 Vss 0.363657f
Cbud_s2_40 x2_x2_net19 Vss 0.410535f
Cbud_s2_41 x2_x2_net2 Vss 1.05097f
Cbud_s2_42 x2_x2_net3 Vss 0.467098f
Cbud_s2_43 x2_x2_net4 Vss 40.5949f
Cbud_s2_44 x2_x2_net5 Vss 26.2743f
Cbud_s2_45 x2_x2_net6 Vss 11.6774f
Cbud_s2_46 x2_x2_net7 Vss 6.56856f
Cbud_s2_47 x2_x2_net8 Vss 1.29749f
Cbud_s2_48 x2_x2_net9 Vss 1.64214f
Cbud_s2_49 NBias Vom 0.262743f
Cbud_s2_50 NBias Vom1 0.173904f
Cbud_s2_51 NBias Vop 0.262743f
Cbud_s2_52 NBias Vop1 0.173904f
Cbud_s2_53 NBias x1_Vtest2 0.0363148f
Cbud_s2_54 NBias x1_net1 0.0363148f
Cbud_s2_55 NBias x1_net5 1.75295f
Cbud_s2_56 NBias x1_net6 1.75295f
Cbud_s2_57 NBias x1_net7 0.886935f
Cbud_s2_58 NBias x1_net8 0.886935f
Cbud_s2_59 NBias x2_x1_net1 0.467099f
Cbud_s2_60 NBias x2_x1_net10 0.621877f
Cbud_s2_61 NBias x2_x1_net11 0.53621f
Cbud_s2_62 NBias x2_x1_net12 1.2975f
Cbud_s2_63 NBias x2_x1_net13 1.64214f
Cbud_s2_64 NBias x2_x1_net14 2.14484f
Cbud_s2_65 NBias x2_x1_net15 2.91937f
Cbud_s2_66 NBias x2_x1_net16 6.40893f
Cbud_s2_67 NBias x2_x1_net17 6.40893f
Cbud_s2_68 NBias x2_x1_net18 6.40893f
Cbud_s2_69 NBias x2_x1_net19 6.40893f
Cbud_s2_70 NBias x2_x1_net2 1.05097f
Cbud_s2_71 NBias x2_x1_net3 4.20389f
Cbud_s2_72 NBias x2_x1_net4 0.291128f
Cbud_s2_73 NBias x2_x1_net5 0.324374f
Cbud_s2_74 NBias x2_x1_net6 0.363658f
Cbud_s2_75 NBias x2_x1_net7 0.410536f
Cbud_s2_76 NBias x2_x1_net8 0.868572f
Cbud_s2_77 NBias x2_x1_net9 0.729842f
Cbud_s2_78 NBias x2_x2_net1 4.20389f
Cbud_s2_79 NBias x2_x2_net10 2.14484f
Cbud_s2_80 NBias x2_x2_net11 2.91937f
Cbud_s2_81 NBias x2_x2_net12 0.868572f
Cbud_s2_82 NBias x2_x2_net13 0.729842f
Cbud_s2_83 NBias x2_x2_net14 0.621877f
Cbud_s2_84 NBias x2_x2_net15 0.53621f
Cbud_s2_85 NBias x2_x2_net16 0.291128f
Cbud_s2_86 NBias x2_x2_net17 0.324374f
Cbud_s2_87 NBias x2_x2_net18 0.363658f
Cbud_s2_88 NBias x2_x2_net19 0.410536f
Cbud_s2_89 NBias x2_x2_net2 1.05097f
Cbud_s2_90 NBias x2_x2_net3 0.467099f
Cbud_s2_91 NBias x2_x2_net4 6.40893f
Cbud_s2_92 NBias x2_x2_net5 6.40893f
Cbud_s2_93 NBias x2_x2_net6 6.40893f
Cbud_s2_94 NBias x2_x2_net7 6.40893f
Cbud_s2_95 NBias x2_x2_net8 1.2975f
Cbud_s2_96 NBias x2_x2_net9 1.64214f
Cbud_s2_97 PBias Vom 0.262742f
Cbud_s2_98 PBias Vom1 0.173904f
Cbud_s2_99 PBias Vop 0.262742f
Cbud_s2_100 PBias Vop1 0.173904f
Cbud_s2_101 PBias net6 8.10735f
Cbud_s2_102 PBias x1_Vtest2 0.0363141f
Cbud_s2_103 PBias x1_net1 0.0363141f
Cbud_s2_104 PBias x1_net5 1.75295f
Cbud_s2_105 PBias x1_net6 1.75295f
Cbud_s2_106 PBias x1_net7 0.886935f
Cbud_s2_107 PBias x1_net8 0.886935f
Cbud_s2_108 PBias x2_x1_net1 0.467097f
Cbud_s2_109 PBias x2_x1_net10 0.621875f
Cbud_s2_110 PBias x2_x1_net11 0.536208f
Cbud_s2_111 PBias x2_x1_net12 1.29749f
Cbud_s2_112 PBias x2_x1_net13 1.64214f
Cbud_s2_113 PBias x2_x1_net14 2.14483f
Cbud_s2_114 PBias x2_x1_net15 2.91936f
Cbud_s2_115 PBias x2_x1_net16 6.75515f
Cbud_s2_116 PBias x2_x1_net17 6.75515f
Cbud_s2_117 PBias x2_x1_net18 6.75515f
Cbud_s2_118 PBias x2_x1_net19 6.56856f
Cbud_s2_119 PBias x2_x1_net2 1.05097f
Cbud_s2_120 PBias x2_x1_net3 4.20388f
Cbud_s2_121 PBias x2_x1_net4 0.291127f
Cbud_s2_122 PBias x2_x1_net5 0.324373f
Cbud_s2_123 PBias x2_x1_net6 0.363657f
Cbud_s2_124 PBias x2_x1_net7 0.410535f
Cbud_s2_125 PBias x2_x1_net8 0.868569f
Cbud_s2_126 PBias x2_x1_net9 0.729839f
Cbud_s2_127 PBias x2_x2_net1 4.20388f
Cbud_s2_128 PBias x2_x2_net10 2.14483f
Cbud_s2_129 PBias x2_x2_net11 2.91936f
Cbud_s2_130 PBias x2_x2_net12 0.868569f
Cbud_s2_131 PBias x2_x2_net13 0.729839f
Cbud_s2_132 PBias x2_x2_net14 0.621875f
Cbud_s2_133 PBias x2_x2_net15 0.536208f
Cbud_s2_134 PBias x2_x2_net16 0.291127f
Cbud_s2_135 PBias x2_x2_net17 0.324373f
Cbud_s2_136 PBias x2_x2_net18 0.363657f
Cbud_s2_137 PBias x2_x2_net19 0.410535f
Cbud_s2_138 PBias x2_x2_net2 1.05097f
Cbud_s2_139 PBias x2_x2_net3 0.467097f
Cbud_s2_140 PBias x2_x2_net4 6.75515f
Cbud_s2_141 PBias x2_x2_net5 6.75515f
Cbud_s2_142 PBias x2_x2_net6 6.75515f
Cbud_s2_143 PBias x2_x2_net7 6.56856f
Cbud_s2_144 PBias x2_x2_net8 1.29749f
Cbud_s2_145 PBias x2_x2_net9 1.64214f
Cbud_s2_146 Rgm Vom 0.262742f
Cbud_s2_147 Rgm Vom1 0.173904f
Cbud_s2_148 Rgm Vop 0.262742f
Cbud_s2_149 Rgm Vop1 0.173904f
Cbud_s2_150 Rgm x1_Vtest2 0.036314f
Cbud_s2_151 Rgm x1_net1 0.036314f
Cbud_s2_152 Rgm x1_net4 1.75295f
Cbud_s2_153 Rgm x1_net5 1.75295f
Cbud_s2_154 Rgm x1_net6 1.75295f
Cbud_s2_155 Rgm x1_net7 0.886935f
Cbud_s2_156 Rgm x1_net8 0.886935f
Cbud_s2_157 Rgm x1_net9 1.8284f
Cbud_s2_158 Rgm x2_x1_net1 0.467098f
Cbud_s2_159 Rgm x2_x1_net10 0.621876f
Cbud_s2_160 Rgm x2_x1_net11 0.536209f
Cbud_s2_161 Rgm x2_x1_net12 1.29749f
Cbud_s2_162 Rgm x2_x1_net13 1.64214f
Cbud_s2_163 Rgm x2_x1_net14 1.8284f
Cbud_s2_164 Rgm x2_x1_net15 1.8284f
Cbud_s2_165 Rgm x2_x1_net16 1.8284f
Cbud_s2_166 Rgm x2_x1_net17 1.8284f
Cbud_s2_167 Rgm x2_x1_net18 1.8284f
Cbud_s2_168 Rgm x2_x1_net19 1.8284f
Cbud_s2_169 Rgm x2_x1_net2 1.05097f
Cbud_s2_170 Rgm x2_x1_net3 1.8284f
Cbud_s2_171 Rgm x2_x1_net4 0.291127f
Cbud_s2_172 Rgm x2_x1_net5 0.324373f
Cbud_s2_173 Rgm x2_x1_net6 0.363657f
Cbud_s2_174 Rgm x2_x1_net7 0.410535f
Cbud_s2_175 Rgm x2_x1_net8 0.86857f
Cbud_s2_176 Rgm x2_x1_net9 0.72984f
Cbud_s2_177 Rgm x2_x2_net1 1.8284f
Cbud_s2_178 Rgm x2_x2_net10 1.8284f
Cbud_s2_179 Rgm x2_x2_net11 1.8284f
Cbud_s2_180 Rgm x2_x2_net12 0.86857f
Cbud_s2_181 Rgm x2_x2_net13 0.72984f
Cbud_s2_182 Rgm x2_x2_net14 0.621876f
Cbud_s2_183 Rgm x2_x2_net15 0.536209f
Cbud_s2_184 Rgm x2_x2_net16 0.291127f
Cbud_s2_185 Rgm x2_x2_net17 0.324373f
Cbud_s2_186 Rgm x2_x2_net18 0.363657f
Cbud_s2_187 Rgm x2_x2_net19 0.410535f
Cbud_s2_188 Rgm x2_x2_net2 1.05097f
Cbud_s2_189 Rgm x2_x2_net3 0.467098f
Cbud_s2_190 Rgm x2_x2_net4 1.8284f
Cbud_s2_191 Rgm x2_x2_net5 1.8284f
Cbud_s2_192 Rgm x2_x2_net6 1.8284f
Cbud_s2_193 Rgm x2_x2_net7 1.8284f
Cbud_s2_194 Rgm x2_x2_net8 1.29749f
Cbud_s2_195 Rgm x2_x2_net9 1.64214f
Cbud_s2_196 Vom Vop 0.0656856f
Cbud_s2_197 Vom Vop1 0.0210274f
Cbud_s2_198 Vom net1 0.262743f
Cbud_s2_199 Vom net2 0.262742f
Cbud_s2_200 Vom net3 0.262743f
Cbud_s2_201 Vom net4 0.262742f
Cbud_s2_202 Vom net5 0.262743f
Cbud_s2_203 Vom net6 0.262743f
Cbud_s2_204 Vom net7 0.262743f
Cbud_s2_205 Vom x1_Vbias 0.262743f
Cbud_s2_206 Vom x1_Vout 0.262742f
Cbud_s2_207 Vom x1_Vtest2 0.0234772f
Cbud_s2_208 Vom x1_net2 0.262742f
Cbud_s2_209 Vom x1_net3 0.262742f
Cbud_s2_210 Vom x1_net4 0.262742f
Cbud_s2_211 Vom x1_net5 0.0236347f
Cbud_s2_212 Vom x1_net8 0.0405285f
Cbud_s2_213 Vom x1_net9 0.262743f
Cbud_s2_214 Vom x2_Vbiasp 0.262743f
Cbud_s2_215 Vom x2_Vcm 0.262743f
Cbud_s2_216 Vom x2_Vout 0.263643f
Cbud_s2_217 Vom x2_Vtest 0.2628f
Cbud_s2_218 Vom x2_net1 0.262811f
Cbud_s2_219 Vom x2_x1_net1 0.0857935f
Cbud_s2_220 Vom x2_x1_net10 0.0965078f
Cbud_s2_221 Vom x2_x1_net11 0.0909144f
Cbud_s2_222 Vom x2_x1_net12 0.124967f
Cbud_s2_223 Vom x2_x1_net13 0.134052f
Cbud_s2_224 Vom x2_x1_net14 0.144166f
Cbud_s2_225 Vom x2_x1_net15 0.155469f
Cbud_s2_226 Vom x2_x1_net16 0.238315f
Cbud_s2_227 Vom x2_x1_net17 0.217143f
Cbud_s2_228 Vom x2_x1_net18 0.198671f
Cbud_s2_229 Vom x2_x1_net19 0.18246f
Cbud_s2_230 Vom x2_x1_net2 0.116774f
Cbud_s2_231 Vom x2_x1_net3 0.168155f
Cbud_s2_232 Vom x2_x1_net4 0.0690973f
Cbud_s2_233 Vom x2_x1_net5 0.0727819f
Cbud_s2_234 Vom x2_x1_net6 0.0767692f
Cbud_s2_235 Vom x2_x1_net7 0.0810934f
Cbud_s2_236 Vom x2_x1_net8 0.109362f
Cbud_s2_237 Vom x2_x1_net9 0.102634f
Cbud_s2_238 Vom x2_x2_net1 0.467098f
Cbud_s2_239 Vom x2_x2_net10 0.621876f
Cbud_s2_240 Vom x2_x2_net11 0.536209f
Cbud_s2_241 Vom x2_x2_net12 1.29749f
Cbud_s2_242 Vom x2_x2_net13 1.64214f
Cbud_s2_243 Vom x2_x2_net14 2.14484f
Cbud_s2_244 Vom x2_x2_net15 2.91936f
Cbud_s2_245 Vom x2_x2_net16 6.75515f
Cbud_s2_246 Vom x2_x2_net17 6.75515f
Cbud_s2_247 Vom x2_x2_net18 6.75515f
Cbud_s2_248 Vom x2_x2_net19 6.56856f
Cbud_s2_249 Vom x2_x2_net2 1.05097f
Cbud_s2_250 Vom x2_x2_net3 4.20388f
Cbud_s2_251 Vom x2_x2_net4 0.291128f
Cbud_s2_252 Vom x2_x2_net5 0.324374f
Cbud_s2_253 Vom x2_x2_net6 0.363658f
Cbud_s2_254 Vom x2_x2_net7 0.410535f
Cbud_s2_255 Vom x2_x2_net8 0.86857f
Cbud_s2_256 Vom x2_x2_net9 0.72984f
Cbud_s2_257 Vom Vm 0.141927f
Cbud_s2_258 Vom1 Vop 0.0210274f
Cbud_s2_259 Vom1 Vop1 0.043476f
Cbud_s2_260 Vom1 net1 0.173904f
Cbud_s2_261 Vom1 net2 0.173904f
Cbud_s2_262 Vom1 net3 0.173904f
Cbud_s2_263 Vom1 net4 0.173904f
Cbud_s2_264 Vom1 net5 0.173904f
Cbud_s2_265 Vom1 net6 0.173904f
Cbud_s2_266 Vom1 net7 0.173904f
Cbud_s2_267 Vom1 x1_Vbias 0.173904f
Cbud_s2_268 Vom1 x1_Vout 0.173904f
Cbud_s2_269 Vom1 x1_Vtest2 0.0164987f
Cbud_s2_270 Vom1 x1_net1 0.0805226f
Cbud_s2_271 Vom1 x1_net2 0.173904f
Cbud_s2_272 Vom1 x1_net3 0.173904f
Cbud_s2_273 Vom1 x1_net4 0.173904f
Cbud_s2_274 Vom1 x1_net5 0.085669f
Cbud_s2_275 Vom1 x1_net7 0.356108f
Cbud_s2_276 Vom1 x1_net8 0.105915f
Cbud_s2_277 Vom1 x1_net9 0.173906f
Cbud_s2_278 Vom1 x2_Vbiasp 0.173904f
Cbud_s2_279 Vom1 x2_Vcm 0.173904f
Cbud_s2_280 Vom1 x2_Vout 0.173921f
Cbud_s2_281 Vom1 x2_Vtest 0.173937f
Cbud_s2_282 Vom1 x2_net1 0.173905f
Cbud_s2_283 Vom1 x2_x1_net1 0.0270513f
Cbud_s2_284 Vom1 x2_x1_net10 0.0305283f
Cbud_s2_285 Vom1 x2_x1_net11 0.0286864f
Cbud_s2_286 Vom1 x2_x1_net12 0.0410166f
Cbud_s2_287 Vom1 x2_x1_net13 0.0448519f
Cbud_s2_288 Vom1 x2_x1_net14 0.0494694f
Cbud_s2_289 Vom1 x2_x1_net15 0.0551356f
Cbud_s2_290 Vom1 x2_x1_net16 0.128114f
Cbud_s2_291 Vom1 x2_x1_net17 0.101374f
Cbud_s2_292 Vom1 x2_x1_net18 0.0838429f
Cbud_s2_293 Vom1 x2_x1_net19 0.0714623f
Cbud_s2_294 Vom1 x2_x1_net2 0.0377802f
Cbud_s2_295 Vom1 x2_x1_net3 0.0622533f
Cbud_s2_296 Vom1 x2_x1_net4 0.0220111f
Cbud_s2_297 Vom1 x2_x1_net5 0.0230895f
Cbud_s2_298 Vom1 x2_x1_net6 0.0242767f
Cbud_s2_299 Vom1 x2_x1_net7 0.0255902f
Cbud_s2_300 Vom1 x2_x1_net8 0.0350127f
Cbud_s2_301 Vom1 x2_x1_net9 0.032619f
Cbud_s2_302 Vom1 x2_x2_net4 0.270361f
Cbud_s2_303 Vom1 x2_x2_net5 0.326817f
Cbud_s2_304 Vom1 Vm 0.0814794f
Cbud_s2_305 Vop net1 0.262743f
Cbud_s2_306 Vop net2 0.262742f
Cbud_s2_307 Vop net3 0.262743f
Cbud_s2_308 Vop net4 0.262742f
Cbud_s2_309 Vop net5 0.262743f
Cbud_s2_310 Vop net6 0.262743f
Cbud_s2_311 Vop net7 0.262743f
Cbud_s2_312 Vop x1_Vbias 0.262743f
Cbud_s2_313 Vop x1_Vout 0.262742f
Cbud_s2_314 Vop x1_net1 0.0234772f
Cbud_s2_315 Vop x1_net2 0.262742f
Cbud_s2_316 Vop x1_net3 0.262742f
Cbud_s2_317 Vop x1_net4 0.262742f
Cbud_s2_318 Vop x1_net6 0.0236347f
Cbud_s2_319 Vop x1_net7 0.0405285f
Cbud_s2_320 Vop x1_net9 0.262743f
Cbud_s2_321 Vop x2_Vbiasp 0.262743f
Cbud_s2_322 Vop x2_Vcm 0.262743f
Cbud_s2_323 Vop x2_Vout 0.263643f
Cbud_s2_324 Vop x2_Vtest 0.2628f
Cbud_s2_325 Vop x2_net1 0.262811f
Cbud_s2_326 Vop x2_x1_net1 4.20388f
Cbud_s2_327 Vop x2_x1_net10 2.14484f
Cbud_s2_328 Vop x2_x1_net11 2.91936f
Cbud_s2_329 Vop x2_x1_net12 0.86857f
Cbud_s2_330 Vop x2_x1_net13 0.72984f
Cbud_s2_331 Vop x2_x1_net14 0.621876f
Cbud_s2_332 Vop x2_x1_net15 0.536209f
Cbud_s2_333 Vop x2_x1_net16 0.291128f
Cbud_s2_334 Vop x2_x1_net17 0.324374f
Cbud_s2_335 Vop x2_x1_net18 0.363658f
Cbud_s2_336 Vop x2_x1_net19 0.410535f
Cbud_s2_337 Vop x2_x1_net2 1.05097f
Cbud_s2_338 Vop x2_x1_net3 0.467098f
Cbud_s2_339 Vop x2_x1_net4 6.75515f
Cbud_s2_340 Vop x2_x1_net5 6.75515f
Cbud_s2_341 Vop x2_x1_net6 6.75515f
Cbud_s2_342 Vop x2_x1_net7 6.56856f
Cbud_s2_343 Vop x2_x1_net8 1.29749f
Cbud_s2_344 Vop x2_x1_net9 1.64214f
Cbud_s2_345 Vop x2_x2_net1 0.168155f
Cbud_s2_346 Vop x2_x2_net10 0.144166f
Cbud_s2_347 Vop x2_x2_net11 0.155469f
Cbud_s2_348 Vop x2_x2_net12 0.109362f
Cbud_s2_349 Vop x2_x2_net13 0.102634f
Cbud_s2_350 Vop x2_x2_net14 0.0965078f
Cbud_s2_351 Vop x2_x2_net15 0.0909144f
Cbud_s2_352 Vop x2_x2_net16 0.0690973f
Cbud_s2_353 Vop x2_x2_net17 0.0727819f
Cbud_s2_354 Vop x2_x2_net18 0.0767692f
Cbud_s2_355 Vop x2_x2_net19 0.0810934f
Cbud_s2_356 Vop x2_x2_net2 0.116774f
Cbud_s2_357 Vop x2_x2_net3 0.0857935f
Cbud_s2_358 Vop x2_x2_net4 0.238315f
Cbud_s2_359 Vop x2_x2_net5 0.217143f
Cbud_s2_360 Vop x2_x2_net6 0.198671f
Cbud_s2_361 Vop x2_x2_net7 0.18246f
Cbud_s2_362 Vop x2_x2_net8 0.124967f
Cbud_s2_363 Vop x2_x2_net9 0.134052f
Cbud_s2_364 Vop Vp 0.141927f
Cbud_s2_365 Vop1 net1 0.173904f
Cbud_s2_366 Vop1 net2 0.173904f
Cbud_s2_367 Vop1 net3 0.173904f
Cbud_s2_368 Vop1 net4 0.173904f
Cbud_s2_369 Vop1 net5 0.173904f
Cbud_s2_370 Vop1 net6 0.173904f
Cbud_s2_371 Vop1 net7 0.173904f
Cbud_s2_372 Vop1 x1_Vbias 0.173904f
Cbud_s2_373 Vop1 x1_Vout 0.173904f
Cbud_s2_374 Vop1 x1_Vtest2 0.0805226f
Cbud_s2_375 Vop1 x1_net1 0.0164987f
Cbud_s2_376 Vop1 x1_net2 0.173904f
Cbud_s2_377 Vop1 x1_net3 0.173904f
Cbud_s2_378 Vop1 x1_net4 0.173904f
Cbud_s2_379 Vop1 x1_net6 0.085669f
Cbud_s2_380 Vop1 x1_net7 0.105915f
Cbud_s2_381 Vop1 x1_net8 0.356108f
Cbud_s2_382 Vop1 x1_net9 0.173906f
Cbud_s2_383 Vop1 x2_Vbiasp 0.173904f
Cbud_s2_384 Vop1 x2_Vcm 0.173904f
Cbud_s2_385 Vop1 x2_Vout 0.173921f
Cbud_s2_386 Vop1 x2_Vtest 0.173937f
Cbud_s2_387 Vop1 x2_net1 0.173905f
Cbud_s2_388 Vop1 x2_x1_net16 0.270361f
Cbud_s2_389 Vop1 x2_x1_net17 0.326817f
Cbud_s2_390 Vop1 x2_x2_net1 0.0622533f
Cbud_s2_391 Vop1 x2_x2_net10 0.0494694f
Cbud_s2_392 Vop1 x2_x2_net11 0.0551356f
Cbud_s2_393 Vop1 x2_x2_net12 0.0350127f
Cbud_s2_394 Vop1 x2_x2_net13 0.032619f
Cbud_s2_395 Vop1 x2_x2_net14 0.0305283f
Cbud_s2_396 Vop1 x2_x2_net15 0.0286864f
Cbud_s2_397 Vop1 x2_x2_net16 0.0220111f
Cbud_s2_398 Vop1 x2_x2_net17 0.0230895f
Cbud_s2_399 Vop1 x2_x2_net18 0.0242767f
Cbud_s2_400 Vop1 x2_x2_net19 0.0255902f
Cbud_s2_401 Vop1 x2_x2_net2 0.0377802f
Cbud_s2_402 Vop1 x2_x2_net3 0.0270513f
Cbud_s2_403 Vop1 x2_x2_net4 0.128114f
Cbud_s2_404 Vop1 x2_x2_net5 0.101374f
Cbud_s2_405 Vop1 x2_x2_net6 0.0838429f
Cbud_s2_406 Vop1 x2_x2_net7 0.0714623f
Cbud_s2_407 Vop1 x2_x2_net8 0.0410166f
Cbud_s2_408 Vop1 x2_x2_net9 0.0448519f
Cbud_s2_409 Vop1 Vp 0.0814794f
Cbud_s2_410 net1 net5 4.95777f
Cbud_s2_411 net1 x1_Vtest2 0.0363144f
Cbud_s2_412 net1 x1_net1 0.0363144f
Cbud_s2_413 net1 x1_net5 1.75295f
Cbud_s2_414 net1 x1_net6 1.75295f
Cbud_s2_415 net1 x1_net7 0.886935f
Cbud_s2_416 net1 x1_net8 0.886935f
Cbud_s2_417 net1 x1_net9 6.00207f
Cbud_s2_418 net1 x2_x1_net1 0.467098f
Cbud_s2_419 net1 x2_x1_net10 0.621876f
Cbud_s2_420 net1 x2_x1_net11 0.536209f
Cbud_s2_421 net1 x2_x1_net12 1.29749f
Cbud_s2_422 net1 x2_x1_net13 1.64214f
Cbud_s2_423 net1 x2_x1_net14 2.14484f
Cbud_s2_424 net1 x2_x1_net15 2.91936f
Cbud_s2_425 net1 x2_x1_net16 6.00207f
Cbud_s2_426 net1 x2_x1_net17 6.00207f
Cbud_s2_427 net1 x2_x1_net18 6.00207f
Cbud_s2_428 net1 x2_x1_net19 6.00207f
Cbud_s2_429 net1 x2_x1_net2 1.05097f
Cbud_s2_430 net1 x2_x1_net3 4.20388f
Cbud_s2_431 net1 x2_x1_net4 0.291128f
Cbud_s2_432 net1 x2_x1_net5 0.324374f
Cbud_s2_433 net1 x2_x1_net6 0.363658f
Cbud_s2_434 net1 x2_x1_net7 0.410535f
Cbud_s2_435 net1 x2_x1_net8 0.868571f
Cbud_s2_436 net1 x2_x1_net9 0.729841f
Cbud_s2_437 net1 x2_x2_net1 4.20388f
Cbud_s2_438 net1 x2_x2_net10 2.14484f
Cbud_s2_439 net1 x2_x2_net11 2.91936f
Cbud_s2_440 net1 x2_x2_net12 0.868571f
Cbud_s2_441 net1 x2_x2_net13 0.729841f
Cbud_s2_442 net1 x2_x2_net14 0.621876f
Cbud_s2_443 net1 x2_x2_net15 0.536209f
Cbud_s2_444 net1 x2_x2_net16 0.291128f
Cbud_s2_445 net1 x2_x2_net17 0.324374f
Cbud_s2_446 net1 x2_x2_net18 0.363658f
Cbud_s2_447 net1 x2_x2_net19 0.410535f
Cbud_s2_448 net1 x2_x2_net2 1.05097f
Cbud_s2_449 net1 x2_x2_net3 0.467098f
Cbud_s2_450 net1 x2_x2_net4 6.00207f
Cbud_s2_451 net1 x2_x2_net5 6.00207f
Cbud_s2_452 net1 x2_x2_net6 6.00207f
Cbud_s2_453 net1 x2_x2_net7 6.00207f
Cbud_s2_454 net1 x2_x2_net8 1.29749f
Cbud_s2_455 net1 x2_x2_net9 1.64214f
Cbud_s2_456 net1 Vp 1.19379f
Cbud_s2_457 net2 net4 4.64822f
Cbud_s2_458 net2 x1_Vtest2 0.0363146f
Cbud_s2_459 net2 x1_net1 0.0363146f
Cbud_s2_460 net2 x1_net5 1.75295f
Cbud_s2_461 net2 x1_net6 1.75295f
Cbud_s2_462 net2 x1_net7 0.886935f
Cbud_s2_463 net2 x1_net8 0.886935f
Cbud_s2_464 net2 x2_x1_net1 0.467097f
Cbud_s2_465 net2 x2_x1_net10 0.621874f
Cbud_s2_466 net2 x2_x1_net11 0.536208f
Cbud_s2_467 net2 x2_x1_net12 1.29749f
Cbud_s2_468 net2 x2_x1_net13 1.64214f
Cbud_s2_469 net2 x2_x1_net14 2.14483f
Cbud_s2_470 net2 x2_x1_net15 2.91935f
Cbud_s2_471 net2 x2_x1_net16 4.64822f
Cbud_s2_472 net2 x2_x1_net17 4.64822f
Cbud_s2_473 net2 x2_x1_net18 4.64822f
Cbud_s2_474 net2 x2_x1_net19 4.64822f
Cbud_s2_475 net2 x2_x1_net2 1.05097f
Cbud_s2_476 net2 x2_x1_net3 4.20387f
Cbud_s2_477 net2 x2_x1_net4 0.291127f
Cbud_s2_478 net2 x2_x1_net5 0.324373f
Cbud_s2_479 net2 x2_x1_net6 0.363657f
Cbud_s2_480 net2 x2_x1_net7 0.410534f
Cbud_s2_481 net2 x2_x1_net8 0.868568f
Cbud_s2_482 net2 x2_x1_net9 0.729839f
Cbud_s2_483 net2 x2_x2_net1 4.20387f
Cbud_s2_484 net2 x2_x2_net10 2.14483f
Cbud_s2_485 net2 x2_x2_net11 2.91935f
Cbud_s2_486 net2 x2_x2_net12 0.868568f
Cbud_s2_487 net2 x2_x2_net13 0.729839f
Cbud_s2_488 net2 x2_x2_net14 0.621874f
Cbud_s2_489 net2 x2_x2_net15 0.536208f
Cbud_s2_490 net2 x2_x2_net16 0.291127f
Cbud_s2_491 net2 x2_x2_net17 0.324373f
Cbud_s2_492 net2 x2_x2_net18 0.363657f
Cbud_s2_493 net2 x2_x2_net19 0.410534f
Cbud_s2_494 net2 x2_x2_net2 1.05097f
Cbud_s2_495 net2 x2_x2_net3 0.467097f
Cbud_s2_496 net2 x2_x2_net4 4.64822f
Cbud_s2_497 net2 x2_x2_net5 4.64822f
Cbud_s2_498 net2 x2_x2_net6 4.64822f
Cbud_s2_499 net2 x2_x2_net7 4.64822f
Cbud_s2_500 net2 x2_x2_net8 1.29749f
Cbud_s2_501 net2 x2_x2_net9 1.64214f
Cbud_s2_502 net3 net7 2.65975f
Cbud_s2_503 net3 x1_Vtest2 0.0363144f
Cbud_s2_504 net3 x1_net1 0.0363144f
Cbud_s2_505 net3 x1_net5 1.75295f
Cbud_s2_506 net3 x1_net6 1.75295f
Cbud_s2_507 net3 x1_net7 0.886936f
Cbud_s2_508 net3 x1_net8 0.886936f
Cbud_s2_509 net3 x2_x1_net1 0.467099f
Cbud_s2_510 net3 x2_x1_net10 0.621878f
Cbud_s2_511 net3 x2_x1_net11 0.536211f
Cbud_s2_512 net3 x2_x1_net12 1.2975f
Cbud_s2_513 net3 x2_x1_net13 1.64215f
Cbud_s2_514 net3 x2_x1_net14 2.14484f
Cbud_s2_515 net3 x2_x1_net15 2.91937f
Cbud_s2_516 net3 x2_x1_net16 5.53033f
Cbud_s2_517 net3 x2_x1_net17 5.53033f
Cbud_s2_518 net3 x2_x1_net18 5.53033f
Cbud_s2_519 net3 x2_x1_net19 5.53033f
Cbud_s2_520 net3 x2_x1_net2 1.05097f
Cbud_s2_521 net3 x2_x1_net3 4.2039f
Cbud_s2_522 net3 x2_x1_net4 0.291128f
Cbud_s2_523 net3 x2_x1_net5 0.324374f
Cbud_s2_524 net3 x2_x1_net6 0.363658f
Cbud_s2_525 net3 x2_x1_net7 0.410536f
Cbud_s2_526 net3 x2_x1_net8 0.868573f
Cbud_s2_527 net3 x2_x1_net9 0.729843f
Cbud_s2_528 net3 x2_x2_net1 4.2039f
Cbud_s2_529 net3 x2_x2_net10 2.14484f
Cbud_s2_530 net3 x2_x2_net11 2.91937f
Cbud_s2_531 net3 x2_x2_net12 0.868573f
Cbud_s2_532 net3 x2_x2_net13 0.729843f
Cbud_s2_533 net3 x2_x2_net14 0.621878f
Cbud_s2_534 net3 x2_x2_net15 0.536211f
Cbud_s2_535 net3 x2_x2_net16 0.291128f
Cbud_s2_536 net3 x2_x2_net17 0.324374f
Cbud_s2_537 net3 x2_x2_net18 0.363658f
Cbud_s2_538 net3 x2_x2_net19 0.410536f
Cbud_s2_539 net3 x2_x2_net2 1.05097f
Cbud_s2_540 net3 x2_x2_net3 0.467099f
Cbud_s2_541 net3 x2_x2_net4 5.53033f
Cbud_s2_542 net3 x2_x2_net5 5.53033f
Cbud_s2_543 net3 x2_x2_net6 5.53033f
Cbud_s2_544 net3 x2_x2_net7 5.53033f
Cbud_s2_545 net3 x2_x2_net8 1.2975f
Cbud_s2_546 net3 x2_x2_net9 1.64215f
Cbud_s2_547 net4 x1_Vtest2 0.0363143f
Cbud_s2_548 net4 x1_net1 0.0363143f
Cbud_s2_549 net4 x1_net3 3.54835f
Cbud_s2_550 net4 x1_net4 3.54835f
Cbud_s2_551 net4 x1_net5 3.54835f
Cbud_s2_552 net4 x1_net6 3.54835f
Cbud_s2_553 net4 x1_net7 0.886935f
Cbud_s2_554 net4 x1_net8 0.886935f
Cbud_s2_555 net4 x2_x1_net1 0.467098f
Cbud_s2_556 net4 x2_x1_net10 0.621876f
Cbud_s2_557 net4 x2_x1_net11 0.536209f
Cbud_s2_558 net4 x2_x1_net12 1.29749f
Cbud_s2_559 net4 x2_x1_net13 1.64214f
Cbud_s2_560 net4 x2_x1_net14 2.14484f
Cbud_s2_561 net4 x2_x1_net15 2.91936f
Cbud_s2_562 net4 x2_x1_net16 6.75515f
Cbud_s2_563 net4 x2_x1_net17 6.75515f
Cbud_s2_564 net4 x2_x1_net18 6.75515f
Cbud_s2_565 net4 x2_x1_net19 6.56857f
Cbud_s2_566 net4 x2_x1_net2 1.05097f
Cbud_s2_567 net4 x2_x1_net3 4.20388f
Cbud_s2_568 net4 x2_x1_net4 0.291127f
Cbud_s2_569 net4 x2_x1_net5 0.324373f
Cbud_s2_570 net4 x2_x1_net6 0.363657f
Cbud_s2_571 net4 x2_x1_net7 0.410535f
Cbud_s2_572 net4 x2_x1_net8 0.86857f
Cbud_s2_573 net4 x2_x1_net9 0.72984f
Cbud_s2_574 net4 x2_x2_net1 4.20388f
Cbud_s2_575 net4 x2_x2_net10 2.14484f
Cbud_s2_576 net4 x2_x2_net11 2.91936f
Cbud_s2_577 net4 x2_x2_net12 0.86857f
Cbud_s2_578 net4 x2_x2_net13 0.72984f
Cbud_s2_579 net4 x2_x2_net14 0.621876f
Cbud_s2_580 net4 x2_x2_net15 0.536209f
Cbud_s2_581 net4 x2_x2_net16 0.291127f
Cbud_s2_582 net4 x2_x2_net17 0.324373f
Cbud_s2_583 net4 x2_x2_net18 0.363657f
Cbud_s2_584 net4 x2_x2_net19 0.410535f
Cbud_s2_585 net4 x2_x2_net2 1.05097f
Cbud_s2_586 net4 x2_x2_net3 0.467098f
Cbud_s2_587 net4 x2_x2_net4 6.75515f
Cbud_s2_588 net4 x2_x2_net5 6.75515f
Cbud_s2_589 net4 x2_x2_net6 6.75515f
Cbud_s2_590 net4 x2_x2_net7 6.56857f
Cbud_s2_591 net4 x2_x2_net8 1.29749f
Cbud_s2_592 net4 x2_x2_net9 1.64214f
Cbud_s2_593 net5 x1_Vtest2 0.0363142f
Cbud_s2_594 net5 x1_net1 0.0363142f
Cbud_s2_595 net5 x1_net2 5.73311f
Cbud_s2_596 net5 x1_net5 2.86655f
Cbud_s2_597 net5 x1_net6 2.86655f
Cbud_s2_598 net5 x1_net7 0.886935f
Cbud_s2_599 net5 x1_net8 0.886935f
Cbud_s2_600 net5 x2_Vout 4.95777f
Cbud_s2_601 net5 x2_x1_net1 0.467098f
Cbud_s2_602 net5 x2_x1_net10 0.621876f
Cbud_s2_603 net5 x2_x1_net11 0.53621f
Cbud_s2_604 net5 x2_x1_net12 1.2975f
Cbud_s2_605 net5 x2_x1_net13 1.64214f
Cbud_s2_606 net5 x2_x1_net14 2.14484f
Cbud_s2_607 net5 x2_x1_net15 2.91937f
Cbud_s2_608 net5 x2_x1_net16 4.95777f
Cbud_s2_609 net5 x2_x1_net17 4.95777f
Cbud_s2_610 net5 x2_x1_net18 4.95777f
Cbud_s2_611 net5 x2_x1_net19 4.95777f
Cbud_s2_612 net5 x2_x1_net2 1.05097f
Cbud_s2_613 net5 x2_x1_net3 4.20389f
Cbud_s2_614 net5 x2_x1_net4 0.291128f
Cbud_s2_615 net5 x2_x1_net5 0.324374f
Cbud_s2_616 net5 x2_x1_net6 0.363658f
Cbud_s2_617 net5 x2_x1_net7 0.410536f
Cbud_s2_618 net5 x2_x1_net8 0.868571f
Cbud_s2_619 net5 x2_x1_net9 0.729841f
Cbud_s2_620 net5 x2_x2_net1 4.20389f
Cbud_s2_621 net5 x2_x2_net10 2.14484f
Cbud_s2_622 net5 x2_x2_net11 2.91937f
Cbud_s2_623 net5 x2_x2_net12 0.868571f
Cbud_s2_624 net5 x2_x2_net13 0.729841f
Cbud_s2_625 net5 x2_x2_net14 0.621876f
Cbud_s2_626 net5 x2_x2_net15 0.53621f
Cbud_s2_627 net5 x2_x2_net16 0.291128f
Cbud_s2_628 net5 x2_x2_net17 0.324374f
Cbud_s2_629 net5 x2_x2_net18 0.363658f
Cbud_s2_630 net5 x2_x2_net19 0.410536f
Cbud_s2_631 net5 x2_x2_net2 1.05097f
Cbud_s2_632 net5 x2_x2_net3 0.467098f
Cbud_s2_633 net5 x2_x2_net4 4.95777f
Cbud_s2_634 net5 x2_x2_net5 4.95777f
Cbud_s2_635 net5 x2_x2_net6 4.95777f
Cbud_s2_636 net5 x2_x2_net7 4.95777f
Cbud_s2_637 net5 x2_x2_net8 1.2975f
Cbud_s2_638 net5 x2_x2_net9 1.64214f
Cbud_s2_639 net6 x1_Vout 2.65975f
Cbud_s2_640 net6 x1_Vtest2 0.0363143f
Cbud_s2_641 net6 x1_net1 0.0363143f
Cbud_s2_642 net6 x1_net3 1.75295f
Cbud_s2_643 net6 x1_net4 1.75295f
Cbud_s2_644 net6 x1_net5 1.75295f
Cbud_s2_645 net6 x1_net6 1.75295f
Cbud_s2_646 net6 x1_net7 0.886935f
Cbud_s2_647 net6 x1_net8 0.886935f
Cbud_s2_648 net6 x1_net9 2.65975f
Cbud_s2_649 net6 x2_net1 2.65975f
Cbud_s2_650 net6 x2_x1_net1 0.467098f
Cbud_s2_651 net6 x2_x1_net10 0.621876f
Cbud_s2_652 net6 x2_x1_net11 0.536209f
Cbud_s2_653 net6 x2_x1_net12 1.29749f
Cbud_s2_654 net6 x2_x1_net13 1.64214f
Cbud_s2_655 net6 x2_x1_net14 2.14484f
Cbud_s2_656 net6 x2_x1_net15 2.65975f
Cbud_s2_657 net6 x2_x1_net16 2.65975f
Cbud_s2_658 net6 x2_x1_net17 2.65975f
Cbud_s2_659 net6 x2_x1_net18 2.65975f
Cbud_s2_660 net6 x2_x1_net19 2.65975f
Cbud_s2_661 net6 x2_x1_net2 1.05097f
Cbud_s2_662 net6 x2_x1_net3 2.65975f
Cbud_s2_663 net6 x2_x1_net4 0.291128f
Cbud_s2_664 net6 x2_x1_net5 0.324374f
Cbud_s2_665 net6 x2_x1_net6 0.363658f
Cbud_s2_666 net6 x2_x1_net7 0.410535f
Cbud_s2_667 net6 x2_x1_net8 0.868571f
Cbud_s2_668 net6 x2_x1_net9 0.729841f
Cbud_s2_669 net6 x2_x2_net1 2.65975f
Cbud_s2_670 net6 x2_x2_net10 2.14484f
Cbud_s2_671 net6 x2_x2_net11 2.65975f
Cbud_s2_672 net6 x2_x2_net12 0.868571f
Cbud_s2_673 net6 x2_x2_net13 0.729841f
Cbud_s2_674 net6 x2_x2_net14 0.621876f
Cbud_s2_675 net6 x2_x2_net15 0.536209f
Cbud_s2_676 net6 x2_x2_net16 0.291128f
Cbud_s2_677 net6 x2_x2_net17 0.324374f
Cbud_s2_678 net6 x2_x2_net18 0.363658f
Cbud_s2_679 net6 x2_x2_net19 0.410535f
Cbud_s2_680 net6 x2_x2_net2 1.05097f
Cbud_s2_681 net6 x2_x2_net3 0.467098f
Cbud_s2_682 net6 x2_x2_net4 2.65975f
Cbud_s2_683 net6 x2_x2_net5 2.65975f
Cbud_s2_684 net6 x2_x2_net6 2.65975f
Cbud_s2_685 net6 x2_x2_net7 2.65975f
Cbud_s2_686 net6 x2_x2_net8 1.29749f
Cbud_s2_687 net6 x2_x2_net9 1.64214f
Cbud_s2_688 net7 x1_Vtest2 0.0363142f
Cbud_s2_689 net7 x1_net1 0.0363142f
Cbud_s2_690 net7 x1_net5 1.75295f
Cbud_s2_691 net7 x1_net6 1.75295f
Cbud_s2_692 net7 x1_net7 0.886935f
Cbud_s2_693 net7 x1_net8 0.886935f
Cbud_s2_694 net7 x2_x1_net1 0.467098f
Cbud_s2_695 net7 x2_x1_net10 0.621876f
Cbud_s2_696 net7 x2_x1_net11 0.53621f
Cbud_s2_697 net7 x2_x1_net12 1.2975f
Cbud_s2_698 net7 x2_x1_net13 1.64214f
Cbud_s2_699 net7 x2_x1_net14 2.14484f
Cbud_s2_700 net7 x2_x1_net15 2.65975f
Cbud_s2_701 net7 x2_x1_net16 2.65975f
Cbud_s2_702 net7 x2_x1_net17 2.65975f
Cbud_s2_703 net7 x2_x1_net18 2.65975f
Cbud_s2_704 net7 x2_x1_net19 2.65975f
Cbud_s2_705 net7 x2_x1_net2 1.05097f
Cbud_s2_706 net7 x2_x1_net3 2.65975f
Cbud_s2_707 net7 x2_x1_net4 0.291128f
Cbud_s2_708 net7 x2_x1_net5 0.324374f
Cbud_s2_709 net7 x2_x1_net6 0.363658f
Cbud_s2_710 net7 x2_x1_net7 0.410535f
Cbud_s2_711 net7 x2_x1_net8 0.868571f
Cbud_s2_712 net7 x2_x1_net9 0.729841f
Cbud_s2_713 net7 x2_x2_net1 2.65975f
Cbud_s2_714 net7 x2_x2_net10 2.14484f
Cbud_s2_715 net7 x2_x2_net11 2.65975f
Cbud_s2_716 net7 x2_x2_net12 0.868571f
Cbud_s2_717 net7 x2_x2_net13 0.729841f
Cbud_s2_718 net7 x2_x2_net14 0.621876f
Cbud_s2_719 net7 x2_x2_net15 0.53621f
Cbud_s2_720 net7 x2_x2_net16 0.291128f
Cbud_s2_721 net7 x2_x2_net17 0.324374f
Cbud_s2_722 net7 x2_x2_net18 0.363658f
Cbud_s2_723 net7 x2_x2_net19 0.410535f
Cbud_s2_724 net7 x2_x2_net2 1.05097f
Cbud_s2_725 net7 x2_x2_net3 0.467098f
Cbud_s2_726 net7 x2_x2_net4 2.65975f
Cbud_s2_727 net7 x2_x2_net5 2.65975f
Cbud_s2_728 net7 x2_x2_net6 2.65975f
Cbud_s2_729 net7 x2_x2_net7 2.65975f
Cbud_s2_730 net7 x2_x2_net8 1.2975f
Cbud_s2_731 net7 x2_x2_net9 1.64214f
Cbud_s2_732 x1_Vbias x1_Vout 5.10867f
Cbud_s2_733 x1_Vbias x1_Vtest2 0.0363142f
Cbud_s2_734 x1_Vbias x1_net1 0.0363142f
Cbud_s2_735 x1_Vbias x1_net5 1.75295f
Cbud_s2_736 x1_Vbias x1_net6 1.75295f
Cbud_s2_737 x1_Vbias x1_net7 0.886935f
Cbud_s2_738 x1_Vbias x1_net8 0.886935f
Cbud_s2_739 x1_Vbias x2_x1_net1 0.467099f
Cbud_s2_740 x1_Vbias x2_x1_net10 0.621877f
Cbud_s2_741 x1_Vbias x2_x1_net11 0.53621f
Cbud_s2_742 x1_Vbias x2_x1_net12 1.2975f
Cbud_s2_743 x1_Vbias x2_x1_net13 1.64214f
Cbud_s2_744 x1_Vbias x2_x1_net14 2.14484f
Cbud_s2_745 x1_Vbias x2_x1_net15 2.91937f
Cbud_s2_746 x1_Vbias x2_x1_net16 5.10867f
Cbud_s2_747 x1_Vbias x2_x1_net17 5.10867f
Cbud_s2_748 x1_Vbias x2_x1_net18 5.10867f
Cbud_s2_749 x1_Vbias x2_x1_net19 5.10867f
Cbud_s2_750 x1_Vbias x2_x1_net2 1.05097f
Cbud_s2_751 x1_Vbias x2_x1_net3 4.20389f
Cbud_s2_752 x1_Vbias x2_x1_net4 0.291128f
Cbud_s2_753 x1_Vbias x2_x1_net5 0.324374f
Cbud_s2_754 x1_Vbias x2_x1_net6 0.363658f
Cbud_s2_755 x1_Vbias x2_x1_net7 0.410536f
Cbud_s2_756 x1_Vbias x2_x1_net8 0.868572f
Cbud_s2_757 x1_Vbias x2_x1_net9 0.729842f
Cbud_s2_758 x1_Vbias x2_x2_net1 4.20389f
Cbud_s2_759 x1_Vbias x2_x2_net10 2.14484f
Cbud_s2_760 x1_Vbias x2_x2_net11 2.91937f
Cbud_s2_761 x1_Vbias x2_x2_net12 0.868572f
Cbud_s2_762 x1_Vbias x2_x2_net13 0.729842f
Cbud_s2_763 x1_Vbias x2_x2_net14 0.621877f
Cbud_s2_764 x1_Vbias x2_x2_net15 0.53621f
Cbud_s2_765 x1_Vbias x2_x2_net16 0.291128f
Cbud_s2_766 x1_Vbias x2_x2_net17 0.324374f
Cbud_s2_767 x1_Vbias x2_x2_net18 0.363658f
Cbud_s2_768 x1_Vbias x2_x2_net19 0.410536f
Cbud_s2_769 x1_Vbias x2_x2_net2 1.05097f
Cbud_s2_770 x1_Vbias x2_x2_net3 0.467099f
Cbud_s2_771 x1_Vbias x2_x2_net4 5.10867f
Cbud_s2_772 x1_Vbias x2_x2_net5 5.10867f
Cbud_s2_773 x1_Vbias x2_x2_net6 5.10867f
Cbud_s2_774 x1_Vbias x2_x2_net7 5.10867f
Cbud_s2_775 x1_Vbias x2_x2_net8 1.2975f
Cbud_s2_776 x1_Vbias x2_x2_net9 1.64214f
Cbud_s2_777 x1_Vout x1_Vtest2 0.0363093f
Cbud_s2_778 x1_Vout x1_net1 0.0363093f
Cbud_s2_779 x1_Vout x1_net5 1.75295f
Cbud_s2_780 x1_Vout x1_net6 1.75295f
Cbud_s2_781 x1_Vout x1_net7 0.886917f
Cbud_s2_782 x1_Vout x1_net8 0.886917f
Cbud_s2_783 x1_Vout x2_x1_net1 0.467099f
Cbud_s2_784 x1_Vout x2_x1_net10 0.621878f
Cbud_s2_785 x1_Vout x2_x1_net11 0.536211f
Cbud_s2_786 x1_Vout x2_x1_net12 1.2975f
Cbud_s2_787 x1_Vout x2_x1_net13 1.64215f
Cbud_s2_788 x1_Vout x2_x1_net14 2.14485f
Cbud_s2_789 x1_Vout x2_x1_net15 2.91938f
Cbud_s2_790 x1_Vout x2_x1_net16 6.75515f
Cbud_s2_791 x1_Vout x2_x1_net17 6.75515f
Cbud_s2_792 x1_Vout x2_x1_net18 6.75515f
Cbud_s2_793 x1_Vout x2_x1_net19 6.56862f
Cbud_s2_794 x1_Vout x2_x1_net2 1.05098f
Cbud_s2_795 x1_Vout x2_x1_net3 4.20391f
Cbud_s2_796 x1_Vout x2_x1_net4 0.291127f
Cbud_s2_797 x1_Vout x2_x1_net5 0.324373f
Cbud_s2_798 x1_Vout x2_x1_net6 0.363658f
Cbud_s2_799 x1_Vout x2_x1_net7 0.410536f
Cbud_s2_800 x1_Vout x2_x1_net8 0.868574f
Cbud_s2_801 x1_Vout x2_x1_net9 0.729843f
Cbud_s2_802 x1_Vout x2_x2_net1 4.20391f
Cbud_s2_803 x1_Vout x2_x2_net10 2.14485f
Cbud_s2_804 x1_Vout x2_x2_net11 2.91938f
Cbud_s2_805 x1_Vout x2_x2_net12 0.868574f
Cbud_s2_806 x1_Vout x2_x2_net13 0.729843f
Cbud_s2_807 x1_Vout x2_x2_net14 0.621878f
Cbud_s2_808 x1_Vout x2_x2_net15 0.536211f
Cbud_s2_809 x1_Vout x2_x2_net16 0.291127f
Cbud_s2_810 x1_Vout x2_x2_net17 0.324373f
Cbud_s2_811 x1_Vout x2_x2_net18 0.363658f
Cbud_s2_812 x1_Vout x2_x2_net19 0.410536f
Cbud_s2_813 x1_Vout x2_x2_net2 1.05098f
Cbud_s2_814 x1_Vout x2_x2_net3 0.467099f
Cbud_s2_815 x1_Vout x2_x2_net4 6.75515f
Cbud_s2_816 x1_Vout x2_x2_net5 6.75515f
Cbud_s2_817 x1_Vout x2_x2_net6 6.75515f
Cbud_s2_818 x1_Vout x2_x2_net7 6.56862f
Cbud_s2_819 x1_Vout x2_x2_net8 1.2975f
Cbud_s2_820 x1_Vout x2_x2_net9 1.64215f
Cbud_s2_821 x1_Vtest2 x1_net1 0.00907855f
Cbud_s2_822 x1_Vtest2 x1_net2 0.0363141f
Cbud_s2_823 x1_Vtest2 x1_net3 0.0363141f
Cbud_s2_824 x1_Vtest2 x1_net4 0.0363141f
Cbud_s2_825 x1_Vtest2 x1_net5 0.0871115f
Cbud_s2_826 x1_Vtest2 x1_net6 0.0175744f
Cbud_s2_827 x1_Vtest2 x1_net8 0.0270819f
Cbud_s2_828 x1_Vtest2 x1_net9 0.0363165f
Cbud_s2_829 x1_Vtest2 x2_Vbiasp 0.0363142f
Cbud_s2_830 x1_Vtest2 x2_Vcm 0.0363141f
Cbud_s2_831 x1_Vtest2 x2_Vout 0.0360971f
Cbud_s2_832 x1_Vtest2 x2_Vtest 0.0363568f
Cbud_s2_833 x1_Vtest2 x2_net1 0.0362958f
Cbud_s2_834 x1_Vtest2 x2_x1_net16 0.0355102f
Cbud_s2_835 x1_Vtest2 x2_x1_net17 0.0347182f
Cbud_s2_836 x1_Vtest2 x2_x1_net18 0.0339388f
Cbud_s2_837 x1_Vtest2 x2_x2_net1 0.0404761f
Cbud_s2_838 x1_Vtest2 x2_x2_net10 0.0421825f
Cbud_s2_839 x1_Vtest2 x2_x2_net11 0.0413279f
Cbud_s2_840 x1_Vtest2 x2_x2_net12 0.0368954f
Cbud_s2_841 x1_Vtest2 x2_x2_net13 0.0346943f
Cbud_s2_842 x1_Vtest2 x2_x2_net14 0.0327406f
Cbud_s2_843 x1_Vtest2 x2_x2_net15 0.0309948f
Cbud_s2_844 x1_Vtest2 x2_x2_net16 0.0244668f
Cbud_s2_845 x1_Vtest2 x2_x2_net17 0.0255433f
Cbud_s2_846 x1_Vtest2 x2_x2_net18 0.0267186f
Cbud_s2_847 x1_Vtest2 x2_x2_net19 0.0280069f
Cbud_s2_848 x1_Vtest2 x2_x2_net2 0.039394f
Cbud_s2_849 x1_Vtest2 x2_x2_net3 0.0294254f
Cbud_s2_850 x1_Vtest2 x2_x2_net4 0.037129f
Cbud_s2_851 x1_Vtest2 x2_x2_net5 0.0379538f
Cbud_s2_852 x1_Vtest2 x2_x2_net6 0.0387875f
Cbud_s2_853 x1_Vtest2 x2_x2_net7 0.0396287f
Cbud_s2_854 x1_Vtest2 x2_x2_net8 0.0422549f
Cbud_s2_855 x1_Vtest2 x2_x2_net9 0.0430378f
Cbud_s2_856 x1_Vtest2 Vm 0.0220581f
Cbud_s2_857 x1_Vtest2 Vp 0.102396f
Cbud_s2_858 x1_net1 x1_net2 0.0363141f
Cbud_s2_859 x1_net1 x1_net3 0.0363141f
Cbud_s2_860 x1_net1 x1_net4 0.0363141f
Cbud_s2_861 x1_net1 x1_net5 0.0175744f
Cbud_s2_862 x1_net1 x1_net6 0.0871115f
Cbud_s2_863 x1_net1 x1_net7 0.0270819f
Cbud_s2_864 x1_net1 x1_net9 0.0363165f
Cbud_s2_865 x1_net1 x2_Vbiasp 0.0363142f
Cbud_s2_866 x1_net1 x2_Vcm 0.0363141f
Cbud_s2_867 x1_net1 x2_Vout 0.0360971f
Cbud_s2_868 x1_net1 x2_Vtest 0.0363568f
Cbud_s2_869 x1_net1 x2_net1 0.0362958f
Cbud_s2_870 x1_net1 x2_x1_net1 0.0294254f
Cbud_s2_871 x1_net1 x2_x1_net10 0.0327406f
Cbud_s2_872 x1_net1 x2_x1_net11 0.0309948f
Cbud_s2_873 x1_net1 x2_x1_net12 0.0422549f
Cbud_s2_874 x1_net1 x2_x1_net13 0.0430378f
Cbud_s2_875 x1_net1 x2_x1_net14 0.0421825f
Cbud_s2_876 x1_net1 x2_x1_net15 0.0413279f
Cbud_s2_877 x1_net1 x2_x1_net16 0.037129f
Cbud_s2_878 x1_net1 x2_x1_net17 0.0379538f
Cbud_s2_879 x1_net1 x2_x1_net18 0.0387875f
Cbud_s2_880 x1_net1 x2_x1_net19 0.0396287f
Cbud_s2_881 x1_net1 x2_x1_net2 0.039394f
Cbud_s2_882 x1_net1 x2_x1_net3 0.0404761f
Cbud_s2_883 x1_net1 x2_x1_net4 0.0244668f
Cbud_s2_884 x1_net1 x2_x1_net5 0.0255433f
Cbud_s2_885 x1_net1 x2_x1_net6 0.0267186f
Cbud_s2_886 x1_net1 x2_x1_net7 0.0280069f
Cbud_s2_887 x1_net1 x2_x1_net8 0.0368954f
Cbud_s2_888 x1_net1 x2_x1_net9 0.0346943f
Cbud_s2_889 x1_net1 x2_x2_net4 0.0355102f
Cbud_s2_890 x1_net1 x2_x2_net5 0.0347182f
Cbud_s2_891 x1_net1 x2_x2_net6 0.0339388f
Cbud_s2_892 x1_net1 Vm 0.102396f
Cbud_s2_893 x1_net1 Vp 0.0220581f
Cbud_s2_894 x1_net2 x1_net3 2.35275f
Cbud_s2_895 x1_net2 x1_net5 1.75295f
Cbud_s2_896 x1_net2 x1_net6 1.75295f
Cbud_s2_897 x1_net2 x1_net7 0.886935f
Cbud_s2_898 x1_net2 x1_net8 0.886935f
Cbud_s2_899 x1_net2 x2_Vout 3.50591f
Cbud_s2_900 x1_net2 x2_Vtest 3.50591f
Cbud_s2_901 x1_net2 x2_x1_net1 0.467098f
Cbud_s2_902 x1_net2 x2_x1_net10 0.621876f
Cbud_s2_903 x1_net2 x2_x1_net11 0.536209f
Cbud_s2_904 x1_net2 x2_x1_net12 1.29749f
Cbud_s2_905 x1_net2 x2_x1_net13 1.64214f
Cbud_s2_906 x1_net2 x2_x1_net14 2.14484f
Cbud_s2_907 x1_net2 x2_x1_net15 2.91936f
Cbud_s2_908 x1_net2 x2_x1_net16 3.50591f
Cbud_s2_909 x1_net2 x2_x1_net17 3.50591f
Cbud_s2_910 x1_net2 x2_x1_net18 3.50591f
Cbud_s2_911 x1_net2 x2_x1_net19 3.50591f
Cbud_s2_912 x1_net2 x2_x1_net2 1.05097f
Cbud_s2_913 x1_net2 x2_x1_net3 3.50591f
Cbud_s2_914 x1_net2 x2_x1_net4 0.291127f
Cbud_s2_915 x1_net2 x2_x1_net5 0.324373f
Cbud_s2_916 x1_net2 x2_x1_net6 0.363657f
Cbud_s2_917 x1_net2 x2_x1_net7 0.410535f
Cbud_s2_918 x1_net2 x2_x1_net8 0.86857f
Cbud_s2_919 x1_net2 x2_x1_net9 0.72984f
Cbud_s2_920 x1_net2 x2_x2_net1 3.50591f
Cbud_s2_921 x1_net2 x2_x2_net10 2.14484f
Cbud_s2_922 x1_net2 x2_x2_net11 2.91936f
Cbud_s2_923 x1_net2 x2_x2_net12 0.86857f
Cbud_s2_924 x1_net2 x2_x2_net13 0.72984f
Cbud_s2_925 x1_net2 x2_x2_net14 0.621876f
Cbud_s2_926 x1_net2 x2_x2_net15 0.536209f
Cbud_s2_927 x1_net2 x2_x2_net16 0.291127f
Cbud_s2_928 x1_net2 x2_x2_net17 0.324373f
Cbud_s2_929 x1_net2 x2_x2_net18 0.363657f
Cbud_s2_930 x1_net2 x2_x2_net19 0.410535f
Cbud_s2_931 x1_net2 x2_x2_net2 1.05097f
Cbud_s2_932 x1_net2 x2_x2_net3 0.467098f
Cbud_s2_933 x1_net2 x2_x2_net4 3.50591f
Cbud_s2_934 x1_net2 x2_x2_net5 3.50591f
Cbud_s2_935 x1_net2 x2_x2_net6 3.50591f
Cbud_s2_936 x1_net2 x2_x2_net7 3.50591f
Cbud_s2_937 x1_net2 x2_x2_net8 1.29749f
Cbud_s2_938 x1_net2 x2_x2_net9 1.64214f
Cbud_s2_939 x1_net3 x1_net5 1.75295f
Cbud_s2_940 x1_net3 x1_net6 1.75295f
Cbud_s2_941 x1_net3 x1_net7 0.886935f
Cbud_s2_942 x1_net3 x1_net8 0.886935f
Cbud_s2_943 x1_net3 x2_Vout 1.75295f
Cbud_s2_944 x1_net3 x2_x1_net1 0.467098f
Cbud_s2_945 x1_net3 x2_x1_net10 0.621876f
Cbud_s2_946 x1_net3 x2_x1_net11 0.536209f
Cbud_s2_947 x1_net3 x2_x1_net12 1.29749f
Cbud_s2_948 x1_net3 x2_x1_net13 1.64214f
Cbud_s2_949 x1_net3 x2_x1_net14 1.75295f
Cbud_s2_950 x1_net3 x2_x1_net15 1.75295f
Cbud_s2_951 x1_net3 x2_x1_net16 1.75295f
Cbud_s2_952 x1_net3 x2_x1_net17 1.75295f
Cbud_s2_953 x1_net3 x2_x1_net18 1.75295f
Cbud_s2_954 x1_net3 x2_x1_net19 1.75295f
Cbud_s2_955 x1_net3 x2_x1_net2 1.05097f
Cbud_s2_956 x1_net3 x2_x1_net3 1.75295f
Cbud_s2_957 x1_net3 x2_x1_net4 0.291127f
Cbud_s2_958 x1_net3 x2_x1_net5 0.324373f
Cbud_s2_959 x1_net3 x2_x1_net6 0.363657f
Cbud_s2_960 x1_net3 x2_x1_net7 0.410535f
Cbud_s2_961 x1_net3 x2_x1_net8 0.86857f
Cbud_s2_962 x1_net3 x2_x1_net9 0.72984f
Cbud_s2_963 x1_net3 x2_x2_net1 1.75295f
Cbud_s2_964 x1_net3 x2_x2_net10 1.75295f
Cbud_s2_965 x1_net3 x2_x2_net11 1.75295f
Cbud_s2_966 x1_net3 x2_x2_net12 0.86857f
Cbud_s2_967 x1_net3 x2_x2_net13 0.72984f
Cbud_s2_968 x1_net3 x2_x2_net14 0.621876f
Cbud_s2_969 x1_net3 x2_x2_net15 0.536209f
Cbud_s2_970 x1_net3 x2_x2_net16 0.291127f
Cbud_s2_971 x1_net3 x2_x2_net17 0.324373f
Cbud_s2_972 x1_net3 x2_x2_net18 0.363657f
Cbud_s2_973 x1_net3 x2_x2_net19 0.410535f
Cbud_s2_974 x1_net3 x2_x2_net2 1.05097f
Cbud_s2_975 x1_net3 x2_x2_net3 0.467098f
Cbud_s2_976 x1_net3 x2_x2_net4 1.75295f
Cbud_s2_977 x1_net3 x2_x2_net5 1.75295f
Cbud_s2_978 x1_net3 x2_x2_net6 1.75295f
Cbud_s2_979 x1_net3 x2_x2_net7 1.75295f
Cbud_s2_980 x1_net3 x2_x2_net8 1.29749f
Cbud_s2_981 x1_net3 x2_x2_net9 1.64214f
Cbud_s2_982 x1_net4 x1_net5 1.75295f
Cbud_s2_983 x1_net4 x1_net6 1.75295f
Cbud_s2_984 x1_net4 x1_net7 0.886935f
Cbud_s2_985 x1_net4 x1_net8 0.886935f
Cbud_s2_986 x1_net4 x2_Vout 1.75295f
Cbud_s2_987 x1_net4 x2_x1_net1 0.467098f
Cbud_s2_988 x1_net4 x2_x1_net10 0.621876f
Cbud_s2_989 x1_net4 x2_x1_net11 0.536209f
Cbud_s2_990 x1_net4 x2_x1_net12 1.29749f
Cbud_s2_991 x1_net4 x2_x1_net13 1.64214f
Cbud_s2_992 x1_net4 x2_x1_net14 1.75295f
Cbud_s2_993 x1_net4 x2_x1_net15 1.75295f
Cbud_s2_994 x1_net4 x2_x1_net16 1.75295f
Cbud_s2_995 x1_net4 x2_x1_net17 1.75295f
Cbud_s2_996 x1_net4 x2_x1_net18 1.75295f
Cbud_s2_997 x1_net4 x2_x1_net19 1.75295f
Cbud_s2_998 x1_net4 x2_x1_net2 1.05097f
Cbud_s2_999 x1_net4 x2_x1_net3 1.75295f
Cbud_s2_1000 x1_net4 x2_x1_net4 0.291127f
Cbud_s2_1001 x1_net4 x2_x1_net5 0.324373f
Cbud_s2_1002 x1_net4 x2_x1_net6 0.363657f
Cbud_s2_1003 x1_net4 x2_x1_net7 0.410535f
Cbud_s2_1004 x1_net4 x2_x1_net8 0.86857f
Cbud_s2_1005 x1_net4 x2_x1_net9 0.72984f
Cbud_s2_1006 x1_net4 x2_x2_net1 1.75295f
Cbud_s2_1007 x1_net4 x2_x2_net10 1.75295f
Cbud_s2_1008 x1_net4 x2_x2_net11 1.75295f
Cbud_s2_1009 x1_net4 x2_x2_net12 0.86857f
Cbud_s2_1010 x1_net4 x2_x2_net13 0.72984f
Cbud_s2_1011 x1_net4 x2_x2_net14 0.621876f
Cbud_s2_1012 x1_net4 x2_x2_net15 0.536209f
Cbud_s2_1013 x1_net4 x2_x2_net16 0.291127f
Cbud_s2_1014 x1_net4 x2_x2_net17 0.324373f
Cbud_s2_1015 x1_net4 x2_x2_net18 0.363657f
Cbud_s2_1016 x1_net4 x2_x2_net19 0.410535f
Cbud_s2_1017 x1_net4 x2_x2_net2 1.05097f
Cbud_s2_1018 x1_net4 x2_x2_net3 0.467098f
Cbud_s2_1019 x1_net4 x2_x2_net4 1.75295f
Cbud_s2_1020 x1_net4 x2_x2_net5 1.75295f
Cbud_s2_1021 x1_net4 x2_x2_net6 1.75295f
Cbud_s2_1022 x1_net4 x2_x2_net7 1.75295f
Cbud_s2_1023 x1_net4 x2_x2_net8 1.29749f
Cbud_s2_1024 x1_net4 x2_x2_net9 1.64214f
Cbud_s2_1025 x1_net5 x1_net6 1.75295f
Cbud_s2_1026 x1_net5 x1_net7 0.342861f
Cbud_s2_1027 x1_net5 x1_net9 1.75295f
Cbud_s2_1028 x1_net5 x2_Vbiasp 1.75295f
Cbud_s2_1029 x1_net5 x2_Vcm 1.75295f
Cbud_s2_1030 x1_net5 x2_Vout 1.75295f
Cbud_s2_1031 x1_net5 x2_Vtest 1.75295f
Cbud_s2_1032 x1_net5 x2_net1 1.75295f
Cbud_s2_1033 x1_net5 x2_x2_net1 0.0953021f
Cbud_s2_1034 x1_net5 x2_x2_net10 0.0680861f
Cbud_s2_1035 x1_net5 x2_x2_net11 0.0794391f
Cbud_s2_1036 x1_net5 x2_x2_net12 0.0432521f
Cbud_s2_1037 x1_net5 x2_x2_net13 0.0396232f
Cbud_s2_1038 x1_net5 x2_x2_net14 0.0365511f
Cbud_s2_1039 x1_net5 x2_x2_net15 0.0339169f
Cbud_s2_1040 x1_net5 x2_x2_net16 0.0248981f
Cbud_s2_1041 x1_net5 x2_x2_net17 0.0263018f
Cbud_s2_1042 x1_net5 x2_x2_net18 0.0278702f
Cbud_s2_1043 x1_net5 x2_x2_net19 0.0296343f
Cbud_s2_1044 x1_net5 x2_x2_net2 0.0476044f
Cbud_s2_1045 x1_net5 x2_x2_net3 0.0316332f
Cbud_s2_1046 x1_net5 x2_x2_net4 0.465411f
Cbud_s2_1047 x1_net5 x2_x2_net5 0.236453f
Cbud_s2_1048 x1_net5 x2_x2_net6 0.158393f
Cbud_s2_1049 x1_net5 x2_x2_net7 0.119029f
Cbud_s2_1050 x1_net5 x2_x2_net8 0.0529202f
Cbud_s2_1051 x1_net5 x2_x2_net9 0.0595593f
Cbud_s2_1052 x1_net5 Vp 0.131251f
Cbud_s2_1053 x1_net6 x1_net8 0.342861f
Cbud_s2_1054 x1_net6 x1_net9 1.75295f
Cbud_s2_1055 x1_net6 x2_Vbiasp 1.75295f
Cbud_s2_1056 x1_net6 x2_Vcm 1.75295f
Cbud_s2_1057 x1_net6 x2_Vout 1.75295f
Cbud_s2_1058 x1_net6 x2_Vtest 1.75295f
Cbud_s2_1059 x1_net6 x2_net1 1.75295f
Cbud_s2_1060 x1_net6 x2_x1_net1 0.0316332f
Cbud_s2_1061 x1_net6 x2_x1_net10 0.0365511f
Cbud_s2_1062 x1_net6 x2_x1_net11 0.0339169f
Cbud_s2_1063 x1_net6 x2_x1_net12 0.0529202f
Cbud_s2_1064 x1_net6 x2_x1_net13 0.0595593f
Cbud_s2_1065 x1_net6 x2_x1_net14 0.0680861f
Cbud_s2_1066 x1_net6 x2_x1_net15 0.0794391f
Cbud_s2_1067 x1_net6 x2_x1_net16 0.465411f
Cbud_s2_1068 x1_net6 x2_x1_net17 0.236453f
Cbud_s2_1069 x1_net6 x2_x1_net18 0.158393f
Cbud_s2_1070 x1_net6 x2_x1_net19 0.119029f
Cbud_s2_1071 x1_net6 x2_x1_net2 0.0476044f
Cbud_s2_1072 x1_net6 x2_x1_net3 0.0953021f
Cbud_s2_1073 x1_net6 x2_x1_net4 0.0248981f
Cbud_s2_1074 x1_net6 x2_x1_net5 0.0263018f
Cbud_s2_1075 x1_net6 x2_x1_net6 0.0278702f
Cbud_s2_1076 x1_net6 x2_x1_net7 0.0296343f
Cbud_s2_1077 x1_net6 x2_x1_net8 0.0432521f
Cbud_s2_1078 x1_net6 x2_x1_net9 0.0396232f
Cbud_s2_1079 x1_net6 Vm 0.131251f
Cbud_s2_1080 x1_net7 x1_net8 0.221733f
Cbud_s2_1081 x1_net7 x1_net9 0.88695f
Cbud_s2_1082 x1_net7 x2_Vbiasp 0.886935f
Cbud_s2_1083 x1_net7 x2_Vcm 0.886934f
Cbud_s2_1084 x1_net7 x2_Vout 0.886526f
Cbud_s2_1085 x1_net7 x2_Vtest 0.886869f
Cbud_s2_1086 x1_net7 x2_net1 0.886912f
Cbud_s2_1087 x1_net7 x2_x1_net1 0.0541696f
Cbud_s2_1088 x1_net7 x2_x1_net10 0.0624959f
Cbud_s2_1089 x1_net7 x2_x1_net11 0.0580419f
Cbud_s2_1090 x1_net7 x2_x1_net12 0.0898766f
Cbud_s2_1091 x1_net7 x2_x1_net13 0.100838f
Cbud_s2_1092 x1_net7 x2_x1_net14 0.114795f
Cbud_s2_1093 x1_net7 x2_x1_net15 0.133171f
Cbud_s2_1094 x1_net7 x2_x1_net16 0.625118f
Cbud_s2_1095 x1_net7 x2_x1_net17 0.365236f
Cbud_s2_1096 x1_net7 x2_x1_net18 0.254763f
Cbud_s2_1097 x1_net7 x2_x1_net19 0.195459f
Cbud_s2_1098 x1_net7 x2_x1_net2 0.0810406f
Cbud_s2_1099 x1_net7 x2_x1_net3 0.158458f
Cbud_s2_1100 x1_net7 x2_x1_net4 0.0426914f
Cbud_s2_1101 x1_net7 x2_x1_net5 0.0450907f
Cbud_s2_1102 x1_net7 x2_x1_net6 0.0477673f
Cbud_s2_1103 x1_net7 x2_x1_net7 0.0507721f
Cbud_s2_1104 x1_net7 x2_x1_net8 0.0737664f
Cbud_s2_1105 x1_net7 x2_x1_net9 0.0676735f
Cbud_s2_1106 x1_net7 Vm 0.053351f
Cbud_s2_1107 x1_net8 x1_net9 0.88695f
Cbud_s2_1108 x1_net8 x2_Vbiasp 0.886935f
Cbud_s2_1109 x1_net8 x2_Vcm 0.886934f
Cbud_s2_1110 x1_net8 x2_Vout 0.886526f
Cbud_s2_1111 x1_net8 x2_Vtest 0.886869f
Cbud_s2_1112 x1_net8 x2_net1 0.886912f
Cbud_s2_1113 x1_net8 x2_x2_net1 0.158458f
Cbud_s2_1114 x1_net8 x2_x2_net10 0.114795f
Cbud_s2_1115 x1_net8 x2_x2_net11 0.133171f
Cbud_s2_1116 x1_net8 x2_x2_net12 0.0737664f
Cbud_s2_1117 x1_net8 x2_x2_net13 0.0676735f
Cbud_s2_1118 x1_net8 x2_x2_net14 0.0624959f
Cbud_s2_1119 x1_net8 x2_x2_net15 0.0580419f
Cbud_s2_1120 x1_net8 x2_x2_net16 0.0426914f
Cbud_s2_1121 x1_net8 x2_x2_net17 0.0450907f
Cbud_s2_1122 x1_net8 x2_x2_net18 0.0477673f
Cbud_s2_1123 x1_net8 x2_x2_net19 0.0507721f
Cbud_s2_1124 x1_net8 x2_x2_net2 0.0810406f
Cbud_s2_1125 x1_net8 x2_x2_net3 0.0541696f
Cbud_s2_1126 x1_net8 x2_x2_net4 0.625118f
Cbud_s2_1127 x1_net8 x2_x2_net5 0.365236f
Cbud_s2_1128 x1_net8 x2_x2_net6 0.254763f
Cbud_s2_1129 x1_net8 x2_x2_net7 0.195459f
Cbud_s2_1130 x1_net8 x2_x2_net8 0.0898766f
Cbud_s2_1131 x1_net8 x2_x2_net9 0.100838f
Cbud_s2_1132 x1_net8 Vp 0.053351f
Cbud_s2_1133 x1_net9 x2_x1_net1 0.467098f
Cbud_s2_1134 x1_net9 x2_x1_net10 0.621877f
Cbud_s2_1135 x1_net9 x2_x1_net11 0.53621f
Cbud_s2_1136 x1_net9 x2_x1_net12 1.2975f
Cbud_s2_1137 x1_net9 x2_x1_net13 1.64214f
Cbud_s2_1138 x1_net9 x2_x1_net14 2.14484f
Cbud_s2_1139 x1_net9 x2_x1_net15 2.91937f
Cbud_s2_1140 x1_net9 x2_x1_net16 6.75515f
Cbud_s2_1141 x1_net9 x2_x1_net17 6.75515f
Cbud_s2_1142 x1_net9 x2_x1_net18 6.75515f
Cbud_s2_1143 x1_net9 x2_x1_net19 6.56858f
Cbud_s2_1144 x1_net9 x2_x1_net2 1.05097f
Cbud_s2_1145 x1_net9 x2_x1_net3 4.20389f
Cbud_s2_1146 x1_net9 x2_x1_net4 0.291128f
Cbud_s2_1147 x1_net9 x2_x1_net5 0.324374f
Cbud_s2_1148 x1_net9 x2_x1_net6 0.363658f
Cbud_s2_1149 x1_net9 x2_x1_net7 0.410536f
Cbud_s2_1150 x1_net9 x2_x1_net8 0.868572f
Cbud_s2_1151 x1_net9 x2_x1_net9 0.729841f
Cbud_s2_1152 x1_net9 x2_x2_net1 4.20389f
Cbud_s2_1153 x1_net9 x2_x2_net10 2.14484f
Cbud_s2_1154 x1_net9 x2_x2_net11 2.91937f
Cbud_s2_1155 x1_net9 x2_x2_net12 0.868572f
Cbud_s2_1156 x1_net9 x2_x2_net13 0.729841f
Cbud_s2_1157 x1_net9 x2_x2_net14 0.621877f
Cbud_s2_1158 x1_net9 x2_x2_net15 0.53621f
Cbud_s2_1159 x1_net9 x2_x2_net16 0.291128f
Cbud_s2_1160 x1_net9 x2_x2_net17 0.324374f
Cbud_s2_1161 x1_net9 x2_x2_net18 0.363658f
Cbud_s2_1162 x1_net9 x2_x2_net19 0.410536f
Cbud_s2_1163 x1_net9 x2_x2_net2 1.05097f
Cbud_s2_1164 x1_net9 x2_x2_net3 0.467098f
Cbud_s2_1165 x1_net9 x2_x2_net4 6.75515f
Cbud_s2_1166 x1_net9 x2_x2_net5 6.75515f
Cbud_s2_1167 x1_net9 x2_x2_net6 6.75515f
Cbud_s2_1168 x1_net9 x2_x2_net7 6.56858f
Cbud_s2_1169 x1_net9 x2_x2_net8 1.2975f
Cbud_s2_1170 x1_net9 x2_x2_net9 1.64214f
Cbud_s2_1171 x2_Vbiasp x2_x1_net1 0.467098f
Cbud_s2_1172 x2_Vbiasp x2_x1_net10 0.621876f
Cbud_s2_1173 x2_Vbiasp x2_x1_net11 0.536209f
Cbud_s2_1174 x2_Vbiasp x2_x1_net12 1.29749f
Cbud_s2_1175 x2_Vbiasp x2_x1_net13 1.64214f
Cbud_s2_1176 x2_Vbiasp x2_x1_net14 2.14484f
Cbud_s2_1177 x2_Vbiasp x2_x1_net15 2.91936f
Cbud_s2_1178 x2_Vbiasp x2_x1_net16 3.95719f
Cbud_s2_1179 x2_Vbiasp x2_x1_net17 3.95719f
Cbud_s2_1180 x2_Vbiasp x2_x1_net18 3.95719f
Cbud_s2_1181 x2_Vbiasp x2_x1_net19 3.95719f
Cbud_s2_1182 x2_Vbiasp x2_x1_net2 1.05097f
Cbud_s2_1183 x2_Vbiasp x2_x1_net3 3.95719f
Cbud_s2_1184 x2_Vbiasp x2_x1_net4 0.291127f
Cbud_s2_1185 x2_Vbiasp x2_x1_net5 0.324373f
Cbud_s2_1186 x2_Vbiasp x2_x1_net6 0.363657f
Cbud_s2_1187 x2_Vbiasp x2_x1_net7 0.410535f
Cbud_s2_1188 x2_Vbiasp x2_x1_net8 0.86857f
Cbud_s2_1189 x2_Vbiasp x2_x1_net9 0.72984f
Cbud_s2_1190 x2_Vbiasp x2_x2_net1 3.95719f
Cbud_s2_1191 x2_Vbiasp x2_x2_net10 2.14484f
Cbud_s2_1192 x2_Vbiasp x2_x2_net11 2.91936f
Cbud_s2_1193 x2_Vbiasp x2_x2_net12 0.86857f
Cbud_s2_1194 x2_Vbiasp x2_x2_net13 0.72984f
Cbud_s2_1195 x2_Vbiasp x2_x2_net14 0.621876f
Cbud_s2_1196 x2_Vbiasp x2_x2_net15 0.536209f
Cbud_s2_1197 x2_Vbiasp x2_x2_net16 0.291127f
Cbud_s2_1198 x2_Vbiasp x2_x2_net17 0.324373f
Cbud_s2_1199 x2_Vbiasp x2_x2_net18 0.363657f
Cbud_s2_1200 x2_Vbiasp x2_x2_net19 0.410535f
Cbud_s2_1201 x2_Vbiasp x2_x2_net2 1.05097f
Cbud_s2_1202 x2_Vbiasp x2_x2_net3 0.467098f
Cbud_s2_1203 x2_Vbiasp x2_x2_net4 3.95719f
Cbud_s2_1204 x2_Vbiasp x2_x2_net5 3.95719f
Cbud_s2_1205 x2_Vbiasp x2_x2_net6 3.95719f
Cbud_s2_1206 x2_Vbiasp x2_x2_net7 3.95719f
Cbud_s2_1207 x2_Vbiasp x2_x2_net8 1.29749f
Cbud_s2_1208 x2_Vbiasp x2_x2_net9 1.64214f
Cbud_s2_1209 x2_Vbiasp Vp 1.19379f
Cbud_s2_1210 x2_Vcm x2_Vout 6.23194f
Cbud_s2_1211 x2_Vcm x2_x1_net1 0.467098f
Cbud_s2_1212 x2_Vcm x2_x1_net10 0.621876f
Cbud_s2_1213 x2_Vcm x2_x1_net11 0.536209f
Cbud_s2_1214 x2_Vcm x2_x1_net12 1.29749f
Cbud_s2_1215 x2_Vcm x2_x1_net13 1.64214f
Cbud_s2_1216 x2_Vcm x2_x1_net14 2.14484f
Cbud_s2_1217 x2_Vcm x2_x1_net15 2.91936f
Cbud_s2_1218 x2_Vcm x2_x1_net16 6.75515f
Cbud_s2_1219 x2_Vcm x2_x1_net17 6.75515f
Cbud_s2_1220 x2_Vcm x2_x1_net18 6.75515f
Cbud_s2_1221 x2_Vcm x2_x1_net19 6.56856f
Cbud_s2_1222 x2_Vcm x2_x1_net2 1.05097f
Cbud_s2_1223 x2_Vcm x2_x1_net3 4.20388f
Cbud_s2_1224 x2_Vcm x2_x1_net4 0.291128f
Cbud_s2_1225 x2_Vcm x2_x1_net5 0.324374f
Cbud_s2_1226 x2_Vcm x2_x1_net6 0.363658f
Cbud_s2_1227 x2_Vcm x2_x1_net7 0.410535f
Cbud_s2_1228 x2_Vcm x2_x1_net8 0.86857f
Cbud_s2_1229 x2_Vcm x2_x1_net9 0.72984f
Cbud_s2_1230 x2_Vcm x2_x2_net1 4.20388f
Cbud_s2_1231 x2_Vcm x2_x2_net10 2.14484f
Cbud_s2_1232 x2_Vcm x2_x2_net11 2.91936f
Cbud_s2_1233 x2_Vcm x2_x2_net12 0.86857f
Cbud_s2_1234 x2_Vcm x2_x2_net13 0.72984f
Cbud_s2_1235 x2_Vcm x2_x2_net14 0.621876f
Cbud_s2_1236 x2_Vcm x2_x2_net15 0.536209f
Cbud_s2_1237 x2_Vcm x2_x2_net16 0.291128f
Cbud_s2_1238 x2_Vcm x2_x2_net17 0.324374f
Cbud_s2_1239 x2_Vcm x2_x2_net18 0.363658f
Cbud_s2_1240 x2_Vcm x2_x2_net19 0.410535f
Cbud_s2_1241 x2_Vcm x2_x2_net2 1.05097f
Cbud_s2_1242 x2_Vcm x2_x2_net3 0.467098f
Cbud_s2_1243 x2_Vcm x2_x2_net4 6.75515f
Cbud_s2_1244 x2_Vcm x2_x2_net5 6.75515f
Cbud_s2_1245 x2_Vcm x2_x2_net6 6.75515f
Cbud_s2_1246 x2_Vcm x2_x2_net7 6.56856f
Cbud_s2_1247 x2_Vcm x2_x2_net8 1.29749f
Cbud_s2_1248 x2_Vcm x2_x2_net9 1.64214f
Cbud_s2_1249 x2_Vout x2_x1_net1 0.468694f
Cbud_s2_1250 x2_Vout x2_x1_net10 0.623998f
Cbud_s2_1251 x2_Vout x2_x1_net11 0.538041f
Cbud_s2_1252 x2_Vout x2_x1_net12 1.3019f
Cbud_s2_1253 x2_Vout x2_x1_net13 1.64771f
Cbud_s2_1254 x2_Vout x2_x1_net14 2.1521f
Cbud_s2_1255 x2_Vout x2_x1_net15 2.92923f
Cbud_s2_1256 x2_Vout x2_x1_net16 6.23194f
Cbud_s2_1257 x2_Vout x2_x1_net17 6.23194f
Cbud_s2_1258 x2_Vout x2_x1_net18 6.23194f
Cbud_s2_1259 x2_Vout x2_x1_net19 6.23194f
Cbud_s2_1260 x2_Vout x2_x1_net2 1.05454f
Cbud_s2_1261 x2_Vout x2_x1_net3 4.21807f
Cbud_s2_1262 x2_Vout x2_x1_net4 0.292125f
Cbud_s2_1263 x2_Vout x2_x1_net5 0.325485f
Cbud_s2_1264 x2_Vout x2_x1_net6 0.364902f
Cbud_s2_1265 x2_Vout x2_x1_net7 0.41194f
Cbud_s2_1266 x2_Vout x2_x1_net8 0.871527f
Cbud_s2_1267 x2_Vout x2_x1_net9 0.732328f
Cbud_s2_1268 x2_Vout x2_x2_net1 4.21807f
Cbud_s2_1269 x2_Vout x2_x2_net10 2.1521f
Cbud_s2_1270 x2_Vout x2_x2_net11 2.92923f
Cbud_s2_1271 x2_Vout x2_x2_net12 0.871527f
Cbud_s2_1272 x2_Vout x2_x2_net13 0.732328f
Cbud_s2_1273 x2_Vout x2_x2_net14 0.623998f
Cbud_s2_1274 x2_Vout x2_x2_net15 0.538041f
Cbud_s2_1275 x2_Vout x2_x2_net16 0.292125f
Cbud_s2_1276 x2_Vout x2_x2_net17 0.325485f
Cbud_s2_1277 x2_Vout x2_x2_net18 0.364902f
Cbud_s2_1278 x2_Vout x2_x2_net19 0.41194f
Cbud_s2_1279 x2_Vout x2_x2_net2 1.05454f
Cbud_s2_1280 x2_Vout x2_x2_net3 0.468694f
Cbud_s2_1281 x2_Vout x2_x2_net4 6.23194f
Cbud_s2_1282 x2_Vout x2_x2_net5 6.23194f
Cbud_s2_1283 x2_Vout x2_x2_net6 6.23194f
Cbud_s2_1284 x2_Vout x2_x2_net7 6.23194f
Cbud_s2_1285 x2_Vout x2_x2_net8 1.3019f
Cbud_s2_1286 x2_Vout x2_x2_net9 1.64771f
Cbud_s2_1287 x2_Vtest x2_x1_net1 0.467205f
Cbud_s2_1288 x2_Vtest x2_x1_net10 0.622022f
Cbud_s2_1289 x2_Vtest x2_x1_net11 0.536334f
Cbud_s2_1290 x2_Vtest x2_x1_net12 1.29781f
Cbud_s2_1291 x2_Vtest x2_x1_net13 1.64254f
Cbud_s2_1292 x2_Vtest x2_x1_net14 2.14536f
Cbud_s2_1293 x2_Vtest x2_x1_net15 2.92008f
Cbud_s2_1294 x2_Vtest x2_x1_net16 6.7072f
Cbud_s2_1295 x2_Vtest x2_x1_net17 6.7072f
Cbud_s2_1296 x2_Vtest x2_x1_net18 6.7072f
Cbud_s2_1297 x2_Vtest x2_x1_net19 6.57021f
Cbud_s2_1298 x2_Vtest x2_x1_net2 1.05122f
Cbud_s2_1299 x2_Vtest x2_x1_net3 4.20493f
Cbud_s2_1300 x2_Vtest x2_x1_net4 0.291191f
Cbud_s2_1301 x2_Vtest x2_x1_net5 0.324446f
Cbud_s2_1302 x2_Vtest x2_x1_net6 0.363739f
Cbud_s2_1303 x2_Vtest x2_x1_net7 0.410629f
Cbud_s2_1304 x2_Vtest x2_x1_net8 0.868778f
Cbud_s2_1305 x2_Vtest x2_x1_net9 0.730013f
Cbud_s2_1306 x2_Vtest x2_x2_net1 4.20493f
Cbud_s2_1307 x2_Vtest x2_x2_net10 2.14536f
Cbud_s2_1308 x2_Vtest x2_x2_net11 2.92008f
Cbud_s2_1309 x2_Vtest x2_x2_net12 0.868778f
Cbud_s2_1310 x2_Vtest x2_x2_net13 0.730013f
Cbud_s2_1311 x2_Vtest x2_x2_net14 0.622022f
Cbud_s2_1312 x2_Vtest x2_x2_net15 0.536334f
Cbud_s2_1313 x2_Vtest x2_x2_net16 0.291191f
Cbud_s2_1314 x2_Vtest x2_x2_net17 0.324446f
Cbud_s2_1315 x2_Vtest x2_x2_net18 0.363739f
Cbud_s2_1316 x2_Vtest x2_x2_net19 0.410629f
Cbud_s2_1317 x2_Vtest x2_x2_net2 1.05122f
Cbud_s2_1318 x2_Vtest x2_x2_net3 0.467205f
Cbud_s2_1319 x2_Vtest x2_x2_net4 6.7072f
Cbud_s2_1320 x2_Vtest x2_x2_net5 6.7072f
Cbud_s2_1321 x2_Vtest x2_x2_net6 6.7072f
Cbud_s2_1322 x2_Vtest x2_x2_net7 6.57021f
Cbud_s2_1323 x2_Vtest x2_x2_net8 1.29781f
Cbud_s2_1324 x2_Vtest x2_x2_net9 1.64254f
Cbud_s2_1325 x2_net1 x2_x1_net1 0.467221f
Cbud_s2_1326 x2_net1 x2_x1_net10 0.62204f
Cbud_s2_1327 x2_net1 x2_x1_net11 0.536351f
Cbud_s2_1328 x2_net1 x2_x1_net12 1.29784f
Cbud_s2_1329 x2_net1 x2_x1_net13 1.64258f
Cbud_s2_1330 x2_net1 x2_x1_net14 2.1454f
Cbud_s2_1331 x2_net1 x2_x1_net15 2.92013f
Cbud_s2_1332 x2_net1 x2_x1_net16 3.31341f
Cbud_s2_1333 x2_net1 x2_x1_net17 3.31341f
Cbud_s2_1334 x2_net1 x2_x1_net18 3.31341f
Cbud_s2_1335 x2_net1 x2_x1_net19 3.31341f
Cbud_s2_1336 x2_net1 x2_x1_net2 1.05125f
Cbud_s2_1337 x2_net1 x2_x1_net3 3.31341f
Cbud_s2_1338 x2_net1 x2_x1_net4 0.291204f
Cbud_s2_1339 x2_net1 x2_x1_net5 0.324459f
Cbud_s2_1340 x2_net1 x2_x1_net6 0.363753f
Cbud_s2_1341 x2_net1 x2_x1_net7 0.410643f
Cbud_s2_1342 x2_net1 x2_x1_net8 0.8688f
Cbud_s2_1343 x2_net1 x2_x1_net9 0.730034f
Cbud_s2_1344 x2_net1 x2_x2_net1 3.31341f
Cbud_s2_1345 x2_net1 x2_x2_net10 2.1454f
Cbud_s2_1346 x2_net1 x2_x2_net11 2.92013f
Cbud_s2_1347 x2_net1 x2_x2_net12 0.8688f
Cbud_s2_1348 x2_net1 x2_x2_net13 0.730034f
Cbud_s2_1349 x2_net1 x2_x2_net14 0.62204f
Cbud_s2_1350 x2_net1 x2_x2_net15 0.536351f
Cbud_s2_1351 x2_net1 x2_x2_net16 0.291204f
Cbud_s2_1352 x2_net1 x2_x2_net17 0.324459f
Cbud_s2_1353 x2_net1 x2_x2_net18 0.363753f
Cbud_s2_1354 x2_net1 x2_x2_net19 0.410643f
Cbud_s2_1355 x2_net1 x2_x2_net2 1.05125f
Cbud_s2_1356 x2_net1 x2_x2_net3 0.467221f
Cbud_s2_1357 x2_net1 x2_x2_net4 3.31341f
Cbud_s2_1358 x2_net1 x2_x2_net5 3.31341f
Cbud_s2_1359 x2_net1 x2_x2_net6 3.31341f
Cbud_s2_1360 x2_net1 x2_x2_net7 3.31341f
Cbud_s2_1361 x2_net1 x2_x2_net8 1.29784f
Cbud_s2_1362 x2_net1 x2_x2_net9 1.64258f
Cbud_s2_1363 x2_net1 Vm 1.19379f
Cbud_s2_1364 x2_x1_net1 x2_x1_net10 6.75515f
Cbud_s2_1365 x2_x1_net1 x2_x1_net11 6.75515f
Cbud_s2_1366 x2_x1_net1 x2_x1_net12 2.91936f
Cbud_s2_1367 x2_x1_net1 x2_x1_net13 2.14484f
Cbud_s2_1368 x2_x1_net1 x2_x1_net14 1.64214f
Cbud_s2_1369 x2_x1_net1 x2_x1_net15 1.29749f
Cbud_s2_1370 x2_x1_net1 x2_x1_net16 0.536209f
Cbud_s2_1371 x2_x1_net1 x2_x1_net17 0.621876f
Cbud_s2_1372 x2_x1_net1 x2_x1_net18 0.72984f
Cbud_s2_1373 x2_x1_net1 x2_x1_net19 0.86857f
Cbud_s2_1374 x2_x1_net1 x2_x1_net2 4.20388f
Cbud_s2_1375 x2_x1_net1 x2_x1_net3 1.05097f
Cbud_s2_1376 x2_x1_net1 x2_x1_net4 6.56856f
Cbud_s2_1377 x2_x1_net1 x2_x1_net5 6.75515f
Cbud_s2_1378 x2_x1_net1 x2_x1_net6 6.75515f
Cbud_s2_1379 x2_x1_net1 x2_x1_net7 6.75515f
Cbud_s2_1380 x2_x1_net1 x2_x1_net8 6.56856f
Cbud_s2_1381 x2_x1_net1 x2_x1_net9 6.75515f
Cbud_s2_1382 x2_x1_net1 x2_x2_net1 0.262743f
Cbud_s2_1383 x2_x1_net1 x2_x2_net10 0.217143f
Cbud_s2_1384 x2_x1_net1 x2_x2_net11 0.238315f
Cbud_s2_1385 x2_x1_net1 x2_x2_net12 0.155469f
Cbud_s2_1386 x2_x1_net1 x2_x2_net13 0.144166f
Cbud_s2_1387 x2_x1_net1 x2_x2_net14 0.134052f
Cbud_s2_1388 x2_x1_net1 x2_x2_net15 0.124967f
Cbud_s2_1389 x2_x1_net1 x2_x2_net16 0.0909144f
Cbud_s2_1390 x2_x1_net1 x2_x2_net17 0.0965078f
Cbud_s2_1391 x2_x1_net1 x2_x2_net18 0.102634f
Cbud_s2_1392 x2_x1_net1 x2_x2_net19 0.109362f
Cbud_s2_1393 x2_x1_net1 x2_x2_net2 0.168155f
Cbud_s2_1394 x2_x1_net1 x2_x2_net3 0.116774f
Cbud_s2_1395 x2_x1_net1 x2_x2_net4 0.410535f
Cbud_s2_1396 x2_x1_net1 x2_x2_net5 0.363658f
Cbud_s2_1397 x2_x1_net1 x2_x2_net6 0.324374f
Cbud_s2_1398 x2_x1_net1 x2_x2_net7 0.291128f
Cbud_s2_1399 x2_x1_net1 x2_x2_net8 0.18246f
Cbud_s2_1400 x2_x1_net1 x2_x2_net9 0.198671f
Cbud_s2_1401 x2_x1_net1 Vp 0.194332f
Cbud_s2_1402 x2_x1_net10 x2_x1_net11 6.75515f
Cbud_s2_1403 x2_x1_net10 x2_x1_net12 6.56856f
Cbud_s2_1404 x2_x1_net10 x2_x1_net13 4.20388f
Cbud_s2_1405 x2_x1_net10 x2_x1_net14 2.91936f
Cbud_s2_1406 x2_x1_net10 x2_x1_net15 2.14484f
Cbud_s2_1407 x2_x1_net10 x2_x1_net16 0.72984f
Cbud_s2_1408 x2_x1_net10 x2_x1_net17 0.86857f
Cbud_s2_1409 x2_x1_net10 x2_x1_net18 1.05097f
Cbud_s2_1410 x2_x1_net10 x2_x1_net19 1.29749f
Cbud_s2_1411 x2_x1_net10 x2_x1_net2 6.75515f
Cbud_s2_1412 x2_x1_net10 x2_x1_net3 1.64214f
Cbud_s2_1413 x2_x1_net10 x2_x1_net4 2.91936f
Cbud_s2_1414 x2_x1_net10 x2_x1_net5 4.20388f
Cbud_s2_1415 x2_x1_net10 x2_x1_net6 6.56856f
Cbud_s2_1416 x2_x1_net10 x2_x1_net7 6.75515f
Cbud_s2_1417 x2_x1_net10 x2_x1_net8 6.75515f
Cbud_s2_1418 x2_x1_net10 x2_x1_net9 6.75515f
Cbud_s2_1419 x2_x1_net10 x2_x2_net1 0.324374f
Cbud_s2_1420 x2_x1_net10 x2_x2_net10 0.262743f
Cbud_s2_1421 x2_x1_net10 x2_x2_net11 0.291128f
Cbud_s2_1422 x2_x1_net10 x2_x2_net12 0.18246f
Cbud_s2_1423 x2_x1_net10 x2_x2_net13 0.168155f
Cbud_s2_1424 x2_x1_net10 x2_x2_net14 0.155469f
Cbud_s2_1425 x2_x1_net10 x2_x2_net15 0.144166f
Cbud_s2_1426 x2_x1_net10 x2_x2_net16 0.102634f
Cbud_s2_1427 x2_x1_net10 x2_x2_net17 0.109362f
Cbud_s2_1428 x2_x1_net10 x2_x2_net18 0.116774f
Cbud_s2_1429 x2_x1_net10 x2_x2_net19 0.124967f
Cbud_s2_1430 x2_x1_net10 x2_x2_net2 0.198671f
Cbud_s2_1431 x2_x1_net10 x2_x2_net3 0.134052f
Cbud_s2_1432 x2_x1_net10 x2_x2_net4 0.536209f
Cbud_s2_1433 x2_x1_net10 x2_x2_net5 0.467098f
Cbud_s2_1434 x2_x1_net10 x2_x2_net6 0.410535f
Cbud_s2_1435 x2_x1_net10 x2_x2_net7 0.363658f
Cbud_s2_1436 x2_x1_net10 x2_x2_net8 0.217143f
Cbud_s2_1437 x2_x1_net10 x2_x2_net9 0.238315f
Cbud_s2_1438 x2_x1_net10 Vp 0.22667f
Cbud_s2_1439 x2_x1_net11 x2_x1_net12 4.20388f
Cbud_s2_1440 x2_x1_net11 x2_x1_net13 2.91936f
Cbud_s2_1441 x2_x1_net11 x2_x1_net14 2.14484f
Cbud_s2_1442 x2_x1_net11 x2_x1_net15 1.64214f
Cbud_s2_1443 x2_x1_net11 x2_x1_net16 0.621876f
Cbud_s2_1444 x2_x1_net11 x2_x1_net17 0.72984f
Cbud_s2_1445 x2_x1_net11 x2_x1_net18 0.86857f
Cbud_s2_1446 x2_x1_net11 x2_x1_net19 1.05097f
Cbud_s2_1447 x2_x1_net11 x2_x1_net2 6.56856f
Cbud_s2_1448 x2_x1_net11 x2_x1_net3 1.29749f
Cbud_s2_1449 x2_x1_net11 x2_x1_net4 4.20388f
Cbud_s2_1450 x2_x1_net11 x2_x1_net5 6.56856f
Cbud_s2_1451 x2_x1_net11 x2_x1_net6 6.75515f
Cbud_s2_1452 x2_x1_net11 x2_x1_net7 6.75515f
Cbud_s2_1453 x2_x1_net11 x2_x1_net8 6.75515f
Cbud_s2_1454 x2_x1_net11 x2_x1_net9 6.75515f
Cbud_s2_1455 x2_x1_net11 x2_x2_net1 0.291128f
Cbud_s2_1456 x2_x1_net11 x2_x2_net10 0.238315f
Cbud_s2_1457 x2_x1_net11 x2_x2_net11 0.262743f
Cbud_s2_1458 x2_x1_net11 x2_x2_net12 0.168155f
Cbud_s2_1459 x2_x1_net11 x2_x2_net13 0.155469f
Cbud_s2_1460 x2_x1_net11 x2_x2_net14 0.144166f
Cbud_s2_1461 x2_x1_net11 x2_x2_net15 0.134052f
Cbud_s2_1462 x2_x1_net11 x2_x2_net16 0.0965078f
Cbud_s2_1463 x2_x1_net11 x2_x2_net17 0.102634f
Cbud_s2_1464 x2_x1_net11 x2_x2_net18 0.109362f
Cbud_s2_1465 x2_x1_net11 x2_x2_net19 0.116774f
Cbud_s2_1466 x2_x1_net11 x2_x2_net2 0.18246f
Cbud_s2_1467 x2_x1_net11 x2_x2_net3 0.124967f
Cbud_s2_1468 x2_x1_net11 x2_x2_net4 0.467098f
Cbud_s2_1469 x2_x1_net11 x2_x2_net5 0.410535f
Cbud_s2_1470 x2_x1_net11 x2_x2_net6 0.363658f
Cbud_s2_1471 x2_x1_net11 x2_x2_net7 0.324374f
Cbud_s2_1472 x2_x1_net11 x2_x2_net8 0.198671f
Cbud_s2_1473 x2_x1_net11 x2_x2_net9 0.217143f
Cbud_s2_1474 x2_x1_net11 Vp 0.20934f
Cbud_s2_1475 x2_x1_net12 x2_x1_net13 6.75515f
Cbud_s2_1476 x2_x1_net12 x2_x1_net14 6.75515f
Cbud_s2_1477 x2_x1_net12 x2_x1_net15 6.75515f
Cbud_s2_1478 x2_x1_net12 x2_x1_net16 1.64214f
Cbud_s2_1479 x2_x1_net12 x2_x1_net17 2.14484f
Cbud_s2_1480 x2_x1_net12 x2_x1_net18 2.91936f
Cbud_s2_1481 x2_x1_net12 x2_x1_net19 4.20388f
Cbud_s2_1482 x2_x1_net12 x2_x1_net2 6.75515f
Cbud_s2_1483 x2_x1_net12 x2_x1_net3 6.56856f
Cbud_s2_1484 x2_x1_net12 x2_x1_net4 1.05097f
Cbud_s2_1485 x2_x1_net12 x2_x1_net5 1.29749f
Cbud_s2_1486 x2_x1_net12 x2_x1_net6 1.64214f
Cbud_s2_1487 x2_x1_net12 x2_x1_net7 2.14484f
Cbud_s2_1488 x2_x1_net12 x2_x1_net8 6.75515f
Cbud_s2_1489 x2_x1_net12 x2_x1_net9 6.75515f
Cbud_s2_1490 x2_x1_net12 x2_x2_net1 0.536209f
Cbud_s2_1491 x2_x1_net12 x2_x2_net10 0.410535f
Cbud_s2_1492 x2_x1_net12 x2_x2_net11 0.467098f
Cbud_s2_1493 x2_x1_net12 x2_x2_net12 0.262743f
Cbud_s2_1494 x2_x1_net12 x2_x2_net13 0.238315f
Cbud_s2_1495 x2_x1_net12 x2_x2_net14 0.217143f
Cbud_s2_1496 x2_x1_net12 x2_x2_net15 0.198671f
Cbud_s2_1497 x2_x1_net12 x2_x2_net16 0.134052f
Cbud_s2_1498 x2_x1_net12 x2_x2_net17 0.144166f
Cbud_s2_1499 x2_x1_net12 x2_x2_net18 0.155469f
Cbud_s2_1500 x2_x1_net12 x2_x2_net19 0.168155f
Cbud_s2_1501 x2_x1_net12 x2_x2_net2 0.291128f
Cbud_s2_1502 x2_x1_net12 x2_x2_net3 0.18246f
Cbud_s2_1503 x2_x1_net12 x2_x2_net4 1.05097f
Cbud_s2_1504 x2_x1_net12 x2_x2_net5 0.86857f
Cbud_s2_1505 x2_x1_net12 x2_x2_net6 0.72984f
Cbud_s2_1506 x2_x1_net12 x2_x2_net7 0.621876f
Cbud_s2_1507 x2_x1_net12 x2_x2_net8 0.324374f
Cbud_s2_1508 x2_x1_net12 x2_x2_net9 0.363658f
Cbud_s2_1509 x2_x1_net12 Vp 0.3347f
Cbud_s2_1510 x2_x1_net13 x2_x1_net14 6.75515f
Cbud_s2_1511 x2_x1_net13 x2_x1_net15 6.75515f
Cbud_s2_1512 x2_x1_net13 x2_x1_net16 2.14484f
Cbud_s2_1513 x2_x1_net13 x2_x1_net17 2.91936f
Cbud_s2_1514 x2_x1_net13 x2_x1_net18 4.20388f
Cbud_s2_1515 x2_x1_net13 x2_x1_net19 6.56856f
Cbud_s2_1516 x2_x1_net13 x2_x1_net2 6.75515f
Cbud_s2_1517 x2_x1_net13 x2_x1_net3 6.75515f
Cbud_s2_1518 x2_x1_net13 x2_x1_net4 0.86857f
Cbud_s2_1519 x2_x1_net13 x2_x1_net5 1.05097f
Cbud_s2_1520 x2_x1_net13 x2_x1_net6 1.29749f
Cbud_s2_1521 x2_x1_net13 x2_x1_net7 1.64214f
Cbud_s2_1522 x2_x1_net13 x2_x1_net8 6.75515f
Cbud_s2_1523 x2_x1_net13 x2_x1_net9 6.56856f
Cbud_s2_1524 x2_x1_net13 x2_x2_net1 0.621876f
Cbud_s2_1525 x2_x1_net13 x2_x2_net10 0.467098f
Cbud_s2_1526 x2_x1_net13 x2_x2_net11 0.536209f
Cbud_s2_1527 x2_x1_net13 x2_x2_net12 0.291128f
Cbud_s2_1528 x2_x1_net13 x2_x2_net13 0.262743f
Cbud_s2_1529 x2_x1_net13 x2_x2_net14 0.238315f
Cbud_s2_1530 x2_x1_net13 x2_x2_net15 0.217143f
Cbud_s2_1531 x2_x1_net13 x2_x2_net16 0.144166f
Cbud_s2_1532 x2_x1_net13 x2_x2_net17 0.155469f
Cbud_s2_1533 x2_x1_net13 x2_x2_net18 0.168155f
Cbud_s2_1534 x2_x1_net13 x2_x2_net19 0.18246f
Cbud_s2_1535 x2_x1_net13 x2_x2_net2 0.324374f
Cbud_s2_1536 x2_x1_net13 x2_x2_net3 0.198671f
Cbud_s2_1537 x2_x1_net13 x2_x2_net4 1.29749f
Cbud_s2_1538 x2_x1_net13 x2_x2_net5 1.05097f
Cbud_s2_1539 x2_x1_net13 x2_x2_net6 0.86857f
Cbud_s2_1540 x2_x1_net13 x2_x2_net7 0.72984f
Cbud_s2_1541 x2_x1_net13 x2_x2_net8 0.363658f
Cbud_s2_1542 x2_x1_net13 x2_x2_net9 0.410535f
Cbud_s2_1543 x2_x1_net13 Vp 0.378645f
Cbud_s2_1544 x2_x1_net14 x2_x1_net15 6.75515f
Cbud_s2_1545 x2_x1_net14 x2_x1_net16 2.91936f
Cbud_s2_1546 x2_x1_net14 x2_x1_net17 4.20388f
Cbud_s2_1547 x2_x1_net14 x2_x1_net18 6.56856f
Cbud_s2_1548 x2_x1_net14 x2_x1_net19 6.75515f
Cbud_s2_1549 x2_x1_net14 x2_x1_net2 6.75515f
Cbud_s2_1550 x2_x1_net14 x2_x1_net3 6.75515f
Cbud_s2_1551 x2_x1_net14 x2_x1_net4 0.72984f
Cbud_s2_1552 x2_x1_net14 x2_x1_net5 0.86857f
Cbud_s2_1553 x2_x1_net14 x2_x1_net6 1.05097f
Cbud_s2_1554 x2_x1_net14 x2_x1_net7 1.29749f
Cbud_s2_1555 x2_x1_net14 x2_x1_net8 6.56856f
Cbud_s2_1556 x2_x1_net14 x2_x1_net9 4.20388f
Cbud_s2_1557 x2_x1_net14 x2_x2_net1 0.72984f
Cbud_s2_1558 x2_x1_net14 x2_x2_net10 0.536209f
Cbud_s2_1559 x2_x1_net14 x2_x2_net11 0.621876f
Cbud_s2_1560 x2_x1_net14 x2_x2_net12 0.324374f
Cbud_s2_1561 x2_x1_net14 x2_x2_net13 0.291128f
Cbud_s2_1562 x2_x1_net14 x2_x2_net14 0.262743f
Cbud_s2_1563 x2_x1_net14 x2_x2_net15 0.238315f
Cbud_s2_1564 x2_x1_net14 x2_x2_net16 0.155469f
Cbud_s2_1565 x2_x1_net14 x2_x2_net17 0.168155f
Cbud_s2_1566 x2_x1_net14 x2_x2_net18 0.18246f
Cbud_s2_1567 x2_x1_net14 x2_x2_net19 0.198671f
Cbud_s2_1568 x2_x1_net14 x2_x2_net2 0.363658f
Cbud_s2_1569 x2_x1_net14 x2_x2_net3 0.217143f
Cbud_s2_1570 x2_x1_net14 x2_x2_net4 1.64214f
Cbud_s2_1571 x2_x1_net14 x2_x2_net5 1.29749f
Cbud_s2_1572 x2_x1_net14 x2_x2_net6 1.05097f
Cbud_s2_1573 x2_x1_net14 x2_x2_net7 0.86857f
Cbud_s2_1574 x2_x1_net14 x2_x2_net8 0.410535f
Cbud_s2_1575 x2_x1_net14 x2_x2_net9 0.467098f
Cbud_s2_1576 x2_x1_net14 Vp 0.435172f
Cbud_s2_1577 x2_x1_net15 x2_x1_net16 4.20388f
Cbud_s2_1578 x2_x1_net15 x2_x1_net17 6.56856f
Cbud_s2_1579 x2_x1_net15 x2_x1_net18 6.75515f
Cbud_s2_1580 x2_x1_net15 x2_x1_net19 6.75515f
Cbud_s2_1581 x2_x1_net15 x2_x1_net2 6.56856f
Cbud_s2_1582 x2_x1_net15 x2_x1_net3 6.75515f
Cbud_s2_1583 x2_x1_net15 x2_x1_net4 0.621876f
Cbud_s2_1584 x2_x1_net15 x2_x1_net5 0.72984f
Cbud_s2_1585 x2_x1_net15 x2_x1_net6 0.86857f
Cbud_s2_1586 x2_x1_net15 x2_x1_net7 1.05097f
Cbud_s2_1587 x2_x1_net15 x2_x1_net8 4.20388f
Cbud_s2_1588 x2_x1_net15 x2_x1_net9 2.91936f
Cbud_s2_1589 x2_x1_net15 x2_x2_net1 0.86857f
Cbud_s2_1590 x2_x1_net15 x2_x2_net10 0.621876f
Cbud_s2_1591 x2_x1_net15 x2_x2_net11 0.72984f
Cbud_s2_1592 x2_x1_net15 x2_x2_net12 0.363658f
Cbud_s2_1593 x2_x1_net15 x2_x2_net13 0.324374f
Cbud_s2_1594 x2_x1_net15 x2_x2_net14 0.291128f
Cbud_s2_1595 x2_x1_net15 x2_x2_net15 0.262743f
Cbud_s2_1596 x2_x1_net15 x2_x2_net16 0.168155f
Cbud_s2_1597 x2_x1_net15 x2_x2_net17 0.18246f
Cbud_s2_1598 x2_x1_net15 x2_x2_net18 0.198671f
Cbud_s2_1599 x2_x1_net15 x2_x2_net19 0.217143f
Cbud_s2_1600 x2_x1_net15 x2_x2_net2 0.410535f
Cbud_s2_1601 x2_x1_net15 x2_x2_net3 0.238315f
Cbud_s2_1602 x2_x1_net15 x2_x2_net4 2.14484f
Cbud_s2_1603 x2_x1_net15 x2_x2_net5 1.64214f
Cbud_s2_1604 x2_x1_net15 x2_x2_net6 1.29749f
Cbud_s2_1605 x2_x1_net15 x2_x2_net7 1.05097f
Cbud_s2_1606 x2_x1_net15 x2_x2_net8 0.467098f
Cbud_s2_1607 x2_x1_net15 x2_x2_net9 0.536209f
Cbud_s2_1608 x2_x1_net15 Vp 0.510574f
Cbud_s2_1609 x2_x1_net16 x2_x1_net17 6.75515f
Cbud_s2_1610 x2_x1_net16 x2_x1_net18 6.75515f
Cbud_s2_1611 x2_x1_net16 x2_x1_net19 6.75515f
Cbud_s2_1612 x2_x1_net16 x2_x1_net2 1.29749f
Cbud_s2_1613 x2_x1_net16 x2_x1_net3 6.56856f
Cbud_s2_1614 x2_x1_net16 x2_x1_net4 0.324374f
Cbud_s2_1615 x2_x1_net16 x2_x1_net5 0.363658f
Cbud_s2_1616 x2_x1_net16 x2_x1_net6 0.410535f
Cbud_s2_1617 x2_x1_net16 x2_x1_net7 0.467098f
Cbud_s2_1618 x2_x1_net16 x2_x1_net8 1.05097f
Cbud_s2_1619 x2_x1_net16 x2_x1_net9 0.86857f
Cbud_s2_1620 x2_x1_net16 x2_x2_net1 2.91936f
Cbud_s2_1621 x2_x1_net16 x2_x2_net10 1.64214f
Cbud_s2_1622 x2_x1_net16 x2_x2_net11 2.14484f
Cbud_s2_1623 x2_x1_net16 x2_x2_net12 0.72984f
Cbud_s2_1624 x2_x1_net16 x2_x2_net13 0.621876f
Cbud_s2_1625 x2_x1_net16 x2_x2_net14 0.536209f
Cbud_s2_1626 x2_x1_net16 x2_x2_net15 0.467098f
Cbud_s2_1627 x2_x1_net16 x2_x2_net16 0.262743f
Cbud_s2_1628 x2_x1_net16 x2_x2_net17 0.291128f
Cbud_s2_1629 x2_x1_net16 x2_x2_net18 0.324374f
Cbud_s2_1630 x2_x1_net16 x2_x2_net19 0.363658f
Cbud_s2_1631 x2_x1_net16 x2_x2_net2 0.86857f
Cbud_s2_1632 x2_x1_net16 x2_x2_net3 0.410535f
Cbud_s2_1633 x2_x1_net16 x2_x2_net4 6.75515f
Cbud_s2_1634 x2_x1_net16 x2_x2_net5 6.75515f
Cbud_s2_1635 x2_x1_net16 x2_x2_net6 6.56856f
Cbud_s2_1636 x2_x1_net16 x2_x2_net7 4.20388f
Cbud_s2_1637 x2_x1_net16 x2_x2_net8 1.05097f
Cbud_s2_1638 x2_x1_net16 x2_x2_net9 1.29749f
Cbud_s2_1639 x2_x1_net16 Vp 1.19379f
Cbud_s2_1640 x2_x1_net17 x2_x1_net18 6.75515f
Cbud_s2_1641 x2_x1_net17 x2_x1_net19 6.75515f
Cbud_s2_1642 x2_x1_net17 x2_x1_net2 1.64214f
Cbud_s2_1643 x2_x1_net17 x2_x1_net3 6.75515f
Cbud_s2_1644 x2_x1_net17 x2_x1_net4 0.363658f
Cbud_s2_1645 x2_x1_net17 x2_x1_net5 0.410535f
Cbud_s2_1646 x2_x1_net17 x2_x1_net6 0.467098f
Cbud_s2_1647 x2_x1_net17 x2_x1_net7 0.536209f
Cbud_s2_1648 x2_x1_net17 x2_x1_net8 1.29749f
Cbud_s2_1649 x2_x1_net17 x2_x1_net9 1.05097f
Cbud_s2_1650 x2_x1_net17 x2_x2_net1 2.14484f
Cbud_s2_1651 x2_x1_net17 x2_x2_net10 1.29749f
Cbud_s2_1652 x2_x1_net17 x2_x2_net11 1.64214f
Cbud_s2_1653 x2_x1_net17 x2_x2_net12 0.621876f
Cbud_s2_1654 x2_x1_net17 x2_x2_net13 0.536209f
Cbud_s2_1655 x2_x1_net17 x2_x2_net14 0.467098f
Cbud_s2_1656 x2_x1_net17 x2_x2_net15 0.410535f
Cbud_s2_1657 x2_x1_net17 x2_x2_net16 0.238315f
Cbud_s2_1658 x2_x1_net17 x2_x2_net17 0.262743f
Cbud_s2_1659 x2_x1_net17 x2_x2_net18 0.291128f
Cbud_s2_1660 x2_x1_net17 x2_x2_net19 0.324374f
Cbud_s2_1661 x2_x1_net17 x2_x2_net2 0.72984f
Cbud_s2_1662 x2_x1_net17 x2_x2_net3 0.363658f
Cbud_s2_1663 x2_x1_net17 x2_x2_net4 6.75515f
Cbud_s2_1664 x2_x1_net17 x2_x2_net5 6.56856f
Cbud_s2_1665 x2_x1_net17 x2_x2_net6 4.20388f
Cbud_s2_1666 x2_x1_net17 x2_x2_net7 2.91936f
Cbud_s2_1667 x2_x1_net17 x2_x2_net8 0.86857f
Cbud_s2_1668 x2_x1_net17 x2_x2_net9 1.05097f
Cbud_s2_1669 x2_x1_net17 Vp 1.19379f
Cbud_s2_1670 x2_x1_net18 x2_x1_net19 6.75515f
Cbud_s2_1671 x2_x1_net18 x2_x1_net2 2.14484f
Cbud_s2_1672 x2_x1_net18 x2_x1_net3 6.75515f
Cbud_s2_1673 x2_x1_net18 x2_x1_net4 0.410535f
Cbud_s2_1674 x2_x1_net18 x2_x1_net5 0.467098f
Cbud_s2_1675 x2_x1_net18 x2_x1_net6 0.536209f
Cbud_s2_1676 x2_x1_net18 x2_x1_net7 0.621876f
Cbud_s2_1677 x2_x1_net18 x2_x1_net8 1.64214f
Cbud_s2_1678 x2_x1_net18 x2_x1_net9 1.29749f
Cbud_s2_1679 x2_x1_net18 x2_x2_net1 1.64214f
Cbud_s2_1680 x2_x1_net18 x2_x2_net10 1.05097f
Cbud_s2_1681 x2_x1_net18 x2_x2_net11 1.29749f
Cbud_s2_1682 x2_x1_net18 x2_x2_net12 0.536209f
Cbud_s2_1683 x2_x1_net18 x2_x2_net13 0.467098f
Cbud_s2_1684 x2_x1_net18 x2_x2_net14 0.410535f
Cbud_s2_1685 x2_x1_net18 x2_x2_net15 0.363658f
Cbud_s2_1686 x2_x1_net18 x2_x2_net16 0.217143f
Cbud_s2_1687 x2_x1_net18 x2_x2_net17 0.238315f
Cbud_s2_1688 x2_x1_net18 x2_x2_net18 0.262743f
Cbud_s2_1689 x2_x1_net18 x2_x2_net19 0.291128f
Cbud_s2_1690 x2_x1_net18 x2_x2_net2 0.621876f
Cbud_s2_1691 x2_x1_net18 x2_x2_net3 0.324374f
Cbud_s2_1692 x2_x1_net18 x2_x2_net4 6.56856f
Cbud_s2_1693 x2_x1_net18 x2_x2_net5 4.20388f
Cbud_s2_1694 x2_x1_net18 x2_x2_net6 2.91936f
Cbud_s2_1695 x2_x1_net18 x2_x2_net7 2.14484f
Cbud_s2_1696 x2_x1_net18 x2_x2_net8 0.72984f
Cbud_s2_1697 x2_x1_net18 x2_x2_net9 0.86857f
Cbud_s2_1698 x2_x1_net18 Vp 1.03878f
Cbud_s2_1699 x2_x1_net19 x2_x1_net2 2.91936f
Cbud_s2_1700 x2_x1_net19 x2_x1_net3 6.75515f
Cbud_s2_1701 x2_x1_net19 x2_x1_net4 0.467098f
Cbud_s2_1702 x2_x1_net19 x2_x1_net5 0.536209f
Cbud_s2_1703 x2_x1_net19 x2_x1_net6 0.621876f
Cbud_s2_1704 x2_x1_net19 x2_x1_net7 0.72984f
Cbud_s2_1705 x2_x1_net19 x2_x1_net8 2.14484f
Cbud_s2_1706 x2_x1_net19 x2_x1_net9 1.64214f
Cbud_s2_1707 x2_x1_net19 x2_x2_net1 1.29749f
Cbud_s2_1708 x2_x1_net19 x2_x2_net10 0.86857f
Cbud_s2_1709 x2_x1_net19 x2_x2_net11 1.05097f
Cbud_s2_1710 x2_x1_net19 x2_x2_net12 0.467098f
Cbud_s2_1711 x2_x1_net19 x2_x2_net13 0.410535f
Cbud_s2_1712 x2_x1_net19 x2_x2_net14 0.363658f
Cbud_s2_1713 x2_x1_net19 x2_x2_net15 0.324374f
Cbud_s2_1714 x2_x1_net19 x2_x2_net16 0.198671f
Cbud_s2_1715 x2_x1_net19 x2_x2_net17 0.217143f
Cbud_s2_1716 x2_x1_net19 x2_x2_net18 0.238315f
Cbud_s2_1717 x2_x1_net19 x2_x2_net19 0.262743f
Cbud_s2_1718 x2_x1_net19 x2_x2_net2 0.536209f
Cbud_s2_1719 x2_x1_net19 x2_x2_net3 0.291128f
Cbud_s2_1720 x2_x1_net19 x2_x2_net4 4.20388f
Cbud_s2_1721 x2_x1_net19 x2_x2_net5 2.91936f
Cbud_s2_1722 x2_x1_net19 x2_x2_net6 2.14484f
Cbud_s2_1723 x2_x1_net19 x2_x2_net7 1.64214f
Cbud_s2_1724 x2_x1_net19 x2_x2_net8 0.621876f
Cbud_s2_1725 x2_x1_net19 x2_x2_net9 0.72984f
Cbud_s2_1726 x2_x1_net19 Vp 0.774629f
Cbud_s2_1727 x2_x1_net2 x2_x1_net3 4.20388f
Cbud_s2_1728 x2_x1_net2 x2_x1_net4 1.29749f
Cbud_s2_1729 x2_x1_net2 x2_x1_net5 1.64214f
Cbud_s2_1730 x2_x1_net2 x2_x1_net6 2.14484f
Cbud_s2_1731 x2_x1_net2 x2_x1_net7 2.91936f
Cbud_s2_1732 x2_x1_net2 x2_x1_net8 6.75515f
Cbud_s2_1733 x2_x1_net2 x2_x1_net9 6.75515f
Cbud_s2_1734 x2_x1_net2 x2_x2_net1 0.467098f
Cbud_s2_1735 x2_x1_net2 x2_x2_net10 0.363658f
Cbud_s2_1736 x2_x1_net2 x2_x2_net11 0.410535f
Cbud_s2_1737 x2_x1_net2 x2_x2_net12 0.238315f
Cbud_s2_1738 x2_x1_net2 x2_x2_net13 0.217143f
Cbud_s2_1739 x2_x1_net2 x2_x2_net14 0.198671f
Cbud_s2_1740 x2_x1_net2 x2_x2_net15 0.18246f
Cbud_s2_1741 x2_x1_net2 x2_x2_net16 0.124967f
Cbud_s2_1742 x2_x1_net2 x2_x2_net17 0.134052f
Cbud_s2_1743 x2_x1_net2 x2_x2_net18 0.144166f
Cbud_s2_1744 x2_x1_net2 x2_x2_net19 0.155469f
Cbud_s2_1745 x2_x1_net2 x2_x2_net2 0.262743f
Cbud_s2_1746 x2_x1_net2 x2_x2_net3 0.168155f
Cbud_s2_1747 x2_x1_net2 x2_x2_net4 0.86857f
Cbud_s2_1748 x2_x1_net2 x2_x2_net5 0.72984f
Cbud_s2_1749 x2_x1_net2 x2_x2_net6 0.621876f
Cbud_s2_1750 x2_x1_net2 x2_x2_net7 0.536209f
Cbud_s2_1751 x2_x1_net2 x2_x2_net8 0.291128f
Cbud_s2_1752 x2_x1_net2 x2_x2_net9 0.324374f
Cbud_s2_1753 x2_x1_net2 Vp 0.299563f
Cbud_s2_1754 x2_x1_net3 x2_x1_net4 0.536209f
Cbud_s2_1755 x2_x1_net3 x2_x1_net5 0.621876f
Cbud_s2_1756 x2_x1_net3 x2_x1_net6 0.72984f
Cbud_s2_1757 x2_x1_net3 x2_x1_net7 0.86857f
Cbud_s2_1758 x2_x1_net3 x2_x1_net8 2.91936f
Cbud_s2_1759 x2_x1_net3 x2_x1_net9 2.14484f
Cbud_s2_1760 x2_x1_net3 x2_x2_net1 1.05097f
Cbud_s2_1761 x2_x1_net3 x2_x2_net10 0.72984f
Cbud_s2_1762 x2_x1_net3 x2_x2_net11 0.86857f
Cbud_s2_1763 x2_x1_net3 x2_x2_net12 0.410535f
Cbud_s2_1764 x2_x1_net3 x2_x2_net13 0.363658f
Cbud_s2_1765 x2_x1_net3 x2_x2_net14 0.324374f
Cbud_s2_1766 x2_x1_net3 x2_x2_net15 0.291128f
Cbud_s2_1767 x2_x1_net3 x2_x2_net16 0.18246f
Cbud_s2_1768 x2_x1_net3 x2_x2_net17 0.198671f
Cbud_s2_1769 x2_x1_net3 x2_x2_net18 0.217143f
Cbud_s2_1770 x2_x1_net3 x2_x2_net19 0.238315f
Cbud_s2_1771 x2_x1_net3 x2_x2_net2 0.467098f
Cbud_s2_1772 x2_x1_net3 x2_x2_net3 0.262743f
Cbud_s2_1773 x2_x1_net3 x2_x2_net4 2.91936f
Cbud_s2_1774 x2_x1_net3 x2_x2_net5 2.14484f
Cbud_s2_1775 x2_x1_net3 x2_x2_net6 1.64214f
Cbud_s2_1776 x2_x1_net3 x2_x2_net7 1.29749f
Cbud_s2_1777 x2_x1_net3 x2_x2_net8 0.536209f
Cbud_s2_1778 x2_x1_net3 x2_x2_net9 0.621876f
Cbud_s2_1779 x2_x1_net3 Vp 0.616176f
Cbud_s2_1780 x2_x1_net4 x2_x1_net5 6.75515f
Cbud_s2_1781 x2_x1_net4 x2_x1_net6 6.75515f
Cbud_s2_1782 x2_x1_net4 x2_x1_net7 6.75515f
Cbud_s2_1783 x2_x1_net4 x2_x1_net8 1.64214f
Cbud_s2_1784 x2_x1_net4 x2_x1_net9 2.14484f
Cbud_s2_1785 x2_x1_net4 x2_x2_net1 0.18246f
Cbud_s2_1786 x2_x1_net4 x2_x2_net10 0.155469f
Cbud_s2_1787 x2_x1_net4 x2_x2_net11 0.168155f
Cbud_s2_1788 x2_x1_net4 x2_x2_net12 0.116774f
Cbud_s2_1789 x2_x1_net4 x2_x2_net13 0.109362f
Cbud_s2_1790 x2_x1_net4 x2_x2_net14 0.102634f
Cbud_s2_1791 x2_x1_net4 x2_x2_net15 0.0965078f
Cbud_s2_1792 x2_x1_net4 x2_x2_net16 0.0727819f
Cbud_s2_1793 x2_x1_net4 x2_x2_net17 0.0767692f
Cbud_s2_1794 x2_x1_net4 x2_x2_net18 0.0810934f
Cbud_s2_1795 x2_x1_net4 x2_x2_net19 0.0857935f
Cbud_s2_1796 x2_x1_net4 x2_x2_net2 0.124967f
Cbud_s2_1797 x2_x1_net4 x2_x2_net3 0.0909144f
Cbud_s2_1798 x2_x1_net4 x2_x2_net4 0.262743f
Cbud_s2_1799 x2_x1_net4 x2_x2_net5 0.238315f
Cbud_s2_1800 x2_x1_net4 x2_x2_net6 0.217143f
Cbud_s2_1801 x2_x1_net4 x2_x2_net7 0.198671f
Cbud_s2_1802 x2_x1_net4 x2_x2_net8 0.134052f
Cbud_s2_1803 x2_x1_net4 x2_x2_net9 0.144166f
Cbud_s2_1804 x2_x1_net4 Vp 0.150185f
Cbud_s2_1805 x2_x1_net5 x2_x1_net6 6.75515f
Cbud_s2_1806 x2_x1_net5 x2_x1_net7 6.75515f
Cbud_s2_1807 x2_x1_net5 x2_x1_net8 2.14484f
Cbud_s2_1808 x2_x1_net5 x2_x1_net9 2.91936f
Cbud_s2_1809 x2_x1_net5 x2_x2_net1 0.198671f
Cbud_s2_1810 x2_x1_net5 x2_x2_net10 0.168155f
Cbud_s2_1811 x2_x1_net5 x2_x2_net11 0.18246f
Cbud_s2_1812 x2_x1_net5 x2_x2_net12 0.124967f
Cbud_s2_1813 x2_x1_net5 x2_x2_net13 0.116774f
Cbud_s2_1814 x2_x1_net5 x2_x2_net14 0.109362f
Cbud_s2_1815 x2_x1_net5 x2_x2_net15 0.102634f
Cbud_s2_1816 x2_x1_net5 x2_x2_net16 0.0767692f
Cbud_s2_1817 x2_x1_net5 x2_x2_net17 0.0810934f
Cbud_s2_1818 x2_x1_net5 x2_x2_net18 0.0857935f
Cbud_s2_1819 x2_x1_net5 x2_x2_net19 0.0909144f
Cbud_s2_1820 x2_x1_net5 x2_x2_net2 0.134052f
Cbud_s2_1821 x2_x1_net5 x2_x2_net3 0.0965078f
Cbud_s2_1822 x2_x1_net5 x2_x2_net4 0.291128f
Cbud_s2_1823 x2_x1_net5 x2_x2_net5 0.262743f
Cbud_s2_1824 x2_x1_net5 x2_x2_net6 0.238315f
Cbud_s2_1825 x2_x1_net5 x2_x2_net7 0.217143f
Cbud_s2_1826 x2_x1_net5 x2_x2_net8 0.144166f
Cbud_s2_1827 x2_x1_net5 x2_x2_net9 0.155469f
Cbud_s2_1828 x2_x1_net5 Vp 0.159368f
Cbud_s2_1829 x2_x1_net6 x2_x1_net7 6.75515f
Cbud_s2_1830 x2_x1_net6 x2_x1_net8 2.91936f
Cbud_s2_1831 x2_x1_net6 x2_x1_net9 4.20388f
Cbud_s2_1832 x2_x1_net6 x2_x2_net1 0.217143f
Cbud_s2_1833 x2_x1_net6 x2_x2_net10 0.18246f
Cbud_s2_1834 x2_x1_net6 x2_x2_net11 0.198671f
Cbud_s2_1835 x2_x1_net6 x2_x2_net12 0.134052f
Cbud_s2_1836 x2_x1_net6 x2_x2_net13 0.124967f
Cbud_s2_1837 x2_x1_net6 x2_x2_net14 0.116774f
Cbud_s2_1838 x2_x1_net6 x2_x2_net15 0.109362f
Cbud_s2_1839 x2_x1_net6 x2_x2_net16 0.0810934f
Cbud_s2_1840 x2_x1_net6 x2_x2_net17 0.0857935f
Cbud_s2_1841 x2_x1_net6 x2_x2_net18 0.0909144f
Cbud_s2_1842 x2_x1_net6 x2_x2_net19 0.0965078f
Cbud_s2_1843 x2_x1_net6 x2_x2_net2 0.144166f
Cbud_s2_1844 x2_x1_net6 x2_x2_net3 0.102634f
Cbud_s2_1845 x2_x1_net6 x2_x2_net4 0.324374f
Cbud_s2_1846 x2_x1_net6 x2_x2_net5 0.291128f
Cbud_s2_1847 x2_x1_net6 x2_x2_net6 0.262743f
Cbud_s2_1848 x2_x1_net6 x2_x2_net7 0.238315f
Cbud_s2_1849 x2_x1_net6 x2_x2_net8 0.155469f
Cbud_s2_1850 x2_x1_net6 x2_x2_net9 0.168155f
Cbud_s2_1851 x2_x1_net6 Vp 0.169642f
Cbud_s2_1852 x2_x1_net7 x2_x1_net8 4.20388f
Cbud_s2_1853 x2_x1_net7 x2_x1_net9 6.56856f
Cbud_s2_1854 x2_x1_net7 x2_x2_net1 0.238315f
Cbud_s2_1855 x2_x1_net7 x2_x2_net10 0.198671f
Cbud_s2_1856 x2_x1_net7 x2_x2_net11 0.217143f
Cbud_s2_1857 x2_x1_net7 x2_x2_net12 0.144166f
Cbud_s2_1858 x2_x1_net7 x2_x2_net13 0.134052f
Cbud_s2_1859 x2_x1_net7 x2_x2_net14 0.124967f
Cbud_s2_1860 x2_x1_net7 x2_x2_net15 0.116774f
Cbud_s2_1861 x2_x1_net7 x2_x2_net16 0.0857935f
Cbud_s2_1862 x2_x1_net7 x2_x2_net17 0.0909144f
Cbud_s2_1863 x2_x1_net7 x2_x2_net18 0.0965078f
Cbud_s2_1864 x2_x1_net7 x2_x2_net19 0.102634f
Cbud_s2_1865 x2_x1_net7 x2_x2_net2 0.155469f
Cbud_s2_1866 x2_x1_net7 x2_x2_net3 0.109362f
Cbud_s2_1867 x2_x1_net7 x2_x2_net4 0.363658f
Cbud_s2_1868 x2_x1_net7 x2_x2_net5 0.324374f
Cbud_s2_1869 x2_x1_net7 x2_x2_net6 0.291128f
Cbud_s2_1870 x2_x1_net7 x2_x2_net7 0.262743f
Cbud_s2_1871 x2_x1_net7 x2_x2_net8 0.168155f
Cbud_s2_1872 x2_x1_net7 x2_x2_net9 0.18246f
Cbud_s2_1873 x2_x1_net7 Vp 0.18121f
Cbud_s2_1874 x2_x1_net8 x2_x1_net9 6.75515f
Cbud_s2_1875 x2_x1_net8 x2_x2_net1 0.410535f
Cbud_s2_1876 x2_x1_net8 x2_x2_net10 0.324374f
Cbud_s2_1877 x2_x1_net8 x2_x2_net11 0.363658f
Cbud_s2_1878 x2_x1_net8 x2_x2_net12 0.217143f
Cbud_s2_1879 x2_x1_net8 x2_x2_net13 0.198671f
Cbud_s2_1880 x2_x1_net8 x2_x2_net14 0.18246f
Cbud_s2_1881 x2_x1_net8 x2_x2_net15 0.168155f
Cbud_s2_1882 x2_x1_net8 x2_x2_net16 0.116774f
Cbud_s2_1883 x2_x1_net8 x2_x2_net17 0.124967f
Cbud_s2_1884 x2_x1_net8 x2_x2_net18 0.134052f
Cbud_s2_1885 x2_x1_net8 x2_x2_net19 0.144166f
Cbud_s2_1886 x2_x1_net8 x2_x2_net2 0.238315f
Cbud_s2_1887 x2_x1_net8 x2_x2_net3 0.155469f
Cbud_s2_1888 x2_x1_net8 x2_x2_net4 0.72984f
Cbud_s2_1889 x2_x1_net8 x2_x2_net5 0.621876f
Cbud_s2_1890 x2_x1_net8 x2_x2_net6 0.536209f
Cbud_s2_1891 x2_x1_net8 x2_x2_net7 0.467098f
Cbud_s2_1892 x2_x1_net8 x2_x2_net8 0.262743f
Cbud_s2_1893 x2_x1_net8 x2_x2_net9 0.291128f
Cbud_s2_1894 x2_x1_net8 Vp 0.270831f
Cbud_s2_1895 x2_x1_net9 x2_x2_net1 0.363658f
Cbud_s2_1896 x2_x1_net9 x2_x2_net10 0.291128f
Cbud_s2_1897 x2_x1_net9 x2_x2_net11 0.324374f
Cbud_s2_1898 x2_x1_net9 x2_x2_net12 0.198671f
Cbud_s2_1899 x2_x1_net9 x2_x2_net13 0.18246f
Cbud_s2_1900 x2_x1_net9 x2_x2_net14 0.168155f
Cbud_s2_1901 x2_x1_net9 x2_x2_net15 0.155469f
Cbud_s2_1902 x2_x1_net9 x2_x2_net16 0.109362f
Cbud_s2_1903 x2_x1_net9 x2_x2_net17 0.116774f
Cbud_s2_1904 x2_x1_net9 x2_x2_net18 0.124967f
Cbud_s2_1905 x2_x1_net9 x2_x2_net19 0.134052f
Cbud_s2_1906 x2_x1_net9 x2_x2_net2 0.217143f
Cbud_s2_1907 x2_x1_net9 x2_x2_net3 0.144166f
Cbud_s2_1908 x2_x1_net9 x2_x2_net4 0.621876f
Cbud_s2_1909 x2_x1_net9 x2_x2_net5 0.536209f
Cbud_s2_1910 x2_x1_net9 x2_x2_net6 0.467098f
Cbud_s2_1911 x2_x1_net9 x2_x2_net7 0.410535f
Cbud_s2_1912 x2_x1_net9 x2_x2_net8 0.238315f
Cbud_s2_1913 x2_x1_net9 x2_x2_net9 0.262743f
Cbud_s2_1914 x2_x1_net9 Vp 0.246903f
Cbud_s2_1915 x2_x2_net1 x2_x2_net10 6.75515f
Cbud_s2_1916 x2_x2_net1 x2_x2_net11 6.75515f
Cbud_s2_1917 x2_x2_net1 x2_x2_net12 2.91936f
Cbud_s2_1918 x2_x2_net1 x2_x2_net13 2.14484f
Cbud_s2_1919 x2_x2_net1 x2_x2_net14 1.64214f
Cbud_s2_1920 x2_x2_net1 x2_x2_net15 1.29749f
Cbud_s2_1921 x2_x2_net1 x2_x2_net16 0.536209f
Cbud_s2_1922 x2_x2_net1 x2_x2_net17 0.621876f
Cbud_s2_1923 x2_x2_net1 x2_x2_net18 0.72984f
Cbud_s2_1924 x2_x2_net1 x2_x2_net19 0.86857f
Cbud_s2_1925 x2_x2_net1 x2_x2_net2 4.20388f
Cbud_s2_1926 x2_x2_net1 x2_x2_net3 1.05097f
Cbud_s2_1927 x2_x2_net1 x2_x2_net4 6.56856f
Cbud_s2_1928 x2_x2_net1 x2_x2_net5 6.75515f
Cbud_s2_1929 x2_x2_net1 x2_x2_net6 6.75515f
Cbud_s2_1930 x2_x2_net1 x2_x2_net7 6.75515f
Cbud_s2_1931 x2_x2_net1 x2_x2_net8 6.56856f
Cbud_s2_1932 x2_x2_net1 x2_x2_net9 6.75515f
Cbud_s2_1933 x2_x2_net1 Vm 0.616176f
Cbud_s2_1934 x2_x2_net10 x2_x2_net11 6.75515f
Cbud_s2_1935 x2_x2_net10 x2_x2_net12 6.56856f
Cbud_s2_1936 x2_x2_net10 x2_x2_net13 4.20388f
Cbud_s2_1937 x2_x2_net10 x2_x2_net14 2.91936f
Cbud_s2_1938 x2_x2_net10 x2_x2_net15 2.14484f
Cbud_s2_1939 x2_x2_net10 x2_x2_net16 0.72984f
Cbud_s2_1940 x2_x2_net10 x2_x2_net17 0.86857f
Cbud_s2_1941 x2_x2_net10 x2_x2_net18 1.05097f
Cbud_s2_1942 x2_x2_net10 x2_x2_net19 1.29749f
Cbud_s2_1943 x2_x2_net10 x2_x2_net2 6.75515f
Cbud_s2_1944 x2_x2_net10 x2_x2_net3 1.64214f
Cbud_s2_1945 x2_x2_net10 x2_x2_net4 2.91936f
Cbud_s2_1946 x2_x2_net10 x2_x2_net5 4.20388f
Cbud_s2_1947 x2_x2_net10 x2_x2_net6 6.56856f
Cbud_s2_1948 x2_x2_net10 x2_x2_net7 6.75515f
Cbud_s2_1949 x2_x2_net10 x2_x2_net8 6.75515f
Cbud_s2_1950 x2_x2_net10 x2_x2_net9 6.75515f
Cbud_s2_1951 x2_x2_net10 Vm 0.435172f
Cbud_s2_1952 x2_x2_net11 x2_x2_net12 4.20388f
Cbud_s2_1953 x2_x2_net11 x2_x2_net13 2.91936f
Cbud_s2_1954 x2_x2_net11 x2_x2_net14 2.14484f
Cbud_s2_1955 x2_x2_net11 x2_x2_net15 1.64214f
Cbud_s2_1956 x2_x2_net11 x2_x2_net16 0.621876f
Cbud_s2_1957 x2_x2_net11 x2_x2_net17 0.72984f
Cbud_s2_1958 x2_x2_net11 x2_x2_net18 0.86857f
Cbud_s2_1959 x2_x2_net11 x2_x2_net19 1.05097f
Cbud_s2_1960 x2_x2_net11 x2_x2_net2 6.56856f
Cbud_s2_1961 x2_x2_net11 x2_x2_net3 1.29749f
Cbud_s2_1962 x2_x2_net11 x2_x2_net4 4.20388f
Cbud_s2_1963 x2_x2_net11 x2_x2_net5 6.56856f
Cbud_s2_1964 x2_x2_net11 x2_x2_net6 6.75515f
Cbud_s2_1965 x2_x2_net11 x2_x2_net7 6.75515f
Cbud_s2_1966 x2_x2_net11 x2_x2_net8 6.75515f
Cbud_s2_1967 x2_x2_net11 x2_x2_net9 6.75515f
Cbud_s2_1968 x2_x2_net11 Vm 0.510574f
Cbud_s2_1969 x2_x2_net12 x2_x2_net13 6.75515f
Cbud_s2_1970 x2_x2_net12 x2_x2_net14 6.75515f
Cbud_s2_1971 x2_x2_net12 x2_x2_net15 6.75515f
Cbud_s2_1972 x2_x2_net12 x2_x2_net16 1.64214f
Cbud_s2_1973 x2_x2_net12 x2_x2_net17 2.14484f
Cbud_s2_1974 x2_x2_net12 x2_x2_net18 2.91936f
Cbud_s2_1975 x2_x2_net12 x2_x2_net19 4.20388f
Cbud_s2_1976 x2_x2_net12 x2_x2_net2 6.75515f
Cbud_s2_1977 x2_x2_net12 x2_x2_net3 6.56856f
Cbud_s2_1978 x2_x2_net12 x2_x2_net4 1.05097f
Cbud_s2_1979 x2_x2_net12 x2_x2_net5 1.29749f
Cbud_s2_1980 x2_x2_net12 x2_x2_net6 1.64214f
Cbud_s2_1981 x2_x2_net12 x2_x2_net7 2.14484f
Cbud_s2_1982 x2_x2_net12 x2_x2_net8 6.75515f
Cbud_s2_1983 x2_x2_net12 x2_x2_net9 6.75515f
Cbud_s2_1984 x2_x2_net12 Vm 0.270831f
Cbud_s2_1985 x2_x2_net13 x2_x2_net14 6.75515f
Cbud_s2_1986 x2_x2_net13 x2_x2_net15 6.75515f
Cbud_s2_1987 x2_x2_net13 x2_x2_net16 2.14484f
Cbud_s2_1988 x2_x2_net13 x2_x2_net17 2.91936f
Cbud_s2_1989 x2_x2_net13 x2_x2_net18 4.20388f
Cbud_s2_1990 x2_x2_net13 x2_x2_net19 6.56856f
Cbud_s2_1991 x2_x2_net13 x2_x2_net2 6.75515f
Cbud_s2_1992 x2_x2_net13 x2_x2_net3 6.75515f
Cbud_s2_1993 x2_x2_net13 x2_x2_net4 0.86857f
Cbud_s2_1994 x2_x2_net13 x2_x2_net5 1.05097f
Cbud_s2_1995 x2_x2_net13 x2_x2_net6 1.29749f
Cbud_s2_1996 x2_x2_net13 x2_x2_net7 1.64214f
Cbud_s2_1997 x2_x2_net13 x2_x2_net8 6.75515f
Cbud_s2_1998 x2_x2_net13 x2_x2_net9 6.56856f
Cbud_s2_1999 x2_x2_net13 Vm 0.246903f
Cbud_s2_2000 x2_x2_net14 x2_x2_net15 6.75515f
Cbud_s2_2001 x2_x2_net14 x2_x2_net16 2.91936f
Cbud_s2_2002 x2_x2_net14 x2_x2_net17 4.20388f
Cbud_s2_2003 x2_x2_net14 x2_x2_net18 6.56856f
Cbud_s2_2004 x2_x2_net14 x2_x2_net19 6.75515f
Cbud_s2_2005 x2_x2_net14 x2_x2_net2 6.75515f
Cbud_s2_2006 x2_x2_net14 x2_x2_net3 6.75515f
Cbud_s2_2007 x2_x2_net14 x2_x2_net4 0.72984f
Cbud_s2_2008 x2_x2_net14 x2_x2_net5 0.86857f
Cbud_s2_2009 x2_x2_net14 x2_x2_net6 1.05097f
Cbud_s2_2010 x2_x2_net14 x2_x2_net7 1.29749f
Cbud_s2_2011 x2_x2_net14 x2_x2_net8 6.56856f
Cbud_s2_2012 x2_x2_net14 x2_x2_net9 4.20388f
Cbud_s2_2013 x2_x2_net14 Vm 0.22667f
Cbud_s2_2014 x2_x2_net15 x2_x2_net16 4.20388f
Cbud_s2_2015 x2_x2_net15 x2_x2_net17 6.56856f
Cbud_s2_2016 x2_x2_net15 x2_x2_net18 6.75515f
Cbud_s2_2017 x2_x2_net15 x2_x2_net19 6.75515f
Cbud_s2_2018 x2_x2_net15 x2_x2_net2 6.56856f
Cbud_s2_2019 x2_x2_net15 x2_x2_net3 6.75515f
Cbud_s2_2020 x2_x2_net15 x2_x2_net4 0.621876f
Cbud_s2_2021 x2_x2_net15 x2_x2_net5 0.72984f
Cbud_s2_2022 x2_x2_net15 x2_x2_net6 0.86857f
Cbud_s2_2023 x2_x2_net15 x2_x2_net7 1.05097f
Cbud_s2_2024 x2_x2_net15 x2_x2_net8 4.20388f
Cbud_s2_2025 x2_x2_net15 x2_x2_net9 2.91936f
Cbud_s2_2026 x2_x2_net15 Vm 0.20934f
Cbud_s2_2027 x2_x2_net16 x2_x2_net17 6.75515f
Cbud_s2_2028 x2_x2_net16 x2_x2_net18 6.75515f
Cbud_s2_2029 x2_x2_net16 x2_x2_net19 6.75515f
Cbud_s2_2030 x2_x2_net16 x2_x2_net2 1.29749f
Cbud_s2_2031 x2_x2_net16 x2_x2_net3 6.56856f
Cbud_s2_2032 x2_x2_net16 x2_x2_net4 0.324374f
Cbud_s2_2033 x2_x2_net16 x2_x2_net5 0.363658f
Cbud_s2_2034 x2_x2_net16 x2_x2_net6 0.410535f
Cbud_s2_2035 x2_x2_net16 x2_x2_net7 0.467098f
Cbud_s2_2036 x2_x2_net16 x2_x2_net8 1.05097f
Cbud_s2_2037 x2_x2_net16 x2_x2_net9 0.86857f
Cbud_s2_2038 x2_x2_net16 Vm 0.150185f
Cbud_s2_2039 x2_x2_net17 x2_x2_net18 6.75515f
Cbud_s2_2040 x2_x2_net17 x2_x2_net19 6.75515f
Cbud_s2_2041 x2_x2_net17 x2_x2_net2 1.64214f
Cbud_s2_2042 x2_x2_net17 x2_x2_net3 6.75515f
Cbud_s2_2043 x2_x2_net17 x2_x2_net4 0.363658f
Cbud_s2_2044 x2_x2_net17 x2_x2_net5 0.410535f
Cbud_s2_2045 x2_x2_net17 x2_x2_net6 0.467098f
Cbud_s2_2046 x2_x2_net17 x2_x2_net7 0.536209f
Cbud_s2_2047 x2_x2_net17 x2_x2_net8 1.29749f
Cbud_s2_2048 x2_x2_net17 x2_x2_net9 1.05097f
Cbud_s2_2049 x2_x2_net17 Vm 0.159368f
Cbud_s2_2050 x2_x2_net18 x2_x2_net19 6.75515f
Cbud_s2_2051 x2_x2_net18 x2_x2_net2 2.14484f
Cbud_s2_2052 x2_x2_net18 x2_x2_net3 6.75515f
Cbud_s2_2053 x2_x2_net18 x2_x2_net4 0.410535f
Cbud_s2_2054 x2_x2_net18 x2_x2_net5 0.467098f
Cbud_s2_2055 x2_x2_net18 x2_x2_net6 0.536209f
Cbud_s2_2056 x2_x2_net18 x2_x2_net7 0.621876f
Cbud_s2_2057 x2_x2_net18 x2_x2_net8 1.64214f
Cbud_s2_2058 x2_x2_net18 x2_x2_net9 1.29749f
Cbud_s2_2059 x2_x2_net18 Vm 0.169642f
Cbud_s2_2060 x2_x2_net19 x2_x2_net2 2.91936f
Cbud_s2_2061 x2_x2_net19 x2_x2_net3 6.75515f
Cbud_s2_2062 x2_x2_net19 x2_x2_net4 0.467098f
Cbud_s2_2063 x2_x2_net19 x2_x2_net5 0.536209f
Cbud_s2_2064 x2_x2_net19 x2_x2_net6 0.621876f
Cbud_s2_2065 x2_x2_net19 x2_x2_net7 0.72984f
Cbud_s2_2066 x2_x2_net19 x2_x2_net8 2.14484f
Cbud_s2_2067 x2_x2_net19 x2_x2_net9 1.64214f
Cbud_s2_2068 x2_x2_net19 Vm 0.18121f
Cbud_s2_2069 x2_x2_net2 x2_x2_net3 4.20388f
Cbud_s2_2070 x2_x2_net2 x2_x2_net4 1.29749f
Cbud_s2_2071 x2_x2_net2 x2_x2_net5 1.64214f
Cbud_s2_2072 x2_x2_net2 x2_x2_net6 2.14484f
Cbud_s2_2073 x2_x2_net2 x2_x2_net7 2.91936f
Cbud_s2_2074 x2_x2_net2 x2_x2_net8 6.75515f
Cbud_s2_2075 x2_x2_net2 x2_x2_net9 6.75515f
Cbud_s2_2076 x2_x2_net2 Vm 0.299563f
Cbud_s2_2077 x2_x2_net3 x2_x2_net4 0.536209f
Cbud_s2_2078 x2_x2_net3 x2_x2_net5 0.621876f
Cbud_s2_2079 x2_x2_net3 x2_x2_net6 0.72984f
Cbud_s2_2080 x2_x2_net3 x2_x2_net7 0.86857f
Cbud_s2_2081 x2_x2_net3 x2_x2_net8 2.91936f
Cbud_s2_2082 x2_x2_net3 x2_x2_net9 2.14484f
Cbud_s2_2083 x2_x2_net3 Vm 0.194332f
Cbud_s2_2084 x2_x2_net4 x2_x2_net5 6.75515f
Cbud_s2_2085 x2_x2_net4 x2_x2_net6 6.75515f
Cbud_s2_2086 x2_x2_net4 x2_x2_net7 6.75515f
Cbud_s2_2087 x2_x2_net4 x2_x2_net8 1.64214f
Cbud_s2_2088 x2_x2_net4 x2_x2_net9 2.14484f
Cbud_s2_2089 x2_x2_net4 Vm 1.19379f
Cbud_s2_2090 x2_x2_net5 x2_x2_net6 6.75515f
Cbud_s2_2091 x2_x2_net5 x2_x2_net7 6.75515f
Cbud_s2_2092 x2_x2_net5 x2_x2_net8 2.14484f
Cbud_s2_2093 x2_x2_net5 x2_x2_net9 2.91936f
Cbud_s2_2094 x2_x2_net5 Vm 1.19379f
Cbud_s2_2095 x2_x2_net6 x2_x2_net7 6.75515f
Cbud_s2_2096 x2_x2_net6 x2_x2_net8 2.91936f
Cbud_s2_2097 x2_x2_net6 x2_x2_net9 4.20388f
Cbud_s2_2098 x2_x2_net6 Vm 1.03878f
Cbud_s2_2099 x2_x2_net7 x2_x2_net8 4.20388f
Cbud_s2_2100 x2_x2_net7 x2_x2_net9 6.56856f
Cbud_s2_2101 x2_x2_net7 Vm 0.774629f
Cbud_s2_2102 x2_x2_net8 x2_x2_net9 6.75515f
Cbud_s2_2103 x2_x2_net8 Vm 0.3347f
Cbud_s2_2104 x2_x2_net9 Vm 0.378645f
XM32 s1r_XM32_d PBias s1r_XM32_s Vdd sky130_fd_pr__pfet_01v8_lvt L=1 W=5 NF=1 AD=1.45 AS=1.45 PD=10.58 PS=10.58 NRD=0.058 NRS=0.058 SA=0 SB=0 SD=0 MULT=2 M=2
Rpar_s1_XM32_s s1r_XM32_s Vdd 0.0731619
Rpar_s1_XM32_d s1r_XM32_d NBias 4.04132
XM33 NBias NBias Vss Vss sky130_fd_pr__nfet_01v8_lvt L=2 W=5 NF=1 AD=1.45 AS=1.45 PD=10.58 PS=10.58 NRD=0.058 NRS=0.058 SA=0 SB=0 SD=0 MULT=2 M=2
XM34 net1 s1r_XM34_g Vdd Vdd sky130_fd_pr__pfet_01v8_lvt L=1 W=5 NF=1 AD=1.45 AS=1.45 PD=10.58 PS=10.58 NRD=0.058 NRS=0.058 SA=0 SB=0 SD=0 MULT=2 M=2
Rpar_s1_XM34_g s1r_XM34_g PBias 374.943
XM35 s1r_XM35_d net1 s1r_XM35_s Vss sky130_fd_pr__nfet_01v8_lvt L=1 W=10 NF=1 AD=2.9 AS=2.9 PD=20.58 PS=20.58 NRD=0.029 NRS=0.029 SA=0 SB=0 SD=0 MULT=2 M=2
Rpar_s1_XM35_s s1r_XM35_s Rgm 0.0531088
Rpar_s1_XM35_d s1r_XM35_d net1 4.24339
XM36 net2 net1 Vss Vss sky130_fd_pr__nfet_01v8_lvt L=2 W=5 NF=1 AD=1.45 AS=1.45 PD=10.58 PS=10.58 NRD=0.058 NRS=0.058 SA=0 SB=0 SD=0 MULT=2 M=2
XM37 s1r_XM37_d NBias s1r_XM37_s Vss sky130_fd_pr__nfet_01v8_lvt L=2 W=5 NF=1 AD=1.45 AS=1.45 PD=10.58 PS=10.58 NRD=0.058 NRS=0.058 SA=0 SB=0 SD=0 MULT=2 M=2
Rpar_s1_XM37_s s1r_XM37_s Vss 0.044179
Rpar_s1_XM37_d s1r_XM37_d PBias 3.85763
XM38 PBias net2 Vdd Vdd sky130_fd_pr__pfet_01v8_lvt L=1 W=5 NF=1 AD=1.45 AS=1.45 PD=10.58 PS=10.58 NRD=0.058 NRS=0.058 SA=0 SB=0 SD=0 MULT=2 M=2
XM39 net2 net2 Vdd Vdd sky130_fd_pr__pfet_01v8_lvt L=1 W=5 NF=1 AD=1.45 AS=1.45 PD=10.58 PS=10.58 NRD=0.058 NRS=0.058 SA=0 SB=0 SD=0 MULT=2 M=2
XM40 PBias net3 NBias Vss sky130_fd_pr__nfet_01v8_lvt L=1 W=2 NF=1 AD=0.58 AS=0.58 PD=4.58 PS=4.58 NRD=0.145 NRS=0.145 SA=0 SB=0 SD=0 MULT=1
XM41 net3 NBias Vss Vss sky130_fd_pr__nfet_01v8_lvt L=2 W=5 NF=1 AD=1.45 AS=1.45 PD=10.58 PS=10.58 NRD=0.058 NRS=0.058 SA=0 SB=0 SD=0 MULT=2 M=2
XM42 net3 net3 Vdd Vdd sky130_fd_pr__pfet_01v8_lvt L=20 W=1 NF=1 AD=0.29 AS=0.29 PD=2.58 PS=2.58 NRD=0.29 NRS=0.29 SA=0 SB=0 SD=0 MULT=2 M=2
XM43 s1r_XM43_d PBias s1r_XM43_s Vdd sky130_fd_pr__pfet_01v8_lvt L=1 W=5 NF=1 AD=1.45 AS=1.45 PD=10.58 PS=10.58 NRD=0.058 NRS=0.058 SA=0 SB=0 SD=0 MULT=2 M=2
Rpar_s1_XM43_s s1r_XM43_s Vdd 0.249526
Rpar_s1_XM43_d s1r_XM43_d net4 17.6677
XM44 s1r_XM44_d PBias s1r_XM44_s Vdd sky130_fd_pr__pfet_01v8_lvt L=1 W=5 NF=1 AD=1.45 AS=1.45 PD=10.58 PS=10.58 NRD=0.058 NRS=0.058 SA=0 SB=0 SD=0 MULT=2 M=2
Rpar_s1_XM44_s s1r_XM44_s Vdd 0.0345131
Rpar_s1_XM44_d s1r_XM44_d net5 2.02066
XM45 s1r_XM45_d PBias s1r_XM45_s Vdd sky130_fd_pr__pfet_01v8_lvt L=1 W=5 NF=1 AD=1.45 AS=1.45 PD=10.58 PS=10.58 NRD=0.058 NRS=0.058 SA=0 SB=0 SD=0 MULT=2 M=2
Rpar_s1_XM45_s s1r_XM45_s Vdd 0.304186
Rpar_s1_XM45_d s1r_XM45_d net6 30.1823
XM54 net7 PBias Vdd Vdd sky130_fd_pr__pfet_01v8_lvt L=1 W=5 NF=1 AD=1.45 AS=1.45 PD=10.58 PS=10.58 NRD=0.058 NRS=0.058 SA=0 SB=0 SD=0 MULT=2 M=2
XX1_M5 s1r_XX1_M5_d s1r_XX1_M5_g s1r_XX1_M5_s Vss sky130_fd_pr__nfet_01v8_lvt L=4 W=4 NF=1 AD=1.16 AS=1.16 PD=8.58 PS=8.58 NRD=0.0725 NRS=0.0725 SA=0 SB=0 SD=0 MULT=2 M=2
Rpar_s1_XX1_M5_s s1r_XX1_M5_s x1_net2 0.15575
Rpar_s1_XX1_M5_g s1r_XX1_M5_g Vm 11.7875
Rpar_s1_XX1_M5_d s1r_XX1_M5_d x1_Vtest2 31.8624
XX1_M6 s1r_XX1_M6_d s1r_XX1_M6_g s1r_XX1_M6_s Vss sky130_fd_pr__nfet_01v8_lvt L=4 W=4 NF=1 AD=1.16 AS=1.16 PD=8.58 PS=8.58 NRD=0.0725 NRS=0.0725 SA=0 SB=0 SD=0 MULT=2 M=2
Rpar_s1_XX1_M6_s s1r_XX1_M6_s x1_net2 0.15575
Rpar_s1_XX1_M6_g s1r_XX1_M6_g Vp 11.7875
Rpar_s1_XX1_M6_d s1r_XX1_M6_d x1_net1 31.8624
XX1_M11 s1r_XX1_M11_d x1_Vbias s1r_XX1_M11_s Vdd sky130_fd_pr__pfet_01v8_lvt L=5 W=2 NF=1 AD=0.58 AS=0.58 PD=4.58 PS=4.58 NRD=0.145 NRS=0.145 SA=0 SB=0 SD=0 MULT=2 M=2
Rpar_s1_XX1_M11_s s1r_XX1_M11_s x1_Vtest2 4.73539
Rpar_s1_XX1_M11_d s1r_XX1_M11_d Vop1 4.04657
XX1_M12 s1r_XX1_M12_d x1_Vbias s1r_XX1_M12_s Vdd sky130_fd_pr__pfet_01v8_lvt L=5 W=2 NF=1 AD=0.58 AS=0.58 PD=4.58 PS=4.58 NRD=0.145 NRS=0.145 SA=0 SB=0 SD=0 MULT=2 M=2
Rpar_s1_XX1_M12_s s1r_XX1_M12_s x1_net1 4.73534
Rpar_s1_XX1_M12_d s1r_XX1_M12_d Vom1 4.04657
XX1_M13 s1r_XX1_M13_d x1_Vout Vdd Vdd sky130_fd_pr__pfet_01v8_lvt L=5 W=2 NF=1 AD=0.58 AS=0.58 PD=4.58 PS=4.58 NRD=0.145 NRS=0.145 SA=0 SB=0 SD=0 MULT=4 M=4
Rpar_s1_XX1_M13_d s1r_XX1_M13_d x1_Vtest2 2.1761
XX1_M14 s1r_XX1_M14_d x1_Vout Vdd Vdd sky130_fd_pr__pfet_01v8_lvt L=5 W=2 NF=1 AD=0.58 AS=0.58 PD=4.58 PS=4.58 NRD=0.145 NRS=0.145 SA=0 SB=0 SD=0 MULT=4 M=4
Rpar_s1_XX1_M14_d s1r_XX1_M14_d x1_net1 2.1761
XX1_M19 x1_net2 net5 s1r_XX1_M19_s Vss sky130_fd_pr__nfet_01v8_lvt L=1 W=1 NF=1 AD=0.29 AS=0.29 PD=2.58 PS=2.58 NRD=0.29 NRS=0.29 SA=0 SB=0 SD=0 MULT=2 M=2
Rpar_s1_XX1_M19_s s1r_XX1_M19_s x1_net3 31.4945
XX1_M1 s1r_XX1_M1_d s1r_XX1_M1_g s1r_XX1_M1_s Vss sky130_fd_pr__nfet_01v8_lvt L=10 W=1 NF=1 AD=0.29 AS=0.29 PD=2.58 PS=2.58 NRD=0.29 NRS=0.29 SA=0 SB=0 SD=0 MULT=2 M=2
Rpar_s1_XX1_M1_s s1r_XX1_M1_s Vss 0.832037
Rpar_s1_XX1_M1_g s1r_XX1_M1_g net4 91.5532
Rpar_s1_XX1_M1_d s1r_XX1_M1_d x1_net3 31.4945
XX1_M2 s1r_XX1_M2_d s1r_XX1_M2_g s1r_XX1_M2_s Vss sky130_fd_pr__nfet_01v8_lvt L=10 W=1 NF=1 AD=0.29 AS=0.29 PD=2.58 PS=2.58 NRD=0.29 NRS=0.29 SA=0 SB=0 SD=0 MULT=2 M=2
Rpar_s1_XX1_M2_s s1r_XX1_M2_s Vss 0.832037
Rpar_s1_XX1_M2_g s1r_XX1_M2_g net4 91.5532
Rpar_s1_XX1_M2_d s1r_XX1_M2_d x1_net4 31.4945
XX1_M3 x1_net2 s1r_XX1_M3_g s1r_XX1_M3_s Vss sky130_fd_pr__nfet_01v8_lvt L=1 W=1 NF=1 AD=0.29 AS=0.29 PD=2.58 PS=2.58 NRD=0.29 NRS=0.29 SA=0 SB=0 SD=0 MULT=2 M=2
Rpar_s1_XX1_M3_s s1r_XX1_M3_s x1_net4 31.4945
Rpar_s1_XX1_M3_g s1r_XX1_M3_g net5 257.11
XX1_M4 s1r_XX1_M4_d net5 x1_net5 Vss sky130_fd_pr__nfet_01v8_lvt L=1 W=1 NF=1 AD=0.29 AS=0.29 PD=2.58 PS=2.58 NRD=0.29 NRS=0.29 SA=0 SB=0 SD=0 MULT=2 M=2
Rpar_s1_XX1_M4_d s1r_XX1_M4_d Vop1 3.53616
XX1_M7 x1_net5 s1r_XX1_M7_g Vss Vss sky130_fd_pr__nfet_01v8_lvt L=10 W=1 NF=1 AD=0.29 AS=0.29 PD=2.58 PS=2.58 NRD=0.29 NRS=0.29 SA=0 SB=0 SD=0 MULT=2 M=2
Rpar_s1_XX1_M7_g s1r_XX1_M7_g net4 91.5532
XX1_M8 s1r_XX1_M8_d net5 x1_net6 Vss sky130_fd_pr__nfet_01v8_lvt L=1 W=1 NF=1 AD=0.29 AS=0.29 PD=2.58 PS=2.58 NRD=0.29 NRS=0.29 SA=0 SB=0 SD=0 MULT=2 M=2
Rpar_s1_XX1_M8_d s1r_XX1_M8_d Vom1 3.53616
XX1_M9 x1_net6 s1r_XX1_M9_g Vss Vss sky130_fd_pr__nfet_01v8_lvt L=10 W=1 NF=1 AD=0.29 AS=0.29 PD=2.58 PS=2.58 NRD=0.29 NRS=0.29 SA=0 SB=0 SD=0 MULT=2 M=2
Rpar_s1_XX1_M9_g s1r_XX1_M9_g net4 91.5532
XX1_M10 s1r_XX1_M10_d s1r_XX1_M10_g s1r_XX1_M10_s Vss sky130_fd_pr__nfet_01v8_lvt L=20 W=5 NF=1 AD=1.45 AS=1.45 PD=10.58 PS=10.58 NRD=0.058 NRS=0.058 SA=0 SB=0 SD=0 MULT=2 M=2
Rpar_s1_XX1_M10_s s1r_XX1_M10_s x1_net8 229.859
Rpar_s1_XX1_M10_g s1r_XX1_M10_g Vref 20.6457
Rpar_s1_XX1_M10_d s1r_XX1_M10_d x1_Vout 229.859
XX1_M17 s1r_XX1_M17_d s1r_XX1_M17_g s1r_XX1_M17_s Vss sky130_fd_pr__nfet_01v8_lvt L=20 W=5 NF=1 AD=1.45 AS=1.45 PD=10.58 PS=10.58 NRD=0.058 NRS=0.058 SA=0 SB=0 SD=0 MULT=2 M=2
Rpar_s1_XX1_M17_s s1r_XX1_M17_s x1_net8 229.859
Rpar_s1_XX1_M17_g s1r_XX1_M17_g Vop1 20.6457
Rpar_s1_XX1_M17_d s1r_XX1_M17_d x1_net9 229.859
XX1_M18 s1r_XX1_M18_d s1r_XX1_M18_g s1r_XX1_M18_s Vss sky130_fd_pr__nfet_01v8_lvt L=20 W=5 NF=1 AD=1.45 AS=1.45 PD=10.58 PS=10.58 NRD=0.058 NRS=0.058 SA=0 SB=0 SD=0 MULT=2 M=2
Rpar_s1_XX1_M18_s s1r_XX1_M18_s x1_net7 229.859
Rpar_s1_XX1_M18_g s1r_XX1_M18_g Vom1 20.6457
Rpar_s1_XX1_M18_d s1r_XX1_M18_d x1_net9 229.859
XX1_M22 s1r_XX1_M22_d s1r_XX1_M22_g Vss Vss sky130_fd_pr__nfet_01v8_lvt L=20 W=1 NF=1 AD=0.29 AS=0.29 PD=2.58 PS=2.58 NRD=0.29 NRS=0.29 SA=0 SB=0 SD=0 MULT=2 M=2
Rpar_s1_XX1_M22_g s1r_XX1_M22_g net4 128.202
Rpar_s1_XX1_M22_d s1r_XX1_M22_d x1_net7 452.712
XX1_M20 s1r_XX1_M20_d x1_net9 Vdd Vdd sky130_fd_pr__pfet_01v8_lvt L=10 W=1 NF=1 AD=0.29 AS=0.29 PD=2.58 PS=2.58 NRD=0.29 NRS=0.29 SA=0 SB=0 SD=0 MULT=2 M=2
Rpar_s1_XX1_M20_d s1r_XX1_M20_d x1_net9 1076.52
XX1_M21 s1r_XX1_M21_d x1_net9 Vdd Vdd sky130_fd_pr__pfet_01v8_lvt L=10 W=1 NF=1 AD=0.29 AS=0.29 PD=2.58 PS=2.58 NRD=0.29 NRS=0.29 SA=0 SB=0 SD=0 MULT=2 M=2
Rpar_s1_XX1_M21_d s1r_XX1_M21_d x1_Vout 1076.52
XX1_M15 s1r_XX1_M15_d s1r_XX1_M15_g Vss Vss sky130_fd_pr__nfet_01v8_lvt L=20 W=1 NF=1 AD=0.29 AS=0.29 PD=2.58 PS=2.58 NRD=0.29 NRS=0.29 SA=0 SB=0 SD=0 MULT=2 M=2
Rpar_s1_XX1_M15_g s1r_XX1_M15_g net4 128.202
Rpar_s1_XX1_M15_d s1r_XX1_M15_d x1_net8 452.712
XX1_M16 s1r_XX1_M16_d s1r_XX1_M16_g s1r_XX1_M16_s Vss sky130_fd_pr__nfet_01v8_lvt L=20 W=5 NF=1 AD=1.45 AS=1.45 PD=10.58 PS=10.58 NRD=0.058 NRS=0.058 SA=0 SB=0 SD=0 MULT=2 M=2
Rpar_s1_XX1_M16_s s1r_XX1_M16_s x1_net7 229.859
Rpar_s1_XX1_M16_g s1r_XX1_M16_g Vref 20.6457
Rpar_s1_XX1_M16_d s1r_XX1_M16_d x1_Vout 229.859
XX1_M46 net4 net4 Vss Vss sky130_fd_pr__nfet_01v8_lvt L=2 W=1 NF=1 AD=0.29 AS=0.29 PD=2.58 PS=2.58 NRD=0.29 NRS=0.29 SA=0 SB=0 SD=0 MULT=2 M=2
XX1_M47 net5 net5 Vss Vss sky130_fd_pr__nfet_01v8_lvt L=5 W=0.6 NF=1 AD=0.174 AS=0.174 PD=1.78 PS=1.78 NRD=0.483333 NRS=0.483333 SA=0 SB=0 SD=0 MULT=2 M=2
XX1_M23 net6 net6 s1r_XX1_M23_s Vss sky130_fd_pr__nfet_01v8_lvt L=1 W=0.6 NF=1 AD=0.174 AS=0.174 PD=1.78 PS=1.78 NRD=0.483333 NRS=0.483333 SA=0 SB=0 SD=0 MULT=2 M=2
Rpar_s1_XX1_M23_s s1r_XX1_M23_s Vss 3.85763
XX1_M24 x1_Vbias net6 s1r_XX1_M24_s Vss sky130_fd_pr__nfet_01v8_lvt L=1 W=0.6 NF=1 AD=0.174 AS=0.174 PD=1.78 PS=1.78 NRD=0.483333 NRS=0.483333 SA=0 SB=0 SD=0 MULT=2 M=2
Rpar_s1_XX1_M24_s s1r_XX1_M24_s Vss 3.85763
XX1_M25 x1_Vbias x1_Vbias Vdd Vdd sky130_fd_pr__pfet_01v8_lvt L=10 W=1.5 NF=1 AD=0.435 AS=0.435 PD=3.58 PS=3.58 NRD=0.193333 NRS=0.193333 SA=0 SB=0 SD=0 MULT=2 M=2
XX2_M9 s1r_XX2_M9_d Vom1 s1r_XX2_M9_s Vdd sky130_fd_pr__pfet_01v8_lvt L=1 W=2 NF=1 AD=0.58 AS=0.58 PD=4.58 PS=4.58 NRD=0.145 NRS=0.145 SA=0 SB=0 SD=0 MULT=9 M=9
Rpar_s1_XX2_M9_s s1r_XX2_M9_s Vdd 0.00934471
Rpar_s1_XX2_M9_d s1r_XX2_M9_d Vop 0.0746826
XX2_M4 s1r_XX2_M4_d Vop1 s1r_XX2_M4_s Vdd sky130_fd_pr__pfet_01v8_lvt L=1 W=2 NF=1 AD=0.58 AS=0.58 PD=4.58 PS=4.58 NRD=0.145 NRS=0.145 SA=0 SB=0 SD=0 MULT=9 M=9
Rpar_s1_XX2_M4_s s1r_XX2_M4_s Vdd 0.00934471
Rpar_s1_XX2_M4_d s1r_XX2_M4_d Vom 0.0746827
XX2_M2 s1r_XX2_M2_d s1r_XX2_M2_g Vss Vss sky130_fd_pr__nfet_01v8_lvt L=1 W=1 NF=1 AD=0.29 AS=0.29 PD=2.58 PS=2.58 NRD=0.29 NRS=0.29 SA=0 SB=0 SD=0 MULT=9 M=9
Rpar_s1_XX2_M2_g s1r_XX2_M2_g x2_Vout 149.983
Rpar_s1_XX2_M2_d s1r_XX2_M2_d Vop 0.426471
XX2_M1 s1r_XX2_M1_d s1r_XX2_M1_g Vss Vss sky130_fd_pr__nfet_01v8_lvt L=1 W=1 NF=1 AD=0.29 AS=0.29 PD=2.58 PS=2.58 NRD=0.29 NRS=0.29 SA=0 SB=0 SD=0 MULT=9 M=9
Rpar_s1_XX2_M1_g s1r_XX2_M1_g x2_Vout 149.983
Rpar_s1_XX2_M1_d s1r_XX2_M1_d Vom 0.426471
XX2_M3 x2_net1 x2_Vbiasp Vdd Vdd sky130_fd_pr__pfet_01v8_lvt L=5 W=1 NF=1 AD=0.29 AS=0.29 PD=2.58 PS=2.58 NRD=0.29 NRS=0.29 SA=0 SB=0 SD=0 MULT=2 M=2
XX2_M7 x2_Vtest x2_Vcm x2_net1 Vdd sky130_fd_pr__pfet_01v8_lvt L=10 W=1 NF=1 AD=0.29 AS=0.29 PD=2.58 PS=2.58 NRD=0.29 NRS=0.29 SA=0 SB=0 SD=0 MULT=2 M=2
XX2_M8 x2_Vout Vref x2_net1 Vdd sky130_fd_pr__pfet_01v8_lvt L=10 W=1 NF=1 AD=0.29 AS=0.29 PD=2.58 PS=2.58 NRD=0.29 NRS=0.29 SA=0 SB=0 SD=0 MULT=2 M=2
XX2_M5 x2_Vtest x2_Vtest Vss Vss sky130_fd_pr__nfet_01v8_lvt L=20 W=0.5 NF=1 AD=0.145 AS=0.145 PD=1.58 PS=1.58 NRD=0.58 NRS=0.58 SA=0 SB=0 SD=0 MULT=2 M=2
XX2_M6 x2_Vout x2_Vtest Vss Vss sky130_fd_pr__nfet_01v8_lvt L=20 W=0.5 NF=1 AD=0.145 AS=0.145 PD=1.58 PS=1.58 NRD=0.58 NRS=0.58 SA=0 SB=0 SD=0 MULT=2 M=2
XX2_M10 net7 net7 Vss Vss sky130_fd_pr__nfet_01v8_lvt L=1 W=0.6 NF=1 AD=0.174 AS=0.174 PD=1.78 PS=1.78 NRD=0.483333 NRS=0.483333 SA=0 SB=0 SD=0 MULT=2 M=2
XX2_M11 x2_Vbiasp net7 Vss Vss sky130_fd_pr__nfet_01v8_lvt L=1 W=0.6 NF=1 AD=0.174 AS=0.174 PD=1.78 PS=1.78 NRD=0.483333 NRS=0.483333 SA=0 SB=0 SD=0 MULT=2 M=2
XX2_M12 x2_Vbiasp x2_Vbiasp Vdd Vdd sky130_fd_pr__pfet_01v8_lvt L=1 W=6 NF=1 AD=1.74 AS=1.74 PD=12.58 PS=12.58 NRD=0.0483333 NRS=0.0483333 SA=0 SB=0 SD=0 MULT=2 M=2
Vref_ext Vref Vss 0.9
XC1 Vop1 Vom sky130_fd_pr__cap_mim_m3_1 W=10 L=10 MF=5 M=5
XC2 Vom1 Vop sky130_fd_pr__cap_mim_m3_1 W=10 L=10 MF=5 M=5
XX2_X1_R1 x2_x1_net4 Vop sky130_fd_pr__res_generic_po W=0.5 L=40
XX2_X1_R2 x2_x1_net5 x2_x1_net4 sky130_fd_pr__res_generic_po W=0.5 L=40
XX2_X1_R3 x2_x1_net6 x2_x1_net5 sky130_fd_pr__res_generic_po W=0.5 L=40
XX2_X1_R4 x2_x1_net7 x2_x1_net6 sky130_fd_pr__res_generic_po W=0.5 L=40
XX2_X1_R5 x2_x1_net1 x2_x1_net7 sky130_fd_pr__res_generic_po W=0.5 L=40
XX2_X1_R6 x2_x1_net8 x2_x1_net2 sky130_fd_pr__res_generic_po W=0.5 L=40
XX2_X1_R7 x2_x1_net9 x2_x1_net8 sky130_fd_pr__res_generic_po W=0.5 L=40
XX2_X1_R8 x2_x1_net10 x2_x1_net9 sky130_fd_pr__res_generic_po W=0.5 L=40
XX2_X1_R9 x2_x1_net11 x2_x1_net10 sky130_fd_pr__res_generic_po W=0.5 L=40
XX2_X1_R10 x2_x1_net1 x2_x1_net11 sky130_fd_pr__res_generic_po W=0.5 L=40
XX2_X1_R11 x2_x1_net12 x2_x1_net2 sky130_fd_pr__res_generic_po W=0.5 L=40
XX2_X1_R12 x2_x1_net13 x2_x1_net12 sky130_fd_pr__res_generic_po W=0.5 L=40
XX2_X1_R13 x2_x1_net14 x2_x1_net13 sky130_fd_pr__res_generic_po W=0.5 L=40
XX2_X1_R14 x2_x1_net15 x2_x1_net14 sky130_fd_pr__res_generic_po W=0.5 L=40
XX2_X1_R16 x2_x1_net16 x2_Vcm sky130_fd_pr__res_generic_po W=0.5 L=40
XX2_X1_R17 x2_x1_net17 x2_x1_net16 sky130_fd_pr__res_generic_po W=0.5 L=40
XX2_X1_R18 x2_x1_net18 x2_x1_net17 sky130_fd_pr__res_generic_po W=0.5 L=40
XX2_X1_R19 x2_x1_net19 x2_x1_net18 sky130_fd_pr__res_generic_po W=0.5 L=40
XX2_X1_R20 x2_x1_net3 x2_x1_net19 sky130_fd_pr__res_generic_po W=0.5 L=40
XX2_X1_R15 x2_x1_net3 x2_x1_net15 sky130_fd_pr__res_generic_po W=0.5 L=40
XX2_X2_R1 x2_x2_net4 x2_Vcm sky130_fd_pr__res_generic_po W=0.5 L=40
XX2_X2_R2 x2_x2_net5 x2_x2_net4 sky130_fd_pr__res_generic_po W=0.5 L=40
XX2_X2_R3 x2_x2_net6 x2_x2_net5 sky130_fd_pr__res_generic_po W=0.5 L=40
XX2_X2_R4 x2_x2_net7 x2_x2_net6 sky130_fd_pr__res_generic_po W=0.5 L=40
XX2_X2_R5 x2_x2_net1 x2_x2_net7 sky130_fd_pr__res_generic_po W=0.5 L=40
XX2_X2_R6 x2_x2_net8 x2_x2_net2 sky130_fd_pr__res_generic_po W=0.5 L=40
XX2_X2_R7 x2_x2_net9 x2_x2_net8 sky130_fd_pr__res_generic_po W=0.5 L=40
XX2_X2_R8 x2_x2_net10 x2_x2_net9 sky130_fd_pr__res_generic_po W=0.5 L=40
XX2_X2_R9 x2_x2_net11 x2_x2_net10 sky130_fd_pr__res_generic_po W=0.5 L=40
XX2_X2_R10 x2_x2_net1 x2_x2_net11 sky130_fd_pr__res_generic_po W=0.5 L=40
XX2_X2_R11 x2_x2_net12 x2_x2_net2 sky130_fd_pr__res_generic_po W=0.5 L=40
XX2_X2_R12 x2_x2_net13 x2_x2_net12 sky130_fd_pr__res_generic_po W=0.5 L=40
XX2_X2_R13 x2_x2_net14 x2_x2_net13 sky130_fd_pr__res_generic_po W=0.5 L=40
XX2_X2_R14 x2_x2_net15 x2_x2_net14 sky130_fd_pr__res_generic_po W=0.5 L=40
XX2_X2_R16 x2_x2_net16 Vom sky130_fd_pr__res_generic_po W=0.5 L=40
XX2_X2_R17 x2_x2_net17 x2_x2_net16 sky130_fd_pr__res_generic_po W=0.5 L=40
XX2_X2_R18 x2_x2_net18 x2_x2_net17 sky130_fd_pr__res_generic_po W=0.5 L=40
XX2_X2_R19 x2_x2_net19 x2_x2_net18 sky130_fd_pr__res_generic_po W=0.5 L=40
XX2_X2_R20 x2_x2_net3 x2_x2_net19 sky130_fd_pr__res_generic_po W=0.5 L=40
XX2_X2_R15 x2_x2_net3 x2_x2_net15 sky130_fd_pr__res_generic_po W=0.5 L=40
Rgm_ext Rgm Vss 12000
.ends ttsky25a_fd
.end
