* ttsky25a_fd on dido_amp_NOISE
.lib $PDK_ROOT/sky130A/libs.tech/combined/sky130.lib.spice tt
.param VDD_V=1.8 VCM_V=0.9 CL_F=529f
.temp 27

**.subckt dido_amp_NOISE
x1 INP INN OUTN VDD 0 OUTP dut_amp
Vsup VDD 0 'VDD_V'
* AC drive through 1 F couplers; DC set by unity feedback through 1 GH chokes (OUTP->INN, OUTN->INP)
Vacp ACP 0 dc 0 ac 1
Vacn ACN 0 dc 0 ac 0
Cinp ACP INP 1
Cinn ACN INN 1
Lfbp OUTP INN 1G
Lfbn OUTN INP 1G
Cloadp OUTP 0 'CL_F'
Cloadn OUTN 0 'CL_F'
.control
  save all
  let npd    = 20
  let fstart = 1
  let fspot  = 1e3
  noise v(OUTP,OUTN) Vacp dec 20 1 1e9
  setplot noise1
  let idx = npd * log10(fspot/fstart)
  let vnoise_nv_rthz = inoise_spectrum[$&idx] * 1e9
  echo MEAS vnoise_nv_rthz $&vnoise_nv_rthz
  write
  set appendwrite
  setplot noise2
  let vnoise_rms_uv_rms = inoise_total * 1e6
  echo MEAS vnoise_rms_uv_rms $&vnoise_rms_uv_rms
  write
  quit 0
.endc
**.ends

.subckt dut_amp INP INN OUTN VDD VSS OUTP
XDUT OUTP INN VDD VSS OUTN INP ttsky25a_fd
.ends

.subckt ttsky25a_fd Vop Vm Vdd Vss Vom Vp
Cbud_s2_0 NBias Vss 137.46f
Cbud_s2_1 PBias Vss 184.089f
Cbud_s2_2 Rgm Vss 26.5503f
Cbud_s2_3 Vom Vss 2.64543f
Cbud_s2_4 Vom1 Vss 6.64227f
Cbud_s2_5 Vop Vss 2.64543f
Cbud_s2_6 Vop1 Vss 6.64227f
Cbud_s2_7 net1 Vss 100.233f
Cbud_s2_8 net2 Vss 84.0051f
Cbud_s2_9 net3 Vss 219.308f
Cbud_s2_10 net4 Vss 308.127f
Cbud_s2_11 net5 Vss 2.90944f
Cbud_s2_12 net6 Vss 52.1349f
Cbud_s2_13 net7 Vss 52.1349f
Cbud_s2_14 x1_Vbias Vss 4.96555f
Cbud_s2_15 x1_Vout Vss 284.122f
Cbud_s2_16 x1_Vtest2 Vss 0.88425f
Cbud_s2_17 x1_net1 Vss 0.88425f
Cbud_s2_18 x1_net2 Vss 33.2107f
Cbud_s2_19 x1_net3 Vss 15.0919f
Cbud_s2_20 x1_net4 Vss 15.0875f
Cbud_s2_21 x1_net5 Vss 0.343571f
Cbud_s2_22 x1_net6 Vss 0.343571f
Cbud_s2_23 x1_net7 Vss 10.2564f
Cbud_s2_24 x1_net8 Vss 10.2564f
Cbud_s2_25 x1_net9 Vss 247.53f
Cbud_s2_26 x2_Vbiasp Vss 104.234f
Cbud_s2_27 x2_Vcm Vss 112.365f
Cbud_s2_28 x2_Vout Vss 150.381f
Cbud_s2_29 x2_Vtest Vss 289.162f
Cbud_s2_30 x2_net1 Vss 27.0817f
Cbud_s2_31 x2_x1_net1 Vss 0.920834f
Cbud_s2_32 x2_x1_net10 Vss 0.920859f
Cbud_s2_33 x2_x1_net11 Vss 0.920845f
Cbud_s2_34 x2_x1_net12 Vss 0.920974f
Cbud_s2_35 x2_x1_net13 Vss 0.921035f
Cbud_s2_36 x2_x1_net14 Vss 0.921129f
Cbud_s2_37 x2_x1_net15 Vss 0.921282f
Cbud_s2_38 x2_x1_net16 Vss 0.933334f
Cbud_s2_39 x2_x1_net17 Vss 0.928223f
Cbud_s2_40 x2_x1_net18 Vss 0.923542f
Cbud_s2_41 x2_x1_net19 Vss 0.922121f
Cbud_s2_42 x2_x1_net2 Vss 0.920932f
Cbud_s2_43 x2_x1_net3 Vss 0.92156f
Cbud_s2_44 x2_x1_net4 Vss 0.920805f
Cbud_s2_45 x2_x1_net5 Vss 0.920811f
Cbud_s2_46 x2_x1_net6 Vss 0.920817f
Cbud_s2_47 x2_x1_net7 Vss 0.920825f
Cbud_s2_48 x2_x1_net8 Vss 0.9209f
Cbud_s2_49 x2_x1_net9 Vss 0.920877f
Cbud_s2_50 x2_x2_net1 Vss 0.921541f
Cbud_s2_51 x2_x2_net10 Vss 0.921124f
Cbud_s2_52 x2_x2_net11 Vss 0.921275f
Cbud_s2_53 x2_x2_net12 Vss 0.9209f
Cbud_s2_54 x2_x2_net13 Vss 0.920877f
Cbud_s2_55 x2_x2_net14 Vss 0.920859f
Cbud_s2_56 x2_x2_net15 Vss 0.920845f
Cbud_s2_57 x2_x2_net16 Vss 0.920805f
Cbud_s2_58 x2_x2_net17 Vss 0.920811f
Cbud_s2_59 x2_x2_net18 Vss 0.920817f
Cbud_s2_60 x2_x2_net19 Vss 0.920825f
Cbud_s2_61 x2_x2_net2 Vss 0.920931f
Cbud_s2_62 x2_x2_net3 Vss 0.920834f
Cbud_s2_63 x2_x2_net4 Vss 1.13915f
Cbud_s2_64 x2_x2_net5 Vss 0.928903f
Cbud_s2_65 x2_x2_net6 Vss 0.923569f
Cbud_s2_66 x2_x2_net7 Vss 0.922143f
Cbud_s2_67 x2_x2_net8 Vss 0.920974f
Cbud_s2_68 x2_x2_net9 Vss 0.921036f
Cbud_s2_69 NBias PBias 19.2174f
Cbud_s2_70 NBias Rgm 1.82169f
Cbud_s2_71 NBias Vom 0.145409f
Cbud_s2_72 NBias Vom1 0.145365f
Cbud_s2_73 NBias Vop 0.145409f
Cbud_s2_74 NBias Vop1 0.145365f
Cbud_s2_75 NBias net1 5.97826f
Cbud_s2_76 NBias net2 4.63116f
Cbud_s2_77 NBias net3 13.1826f
Cbud_s2_78 NBias net4 6.38541f
Cbud_s2_79 NBias net5 0.475321f
Cbud_s2_80 NBias net6 2.64999f
Cbud_s2_81 NBias net7 2.6492f
Cbud_s2_82 NBias x1_Vbias 0.538698f
Cbud_s2_83 NBias x1_Vout 6.38541f
Cbud_s2_84 NBias x1_Vtest2 0.0830871f
Cbud_s2_85 NBias x1_net1 0.0830871f
Cbud_s2_86 NBias x1_net2 3.49304f
Cbud_s2_87 NBias x1_net3 1.74652f
Cbud_s2_88 NBias x1_net4 1.746f
Cbud_s2_89 NBias x1_net5 0.0397601f
Cbud_s2_90 NBias x1_net6 0.0397601f
Cbud_s2_91 NBias x1_net7 1.81155f
Cbud_s2_92 NBias x1_net8 1.81155f
Cbud_s2_93 NBias x1_net9 6.38541f
Cbud_s2_94 NBias x2_Vbiasp 3.94267f
Cbud_s2_95 NBias x2_Vcm 6.37439f
Cbud_s2_96 NBias x2_Vout 6.20723f
Cbud_s2_97 NBias x2_Vtest 6.38351f
Cbud_s2_98 NBias x2_net1 3.29868f
Cbud_s2_99 NBias x2_x1_net1 0.145448f
Cbud_s2_100 NBias x2_x1_net10 0.145481f
Cbud_s2_101 NBias x2_x1_net11 0.145462f
Cbud_s2_102 NBias x2_x1_net12 0.145647f
Cbud_s2_103 NBias x2_x1_net13 0.145748f
Cbud_s2_104 NBias x2_x1_net14 0.145889f
Cbud_s2_105 NBias x2_x1_net15 0.14614f
Cbud_s2_106 NBias x2_x1_net16 0.692522f
Cbud_s2_107 NBias x2_x1_net17 0.247559f
Cbud_s2_108 NBias x2_x1_net18 0.15805f
Cbud_s2_109 NBias x2_x1_net19 0.14759f
Cbud_s2_110 NBias x2_x1_net2 0.145583f
Cbud_s2_111 NBias x2_x1_net3 0.14662f
Cbud_s2_112 NBias x2_x1_net4 0.145415f
Cbud_s2_113 NBias x2_x1_net5 0.145421f
Cbud_s2_114 NBias x2_x1_net6 0.145428f
Cbud_s2_115 NBias x2_x1_net7 0.145437f
Cbud_s2_116 NBias x2_x1_net8 0.145537f
Cbud_s2_117 NBias x2_x1_net9 0.145504f
Cbud_s2_118 NBias x2_x2_net1 0.146602f
Cbud_s2_119 NBias x2_x2_net10 0.145889f
Cbud_s2_120 NBias x2_x2_net11 0.146143f
Cbud_s2_121 NBias x2_x2_net12 0.145537f
Cbud_s2_122 NBias x2_x2_net13 0.145504f
Cbud_s2_123 NBias x2_x2_net14 0.14548f
Cbud_s2_124 NBias x2_x2_net15 0.145462f
Cbud_s2_125 NBias x2_x2_net16 0.145415f
Cbud_s2_126 NBias x2_x2_net17 0.145421f
Cbud_s2_127 NBias x2_x2_net18 0.145428f
Cbud_s2_128 NBias x2_x2_net19 0.145437f
Cbud_s2_129 NBias x2_x2_net2 0.145583f
Cbud_s2_130 NBias x2_x2_net3 0.145448f
Cbud_s2_131 NBias x2_x2_net4 3.1603f
Cbud_s2_132 NBias x2_x2_net5 0.252649f
Cbud_s2_133 NBias x2_x2_net6 0.157438f
Cbud_s2_134 NBias x2_x2_net7 0.14768f
Cbud_s2_135 NBias x2_x2_net8 0.145647f
Cbud_s2_136 NBias x2_x2_net9 0.145746f
Cbud_s2_137 NBias Vm 1.18905f
Cbud_s2_138 NBias Vp 1.1894f
Cbud_s2_139 PBias Rgm 1.82115f
Cbud_s2_140 PBias Vom 0.220882f
Cbud_s2_141 PBias Vom1 0.220838f
Cbud_s2_142 PBias Vop 0.220881f
Cbud_s2_143 PBias Vop1 0.220838f
Cbud_s2_144 PBias net1 11.4077f
Cbud_s2_145 PBias net2 10.0558f
Cbud_s2_146 PBias net3 6.09528f
Cbud_s2_147 PBias net4 15.1238f
Cbud_s2_148 PBias net5 0.412997f
Cbud_s2_149 PBias net6 8.0752f
Cbud_s2_150 PBias net7 8.0776f
Cbud_s2_151 PBias x1_Vbias 0.538698f
Cbud_s2_152 PBias x1_Vout 9.03259f
Cbud_s2_153 PBias x1_Vtest2 0.0830871f
Cbud_s2_154 PBias x1_net1 0.0830871f
Cbud_s2_155 PBias x1_net2 3.49304f
Cbud_s2_156 PBias x1_net3 1.746f
Cbud_s2_157 PBias x1_net4 1.746f
Cbud_s2_158 PBias x1_net5 0.0397601f
Cbud_s2_159 PBias x1_net6 0.0397601f
Cbud_s2_160 PBias x1_net7 1.81252f
Cbud_s2_161 PBias x1_net8 1.81252f
Cbud_s2_162 PBias x1_net9 8.56048f
Cbud_s2_163 PBias x2_Vbiasp 3.9415f
Cbud_s2_164 PBias x2_Vcm 7.94406f
Cbud_s2_165 PBias x2_Vout 6.20261f
Cbud_s2_166 PBias x2_Vtest 6.6806f
Cbud_s2_167 PBias x2_net1 3.30125f
Cbud_s2_168 PBias x2_x1_net1 0.1533f
Cbud_s2_169 PBias x2_x1_net10 0.153332f
Cbud_s2_170 PBias x2_x1_net11 0.153314f
Cbud_s2_171 PBias x2_x1_net12 0.153499f
Cbud_s2_172 PBias x2_x1_net13 0.153582f
Cbud_s2_173 PBias x2_x1_net14 0.153733f
Cbud_s2_174 PBias x2_x1_net15 0.15398f
Cbud_s2_175 PBias x2_x1_net16 0.688454f
Cbud_s2_176 PBias x2_x1_net17 0.260722f
Cbud_s2_177 PBias x2_x1_net18 0.164508f
Cbud_s2_178 PBias x2_x1_net19 0.155363f
Cbud_s2_179 PBias x2_x1_net2 0.153434f
Cbud_s2_180 PBias x2_x1_net3 0.154462f
Cbud_s2_181 PBias x2_x1_net4 0.153267f
Cbud_s2_182 PBias x2_x1_net5 0.153273f
Cbud_s2_183 PBias x2_x1_net6 0.15328f
Cbud_s2_184 PBias x2_x1_net7 0.153289f
Cbud_s2_185 PBias x2_x1_net8 0.153388f
Cbud_s2_186 PBias x2_x1_net9 0.153356f
Cbud_s2_187 PBias x2_x2_net1 0.154463f
Cbud_s2_188 PBias x2_x2_net10 0.153734f
Cbud_s2_189 PBias x2_x2_net11 0.153983f
Cbud_s2_190 PBias x2_x2_net12 0.153388f
Cbud_s2_191 PBias x2_x2_net13 0.153356f
Cbud_s2_192 PBias x2_x2_net14 0.153332f
Cbud_s2_193 PBias x2_x2_net15 0.153314f
Cbud_s2_194 PBias x2_x2_net16 0.153267f
Cbud_s2_195 PBias x2_x2_net17 0.153273f
Cbud_s2_196 PBias x2_x2_net18 0.15328f
Cbud_s2_197 PBias x2_x2_net19 0.153289f
Cbud_s2_198 PBias x2_x2_net2 0.153434f
Cbud_s2_199 PBias x2_x2_net3 0.1533f
Cbud_s2_200 PBias x2_x2_net4 3.36364f
Cbud_s2_201 PBias x2_x2_net5 0.261815f
Cbud_s2_202 PBias x2_x2_net6 0.164929f
Cbud_s2_203 PBias x2_x2_net7 0.155365f
Cbud_s2_204 PBias x2_x2_net8 0.153499f
Cbud_s2_205 PBias x2_x2_net9 0.153586f
Cbud_s2_206 PBias Vm 1.1894f
Cbud_s2_207 PBias Vp 1.1894f
Cbud_s2_208 Rgm Vom 0.041524f
Cbud_s2_209 Rgm Vom1 0.0414712f
Cbud_s2_210 Rgm Vop 0.0415237f
Cbud_s2_211 Rgm Vop1 0.0414712f
Cbud_s2_212 Rgm net1 18.5515f
Cbud_s2_213 Rgm net2 1.82115f
Cbud_s2_214 Rgm net3 1.82115f
Cbud_s2_215 Rgm net4 1.82169f
Cbud_s2_216 Rgm net5 1.73733f
Cbud_s2_217 Rgm net6 1.82169f
Cbud_s2_218 Rgm net7 1.82169f
Cbud_s2_219 Rgm x1_Vbias 1.7841f
Cbud_s2_220 Rgm x1_Vout 1.82169f
Cbud_s2_221 Rgm x1_Vtest2 0.041472f
Cbud_s2_222 Rgm x1_net1 0.041472f
Cbud_s2_223 Rgm x1_net2 1.82115f
Cbud_s2_224 Rgm x1_net3 1.746f
Cbud_s2_225 Rgm x1_net4 1.74604f
Cbud_s2_226 Rgm x1_net5 0.0397601f
Cbud_s2_227 Rgm x1_net6 0.0397601f
Cbud_s2_228 Rgm x1_net7 1.69141f
Cbud_s2_229 Rgm x1_net8 1.69141f
Cbud_s2_230 Rgm x1_net9 1.82115f
Cbud_s2_231 Rgm x2_Vbiasp 1.82115f
Cbud_s2_232 Rgm x2_Vcm 1.82169f
Cbud_s2_233 Rgm x2_Vout 1.82115f
Cbud_s2_234 Rgm x2_Vtest 1.82169f
Cbud_s2_235 Rgm x2_net1 1.82115f
Cbud_s2_236 Rgm x2_x1_net1 0.0415791f
Cbud_s2_237 Rgm x2_x1_net10 0.0416232f
Cbud_s2_238 Rgm x2_x1_net11 0.0415983f
Cbud_s2_239 Rgm x2_x1_net12 0.0418487f
Cbud_s2_240 Rgm x2_x1_net13 0.0419809f
Cbud_s2_241 Rgm x2_x1_net14 0.0423529f
Cbud_s2_242 Rgm x2_x1_net15 0.0437952f
Cbud_s2_243 Rgm x2_x1_net16 1.81703f
Cbud_s2_244 Rgm x2_x1_net17 0.280508f
Cbud_s2_245 Rgm x2_x1_net18 0.127111f
Cbud_s2_246 Rgm x2_x1_net19 0.063017f
Cbud_s2_247 Rgm x2_x1_net2 0.0417798f
Cbud_s2_248 Rgm x2_x1_net3 0.0484763f
Cbud_s2_249 Rgm x2_x1_net4 0.0415315f
Cbud_s2_250 Rgm x2_x1_net5 0.0415401f
Cbud_s2_251 Rgm x2_x1_net6 0.0415504f
Cbud_s2_252 Rgm x2_x1_net7 0.0415636f
Cbud_s2_253 Rgm x2_x1_net8 0.0417066f
Cbud_s2_254 Rgm x2_x1_net9 0.0416572f
Cbud_s2_255 Rgm x2_x2_net1 0.0483076f
Cbud_s2_256 Rgm x2_x2_net10 0.0423432f
Cbud_s2_257 Rgm x2_x2_net11 0.0438179f
Cbud_s2_258 Rgm x2_x2_net12 0.0417054f
Cbud_s2_259 Rgm x2_x2_net13 0.0416572f
Cbud_s2_260 Rgm x2_x2_net14 0.0416237f
Cbud_s2_261 Rgm x2_x2_net15 0.0415981f
Cbud_s2_262 Rgm x2_x2_net16 0.0415313f
Cbud_s2_263 Rgm x2_x2_net17 0.0415401f
Cbud_s2_264 Rgm x2_x2_net18 0.0415504f
Cbud_s2_265 Rgm x2_x2_net19 0.0415637f
Cbud_s2_266 Rgm x2_x2_net2 0.0417799f
Cbud_s2_267 Rgm x2_x2_net3 0.0415794f
Cbud_s2_268 Rgm x2_x2_net4 1.81637f
Cbud_s2_269 Rgm x2_x2_net5 0.155558f
Cbud_s2_270 Rgm x2_x2_net6 0.128478f
Cbud_s2_271 Rgm x2_x2_net7 0.0648178f
Cbud_s2_272 Rgm x2_x2_net8 0.0418488f
Cbud_s2_273 Rgm x2_x2_net9 0.0419808f
Cbud_s2_274 Rgm Vm 1.1894f
Cbud_s2_275 Rgm Vp 1.18905f
Cbud_s2_276 Vom Vom1 1.77144f
Cbud_s2_277 Vom Vop 0.300001f
Cbud_s2_278 Vom Vop1 0.50303f
Cbud_s2_279 Vom net1 0.136181f
Cbud_s2_280 Vom net2 0.105475f
Cbud_s2_281 Vom net3 0.125482f
Cbud_s2_282 Vom net4 0.249174f
Cbud_s2_283 Vom net5 0.112496f
Cbud_s2_284 Vom net6 0.0603768f
Cbud_s2_285 Vom net7 0.0603764f
Cbud_s2_286 Vom x1_Vbias 0.115918f
Cbud_s2_287 Vom x1_Vout 0.205671f
Cbud_s2_288 Vom x1_Vtest2 0.0830863f
Cbud_s2_289 Vom x1_net1 0.528022f
Cbud_s2_290 Vom x1_net2 0.0795663f
Cbud_s2_291 Vom x1_net3 0.0398134f
Cbud_s2_292 Vom x1_net4 0.039813f
Cbud_s2_293 Vom x1_net5 0.0397599f
Cbud_s2_294 Vom x1_net6 0.253196f
Cbud_s2_295 Vom x1_net7 0.154812f
Cbud_s2_296 Vom x1_net8 0.984797f
Cbud_s2_297 Vom x1_net9 0.194925f
Cbud_s2_298 Vom x2_Vbiasp 0.089802f
Cbud_s2_299 Vom x2_Vcm 0.180978f
Cbud_s2_300 Vom x2_Vout 0.255056f
Cbud_s2_301 Vom x2_Vtest 0.152174f
Cbud_s2_302 Vom x2_net1 0.0752008f
Cbud_s2_303 Vom x2_x1_net1 0.153232f
Cbud_s2_304 Vom x2_x1_net10 0.153233f
Cbud_s2_305 Vom x2_x1_net11 0.153233f
Cbud_s2_306 Vom x2_x1_net12 0.153238f
Cbud_s2_307 Vom x2_x1_net13 0.15324f
Cbud_s2_308 Vom x2_x1_net14 0.153241f
Cbud_s2_309 Vom x2_x1_net15 0.153243f
Cbud_s2_310 Vom x2_x1_net16 0.153258f
Cbud_s2_311 Vom x2_x1_net17 0.153254f
Cbud_s2_312 Vom x2_x1_net18 0.153251f
Cbud_s2_313 Vom x2_x1_net19 0.153248f
Cbud_s2_314 Vom x2_x1_net2 0.153237f
Cbud_s2_315 Vom x2_x1_net3 0.153245f
Cbud_s2_316 Vom x2_x1_net4 0.153229f
Cbud_s2_317 Vom x2_x1_net5 0.15323f
Cbud_s2_318 Vom x2_x1_net6 0.15323f
Cbud_s2_319 Vom x2_x1_net7 0.153231f
Cbud_s2_320 Vom x2_x1_net8 0.153236f
Cbud_s2_321 Vom x2_x1_net9 0.153234f
Cbud_s2_322 Vom x2_x2_net1 0.1533f
Cbud_s2_323 Vom x2_x2_net10 0.153332f
Cbud_s2_324 Vom x2_x2_net11 0.153314f
Cbud_s2_325 Vom x2_x2_net12 0.153499f
Cbud_s2_326 Vom x2_x2_net13 0.153582f
Cbud_s2_327 Vom x2_x2_net14 0.153732f
Cbud_s2_328 Vom x2_x2_net15 0.153979f
Cbud_s2_329 Vom x2_x2_net16 6.72735f
Cbud_s2_330 Vom x2_x2_net17 0.257538f
Cbud_s2_331 Vom x2_x2_net18 0.164045f
Cbud_s2_332 Vom x2_x2_net19 0.155394f
Cbud_s2_333 Vom x2_x2_net2 0.153434f
Cbud_s2_334 Vom x2_x2_net3 0.154468f
Cbud_s2_335 Vom x2_x2_net4 0.153267f
Cbud_s2_336 Vom x2_x2_net5 0.153273f
Cbud_s2_337 Vom x2_x2_net6 0.15328f
Cbud_s2_338 Vom x2_x2_net7 0.153289f
Cbud_s2_339 Vom x2_x2_net8 0.153388f
Cbud_s2_340 Vom x2_x2_net9 0.153355f
Cbud_s2_341 Vom Vm 0.0271359f
Cbud_s2_342 Vom Vp 0.0271359f
Cbud_s2_343 Vom1 Vop 0.50303f
Cbud_s2_344 Vom1 Vop1 0.278767f
Cbud_s2_345 Vom1 net1 0.136137f
Cbud_s2_346 Vom1 net2 0.105429f
Cbud_s2_347 Vom1 net3 0.125437f
Cbud_s2_348 Vom1 net4 0.249131f
Cbud_s2_349 Vom1 net5 0.137709f
Cbud_s2_350 Vom1 net6 0.0603276f
Cbud_s2_351 Vom1 net7 0.0603276f
Cbud_s2_352 Vom1 x1_Vbias 0.157126f
Cbud_s2_353 Vom1 x1_Vout 0.205629f
Cbud_s2_354 Vom1 x1_Vtest2 0.0830863f
Cbud_s2_355 Vom1 x1_net1 0.0863978f
Cbud_s2_356 Vom1 x1_net2 0.0795198f
Cbud_s2_357 Vom1 x1_net3 0.0397599f
Cbud_s2_358 Vom1 x1_net4 0.0397599f
Cbud_s2_359 Vom1 x1_net5 0.0397599f
Cbud_s2_360 Vom1 x1_net6 0.0533647f
Cbud_s2_361 Vom1 x1_net7 0.35474f
Cbud_s2_362 Vom1 x1_net8 0.154801f
Cbud_s2_363 Vom1 x1_net9 0.39482f
Cbud_s2_364 Vom1 x2_Vbiasp 0.0897556f
Cbud_s2_365 Vom1 x2_Vcm 0.180935f
Cbud_s2_366 Vom1 x2_Vout 0.141351f
Cbud_s2_367 Vom1 x2_Vtest 0.15213f
Cbud_s2_368 Vom1 x2_net1 0.0751535f
Cbud_s2_369 Vom1 x2_x1_net1 0.153218f
Cbud_s2_370 Vom1 x2_x1_net10 0.153218f
Cbud_s2_371 Vom1 x2_x1_net11 0.153218f
Cbud_s2_372 Vom1 x2_x1_net12 0.153218f
Cbud_s2_373 Vom1 x2_x1_net13 0.153218f
Cbud_s2_374 Vom1 x2_x1_net14 0.153218f
Cbud_s2_375 Vom1 x2_x1_net15 0.153218f
Cbud_s2_376 Vom1 x2_x1_net16 0.153218f
Cbud_s2_377 Vom1 x2_x1_net17 0.153218f
Cbud_s2_378 Vom1 x2_x1_net18 0.153218f
Cbud_s2_379 Vom1 x2_x1_net19 0.153218f
Cbud_s2_380 Vom1 x2_x1_net2 0.153218f
Cbud_s2_381 Vom1 x2_x1_net3 0.153218f
Cbud_s2_382 Vom1 x2_x1_net4 0.153218f
Cbud_s2_383 Vom1 x2_x1_net5 0.153218f
Cbud_s2_384 Vom1 x2_x1_net6 0.153218f
Cbud_s2_385 Vom1 x2_x1_net7 0.153218f
Cbud_s2_386 Vom1 x2_x1_net8 0.153218f
Cbud_s2_387 Vom1 x2_x1_net9 0.153218f
Cbud_s2_388 Vom1 x2_x2_net1 0.975289f
Cbud_s2_389 Vom1 x2_x2_net10 0.974745f
Cbud_s2_390 Vom1 x2_x2_net11 0.974974f
Cbud_s2_391 Vom1 x2_x2_net12 0.974233f
Cbud_s2_392 Vom1 x2_x2_net13 0.974157f
Cbud_s2_393 Vom1 x2_x2_net14 0.974093f
Cbud_s2_394 Vom1 x2_x2_net15 0.974038f
Cbud_s2_395 Vom1 x2_x2_net16 0.97385f
Cbud_s2_396 Vom1 x2_x2_net17 0.973879f
Cbud_s2_397 Vom1 x2_x2_net18 0.973912f
Cbud_s2_398 Vom1 x2_x2_net19 0.973948f
Cbud_s2_399 Vom1 x2_x2_net2 0.974323f
Cbud_s2_400 Vom1 x2_x2_net3 0.97399f
Cbud_s2_401 Vom1 x2_x2_net4 0.153218f
Cbud_s2_402 Vom1 x2_x2_net5 0.977456f
Cbud_s2_403 Vom1 x2_x2_net6 0.976469f
Cbud_s2_404 Vom1 x2_x2_net7 0.975746f
Cbud_s2_405 Vom1 x2_x2_net8 0.974434f
Cbud_s2_406 Vom1 x2_x2_net9 0.974571f
Cbud_s2_407 Vom1 Vm 0.027077f
Cbud_s2_408 Vom1 Vp 0.027077f
Cbud_s2_409 Vop Vop1 1.77144f
Cbud_s2_410 Vop net1 0.136181f
Cbud_s2_411 Vop net2 0.105474f
Cbud_s2_412 Vop net3 0.125482f
Cbud_s2_413 Vop net4 0.249174f
Cbud_s2_414 Vop net5 0.112495f
Cbud_s2_415 Vop net6 0.0603774f
Cbud_s2_416 Vop net7 0.0603768f
Cbud_s2_417 Vop x1_Vbias 0.115918f
Cbud_s2_418 Vop x1_Vout 0.205673f
Cbud_s2_419 Vop x1_Vtest2 0.528022f
Cbud_s2_420 Vop x1_net1 0.0830863f
Cbud_s2_421 Vop x1_net2 0.0795661f
Cbud_s2_422 Vop x1_net3 0.039813f
Cbud_s2_423 Vop x1_net4 0.039813f
Cbud_s2_424 Vop x1_net5 0.253196f
Cbud_s2_425 Vop x1_net6 0.0397599f
Cbud_s2_426 Vop x1_net7 0.984797f
Cbud_s2_427 Vop x1_net8 0.154812f
Cbud_s2_428 Vop x1_net9 0.194924f
Cbud_s2_429 Vop x2_Vbiasp 0.089803f
Cbud_s2_430 Vop x2_Vcm 0.180978f
Cbud_s2_431 Vop x2_Vout 0.255056f
Cbud_s2_432 Vop x2_Vtest 0.152174f
Cbud_s2_433 Vop x2_net1 0.0752005f
Cbud_s2_434 Vop x2_x1_net1 0.154356f
Cbud_s2_435 Vop x2_x1_net10 0.153711f
Cbud_s2_436 Vop x2_x1_net11 0.153929f
Cbud_s2_437 Vop x2_x1_net12 0.153385f
Cbud_s2_438 Vop x2_x1_net13 0.153354f
Cbud_s2_439 Vop x2_x1_net14 0.153331f
Cbud_s2_440 Vop x2_x1_net15 0.153313f
Cbud_s2_441 Vop x2_x1_net16 0.153267f
Cbud_s2_442 Vop x2_x1_net17 0.153273f
Cbud_s2_443 Vop x2_x1_net18 0.15328f
Cbud_s2_444 Vop x2_x1_net19 0.153289f
Cbud_s2_445 Vop x2_x1_net2 0.153428f
Cbud_s2_446 Vop x2_x1_net3 0.1533f
Cbud_s2_447 Vop x2_x1_net4 0.860914f
Cbud_s2_448 Vop x2_x1_net5 0.189905f
Cbud_s2_449 Vop x2_x1_net6 0.158674f
Cbud_s2_450 Vop x2_x1_net7 0.15492f
Cbud_s2_451 Vop x2_x1_net8 0.153492f
Cbud_s2_452 Vop x2_x1_net9 0.153558f
Cbud_s2_453 Vop x2_x2_net1 0.153245f
Cbud_s2_454 Vop x2_x2_net10 0.153241f
Cbud_s2_455 Vop x2_x2_net11 0.153243f
Cbud_s2_456 Vop x2_x2_net12 0.153236f
Cbud_s2_457 Vop x2_x2_net13 0.153234f
Cbud_s2_458 Vop x2_x2_net14 0.153233f
Cbud_s2_459 Vop x2_x2_net15 0.153232f
Cbud_s2_460 Vop x2_x2_net16 0.153229f
Cbud_s2_461 Vop x2_x2_net17 0.15323f
Cbud_s2_462 Vop x2_x2_net18 0.15323f
Cbud_s2_463 Vop x2_x2_net19 0.153231f
Cbud_s2_464 Vop x2_x2_net2 0.153237f
Cbud_s2_465 Vop x2_x2_net3 0.153232f
Cbud_s2_466 Vop x2_x2_net4 0.153257f
Cbud_s2_467 Vop x2_x2_net5 0.153254f
Cbud_s2_468 Vop x2_x2_net6 0.153251f
Cbud_s2_469 Vop x2_x2_net7 0.153248f
Cbud_s2_470 Vop x2_x2_net8 0.153238f
Cbud_s2_471 Vop x2_x2_net9 0.15324f
Cbud_s2_472 Vop Vm 0.0271355f
Cbud_s2_473 Vop Vp 0.0271356f
Cbud_s2_474 Vop1 net1 0.136137f
Cbud_s2_475 Vop1 net2 0.105429f
Cbud_s2_476 Vop1 net3 0.125437f
Cbud_s2_477 Vop1 net4 0.249131f
Cbud_s2_478 Vop1 net5 0.137709f
Cbud_s2_479 Vop1 net6 0.0603276f
Cbud_s2_480 Vop1 net7 0.0603276f
Cbud_s2_481 Vop1 x1_Vbias 0.157126f
Cbud_s2_482 Vop1 x1_Vout 0.205629f
Cbud_s2_483 Vop1 x1_Vtest2 0.0863978f
Cbud_s2_484 Vop1 x1_net1 0.0830863f
Cbud_s2_485 Vop1 x1_net2 0.0795198f
Cbud_s2_486 Vop1 x1_net3 0.0397599f
Cbud_s2_487 Vop1 x1_net4 0.0397599f
Cbud_s2_488 Vop1 x1_net5 0.0533647f
Cbud_s2_489 Vop1 x1_net6 0.0397599f
Cbud_s2_490 Vop1 x1_net7 0.154801f
Cbud_s2_491 Vop1 x1_net8 0.35474f
Cbud_s2_492 Vop1 x1_net9 0.39482f
Cbud_s2_493 Vop1 x2_Vbiasp 0.0897556f
Cbud_s2_494 Vop1 x2_Vcm 0.180935f
Cbud_s2_495 Vop1 x2_Vout 0.141351f
Cbud_s2_496 Vop1 x2_Vtest 0.15213f
Cbud_s2_497 Vop1 x2_net1 0.0751535f
Cbud_s2_498 Vop1 x2_x1_net1 0.97399f
Cbud_s2_499 Vop1 x2_x1_net10 0.974093f
Cbud_s2_500 Vop1 x2_x1_net11 0.974038f
Cbud_s2_501 Vop1 x2_x1_net12 0.974434f
Cbud_s2_502 Vop1 x2_x1_net13 0.974571f
Cbud_s2_503 Vop1 x2_x1_net14 0.974745f
Cbud_s2_504 Vop1 x2_x1_net15 0.974974f
Cbud_s2_505 Vop1 x2_x1_net16 0.153218f
Cbud_s2_506 Vop1 x2_x1_net17 0.977456f
Cbud_s2_507 Vop1 x2_x1_net18 0.976469f
Cbud_s2_508 Vop1 x2_x1_net19 0.975746f
Cbud_s2_509 Vop1 x2_x1_net2 0.974323f
Cbud_s2_510 Vop1 x2_x1_net3 0.975289f
Cbud_s2_511 Vop1 x2_x1_net4 0.97385f
Cbud_s2_512 Vop1 x2_x1_net5 0.973879f
Cbud_s2_513 Vop1 x2_x1_net6 0.973912f
Cbud_s2_514 Vop1 x2_x1_net7 0.973948f
Cbud_s2_515 Vop1 x2_x1_net8 0.974233f
Cbud_s2_516 Vop1 x2_x1_net9 0.974157f
Cbud_s2_517 Vop1 x2_x2_net1 0.153218f
Cbud_s2_518 Vop1 x2_x2_net10 0.153218f
Cbud_s2_519 Vop1 x2_x2_net11 0.153218f
Cbud_s2_520 Vop1 x2_x2_net12 0.153218f
Cbud_s2_521 Vop1 x2_x2_net13 0.153218f
Cbud_s2_522 Vop1 x2_x2_net14 0.153218f
Cbud_s2_523 Vop1 x2_x2_net15 0.153218f
Cbud_s2_524 Vop1 x2_x2_net16 0.153218f
Cbud_s2_525 Vop1 x2_x2_net17 0.153218f
Cbud_s2_526 Vop1 x2_x2_net18 0.153218f
Cbud_s2_527 Vop1 x2_x2_net19 0.153218f
Cbud_s2_528 Vop1 x2_x2_net2 0.153218f
Cbud_s2_529 Vop1 x2_x2_net3 0.153218f
Cbud_s2_530 Vop1 x2_x2_net4 0.153218f
Cbud_s2_531 Vop1 x2_x2_net5 0.153218f
Cbud_s2_532 Vop1 x2_x2_net6 0.153218f
Cbud_s2_533 Vop1 x2_x2_net7 0.153218f
Cbud_s2_534 Vop1 x2_x2_net8 0.153218f
Cbud_s2_535 Vop1 x2_x2_net9 0.153218f
Cbud_s2_536 Vop1 Vm 0.027077f
Cbud_s2_537 Vop1 Vp 0.027077f
Cbud_s2_538 net1 net2 11.715f
Cbud_s2_539 net1 net3 5.5084f
Cbud_s2_540 net1 net4 5.98004f
Cbud_s2_541 net1 net5 0.475321f
Cbud_s2_542 net1 net6 2.64999f
Cbud_s2_543 net1 net7 2.6492f
Cbud_s2_544 net1 x1_Vbias 0.538698f
Cbud_s2_545 net1 x1_Vout 5.98004f
Cbud_s2_546 net1 x1_Vtest2 0.0830871f
Cbud_s2_547 net1 x1_net1 0.0830871f
Cbud_s2_548 net1 x1_net2 3.49304f
Cbud_s2_549 net1 x1_net3 1.746f
Cbud_s2_550 net1 x1_net4 1.74652f
Cbud_s2_551 net1 x1_net5 0.0397601f
Cbud_s2_552 net1 x1_net6 0.0397601f
Cbud_s2_553 net1 x1_net7 1.81056f
Cbud_s2_554 net1 x1_net8 1.81056f
Cbud_s2_555 net1 x1_net9 5.97826f
Cbud_s2_556 net1 x2_Vbiasp 3.94267f
Cbud_s2_557 net1 x2_Vcm 5.97745f
Cbud_s2_558 net1 x2_Vout 5.98004f
Cbud_s2_559 net1 x2_Vtest 5.98004f
Cbud_s2_560 net1 x2_net1 3.30027f
Cbud_s2_561 net1 x2_x1_net1 0.136221f
Cbud_s2_562 net1 x2_x1_net10 0.136254f
Cbud_s2_563 net1 x2_x1_net11 0.136235f
Cbud_s2_564 net1 x2_x1_net12 0.136425f
Cbud_s2_565 net1 x2_x1_net13 0.136519f
Cbud_s2_566 net1 x2_x1_net14 0.136666f
Cbud_s2_567 net1 x2_x1_net15 0.136943f
Cbud_s2_568 net1 x2_x1_net16 0.844552f
Cbud_s2_569 net1 x2_x1_net17 0.248289f
Cbud_s2_570 net1 x2_x1_net18 0.150607f
Cbud_s2_571 net1 x2_x1_net19 0.138575f
Cbud_s2_572 net1 x2_x1_net2 0.136359f
Cbud_s2_573 net1 x2_x1_net3 0.137361f
Cbud_s2_574 net1 x2_x1_net4 0.136187f
Cbud_s2_575 net1 x2_x1_net5 0.136193f
Cbud_s2_576 net1 x2_x1_net6 0.1362f
Cbud_s2_577 net1 x2_x1_net7 0.136209f
Cbud_s2_578 net1 x2_x1_net8 0.136312f
Cbud_s2_579 net1 x2_x1_net9 0.136278f
Cbud_s2_580 net1 x2_x2_net1 0.137364f
Cbud_s2_581 net1 x2_x2_net10 0.136665f
Cbud_s2_582 net1 x2_x2_net11 0.136941f
Cbud_s2_583 net1 x2_x2_net12 0.136312f
Cbud_s2_584 net1 x2_x2_net13 0.136278f
Cbud_s2_585 net1 x2_x2_net14 0.136254f
Cbud_s2_586 net1 x2_x2_net15 0.136235f
Cbud_s2_587 net1 x2_x2_net16 0.136186f
Cbud_s2_588 net1 x2_x2_net17 0.136193f
Cbud_s2_589 net1 x2_x2_net18 0.1362f
Cbud_s2_590 net1 x2_x2_net19 0.136209f
Cbud_s2_591 net1 x2_x2_net2 0.136359f
Cbud_s2_592 net1 x2_x2_net3 0.136221f
Cbud_s2_593 net1 x2_x2_net4 0.844552f
Cbud_s2_594 net1 x2_x2_net5 0.268827f
Cbud_s2_595 net1 x2_x2_net6 0.149668f
Cbud_s2_596 net1 x2_x2_net7 0.138523f
Cbud_s2_597 net1 x2_x2_net8 0.136426f
Cbud_s2_598 net1 x2_x2_net9 0.136521f
Cbud_s2_599 net1 Vm 1.1894f
Cbud_s2_600 net1 Vp 1.18905f
Cbud_s2_601 net2 net3 4.63116f
Cbud_s2_602 net2 net4 4.62989f
Cbud_s2_603 net2 net5 0.480101f
Cbud_s2_604 net2 net6 2.6492f
Cbud_s2_605 net2 net7 2.64999f
Cbud_s2_606 net2 x1_Vbias 0.544537f
Cbud_s2_607 net2 x1_Vout 4.62978f
Cbud_s2_608 net2 x1_Vtest2 0.0830871f
Cbud_s2_609 net2 x1_net1 0.0830871f
Cbud_s2_610 net2 x1_net2 3.492f
Cbud_s2_611 net2 x1_net3 1.74652f
Cbud_s2_612 net2 x1_net4 1.746f
Cbud_s2_613 net2 x1_net5 0.0397601f
Cbud_s2_614 net2 x1_net6 0.0397601f
Cbud_s2_615 net2 x1_net7 1.80699f
Cbud_s2_616 net2 x1_net8 1.80699f
Cbud_s2_617 net2 x1_net9 4.62978f
Cbud_s2_618 net2 x2_Vbiasp 3.9415f
Cbud_s2_619 net2 x2_Vcm 4.62978f
Cbud_s2_620 net2 x2_Vout 4.62978f
Cbud_s2_621 net2 x2_Vtest 4.62809f
Cbud_s2_622 net2 x2_net1 3.29668f
Cbud_s2_623 net2 x2_x1_net1 0.105516f
Cbud_s2_624 net2 x2_x1_net10 0.105552f
Cbud_s2_625 net2 x2_x1_net11 0.105532f
Cbud_s2_626 net2 x2_x1_net12 0.105732f
Cbud_s2_627 net2 x2_x1_net13 0.105836f
Cbud_s2_628 net2 x2_x1_net14 0.106005f
Cbud_s2_629 net2 x2_x1_net15 0.1063f
Cbud_s2_630 net2 x2_x1_net16 2.98596f
Cbud_s2_631 net2 x2_x1_net17 0.275576f
Cbud_s2_632 net2 x2_x1_net18 0.129422f
Cbud_s2_633 net2 x2_x1_net19 0.1095f
Cbud_s2_634 net2 x2_x1_net2 0.105663f
Cbud_s2_635 net2 x2_x1_net3 0.106729f
Cbud_s2_636 net2 x2_x1_net4 0.10548f
Cbud_s2_637 net2 x2_x1_net5 0.105487f
Cbud_s2_638 net2 x2_x1_net6 0.105495f
Cbud_s2_639 net2 x2_x1_net7 0.105504f
Cbud_s2_640 net2 x2_x1_net8 0.105617f
Cbud_s2_641 net2 x2_x1_net9 0.105579f
Cbud_s2_642 net2 x2_x2_net1 0.106714f
Cbud_s2_643 net2 x2_x2_net10 0.106001f
Cbud_s2_644 net2 x2_x2_net11 0.106298f
Cbud_s2_645 net2 x2_x2_net12 0.105616f
Cbud_s2_646 net2 x2_x2_net13 0.105579f
Cbud_s2_647 net2 x2_x2_net14 0.105552f
Cbud_s2_648 net2 x2_x2_net15 0.105532f
Cbud_s2_649 net2 x2_x2_net16 0.10548f
Cbud_s2_650 net2 x2_x2_net17 0.105487f
Cbud_s2_651 net2 x2_x2_net18 0.105495f
Cbud_s2_652 net2 x2_x2_net19 0.105504f
Cbud_s2_653 net2 x2_x2_net2 0.105663f
Cbud_s2_654 net2 x2_x2_net3 0.105516f
Cbud_s2_655 net2 x2_x2_net4 4.51707f
Cbud_s2_656 net2 x2_x2_net5 0.250589f
Cbud_s2_657 net2 x2_x2_net6 0.131048f
Cbud_s2_658 net2 x2_x2_net7 0.109645f
Cbud_s2_659 net2 x2_x2_net8 0.105733f
Cbud_s2_660 net2 x2_x2_net9 0.105835f
Cbud_s2_661 net2 Vm 1.18905f
Cbud_s2_662 net2 Vp 1.18905f
Cbud_s2_663 net3 net4 5.5084f
Cbud_s2_664 net3 net5 0.475321f
Cbud_s2_665 net3 net6 2.6492f
Cbud_s2_666 net3 net7 2.64927f
Cbud_s2_667 net3 x1_Vbias 0.538698f
Cbud_s2_668 net3 x1_Vout 5.51004f
Cbud_s2_669 net3 x1_Vtest2 0.0830871f
Cbud_s2_670 net3 x1_net1 0.0830871f
Cbud_s2_671 net3 x1_net2 3.49304f
Cbud_s2_672 net3 x1_net3 1.74652f
Cbud_s2_673 net3 x1_net4 1.74652f
Cbud_s2_674 net3 x1_net5 0.0397601f
Cbud_s2_675 net3 x1_net6 0.0397601f
Cbud_s2_676 net3 x1_net7 1.80939f
Cbud_s2_677 net3 x1_net8 1.80939f
Cbud_s2_678 net3 x1_net9 5.5084f
Cbud_s2_679 net3 x2_Vbiasp 3.9415f
Cbud_s2_680 net3 x2_Vcm 5.49999f
Cbud_s2_681 net3 x2_Vout 5.51004f
Cbud_s2_682 net3 x2_Vtest 5.51004f
Cbud_s2_683 net3 x2_net1 3.29785f
Cbud_s2_684 net3 x2_x1_net1 0.125522f
Cbud_s2_685 net3 x2_x1_net10 0.125556f
Cbud_s2_686 net3 x2_x1_net11 0.125536f
Cbud_s2_687 net3 x2_x1_net12 0.125724f
Cbud_s2_688 net3 x2_x1_net13 0.125827f
Cbud_s2_689 net3 x2_x1_net14 0.125982f
Cbud_s2_690 net3 x2_x1_net15 0.126278f
Cbud_s2_691 net3 x2_x1_net16 0.139496f
Cbud_s2_692 net3 x2_x1_net17 0.246872f
Cbud_s2_693 net3 x2_x1_net18 0.142519f
Cbud_s2_694 net3 x2_x1_net19 0.128203f
Cbud_s2_695 net3 x2_x1_net2 0.125665f
Cbud_s2_696 net3 x2_x1_net3 0.126672f
Cbud_s2_697 net3 x2_x1_net4 0.125487f
Cbud_s2_698 net3 x2_x1_net5 0.125493f
Cbud_s2_699 net3 x2_x1_net6 0.125501f
Cbud_s2_700 net3 x2_x1_net7 0.12551f
Cbud_s2_701 net3 x2_x1_net8 0.125616f
Cbud_s2_702 net3 x2_x1_net9 0.125581f
Cbud_s2_703 net3 x2_x2_net1 0.126646f
Cbud_s2_704 net3 x2_x2_net10 0.125974f
Cbud_s2_705 net3 x2_x2_net11 0.126263f
Cbud_s2_706 net3 x2_x2_net12 0.125616f
Cbud_s2_707 net3 x2_x2_net13 0.125581f
Cbud_s2_708 net3 x2_x2_net14 0.125556f
Cbud_s2_709 net3 x2_x2_net15 0.125537f
Cbud_s2_710 net3 x2_x2_net16 0.125487f
Cbud_s2_711 net3 x2_x2_net17 0.125493f
Cbud_s2_712 net3 x2_x2_net18 0.125501f
Cbud_s2_713 net3 x2_x2_net19 0.12551f
Cbud_s2_714 net3 x2_x2_net2 0.125664f
Cbud_s2_715 net3 x2_x2_net3 0.125522f
Cbud_s2_716 net3 x2_x2_net4 1.97713f
Cbud_s2_717 net3 x2_x2_net5 0.278073f
Cbud_s2_718 net3 x2_x2_net6 0.142939f
Cbud_s2_719 net3 x2_x2_net7 0.128304f
Cbud_s2_720 net3 x2_x2_net8 0.125725f
Cbud_s2_721 net3 x2_x2_net9 0.125828f
Cbud_s2_722 net3 Vm 1.1894f
Cbud_s2_723 net3 Vp 1.1894f
Cbud_s2_724 net4 net5 0.665932f
Cbud_s2_725 net4 net6 2.6492f
Cbud_s2_726 net4 net7 2.6492f
Cbud_s2_727 net4 x1_Vbias 5.08841f
Cbud_s2_728 net4 x1_Vout 9.0299f
Cbud_s2_729 net4 x1_Vtest2 0.0830871f
Cbud_s2_730 net4 x1_net1 0.0830871f
Cbud_s2_731 net4 x1_net2 3.49135f
Cbud_s2_732 net4 x1_net3 3.53428f
Cbud_s2_733 net4 x1_net4 3.53428f
Cbud_s2_734 net4 x1_net5 0.0804828f
Cbud_s2_735 net4 x1_net6 0.0804828f
Cbud_s2_736 net4 x1_net7 1.41454f
Cbud_s2_737 net4 x1_net8 1.41454f
Cbud_s2_738 net4 x1_net9 8.55794f
Cbud_s2_739 net4 x2_Vbiasp 3.94267f
Cbud_s2_740 net4 x2_Vcm 7.9455f
Cbud_s2_741 net4 x2_Vout 6.20723f
Cbud_s2_742 net4 x2_Vtest 6.6806f
Cbud_s2_743 net4 x2_net1 3.29785f
Cbud_s2_744 net4 x2_x1_net1 0.1533f
Cbud_s2_745 net4 x2_x1_net10 0.153332f
Cbud_s2_746 net4 x2_x1_net11 0.153314f
Cbud_s2_747 net4 x2_x1_net12 0.153499f
Cbud_s2_748 net4 x2_x1_net13 0.153586f
Cbud_s2_749 net4 x2_x1_net14 0.153736f
Cbud_s2_750 net4 x2_x1_net15 0.153988f
Cbud_s2_751 net4 x2_x1_net16 0.997799f
Cbud_s2_752 net4 x2_x1_net17 0.242707f
Cbud_s2_753 net4 x2_x1_net18 0.165335f
Cbud_s2_754 net4 x2_x1_net19 0.155367f
Cbud_s2_755 net4 x2_x1_net2 0.153434f
Cbud_s2_756 net4 x2_x1_net3 0.154474f
Cbud_s2_757 net4 x2_x1_net4 0.153267f
Cbud_s2_758 net4 x2_x1_net5 0.153273f
Cbud_s2_759 net4 x2_x1_net6 0.15328f
Cbud_s2_760 net4 x2_x1_net7 0.153289f
Cbud_s2_761 net4 x2_x1_net8 0.153388f
Cbud_s2_762 net4 x2_x1_net9 0.153356f
Cbud_s2_763 net4 x2_x2_net1 0.154456f
Cbud_s2_764 net4 x2_x2_net10 0.153732f
Cbud_s2_765 net4 x2_x2_net11 0.153979f
Cbud_s2_766 net4 x2_x2_net12 0.153388f
Cbud_s2_767 net4 x2_x2_net13 0.153356f
Cbud_s2_768 net4 x2_x2_net14 0.153332f
Cbud_s2_769 net4 x2_x2_net15 0.153314f
Cbud_s2_770 net4 x2_x2_net16 0.153267f
Cbud_s2_771 net4 x2_x2_net17 0.153273f
Cbud_s2_772 net4 x2_x2_net18 0.15328f
Cbud_s2_773 net4 x2_x2_net19 0.153289f
Cbud_s2_774 net4 x2_x2_net2 0.153433f
Cbud_s2_775 net4 x2_x2_net3 0.1533f
Cbud_s2_776 net4 x2_x2_net4 0.688454f
Cbud_s2_777 net4 x2_x2_net5 0.267523f
Cbud_s2_778 net4 x2_x2_net6 0.163773f
Cbud_s2_779 net4 x2_x2_net7 0.155415f
Cbud_s2_780 net4 x2_x2_net8 0.153499f
Cbud_s2_781 net4 x2_x2_net9 0.15359f
Cbud_s2_782 net4 Vm 1.18905f
Cbud_s2_783 net4 Vp 1.18905f
Cbud_s2_784 net5 net6 0.265666f
Cbud_s2_785 net5 net7 0.535626f
Cbud_s2_786 net5 x1_Vbias 4.92269f
Cbud_s2_787 net5 x1_Vout 0.480341f
Cbud_s2_788 net5 x1_Vtest2 0.0830871f
Cbud_s2_789 net5 x1_net1 0.0830871f
Cbud_s2_790 net5 x1_net2 0.425371f
Cbud_s2_791 net5 x1_net3 2.85519f
Cbud_s2_792 net5 x1_net4 2.85519f
Cbud_s2_793 net5 x1_net5 0.0650182f
Cbud_s2_794 net5 x1_net6 0.0650184f
Cbud_s2_795 net5 x1_net7 1.80788f
Cbud_s2_796 net5 x1_net8 1.80788f
Cbud_s2_797 net5 x1_net9 0.472019f
Cbud_s2_798 net5 x2_Vbiasp 0.268665f
Cbud_s2_799 net5 x2_Vcm 0.46074f
Cbud_s2_800 net5 x2_Vout 0.483733f
Cbud_s2_801 net5 x2_Vtest 0.456036f
Cbud_s2_802 net5 x2_net1 0.468657f
Cbud_s2_803 net5 x2_x1_net1 0.112536f
Cbud_s2_804 net5 x2_x1_net10 0.11257f
Cbud_s2_805 net5 x2_x1_net11 0.11255f
Cbud_s2_806 net5 x2_x1_net12 0.112742f
Cbud_s2_807 net5 x2_x1_net13 0.112833f
Cbud_s2_808 net5 x2_x1_net14 0.112977f
Cbud_s2_809 net5 x2_x1_net15 0.113245f
Cbud_s2_810 net5 x2_x1_net16 0.331789f
Cbud_s2_811 net5 x2_x1_net17 0.158282f
Cbud_s2_812 net5 x2_x1_net18 0.122658f
Cbud_s2_813 net5 x2_x1_net19 0.114728f
Cbud_s2_814 net5 x2_x1_net2 0.112673f
Cbud_s2_815 net5 x2_x1_net3 0.113568f
Cbud_s2_816 net5 x2_x1_net4 0.112501f
Cbud_s2_817 net5 x2_x1_net5 0.112507f
Cbud_s2_818 net5 x2_x1_net6 0.112514f
Cbud_s2_819 net5 x2_x1_net7 0.112524f
Cbud_s2_820 net5 x2_x1_net8 0.11263f
Cbud_s2_821 net5 x2_x1_net9 0.112595f
Cbud_s2_822 net5 x2_x2_net1 0.113559f
Cbud_s2_823 net5 x2_x2_net10 0.112975f
Cbud_s2_824 net5 x2_x2_net11 0.113245f
Cbud_s2_825 net5 x2_x2_net12 0.11263f
Cbud_s2_826 net5 x2_x2_net13 0.112595f
Cbud_s2_827 net5 x2_x2_net14 0.11257f
Cbud_s2_828 net5 x2_x2_net15 0.11255f
Cbud_s2_829 net5 x2_x2_net16 0.112502f
Cbud_s2_830 net5 x2_x2_net17 0.112507f
Cbud_s2_831 net5 x2_x2_net18 0.112515f
Cbud_s2_832 net5 x2_x2_net19 0.112524f
Cbud_s2_833 net5 x2_x2_net2 0.112674f
Cbud_s2_834 net5 x2_x2_net3 0.112536f
Cbud_s2_835 net5 x2_x2_net4 0.33085f
Cbud_s2_836 net5 x2_x2_net5 0.162775f
Cbud_s2_837 net5 x2_x2_net6 0.123041f
Cbud_s2_838 net5 x2_x2_net7 0.114801f
Cbud_s2_839 net5 x2_x2_net8 0.112742f
Cbud_s2_840 net5 x2_x2_net9 0.112832f
Cbud_s2_841 net5 Vm 1.18068f
Cbud_s2_842 net5 Vp 1.18068f
Cbud_s2_843 net6 net7 2.64999f
Cbud_s2_844 net6 x1_Vbias 0.278009f
Cbud_s2_845 net6 x1_Vout 0.24287f
Cbud_s2_846 net6 x1_Vtest2 0.0603283f
Cbud_s2_847 net6 x1_net1 0.0603283f
Cbud_s2_848 net6 x1_net2 2.6492f
Cbud_s2_849 net6 x1_net3 1.74604f
Cbud_s2_850 net6 x1_net4 1.74604f
Cbud_s2_851 net6 x1_net5 0.0397601f
Cbud_s2_852 net6 x1_net6 0.0397601f
Cbud_s2_853 net6 x1_net7 1.79329f
Cbud_s2_854 net6 x1_net8 1.79329f
Cbud_s2_855 net6 x1_net9 2.64927f
Cbud_s2_856 net6 x2_Vbiasp 2.6492f
Cbud_s2_857 net6 x2_Vcm 2.64756f
Cbud_s2_858 net6 x2_Vout 2.64756f
Cbud_s2_859 net6 x2_Vtest 2.64999f
Cbud_s2_860 net6 x2_net1 2.6477f
Cbud_s2_861 net6 x2_x1_net1 0.0604264f
Cbud_s2_862 net6 x2_x1_net10 0.0603978f
Cbud_s2_863 net6 x2_x1_net11 0.0604441f
Cbud_s2_864 net6 x2_x1_net12 0.0606834f
Cbud_s2_865 net6 x2_x1_net13 0.0608154f
Cbud_s2_866 net6 x2_x1_net14 0.0609567f
Cbud_s2_867 net6 x2_x1_net15 0.0614269f
Cbud_s2_868 net6 x2_x1_net16 2.6324f
Cbud_s2_869 net6 x2_x1_net17 0.285987f
Cbud_s2_870 net6 x2_x1_net18 0.113971f
Cbud_s2_871 net6 x2_x1_net19 0.0730147f
Cbud_s2_872 net6 x2_x1_net2 0.0605947f
Cbud_s2_873 net6 x2_x1_net3 0.0635093f
Cbud_s2_874 net6 x2_x1_net4 0.0603824f
Cbud_s2_875 net6 x2_x1_net5 0.0603903f
Cbud_s2_876 net6 x2_x1_net6 0.0603998f
Cbud_s2_877 net6 x2_x1_net7 0.0604116f
Cbud_s2_878 net6 x2_x1_net8 0.0605379f
Cbud_s2_879 net6 x2_x1_net9 0.0604981f
Cbud_s2_880 net6 x2_x2_net1 0.0635188f
Cbud_s2_881 net6 x2_x2_net10 0.0609478f
Cbud_s2_882 net6 x2_x2_net11 0.0614098f
Cbud_s2_883 net6 x2_x2_net12 0.060538f
Cbud_s2_884 net6 x2_x2_net13 0.0604981f
Cbud_s2_885 net6 x2_x2_net14 0.0604086f
Cbud_s2_886 net6 x2_x2_net15 0.0604441f
Cbud_s2_887 net6 x2_x2_net16 0.0603824f
Cbud_s2_888 net6 x2_x2_net17 0.0603905f
Cbud_s2_889 net6 x2_x2_net18 0.0603998f
Cbud_s2_890 net6 x2_x2_net19 0.0604116f
Cbud_s2_891 net6 x2_x2_net2 0.0605939f
Cbud_s2_892 net6 x2_x2_net3 0.0604266f
Cbud_s2_893 net6 x2_x2_net4 2.63442f
Cbud_s2_894 net6 x2_x2_net5 0.319184f
Cbud_s2_895 net6 x2_x2_net6 0.116997f
Cbud_s2_896 net6 x2_x2_net7 0.0734762f
Cbud_s2_897 net6 x2_x2_net8 0.0606819f
Cbud_s2_898 net6 x2_x2_net9 0.0608156f
Cbud_s2_899 net6 Vm 1.18905f
Cbud_s2_900 net6 Vp 1.1894f
Cbud_s2_901 net7 x1_Vbias 0.317467f
Cbud_s2_902 net7 x1_Vout 2.6492f
Cbud_s2_903 net7 x1_Vtest2 0.0603283f
Cbud_s2_904 net7 x1_net1 0.0603283f
Cbud_s2_905 net7 x1_net2 2.6492f
Cbud_s2_906 net7 x1_net3 1.74652f
Cbud_s2_907 net7 x1_net4 1.74652f
Cbud_s2_908 net7 x1_net5 0.0397601f
Cbud_s2_909 net7 x1_net6 0.0397601f
Cbud_s2_910 net7 x1_net7 1.79329f
Cbud_s2_911 net7 x1_net8 1.79329f
Cbud_s2_912 net7 x1_net9 2.64999f
Cbud_s2_913 net7 x2_Vbiasp 3.07232f
Cbud_s2_914 net7 x2_Vcm 2.6492f
Cbud_s2_915 net7 x2_Vout 2.6492f
Cbud_s2_916 net7 x2_Vtest 2.64844f
Cbud_s2_917 net7 x2_net1 2.64607f
Cbud_s2_918 net7 x2_x1_net1 0.0604266f
Cbud_s2_919 net7 x2_x1_net10 0.0603953f
Cbud_s2_920 net7 x2_x1_net11 0.0604443f
Cbud_s2_921 net7 x2_x1_net12 0.0606809f
Cbud_s2_922 net7 x2_x1_net13 0.0608165f
Cbud_s2_923 net7 x2_x1_net14 0.0609539f
Cbud_s2_924 net7 x2_x1_net15 0.0614087f
Cbud_s2_925 net7 x2_x1_net16 2.62853f
Cbud_s2_926 net7 x2_x1_net17 0.304942f
Cbud_s2_927 net7 x2_x1_net18 0.113129f
Cbud_s2_928 net7 x2_x1_net19 0.0731787f
Cbud_s2_929 net7 x2_x1_net2 0.0605948f
Cbud_s2_930 net7 x2_x1_net3 0.0636227f
Cbud_s2_931 net7 x2_x1_net4 0.0603826f
Cbud_s2_932 net7 x2_x1_net5 0.06039f
Cbud_s2_933 net7 x2_x1_net6 0.0603998f
Cbud_s2_934 net7 x2_x1_net7 0.0604115f
Cbud_s2_935 net7 x2_x1_net8 0.0605376f
Cbud_s2_936 net7 x2_x1_net9 0.0604984f
Cbud_s2_937 net7 x2_x2_net1 0.0635093f
Cbud_s2_938 net7 x2_x2_net10 0.0609535f
Cbud_s2_939 net7 x2_x2_net11 0.0614161f
Cbud_s2_940 net7 x2_x2_net12 0.0605377f
Cbud_s2_941 net7 x2_x2_net13 0.0604982f
Cbud_s2_942 net7 x2_x2_net14 0.0603996f
Cbud_s2_943 net7 x2_x2_net15 0.060444f
Cbud_s2_944 net7 x2_x2_net16 0.0603832f
Cbud_s2_945 net7 x2_x2_net17 0.0603899f
Cbud_s2_946 net7 x2_x2_net18 0.0603998f
Cbud_s2_947 net7 x2_x2_net19 0.0604117f
Cbud_s2_948 net7 x2_x2_net2 0.060595f
Cbud_s2_949 net7 x2_x2_net3 0.0604266f
Cbud_s2_950 net7 x2_x2_net4 2.63665f
Cbud_s2_951 net7 x2_x2_net5 0.285987f
Cbud_s2_952 net7 x2_x2_net6 0.116092f
Cbud_s2_953 net7 x2_x2_net7 0.0732339f
Cbud_s2_954 net7 x2_x2_net8 0.0606829f
Cbud_s2_955 net7 x2_x2_net9 0.0608157f
Cbud_s2_956 net7 Vm 1.18905f
Cbud_s2_957 net7 Vp 1.1894f
Cbud_s2_958 x1_Vbias x1_Vout 5.08853f
Cbud_s2_959 x1_Vbias x1_Vtest2 0.12434f
Cbud_s2_960 x1_Vbias x1_net1 0.12434f
Cbud_s2_961 x1_Vbias x1_net2 0.17044f
Cbud_s2_962 x1_Vbias x1_net3 1.71689f
Cbud_s2_963 x1_Vbias x1_net4 1.71689f
Cbud_s2_964 x1_Vbias x1_net5 0.0397601f
Cbud_s2_965 x1_Vbias x1_net6 0.0397601f
Cbud_s2_966 x1_Vbias x1_net7 1.80829f
Cbud_s2_967 x1_Vbias x1_net8 1.80829f
Cbud_s2_968 x1_Vbias x1_net9 0.542727f
Cbud_s2_969 x1_Vbias x2_Vbiasp 3.92871f
Cbud_s2_970 x1_Vbias x2_Vcm 0.498856f
Cbud_s2_971 x1_Vbias x2_Vout 0.575734f
Cbud_s2_972 x1_Vbias x2_Vtest 0.538698f
Cbud_s2_973 x1_Vbias x2_net1 0.154198f
Cbud_s2_974 x1_Vbias x2_x1_net1 0.115958f
Cbud_s2_975 x1_Vbias x2_x1_net10 0.115992f
Cbud_s2_976 x1_Vbias x2_x1_net11 0.115973f
Cbud_s2_977 x1_Vbias x2_x1_net12 0.116162f
Cbud_s2_978 x1_Vbias x2_x1_net13 0.116251f
Cbud_s2_979 x1_Vbias x2_x1_net14 0.116396f
Cbud_s2_980 x1_Vbias x2_x1_net15 0.116662f
Cbud_s2_981 x1_Vbias x2_x1_net16 0.364854f
Cbud_s2_982 x1_Vbias x2_x1_net17 0.164744f
Cbud_s2_983 x1_Vbias x2_x1_net18 0.126183f
Cbud_s2_984 x1_Vbias x2_x1_net19 0.118095f
Cbud_s2_985 x1_Vbias x2_x1_net2 0.116097f
Cbud_s2_986 x1_Vbias x2_x1_net3 0.117002f
Cbud_s2_987 x1_Vbias x2_x1_net4 0.115923f
Cbud_s2_988 x1_Vbias x2_x1_net5 0.115929f
Cbud_s2_989 x1_Vbias x2_x1_net6 0.115937f
Cbud_s2_990 x1_Vbias x2_x1_net7 0.115946f
Cbud_s2_991 x1_Vbias x2_x1_net8 0.116051f
Cbud_s2_992 x1_Vbias x2_x1_net9 0.116017f
Cbud_s2_993 x1_Vbias x2_x2_net1 0.116984f
Cbud_s2_994 x1_Vbias x2_x2_net10 0.116395f
Cbud_s2_995 x1_Vbias x2_x2_net11 0.116652f
Cbud_s2_996 x1_Vbias x2_x2_net12 0.116051f
Cbud_s2_997 x1_Vbias x2_x2_net13 0.116017f
Cbud_s2_998 x1_Vbias x2_x2_net14 0.115992f
Cbud_s2_999 x1_Vbias x2_x2_net15 0.115973f
Cbud_s2_1000 x1_Vbias x2_x2_net16 0.115923f
Cbud_s2_1001 x1_Vbias x2_x2_net17 0.115929f
Cbud_s2_1002 x1_Vbias x2_x2_net18 0.115937f
Cbud_s2_1003 x1_Vbias x2_x2_net19 0.115946f
Cbud_s2_1004 x1_Vbias x2_x2_net2 0.116096f
Cbud_s2_1005 x1_Vbias x2_x2_net3 0.115958f
Cbud_s2_1006 x1_Vbias x2_x2_net4 0.396232f
Cbud_s2_1007 x1_Vbias x2_x2_net5 0.171838f
Cbud_s2_1008 x1_Vbias x2_x2_net6 0.12587f
Cbud_s2_1009 x1_Vbias x2_x2_net7 0.118146f
Cbud_s2_1010 x1_Vbias x2_x2_net8 0.116162f
Cbud_s2_1011 x1_Vbias x2_x2_net9 0.116255f
Cbud_s2_1012 x1_Vbias Vm 1.18283f
Cbud_s2_1013 x1_Vbias Vp 1.1823f
Cbud_s2_1014 x1_Vout x1_Vtest2 0.237504f
Cbud_s2_1015 x1_Vout x1_net1 0.237504f
Cbud_s2_1016 x1_Vout x1_net2 0.574863f
Cbud_s2_1017 x1_Vout x1_net3 1.74652f
Cbud_s2_1018 x1_Vout x1_net4 1.74652f
Cbud_s2_1019 x1_Vout x1_net5 0.0397601f
Cbud_s2_1020 x1_Vout x1_net6 0.0397601f
Cbud_s2_1021 x1_Vout x1_net7 1.81249f
Cbud_s2_1022 x1_Vout x1_net8 1.81249f
Cbud_s2_1023 x1_Vout x1_net9 10.3493f
Cbud_s2_1024 x1_Vout x2_Vbiasp 0.28582f
Cbud_s2_1025 x1_Vout x2_Vcm 7.94455f
Cbud_s2_1026 x1_Vout x2_Vout 6.20664f
Cbud_s2_1027 x1_Vout x2_Vtest 6.67608f
Cbud_s2_1028 x1_Vout x2_net1 3.30125f
Cbud_s2_1029 x1_Vout x2_x1_net1 0.1533f
Cbud_s2_1030 x1_Vout x2_x1_net10 0.153333f
Cbud_s2_1031 x1_Vout x2_x1_net11 0.153314f
Cbud_s2_1032 x1_Vout x2_x1_net12 0.153499f
Cbud_s2_1033 x1_Vout x2_x1_net13 0.153588f
Cbud_s2_1034 x1_Vout x2_x1_net14 0.153735f
Cbud_s2_1035 x1_Vout x2_x1_net15 0.153979f
Cbud_s2_1036 x1_Vout x2_x1_net16 0.879437f
Cbud_s2_1037 x1_Vout x2_x1_net17 0.238721f
Cbud_s2_1038 x1_Vout x2_x1_net18 0.163773f
Cbud_s2_1039 x1_Vout x2_x1_net19 0.155312f
Cbud_s2_1040 x1_Vout x2_x1_net2 0.153433f
Cbud_s2_1041 x1_Vout x2_x1_net3 0.154459f
Cbud_s2_1042 x1_Vout x2_x1_net4 0.153268f
Cbud_s2_1043 x1_Vout x2_x1_net5 0.153273f
Cbud_s2_1044 x1_Vout x2_x1_net6 0.15328f
Cbud_s2_1045 x1_Vout x2_x1_net7 0.153289f
Cbud_s2_1046 x1_Vout x2_x1_net8 0.153388f
Cbud_s2_1047 x1_Vout x2_x1_net9 0.153356f
Cbud_s2_1048 x1_Vout x2_x2_net1 0.154459f
Cbud_s2_1049 x1_Vout x2_x2_net10 0.153736f
Cbud_s2_1050 x1_Vout x2_x2_net11 0.153979f
Cbud_s2_1051 x1_Vout x2_x2_net12 0.153388f
Cbud_s2_1052 x1_Vout x2_x2_net13 0.153356f
Cbud_s2_1053 x1_Vout x2_x2_net14 0.153332f
Cbud_s2_1054 x1_Vout x2_x2_net15 0.153314f
Cbud_s2_1055 x1_Vout x2_x2_net16 0.153266f
Cbud_s2_1056 x1_Vout x2_x2_net17 0.153273f
Cbud_s2_1057 x1_Vout x2_x2_net18 0.15328f
Cbud_s2_1058 x1_Vout x2_x2_net19 0.153289f
Cbud_s2_1059 x1_Vout x2_x2_net2 0.153434f
Cbud_s2_1060 x1_Vout x2_x2_net3 0.1533f
Cbud_s2_1061 x1_Vout x2_x2_net4 5.8151f
Cbud_s2_1062 x1_Vout x2_x2_net5 0.236089f
Cbud_s2_1063 x1_Vout x2_x2_net6 0.164015f
Cbud_s2_1064 x1_Vout x2_x2_net7 0.155355f
Cbud_s2_1065 x1_Vout x2_x2_net8 0.153499f
Cbud_s2_1066 x1_Vout x2_x2_net9 0.153588f
Cbud_s2_1067 x1_Vout Vm 1.18905f
Cbud_s2_1068 x1_Vout Vp 1.18905f
Cbud_s2_1069 x1_Vtest2 x1_net1 0.0830865f
Cbud_s2_1070 x1_Vtest2 x1_net2 0.0874637f
Cbud_s2_1071 x1_Vtest2 x1_net3 0.0397607f
Cbud_s2_1072 x1_Vtest2 x1_net4 0.0397607f
Cbud_s2_1073 x1_Vtest2 x1_net5 0.0397826f
Cbud_s2_1074 x1_Vtest2 x1_net6 0.03976f
Cbud_s2_1075 x1_Vtest2 x1_net7 0.0830863f
Cbud_s2_1076 x1_Vtest2 x1_net8 0.528583f
Cbud_s2_1077 x1_Vtest2 x1_net9 0.0830871f
Cbud_s2_1078 x1_Vtest2 x2_Vbiasp 0.0830871f
Cbud_s2_1079 x1_Vtest2 x2_Vcm 0.0830871f
Cbud_s2_1080 x1_Vtest2 x2_Vout 0.0830871f
Cbud_s2_1081 x1_Vtest2 x2_Vtest 0.0830871f
Cbud_s2_1082 x1_Vtest2 x2_net1 0.0751543f
Cbud_s2_1083 x1_Vtest2 x2_x1_net1 0.528043f
Cbud_s2_1084 x1_Vtest2 x2_x1_net10 0.528052f
Cbud_s2_1085 x1_Vtest2 x2_x1_net11 0.528048f
Cbud_s2_1086 x1_Vtest2 x2_x1_net12 0.528073f
Cbud_s2_1087 x1_Vtest2 x2_x1_net13 0.528078f
Cbud_s2_1088 x1_Vtest2 x2_x1_net14 0.528084f
Cbud_s2_1089 x1_Vtest2 x2_x1_net15 0.528089f
Cbud_s2_1090 x1_Vtest2 x2_x1_net16 0.528117f
Cbud_s2_1091 x1_Vtest2 x2_x1_net17 0.528112f
Cbud_s2_1092 x1_Vtest2 x2_x1_net18 0.528107f
Cbud_s2_1093 x1_Vtest2 x2_x1_net19 0.528101f
Cbud_s2_1094 x1_Vtest2 x2_x1_net2 0.528067f
Cbud_s2_1095 x1_Vtest2 x2_x1_net3 0.528095f
Cbud_s2_1096 x1_Vtest2 x2_x1_net4 0.528026f
Cbud_s2_1097 x1_Vtest2 x2_x1_net5 0.52803f
Cbud_s2_1098 x1_Vtest2 x2_x1_net6 0.528034f
Cbud_s2_1099 x1_Vtest2 x2_x1_net7 0.528038f
Cbud_s2_1100 x1_Vtest2 x2_x1_net8 0.528062f
Cbud_s2_1101 x1_Vtest2 x2_x1_net9 0.528057f
Cbud_s2_1102 x1_Vtest2 x2_x2_net1 0.0830863f
Cbud_s2_1103 x1_Vtest2 x2_x2_net10 0.0830863f
Cbud_s2_1104 x1_Vtest2 x2_x2_net11 0.0830863f
Cbud_s2_1105 x1_Vtest2 x2_x2_net12 0.0830863f
Cbud_s2_1106 x1_Vtest2 x2_x2_net13 0.0830863f
Cbud_s2_1107 x1_Vtest2 x2_x2_net14 0.0830863f
Cbud_s2_1108 x1_Vtest2 x2_x2_net15 0.0830863f
Cbud_s2_1109 x1_Vtest2 x2_x2_net16 0.0830863f
Cbud_s2_1110 x1_Vtest2 x2_x2_net17 0.0830863f
Cbud_s2_1111 x1_Vtest2 x2_x2_net18 0.0830863f
Cbud_s2_1112 x1_Vtest2 x2_x2_net19 0.0830863f
Cbud_s2_1113 x1_Vtest2 x2_x2_net2 0.0830863f
Cbud_s2_1114 x1_Vtest2 x2_x2_net3 0.0830863f
Cbud_s2_1115 x1_Vtest2 x2_x2_net4 0.0830863f
Cbud_s2_1116 x1_Vtest2 x2_x2_net5 0.0830863f
Cbud_s2_1117 x1_Vtest2 x2_x2_net6 0.0830863f
Cbud_s2_1118 x1_Vtest2 x2_x2_net7 0.0830863f
Cbud_s2_1119 x1_Vtest2 x2_x2_net8 0.0830863f
Cbud_s2_1120 x1_Vtest2 x2_x2_net9 0.0830863f
Cbud_s2_1121 x1_Vtest2 Vm 0.104245f
Cbud_s2_1122 x1_Vtest2 Vp 0.0270778f
Cbud_s2_1123 x1_net1 x1_net2 0.0874637f
Cbud_s2_1124 x1_net1 x1_net3 0.0397607f
Cbud_s2_1125 x1_net1 x1_net4 0.0397607f
Cbud_s2_1126 x1_net1 x1_net5 0.03976f
Cbud_s2_1127 x1_net1 x1_net6 0.0397825f
Cbud_s2_1128 x1_net1 x1_net7 0.528583f
Cbud_s2_1129 x1_net1 x1_net8 0.0830863f
Cbud_s2_1130 x1_net1 x1_net9 0.0830871f
Cbud_s2_1131 x1_net1 x2_Vbiasp 0.0830871f
Cbud_s2_1132 x1_net1 x2_Vcm 0.0830871f
Cbud_s2_1133 x1_net1 x2_Vout 0.0830871f
Cbud_s2_1134 x1_net1 x2_Vtest 0.0830871f
Cbud_s2_1135 x1_net1 x2_net1 0.0751543f
Cbud_s2_1136 x1_net1 x2_x1_net1 0.0830863f
Cbud_s2_1137 x1_net1 x2_x1_net10 0.0830863f
Cbud_s2_1138 x1_net1 x2_x1_net11 0.0830863f
Cbud_s2_1139 x1_net1 x2_x1_net12 0.0830863f
Cbud_s2_1140 x1_net1 x2_x1_net13 0.0830863f
Cbud_s2_1141 x1_net1 x2_x1_net14 0.0830863f
Cbud_s2_1142 x1_net1 x2_x1_net15 0.0830863f
Cbud_s2_1143 x1_net1 x2_x1_net16 0.0830863f
Cbud_s2_1144 x1_net1 x2_x1_net17 0.0830863f
Cbud_s2_1145 x1_net1 x2_x1_net18 0.0830863f
Cbud_s2_1146 x1_net1 x2_x1_net19 0.0830863f
Cbud_s2_1147 x1_net1 x2_x1_net2 0.0830863f
Cbud_s2_1148 x1_net1 x2_x1_net3 0.0830863f
Cbud_s2_1149 x1_net1 x2_x1_net4 0.0830863f
Cbud_s2_1150 x1_net1 x2_x1_net5 0.0830863f
Cbud_s2_1151 x1_net1 x2_x1_net6 0.0830863f
Cbud_s2_1152 x1_net1 x2_x1_net7 0.0830863f
Cbud_s2_1153 x1_net1 x2_x1_net8 0.0830863f
Cbud_s2_1154 x1_net1 x2_x1_net9 0.0830863f
Cbud_s2_1155 x1_net1 x2_x2_net1 0.528095f
Cbud_s2_1156 x1_net1 x2_x2_net10 0.528084f
Cbud_s2_1157 x1_net1 x2_x2_net11 0.528089f
Cbud_s2_1158 x1_net1 x2_x2_net12 0.528062f
Cbud_s2_1159 x1_net1 x2_x2_net13 0.528057f
Cbud_s2_1160 x1_net1 x2_x2_net14 0.528052f
Cbud_s2_1161 x1_net1 x2_x2_net15 0.528048f
Cbud_s2_1162 x1_net1 x2_x2_net16 0.528026f
Cbud_s2_1163 x1_net1 x2_x2_net17 0.52803f
Cbud_s2_1164 x1_net1 x2_x2_net18 0.528034f
Cbud_s2_1165 x1_net1 x2_x2_net19 0.528038f
Cbud_s2_1166 x1_net1 x2_x2_net2 0.528067f
Cbud_s2_1167 x1_net1 x2_x2_net3 0.528043f
Cbud_s2_1168 x1_net1 x2_x2_net4 0.528117f
Cbud_s2_1169 x1_net1 x2_x2_net5 0.528112f
Cbud_s2_1170 x1_net1 x2_x2_net6 0.528107f
Cbud_s2_1171 x1_net1 x2_x2_net7 0.528101f
Cbud_s2_1172 x1_net1 x2_x2_net8 0.528073f
Cbud_s2_1173 x1_net1 x2_x2_net9 0.528078f
Cbud_s2_1174 x1_net1 Vm 0.0270778f
Cbud_s2_1175 x1_net1 Vp 0.104245f
Cbud_s2_1176 x1_net2 x1_net3 2.34348f
Cbud_s2_1177 x1_net2 x1_net4 2.34412f
Cbud_s2_1178 x1_net2 x1_net5 0.0397601f
Cbud_s2_1179 x1_net2 x1_net6 0.0397601f
Cbud_s2_1180 x1_net2 x1_net7 1.8025f
Cbud_s2_1181 x1_net2 x1_net8 1.8025f
Cbud_s2_1182 x1_net2 x1_net9 3.492f
Cbud_s2_1183 x1_net2 x2_Vbiasp 3.49304f
Cbud_s2_1184 x1_net2 x2_Vcm 3.492f
Cbud_s2_1185 x1_net2 x2_Vout 3.49065f
Cbud_s2_1186 x1_net2 x2_Vtest 3.492f
Cbud_s2_1187 x1_net2 x2_net1 3.29827f
Cbud_s2_1188 x1_net2 x2_x1_net1 0.0796121f
Cbud_s2_1189 x1_net2 x2_x1_net10 0.079652f
Cbud_s2_1190 x1_net2 x2_x1_net11 0.0796292f
Cbud_s2_1191 x1_net2 x2_x1_net12 0.0798433f
Cbud_s2_1192 x1_net2 x2_x1_net13 0.0799632f
Cbud_s2_1193 x1_net2 x2_x1_net14 0.0801559f
Cbud_s2_1194 x1_net2 x2_x1_net15 0.0803762f
Cbud_s2_1195 x1_net2 x2_x1_net16 3.46701f
Cbud_s2_1196 x1_net2 x2_x1_net17 0.282133f
Cbud_s2_1197 x1_net2 x2_x1_net18 0.114429f
Cbud_s2_1198 x1_net2 x2_x1_net19 0.0868111f
Cbud_s2_1199 x1_net2 x2_x1_net2 0.0797702f
Cbud_s2_1200 x1_net2 x2_x1_net3 0.081338f
Cbud_s2_1201 x1_net2 x2_x1_net4 0.0795727f
Cbud_s2_1202 x1_net2 x2_x1_net5 0.0795795f
Cbud_s2_1203 x1_net2 x2_x1_net6 0.079588f
Cbud_s2_1204 x1_net2 x2_x1_net7 0.0795987f
Cbud_s2_1205 x1_net2 x2_x1_net8 0.0797186f
Cbud_s2_1206 x1_net2 x2_x1_net9 0.0796787f
Cbud_s2_1207 x1_net2 x2_x2_net1 0.0812602f
Cbud_s2_1208 x1_net2 x2_x2_net10 0.0801541f
Cbud_s2_1209 x1_net2 x2_x2_net11 0.080387f
Cbud_s2_1210 x1_net2 x2_x2_net12 0.0797184f
Cbud_s2_1211 x1_net2 x2_x2_net13 0.0796793f
Cbud_s2_1212 x1_net2 x2_x2_net14 0.0796518f
Cbud_s2_1213 x1_net2 x2_x2_net15 0.0796293f
Cbud_s2_1214 x1_net2 x2_x2_net16 0.0795723f
Cbud_s2_1215 x1_net2 x2_x2_net17 0.0795802f
Cbud_s2_1216 x1_net2 x2_x2_net18 0.079588f
Cbud_s2_1217 x1_net2 x2_x2_net19 0.0795987f
Cbud_s2_1218 x1_net2 x2_x2_net2 0.0797693f
Cbud_s2_1219 x1_net2 x2_x2_net3 0.0796121f
Cbud_s2_1220 x1_net2 x2_x2_net4 3.46573f
Cbud_s2_1221 x1_net2 x2_x2_net5 0.301371f
Cbud_s2_1222 x1_net2 x2_x2_net6 0.117864f
Cbud_s2_1223 x1_net2 x2_x2_net7 0.0871309f
Cbud_s2_1224 x1_net2 x2_x2_net8 0.0798425f
Cbud_s2_1225 x1_net2 x2_x2_net9 0.0799614f
Cbud_s2_1226 x1_net2 Vm 4.57776f
Cbud_s2_1227 x1_net2 Vp 4.57912f
Cbud_s2_1228 x1_net3 x1_net4 1.74652f
Cbud_s2_1229 x1_net3 x1_net5 0.0397601f
Cbud_s2_1230 x1_net3 x1_net6 0.0397601f
Cbud_s2_1231 x1_net3 x1_net7 1.64468f
Cbud_s2_1232 x1_net3 x1_net8 1.64468f
Cbud_s2_1233 x1_net3 x1_net9 1.74652f
Cbud_s2_1234 x1_net3 x2_Vbiasp 1.746f
Cbud_s2_1235 x1_net3 x2_Vcm 1.74652f
Cbud_s2_1236 x1_net3 x2_Vout 1.74586f
Cbud_s2_1237 x1_net3 x2_Vtest 1.746f
Cbud_s2_1238 x1_net3 x2_net1 1.74548f
Cbud_s2_1239 x1_net3 x2_x1_net1 0.0398688f
Cbud_s2_1240 x1_net3 x2_x1_net10 0.0399137f
Cbud_s2_1241 x1_net3 x2_x1_net11 0.0398881f
Cbud_s2_1242 x1_net3 x2_x1_net12 0.0401355f
Cbud_s2_1243 x1_net3 x2_x1_net13 0.0402855f
Cbud_s2_1244 x1_net3 x2_x1_net14 0.0407277f
Cbud_s2_1245 x1_net3 x2_x1_net15 0.0422581f
Cbud_s2_1246 x1_net3 x2_x1_net16 1.74259f
Cbud_s2_1247 x1_net3 x2_x1_net17 0.295019f
Cbud_s2_1248 x1_net3 x2_x1_net18 0.126427f
Cbud_s2_1249 x1_net3 x2_x1_net19 0.062933f
Cbud_s2_1250 x1_net3 x2_x1_net2 0.0400715f
Cbud_s2_1251 x1_net3 x2_x1_net3 0.0476386f
Cbud_s2_1252 x1_net3 x2_x1_net4 0.0398209f
Cbud_s2_1253 x1_net3 x2_x1_net5 0.0398295f
Cbud_s2_1254 x1_net3 x2_x1_net6 0.0398392f
Cbud_s2_1255 x1_net3 x2_x1_net7 0.0397876f
Cbud_s2_1256 x1_net3 x2_x1_net8 0.0399995f
Cbud_s2_1257 x1_net3 x2_x1_net9 0.0399477f
Cbud_s2_1258 x1_net3 x2_x2_net1 0.0471645f
Cbud_s2_1259 x1_net3 x2_x2_net10 0.0407097f
Cbud_s2_1260 x1_net3 x2_x2_net11 0.0423139f
Cbud_s2_1261 x1_net3 x2_x2_net12 0.0399992f
Cbud_s2_1262 x1_net3 x2_x2_net13 0.0399482f
Cbud_s2_1263 x1_net3 x2_x2_net14 0.0399134f
Cbud_s2_1264 x1_net3 x2_x2_net15 0.0398879f
Cbud_s2_1265 x1_net3 x2_x2_net16 0.0398208f
Cbud_s2_1266 x1_net3 x2_x2_net17 0.0398292f
Cbud_s2_1267 x1_net3 x2_x2_net18 0.0398391f
Cbud_s2_1268 x1_net3 x2_x2_net19 0.0397956f
Cbud_s2_1269 x1_net3 x2_x2_net2 0.0400705f
Cbud_s2_1270 x1_net3 x2_x2_net3 0.0398689f
Cbud_s2_1271 x1_net3 x2_x2_net4 1.74259f
Cbud_s2_1272 x1_net3 x2_x2_net5 0.316943f
Cbud_s2_1273 x1_net3 x2_x2_net6 0.132498f
Cbud_s2_1274 x1_net3 x2_x2_net7 0.0644501f
Cbud_s2_1275 x1_net3 x2_x2_net8 0.040135f
Cbud_s2_1276 x1_net3 x2_x2_net9 0.0402828f
Cbud_s2_1277 x1_net3 Vm 1.18905f
Cbud_s2_1278 x1_net3 Vp 1.18905f
Cbud_s2_1279 x1_net4 x1_net5 0.0397601f
Cbud_s2_1280 x1_net4 x1_net6 0.0397601f
Cbud_s2_1281 x1_net4 x1_net7 1.64468f
Cbud_s2_1282 x1_net4 x1_net8 1.64468f
Cbud_s2_1283 x1_net4 x1_net9 1.746f
Cbud_s2_1284 x1_net4 x2_Vbiasp 1.74652f
Cbud_s2_1285 x1_net4 x2_Vcm 1.746f
Cbud_s2_1286 x1_net4 x2_Vout 1.74586f
Cbud_s2_1287 x1_net4 x2_Vtest 1.746f
Cbud_s2_1288 x1_net4 x2_net1 1.74548f
Cbud_s2_1289 x1_net4 x2_x1_net1 0.0398688f
Cbud_s2_1290 x1_net4 x2_x1_net10 0.0399137f
Cbud_s2_1291 x1_net4 x2_x1_net11 0.0398881f
Cbud_s2_1292 x1_net4 x2_x1_net12 0.0401355f
Cbud_s2_1293 x1_net4 x2_x1_net13 0.0402855f
Cbud_s2_1294 x1_net4 x2_x1_net14 0.0407277f
Cbud_s2_1295 x1_net4 x2_x1_net15 0.0422581f
Cbud_s2_1296 x1_net4 x2_x1_net16 1.74259f
Cbud_s2_1297 x1_net4 x2_x1_net17 0.295019f
Cbud_s2_1298 x1_net4 x2_x1_net18 0.126427f
Cbud_s2_1299 x1_net4 x2_x1_net19 0.062933f
Cbud_s2_1300 x1_net4 x2_x1_net2 0.0400715f
Cbud_s2_1301 x1_net4 x2_x1_net3 0.0476386f
Cbud_s2_1302 x1_net4 x2_x1_net4 0.0398213f
Cbud_s2_1303 x1_net4 x2_x1_net5 0.0398295f
Cbud_s2_1304 x1_net4 x2_x1_net6 0.0398392f
Cbud_s2_1305 x1_net4 x2_x1_net7 0.0397876f
Cbud_s2_1306 x1_net4 x2_x1_net8 0.0399995f
Cbud_s2_1307 x1_net4 x2_x1_net9 0.0399477f
Cbud_s2_1308 x1_net4 x2_x2_net1 0.0471645f
Cbud_s2_1309 x1_net4 x2_x2_net10 0.0407097f
Cbud_s2_1310 x1_net4 x2_x2_net11 0.0423139f
Cbud_s2_1311 x1_net4 x2_x2_net12 0.0399992f
Cbud_s2_1312 x1_net4 x2_x2_net13 0.0399482f
Cbud_s2_1313 x1_net4 x2_x2_net14 0.0399134f
Cbud_s2_1314 x1_net4 x2_x2_net15 0.0398879f
Cbud_s2_1315 x1_net4 x2_x2_net16 0.0398208f
Cbud_s2_1316 x1_net4 x2_x2_net17 0.0398298f
Cbud_s2_1317 x1_net4 x2_x2_net18 0.0398391f
Cbud_s2_1318 x1_net4 x2_x2_net19 0.0397956f
Cbud_s2_1319 x1_net4 x2_x2_net2 0.0400705f
Cbud_s2_1320 x1_net4 x2_x2_net3 0.0398689f
Cbud_s2_1321 x1_net4 x2_x2_net4 1.74259f
Cbud_s2_1322 x1_net4 x2_x2_net5 0.316943f
Cbud_s2_1323 x1_net4 x2_x2_net6 0.132498f
Cbud_s2_1324 x1_net4 x2_x2_net7 0.0644501f
Cbud_s2_1325 x1_net4 x2_x2_net8 0.040135f
Cbud_s2_1326 x1_net4 x2_x2_net9 0.0402828f
Cbud_s2_1327 x1_net4 Vm 1.18905f
Cbud_s2_1328 x1_net4 Vp 1.18905f
Cbud_s2_1329 x1_net5 x1_net6 0.0397599f
Cbud_s2_1330 x1_net5 x1_net7 0.0397599f
Cbud_s2_1331 x1_net5 x1_net8 1.74238f
Cbud_s2_1332 x1_net5 x1_net9 0.0397601f
Cbud_s2_1333 x1_net5 x2_Vbiasp 0.0397601f
Cbud_s2_1334 x1_net5 x2_Vcm 0.0397601f
Cbud_s2_1335 x1_net5 x2_Vout 0.0397601f
Cbud_s2_1336 x1_net5 x2_Vtest 0.0397601f
Cbud_s2_1337 x1_net5 x2_net1 0.0397601f
Cbud_s2_1338 x1_net5 x2_x1_net1 0.253677f
Cbud_s2_1339 x1_net5 x2_x1_net10 0.254135f
Cbud_s2_1340 x1_net5 x2_x1_net11 0.253868f
Cbud_s2_1341 x1_net5 x2_x1_net12 0.259146f
Cbud_s2_1342 x1_net5 x2_x1_net13 0.271734f
Cbud_s2_1343 x1_net5 x2_x1_net14 0.409023f
Cbud_s2_1344 x1_net5 x2_x1_net15 0.489121f
Cbud_s2_1345 x1_net5 x2_x1_net16 1.74219f
Cbud_s2_1346 x1_net5 x2_x1_net17 1.50038f
Cbud_s2_1347 x1_net5 x2_x1_net18 1.00674f
Cbud_s2_1348 x1_net5 x2_x1_net19 0.748176f
Cbud_s2_1349 x1_net5 x2_x1_net2 0.256332f
Cbud_s2_1350 x1_net5 x2_x1_net3 0.592704f
Cbud_s2_1351 x1_net5 x2_x1_net4 0.253257f
Cbud_s2_1352 x1_net5 x2_x1_net5 0.25333f
Cbud_s2_1353 x1_net5 x2_x1_net6 0.25342f
Cbud_s2_1354 x1_net5 x2_x1_net7 0.253532f
Cbud_s2_1355 x1_net5 x2_x1_net8 0.255161f
Cbud_s2_1356 x1_net5 x2_x1_net9 0.254527f
Cbud_s2_1357 x1_net5 x2_x2_net1 0.0397599f
Cbud_s2_1358 x1_net5 x2_x2_net10 0.0397599f
Cbud_s2_1359 x1_net5 x2_x2_net11 0.0397599f
Cbud_s2_1360 x1_net5 x2_x2_net12 0.0397599f
Cbud_s2_1361 x1_net5 x2_x2_net13 0.0397599f
Cbud_s2_1362 x1_net5 x2_x2_net14 0.0397599f
Cbud_s2_1363 x1_net5 x2_x2_net15 0.0397599f
Cbud_s2_1364 x1_net5 x2_x2_net16 0.0397599f
Cbud_s2_1365 x1_net5 x2_x2_net17 0.0397599f
Cbud_s2_1366 x1_net5 x2_x2_net18 0.0397599f
Cbud_s2_1367 x1_net5 x2_x2_net19 0.0397599f
Cbud_s2_1368 x1_net5 x2_x2_net2 0.0397599f
Cbud_s2_1369 x1_net5 x2_x2_net3 0.0397599f
Cbud_s2_1370 x1_net5 x2_x2_net4 0.0397599f
Cbud_s2_1371 x1_net5 x2_x2_net5 0.0397599f
Cbud_s2_1372 x1_net5 x2_x2_net6 0.0397599f
Cbud_s2_1373 x1_net5 x2_x2_net7 0.0397599f
Cbud_s2_1374 x1_net5 x2_x2_net8 0.0397599f
Cbud_s2_1375 x1_net5 x2_x2_net9 0.0397599f
Cbud_s2_1376 x1_net5 Vm 0.0270773f
Cbud_s2_1377 x1_net5 Vp 0.0270773f
Cbud_s2_1378 x1_net6 x1_net7 1.74238f
Cbud_s2_1379 x1_net6 x1_net8 0.0397599f
Cbud_s2_1380 x1_net6 x1_net9 0.0397601f
Cbud_s2_1381 x1_net6 x2_Vbiasp 0.0397601f
Cbud_s2_1382 x1_net6 x2_Vcm 0.0397601f
Cbud_s2_1383 x1_net6 x2_Vout 0.0397601f
Cbud_s2_1384 x1_net6 x2_Vtest 0.0397601f
Cbud_s2_1385 x1_net6 x2_net1 0.0397601f
Cbud_s2_1386 x1_net6 x2_x1_net1 0.0397599f
Cbud_s2_1387 x1_net6 x2_x1_net10 0.0397599f
Cbud_s2_1388 x1_net6 x2_x1_net11 0.0397599f
Cbud_s2_1389 x1_net6 x2_x1_net12 0.0397599f
Cbud_s2_1390 x1_net6 x2_x1_net13 0.0397599f
Cbud_s2_1391 x1_net6 x2_x1_net14 0.0397599f
Cbud_s2_1392 x1_net6 x2_x1_net15 0.0397599f
Cbud_s2_1393 x1_net6 x2_x1_net16 0.0397599f
Cbud_s2_1394 x1_net6 x2_x1_net17 0.0397599f
Cbud_s2_1395 x1_net6 x2_x1_net18 0.0397599f
Cbud_s2_1396 x1_net6 x2_x1_net19 0.0397599f
Cbud_s2_1397 x1_net6 x2_x1_net2 0.0397599f
Cbud_s2_1398 x1_net6 x2_x1_net3 0.0397599f
Cbud_s2_1399 x1_net6 x2_x1_net4 0.0397599f
Cbud_s2_1400 x1_net6 x2_x1_net5 0.0397599f
Cbud_s2_1401 x1_net6 x2_x1_net6 0.0397599f
Cbud_s2_1402 x1_net6 x2_x1_net7 0.0397599f
Cbud_s2_1403 x1_net6 x2_x1_net8 0.0397599f
Cbud_s2_1404 x1_net6 x2_x1_net9 0.0397599f
Cbud_s2_1405 x1_net6 x2_x2_net1 0.592704f
Cbud_s2_1406 x1_net6 x2_x2_net10 0.409023f
Cbud_s2_1407 x1_net6 x2_x2_net11 0.489121f
Cbud_s2_1408 x1_net6 x2_x2_net12 0.255161f
Cbud_s2_1409 x1_net6 x2_x2_net13 0.254527f
Cbud_s2_1410 x1_net6 x2_x2_net14 0.254135f
Cbud_s2_1411 x1_net6 x2_x2_net15 0.253868f
Cbud_s2_1412 x1_net6 x2_x2_net16 0.253257f
Cbud_s2_1413 x1_net6 x2_x2_net17 0.25333f
Cbud_s2_1414 x1_net6 x2_x2_net18 0.25342f
Cbud_s2_1415 x1_net6 x2_x2_net19 0.253532f
Cbud_s2_1416 x1_net6 x2_x2_net2 0.256332f
Cbud_s2_1417 x1_net6 x2_x2_net3 0.253677f
Cbud_s2_1418 x1_net6 x2_x2_net4 1.74219f
Cbud_s2_1419 x1_net6 x2_x2_net5 1.50038f
Cbud_s2_1420 x1_net6 x2_x2_net6 1.00674f
Cbud_s2_1421 x1_net6 x2_x2_net7 0.748176f
Cbud_s2_1422 x1_net6 x2_x2_net8 0.259146f
Cbud_s2_1423 x1_net6 x2_x2_net9 0.271734f
Cbud_s2_1424 x1_net6 Vm 0.0270773f
Cbud_s2_1425 x1_net6 Vp 0.0270773f
Cbud_s2_1426 x1_net7 x1_net8 0.985614f
Cbud_s2_1427 x1_net7 x1_net9 1.81256f
Cbud_s2_1428 x1_net7 x2_Vbiasp 1.80463f
Cbud_s2_1429 x1_net7 x2_Vcm 1.81252f
Cbud_s2_1430 x1_net7 x2_Vout 1.81039f
Cbud_s2_1431 x1_net7 x2_Vtest 1.81217f
Cbud_s2_1432 x1_net7 x2_net1 1.80127f
Cbud_s2_1433 x1_net7 x2_x1_net1 0.975695f
Cbud_s2_1434 x1_net7 x2_x1_net10 0.976415f
Cbud_s2_1435 x1_net7 x2_x1_net11 0.976016f
Cbud_s2_1436 x1_net7 x2_x1_net12 0.979685f
Cbud_s2_1437 x1_net7 x2_x1_net13 0.981481f
Cbud_s2_1438 x1_net7 x2_x1_net14 0.984301f
Cbud_s2_1439 x1_net7 x2_x1_net15 0.989172f
Cbud_s2_1440 x1_net7 x2_x1_net16 1.62289f
Cbud_s2_1441 x1_net7 x2_x1_net17 1.41924f
Cbud_s2_1442 x1_net7 x2_x1_net18 1.13879f
Cbud_s2_1443 x1_net7 x2_x1_net19 1.02539f
Cbud_s2_1444 x1_net7 x2_x1_net2 0.978459f
Cbud_s2_1445 x1_net7 x2_x1_net3 0.999026f
Cbud_s2_1446 x1_net7 x2_x1_net4 0.974876f
Cbud_s2_1447 x1_net7 x2_x1_net5 0.975031f
Cbud_s2_1448 x1_net7 x2_x1_net6 0.975215f
Cbud_s2_1449 x1_net7 x2_x1_net7 0.975433f
Cbud_s2_1450 x1_net7 x2_x1_net8 0.977578f
Cbud_s2_1451 x1_net7 x2_x1_net9 0.976921f
Cbud_s2_1452 x1_net7 x2_x2_net1 0.153279f
Cbud_s2_1453 x1_net7 x2_x2_net10 0.153258f
Cbud_s2_1454 x1_net7 x2_x2_net11 0.153266f
Cbud_s2_1455 x1_net7 x2_x2_net12 0.153241f
Cbud_s2_1456 x1_net7 x2_x2_net13 0.153238f
Cbud_s2_1457 x1_net7 x2_x2_net14 0.153236f
Cbud_s2_1458 x1_net7 x2_x2_net15 0.153235f
Cbud_s2_1459 x1_net7 x2_x2_net16 0.153229f
Cbud_s2_1460 x1_net7 x2_x2_net17 0.15323f
Cbud_s2_1461 x1_net7 x2_x2_net18 0.153231f
Cbud_s2_1462 x1_net7 x2_x2_net19 0.153232f
Cbud_s2_1463 x1_net7 x2_x2_net2 0.153243f
Cbud_s2_1464 x1_net7 x2_x2_net3 0.153233f
Cbud_s2_1465 x1_net7 x2_x2_net4 0.154245f
Cbud_s2_1466 x1_net7 x2_x2_net5 0.153453f
Cbud_s2_1467 x1_net7 x2_x2_net6 0.153341f
Cbud_s2_1468 x1_net7 x2_x2_net7 0.1533f
Cbud_s2_1469 x1_net7 x2_x2_net8 0.153247f
Cbud_s2_1470 x1_net7 x2_x2_net9 0.153252f
Cbud_s2_1471 x1_net7 Vm 1.09844f
Cbud_s2_1472 x1_net7 Vp 0.173895f
Cbud_s2_1473 x1_net8 x1_net9 1.81256f
Cbud_s2_1474 x1_net8 x2_Vbiasp 1.80463f
Cbud_s2_1475 x1_net8 x2_Vcm 1.81252f
Cbud_s2_1476 x1_net8 x2_Vout 1.81039f
Cbud_s2_1477 x1_net8 x2_Vtest 1.81217f
Cbud_s2_1478 x1_net8 x2_net1 1.80127f
Cbud_s2_1479 x1_net8 x2_x1_net1 0.153233f
Cbud_s2_1480 x1_net8 x2_x1_net10 0.153236f
Cbud_s2_1481 x1_net8 x2_x1_net11 0.153235f
Cbud_s2_1482 x1_net8 x2_x1_net12 0.153247f
Cbud_s2_1483 x1_net8 x2_x1_net13 0.153252f
Cbud_s2_1484 x1_net8 x2_x1_net14 0.153258f
Cbud_s2_1485 x1_net8 x2_x1_net15 0.153266f
Cbud_s2_1486 x1_net8 x2_x1_net16 0.154246f
Cbud_s2_1487 x1_net8 x2_x1_net17 0.153452f
Cbud_s2_1488 x1_net8 x2_x1_net18 0.153341f
Cbud_s2_1489 x1_net8 x2_x1_net19 0.1533f
Cbud_s2_1490 x1_net8 x2_x1_net2 0.153243f
Cbud_s2_1491 x1_net8 x2_x1_net3 0.153279f
Cbud_s2_1492 x1_net8 x2_x1_net4 0.153229f
Cbud_s2_1493 x1_net8 x2_x1_net5 0.15323f
Cbud_s2_1494 x1_net8 x2_x1_net6 0.153231f
Cbud_s2_1495 x1_net8 x2_x1_net7 0.153232f
Cbud_s2_1496 x1_net8 x2_x1_net8 0.153241f
Cbud_s2_1497 x1_net8 x2_x1_net9 0.153238f
Cbud_s2_1498 x1_net8 x2_x2_net1 0.999026f
Cbud_s2_1499 x1_net8 x2_x2_net10 0.984301f
Cbud_s2_1500 x1_net8 x2_x2_net11 0.989172f
Cbud_s2_1501 x1_net8 x2_x2_net12 0.977578f
Cbud_s2_1502 x1_net8 x2_x2_net13 0.976921f
Cbud_s2_1503 x1_net8 x2_x2_net14 0.976415f
Cbud_s2_1504 x1_net8 x2_x2_net15 0.976016f
Cbud_s2_1505 x1_net8 x2_x2_net16 0.974876f
Cbud_s2_1506 x1_net8 x2_x2_net17 0.975031f
Cbud_s2_1507 x1_net8 x2_x2_net18 0.975215f
Cbud_s2_1508 x1_net8 x2_x2_net19 0.975433f
Cbud_s2_1509 x1_net8 x2_x2_net2 0.978459f
Cbud_s2_1510 x1_net8 x2_x2_net3 0.975695f
Cbud_s2_1511 x1_net8 x2_x2_net4 1.62289f
Cbud_s2_1512 x1_net8 x2_x2_net5 1.41924f
Cbud_s2_1513 x1_net8 x2_x2_net6 1.13879f
Cbud_s2_1514 x1_net8 x2_x2_net7 1.02539f
Cbud_s2_1515 x1_net8 x2_x2_net8 0.979685f
Cbud_s2_1516 x1_net8 x2_x2_net9 0.981481f
Cbud_s2_1517 x1_net8 Vm 0.173895f
Cbud_s2_1518 x1_net8 Vp 1.09844f
Cbud_s2_1519 x1_net9 x2_Vbiasp 3.9415f
Cbud_s2_1520 x1_net9 x2_Vcm 7.94019f
Cbud_s2_1521 x1_net9 x2_Vout 6.20907f
Cbud_s2_1522 x1_net9 x2_Vtest 6.67424f
Cbud_s2_1523 x1_net9 x2_net1 3.2996f
Cbud_s2_1524 x1_net9 x2_x1_net1 0.1533f
Cbud_s2_1525 x1_net9 x2_x1_net10 0.153332f
Cbud_s2_1526 x1_net9 x2_x1_net11 0.153314f
Cbud_s2_1527 x1_net9 x2_x1_net12 0.153498f
Cbud_s2_1528 x1_net9 x2_x1_net13 0.153585f
Cbud_s2_1529 x1_net9 x2_x1_net14 0.153735f
Cbud_s2_1530 x1_net9 x2_x1_net15 0.153979f
Cbud_s2_1531 x1_net9 x2_x1_net16 0.835666f
Cbud_s2_1532 x1_net9 x2_x1_net17 0.250161f
Cbud_s2_1533 x1_net9 x2_x1_net18 0.164765f
Cbud_s2_1534 x1_net9 x2_x1_net19 0.155355f
Cbud_s2_1535 x1_net9 x2_x1_net2 0.153433f
Cbud_s2_1536 x1_net9 x2_x1_net3 0.154462f
Cbud_s2_1537 x1_net9 x2_x1_net4 0.153267f
Cbud_s2_1538 x1_net9 x2_x1_net5 0.153273f
Cbud_s2_1539 x1_net9 x2_x1_net6 0.153281f
Cbud_s2_1540 x1_net9 x2_x1_net7 0.153289f
Cbud_s2_1541 x1_net9 x2_x1_net8 0.153388f
Cbud_s2_1542 x1_net9 x2_x1_net9 0.153356f
Cbud_s2_1543 x1_net9 x2_x2_net1 0.154459f
Cbud_s2_1544 x1_net9 x2_x2_net10 0.153734f
Cbud_s2_1545 x1_net9 x2_x2_net11 0.153987f
Cbud_s2_1546 x1_net9 x2_x2_net12 0.153388f
Cbud_s2_1547 x1_net9 x2_x2_net13 0.153356f
Cbud_s2_1548 x1_net9 x2_x2_net14 0.153333f
Cbud_s2_1549 x1_net9 x2_x2_net15 0.153314f
Cbud_s2_1550 x1_net9 x2_x2_net16 0.153267f
Cbud_s2_1551 x1_net9 x2_x2_net17 0.153273f
Cbud_s2_1552 x1_net9 x2_x2_net18 0.15328f
Cbud_s2_1553 x1_net9 x2_x2_net19 0.153289f
Cbud_s2_1554 x1_net9 x2_x2_net2 0.153433f
Cbud_s2_1555 x1_net9 x2_x2_net3 0.1533f
Cbud_s2_1556 x1_net9 x2_x2_net4 6.45081f
Cbud_s2_1557 x1_net9 x2_x2_net5 0.258584f
Cbud_s2_1558 x1_net9 x2_x2_net6 0.165579f
Cbud_s2_1559 x1_net9 x2_x2_net7 0.155407f
Cbud_s2_1560 x1_net9 x2_x2_net8 0.153499f
Cbud_s2_1561 x1_net9 x2_x2_net9 0.153577f
Cbud_s2_1562 x1_net9 Vm 1.1894f
Cbud_s2_1563 x1_net9 Vp 1.18905f
Cbud_s2_1564 x2_Vbiasp x2_Vcm 3.9415f
Cbud_s2_1565 x2_Vbiasp x2_Vout 3.9415f
Cbud_s2_1566 x2_Vbiasp x2_Vtest 3.9415f
Cbud_s2_1567 x2_Vbiasp x2_net1 5.01524f
Cbud_s2_1568 x2_Vbiasp x2_x1_net1 0.0898454f
Cbud_s2_1569 x2_Vbiasp x2_x1_net10 0.0898838f
Cbud_s2_1570 x2_Vbiasp x2_x1_net11 0.089862f
Cbud_s2_1571 x2_Vbiasp x2_x1_net12 0.0900699f
Cbud_s2_1572 x2_Vbiasp x2_x1_net13 0.0901803f
Cbud_s2_1573 x2_Vbiasp x2_x1_net14 0.0903746f
Cbud_s2_1574 x2_Vbiasp x2_x1_net15 0.0905998f
Cbud_s2_1575 x2_Vbiasp x2_x1_net16 3.88611f
Cbud_s2_1576 x2_Vbiasp x2_x1_net17 0.275538f
Cbud_s2_1577 x2_Vbiasp x2_x1_net18 0.121591f
Cbud_s2_1578 x2_Vbiasp x2_x1_net19 0.0953071f
Cbud_s2_1579 x2_Vbiasp x2_x1_net2 0.0900011f
Cbud_s2_1580 x2_Vbiasp x2_x1_net3 0.0912626f
Cbud_s2_1581 x2_Vbiasp x2_x1_net4 0.0898072f
Cbud_s2_1582 x2_Vbiasp x2_x1_net5 0.0898137f
Cbud_s2_1583 x2_Vbiasp x2_x1_net6 0.0898225f
Cbud_s2_1584 x2_Vbiasp x2_x1_net7 0.0898326f
Cbud_s2_1585 x2_Vbiasp x2_x1_net8 0.0899504f
Cbud_s2_1586 x2_Vbiasp x2_x1_net9 0.0899122f
Cbud_s2_1587 x2_Vbiasp x2_x2_net1 0.0912531f
Cbud_s2_1588 x2_Vbiasp x2_x2_net10 0.0903718f
Cbud_s2_1589 x2_Vbiasp x2_x2_net11 0.0906089f
Cbud_s2_1590 x2_Vbiasp x2_x2_net12 0.0899499f
Cbud_s2_1591 x2_Vbiasp x2_x2_net13 0.0899125f
Cbud_s2_1592 x2_Vbiasp x2_x2_net14 0.0898837f
Cbud_s2_1593 x2_Vbiasp x2_x2_net15 0.0898618f
Cbud_s2_1594 x2_Vbiasp x2_x2_net16 0.0898073f
Cbud_s2_1595 x2_Vbiasp x2_x2_net17 0.0898139f
Cbud_s2_1596 x2_Vbiasp x2_x2_net18 0.0898224f
Cbud_s2_1597 x2_Vbiasp x2_x2_net19 0.0898328f
Cbud_s2_1598 x2_Vbiasp x2_x2_net2 0.0900003f
Cbud_s2_1599 x2_Vbiasp x2_x2_net3 0.0898455f
Cbud_s2_1600 x2_Vbiasp x2_x2_net4 3.88611f
Cbud_s2_1601 x2_Vbiasp x2_x2_net5 0.304364f
Cbud_s2_1602 x2_Vbiasp x2_x2_net6 0.120758f
Cbud_s2_1603 x2_Vbiasp x2_x2_net7 0.095403f
Cbud_s2_1604 x2_Vbiasp x2_x2_net8 0.0900714f
Cbud_s2_1605 x2_Vbiasp x2_x2_net9 0.0901808f
Cbud_s2_1606 x2_Vbiasp Vm 1.18905f
Cbud_s2_1607 x2_Vbiasp Vp 1.18905f
Cbud_s2_1608 x2_Vcm x2_Vout 6.2001f
Cbud_s2_1609 x2_Vcm x2_Vtest 8.45971f
Cbud_s2_1610 x2_Vcm x2_net1 5.09006f
Cbud_s2_1611 x2_Vcm x2_x1_net1 0.1533f
Cbud_s2_1612 x2_Vcm x2_x1_net10 0.153332f
Cbud_s2_1613 x2_Vcm x2_x1_net11 0.153314f
Cbud_s2_1614 x2_Vcm x2_x1_net12 0.1535f
Cbud_s2_1615 x2_Vcm x2_x1_net13 0.153552f
Cbud_s2_1616 x2_Vcm x2_x1_net14 0.153733f
Cbud_s2_1617 x2_Vcm x2_x1_net15 0.153984f
Cbud_s2_1618 x2_Vcm x2_x1_net16 0.908872f
Cbud_s2_1619 x2_Vcm x2_x1_net17 0.253504f
Cbud_s2_1620 x2_Vcm x2_x1_net18 0.163686f
Cbud_s2_1621 x2_Vcm x2_x1_net19 0.155304f
Cbud_s2_1622 x2_Vcm x2_x1_net2 0.153433f
Cbud_s2_1623 x2_Vcm x2_x1_net3 0.154468f
Cbud_s2_1624 x2_Vcm x2_x1_net4 0.153267f
Cbud_s2_1625 x2_Vcm x2_x1_net5 0.153273f
Cbud_s2_1626 x2_Vcm x2_x1_net6 0.153281f
Cbud_s2_1627 x2_Vcm x2_x1_net7 0.153289f
Cbud_s2_1628 x2_Vcm x2_x1_net8 0.153388f
Cbud_s2_1629 x2_Vcm x2_x1_net9 0.153356f
Cbud_s2_1630 x2_Vcm x2_x2_net1 0.154471f
Cbud_s2_1631 x2_Vcm x2_x2_net10 0.153733f
Cbud_s2_1632 x2_Vcm x2_x2_net11 0.15398f
Cbud_s2_1633 x2_Vcm x2_x2_net12 0.153389f
Cbud_s2_1634 x2_Vcm x2_x2_net13 0.153356f
Cbud_s2_1635 x2_Vcm x2_x2_net14 0.153332f
Cbud_s2_1636 x2_Vcm x2_x2_net15 0.153314f
Cbud_s2_1637 x2_Vcm x2_x2_net16 0.153267f
Cbud_s2_1638 x2_Vcm x2_x2_net17 0.153273f
Cbud_s2_1639 x2_Vcm x2_x2_net18 0.15328f
Cbud_s2_1640 x2_Vcm x2_x2_net19 0.153289f
Cbud_s2_1641 x2_Vcm x2_x2_net2 0.153433f
Cbud_s2_1642 x2_Vcm x2_x2_net3 0.1533f
Cbud_s2_1643 x2_Vcm x2_x2_net4 1.4254f
Cbud_s2_1644 x2_Vcm x2_x2_net5 0.248325f
Cbud_s2_1645 x2_Vcm x2_x2_net6 0.1636f
Cbud_s2_1646 x2_Vcm x2_x2_net7 0.155384f
Cbud_s2_1647 x2_Vcm x2_x2_net8 0.153499f
Cbud_s2_1648 x2_Vcm x2_x2_net9 0.153585f
Cbud_s2_1649 x2_Vcm Vm 1.18874f
Cbud_s2_1650 x2_Vcm Vp 1.18874f
Cbud_s2_1651 x2_Vout x2_Vtest 7.11831f
Cbud_s2_1652 x2_Vout x2_net1 3.29796f
Cbud_s2_1653 x2_Vout x2_x1_net1 0.141434f
Cbud_s2_1654 x2_Vout x2_x1_net10 0.141467f
Cbud_s2_1655 x2_Vout x2_x1_net11 0.141448f
Cbud_s2_1656 x2_Vout x2_x1_net12 0.141634f
Cbud_s2_1657 x2_Vout x2_x1_net13 0.141734f
Cbud_s2_1658 x2_Vout x2_x1_net14 0.141878f
Cbud_s2_1659 x2_Vout x2_x1_net15 0.142129f
Cbud_s2_1660 x2_Vout x2_x1_net16 0.780687f
Cbud_s2_1661 x2_Vout x2_x1_net17 0.251573f
Cbud_s2_1662 x2_Vout x2_x1_net18 0.15461f
Cbud_s2_1663 x2_Vout x2_x1_net19 0.143742f
Cbud_s2_1664 x2_Vout x2_x1_net2 0.141571f
Cbud_s2_1665 x2_Vout x2_x1_net3 0.142606f
Cbud_s2_1666 x2_Vout x2_x1_net4 0.1414f
Cbud_s2_1667 x2_Vout x2_x1_net5 0.141406f
Cbud_s2_1668 x2_Vout x2_x1_net6 0.141414f
Cbud_s2_1669 x2_Vout x2_x1_net7 0.141423f
Cbud_s2_1670 x2_Vout x2_x1_net8 0.141524f
Cbud_s2_1671 x2_Vout x2_x1_net9 0.141491f
Cbud_s2_1672 x2_Vout x2_x2_net1 0.142574f
Cbud_s2_1673 x2_Vout x2_x2_net10 0.14188f
Cbud_s2_1674 x2_Vout x2_x2_net11 0.142135f
Cbud_s2_1675 x2_Vout x2_x2_net12 0.141524f
Cbud_s2_1676 x2_Vout x2_x2_net13 0.141491f
Cbud_s2_1677 x2_Vout x2_x2_net14 0.141467f
Cbud_s2_1678 x2_Vout x2_x2_net15 0.141448f
Cbud_s2_1679 x2_Vout x2_x2_net16 0.1414f
Cbud_s2_1680 x2_Vout x2_x2_net17 0.141406f
Cbud_s2_1681 x2_Vout x2_x2_net18 0.141414f
Cbud_s2_1682 x2_Vout x2_x2_net19 0.141423f
Cbud_s2_1683 x2_Vout x2_x2_net2 0.14157f
Cbud_s2_1684 x2_Vout x2_x2_net3 0.141434f
Cbud_s2_1685 x2_Vout x2_x2_net4 1.80779f
Cbud_s2_1686 x2_Vout x2_x2_net5 0.243394f
Cbud_s2_1687 x2_Vout x2_x2_net6 0.155129f
Cbud_s2_1688 x2_Vout x2_x2_net7 0.143662f
Cbud_s2_1689 x2_Vout x2_x2_net8 0.141635f
Cbud_s2_1690 x2_Vout x2_x2_net9 0.141736f
Cbud_s2_1691 x2_Vout Vm 1.1894f
Cbud_s2_1692 x2_Vout Vp 1.18905f
Cbud_s2_1693 x2_Vtest x2_net1 3.29752f
Cbud_s2_1694 x2_Vtest x2_x1_net1 0.152213f
Cbud_s2_1695 x2_Vtest x2_x1_net10 0.152245f
Cbud_s2_1696 x2_Vtest x2_x1_net11 0.152227f
Cbud_s2_1697 x2_Vtest x2_x1_net12 0.152412f
Cbud_s2_1698 x2_Vtest x2_x1_net13 0.152504f
Cbud_s2_1699 x2_Vtest x2_x1_net14 0.152648f
Cbud_s2_1700 x2_Vtest x2_x1_net15 0.152893f
Cbud_s2_1701 x2_Vtest x2_x1_net16 0.177475f
Cbud_s2_1702 x2_Vtest x2_x1_net17 0.265284f
Cbud_s2_1703 x2_Vtest x2_x1_net18 0.164466f
Cbud_s2_1704 x2_Vtest x2_x1_net19 0.154245f
Cbud_s2_1705 x2_Vtest x2_x1_net2 0.152346f
Cbud_s2_1706 x2_Vtest x2_x1_net3 0.153376f
Cbud_s2_1707 x2_Vtest x2_x1_net4 0.15218f
Cbud_s2_1708 x2_Vtest x2_x1_net5 0.152186f
Cbud_s2_1709 x2_Vtest x2_x1_net6 0.152193f
Cbud_s2_1710 x2_Vtest x2_x1_net7 0.152202f
Cbud_s2_1711 x2_Vtest x2_x1_net8 0.152301f
Cbud_s2_1712 x2_Vtest x2_x1_net9 0.152268f
Cbud_s2_1713 x2_Vtest x2_x2_net1 0.153373f
Cbud_s2_1714 x2_Vtest x2_x2_net10 0.15265f
Cbud_s2_1715 x2_Vtest x2_x2_net11 0.152902f
Cbud_s2_1716 x2_Vtest x2_x2_net12 0.152301f
Cbud_s2_1717 x2_Vtest x2_x2_net13 0.152268f
Cbud_s2_1718 x2_Vtest x2_x2_net14 0.152245f
Cbud_s2_1719 x2_Vtest x2_x2_net15 0.152227f
Cbud_s2_1720 x2_Vtest x2_x2_net16 0.15218f
Cbud_s2_1721 x2_Vtest x2_x2_net17 0.152186f
Cbud_s2_1722 x2_Vtest x2_x2_net18 0.152193f
Cbud_s2_1723 x2_Vtest x2_x2_net19 0.152202f
Cbud_s2_1724 x2_Vtest x2_x2_net2 0.152346f
Cbud_s2_1725 x2_Vtest x2_x2_net3 0.152213f
Cbud_s2_1726 x2_Vtest x2_x2_net4 1.76858f
Cbud_s2_1727 x2_Vtest x2_x2_net5 0.266456f
Cbud_s2_1728 x2_Vtest x2_x2_net6 0.162088f
Cbud_s2_1729 x2_Vtest x2_x2_net7 0.154328f
Cbud_s2_1730 x2_Vtest x2_x2_net8 0.152412f
Cbud_s2_1731 x2_Vtest x2_x2_net9 0.152497f
Cbud_s2_1732 x2_Vtest Vm 1.18905f
Cbud_s2_1733 x2_Vtest Vp 1.18905f
Cbud_s2_1734 x2_net1 x2_x1_net1 0.0752472f
Cbud_s2_1735 x2_net1 x2_x1_net10 0.0752879f
Cbud_s2_1736 x2_net1 x2_x1_net11 0.0752648f
Cbud_s2_1737 x2_net1 x2_x1_net12 0.0754817f
Cbud_s2_1738 x2_net1 x2_x1_net13 0.0756034f
Cbud_s2_1739 x2_net1 x2_x1_net14 0.0757896f
Cbud_s2_1740 x2_net1 x2_x1_net15 0.0760336f
Cbud_s2_1741 x2_net1 x2_x1_net16 3.24866f
Cbud_s2_1742 x2_net1 x2_x1_net17 0.301196f
Cbud_s2_1743 x2_net1 x2_x1_net18 0.11166f
Cbud_s2_1744 x2_net1 x2_x1_net19 0.0827915f
Cbud_s2_1745 x2_net1 x2_x1_net2 0.0754065f
Cbud_s2_1746 x2_net1 x2_x1_net3 0.0771782f
Cbud_s2_1747 x2_net1 x2_x1_net4 0.0752068f
Cbud_s2_1748 x2_net1 x2_x1_net5 0.0752138f
Cbud_s2_1749 x2_net1 x2_x1_net6 0.0752225f
Cbud_s2_1750 x2_net1 x2_x1_net7 0.0752335f
Cbud_s2_1751 x2_net1 x2_x1_net8 0.0753562f
Cbud_s2_1752 x2_net1 x2_x1_net9 0.0753176f
Cbud_s2_1753 x2_net1 x2_x2_net1 0.0771681f
Cbud_s2_1754 x2_net1 x2_x2_net10 0.0757888f
Cbud_s2_1755 x2_net1 x2_x2_net11 0.0760425f
Cbud_s2_1756 x2_net1 x2_x2_net12 0.075355f
Cbud_s2_1757 x2_net1 x2_x2_net13 0.0753173f
Cbud_s2_1758 x2_net1 x2_x2_net14 0.0752876f
Cbud_s2_1759 x2_net1 x2_x2_net15 0.0752648f
Cbud_s2_1760 x2_net1 x2_x2_net16 0.0752068f
Cbud_s2_1761 x2_net1 x2_x2_net17 0.0752138f
Cbud_s2_1762 x2_net1 x2_x2_net18 0.0752225f
Cbud_s2_1763 x2_net1 x2_x2_net19 0.0752334f
Cbud_s2_1764 x2_net1 x2_x2_net2 0.0754063f
Cbud_s2_1765 x2_net1 x2_x2_net3 0.075247f
Cbud_s2_1766 x2_net1 x2_x2_net4 3.27615f
Cbud_s2_1767 x2_net1 x2_x2_net5 0.299834f
Cbud_s2_1768 x2_net1 x2_x2_net6 0.116859f
Cbud_s2_1769 x2_net1 x2_x2_net7 0.0833698f
Cbud_s2_1770 x2_net1 x2_x2_net8 0.075482f
Cbud_s2_1771 x2_net1 x2_x2_net9 0.0756063f
Cbud_s2_1772 x2_net1 Vm 1.18886f
Cbud_s2_1773 x2_net1 Vp 1.18872f
Cbud_s2_1774 x2_x1_net1 x2_x1_net10 0.250628f
Cbud_s2_1775 x2_x1_net1 x2_x1_net11 0.811354f
Cbud_s2_1776 x2_x1_net1 x2_x1_net12 0.153978f
Cbud_s2_1777 x2_x1_net1 x2_x1_net13 0.153734f
Cbud_s2_1778 x2_x1_net1 x2_x1_net14 0.153577f
Cbud_s2_1779 x2_x1_net1 x2_x1_net15 0.1535f
Cbud_s2_1780 x2_x1_net1 x2_x1_net16 0.153314f
Cbud_s2_1781 x2_x1_net1 x2_x1_net17 0.153332f
Cbud_s2_1782 x2_x1_net1 x2_x1_net18 0.153356f
Cbud_s2_1783 x2_x1_net1 x2_x1_net19 0.153388f
Cbud_s2_1784 x2_x1_net1 x2_x1_net2 0.154471f
Cbud_s2_1785 x2_x1_net1 x2_x1_net3 0.153434f
Cbud_s2_1786 x2_x1_net1 x2_x1_net4 0.155645f
Cbud_s2_1787 x2_x1_net1 x2_x1_net5 0.163157f
Cbud_s2_1788 x2_x1_net1 x2_x1_net6 0.250628f
Cbud_s2_1789 x2_x1_net1 x2_x1_net7 0.811354f
Cbud_s2_1790 x2_x1_net1 x2_x1_net8 0.155382f
Cbud_s2_1791 x2_x1_net1 x2_x1_net9 0.163807f
Cbud_s2_1792 x2_x1_net1 x2_x2_net1 0.153262f
Cbud_s2_1793 x2_x1_net1 x2_x2_net10 0.153254f
Cbud_s2_1794 x2_x1_net1 x2_x2_net11 0.153258f
Cbud_s2_1795 x2_x1_net1 x2_x2_net12 0.153243f
Cbud_s2_1796 x2_x1_net1 x2_x2_net13 0.153241f
Cbud_s2_1797 x2_x1_net1 x2_x2_net14 0.15324f
Cbud_s2_1798 x2_x1_net1 x2_x2_net15 0.153238f
Cbud_s2_1799 x2_x1_net1 x2_x2_net16 0.153233f
Cbud_s2_1800 x2_x1_net1 x2_x2_net17 0.153233f
Cbud_s2_1801 x2_x1_net1 x2_x2_net18 0.153234f
Cbud_s2_1802 x2_x1_net1 x2_x2_net19 0.153236f
Cbud_s2_1803 x2_x1_net1 x2_x2_net2 0.153245f
Cbud_s2_1804 x2_x1_net1 x2_x2_net3 0.153237f
Cbud_s2_1805 x2_x1_net1 x2_x2_net4 0.153289f
Cbud_s2_1806 x2_x1_net1 x2_x2_net5 0.15328f
Cbud_s2_1807 x2_x1_net1 x2_x2_net6 0.153273f
Cbud_s2_1808 x2_x1_net1 x2_x2_net7 0.153267f
Cbud_s2_1809 x2_x1_net1 x2_x2_net8 0.153248f
Cbud_s2_1810 x2_x1_net1 x2_x2_net9 0.153251f
Cbud_s2_1811 x2_x1_net1 Vm 0.0271952f
Cbud_s2_1812 x2_x1_net1 Vp 0.0271952f
Cbud_s2_1813 x2_x1_net10 x2_x1_net11 0.811354f
Cbud_s2_1814 x2_x1_net10 x2_x1_net12 0.155396f
Cbud_s2_1815 x2_x1_net10 x2_x1_net13 0.154478f
Cbud_s2_1816 x2_x1_net10 x2_x1_net14 0.153985f
Cbud_s2_1817 x2_x1_net10 x2_x1_net15 0.153735f
Cbud_s2_1818 x2_x1_net10 x2_x1_net16 0.153356f
Cbud_s2_1819 x2_x1_net10 x2_x1_net17 0.153388f
Cbud_s2_1820 x2_x1_net10 x2_x1_net18 0.153434f
Cbud_s2_1821 x2_x1_net10 x2_x1_net19 0.1535f
Cbud_s2_1822 x2_x1_net10 x2_x1_net2 0.163744f
Cbud_s2_1823 x2_x1_net10 x2_x1_net3 0.153582f
Cbud_s2_1824 x2_x1_net10 x2_x1_net4 0.154002f
Cbud_s2_1825 x2_x1_net10 x2_x1_net5 0.154463f
Cbud_s2_1826 x2_x1_net10 x2_x1_net6 0.155388f
Cbud_s2_1827 x2_x1_net10 x2_x1_net7 0.163807f
Cbud_s2_1828 x2_x1_net10 x2_x1_net8 0.254491f
Cbud_s2_1829 x2_x1_net10 x2_x1_net9 0.811354f
Cbud_s2_1830 x2_x1_net10 x2_x2_net1 0.153273f
Cbud_s2_1831 x2_x1_net10 x2_x2_net10 0.153262f
Cbud_s2_1832 x2_x1_net10 x2_x2_net11 0.153267f
Cbud_s2_1833 x2_x1_net10 x2_x2_net12 0.153248f
Cbud_s2_1834 x2_x1_net10 x2_x2_net13 0.153245f
Cbud_s2_1835 x2_x1_net10 x2_x2_net14 0.153243f
Cbud_s2_1836 x2_x1_net10 x2_x2_net15 0.153241f
Cbud_s2_1837 x2_x1_net10 x2_x2_net16 0.153234f
Cbud_s2_1838 x2_x1_net10 x2_x2_net17 0.153236f
Cbud_s2_1839 x2_x1_net10 x2_x2_net18 0.153237f
Cbud_s2_1840 x2_x1_net10 x2_x2_net19 0.153238f
Cbud_s2_1841 x2_x1_net10 x2_x2_net2 0.153251f
Cbud_s2_1842 x2_x1_net10 x2_x2_net3 0.15324f
Cbud_s2_1843 x2_x1_net10 x2_x2_net4 0.153314f
Cbud_s2_1844 x2_x1_net10 x2_x2_net5 0.1533f
Cbud_s2_1845 x2_x1_net10 x2_x2_net6 0.153289f
Cbud_s2_1846 x2_x1_net10 x2_x2_net7 0.153281f
Cbud_s2_1847 x2_x1_net10 x2_x2_net8 0.153254f
Cbud_s2_1848 x2_x1_net10 x2_x2_net9 0.153258f
Cbud_s2_1849 x2_x1_net10 Vm 0.027253f
Cbud_s2_1850 x2_x1_net10 Vp 0.0272529f
Cbud_s2_1851 x2_x1_net11 x2_x1_net12 0.154463f
Cbud_s2_1852 x2_x1_net11 x2_x1_net13 0.153979f
Cbud_s2_1853 x2_x1_net11 x2_x1_net14 0.153734f
Cbud_s2_1854 x2_x1_net11 x2_x1_net15 0.15358f
Cbud_s2_1855 x2_x1_net11 x2_x1_net16 0.153332f
Cbud_s2_1856 x2_x1_net11 x2_x1_net17 0.153356f
Cbud_s2_1857 x2_x1_net11 x2_x1_net18 0.153388f
Cbud_s2_1858 x2_x1_net11 x2_x1_net19 0.153434f
Cbud_s2_1859 x2_x1_net11 x2_x1_net2 0.155251f
Cbud_s2_1860 x2_x1_net11 x2_x1_net3 0.153499f
Cbud_s2_1861 x2_x1_net11 x2_x1_net4 0.154508f
Cbud_s2_1862 x2_x1_net11 x2_x1_net5 0.155413f
Cbud_s2_1863 x2_x1_net11 x2_x1_net6 0.163515f
Cbud_s2_1864 x2_x1_net11 x2_x1_net7 0.250628f
Cbud_s2_1865 x2_x1_net11 x2_x1_net8 0.163955f
Cbud_s2_1866 x2_x1_net11 x2_x1_net9 0.250628f
Cbud_s2_1867 x2_x1_net11 x2_x2_net1 0.153267f
Cbud_s2_1868 x2_x1_net11 x2_x2_net10 0.153258f
Cbud_s2_1869 x2_x1_net11 x2_x2_net11 0.153262f
Cbud_s2_1870 x2_x1_net11 x2_x2_net12 0.153245f
Cbud_s2_1871 x2_x1_net11 x2_x2_net13 0.153243f
Cbud_s2_1872 x2_x1_net11 x2_x2_net14 0.153241f
Cbud_s2_1873 x2_x1_net11 x2_x2_net15 0.15324f
Cbud_s2_1874 x2_x1_net11 x2_x2_net16 0.153233f
Cbud_s2_1875 x2_x1_net11 x2_x2_net17 0.153234f
Cbud_s2_1876 x2_x1_net11 x2_x2_net18 0.153236f
Cbud_s2_1877 x2_x1_net11 x2_x2_net19 0.153237f
Cbud_s2_1878 x2_x1_net11 x2_x2_net2 0.153248f
Cbud_s2_1879 x2_x1_net11 x2_x2_net3 0.153238f
Cbud_s2_1880 x2_x1_net11 x2_x2_net4 0.1533f
Cbud_s2_1881 x2_x1_net11 x2_x2_net5 0.153289f
Cbud_s2_1882 x2_x1_net11 x2_x2_net6 0.153281f
Cbud_s2_1883 x2_x1_net11 x2_x2_net7 0.153273f
Cbud_s2_1884 x2_x1_net11 x2_x2_net8 0.153251f
Cbud_s2_1885 x2_x1_net11 x2_x2_net9 0.153254f
Cbud_s2_1886 x2_x1_net11 Vm 0.0272185f
Cbud_s2_1887 x2_x1_net11 Vp 0.0272184f
Cbud_s2_1888 x2_x1_net12 x2_x1_net13 0.908872f
Cbud_s2_1889 x2_x1_net12 x2_x1_net14 0.253504f
Cbud_s2_1890 x2_x1_net12 x2_x1_net15 0.163686f
Cbud_s2_1891 x2_x1_net12 x2_x1_net16 0.153579f
Cbud_s2_1892 x2_x1_net12 x2_x1_net17 0.153733f
Cbud_s2_1893 x2_x1_net12 x2_x1_net18 0.153984f
Cbud_s2_1894 x2_x1_net12 x2_x1_net19 0.154468f
Cbud_s2_1895 x2_x1_net12 x2_x1_net2 0.908872f
Cbud_s2_1896 x2_x1_net12 x2_x1_net3 0.155304f
Cbud_s2_1897 x2_x1_net12 x2_x1_net4 0.153436f
Cbud_s2_1898 x2_x1_net12 x2_x1_net5 0.153499f
Cbud_s2_1899 x2_x1_net12 x2_x1_net6 0.153565f
Cbud_s2_1900 x2_x1_net12 x2_x1_net7 0.153735f
Cbud_s2_1901 x2_x1_net12 x2_x1_net8 0.253504f
Cbud_s2_1902 x2_x1_net12 x2_x1_net9 0.163572f
Cbud_s2_1903 x2_x1_net12 x2_x2_net1 0.153314f
Cbud_s2_1904 x2_x1_net12 x2_x2_net10 0.153289f
Cbud_s2_1905 x2_x1_net12 x2_x2_net11 0.1533f
Cbud_s2_1906 x2_x1_net12 x2_x2_net12 0.153262f
Cbud_s2_1907 x2_x1_net12 x2_x2_net13 0.153258f
Cbud_s2_1908 x2_x1_net12 x2_x2_net14 0.153254f
Cbud_s2_1909 x2_x1_net12 x2_x2_net15 0.153251f
Cbud_s2_1910 x2_x1_net12 x2_x2_net16 0.15324f
Cbud_s2_1911 x2_x1_net12 x2_x2_net17 0.153241f
Cbud_s2_1912 x2_x1_net12 x2_x2_net18 0.153243f
Cbud_s2_1913 x2_x1_net12 x2_x2_net19 0.153245f
Cbud_s2_1914 x2_x1_net12 x2_x2_net2 0.153267f
Cbud_s2_1915 x2_x1_net12 x2_x2_net3 0.153248f
Cbud_s2_1916 x2_x1_net12 x2_x2_net4 0.153433f
Cbud_s2_1917 x2_x1_net12 x2_x2_net5 0.153388f
Cbud_s2_1918 x2_x1_net12 x2_x2_net6 0.153356f
Cbud_s2_1919 x2_x1_net12 x2_x2_net7 0.153332f
Cbud_s2_1920 x2_x1_net12 x2_x2_net8 0.153273f
Cbud_s2_1921 x2_x1_net12 x2_x2_net9 0.15328f
Cbud_s2_1922 x2_x1_net12 Vm 0.0275578f
Cbud_s2_1923 x2_x1_net12 Vp 0.0275505f
Cbud_s2_1924 x2_x1_net13 x2_x1_net14 0.908872f
Cbud_s2_1925 x2_x1_net13 x2_x1_net15 0.253504f
Cbud_s2_1926 x2_x1_net13 x2_x1_net16 0.153735f
Cbud_s2_1927 x2_x1_net13 x2_x1_net17 0.153984f
Cbud_s2_1928 x2_x1_net13 x2_x1_net18 0.154468f
Cbud_s2_1929 x2_x1_net13 x2_x1_net19 0.155304f
Cbud_s2_1930 x2_x1_net13 x2_x1_net2 0.253504f
Cbud_s2_1931 x2_x1_net13 x2_x1_net3 0.163686f
Cbud_s2_1932 x2_x1_net13 x2_x1_net4 0.15339f
Cbud_s2_1933 x2_x1_net13 x2_x1_net5 0.153433f
Cbud_s2_1934 x2_x1_net13 x2_x1_net6 0.1535f
Cbud_s2_1935 x2_x1_net13 x2_x1_net7 0.153563f
Cbud_s2_1936 x2_x1_net13 x2_x1_net8 0.163686f
Cbud_s2_1937 x2_x1_net13 x2_x1_net9 0.155407f
Cbud_s2_1938 x2_x1_net13 x2_x2_net1 0.153332f
Cbud_s2_1939 x2_x1_net13 x2_x2_net10 0.1533f
Cbud_s2_1940 x2_x1_net13 x2_x2_net11 0.153314f
Cbud_s2_1941 x2_x1_net13 x2_x2_net12 0.153267f
Cbud_s2_1942 x2_x1_net13 x2_x2_net13 0.153262f
Cbud_s2_1943 x2_x1_net13 x2_x2_net14 0.153258f
Cbud_s2_1944 x2_x1_net13 x2_x2_net15 0.153254f
Cbud_s2_1945 x2_x1_net13 x2_x2_net16 0.153241f
Cbud_s2_1946 x2_x1_net13 x2_x2_net17 0.153243f
Cbud_s2_1947 x2_x1_net13 x2_x2_net18 0.153245f
Cbud_s2_1948 x2_x1_net13 x2_x2_net19 0.153248f
Cbud_s2_1949 x2_x1_net13 x2_x2_net2 0.153273f
Cbud_s2_1950 x2_x1_net13 x2_x2_net3 0.153251f
Cbud_s2_1951 x2_x1_net13 x2_x2_net4 0.1535f
Cbud_s2_1952 x2_x1_net13 x2_x2_net5 0.153433f
Cbud_s2_1953 x2_x1_net13 x2_x2_net6 0.153388f
Cbud_s2_1954 x2_x1_net13 x2_x2_net7 0.153356f
Cbud_s2_1955 x2_x1_net13 x2_x2_net8 0.153281f
Cbud_s2_1956 x2_x1_net13 x2_x2_net9 0.153289f
Cbud_s2_1957 x2_x1_net13 Vm 0.0280159f
Cbud_s2_1958 x2_x1_net13 Vp 0.0280246f
Cbud_s2_1959 x2_x1_net14 x2_x1_net15 0.908872f
Cbud_s2_1960 x2_x1_net14 x2_x1_net16 0.153981f
Cbud_s2_1961 x2_x1_net14 x2_x1_net17 0.154468f
Cbud_s2_1962 x2_x1_net14 x2_x1_net18 0.155304f
Cbud_s2_1963 x2_x1_net14 x2_x1_net19 0.163686f
Cbud_s2_1964 x2_x1_net14 x2_x1_net2 0.163686f
Cbud_s2_1965 x2_x1_net14 x2_x1_net3 0.253504f
Cbud_s2_1966 x2_x1_net14 x2_x1_net4 0.153357f
Cbud_s2_1967 x2_x1_net14 x2_x1_net5 0.153388f
Cbud_s2_1968 x2_x1_net14 x2_x1_net6 0.153434f
Cbud_s2_1969 x2_x1_net14 x2_x1_net7 0.153501f
Cbud_s2_1970 x2_x1_net14 x2_x1_net8 0.155304f
Cbud_s2_1971 x2_x1_net14 x2_x1_net9 0.154469f
Cbud_s2_1972 x2_x1_net14 x2_x2_net1 0.153356f
Cbud_s2_1973 x2_x1_net14 x2_x2_net10 0.153314f
Cbud_s2_1974 x2_x1_net14 x2_x2_net11 0.153332f
Cbud_s2_1975 x2_x1_net14 x2_x2_net12 0.153273f
Cbud_s2_1976 x2_x1_net14 x2_x2_net13 0.153267f
Cbud_s2_1977 x2_x1_net14 x2_x2_net14 0.153262f
Cbud_s2_1978 x2_x1_net14 x2_x2_net15 0.153258f
Cbud_s2_1979 x2_x1_net14 x2_x2_net16 0.153243f
Cbud_s2_1980 x2_x1_net14 x2_x2_net17 0.153245f
Cbud_s2_1981 x2_x1_net14 x2_x2_net18 0.153248f
Cbud_s2_1982 x2_x1_net14 x2_x2_net19 0.153251f
Cbud_s2_1983 x2_x1_net14 x2_x2_net2 0.15328f
Cbud_s2_1984 x2_x1_net14 x2_x2_net3 0.153254f
Cbud_s2_1985 x2_x1_net14 x2_x2_net4 0.153564f
Cbud_s2_1986 x2_x1_net14 x2_x2_net5 0.153498f
Cbud_s2_1987 x2_x1_net14 x2_x2_net6 0.153434f
Cbud_s2_1988 x2_x1_net14 x2_x2_net7 0.153388f
Cbud_s2_1989 x2_x1_net14 x2_x2_net8 0.153289f
Cbud_s2_1990 x2_x1_net14 x2_x2_net9 0.1533f
Cbud_s2_1991 x2_x1_net14 Vm 0.0292958f
Cbud_s2_1992 x2_x1_net14 Vp 0.0293003f
Cbud_s2_1993 x2_x1_net15 x2_x1_net16 0.154468f
Cbud_s2_1994 x2_x1_net15 x2_x1_net17 0.155304f
Cbud_s2_1995 x2_x1_net15 x2_x1_net18 0.163686f
Cbud_s2_1996 x2_x1_net15 x2_x1_net19 0.253504f
Cbud_s2_1997 x2_x1_net15 x2_x1_net2 0.155304f
Cbud_s2_1998 x2_x1_net15 x2_x1_net3 0.908872f
Cbud_s2_1999 x2_x1_net15 x2_x1_net4 0.153333f
Cbud_s2_2000 x2_x1_net15 x2_x1_net5 0.153356f
Cbud_s2_2001 x2_x1_net15 x2_x1_net6 0.153388f
Cbud_s2_2002 x2_x1_net15 x2_x1_net7 0.153434f
Cbud_s2_2003 x2_x1_net15 x2_x1_net8 0.154468f
Cbud_s2_2004 x2_x1_net15 x2_x1_net9 0.153988f
Cbud_s2_2005 x2_x1_net15 x2_x2_net1 0.153388f
Cbud_s2_2006 x2_x1_net15 x2_x2_net10 0.153332f
Cbud_s2_2007 x2_x1_net15 x2_x2_net11 0.153356f
Cbud_s2_2008 x2_x1_net15 x2_x2_net12 0.15328f
Cbud_s2_2009 x2_x1_net15 x2_x2_net13 0.153273f
Cbud_s2_2010 x2_x1_net15 x2_x2_net14 0.153267f
Cbud_s2_2011 x2_x1_net15 x2_x2_net15 0.153262f
Cbud_s2_2012 x2_x1_net15 x2_x2_net16 0.153245f
Cbud_s2_2013 x2_x1_net15 x2_x2_net17 0.153248f
Cbud_s2_2014 x2_x1_net15 x2_x2_net18 0.153251f
Cbud_s2_2015 x2_x1_net15 x2_x2_net19 0.153254f
Cbud_s2_2016 x2_x1_net15 x2_x2_net2 0.153289f
Cbud_s2_2017 x2_x1_net15 x2_x2_net3 0.153258f
Cbud_s2_2018 x2_x1_net15 x2_x2_net4 0.153734f
Cbud_s2_2019 x2_x1_net15 x2_x2_net5 0.153581f
Cbud_s2_2020 x2_x1_net15 x2_x2_net6 0.153499f
Cbud_s2_2021 x2_x1_net15 x2_x2_net7 0.153434f
Cbud_s2_2022 x2_x1_net15 x2_x2_net8 0.153301f
Cbud_s2_2023 x2_x1_net15 x2_x2_net9 0.153314f
Cbud_s2_2024 x2_x1_net15 Vm 0.0326999f
Cbud_s2_2025 x2_x1_net15 Vp 0.0327261f
Cbud_s2_2026 x2_x1_net16 x2_x1_net17 0.908872f
Cbud_s2_2027 x2_x1_net16 x2_x1_net18 0.253504f
Cbud_s2_2028 x2_x1_net16 x2_x1_net19 0.163686f
Cbud_s2_2029 x2_x1_net16 x2_x1_net2 0.1535f
Cbud_s2_2030 x2_x1_net16 x2_x1_net3 0.155312f
Cbud_s2_2031 x2_x1_net16 x2_x1_net4 0.153273f
Cbud_s2_2032 x2_x1_net16 x2_x1_net5 0.153281f
Cbud_s2_2033 x2_x1_net16 x2_x1_net6 0.153289f
Cbud_s2_2034 x2_x1_net16 x2_x1_net7 0.1533f
Cbud_s2_2035 x2_x1_net16 x2_x1_net8 0.153433f
Cbud_s2_2036 x2_x1_net16 x2_x1_net9 0.153388f
Cbud_s2_2037 x2_x1_net16 x2_x2_net1 0.153981f
Cbud_s2_2038 x2_x1_net16 x2_x2_net10 0.153586f
Cbud_s2_2039 x2_x1_net16 x2_x2_net11 0.153734f
Cbud_s2_2040 x2_x1_net16 x2_x2_net12 0.153356f
Cbud_s2_2041 x2_x1_net16 x2_x2_net13 0.153332f
Cbud_s2_2042 x2_x1_net16 x2_x2_net14 0.153314f
Cbud_s2_2043 x2_x1_net16 x2_x2_net15 0.1533f
Cbud_s2_2044 x2_x1_net16 x2_x2_net16 0.153262f
Cbud_s2_2045 x2_x1_net16 x2_x2_net17 0.153267f
Cbud_s2_2046 x2_x1_net16 x2_x2_net18 0.153273f
Cbud_s2_2047 x2_x1_net16 x2_x2_net19 0.153281f
Cbud_s2_2048 x2_x1_net16 x2_x2_net2 0.153388f
Cbud_s2_2049 x2_x1_net16 x2_x2_net3 0.153289f
Cbud_s2_2050 x2_x1_net16 x2_x2_net4 0.251573f
Cbud_s2_2051 x2_x1_net16 x2_x2_net5 0.164732f
Cbud_s2_2052 x2_x1_net16 x2_x2_net6 0.155351f
Cbud_s2_2053 x2_x1_net16 x2_x2_net7 0.154472f
Cbud_s2_2054 x2_x1_net16 x2_x2_net8 0.153434f
Cbud_s2_2055 x2_x1_net16 x2_x2_net9 0.153499f
Cbud_s2_2056 x2_x1_net16 Vm 1.18701f
Cbud_s2_2057 x2_x1_net16 Vp 1.18704f
Cbud_s2_2058 x2_x1_net17 x2_x1_net18 0.908872f
Cbud_s2_2059 x2_x1_net17 x2_x1_net19 0.253504f
Cbud_s2_2060 x2_x1_net17 x2_x1_net2 0.153552f
Cbud_s2_2061 x2_x1_net17 x2_x1_net3 0.163686f
Cbud_s2_2062 x2_x1_net17 x2_x1_net4 0.153281f
Cbud_s2_2063 x2_x1_net17 x2_x1_net5 0.153289f
Cbud_s2_2064 x2_x1_net17 x2_x1_net6 0.1533f
Cbud_s2_2065 x2_x1_net17 x2_x1_net7 0.153314f
Cbud_s2_2066 x2_x1_net17 x2_x1_net8 0.1535f
Cbud_s2_2067 x2_x1_net17 x2_x1_net9 0.153433f
Cbud_s2_2068 x2_x1_net17 x2_x2_net1 0.153738f
Cbud_s2_2069 x2_x1_net17 x2_x2_net10 0.153499f
Cbud_s2_2070 x2_x1_net17 x2_x2_net11 0.15358f
Cbud_s2_2071 x2_x1_net17 x2_x2_net12 0.153332f
Cbud_s2_2072 x2_x1_net17 x2_x2_net13 0.153314f
Cbud_s2_2073 x2_x1_net17 x2_x2_net14 0.1533f
Cbud_s2_2074 x2_x1_net17 x2_x2_net15 0.153289f
Cbud_s2_2075 x2_x1_net17 x2_x2_net16 0.153258f
Cbud_s2_2076 x2_x1_net17 x2_x2_net17 0.153262f
Cbud_s2_2077 x2_x1_net17 x2_x2_net18 0.153267f
Cbud_s2_2078 x2_x1_net17 x2_x2_net19 0.153273f
Cbud_s2_2079 x2_x1_net17 x2_x2_net2 0.153356f
Cbud_s2_2080 x2_x1_net17 x2_x2_net3 0.15328f
Cbud_s2_2081 x2_x1_net17 x2_x2_net4 0.1653f
Cbud_s2_2082 x2_x1_net17 x2_x2_net5 0.155392f
Cbud_s2_2083 x2_x1_net17 x2_x2_net6 0.154461f
Cbud_s2_2084 x2_x1_net17 x2_x2_net7 0.153975f
Cbud_s2_2085 x2_x1_net17 x2_x2_net8 0.153388f
Cbud_s2_2086 x2_x1_net17 x2_x2_net9 0.153433f
Cbud_s2_2087 x2_x1_net17 Vm 0.355837f
Cbud_s2_2088 x2_x1_net17 Vp 0.75225f
Cbud_s2_2089 x2_x1_net18 x2_x1_net19 0.908872f
Cbud_s2_2090 x2_x1_net18 x2_x1_net2 0.153733f
Cbud_s2_2091 x2_x1_net18 x2_x1_net3 0.253504f
Cbud_s2_2092 x2_x1_net18 x2_x1_net4 0.15329f
Cbud_s2_2093 x2_x1_net18 x2_x1_net5 0.1533f
Cbud_s2_2094 x2_x1_net18 x2_x1_net6 0.153314f
Cbud_s2_2095 x2_x1_net18 x2_x1_net7 0.153332f
Cbud_s2_2096 x2_x1_net18 x2_x1_net8 0.153552f
Cbud_s2_2097 x2_x1_net18 x2_x1_net9 0.1535f
Cbud_s2_2098 x2_x1_net18 x2_x2_net1 0.153582f
Cbud_s2_2099 x2_x1_net18 x2_x2_net10 0.153433f
Cbud_s2_2100 x2_x1_net18 x2_x2_net11 0.153499f
Cbud_s2_2101 x2_x1_net18 x2_x2_net12 0.153314f
Cbud_s2_2102 x2_x1_net18 x2_x2_net13 0.1533f
Cbud_s2_2103 x2_x1_net18 x2_x2_net14 0.153289f
Cbud_s2_2104 x2_x1_net18 x2_x2_net15 0.15328f
Cbud_s2_2105 x2_x1_net18 x2_x2_net16 0.153254f
Cbud_s2_2106 x2_x1_net18 x2_x2_net17 0.153258f
Cbud_s2_2107 x2_x1_net18 x2_x2_net18 0.153262f
Cbud_s2_2108 x2_x1_net18 x2_x2_net19 0.153267f
Cbud_s2_2109 x2_x1_net18 x2_x2_net2 0.153332f
Cbud_s2_2110 x2_x1_net18 x2_x2_net3 0.153273f
Cbud_s2_2111 x2_x1_net18 x2_x2_net4 0.155396f
Cbud_s2_2112 x2_x1_net18 x2_x2_net5 0.154474f
Cbud_s2_2113 x2_x1_net18 x2_x2_net6 0.15398f
Cbud_s2_2114 x2_x1_net18 x2_x2_net7 0.153734f
Cbud_s2_2115 x2_x1_net18 x2_x2_net8 0.153356f
Cbud_s2_2116 x2_x1_net18 x2_x2_net9 0.153388f
Cbud_s2_2117 x2_x1_net18 Vm 0.133951f
Cbud_s2_2118 x2_x1_net18 Vp 0.134601f
Cbud_s2_2119 x2_x1_net19 x2_x1_net2 0.153984f
Cbud_s2_2120 x2_x1_net19 x2_x1_net3 0.908872f
Cbud_s2_2121 x2_x1_net19 x2_x1_net4 0.153301f
Cbud_s2_2122 x2_x1_net19 x2_x1_net5 0.153314f
Cbud_s2_2123 x2_x1_net19 x2_x1_net6 0.153332f
Cbud_s2_2124 x2_x1_net19 x2_x1_net7 0.153356f
Cbud_s2_2125 x2_x1_net19 x2_x1_net8 0.153733f
Cbud_s2_2126 x2_x1_net19 x2_x1_net9 0.153574f
Cbud_s2_2127 x2_x1_net19 x2_x2_net1 0.153499f
Cbud_s2_2128 x2_x1_net19 x2_x2_net10 0.153388f
Cbud_s2_2129 x2_x1_net19 x2_x2_net11 0.153433f
Cbud_s2_2130 x2_x1_net19 x2_x2_net12 0.153301f
Cbud_s2_2131 x2_x1_net19 x2_x2_net13 0.153289f
Cbud_s2_2132 x2_x1_net19 x2_x2_net14 0.153281f
Cbud_s2_2133 x2_x1_net19 x2_x2_net15 0.153273f
Cbud_s2_2134 x2_x1_net19 x2_x2_net16 0.153251f
Cbud_s2_2135 x2_x1_net19 x2_x2_net17 0.153254f
Cbud_s2_2136 x2_x1_net19 x2_x2_net18 0.153258f
Cbud_s2_2137 x2_x1_net19 x2_x2_net19 0.153262f
Cbud_s2_2138 x2_x1_net19 x2_x2_net2 0.153314f
Cbud_s2_2139 x2_x1_net19 x2_x2_net3 0.153267f
Cbud_s2_2140 x2_x1_net19 x2_x2_net4 0.154468f
Cbud_s2_2141 x2_x1_net19 x2_x2_net5 0.153985f
Cbud_s2_2142 x2_x1_net19 x2_x2_net6 0.153735f
Cbud_s2_2143 x2_x1_net19 x2_x2_net7 0.153592f
Cbud_s2_2144 x2_x1_net19 x2_x2_net8 0.153332f
Cbud_s2_2145 x2_x1_net19 x2_x2_net9 0.153356f
Cbud_s2_2146 x2_x1_net19 Vm 0.06866f
Cbud_s2_2147 x2_x1_net19 Vp 0.0688925f
Cbud_s2_2148 x2_x1_net2 x2_x1_net3 0.154468f
Cbud_s2_2149 x2_x1_net2 x2_x1_net4 0.153504f
Cbud_s2_2150 x2_x1_net2 x2_x1_net5 0.153567f
Cbud_s2_2151 x2_x1_net2 x2_x1_net6 0.153733f
Cbud_s2_2152 x2_x1_net2 x2_x1_net7 0.153981f
Cbud_s2_2153 x2_x1_net2 x2_x1_net8 0.908872f
Cbud_s2_2154 x2_x1_net2 x2_x1_net9 0.246541f
Cbud_s2_2155 x2_x1_net2 x2_x2_net1 0.1533f
Cbud_s2_2156 x2_x1_net2 x2_x2_net10 0.153281f
Cbud_s2_2157 x2_x1_net2 x2_x2_net11 0.153289f
Cbud_s2_2158 x2_x1_net2 x2_x2_net12 0.153258f
Cbud_s2_2159 x2_x1_net2 x2_x2_net13 0.153254f
Cbud_s2_2160 x2_x1_net2 x2_x2_net14 0.153251f
Cbud_s2_2161 x2_x1_net2 x2_x2_net15 0.153248f
Cbud_s2_2162 x2_x1_net2 x2_x2_net16 0.153238f
Cbud_s2_2163 x2_x1_net2 x2_x2_net17 0.15324f
Cbud_s2_2164 x2_x1_net2 x2_x2_net18 0.153241f
Cbud_s2_2165 x2_x1_net2 x2_x2_net19 0.153243f
Cbud_s2_2166 x2_x1_net2 x2_x2_net2 0.153262f
Cbud_s2_2167 x2_x1_net2 x2_x2_net3 0.153245f
Cbud_s2_2168 x2_x1_net2 x2_x2_net4 0.153388f
Cbud_s2_2169 x2_x1_net2 x2_x2_net5 0.153356f
Cbud_s2_2170 x2_x1_net2 x2_x2_net6 0.153332f
Cbud_s2_2171 x2_x1_net2 x2_x2_net7 0.153314f
Cbud_s2_2172 x2_x1_net2 x2_x2_net8 0.153267f
Cbud_s2_2173 x2_x1_net2 x2_x2_net9 0.153273f
Cbud_s2_2174 x2_x1_net2 Vm 0.0273974f
Cbud_s2_2175 x2_x1_net2 Vp 0.0273949f
Cbud_s2_2176 x2_x1_net3 x2_x1_net4 0.153315f
Cbud_s2_2177 x2_x1_net3 x2_x1_net5 0.153332f
Cbud_s2_2178 x2_x1_net3 x2_x1_net6 0.153356f
Cbud_s2_2179 x2_x1_net3 x2_x1_net7 0.153388f
Cbud_s2_2180 x2_x1_net3 x2_x1_net8 0.153984f
Cbud_s2_2181 x2_x1_net3 x2_x1_net9 0.153734f
Cbud_s2_2182 x2_x1_net3 x2_x2_net1 0.153433f
Cbud_s2_2183 x2_x1_net3 x2_x2_net10 0.153356f
Cbud_s2_2184 x2_x1_net3 x2_x2_net11 0.153388f
Cbud_s2_2185 x2_x1_net3 x2_x2_net12 0.153289f
Cbud_s2_2186 x2_x1_net3 x2_x2_net13 0.15328f
Cbud_s2_2187 x2_x1_net3 x2_x2_net14 0.153273f
Cbud_s2_2188 x2_x1_net3 x2_x2_net15 0.153267f
Cbud_s2_2189 x2_x1_net3 x2_x2_net16 0.153248f
Cbud_s2_2190 x2_x1_net3 x2_x2_net17 0.153251f
Cbud_s2_2191 x2_x1_net3 x2_x2_net18 0.153254f
Cbud_s2_2192 x2_x1_net3 x2_x2_net19 0.153258f
Cbud_s2_2193 x2_x1_net3 x2_x2_net2 0.1533f
Cbud_s2_2194 x2_x1_net3 x2_x2_net3 0.153262f
Cbud_s2_2195 x2_x1_net3 x2_x2_net4 0.153976f
Cbud_s2_2196 x2_x1_net3 x2_x2_net5 0.153737f
Cbud_s2_2197 x2_x1_net3 x2_x2_net6 0.15358f
Cbud_s2_2198 x2_x1_net3 x2_x2_net7 0.153499f
Cbud_s2_2199 x2_x1_net3 x2_x2_net8 0.153314f
Cbud_s2_2200 x2_x1_net3 x2_x2_net9 0.153332f
Cbud_s2_2201 x2_x1_net3 Vm 0.0414198f
Cbud_s2_2202 x2_x1_net3 Vp 0.0414842f
Cbud_s2_2203 x2_x1_net4 x2_x1_net5 0.30724f
Cbud_s2_2204 x2_x1_net4 x2_x1_net6 0.349211f
Cbud_s2_2205 x2_x1_net4 x2_x1_net7 0.166859f
Cbud_s2_2206 x2_x1_net4 x2_x1_net8 0.153596f
Cbud_s2_2207 x2_x1_net4 x2_x1_net9 0.153749f
Cbud_s2_2208 x2_x1_net4 x2_x2_net1 0.153248f
Cbud_s2_2209 x2_x1_net4 x2_x2_net10 0.153243f
Cbud_s2_2210 x2_x1_net4 x2_x2_net11 0.153246f
Cbud_s2_2211 x2_x1_net4 x2_x2_net12 0.153237f
Cbud_s2_2212 x2_x1_net4 x2_x2_net13 0.153236f
Cbud_s2_2213 x2_x1_net4 x2_x2_net14 0.153234f
Cbud_s2_2214 x2_x1_net4 x2_x2_net15 0.153233f
Cbud_s2_2215 x2_x1_net4 x2_x2_net16 0.15323f
Cbud_s2_2216 x2_x1_net4 x2_x2_net17 0.15323f
Cbud_s2_2217 x2_x1_net4 x2_x2_net18 0.153231f
Cbud_s2_2218 x2_x1_net4 x2_x2_net19 0.153232f
Cbud_s2_2219 x2_x1_net4 x2_x2_net2 0.153238f
Cbud_s2_2220 x2_x1_net4 x2_x2_net3 0.153233f
Cbud_s2_2221 x2_x1_net4 x2_x2_net4 0.153262f
Cbud_s2_2222 x2_x1_net4 x2_x2_net5 0.153258f
Cbud_s2_2223 x2_x1_net4 x2_x2_net6 0.153254f
Cbud_s2_2224 x2_x1_net4 x2_x2_net7 0.153251f
Cbud_s2_2225 x2_x1_net4 x2_x2_net8 0.15324f
Cbud_s2_2226 x2_x1_net4 x2_x2_net9 0.153241f
Cbud_s2_2227 x2_x1_net4 Vm 0.0271389f
Cbud_s2_2228 x2_x1_net4 Vp 0.0271431f
Cbud_s2_2229 x2_x1_net5 x2_x1_net6 0.930604f
Cbud_s2_2230 x2_x1_net5 x2_x1_net7 0.24108f
Cbud_s2_2231 x2_x1_net5 x2_x1_net8 0.153733f
Cbud_s2_2232 x2_x1_net5 x2_x1_net9 0.153971f
Cbud_s2_2233 x2_x1_net5 x2_x2_net1 0.153251f
Cbud_s2_2234 x2_x1_net5 x2_x2_net10 0.153245f
Cbud_s2_2235 x2_x1_net5 x2_x2_net11 0.153248f
Cbud_s2_2236 x2_x1_net5 x2_x2_net12 0.153238f
Cbud_s2_2237 x2_x1_net5 x2_x2_net13 0.153237f
Cbud_s2_2238 x2_x1_net5 x2_x2_net14 0.153236f
Cbud_s2_2239 x2_x1_net5 x2_x2_net15 0.153234f
Cbud_s2_2240 x2_x1_net5 x2_x2_net16 0.15323f
Cbud_s2_2241 x2_x1_net5 x2_x2_net17 0.153231f
Cbud_s2_2242 x2_x1_net5 x2_x2_net18 0.153232f
Cbud_s2_2243 x2_x1_net5 x2_x2_net19 0.153233f
Cbud_s2_2244 x2_x1_net5 x2_x2_net2 0.15324f
Cbud_s2_2245 x2_x1_net5 x2_x2_net3 0.153233f
Cbud_s2_2246 x2_x1_net5 x2_x2_net4 0.153267f
Cbud_s2_2247 x2_x1_net5 x2_x2_net5 0.153262f
Cbud_s2_2248 x2_x1_net5 x2_x2_net6 0.153258f
Cbud_s2_2249 x2_x1_net5 x2_x2_net7 0.153254f
Cbud_s2_2250 x2_x1_net5 x2_x2_net8 0.153241f
Cbud_s2_2251 x2_x1_net5 x2_x2_net9 0.153243f
Cbud_s2_2252 x2_x1_net5 Vm 0.0271527f
Cbud_s2_2253 x2_x1_net5 Vp 0.0271527f
Cbud_s2_2254 x2_x1_net6 x2_x1_net7 1.07452f
Cbud_s2_2255 x2_x1_net6 x2_x1_net8 0.153974f
Cbud_s2_2256 x2_x1_net6 x2_x1_net9 0.154461f
Cbud_s2_2257 x2_x1_net6 x2_x2_net1 0.153254f
Cbud_s2_2258 x2_x1_net6 x2_x2_net10 0.153248f
Cbud_s2_2259 x2_x1_net6 x2_x2_net11 0.153251f
Cbud_s2_2260 x2_x1_net6 x2_x2_net12 0.15324f
Cbud_s2_2261 x2_x1_net6 x2_x2_net13 0.153238f
Cbud_s2_2262 x2_x1_net6 x2_x2_net14 0.153237f
Cbud_s2_2263 x2_x1_net6 x2_x2_net15 0.153236f
Cbud_s2_2264 x2_x1_net6 x2_x2_net16 0.153231f
Cbud_s2_2265 x2_x1_net6 x2_x2_net17 0.153232f
Cbud_s2_2266 x2_x1_net6 x2_x2_net18 0.153233f
Cbud_s2_2267 x2_x1_net6 x2_x2_net19 0.153233f
Cbud_s2_2268 x2_x1_net6 x2_x2_net2 0.153241f
Cbud_s2_2269 x2_x1_net6 x2_x2_net3 0.153234f
Cbud_s2_2270 x2_x1_net6 x2_x2_net4 0.153273f
Cbud_s2_2271 x2_x1_net6 x2_x2_net5 0.153267f
Cbud_s2_2272 x2_x1_net6 x2_x2_net6 0.153262f
Cbud_s2_2273 x2_x1_net6 x2_x2_net7 0.153258f
Cbud_s2_2274 x2_x1_net6 x2_x2_net8 0.153243f
Cbud_s2_2275 x2_x1_net6 x2_x2_net9 0.153245f
Cbud_s2_2276 x2_x1_net6 Vm 0.0271637f
Cbud_s2_2277 x2_x1_net6 Vp 0.0271637f
Cbud_s2_2278 x2_x1_net7 x2_x1_net8 0.154466f
Cbud_s2_2279 x2_x1_net7 x2_x1_net9 0.155388f
Cbud_s2_2280 x2_x1_net7 x2_x2_net1 0.153258f
Cbud_s2_2281 x2_x1_net7 x2_x2_net10 0.153251f
Cbud_s2_2282 x2_x1_net7 x2_x2_net11 0.153254f
Cbud_s2_2283 x2_x1_net7 x2_x2_net12 0.153241f
Cbud_s2_2284 x2_x1_net7 x2_x2_net13 0.15324f
Cbud_s2_2285 x2_x1_net7 x2_x2_net14 0.153238f
Cbud_s2_2286 x2_x1_net7 x2_x2_net15 0.153237f
Cbud_s2_2287 x2_x1_net7 x2_x2_net16 0.153232f
Cbud_s2_2288 x2_x1_net7 x2_x2_net17 0.153233f
Cbud_s2_2289 x2_x1_net7 x2_x2_net18 0.153233f
Cbud_s2_2290 x2_x1_net7 x2_x2_net19 0.153234f
Cbud_s2_2291 x2_x1_net7 x2_x2_net2 0.153243f
Cbud_s2_2292 x2_x1_net7 x2_x2_net3 0.153236f
Cbud_s2_2293 x2_x1_net7 x2_x2_net4 0.15328f
Cbud_s2_2294 x2_x1_net7 x2_x2_net5 0.153273f
Cbud_s2_2295 x2_x1_net7 x2_x2_net6 0.153267f
Cbud_s2_2296 x2_x1_net7 x2_x2_net7 0.153262f
Cbud_s2_2297 x2_x1_net7 x2_x2_net8 0.153245f
Cbud_s2_2298 x2_x1_net7 x2_x2_net9 0.153248f
Cbud_s2_2299 x2_x1_net7 Vm 0.0271776f
Cbud_s2_2300 x2_x1_net7 Vp 0.0271777f
Cbud_s2_2301 x2_x1_net8 x2_x1_net9 0.930604f
Cbud_s2_2302 x2_x1_net8 x2_x2_net1 0.153289f
Cbud_s2_2303 x2_x1_net8 x2_x2_net10 0.153273f
Cbud_s2_2304 x2_x1_net8 x2_x2_net11 0.15328f
Cbud_s2_2305 x2_x1_net8 x2_x2_net12 0.153254f
Cbud_s2_2306 x2_x1_net8 x2_x2_net13 0.153251f
Cbud_s2_2307 x2_x1_net8 x2_x2_net14 0.153248f
Cbud_s2_2308 x2_x1_net8 x2_x2_net15 0.153245f
Cbud_s2_2309 x2_x1_net8 x2_x2_net16 0.153237f
Cbud_s2_2310 x2_x1_net8 x2_x2_net17 0.153238f
Cbud_s2_2311 x2_x1_net8 x2_x2_net18 0.15324f
Cbud_s2_2312 x2_x1_net8 x2_x2_net19 0.153241f
Cbud_s2_2313 x2_x1_net8 x2_x2_net2 0.153258f
Cbud_s2_2314 x2_x1_net8 x2_x2_net3 0.153243f
Cbud_s2_2315 x2_x1_net8 x2_x2_net4 0.153356f
Cbud_s2_2316 x2_x1_net8 x2_x2_net5 0.153332f
Cbud_s2_2317 x2_x1_net8 x2_x2_net6 0.153314f
Cbud_s2_2318 x2_x1_net8 x2_x2_net7 0.1533f
Cbud_s2_2319 x2_x1_net8 x2_x2_net8 0.153262f
Cbud_s2_2320 x2_x1_net8 x2_x2_net9 0.153267f
Cbud_s2_2321 x2_x1_net8 Vm 0.0273299f
Cbud_s2_2322 x2_x1_net8 Vp 0.0273275f
Cbud_s2_2323 x2_x1_net9 x2_x2_net1 0.153281f
Cbud_s2_2324 x2_x1_net9 x2_x2_net10 0.153267f
Cbud_s2_2325 x2_x1_net9 x2_x2_net11 0.153273f
Cbud_s2_2326 x2_x1_net9 x2_x2_net12 0.153251f
Cbud_s2_2327 x2_x1_net9 x2_x2_net13 0.153248f
Cbud_s2_2328 x2_x1_net9 x2_x2_net14 0.153245f
Cbud_s2_2329 x2_x1_net9 x2_x2_net15 0.153243f
Cbud_s2_2330 x2_x1_net9 x2_x2_net16 0.153236f
Cbud_s2_2331 x2_x1_net9 x2_x2_net17 0.153237f
Cbud_s2_2332 x2_x1_net9 x2_x2_net18 0.153238f
Cbud_s2_2333 x2_x1_net9 x2_x2_net19 0.15324f
Cbud_s2_2334 x2_x1_net9 x2_x2_net2 0.153254f
Cbud_s2_2335 x2_x1_net9 x2_x2_net3 0.153241f
Cbud_s2_2336 x2_x1_net9 x2_x2_net4 0.153332f
Cbud_s2_2337 x2_x1_net9 x2_x2_net5 0.153314f
Cbud_s2_2338 x2_x1_net9 x2_x2_net6 0.1533f
Cbud_s2_2339 x2_x1_net9 x2_x2_net7 0.153289f
Cbud_s2_2340 x2_x1_net9 x2_x2_net8 0.153258f
Cbud_s2_2341 x2_x1_net9 x2_x2_net9 0.153262f
Cbud_s2_2342 x2_x1_net9 Vm 0.0272933f
Cbud_s2_2343 x2_x1_net9 Vp 0.027293f
Cbud_s2_2344 x2_x2_net1 x2_x2_net10 0.278232f
Cbud_s2_2345 x2_x2_net1 x2_x2_net11 0.879435f
Cbud_s2_2346 x2_x2_net1 x2_x2_net12 0.153984f
Cbud_s2_2347 x2_x2_net1 x2_x2_net13 0.153731f
Cbud_s2_2348 x2_x2_net1 x2_x2_net14 0.153585f
Cbud_s2_2349 x2_x2_net1 x2_x2_net15 0.1535f
Cbud_s2_2350 x2_x2_net1 x2_x2_net16 0.153314f
Cbud_s2_2351 x2_x2_net1 x2_x2_net17 0.153332f
Cbud_s2_2352 x2_x2_net1 x2_x2_net18 0.153356f
Cbud_s2_2353 x2_x2_net1 x2_x2_net19 0.153388f
Cbud_s2_2354 x2_x2_net1 x2_x2_net2 0.154458f
Cbud_s2_2355 x2_x2_net1 x2_x2_net3 0.153433f
Cbud_s2_2356 x2_x2_net1 x2_x2_net4 0.155413f
Cbud_s2_2357 x2_x2_net1 x2_x2_net5 0.163515f
Cbud_s2_2358 x2_x2_net1 x2_x2_net6 0.258059f
Cbud_s2_2359 x2_x2_net1 x2_x2_net7 0.879435f
Cbud_s2_2360 x2_x2_net1 x2_x2_net8 0.155396f
Cbud_s2_2361 x2_x2_net1 x2_x2_net9 0.164571f
Cbud_s2_2362 x2_x2_net1 Vm 0.0407149f
Cbud_s2_2363 x2_x2_net1 Vp 0.0406758f
Cbud_s2_2364 x2_x2_net10 x2_x2_net11 0.879435f
Cbud_s2_2365 x2_x2_net10 x2_x2_net12 0.155396f
Cbud_s2_2366 x2_x2_net10 x2_x2_net13 0.154462f
Cbud_s2_2367 x2_x2_net10 x2_x2_net14 0.153983f
Cbud_s2_2368 x2_x2_net10 x2_x2_net15 0.153735f
Cbud_s2_2369 x2_x2_net10 x2_x2_net16 0.153356f
Cbud_s2_2370 x2_x2_net10 x2_x2_net17 0.153388f
Cbud_s2_2371 x2_x2_net10 x2_x2_net18 0.153433f
Cbud_s2_2372 x2_x2_net10 x2_x2_net19 0.1535f
Cbud_s2_2373 x2_x2_net10 x2_x2_net2 0.165197f
Cbud_s2_2374 x2_x2_net10 x2_x2_net3 0.153587f
Cbud_s2_2375 x2_x2_net10 x2_x2_net4 0.153984f
Cbud_s2_2376 x2_x2_net10 x2_x2_net5 0.154471f
Cbud_s2_2377 x2_x2_net10 x2_x2_net6 0.155341f
Cbud_s2_2378 x2_x2_net10 x2_x2_net7 0.164571f
Cbud_s2_2379 x2_x2_net10 x2_x2_net8 0.254491f
Cbud_s2_2380 x2_x2_net10 x2_x2_net9 0.879435f
Cbud_s2_2381 x2_x2_net10 Vm 0.0292092f
Cbud_s2_2382 x2_x2_net10 Vp 0.0292525f
Cbud_s2_2383 x2_x2_net11 x2_x2_net12 0.154465f
Cbud_s2_2384 x2_x2_net11 x2_x2_net13 0.153973f
Cbud_s2_2385 x2_x2_net11 x2_x2_net14 0.153737f
Cbud_s2_2386 x2_x2_net11 x2_x2_net15 0.153586f
Cbud_s2_2387 x2_x2_net11 x2_x2_net16 0.153332f
Cbud_s2_2388 x2_x2_net11 x2_x2_net17 0.153356f
Cbud_s2_2389 x2_x2_net11 x2_x2_net18 0.153388f
Cbud_s2_2390 x2_x2_net11 x2_x2_net19 0.153434f
Cbud_s2_2391 x2_x2_net11 x2_x2_net2 0.155435f
Cbud_s2_2392 x2_x2_net11 x2_x2_net3 0.153498f
Cbud_s2_2393 x2_x2_net11 x2_x2_net4 0.154476f
Cbud_s2_2394 x2_x2_net11 x2_x2_net5 0.155361f
Cbud_s2_2395 x2_x2_net11 x2_x2_net6 0.164289f
Cbud_s2_2396 x2_x2_net11 x2_x2_net7 0.278232f
Cbud_s2_2397 x2_x2_net11 x2_x2_net8 0.163572f
Cbud_s2_2398 x2_x2_net11 x2_x2_net9 0.278232f
Cbud_s2_2399 x2_x2_net11 Vm 0.0325696f
Cbud_s2_2400 x2_x2_net11 Vp 0.0325512f
Cbud_s2_2401 x2_x2_net12 x2_x2_net13 0.843453f
Cbud_s2_2402 x2_x2_net12 x2_x2_net14 0.250161f
Cbud_s2_2403 x2_x2_net12 x2_x2_net15 0.163572f
Cbud_s2_2404 x2_x2_net12 x2_x2_net16 0.153583f
Cbud_s2_2405 x2_x2_net12 x2_x2_net17 0.153731f
Cbud_s2_2406 x2_x2_net12 x2_x2_net18 0.153986f
Cbud_s2_2407 x2_x2_net12 x2_x2_net19 0.154476f
Cbud_s2_2408 x2_x2_net12 x2_x2_net2 0.843453f
Cbud_s2_2409 x2_x2_net12 x2_x2_net3 0.155355f
Cbud_s2_2410 x2_x2_net12 x2_x2_net4 0.153433f
Cbud_s2_2411 x2_x2_net12 x2_x2_net5 0.1535f
Cbud_s2_2412 x2_x2_net12 x2_x2_net6 0.153583f
Cbud_s2_2413 x2_x2_net12 x2_x2_net7 0.153734f
Cbud_s2_2414 x2_x2_net12 x2_x2_net8 0.247874f
Cbud_s2_2415 x2_x2_net12 x2_x2_net9 0.163658f
Cbud_s2_2416 x2_x2_net12 Vm 0.0273272f
Cbud_s2_2417 x2_x2_net12 Vp 0.02733f
Cbud_s2_2418 x2_x2_net13 x2_x2_net14 0.843453f
Cbud_s2_2419 x2_x2_net13 x2_x2_net15 0.250161f
Cbud_s2_2420 x2_x2_net13 x2_x2_net16 0.153734f
Cbud_s2_2421 x2_x2_net13 x2_x2_net17 0.153981f
Cbud_s2_2422 x2_x2_net13 x2_x2_net18 0.154476f
Cbud_s2_2423 x2_x2_net13 x2_x2_net19 0.155271f
Cbud_s2_2424 x2_x2_net13 x2_x2_net2 0.250161f
Cbud_s2_2425 x2_x2_net13 x2_x2_net3 0.163572f
Cbud_s2_2426 x2_x2_net13 x2_x2_net4 0.153388f
Cbud_s2_2427 x2_x2_net13 x2_x2_net5 0.153434f
Cbud_s2_2428 x2_x2_net13 x2_x2_net6 0.153499f
Cbud_s2_2429 x2_x2_net13 x2_x2_net7 0.153587f
Cbud_s2_2430 x2_x2_net13 x2_x2_net8 0.163866f
Cbud_s2_2431 x2_x2_net13 x2_x2_net9 0.155308f
Cbud_s2_2432 x2_x2_net13 Vm 0.0272929f
Cbud_s2_2433 x2_x2_net13 Vp 0.0272936f
Cbud_s2_2434 x2_x2_net14 x2_x2_net15 0.843453f
Cbud_s2_2435 x2_x2_net14 x2_x2_net16 0.15399f
Cbud_s2_2436 x2_x2_net14 x2_x2_net17 0.154462f
Cbud_s2_2437 x2_x2_net14 x2_x2_net18 0.155284f
Cbud_s2_2438 x2_x2_net14 x2_x2_net19 0.16483f
Cbud_s2_2439 x2_x2_net14 x2_x2_net2 0.163572f
Cbud_s2_2440 x2_x2_net14 x2_x2_net3 0.250161f
Cbud_s2_2441 x2_x2_net14 x2_x2_net4 0.153356f
Cbud_s2_2442 x2_x2_net14 x2_x2_net5 0.153388f
Cbud_s2_2443 x2_x2_net14 x2_x2_net6 0.153434f
Cbud_s2_2444 x2_x2_net14 x2_x2_net7 0.153499f
Cbud_s2_2445 x2_x2_net14 x2_x2_net8 0.155304f
Cbud_s2_2446 x2_x2_net14 x2_x2_net9 0.154466f
Cbud_s2_2447 x2_x2_net14 Vm 0.0272526f
Cbud_s2_2448 x2_x2_net14 Vp 0.0272526f
Cbud_s2_2449 x2_x2_net15 x2_x2_net16 0.154482f
Cbud_s2_2450 x2_x2_net15 x2_x2_net17 0.155284f
Cbud_s2_2451 x2_x2_net15 x2_x2_net18 0.1636f
Cbud_s2_2452 x2_x2_net15 x2_x2_net19 0.252051f
Cbud_s2_2453 x2_x2_net15 x2_x2_net2 0.155355f
Cbud_s2_2454 x2_x2_net15 x2_x2_net3 0.843453f
Cbud_s2_2455 x2_x2_net15 x2_x2_net4 0.153332f
Cbud_s2_2456 x2_x2_net15 x2_x2_net5 0.153356f
Cbud_s2_2457 x2_x2_net15 x2_x2_net6 0.153387f
Cbud_s2_2458 x2_x2_net15 x2_x2_net7 0.153433f
Cbud_s2_2459 x2_x2_net15 x2_x2_net8 0.154475f
Cbud_s2_2460 x2_x2_net15 x2_x2_net9 0.153982f
Cbud_s2_2461 x2_x2_net15 Vm 0.0272186f
Cbud_s2_2462 x2_x2_net15 Vp 0.0272185f
Cbud_s2_2463 x2_x2_net16 x2_x2_net17 0.206259f
Cbud_s2_2464 x2_x2_net16 x2_x2_net18 0.262923f
Cbud_s2_2465 x2_x2_net16 x2_x2_net19 0.165474f
Cbud_s2_2466 x2_x2_net16 x2_x2_net2 0.153499f
Cbud_s2_2467 x2_x2_net16 x2_x2_net3 0.155407f
Cbud_s2_2468 x2_x2_net16 x2_x2_net4 0.153273f
Cbud_s2_2469 x2_x2_net16 x2_x2_net5 0.153281f
Cbud_s2_2470 x2_x2_net16 x2_x2_net6 0.153289f
Cbud_s2_2471 x2_x2_net16 x2_x2_net7 0.153301f
Cbud_s2_2472 x2_x2_net16 x2_x2_net8 0.153434f
Cbud_s2_2473 x2_x2_net16 x2_x2_net9 0.153389f
Cbud_s2_2474 x2_x2_net16 Vm 0.0271426f
Cbud_s2_2475 x2_x2_net16 Vp 0.0271363f
Cbud_s2_2476 x2_x2_net17 x2_x2_net18 0.913075f
Cbud_s2_2477 x2_x2_net17 x2_x2_net19 0.249236f
Cbud_s2_2478 x2_x2_net17 x2_x2_net2 0.153559f
Cbud_s2_2479 x2_x2_net17 x2_x2_net3 0.16432f
Cbud_s2_2480 x2_x2_net17 x2_x2_net4 0.153281f
Cbud_s2_2481 x2_x2_net17 x2_x2_net5 0.153289f
Cbud_s2_2482 x2_x2_net17 x2_x2_net6 0.1533f
Cbud_s2_2483 x2_x2_net17 x2_x2_net7 0.153314f
Cbud_s2_2484 x2_x2_net17 x2_x2_net8 0.153499f
Cbud_s2_2485 x2_x2_net17 x2_x2_net9 0.153434f
Cbud_s2_2486 x2_x2_net17 Vm 0.0271527f
Cbud_s2_2487 x2_x2_net17 Vp 0.0271528f
Cbud_s2_2488 x2_x2_net18 x2_x2_net19 0.864631f
Cbud_s2_2489 x2_x2_net18 x2_x2_net2 0.153733f
Cbud_s2_2490 x2_x2_net18 x2_x2_net3 0.251099f
Cbud_s2_2491 x2_x2_net18 x2_x2_net4 0.153289f
Cbud_s2_2492 x2_x2_net18 x2_x2_net5 0.153301f
Cbud_s2_2493 x2_x2_net18 x2_x2_net6 0.153314f
Cbud_s2_2494 x2_x2_net18 x2_x2_net7 0.153332f
Cbud_s2_2495 x2_x2_net18 x2_x2_net8 0.153585f
Cbud_s2_2496 x2_x2_net18 x2_x2_net9 0.153499f
Cbud_s2_2497 x2_x2_net18 Vm 0.0271638f
Cbud_s2_2498 x2_x2_net18 Vp 0.0271638f
Cbud_s2_2499 x2_x2_net19 x2_x2_net2 0.153987f
Cbud_s2_2500 x2_x2_net19 x2_x2_net3 0.839116f
Cbud_s2_2501 x2_x2_net19 x2_x2_net4 0.1533f
Cbud_s2_2502 x2_x2_net19 x2_x2_net5 0.153314f
Cbud_s2_2503 x2_x2_net19 x2_x2_net6 0.153332f
Cbud_s2_2504 x2_x2_net19 x2_x2_net7 0.153356f
Cbud_s2_2505 x2_x2_net19 x2_x2_net8 0.153734f
Cbud_s2_2506 x2_x2_net19 x2_x2_net9 0.153582f
Cbud_s2_2507 x2_x2_net19 Vm 0.0271777f
Cbud_s2_2508 x2_x2_net19 Vp 0.0271776f
Cbud_s2_2509 x2_x2_net2 x2_x2_net3 0.154475f
Cbud_s2_2510 x2_x2_net2 x2_x2_net4 0.1535f
Cbud_s2_2511 x2_x2_net2 x2_x2_net5 0.153583f
Cbud_s2_2512 x2_x2_net2 x2_x2_net6 0.153738f
Cbud_s2_2513 x2_x2_net2 x2_x2_net7 0.153988f
Cbud_s2_2514 x2_x2_net2 x2_x2_net8 0.848329f
Cbud_s2_2515 x2_x2_net2 x2_x2_net9 0.254989f
Cbud_s2_2516 x2_x2_net2 Vm 0.0273921f
Cbud_s2_2517 x2_x2_net2 Vp 0.0273968f
Cbud_s2_2518 x2_x2_net3 x2_x2_net4 0.153314f
Cbud_s2_2519 x2_x2_net3 x2_x2_net5 0.153332f
Cbud_s2_2520 x2_x2_net3 x2_x2_net6 0.153356f
Cbud_s2_2521 x2_x2_net3 x2_x2_net7 0.153388f
Cbud_s2_2522 x2_x2_net3 x2_x2_net8 0.15398f
Cbud_s2_2523 x2_x2_net3 x2_x2_net9 0.153735f
Cbud_s2_2524 x2_x2_net3 Vm 0.0271954f
Cbud_s2_2525 x2_x2_net3 Vp 0.0271953f
Cbud_s2_2526 x2_x2_net4 x2_x2_net5 0.879435f
Cbud_s2_2527 x2_x2_net4 x2_x2_net6 0.243538f
Cbud_s2_2528 x2_x2_net4 x2_x2_net7 0.164351f
Cbud_s2_2529 x2_x2_net4 x2_x2_net8 0.153564f
Cbud_s2_2530 x2_x2_net4 x2_x2_net9 0.153729f
Cbud_s2_2531 x2_x2_net4 Vm 1.18722f
Cbud_s2_2532 x2_x2_net4 Vp 1.18715f
Cbud_s2_2533 x2_x2_net5 x2_x2_net6 1.06085f
Cbud_s2_2534 x2_x2_net5 x2_x2_net7 0.257021f
Cbud_s2_2535 x2_x2_net5 x2_x2_net8 0.153731f
Cbud_s2_2536 x2_x2_net5 x2_x2_net9 0.153984f
Cbud_s2_2537 x2_x2_net5 Vm 1.10229f
Cbud_s2_2538 x2_x2_net5 Vp 1.05624f
Cbud_s2_2539 x2_x2_net6 x2_x2_net7 1.26158f
Cbud_s2_2540 x2_x2_net6 x2_x2_net8 0.153987f
Cbud_s2_2541 x2_x2_net6 x2_x2_net9 0.154467f
Cbud_s2_2542 x2_x2_net6 Vm 0.135808f
Cbud_s2_2543 x2_x2_net6 Vp 0.134311f
Cbud_s2_2544 x2_x2_net7 x2_x2_net8 0.154481f
Cbud_s2_2545 x2_x2_net7 x2_x2_net9 0.155444f
Cbud_s2_2546 x2_x2_net7 Vm 0.0700227f
Cbud_s2_2547 x2_x2_net7 Vp 0.0697821f
Cbud_s2_2548 x2_x2_net8 x2_x2_net9 3.69301f
Cbud_s2_2549 x2_x2_net8 Vm 0.0275504f
Cbud_s2_2550 x2_x2_net8 Vp 0.0275575f
Cbud_s2_2551 x2_x2_net9 Vm 0.028023f
Cbud_s2_2552 x2_x2_net9 Vp 0.0280229f
XM32 s1r_XM32_d PBias s1r_XM32_s Vdd sky130_fd_pr__pfet_01v8_lvt L=1 W=5 NF=1 AD=1.45 AS=1.45 PD=10.58 PS=10.58 NRD=0.058 NRS=0.058 SA=0 SB=0 SD=0 MULT=2 M=2
Rpar_s1_XM32_s s1r_XM32_s Vdd 6.57044
Rpar_s1_XM32_d s1r_XM32_d NBias 6.57044
XM33 s1r_XM33_d NBias s1r_XM33_s Vss sky130_fd_pr__nfet_01v8_lvt L=2 W=5 NF=1 AD=1.45 AS=1.45 PD=10.58 PS=10.58 NRD=0.058 NRS=0.058 SA=0 SB=0 SD=0 MULT=2 M=2
Rpar_s1_XM33_s s1r_XM33_s Vss 21.5535
Rpar_s1_XM33_d s1r_XM33_d NBias 3.39096
XM34 s1r_XM34_d s1r_XM34_g s1r_XM34_s Vdd sky130_fd_pr__pfet_01v8_lvt L=1 W=5 NF=1 AD=1.45 AS=1.45 PD=10.58 PS=10.58 NRD=0.058 NRS=0.058 SA=0 SB=0 SD=0 MULT=2 M=2
Rpar_s1_XM34_s s1r_XM34_s Vdd 41.7516
Rpar_s1_XM34_g s1r_XM34_g PBias 372.003
Rpar_s1_XM34_d s1r_XM34_d net1 51.9423
XM35 s1r_XM35_d s1r_XM35_g s1r_XM35_s Vss sky130_fd_pr__nfet_01v8_lvt L=1 W=10 NF=1 AD=2.9 AS=2.9 PD=20.58 PS=20.58 NRD=0.029 NRS=0.029 SA=0 SB=0 SD=0 MULT=2 M=2
Rpar_s1_XM35_s s1r_XM35_s Rgm 3.59358
Rpar_s1_XM35_g s1r_XM35_g net1 516.315
Rpar_s1_XM35_d s1r_XM35_d net1 3.59358
XM36 s1r_XM36_d s1r_XM36_g s1r_XM36_s Vss sky130_fd_pr__nfet_01v8_lvt L=2 W=5 NF=1 AD=1.45 AS=1.45 PD=10.58 PS=10.58 NRD=0.058 NRS=0.058 SA=0 SB=0 SD=0 MULT=2 M=2
Rpar_s1_XM36_s s1r_XM36_s Vss 21.5524
Rpar_s1_XM36_g s1r_XM36_g net1 205.62
Rpar_s1_XM36_d s1r_XM36_d net2 3.39096
XM37 s1r_XM37_d s1r_XM37_g s1r_XM37_s Vss sky130_fd_pr__nfet_01v8_lvt L=2 W=5 NF=1 AD=1.45 AS=1.45 PD=10.58 PS=10.58 NRD=0.058 NRS=0.058 SA=0 SB=0 SD=0 MULT=2 M=2
Rpar_s1_XM37_s s1r_XM37_s Vss 3.39096
Rpar_s1_XM37_g s1r_XM37_g NBias 205.681
Rpar_s1_XM37_d s1r_XM37_d PBias 3.39096
XM38 s1r_XM38_d s1r_XM38_g s1r_XM38_s Vdd sky130_fd_pr__pfet_01v8_lvt L=1 W=5 NF=1 AD=1.45 AS=1.45 PD=10.58 PS=10.58 NRD=0.058 NRS=0.058 SA=0 SB=0 SD=0 MULT=2 M=2
Rpar_s1_XM38_s s1r_XM38_s Vdd 48.7138
Rpar_s1_XM38_g s1r_XM38_g net2 373.568
Rpar_s1_XM38_d s1r_XM38_d PBias 283.903
XM39 s1r_XM39_d s1r_XM39_g s1r_XM39_s Vdd sky130_fd_pr__pfet_01v8_lvt L=1 W=5 NF=1 AD=1.45 AS=1.45 PD=10.58 PS=10.58 NRD=0.058 NRS=0.058 SA=0 SB=0 SD=0 MULT=2 M=2
Rpar_s1_XM39_s s1r_XM39_s Vdd 48.7138
Rpar_s1_XM39_g s1r_XM39_g net2 373.568
Rpar_s1_XM39_d s1r_XM39_d net2 283.903
XM40 PBias net3 s1r_XM40_s Vss sky130_fd_pr__nfet_01v8_lvt L=1 W=2 NF=1 AD=0.58 AS=0.58 PD=4.58 PS=4.58 NRD=0.145 NRS=0.145 SA=0 SB=0 SD=0 MULT=1
Rpar_s1_XM40_s s1r_XM40_s NBias 680.003
XM41 s1r_XM41_d s1r_XM41_g s1r_XM41_s Vss sky130_fd_pr__nfet_01v8_lvt L=2 W=5 NF=1 AD=1.45 AS=1.45 PD=10.58 PS=10.58 NRD=0.058 NRS=0.058 SA=0 SB=0 SD=0 MULT=2 M=2
Rpar_s1_XM41_s s1r_XM41_s Vss 148.954
Rpar_s1_XM41_g s1r_XM41_g NBias 205.681
Rpar_s1_XM41_d s1r_XM41_d net3 148.954
XM42 s1r_XM42_d net3 s1r_XM42_s Vdd sky130_fd_pr__pfet_01v8_lvt L=20 W=1 NF=1 AD=0.29 AS=0.29 PD=2.58 PS=2.58 NRD=0.29 NRS=0.29 SA=0 SB=0 SD=0 MULT=2 M=2
Rpar_s1_XM42_s s1r_XM42_s Vdd 1113.02
Rpar_s1_XM42_d s1r_XM42_d net3 1113.02
XM43 s1r_XM43_d s1r_XM43_g s1r_XM43_s Vdd sky130_fd_pr__pfet_01v8_lvt L=1 W=5 NF=1 AD=1.45 AS=1.45 PD=10.58 PS=10.58 NRD=0.058 NRS=0.058 SA=0 SB=0 SD=0 MULT=2 M=2
Rpar_s1_XM43_s s1r_XM43_s Vdd 181.39
Rpar_s1_XM43_g s1r_XM43_g PBias 290.424
Rpar_s1_XM43_d s1r_XM43_d net4 157.161
XM44 s1r_XM44_d s1r_XM44_g s1r_XM44_s Vdd sky130_fd_pr__pfet_01v8_lvt L=1 W=5 NF=1 AD=1.45 AS=1.45 PD=10.58 PS=10.58 NRD=0.058 NRS=0.058 SA=0 SB=0 SD=0 MULT=2 M=2
Rpar_s1_XM44_s s1r_XM44_s Vdd 6.57044
Rpar_s1_XM44_g s1r_XM44_g PBias 373.568
Rpar_s1_XM44_d s1r_XM44_d net5 6.57044
XM45 s1r_XM45_d s1r_XM45_g s1r_XM45_s Vdd sky130_fd_pr__pfet_01v8_lvt L=1 W=5 NF=1 AD=1.45 AS=1.45 PD=10.58 PS=10.58 NRD=0.058 NRS=0.058 SA=0 SB=0 SD=0 MULT=2 M=2
Rpar_s1_XM45_s s1r_XM45_s Vdd 6.57044
Rpar_s1_XM45_g s1r_XM45_g PBias 290.424
Rpar_s1_XM45_d s1r_XM45_d net6 236.839
XM54 s1r_XM54_d s1r_XM54_g s1r_XM54_s Vdd sky130_fd_pr__pfet_01v8_lvt L=1 W=5 NF=1 AD=1.45 AS=1.45 PD=10.58 PS=10.58 NRD=0.058 NRS=0.058 SA=0 SB=0 SD=0 MULT=2 M=2
Rpar_s1_XM54_s s1r_XM54_s Vdd 288.618
Rpar_s1_XM54_g s1r_XM54_g PBias 290.424
Rpar_s1_XM54_d s1r_XM54_d net7 288.618
XX1_M5 s1r_XX1_M5_d s1r_XX1_M5_g s1r_XX1_M5_s Vss sky130_fd_pr__nfet_01v8_lvt L=4 W=4 NF=1 AD=1.16 AS=1.16 PD=8.58 PS=8.58 NRD=0.0725 NRS=0.0725 SA=0 SB=0 SD=0 MULT=2 M=2
Rpar_s1_XX1_M5_s s1r_XX1_M5_s x1_net2 5.49277
Rpar_s1_XX1_M5_g s1r_XX1_M5_g Vm 19.5784
Rpar_s1_XX1_M5_d s1r_XX1_M5_d x1_Vtest2 5.49277
XX1_M6 s1r_XX1_M6_d s1r_XX1_M6_g s1r_XX1_M6_s Vss sky130_fd_pr__nfet_01v8_lvt L=4 W=4 NF=1 AD=1.16 AS=1.16 PD=8.58 PS=8.58 NRD=0.0725 NRS=0.0725 SA=0 SB=0 SD=0 MULT=2 M=2
Rpar_s1_XX1_M6_s s1r_XX1_M6_s x1_net2 5.49277
Rpar_s1_XX1_M6_g s1r_XX1_M6_g Vp 19.5784
Rpar_s1_XX1_M6_d s1r_XX1_M6_d x1_net1 5.49277
XX1_M11 s1r_XX1_M11_d s1r_XX1_M11_g s1r_XX1_M11_s Vdd sky130_fd_pr__pfet_01v8_lvt L=5 W=2 NF=1 AD=0.58 AS=0.58 PD=4.58 PS=4.58 NRD=0.145 NRS=0.145 SA=0 SB=0 SD=0 MULT=2 M=2
Rpar_s1_XX1_M11_s s1r_XX1_M11_s x1_Vtest2 23.9674
Rpar_s1_XX1_M11_g s1r_XX1_M11_g x1_Vbias 100.537
Rpar_s1_XX1_M11_d s1r_XX1_M11_d Vop1 23.9674
XX1_M12 s1r_XX1_M12_d s1r_XX1_M12_g s1r_XX1_M12_s Vdd sky130_fd_pr__pfet_01v8_lvt L=5 W=2 NF=1 AD=0.58 AS=0.58 PD=4.58 PS=4.58 NRD=0.145 NRS=0.145 SA=0 SB=0 SD=0 MULT=2 M=2
Rpar_s1_XX1_M12_s s1r_XX1_M12_s x1_net1 23.9674
Rpar_s1_XX1_M12_g s1r_XX1_M12_g x1_Vbias 100.537
Rpar_s1_XX1_M12_d s1r_XX1_M12_d Vom1 23.9674
XX1_M13 s1r_XX1_M13_d s1r_XX1_M13_g s1r_XX1_M13_s Vdd sky130_fd_pr__pfet_01v8_lvt L=5 W=2 NF=1 AD=0.58 AS=0.58 PD=4.58 PS=4.58 NRD=0.145 NRS=0.145 SA=0 SB=0 SD=0 MULT=4 M=4
Rpar_s1_XX1_M13_s s1r_XX1_M13_s Vdd 7.74968
Rpar_s1_XX1_M13_g s1r_XX1_M13_g x1_Vout 110.408
Rpar_s1_XX1_M13_d s1r_XX1_M13_d x1_Vtest2 7.74968
XX1_M14 s1r_XX1_M14_d s1r_XX1_M14_g s1r_XX1_M14_s Vdd sky130_fd_pr__pfet_01v8_lvt L=5 W=2 NF=1 AD=0.58 AS=0.58 PD=4.58 PS=4.58 NRD=0.145 NRS=0.145 SA=0 SB=0 SD=0 MULT=4 M=4
Rpar_s1_XX1_M14_s s1r_XX1_M14_s Vdd 7.74968
Rpar_s1_XX1_M14_g s1r_XX1_M14_g x1_Vout 107.443
Rpar_s1_XX1_M14_d s1r_XX1_M14_d x1_net1 7.74968
XX1_M19 s1r_XX1_M19_d s1r_XX1_M19_g s1r_XX1_M19_s Vss sky130_fd_pr__nfet_01v8_lvt L=1 W=1 NF=1 AD=0.29 AS=0.29 PD=2.58 PS=2.58 NRD=0.29 NRS=0.29 SA=0 SB=0 SD=0 MULT=2 M=2
Rpar_s1_XX1_M19_s s1r_XX1_M19_s x1_net3 175.073
Rpar_s1_XX1_M19_g s1r_XX1_M19_g net5 256.167
Rpar_s1_XX1_M19_d s1r_XX1_M19_d x1_net2 278.901
XX1_M1 s1r_XX1_M1_d s1r_XX1_M1_g s1r_XX1_M1_s Vss sky130_fd_pr__nfet_01v8_lvt L=10 W=1 NF=1 AD=0.29 AS=0.29 PD=2.58 PS=2.58 NRD=0.29 NRS=0.29 SA=0 SB=0 SD=0 MULT=2 M=2
Rpar_s1_XX1_M1_s s1r_XX1_M1_s Vss 9.25569
Rpar_s1_XX1_M1_g s1r_XX1_M1_g net4 91.1924
Rpar_s1_XX1_M1_d s1r_XX1_M1_d x1_net3 175.684
XX1_M2 s1r_XX1_M2_d s1r_XX1_M2_g s1r_XX1_M2_s Vss sky130_fd_pr__nfet_01v8_lvt L=10 W=1 NF=1 AD=0.29 AS=0.29 PD=2.58 PS=2.58 NRD=0.29 NRS=0.29 SA=0 SB=0 SD=0 MULT=2 M=2
Rpar_s1_XX1_M2_s s1r_XX1_M2_s Vss 9.25569
Rpar_s1_XX1_M2_g s1r_XX1_M2_g net4 91.1924
Rpar_s1_XX1_M2_d s1r_XX1_M2_d x1_net4 175.684
XX1_M3 s1r_XX1_M3_d s1r_XX1_M3_g s1r_XX1_M3_s Vss sky130_fd_pr__nfet_01v8_lvt L=1 W=1 NF=1 AD=0.29 AS=0.29 PD=2.58 PS=2.58 NRD=0.29 NRS=0.29 SA=0 SB=0 SD=0 MULT=2 M=2
Rpar_s1_XX1_M3_s s1r_XX1_M3_s x1_net4 175.073
Rpar_s1_XX1_M3_g s1r_XX1_M3_g net5 256.097
Rpar_s1_XX1_M3_d s1r_XX1_M3_d x1_net2 278.901
XX1_M4 s1r_XX1_M4_d s1r_XX1_M4_g s1r_XX1_M4_s Vss sky130_fd_pr__nfet_01v8_lvt L=1 W=1 NF=1 AD=0.29 AS=0.29 PD=2.58 PS=2.58 NRD=0.29 NRS=0.29 SA=0 SB=0 SD=0 MULT=2 M=2
Rpar_s1_XX1_M4_s s1r_XX1_M4_s x1_net5 8.34438
Rpar_s1_XX1_M4_g s1r_XX1_M4_g net5 256.09
Rpar_s1_XX1_M4_d s1r_XX1_M4_d Vop1 8.34438
XX1_M7 s1r_XX1_M7_d s1r_XX1_M7_g s1r_XX1_M7_s Vss sky130_fd_pr__nfet_01v8_lvt L=10 W=1 NF=1 AD=0.29 AS=0.29 PD=2.58 PS=2.58 NRD=0.29 NRS=0.29 SA=0 SB=0 SD=0 MULT=2 M=2
Rpar_s1_XX1_M7_s s1r_XX1_M7_s Vss 406.572
Rpar_s1_XX1_M7_g s1r_XX1_M7_g net4 91.1901
Rpar_s1_XX1_M7_d s1r_XX1_M7_d x1_net5 9.25569
XX1_M8 s1r_XX1_M8_d s1r_XX1_M8_g s1r_XX1_M8_s Vss sky130_fd_pr__nfet_01v8_lvt L=1 W=1 NF=1 AD=0.29 AS=0.29 PD=2.58 PS=2.58 NRD=0.29 NRS=0.29 SA=0 SB=0 SD=0 MULT=2 M=2
Rpar_s1_XX1_M8_s s1r_XX1_M8_s x1_net6 8.34438
Rpar_s1_XX1_M8_g s1r_XX1_M8_g net5 256.09
Rpar_s1_XX1_M8_d s1r_XX1_M8_d Vom1 8.34438
XX1_M9 s1r_XX1_M9_d s1r_XX1_M9_g s1r_XX1_M9_s Vss sky130_fd_pr__nfet_01v8_lvt L=10 W=1 NF=1 AD=0.29 AS=0.29 PD=2.58 PS=2.58 NRD=0.29 NRS=0.29 SA=0 SB=0 SD=0 MULT=2 M=2
Rpar_s1_XX1_M9_s s1r_XX1_M9_s Vss 406.572
Rpar_s1_XX1_M9_g s1r_XX1_M9_g net4 91.1901
Rpar_s1_XX1_M9_d s1r_XX1_M9_d x1_net6 9.25569
XX1_M10 s1r_XX1_M10_d s1r_XX1_M10_g s1r_XX1_M10_s Vss sky130_fd_pr__nfet_01v8_lvt L=20 W=5 NF=1 AD=1.45 AS=1.45 PD=10.58 PS=10.58 NRD=0.058 NRS=0.058 SA=0 SB=0 SD=0 MULT=2 M=2
Rpar_s1_XX1_M10_s s1r_XX1_M10_s x1_net8 228.922
Rpar_s1_XX1_M10_g s1r_XX1_M10_g Vref 166.757
Rpar_s1_XX1_M10_d s1r_XX1_M10_d x1_Vout 228.952
XX1_M17 s1r_XX1_M17_d s1r_XX1_M17_g s1r_XX1_M17_s Vss sky130_fd_pr__nfet_01v8_lvt L=20 W=5 NF=1 AD=1.45 AS=1.45 PD=10.58 PS=10.58 NRD=0.058 NRS=0.058 SA=0 SB=0 SD=0 MULT=2 M=2
Rpar_s1_XX1_M17_s s1r_XX1_M17_s x1_net8 228.922
Rpar_s1_XX1_M17_g s1r_XX1_M17_g Vop1 166.757
Rpar_s1_XX1_M17_d s1r_XX1_M17_d x1_net9 228.952
XX1_M18 s1r_XX1_M18_d s1r_XX1_M18_g s1r_XX1_M18_s Vss sky130_fd_pr__nfet_01v8_lvt L=20 W=5 NF=1 AD=1.45 AS=1.45 PD=10.58 PS=10.58 NRD=0.058 NRS=0.058 SA=0 SB=0 SD=0 MULT=2 M=2
Rpar_s1_XX1_M18_s s1r_XX1_M18_s x1_net7 228.922
Rpar_s1_XX1_M18_g s1r_XX1_M18_g Vom1 166.757
Rpar_s1_XX1_M18_d s1r_XX1_M18_d x1_net9 228.952
XX1_M22 s1r_XX1_M22_d s1r_XX1_M22_g s1r_XX1_M22_s Vss sky130_fd_pr__nfet_01v8_lvt L=20 W=1 NF=1 AD=0.29 AS=0.29 PD=2.58 PS=2.58 NRD=0.29 NRS=0.29 SA=0 SB=0 SD=0 MULT=2 M=2
Rpar_s1_XX1_M22_s s1r_XX1_M22_s Vss 288.012
Rpar_s1_XX1_M22_g s1r_XX1_M22_g net4 127.692
Rpar_s1_XX1_M22_d s1r_XX1_M22_d x1_net7 414.565
XX1_M20 s1r_XX1_M20_d s1r_XX1_M20_g s1r_XX1_M20_s Vdd sky130_fd_pr__pfet_01v8_lvt L=10 W=1 NF=1 AD=0.29 AS=0.29 PD=2.58 PS=2.58 NRD=0.29 NRS=0.29 SA=0 SB=0 SD=0 MULT=2 M=2
Rpar_s1_XX1_M20_s s1r_XX1_M20_s Vdd 1069.06
Rpar_s1_XX1_M20_g s1r_XX1_M20_g x1_net9 92.9964
Rpar_s1_XX1_M20_d s1r_XX1_M20_d x1_net9 332.894
XX1_M21 s1r_XX1_M21_d s1r_XX1_M21_g s1r_XX1_M21_s Vdd sky130_fd_pr__pfet_01v8_lvt L=10 W=1 NF=1 AD=0.29 AS=0.29 PD=2.58 PS=2.58 NRD=0.29 NRS=0.29 SA=0 SB=0 SD=0 MULT=2 M=2
Rpar_s1_XX1_M21_s s1r_XX1_M21_s Vdd 1069.06
Rpar_s1_XX1_M21_g s1r_XX1_M21_g x1_net9 92.9964
Rpar_s1_XX1_M21_d s1r_XX1_M21_d x1_Vout 332.894
XX1_M15 s1r_XX1_M15_d s1r_XX1_M15_g s1r_XX1_M15_s Vss sky130_fd_pr__nfet_01v8_lvt L=20 W=1 NF=1 AD=0.29 AS=0.29 PD=2.58 PS=2.58 NRD=0.29 NRS=0.29 SA=0 SB=0 SD=0 MULT=2 M=2
Rpar_s1_XX1_M15_s s1r_XX1_M15_s Vss 288.012
Rpar_s1_XX1_M15_g s1r_XX1_M15_g net4 127.692
Rpar_s1_XX1_M15_d s1r_XX1_M15_d x1_net8 414.565
XX1_M16 s1r_XX1_M16_d s1r_XX1_M16_g s1r_XX1_M16_s Vss sky130_fd_pr__nfet_01v8_lvt L=20 W=5 NF=1 AD=1.45 AS=1.45 PD=10.58 PS=10.58 NRD=0.058 NRS=0.058 SA=0 SB=0 SD=0 MULT=2 M=2
Rpar_s1_XX1_M16_s s1r_XX1_M16_s x1_net7 228.922
Rpar_s1_XX1_M16_g s1r_XX1_M16_g Vref 166.757
Rpar_s1_XX1_M16_d s1r_XX1_M16_d x1_Vout 228.952
XX1_M46 s1r_XX1_M46_d s1r_XX1_M46_g s1r_XX1_M46_s Vss sky130_fd_pr__nfet_01v8_lvt L=2 W=1 NF=1 AD=0.29 AS=0.29 PD=2.58 PS=2.58 NRD=0.29 NRS=0.29 SA=0 SB=0 SD=0 MULT=2 M=2
Rpar_s1_XX1_M46_s s1r_XX1_M46_s Vss 8.44563
Rpar_s1_XX1_M46_g s1r_XX1_M46_g net4 130.079
Rpar_s1_XX1_M46_d s1r_XX1_M46_d net4 8.44563
XX1_M47 s1r_XX1_M47_d s1r_XX1_M47_g s1r_XX1_M47_s Vss sky130_fd_pr__nfet_01v8_lvt L=5 W=0.6 NF=1 AD=0.174 AS=0.174 PD=1.78 PS=1.78 NRD=0.483333 NRS=0.483333 SA=0 SB=0 SD=0 MULT=2 M=2
Rpar_s1_XX1_M47_s s1r_XX1_M47_s Vss 1015.5
Rpar_s1_XX1_M47_g s1r_XX1_M47_g net5 80.7315
Rpar_s1_XX1_M47_d s1r_XX1_M47_d net5 23.1843
XX1_M23 s1r_XX1_M23_d net6 s1r_XX1_M23_s Vss sky130_fd_pr__nfet_01v8_lvt L=1 W=0.6 NF=1 AD=0.174 AS=0.174 PD=1.78 PS=1.78 NRD=0.483333 NRS=0.483333 SA=0 SB=0 SD=0 MULT=2 M=2
Rpar_s1_XX1_M23_s s1r_XX1_M23_s Vss 22.7792
Rpar_s1_XX1_M23_d s1r_XX1_M23_d net6 997.937
XX1_M24 s1r_XX1_M24_d net6 s1r_XX1_M24_s Vss sky130_fd_pr__nfet_01v8_lvt L=1 W=0.6 NF=1 AD=0.174 AS=0.174 PD=1.78 PS=1.78 NRD=0.483333 NRS=0.483333 SA=0 SB=0 SD=0 MULT=2 M=2
Rpar_s1_XX1_M24_s s1r_XX1_M24_s Vss 22.7792
Rpar_s1_XX1_M24_d s1r_XX1_M24_d x1_Vbias 997.937
XX1_M25 s1r_XX1_M25_d s1r_XX1_M25_g s1r_XX1_M25_s Vdd sky130_fd_pr__pfet_01v8_lvt L=10 W=1.5 NF=1 AD=0.435 AS=0.435 PD=3.58 PS=3.58 NRD=0.193333 NRS=0.193333 SA=0 SB=0 SD=0 MULT=2 M=2
Rpar_s1_XX1_M25_s s1r_XX1_M25_s Vdd 174.326
Rpar_s1_XX1_M25_g s1r_XX1_M25_g x1_Vbias 98.4448
Rpar_s1_XX1_M25_d s1r_XX1_M25_d x1_Vbias 822.172
XX2_M9 s1r_XX2_M9_d s1r_XX2_M9_g s1r_XX2_M9_s Vdd sky130_fd_pr__pfet_01v8_lvt L=1 W=2 NF=1 AD=0.58 AS=0.58 PD=4.58 PS=4.58 NRD=0.145 NRS=0.145 SA=0 SB=0 SD=0 MULT=9 M=9
Rpar_s1_XX2_M9_s s1r_XX2_M9_s Vdd 5.81316
Rpar_s1_XX2_M9_g s1r_XX2_M9_g Vom1 56.5005
Rpar_s1_XX2_M9_d s1r_XX2_M9_d Vop 5.81316
XX2_M4 s1r_XX2_M4_d s1r_XX2_M4_g s1r_XX2_M4_s Vdd sky130_fd_pr__pfet_01v8_lvt L=1 W=2 NF=1 AD=0.58 AS=0.58 PD=4.58 PS=4.58 NRD=0.145 NRS=0.145 SA=0 SB=0 SD=0 MULT=9 M=9
Rpar_s1_XX2_M4_s s1r_XX2_M4_s Vdd 5.81316
Rpar_s1_XX2_M4_g s1r_XX2_M4_g Vop1 56.5009
Rpar_s1_XX2_M4_d s1r_XX2_M4_d Vom 5.81316
XX2_M2 s1r_XX2_M2_d s1r_XX2_M2_g s1r_XX2_M2_s Vss sky130_fd_pr__nfet_01v8_lvt L=1 W=1 NF=1 AD=0.29 AS=0.29 PD=2.58 PS=2.58 NRD=0.29 NRS=0.29 SA=0 SB=0 SD=0 MULT=9 M=9
Rpar_s1_XX2_M2_s s1r_XX2_M2_s Vss 27.9772
Rpar_s1_XX2_M2_g s1r_XX2_M2_g x2_Vout 149.391
Rpar_s1_XX2_M2_d s1r_XX2_M2_d Vop 3.96023
XX2_M1 s1r_XX2_M1_d s1r_XX2_M1_g s1r_XX2_M1_s Vss sky130_fd_pr__nfet_01v8_lvt L=1 W=1 NF=1 AD=0.29 AS=0.29 PD=2.58 PS=2.58 NRD=0.29 NRS=0.29 SA=0 SB=0 SD=0 MULT=9 M=9
Rpar_s1_XX2_M1_s s1r_XX2_M1_s Vss 27.9772
Rpar_s1_XX2_M1_g s1r_XX2_M1_g x2_Vout 149.391
Rpar_s1_XX2_M1_d s1r_XX2_M1_d Vom 3.96023
XX2_M3 s1r_XX2_M3_d s1r_XX2_M3_g s1r_XX2_M3_s Vdd sky130_fd_pr__pfet_01v8_lvt L=5 W=1 NF=1 AD=0.29 AS=0.29 PD=2.58 PS=2.58 NRD=0.29 NRS=0.29 SA=0 SB=0 SD=0 MULT=2 M=2
Rpar_s1_XX2_M3_s s1r_XX2_M3_s Vdd 1047.08
Rpar_s1_XX2_M3_g s1r_XX2_M3_g x2_Vbiasp 87.6437
Rpar_s1_XX2_M3_d s1r_XX2_M3_d x2_net1 331.127
XX2_M7 s1r_XX2_M7_d s1r_XX2_M7_g s1r_XX2_M7_s Vdd sky130_fd_pr__pfet_01v8_lvt L=10 W=1 NF=1 AD=0.29 AS=0.29 PD=2.58 PS=2.58 NRD=0.29 NRS=0.29 SA=0 SB=0 SD=0 MULT=2 M=2
Rpar_s1_XX2_M7_s s1r_XX2_M7_s x2_net1 1069.06
Rpar_s1_XX2_M7_g s1r_XX2_M7_g x2_Vcm 92.9688
Rpar_s1_XX2_M7_d s1r_XX2_M7_d x2_Vtest 282.09
XX2_M8 s1r_XX2_M8_d s1r_XX2_M8_g s1r_XX2_M8_s Vdd sky130_fd_pr__pfet_01v8_lvt L=10 W=1 NF=1 AD=0.29 AS=0.29 PD=2.58 PS=2.58 NRD=0.29 NRS=0.29 SA=0 SB=0 SD=0 MULT=2 M=2
Rpar_s1_XX2_M8_s s1r_XX2_M8_s x2_net1 1069.06
Rpar_s1_XX2_M8_g s1r_XX2_M8_g Vref 92.9688
Rpar_s1_XX2_M8_d s1r_XX2_M8_d x2_Vout 282.09
XX2_M5 s1r_XX2_M5_d s1r_XX2_M5_g s1r_XX2_M5_s Vss sky130_fd_pr__nfet_01v8_lvt L=20 W=0.5 NF=1 AD=0.145 AS=0.145 PD=1.58 PS=1.58 NRD=0.58 NRS=0.58 SA=0 SB=0 SD=0 MULT=2 M=2
Rpar_s1_XX2_M5_s s1r_XX2_M5_s Vss 1080.08
Rpar_s1_XX2_M5_g s1r_XX2_M5_g x2_Vtest 122.747
Rpar_s1_XX2_M5_d s1r_XX2_M5_d x2_Vtest 1080.08
XX2_M6 s1r_XX2_M6_d s1r_XX2_M6_g s1r_XX2_M6_s Vss sky130_fd_pr__nfet_01v8_lvt L=20 W=0.5 NF=1 AD=0.145 AS=0.145 PD=1.58 PS=1.58 NRD=0.58 NRS=0.58 SA=0 SB=0 SD=0 MULT=2 M=2
Rpar_s1_XX2_M6_s s1r_XX2_M6_s Vss 1080.08
Rpar_s1_XX2_M6_g s1r_XX2_M6_g x2_Vtest 122.747
Rpar_s1_XX2_M6_d s1r_XX2_M6_d x2_Vout 1080.08
XX2_M10 s1r_XX2_M10_d s1r_XX2_M10_g s1r_XX2_M10_s Vss sky130_fd_pr__nfet_01v8_lvt L=1 W=0.6 NF=1 AD=0.174 AS=0.174 PD=1.78 PS=1.78 NRD=0.483333 NRS=0.483333 SA=0 SB=0 SD=0 MULT=2 M=2
Rpar_s1_XX2_M10_s s1r_XX2_M10_s Vss 997.939
Rpar_s1_XX2_M10_g s1r_XX2_M10_g net7 244.604
Rpar_s1_XX2_M10_d s1r_XX2_M10_d net7 997.938
XX2_M11 s1r_XX2_M11_d s1r_XX2_M11_g s1r_XX2_M11_s Vss sky130_fd_pr__nfet_01v8_lvt L=1 W=0.6 NF=1 AD=0.174 AS=0.174 PD=1.78 PS=1.78 NRD=0.483333 NRS=0.483333 SA=0 SB=0 SD=0 MULT=2 M=2
Rpar_s1_XX2_M11_s s1r_XX2_M11_s Vss 997.939
Rpar_s1_XX2_M11_g s1r_XX2_M11_g net7 244.604
Rpar_s1_XX2_M11_d s1r_XX2_M11_d x2_Vbiasp 997.938
XX2_M12 s1r_XX2_M12_d x2_Vbiasp s1r_XX2_M12_s Vdd sky130_fd_pr__pfet_01v8_lvt L=1 W=6 NF=1 AD=1.74 AS=1.74 PD=12.58 PS=12.58 NRD=0.0483333 NRS=0.0483333 SA=0 SB=0 SD=0 MULT=2 M=2
Rpar_s1_XX2_M12_s s1r_XX2_M12_s Vdd 261.268
Rpar_s1_XX2_M12_d s1r_XX2_M12_d x2_Vbiasp 261.268
Vref_ext Vref Vss 0.9
XC1 Vop1 Vom sky130_fd_pr__cap_mim_m3_1 W=10 L=10 MF=5 M=5
XC2 Vom1 Vop sky130_fd_pr__cap_mim_m3_1 W=10 L=10 MF=5 M=5
XX2_X1_R1 x2_x1_net4 Vop sky130_fd_pr__res_generic_po W=0.5 L=40
XX2_X1_R2 x2_x1_net5 x2_x1_net4 sky130_fd_pr__res_generic_po W=0.5 L=40
XX2_X1_R3 x2_x1_net6 x2_x1_net5 sky130_fd_pr__res_generic_po W=0.5 L=40
XX2_X1_R4 x2_x1_net7 x2_x1_net6 sky130_fd_pr__res_generic_po W=0.5 L=40
XX2_X1_R5 x2_x1_net1 x2_x1_net7 sky130_fd_pr__res_generic_po W=0.5 L=40
XX2_X1_R6 x2_x1_net8 x2_x1_net2 sky130_fd_pr__res_generic_po W=0.5 L=40
XX2_X1_R7 x2_x1_net9 x2_x1_net8 sky130_fd_pr__res_generic_po W=0.5 L=40
XX2_X1_R8 x2_x1_net10 x2_x1_net9 sky130_fd_pr__res_generic_po W=0.5 L=40
XX2_X1_R9 x2_x1_net11 x2_x1_net10 sky130_fd_pr__res_generic_po W=0.5 L=40
XX2_X1_R10 x2_x1_net1 x2_x1_net11 sky130_fd_pr__res_generic_po W=0.5 L=40
XX2_X1_R11 x2_x1_net12 x2_x1_net2 sky130_fd_pr__res_generic_po W=0.5 L=40
XX2_X1_R12 x2_x1_net13 x2_x1_net12 sky130_fd_pr__res_generic_po W=0.5 L=40
XX2_X1_R13 x2_x1_net14 x2_x1_net13 sky130_fd_pr__res_generic_po W=0.5 L=40
XX2_X1_R14 x2_x1_net15 x2_x1_net14 sky130_fd_pr__res_generic_po W=0.5 L=40
XX2_X1_R16 x2_x1_net16 x2_Vcm sky130_fd_pr__res_generic_po W=0.5 L=40
XX2_X1_R17 x2_x1_net17 x2_x1_net16 sky130_fd_pr__res_generic_po W=0.5 L=40
XX2_X1_R18 x2_x1_net18 x2_x1_net17 sky130_fd_pr__res_generic_po W=0.5 L=40
XX2_X1_R19 x2_x1_net19 x2_x1_net18 sky130_fd_pr__res_generic_po W=0.5 L=40
XX2_X1_R20 x2_x1_net3 x2_x1_net19 sky130_fd_pr__res_generic_po W=0.5 L=40
XX2_X1_R15 x2_x1_net3 x2_x1_net15 sky130_fd_pr__res_generic_po W=0.5 L=40
XX2_X2_R1 x2_x2_net4 x2_Vcm sky130_fd_pr__res_generic_po W=0.5 L=40
XX2_X2_R2 x2_x2_net5 x2_x2_net4 sky130_fd_pr__res_generic_po W=0.5 L=40
XX2_X2_R3 x2_x2_net6 x2_x2_net5 sky130_fd_pr__res_generic_po W=0.5 L=40
XX2_X2_R4 x2_x2_net7 x2_x2_net6 sky130_fd_pr__res_generic_po W=0.5 L=40
XX2_X2_R5 x2_x2_net1 x2_x2_net7 sky130_fd_pr__res_generic_po W=0.5 L=40
XX2_X2_R6 x2_x2_net8 x2_x2_net2 sky130_fd_pr__res_generic_po W=0.5 L=40
XX2_X2_R7 x2_x2_net9 x2_x2_net8 sky130_fd_pr__res_generic_po W=0.5 L=40
XX2_X2_R8 x2_x2_net10 x2_x2_net9 sky130_fd_pr__res_generic_po W=0.5 L=40
XX2_X2_R9 x2_x2_net11 x2_x2_net10 sky130_fd_pr__res_generic_po W=0.5 L=40
XX2_X2_R10 x2_x2_net1 x2_x2_net11 sky130_fd_pr__res_generic_po W=0.5 L=40
XX2_X2_R11 x2_x2_net12 x2_x2_net2 sky130_fd_pr__res_generic_po W=0.5 L=40
XX2_X2_R12 x2_x2_net13 x2_x2_net12 sky130_fd_pr__res_generic_po W=0.5 L=40
XX2_X2_R13 x2_x2_net14 x2_x2_net13 sky130_fd_pr__res_generic_po W=0.5 L=40
XX2_X2_R14 x2_x2_net15 x2_x2_net14 sky130_fd_pr__res_generic_po W=0.5 L=40
XX2_X2_R16 x2_x2_net16 Vom sky130_fd_pr__res_generic_po W=0.5 L=40
XX2_X2_R17 x2_x2_net17 x2_x2_net16 sky130_fd_pr__res_generic_po W=0.5 L=40
XX2_X2_R18 x2_x2_net18 x2_x2_net17 sky130_fd_pr__res_generic_po W=0.5 L=40
XX2_X2_R19 x2_x2_net19 x2_x2_net18 sky130_fd_pr__res_generic_po W=0.5 L=40
XX2_X2_R20 x2_x2_net3 x2_x2_net19 sky130_fd_pr__res_generic_po W=0.5 L=40
XX2_X2_R15 x2_x2_net3 x2_x2_net15 sky130_fd_pr__res_generic_po W=0.5 L=40
Rgm_ext Rgm Vss 12000
.ends ttsky25a_fd
.end
