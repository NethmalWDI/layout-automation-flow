* ttsky25a_fd on dido_amp_OP
.lib $PDK_ROOT/sky130A/libs.tech/combined/sky130.lib.spice tt
.param VDD_V=1.8 VCM_V=0.9 CL_F=529f
.temp 27

**.subckt dido_amp_OP
x1 INP INN OUTN VDD 0 OUTP dut_amp
Vsup VDD 0 'VDD_V'
* AC drive through 1 F couplers; DC set by unity feedback through 1 GH chokes (OUTP->INN, OUTN->INP)
Vacp ACP 0 dc 0 ac 0
Vacn ACN 0 dc 0 ac 0
Cinp ACP INP 1
Cinn ACN INN 1
Lfbp OUTP INN 1G
Lfbn OUTN INP 1G
Cloadp OUTP 0 'CL_F'
Cloadn OUTN 0 'CL_F'
.control
set numdgt=12
op
let s1_xm32_id = @m.x1.xdut.xm32.msky130_fd_pr__pfet_01v8_lvt[id]
echo OPV XM32 id $&s1_xm32_id
let s1_xm32_vgs = @m.x1.xdut.xm32.msky130_fd_pr__pfet_01v8_lvt[vgs]
echo OPV XM32 vgs $&s1_xm32_vgs
let s1_xm32_vds = @m.x1.xdut.xm32.msky130_fd_pr__pfet_01v8_lvt[vds]
echo OPV XM32 vds $&s1_xm32_vds
let s1_xm32_vbs = @m.x1.xdut.xm32.msky130_fd_pr__pfet_01v8_lvt[vbs]
echo OPV XM32 vbs $&s1_xm32_vbs
let s1_xm32_vth = @m.x1.xdut.xm32.msky130_fd_pr__pfet_01v8_lvt[vth]
echo OPV XM32 vth $&s1_xm32_vth
let s1_xm32_vdsat = @m.x1.xdut.xm32.msky130_fd_pr__pfet_01v8_lvt[vdsat]
echo OPV XM32 vdsat $&s1_xm32_vdsat
let s1_xm32_gm = @m.x1.xdut.xm32.msky130_fd_pr__pfet_01v8_lvt[gm]
echo OPV XM32 gm $&s1_xm32_gm
let s1_xm32_gds = @m.x1.xdut.xm32.msky130_fd_pr__pfet_01v8_lvt[gds]
echo OPV XM32 gds $&s1_xm32_gds
let s1_xm32_gmbs = @m.x1.xdut.xm32.msky130_fd_pr__pfet_01v8_lvt[gmbs]
echo OPV XM32 gmbs $&s1_xm32_gmbs
let s1_xm32_cgg = @m.x1.xdut.xm32.msky130_fd_pr__pfet_01v8_lvt[cgg]
echo OPV XM32 cgg $&s1_xm32_cgg
let s1_xm32_cgd = @m.x1.xdut.xm32.msky130_fd_pr__pfet_01v8_lvt[cgd]
echo OPV XM32 cgd $&s1_xm32_cgd
let s1_xm32_cgs = @m.x1.xdut.xm32.msky130_fd_pr__pfet_01v8_lvt[cgs]
echo OPV XM32 cgs $&s1_xm32_cgs
let s1_xm32_cgb = @m.x1.xdut.xm32.msky130_fd_pr__pfet_01v8_lvt[cgb]
echo OPV XM32 cgb $&s1_xm32_cgb
let s1_xm32_cdg = @m.x1.xdut.xm32.msky130_fd_pr__pfet_01v8_lvt[cdg]
echo OPV XM32 cdg $&s1_xm32_cdg
let s1_xm32_cdd = @m.x1.xdut.xm32.msky130_fd_pr__pfet_01v8_lvt[cdd]
echo OPV XM32 cdd $&s1_xm32_cdd
let s1_xm32_cds = @m.x1.xdut.xm32.msky130_fd_pr__pfet_01v8_lvt[cds]
echo OPV XM32 cds $&s1_xm32_cds
let s1_xm32_cdb = @m.x1.xdut.xm32.msky130_fd_pr__pfet_01v8_lvt[cdb]
echo OPV XM32 cdb $&s1_xm32_cdb
let s1_xm32_csg = @m.x1.xdut.xm32.msky130_fd_pr__pfet_01v8_lvt[csg]
echo OPV XM32 csg $&s1_xm32_csg
let s1_xm32_csd = @m.x1.xdut.xm32.msky130_fd_pr__pfet_01v8_lvt[csd]
echo OPV XM32 csd $&s1_xm32_csd
let s1_xm32_css = @m.x1.xdut.xm32.msky130_fd_pr__pfet_01v8_lvt[css]
echo OPV XM32 css $&s1_xm32_css
let s1_xm32_csb = @m.x1.xdut.xm32.msky130_fd_pr__pfet_01v8_lvt[csb]
echo OPV XM32 csb $&s1_xm32_csb
let s1_xm32_cbg = @m.x1.xdut.xm32.msky130_fd_pr__pfet_01v8_lvt[cbg]
echo OPV XM32 cbg $&s1_xm32_cbg
let s1_xm32_cbd = @m.x1.xdut.xm32.msky130_fd_pr__pfet_01v8_lvt[cbd]
echo OPV XM32 cbd $&s1_xm32_cbd
let s1_xm32_cbs = @m.x1.xdut.xm32.msky130_fd_pr__pfet_01v8_lvt[cbs]
echo OPV XM32 cbs $&s1_xm32_cbs
let s1_xm32_cbb = @m.x1.xdut.xm32.msky130_fd_pr__pfet_01v8_lvt[cbb]
echo OPV XM32 cbb $&s1_xm32_cbb
let s1_xm32_capbd = @m.x1.xdut.xm32.msky130_fd_pr__pfet_01v8_lvt[capbd]
echo OPV XM32 capbd $&s1_xm32_capbd
let s1_xm32_capbs = @m.x1.xdut.xm32.msky130_fd_pr__pfet_01v8_lvt[capbs]
echo OPV XM32 capbs $&s1_xm32_capbs
let s1_xm32_cgso = @m.x1.xdut.xm32.msky130_fd_pr__pfet_01v8_lvt[cgso]
echo OPV XM32 cgso $&s1_xm32_cgso
let s1_xm32_cgdo = @m.x1.xdut.xm32.msky130_fd_pr__pfet_01v8_lvt[cgdo]
echo OPV XM32 cgdo $&s1_xm32_cgdo
let s1_xm32_cgbo = @m.x1.xdut.xm32.msky130_fd_pr__pfet_01v8_lvt[cgbo]
echo OPV XM32 cgbo $&s1_xm32_cgbo
let s1_xm32_weff = @m.x1.xdut.xm32.msky130_fd_pr__pfet_01v8_lvt[weff]
echo OPV XM32 weff $&s1_xm32_weff
let s1_xm32_leff = @m.x1.xdut.xm32.msky130_fd_pr__pfet_01v8_lvt[leff]
echo OPV XM32 leff $&s1_xm32_leff
let s1_xm33_id = @m.x1.xdut.xm33.msky130_fd_pr__nfet_01v8_lvt[id]
echo OPV XM33 id $&s1_xm33_id
let s1_xm33_vgs = @m.x1.xdut.xm33.msky130_fd_pr__nfet_01v8_lvt[vgs]
echo OPV XM33 vgs $&s1_xm33_vgs
let s1_xm33_vds = @m.x1.xdut.xm33.msky130_fd_pr__nfet_01v8_lvt[vds]
echo OPV XM33 vds $&s1_xm33_vds
let s1_xm33_vbs = @m.x1.xdut.xm33.msky130_fd_pr__nfet_01v8_lvt[vbs]
echo OPV XM33 vbs $&s1_xm33_vbs
let s1_xm33_vth = @m.x1.xdut.xm33.msky130_fd_pr__nfet_01v8_lvt[vth]
echo OPV XM33 vth $&s1_xm33_vth
let s1_xm33_vdsat = @m.x1.xdut.xm33.msky130_fd_pr__nfet_01v8_lvt[vdsat]
echo OPV XM33 vdsat $&s1_xm33_vdsat
let s1_xm33_gm = @m.x1.xdut.xm33.msky130_fd_pr__nfet_01v8_lvt[gm]
echo OPV XM33 gm $&s1_xm33_gm
let s1_xm33_gds = @m.x1.xdut.xm33.msky130_fd_pr__nfet_01v8_lvt[gds]
echo OPV XM33 gds $&s1_xm33_gds
let s1_xm33_gmbs = @m.x1.xdut.xm33.msky130_fd_pr__nfet_01v8_lvt[gmbs]
echo OPV XM33 gmbs $&s1_xm33_gmbs
let s1_xm33_cgg = @m.x1.xdut.xm33.msky130_fd_pr__nfet_01v8_lvt[cgg]
echo OPV XM33 cgg $&s1_xm33_cgg
let s1_xm33_cgd = @m.x1.xdut.xm33.msky130_fd_pr__nfet_01v8_lvt[cgd]
echo OPV XM33 cgd $&s1_xm33_cgd
let s1_xm33_cgs = @m.x1.xdut.xm33.msky130_fd_pr__nfet_01v8_lvt[cgs]
echo OPV XM33 cgs $&s1_xm33_cgs
let s1_xm33_cgb = @m.x1.xdut.xm33.msky130_fd_pr__nfet_01v8_lvt[cgb]
echo OPV XM33 cgb $&s1_xm33_cgb
let s1_xm33_cdg = @m.x1.xdut.xm33.msky130_fd_pr__nfet_01v8_lvt[cdg]
echo OPV XM33 cdg $&s1_xm33_cdg
let s1_xm33_cdd = @m.x1.xdut.xm33.msky130_fd_pr__nfet_01v8_lvt[cdd]
echo OPV XM33 cdd $&s1_xm33_cdd
let s1_xm33_cds = @m.x1.xdut.xm33.msky130_fd_pr__nfet_01v8_lvt[cds]
echo OPV XM33 cds $&s1_xm33_cds
let s1_xm33_cdb = @m.x1.xdut.xm33.msky130_fd_pr__nfet_01v8_lvt[cdb]
echo OPV XM33 cdb $&s1_xm33_cdb
let s1_xm33_csg = @m.x1.xdut.xm33.msky130_fd_pr__nfet_01v8_lvt[csg]
echo OPV XM33 csg $&s1_xm33_csg
let s1_xm33_csd = @m.x1.xdut.xm33.msky130_fd_pr__nfet_01v8_lvt[csd]
echo OPV XM33 csd $&s1_xm33_csd
let s1_xm33_css = @m.x1.xdut.xm33.msky130_fd_pr__nfet_01v8_lvt[css]
echo OPV XM33 css $&s1_xm33_css
let s1_xm33_csb = @m.x1.xdut.xm33.msky130_fd_pr__nfet_01v8_lvt[csb]
echo OPV XM33 csb $&s1_xm33_csb
let s1_xm33_cbg = @m.x1.xdut.xm33.msky130_fd_pr__nfet_01v8_lvt[cbg]
echo OPV XM33 cbg $&s1_xm33_cbg
let s1_xm33_cbd = @m.x1.xdut.xm33.msky130_fd_pr__nfet_01v8_lvt[cbd]
echo OPV XM33 cbd $&s1_xm33_cbd
let s1_xm33_cbs = @m.x1.xdut.xm33.msky130_fd_pr__nfet_01v8_lvt[cbs]
echo OPV XM33 cbs $&s1_xm33_cbs
let s1_xm33_cbb = @m.x1.xdut.xm33.msky130_fd_pr__nfet_01v8_lvt[cbb]
echo OPV XM33 cbb $&s1_xm33_cbb
let s1_xm33_capbd = @m.x1.xdut.xm33.msky130_fd_pr__nfet_01v8_lvt[capbd]
echo OPV XM33 capbd $&s1_xm33_capbd
let s1_xm33_capbs = @m.x1.xdut.xm33.msky130_fd_pr__nfet_01v8_lvt[capbs]
echo OPV XM33 capbs $&s1_xm33_capbs
let s1_xm33_cgso = @m.x1.xdut.xm33.msky130_fd_pr__nfet_01v8_lvt[cgso]
echo OPV XM33 cgso $&s1_xm33_cgso
let s1_xm33_cgdo = @m.x1.xdut.xm33.msky130_fd_pr__nfet_01v8_lvt[cgdo]
echo OPV XM33 cgdo $&s1_xm33_cgdo
let s1_xm33_cgbo = @m.x1.xdut.xm33.msky130_fd_pr__nfet_01v8_lvt[cgbo]
echo OPV XM33 cgbo $&s1_xm33_cgbo
let s1_xm33_weff = @m.x1.xdut.xm33.msky130_fd_pr__nfet_01v8_lvt[weff]
echo OPV XM33 weff $&s1_xm33_weff
let s1_xm33_leff = @m.x1.xdut.xm33.msky130_fd_pr__nfet_01v8_lvt[leff]
echo OPV XM33 leff $&s1_xm33_leff
let s1_xm34_id = @m.x1.xdut.xm34.msky130_fd_pr__pfet_01v8_lvt[id]
echo OPV XM34 id $&s1_xm34_id
let s1_xm34_vgs = @m.x1.xdut.xm34.msky130_fd_pr__pfet_01v8_lvt[vgs]
echo OPV XM34 vgs $&s1_xm34_vgs
let s1_xm34_vds = @m.x1.xdut.xm34.msky130_fd_pr__pfet_01v8_lvt[vds]
echo OPV XM34 vds $&s1_xm34_vds
let s1_xm34_vbs = @m.x1.xdut.xm34.msky130_fd_pr__pfet_01v8_lvt[vbs]
echo OPV XM34 vbs $&s1_xm34_vbs
let s1_xm34_vth = @m.x1.xdut.xm34.msky130_fd_pr__pfet_01v8_lvt[vth]
echo OPV XM34 vth $&s1_xm34_vth
let s1_xm34_vdsat = @m.x1.xdut.xm34.msky130_fd_pr__pfet_01v8_lvt[vdsat]
echo OPV XM34 vdsat $&s1_xm34_vdsat
let s1_xm34_gm = @m.x1.xdut.xm34.msky130_fd_pr__pfet_01v8_lvt[gm]
echo OPV XM34 gm $&s1_xm34_gm
let s1_xm34_gds = @m.x1.xdut.xm34.msky130_fd_pr__pfet_01v8_lvt[gds]
echo OPV XM34 gds $&s1_xm34_gds
let s1_xm34_gmbs = @m.x1.xdut.xm34.msky130_fd_pr__pfet_01v8_lvt[gmbs]
echo OPV XM34 gmbs $&s1_xm34_gmbs
let s1_xm34_cgg = @m.x1.xdut.xm34.msky130_fd_pr__pfet_01v8_lvt[cgg]
echo OPV XM34 cgg $&s1_xm34_cgg
let s1_xm34_cgd = @m.x1.xdut.xm34.msky130_fd_pr__pfet_01v8_lvt[cgd]
echo OPV XM34 cgd $&s1_xm34_cgd
let s1_xm34_cgs = @m.x1.xdut.xm34.msky130_fd_pr__pfet_01v8_lvt[cgs]
echo OPV XM34 cgs $&s1_xm34_cgs
let s1_xm34_cgb = @m.x1.xdut.xm34.msky130_fd_pr__pfet_01v8_lvt[cgb]
echo OPV XM34 cgb $&s1_xm34_cgb
let s1_xm34_cdg = @m.x1.xdut.xm34.msky130_fd_pr__pfet_01v8_lvt[cdg]
echo OPV XM34 cdg $&s1_xm34_cdg
let s1_xm34_cdd = @m.x1.xdut.xm34.msky130_fd_pr__pfet_01v8_lvt[cdd]
echo OPV XM34 cdd $&s1_xm34_cdd
let s1_xm34_cds = @m.x1.xdut.xm34.msky130_fd_pr__pfet_01v8_lvt[cds]
echo OPV XM34 cds $&s1_xm34_cds
let s1_xm34_cdb = @m.x1.xdut.xm34.msky130_fd_pr__pfet_01v8_lvt[cdb]
echo OPV XM34 cdb $&s1_xm34_cdb
let s1_xm34_csg = @m.x1.xdut.xm34.msky130_fd_pr__pfet_01v8_lvt[csg]
echo OPV XM34 csg $&s1_xm34_csg
let s1_xm34_csd = @m.x1.xdut.xm34.msky130_fd_pr__pfet_01v8_lvt[csd]
echo OPV XM34 csd $&s1_xm34_csd
let s1_xm34_css = @m.x1.xdut.xm34.msky130_fd_pr__pfet_01v8_lvt[css]
echo OPV XM34 css $&s1_xm34_css
let s1_xm34_csb = @m.x1.xdut.xm34.msky130_fd_pr__pfet_01v8_lvt[csb]
echo OPV XM34 csb $&s1_xm34_csb
let s1_xm34_cbg = @m.x1.xdut.xm34.msky130_fd_pr__pfet_01v8_lvt[cbg]
echo OPV XM34 cbg $&s1_xm34_cbg
let s1_xm34_cbd = @m.x1.xdut.xm34.msky130_fd_pr__pfet_01v8_lvt[cbd]
echo OPV XM34 cbd $&s1_xm34_cbd
let s1_xm34_cbs = @m.x1.xdut.xm34.msky130_fd_pr__pfet_01v8_lvt[cbs]
echo OPV XM34 cbs $&s1_xm34_cbs
let s1_xm34_cbb = @m.x1.xdut.xm34.msky130_fd_pr__pfet_01v8_lvt[cbb]
echo OPV XM34 cbb $&s1_xm34_cbb
let s1_xm34_capbd = @m.x1.xdut.xm34.msky130_fd_pr__pfet_01v8_lvt[capbd]
echo OPV XM34 capbd $&s1_xm34_capbd
let s1_xm34_capbs = @m.x1.xdut.xm34.msky130_fd_pr__pfet_01v8_lvt[capbs]
echo OPV XM34 capbs $&s1_xm34_capbs
let s1_xm34_cgso = @m.x1.xdut.xm34.msky130_fd_pr__pfet_01v8_lvt[cgso]
echo OPV XM34 cgso $&s1_xm34_cgso
let s1_xm34_cgdo = @m.x1.xdut.xm34.msky130_fd_pr__pfet_01v8_lvt[cgdo]
echo OPV XM34 cgdo $&s1_xm34_cgdo
let s1_xm34_cgbo = @m.x1.xdut.xm34.msky130_fd_pr__pfet_01v8_lvt[cgbo]
echo OPV XM34 cgbo $&s1_xm34_cgbo
let s1_xm34_weff = @m.x1.xdut.xm34.msky130_fd_pr__pfet_01v8_lvt[weff]
echo OPV XM34 weff $&s1_xm34_weff
let s1_xm34_leff = @m.x1.xdut.xm34.msky130_fd_pr__pfet_01v8_lvt[leff]
echo OPV XM34 leff $&s1_xm34_leff
let s1_xm35_id = @m.x1.xdut.xm35.msky130_fd_pr__nfet_01v8_lvt[id]
echo OPV XM35 id $&s1_xm35_id
let s1_xm35_vgs = @m.x1.xdut.xm35.msky130_fd_pr__nfet_01v8_lvt[vgs]
echo OPV XM35 vgs $&s1_xm35_vgs
let s1_xm35_vds = @m.x1.xdut.xm35.msky130_fd_pr__nfet_01v8_lvt[vds]
echo OPV XM35 vds $&s1_xm35_vds
let s1_xm35_vbs = @m.x1.xdut.xm35.msky130_fd_pr__nfet_01v8_lvt[vbs]
echo OPV XM35 vbs $&s1_xm35_vbs
let s1_xm35_vth = @m.x1.xdut.xm35.msky130_fd_pr__nfet_01v8_lvt[vth]
echo OPV XM35 vth $&s1_xm35_vth
let s1_xm35_vdsat = @m.x1.xdut.xm35.msky130_fd_pr__nfet_01v8_lvt[vdsat]
echo OPV XM35 vdsat $&s1_xm35_vdsat
let s1_xm35_gm = @m.x1.xdut.xm35.msky130_fd_pr__nfet_01v8_lvt[gm]
echo OPV XM35 gm $&s1_xm35_gm
let s1_xm35_gds = @m.x1.xdut.xm35.msky130_fd_pr__nfet_01v8_lvt[gds]
echo OPV XM35 gds $&s1_xm35_gds
let s1_xm35_gmbs = @m.x1.xdut.xm35.msky130_fd_pr__nfet_01v8_lvt[gmbs]
echo OPV XM35 gmbs $&s1_xm35_gmbs
let s1_xm35_cgg = @m.x1.xdut.xm35.msky130_fd_pr__nfet_01v8_lvt[cgg]
echo OPV XM35 cgg $&s1_xm35_cgg
let s1_xm35_cgd = @m.x1.xdut.xm35.msky130_fd_pr__nfet_01v8_lvt[cgd]
echo OPV XM35 cgd $&s1_xm35_cgd
let s1_xm35_cgs = @m.x1.xdut.xm35.msky130_fd_pr__nfet_01v8_lvt[cgs]
echo OPV XM35 cgs $&s1_xm35_cgs
let s1_xm35_cgb = @m.x1.xdut.xm35.msky130_fd_pr__nfet_01v8_lvt[cgb]
echo OPV XM35 cgb $&s1_xm35_cgb
let s1_xm35_cdg = @m.x1.xdut.xm35.msky130_fd_pr__nfet_01v8_lvt[cdg]
echo OPV XM35 cdg $&s1_xm35_cdg
let s1_xm35_cdd = @m.x1.xdut.xm35.msky130_fd_pr__nfet_01v8_lvt[cdd]
echo OPV XM35 cdd $&s1_xm35_cdd
let s1_xm35_cds = @m.x1.xdut.xm35.msky130_fd_pr__nfet_01v8_lvt[cds]
echo OPV XM35 cds $&s1_xm35_cds
let s1_xm35_cdb = @m.x1.xdut.xm35.msky130_fd_pr__nfet_01v8_lvt[cdb]
echo OPV XM35 cdb $&s1_xm35_cdb
let s1_xm35_csg = @m.x1.xdut.xm35.msky130_fd_pr__nfet_01v8_lvt[csg]
echo OPV XM35 csg $&s1_xm35_csg
let s1_xm35_csd = @m.x1.xdut.xm35.msky130_fd_pr__nfet_01v8_lvt[csd]
echo OPV XM35 csd $&s1_xm35_csd
let s1_xm35_css = @m.x1.xdut.xm35.msky130_fd_pr__nfet_01v8_lvt[css]
echo OPV XM35 css $&s1_xm35_css
let s1_xm35_csb = @m.x1.xdut.xm35.msky130_fd_pr__nfet_01v8_lvt[csb]
echo OPV XM35 csb $&s1_xm35_csb
let s1_xm35_cbg = @m.x1.xdut.xm35.msky130_fd_pr__nfet_01v8_lvt[cbg]
echo OPV XM35 cbg $&s1_xm35_cbg
let s1_xm35_cbd = @m.x1.xdut.xm35.msky130_fd_pr__nfet_01v8_lvt[cbd]
echo OPV XM35 cbd $&s1_xm35_cbd
let s1_xm35_cbs = @m.x1.xdut.xm35.msky130_fd_pr__nfet_01v8_lvt[cbs]
echo OPV XM35 cbs $&s1_xm35_cbs
let s1_xm35_cbb = @m.x1.xdut.xm35.msky130_fd_pr__nfet_01v8_lvt[cbb]
echo OPV XM35 cbb $&s1_xm35_cbb
let s1_xm35_capbd = @m.x1.xdut.xm35.msky130_fd_pr__nfet_01v8_lvt[capbd]
echo OPV XM35 capbd $&s1_xm35_capbd
let s1_xm35_capbs = @m.x1.xdut.xm35.msky130_fd_pr__nfet_01v8_lvt[capbs]
echo OPV XM35 capbs $&s1_xm35_capbs
let s1_xm35_cgso = @m.x1.xdut.xm35.msky130_fd_pr__nfet_01v8_lvt[cgso]
echo OPV XM35 cgso $&s1_xm35_cgso
let s1_xm35_cgdo = @m.x1.xdut.xm35.msky130_fd_pr__nfet_01v8_lvt[cgdo]
echo OPV XM35 cgdo $&s1_xm35_cgdo
let s1_xm35_cgbo = @m.x1.xdut.xm35.msky130_fd_pr__nfet_01v8_lvt[cgbo]
echo OPV XM35 cgbo $&s1_xm35_cgbo
let s1_xm35_weff = @m.x1.xdut.xm35.msky130_fd_pr__nfet_01v8_lvt[weff]
echo OPV XM35 weff $&s1_xm35_weff
let s1_xm35_leff = @m.x1.xdut.xm35.msky130_fd_pr__nfet_01v8_lvt[leff]
echo OPV XM35 leff $&s1_xm35_leff
let s1_xm36_id = @m.x1.xdut.xm36.msky130_fd_pr__nfet_01v8_lvt[id]
echo OPV XM36 id $&s1_xm36_id
let s1_xm36_vgs = @m.x1.xdut.xm36.msky130_fd_pr__nfet_01v8_lvt[vgs]
echo OPV XM36 vgs $&s1_xm36_vgs
let s1_xm36_vds = @m.x1.xdut.xm36.msky130_fd_pr__nfet_01v8_lvt[vds]
echo OPV XM36 vds $&s1_xm36_vds
let s1_xm36_vbs = @m.x1.xdut.xm36.msky130_fd_pr__nfet_01v8_lvt[vbs]
echo OPV XM36 vbs $&s1_xm36_vbs
let s1_xm36_vth = @m.x1.xdut.xm36.msky130_fd_pr__nfet_01v8_lvt[vth]
echo OPV XM36 vth $&s1_xm36_vth
let s1_xm36_vdsat = @m.x1.xdut.xm36.msky130_fd_pr__nfet_01v8_lvt[vdsat]
echo OPV XM36 vdsat $&s1_xm36_vdsat
let s1_xm36_gm = @m.x1.xdut.xm36.msky130_fd_pr__nfet_01v8_lvt[gm]
echo OPV XM36 gm $&s1_xm36_gm
let s1_xm36_gds = @m.x1.xdut.xm36.msky130_fd_pr__nfet_01v8_lvt[gds]
echo OPV XM36 gds $&s1_xm36_gds
let s1_xm36_gmbs = @m.x1.xdut.xm36.msky130_fd_pr__nfet_01v8_lvt[gmbs]
echo OPV XM36 gmbs $&s1_xm36_gmbs
let s1_xm36_cgg = @m.x1.xdut.xm36.msky130_fd_pr__nfet_01v8_lvt[cgg]
echo OPV XM36 cgg $&s1_xm36_cgg
let s1_xm36_cgd = @m.x1.xdut.xm36.msky130_fd_pr__nfet_01v8_lvt[cgd]
echo OPV XM36 cgd $&s1_xm36_cgd
let s1_xm36_cgs = @m.x1.xdut.xm36.msky130_fd_pr__nfet_01v8_lvt[cgs]
echo OPV XM36 cgs $&s1_xm36_cgs
let s1_xm36_cgb = @m.x1.xdut.xm36.msky130_fd_pr__nfet_01v8_lvt[cgb]
echo OPV XM36 cgb $&s1_xm36_cgb
let s1_xm36_cdg = @m.x1.xdut.xm36.msky130_fd_pr__nfet_01v8_lvt[cdg]
echo OPV XM36 cdg $&s1_xm36_cdg
let s1_xm36_cdd = @m.x1.xdut.xm36.msky130_fd_pr__nfet_01v8_lvt[cdd]
echo OPV XM36 cdd $&s1_xm36_cdd
let s1_xm36_cds = @m.x1.xdut.xm36.msky130_fd_pr__nfet_01v8_lvt[cds]
echo OPV XM36 cds $&s1_xm36_cds
let s1_xm36_cdb = @m.x1.xdut.xm36.msky130_fd_pr__nfet_01v8_lvt[cdb]
echo OPV XM36 cdb $&s1_xm36_cdb
let s1_xm36_csg = @m.x1.xdut.xm36.msky130_fd_pr__nfet_01v8_lvt[csg]
echo OPV XM36 csg $&s1_xm36_csg
let s1_xm36_csd = @m.x1.xdut.xm36.msky130_fd_pr__nfet_01v8_lvt[csd]
echo OPV XM36 csd $&s1_xm36_csd
let s1_xm36_css = @m.x1.xdut.xm36.msky130_fd_pr__nfet_01v8_lvt[css]
echo OPV XM36 css $&s1_xm36_css
let s1_xm36_csb = @m.x1.xdut.xm36.msky130_fd_pr__nfet_01v8_lvt[csb]
echo OPV XM36 csb $&s1_xm36_csb
let s1_xm36_cbg = @m.x1.xdut.xm36.msky130_fd_pr__nfet_01v8_lvt[cbg]
echo OPV XM36 cbg $&s1_xm36_cbg
let s1_xm36_cbd = @m.x1.xdut.xm36.msky130_fd_pr__nfet_01v8_lvt[cbd]
echo OPV XM36 cbd $&s1_xm36_cbd
let s1_xm36_cbs = @m.x1.xdut.xm36.msky130_fd_pr__nfet_01v8_lvt[cbs]
echo OPV XM36 cbs $&s1_xm36_cbs
let s1_xm36_cbb = @m.x1.xdut.xm36.msky130_fd_pr__nfet_01v8_lvt[cbb]
echo OPV XM36 cbb $&s1_xm36_cbb
let s1_xm36_capbd = @m.x1.xdut.xm36.msky130_fd_pr__nfet_01v8_lvt[capbd]
echo OPV XM36 capbd $&s1_xm36_capbd
let s1_xm36_capbs = @m.x1.xdut.xm36.msky130_fd_pr__nfet_01v8_lvt[capbs]
echo OPV XM36 capbs $&s1_xm36_capbs
let s1_xm36_cgso = @m.x1.xdut.xm36.msky130_fd_pr__nfet_01v8_lvt[cgso]
echo OPV XM36 cgso $&s1_xm36_cgso
let s1_xm36_cgdo = @m.x1.xdut.xm36.msky130_fd_pr__nfet_01v8_lvt[cgdo]
echo OPV XM36 cgdo $&s1_xm36_cgdo
let s1_xm36_cgbo = @m.x1.xdut.xm36.msky130_fd_pr__nfet_01v8_lvt[cgbo]
echo OPV XM36 cgbo $&s1_xm36_cgbo
let s1_xm36_weff = @m.x1.xdut.xm36.msky130_fd_pr__nfet_01v8_lvt[weff]
echo OPV XM36 weff $&s1_xm36_weff
let s1_xm36_leff = @m.x1.xdut.xm36.msky130_fd_pr__nfet_01v8_lvt[leff]
echo OPV XM36 leff $&s1_xm36_leff
let s1_xm37_id = @m.x1.xdut.xm37.msky130_fd_pr__nfet_01v8_lvt[id]
echo OPV XM37 id $&s1_xm37_id
let s1_xm37_vgs = @m.x1.xdut.xm37.msky130_fd_pr__nfet_01v8_lvt[vgs]
echo OPV XM37 vgs $&s1_xm37_vgs
let s1_xm37_vds = @m.x1.xdut.xm37.msky130_fd_pr__nfet_01v8_lvt[vds]
echo OPV XM37 vds $&s1_xm37_vds
let s1_xm37_vbs = @m.x1.xdut.xm37.msky130_fd_pr__nfet_01v8_lvt[vbs]
echo OPV XM37 vbs $&s1_xm37_vbs
let s1_xm37_vth = @m.x1.xdut.xm37.msky130_fd_pr__nfet_01v8_lvt[vth]
echo OPV XM37 vth $&s1_xm37_vth
let s1_xm37_vdsat = @m.x1.xdut.xm37.msky130_fd_pr__nfet_01v8_lvt[vdsat]
echo OPV XM37 vdsat $&s1_xm37_vdsat
let s1_xm37_gm = @m.x1.xdut.xm37.msky130_fd_pr__nfet_01v8_lvt[gm]
echo OPV XM37 gm $&s1_xm37_gm
let s1_xm37_gds = @m.x1.xdut.xm37.msky130_fd_pr__nfet_01v8_lvt[gds]
echo OPV XM37 gds $&s1_xm37_gds
let s1_xm37_gmbs = @m.x1.xdut.xm37.msky130_fd_pr__nfet_01v8_lvt[gmbs]
echo OPV XM37 gmbs $&s1_xm37_gmbs
let s1_xm37_cgg = @m.x1.xdut.xm37.msky130_fd_pr__nfet_01v8_lvt[cgg]
echo OPV XM37 cgg $&s1_xm37_cgg
let s1_xm37_cgd = @m.x1.xdut.xm37.msky130_fd_pr__nfet_01v8_lvt[cgd]
echo OPV XM37 cgd $&s1_xm37_cgd
let s1_xm37_cgs = @m.x1.xdut.xm37.msky130_fd_pr__nfet_01v8_lvt[cgs]
echo OPV XM37 cgs $&s1_xm37_cgs
let s1_xm37_cgb = @m.x1.xdut.xm37.msky130_fd_pr__nfet_01v8_lvt[cgb]
echo OPV XM37 cgb $&s1_xm37_cgb
let s1_xm37_cdg = @m.x1.xdut.xm37.msky130_fd_pr__nfet_01v8_lvt[cdg]
echo OPV XM37 cdg $&s1_xm37_cdg
let s1_xm37_cdd = @m.x1.xdut.xm37.msky130_fd_pr__nfet_01v8_lvt[cdd]
echo OPV XM37 cdd $&s1_xm37_cdd
let s1_xm37_cds = @m.x1.xdut.xm37.msky130_fd_pr__nfet_01v8_lvt[cds]
echo OPV XM37 cds $&s1_xm37_cds
let s1_xm37_cdb = @m.x1.xdut.xm37.msky130_fd_pr__nfet_01v8_lvt[cdb]
echo OPV XM37 cdb $&s1_xm37_cdb
let s1_xm37_csg = @m.x1.xdut.xm37.msky130_fd_pr__nfet_01v8_lvt[csg]
echo OPV XM37 csg $&s1_xm37_csg
let s1_xm37_csd = @m.x1.xdut.xm37.msky130_fd_pr__nfet_01v8_lvt[csd]
echo OPV XM37 csd $&s1_xm37_csd
let s1_xm37_css = @m.x1.xdut.xm37.msky130_fd_pr__nfet_01v8_lvt[css]
echo OPV XM37 css $&s1_xm37_css
let s1_xm37_csb = @m.x1.xdut.xm37.msky130_fd_pr__nfet_01v8_lvt[csb]
echo OPV XM37 csb $&s1_xm37_csb
let s1_xm37_cbg = @m.x1.xdut.xm37.msky130_fd_pr__nfet_01v8_lvt[cbg]
echo OPV XM37 cbg $&s1_xm37_cbg
let s1_xm37_cbd = @m.x1.xdut.xm37.msky130_fd_pr__nfet_01v8_lvt[cbd]
echo OPV XM37 cbd $&s1_xm37_cbd
let s1_xm37_cbs = @m.x1.xdut.xm37.msky130_fd_pr__nfet_01v8_lvt[cbs]
echo OPV XM37 cbs $&s1_xm37_cbs
let s1_xm37_cbb = @m.x1.xdut.xm37.msky130_fd_pr__nfet_01v8_lvt[cbb]
echo OPV XM37 cbb $&s1_xm37_cbb
let s1_xm37_capbd = @m.x1.xdut.xm37.msky130_fd_pr__nfet_01v8_lvt[capbd]
echo OPV XM37 capbd $&s1_xm37_capbd
let s1_xm37_capbs = @m.x1.xdut.xm37.msky130_fd_pr__nfet_01v8_lvt[capbs]
echo OPV XM37 capbs $&s1_xm37_capbs
let s1_xm37_cgso = @m.x1.xdut.xm37.msky130_fd_pr__nfet_01v8_lvt[cgso]
echo OPV XM37 cgso $&s1_xm37_cgso
let s1_xm37_cgdo = @m.x1.xdut.xm37.msky130_fd_pr__nfet_01v8_lvt[cgdo]
echo OPV XM37 cgdo $&s1_xm37_cgdo
let s1_xm37_cgbo = @m.x1.xdut.xm37.msky130_fd_pr__nfet_01v8_lvt[cgbo]
echo OPV XM37 cgbo $&s1_xm37_cgbo
let s1_xm37_weff = @m.x1.xdut.xm37.msky130_fd_pr__nfet_01v8_lvt[weff]
echo OPV XM37 weff $&s1_xm37_weff
let s1_xm37_leff = @m.x1.xdut.xm37.msky130_fd_pr__nfet_01v8_lvt[leff]
echo OPV XM37 leff $&s1_xm37_leff
let s1_xm38_id = @m.x1.xdut.xm38.msky130_fd_pr__pfet_01v8_lvt[id]
echo OPV XM38 id $&s1_xm38_id
let s1_xm38_vgs = @m.x1.xdut.xm38.msky130_fd_pr__pfet_01v8_lvt[vgs]
echo OPV XM38 vgs $&s1_xm38_vgs
let s1_xm38_vds = @m.x1.xdut.xm38.msky130_fd_pr__pfet_01v8_lvt[vds]
echo OPV XM38 vds $&s1_xm38_vds
let s1_xm38_vbs = @m.x1.xdut.xm38.msky130_fd_pr__pfet_01v8_lvt[vbs]
echo OPV XM38 vbs $&s1_xm38_vbs
let s1_xm38_vth = @m.x1.xdut.xm38.msky130_fd_pr__pfet_01v8_lvt[vth]
echo OPV XM38 vth $&s1_xm38_vth
let s1_xm38_vdsat = @m.x1.xdut.xm38.msky130_fd_pr__pfet_01v8_lvt[vdsat]
echo OPV XM38 vdsat $&s1_xm38_vdsat
let s1_xm38_gm = @m.x1.xdut.xm38.msky130_fd_pr__pfet_01v8_lvt[gm]
echo OPV XM38 gm $&s1_xm38_gm
let s1_xm38_gds = @m.x1.xdut.xm38.msky130_fd_pr__pfet_01v8_lvt[gds]
echo OPV XM38 gds $&s1_xm38_gds
let s1_xm38_gmbs = @m.x1.xdut.xm38.msky130_fd_pr__pfet_01v8_lvt[gmbs]
echo OPV XM38 gmbs $&s1_xm38_gmbs
let s1_xm38_cgg = @m.x1.xdut.xm38.msky130_fd_pr__pfet_01v8_lvt[cgg]
echo OPV XM38 cgg $&s1_xm38_cgg
let s1_xm38_cgd = @m.x1.xdut.xm38.msky130_fd_pr__pfet_01v8_lvt[cgd]
echo OPV XM38 cgd $&s1_xm38_cgd
let s1_xm38_cgs = @m.x1.xdut.xm38.msky130_fd_pr__pfet_01v8_lvt[cgs]
echo OPV XM38 cgs $&s1_xm38_cgs
let s1_xm38_cgb = @m.x1.xdut.xm38.msky130_fd_pr__pfet_01v8_lvt[cgb]
echo OPV XM38 cgb $&s1_xm38_cgb
let s1_xm38_cdg = @m.x1.xdut.xm38.msky130_fd_pr__pfet_01v8_lvt[cdg]
echo OPV XM38 cdg $&s1_xm38_cdg
let s1_xm38_cdd = @m.x1.xdut.xm38.msky130_fd_pr__pfet_01v8_lvt[cdd]
echo OPV XM38 cdd $&s1_xm38_cdd
let s1_xm38_cds = @m.x1.xdut.xm38.msky130_fd_pr__pfet_01v8_lvt[cds]
echo OPV XM38 cds $&s1_xm38_cds
let s1_xm38_cdb = @m.x1.xdut.xm38.msky130_fd_pr__pfet_01v8_lvt[cdb]
echo OPV XM38 cdb $&s1_xm38_cdb
let s1_xm38_csg = @m.x1.xdut.xm38.msky130_fd_pr__pfet_01v8_lvt[csg]
echo OPV XM38 csg $&s1_xm38_csg
let s1_xm38_csd = @m.x1.xdut.xm38.msky130_fd_pr__pfet_01v8_lvt[csd]
echo OPV XM38 csd $&s1_xm38_csd
let s1_xm38_css = @m.x1.xdut.xm38.msky130_fd_pr__pfet_01v8_lvt[css]
echo OPV XM38 css $&s1_xm38_css
let s1_xm38_csb = @m.x1.xdut.xm38.msky130_fd_pr__pfet_01v8_lvt[csb]
echo OPV XM38 csb $&s1_xm38_csb
let s1_xm38_cbg = @m.x1.xdut.xm38.msky130_fd_pr__pfet_01v8_lvt[cbg]
echo OPV XM38 cbg $&s1_xm38_cbg
let s1_xm38_cbd = @m.x1.xdut.xm38.msky130_fd_pr__pfet_01v8_lvt[cbd]
echo OPV XM38 cbd $&s1_xm38_cbd
let s1_xm38_cbs = @m.x1.xdut.xm38.msky130_fd_pr__pfet_01v8_lvt[cbs]
echo OPV XM38 cbs $&s1_xm38_cbs
let s1_xm38_cbb = @m.x1.xdut.xm38.msky130_fd_pr__pfet_01v8_lvt[cbb]
echo OPV XM38 cbb $&s1_xm38_cbb
let s1_xm38_capbd = @m.x1.xdut.xm38.msky130_fd_pr__pfet_01v8_lvt[capbd]
echo OPV XM38 capbd $&s1_xm38_capbd
let s1_xm38_capbs = @m.x1.xdut.xm38.msky130_fd_pr__pfet_01v8_lvt[capbs]
echo OPV XM38 capbs $&s1_xm38_capbs
let s1_xm38_cgso = @m.x1.xdut.xm38.msky130_fd_pr__pfet_01v8_lvt[cgso]
echo OPV XM38 cgso $&s1_xm38_cgso
let s1_xm38_cgdo = @m.x1.xdut.xm38.msky130_fd_pr__pfet_01v8_lvt[cgdo]
echo OPV XM38 cgdo $&s1_xm38_cgdo
let s1_xm38_cgbo = @m.x1.xdut.xm38.msky130_fd_pr__pfet_01v8_lvt[cgbo]
echo OPV XM38 cgbo $&s1_xm38_cgbo
let s1_xm38_weff = @m.x1.xdut.xm38.msky130_fd_pr__pfet_01v8_lvt[weff]
echo OPV XM38 weff $&s1_xm38_weff
let s1_xm38_leff = @m.x1.xdut.xm38.msky130_fd_pr__pfet_01v8_lvt[leff]
echo OPV XM38 leff $&s1_xm38_leff
let s1_xm39_id = @m.x1.xdut.xm39.msky130_fd_pr__pfet_01v8_lvt[id]
echo OPV XM39 id $&s1_xm39_id
let s1_xm39_vgs = @m.x1.xdut.xm39.msky130_fd_pr__pfet_01v8_lvt[vgs]
echo OPV XM39 vgs $&s1_xm39_vgs
let s1_xm39_vds = @m.x1.xdut.xm39.msky130_fd_pr__pfet_01v8_lvt[vds]
echo OPV XM39 vds $&s1_xm39_vds
let s1_xm39_vbs = @m.x1.xdut.xm39.msky130_fd_pr__pfet_01v8_lvt[vbs]
echo OPV XM39 vbs $&s1_xm39_vbs
let s1_xm39_vth = @m.x1.xdut.xm39.msky130_fd_pr__pfet_01v8_lvt[vth]
echo OPV XM39 vth $&s1_xm39_vth
let s1_xm39_vdsat = @m.x1.xdut.xm39.msky130_fd_pr__pfet_01v8_lvt[vdsat]
echo OPV XM39 vdsat $&s1_xm39_vdsat
let s1_xm39_gm = @m.x1.xdut.xm39.msky130_fd_pr__pfet_01v8_lvt[gm]
echo OPV XM39 gm $&s1_xm39_gm
let s1_xm39_gds = @m.x1.xdut.xm39.msky130_fd_pr__pfet_01v8_lvt[gds]
echo OPV XM39 gds $&s1_xm39_gds
let s1_xm39_gmbs = @m.x1.xdut.xm39.msky130_fd_pr__pfet_01v8_lvt[gmbs]
echo OPV XM39 gmbs $&s1_xm39_gmbs
let s1_xm39_cgg = @m.x1.xdut.xm39.msky130_fd_pr__pfet_01v8_lvt[cgg]
echo OPV XM39 cgg $&s1_xm39_cgg
let s1_xm39_cgd = @m.x1.xdut.xm39.msky130_fd_pr__pfet_01v8_lvt[cgd]
echo OPV XM39 cgd $&s1_xm39_cgd
let s1_xm39_cgs = @m.x1.xdut.xm39.msky130_fd_pr__pfet_01v8_lvt[cgs]
echo OPV XM39 cgs $&s1_xm39_cgs
let s1_xm39_cgb = @m.x1.xdut.xm39.msky130_fd_pr__pfet_01v8_lvt[cgb]
echo OPV XM39 cgb $&s1_xm39_cgb
let s1_xm39_cdg = @m.x1.xdut.xm39.msky130_fd_pr__pfet_01v8_lvt[cdg]
echo OPV XM39 cdg $&s1_xm39_cdg
let s1_xm39_cdd = @m.x1.xdut.xm39.msky130_fd_pr__pfet_01v8_lvt[cdd]
echo OPV XM39 cdd $&s1_xm39_cdd
let s1_xm39_cds = @m.x1.xdut.xm39.msky130_fd_pr__pfet_01v8_lvt[cds]
echo OPV XM39 cds $&s1_xm39_cds
let s1_xm39_cdb = @m.x1.xdut.xm39.msky130_fd_pr__pfet_01v8_lvt[cdb]
echo OPV XM39 cdb $&s1_xm39_cdb
let s1_xm39_csg = @m.x1.xdut.xm39.msky130_fd_pr__pfet_01v8_lvt[csg]
echo OPV XM39 csg $&s1_xm39_csg
let s1_xm39_csd = @m.x1.xdut.xm39.msky130_fd_pr__pfet_01v8_lvt[csd]
echo OPV XM39 csd $&s1_xm39_csd
let s1_xm39_css = @m.x1.xdut.xm39.msky130_fd_pr__pfet_01v8_lvt[css]
echo OPV XM39 css $&s1_xm39_css
let s1_xm39_csb = @m.x1.xdut.xm39.msky130_fd_pr__pfet_01v8_lvt[csb]
echo OPV XM39 csb $&s1_xm39_csb
let s1_xm39_cbg = @m.x1.xdut.xm39.msky130_fd_pr__pfet_01v8_lvt[cbg]
echo OPV XM39 cbg $&s1_xm39_cbg
let s1_xm39_cbd = @m.x1.xdut.xm39.msky130_fd_pr__pfet_01v8_lvt[cbd]
echo OPV XM39 cbd $&s1_xm39_cbd
let s1_xm39_cbs = @m.x1.xdut.xm39.msky130_fd_pr__pfet_01v8_lvt[cbs]
echo OPV XM39 cbs $&s1_xm39_cbs
let s1_xm39_cbb = @m.x1.xdut.xm39.msky130_fd_pr__pfet_01v8_lvt[cbb]
echo OPV XM39 cbb $&s1_xm39_cbb
let s1_xm39_capbd = @m.x1.xdut.xm39.msky130_fd_pr__pfet_01v8_lvt[capbd]
echo OPV XM39 capbd $&s1_xm39_capbd
let s1_xm39_capbs = @m.x1.xdut.xm39.msky130_fd_pr__pfet_01v8_lvt[capbs]
echo OPV XM39 capbs $&s1_xm39_capbs
let s1_xm39_cgso = @m.x1.xdut.xm39.msky130_fd_pr__pfet_01v8_lvt[cgso]
echo OPV XM39 cgso $&s1_xm39_cgso
let s1_xm39_cgdo = @m.x1.xdut.xm39.msky130_fd_pr__pfet_01v8_lvt[cgdo]
echo OPV XM39 cgdo $&s1_xm39_cgdo
let s1_xm39_cgbo = @m.x1.xdut.xm39.msky130_fd_pr__pfet_01v8_lvt[cgbo]
echo OPV XM39 cgbo $&s1_xm39_cgbo
let s1_xm39_weff = @m.x1.xdut.xm39.msky130_fd_pr__pfet_01v8_lvt[weff]
echo OPV XM39 weff $&s1_xm39_weff
let s1_xm39_leff = @m.x1.xdut.xm39.msky130_fd_pr__pfet_01v8_lvt[leff]
echo OPV XM39 leff $&s1_xm39_leff
let s1_xm40_id = @m.x1.xdut.xm40.msky130_fd_pr__nfet_01v8_lvt[id]
echo OPV XM40 id $&s1_xm40_id
let s1_xm40_vgs = @m.x1.xdut.xm40.msky130_fd_pr__nfet_01v8_lvt[vgs]
echo OPV XM40 vgs $&s1_xm40_vgs
let s1_xm40_vds = @m.x1.xdut.xm40.msky130_fd_pr__nfet_01v8_lvt[vds]
echo OPV XM40 vds $&s1_xm40_vds
let s1_xm40_vbs = @m.x1.xdut.xm40.msky130_fd_pr__nfet_01v8_lvt[vbs]
echo OPV XM40 vbs $&s1_xm40_vbs
let s1_xm40_vth = @m.x1.xdut.xm40.msky130_fd_pr__nfet_01v8_lvt[vth]
echo OPV XM40 vth $&s1_xm40_vth
let s1_xm40_vdsat = @m.x1.xdut.xm40.msky130_fd_pr__nfet_01v8_lvt[vdsat]
echo OPV XM40 vdsat $&s1_xm40_vdsat
let s1_xm40_gm = @m.x1.xdut.xm40.msky130_fd_pr__nfet_01v8_lvt[gm]
echo OPV XM40 gm $&s1_xm40_gm
let s1_xm40_gds = @m.x1.xdut.xm40.msky130_fd_pr__nfet_01v8_lvt[gds]
echo OPV XM40 gds $&s1_xm40_gds
let s1_xm40_gmbs = @m.x1.xdut.xm40.msky130_fd_pr__nfet_01v8_lvt[gmbs]
echo OPV XM40 gmbs $&s1_xm40_gmbs
let s1_xm40_cgg = @m.x1.xdut.xm40.msky130_fd_pr__nfet_01v8_lvt[cgg]
echo OPV XM40 cgg $&s1_xm40_cgg
let s1_xm40_cgd = @m.x1.xdut.xm40.msky130_fd_pr__nfet_01v8_lvt[cgd]
echo OPV XM40 cgd $&s1_xm40_cgd
let s1_xm40_cgs = @m.x1.xdut.xm40.msky130_fd_pr__nfet_01v8_lvt[cgs]
echo OPV XM40 cgs $&s1_xm40_cgs
let s1_xm40_cgb = @m.x1.xdut.xm40.msky130_fd_pr__nfet_01v8_lvt[cgb]
echo OPV XM40 cgb $&s1_xm40_cgb
let s1_xm40_cdg = @m.x1.xdut.xm40.msky130_fd_pr__nfet_01v8_lvt[cdg]
echo OPV XM40 cdg $&s1_xm40_cdg
let s1_xm40_cdd = @m.x1.xdut.xm40.msky130_fd_pr__nfet_01v8_lvt[cdd]
echo OPV XM40 cdd $&s1_xm40_cdd
let s1_xm40_cds = @m.x1.xdut.xm40.msky130_fd_pr__nfet_01v8_lvt[cds]
echo OPV XM40 cds $&s1_xm40_cds
let s1_xm40_cdb = @m.x1.xdut.xm40.msky130_fd_pr__nfet_01v8_lvt[cdb]
echo OPV XM40 cdb $&s1_xm40_cdb
let s1_xm40_csg = @m.x1.xdut.xm40.msky130_fd_pr__nfet_01v8_lvt[csg]
echo OPV XM40 csg $&s1_xm40_csg
let s1_xm40_csd = @m.x1.xdut.xm40.msky130_fd_pr__nfet_01v8_lvt[csd]
echo OPV XM40 csd $&s1_xm40_csd
let s1_xm40_css = @m.x1.xdut.xm40.msky130_fd_pr__nfet_01v8_lvt[css]
echo OPV XM40 css $&s1_xm40_css
let s1_xm40_csb = @m.x1.xdut.xm40.msky130_fd_pr__nfet_01v8_lvt[csb]
echo OPV XM40 csb $&s1_xm40_csb
let s1_xm40_cbg = @m.x1.xdut.xm40.msky130_fd_pr__nfet_01v8_lvt[cbg]
echo OPV XM40 cbg $&s1_xm40_cbg
let s1_xm40_cbd = @m.x1.xdut.xm40.msky130_fd_pr__nfet_01v8_lvt[cbd]
echo OPV XM40 cbd $&s1_xm40_cbd
let s1_xm40_cbs = @m.x1.xdut.xm40.msky130_fd_pr__nfet_01v8_lvt[cbs]
echo OPV XM40 cbs $&s1_xm40_cbs
let s1_xm40_cbb = @m.x1.xdut.xm40.msky130_fd_pr__nfet_01v8_lvt[cbb]
echo OPV XM40 cbb $&s1_xm40_cbb
let s1_xm40_capbd = @m.x1.xdut.xm40.msky130_fd_pr__nfet_01v8_lvt[capbd]
echo OPV XM40 capbd $&s1_xm40_capbd
let s1_xm40_capbs = @m.x1.xdut.xm40.msky130_fd_pr__nfet_01v8_lvt[capbs]
echo OPV XM40 capbs $&s1_xm40_capbs
let s1_xm40_cgso = @m.x1.xdut.xm40.msky130_fd_pr__nfet_01v8_lvt[cgso]
echo OPV XM40 cgso $&s1_xm40_cgso
let s1_xm40_cgdo = @m.x1.xdut.xm40.msky130_fd_pr__nfet_01v8_lvt[cgdo]
echo OPV XM40 cgdo $&s1_xm40_cgdo
let s1_xm40_cgbo = @m.x1.xdut.xm40.msky130_fd_pr__nfet_01v8_lvt[cgbo]
echo OPV XM40 cgbo $&s1_xm40_cgbo
let s1_xm40_weff = @m.x1.xdut.xm40.msky130_fd_pr__nfet_01v8_lvt[weff]
echo OPV XM40 weff $&s1_xm40_weff
let s1_xm40_leff = @m.x1.xdut.xm40.msky130_fd_pr__nfet_01v8_lvt[leff]
echo OPV XM40 leff $&s1_xm40_leff
let s1_xm41_id = @m.x1.xdut.xm41.msky130_fd_pr__nfet_01v8_lvt[id]
echo OPV XM41 id $&s1_xm41_id
let s1_xm41_vgs = @m.x1.xdut.xm41.msky130_fd_pr__nfet_01v8_lvt[vgs]
echo OPV XM41 vgs $&s1_xm41_vgs
let s1_xm41_vds = @m.x1.xdut.xm41.msky130_fd_pr__nfet_01v8_lvt[vds]
echo OPV XM41 vds $&s1_xm41_vds
let s1_xm41_vbs = @m.x1.xdut.xm41.msky130_fd_pr__nfet_01v8_lvt[vbs]
echo OPV XM41 vbs $&s1_xm41_vbs
let s1_xm41_vth = @m.x1.xdut.xm41.msky130_fd_pr__nfet_01v8_lvt[vth]
echo OPV XM41 vth $&s1_xm41_vth
let s1_xm41_vdsat = @m.x1.xdut.xm41.msky130_fd_pr__nfet_01v8_lvt[vdsat]
echo OPV XM41 vdsat $&s1_xm41_vdsat
let s1_xm41_gm = @m.x1.xdut.xm41.msky130_fd_pr__nfet_01v8_lvt[gm]
echo OPV XM41 gm $&s1_xm41_gm
let s1_xm41_gds = @m.x1.xdut.xm41.msky130_fd_pr__nfet_01v8_lvt[gds]
echo OPV XM41 gds $&s1_xm41_gds
let s1_xm41_gmbs = @m.x1.xdut.xm41.msky130_fd_pr__nfet_01v8_lvt[gmbs]
echo OPV XM41 gmbs $&s1_xm41_gmbs
let s1_xm41_cgg = @m.x1.xdut.xm41.msky130_fd_pr__nfet_01v8_lvt[cgg]
echo OPV XM41 cgg $&s1_xm41_cgg
let s1_xm41_cgd = @m.x1.xdut.xm41.msky130_fd_pr__nfet_01v8_lvt[cgd]
echo OPV XM41 cgd $&s1_xm41_cgd
let s1_xm41_cgs = @m.x1.xdut.xm41.msky130_fd_pr__nfet_01v8_lvt[cgs]
echo OPV XM41 cgs $&s1_xm41_cgs
let s1_xm41_cgb = @m.x1.xdut.xm41.msky130_fd_pr__nfet_01v8_lvt[cgb]
echo OPV XM41 cgb $&s1_xm41_cgb
let s1_xm41_cdg = @m.x1.xdut.xm41.msky130_fd_pr__nfet_01v8_lvt[cdg]
echo OPV XM41 cdg $&s1_xm41_cdg
let s1_xm41_cdd = @m.x1.xdut.xm41.msky130_fd_pr__nfet_01v8_lvt[cdd]
echo OPV XM41 cdd $&s1_xm41_cdd
let s1_xm41_cds = @m.x1.xdut.xm41.msky130_fd_pr__nfet_01v8_lvt[cds]
echo OPV XM41 cds $&s1_xm41_cds
let s1_xm41_cdb = @m.x1.xdut.xm41.msky130_fd_pr__nfet_01v8_lvt[cdb]
echo OPV XM41 cdb $&s1_xm41_cdb
let s1_xm41_csg = @m.x1.xdut.xm41.msky130_fd_pr__nfet_01v8_lvt[csg]
echo OPV XM41 csg $&s1_xm41_csg
let s1_xm41_csd = @m.x1.xdut.xm41.msky130_fd_pr__nfet_01v8_lvt[csd]
echo OPV XM41 csd $&s1_xm41_csd
let s1_xm41_css = @m.x1.xdut.xm41.msky130_fd_pr__nfet_01v8_lvt[css]
echo OPV XM41 css $&s1_xm41_css
let s1_xm41_csb = @m.x1.xdut.xm41.msky130_fd_pr__nfet_01v8_lvt[csb]
echo OPV XM41 csb $&s1_xm41_csb
let s1_xm41_cbg = @m.x1.xdut.xm41.msky130_fd_pr__nfet_01v8_lvt[cbg]
echo OPV XM41 cbg $&s1_xm41_cbg
let s1_xm41_cbd = @m.x1.xdut.xm41.msky130_fd_pr__nfet_01v8_lvt[cbd]
echo OPV XM41 cbd $&s1_xm41_cbd
let s1_xm41_cbs = @m.x1.xdut.xm41.msky130_fd_pr__nfet_01v8_lvt[cbs]
echo OPV XM41 cbs $&s1_xm41_cbs
let s1_xm41_cbb = @m.x1.xdut.xm41.msky130_fd_pr__nfet_01v8_lvt[cbb]
echo OPV XM41 cbb $&s1_xm41_cbb
let s1_xm41_capbd = @m.x1.xdut.xm41.msky130_fd_pr__nfet_01v8_lvt[capbd]
echo OPV XM41 capbd $&s1_xm41_capbd
let s1_xm41_capbs = @m.x1.xdut.xm41.msky130_fd_pr__nfet_01v8_lvt[capbs]
echo OPV XM41 capbs $&s1_xm41_capbs
let s1_xm41_cgso = @m.x1.xdut.xm41.msky130_fd_pr__nfet_01v8_lvt[cgso]
echo OPV XM41 cgso $&s1_xm41_cgso
let s1_xm41_cgdo = @m.x1.xdut.xm41.msky130_fd_pr__nfet_01v8_lvt[cgdo]
echo OPV XM41 cgdo $&s1_xm41_cgdo
let s1_xm41_cgbo = @m.x1.xdut.xm41.msky130_fd_pr__nfet_01v8_lvt[cgbo]
echo OPV XM41 cgbo $&s1_xm41_cgbo
let s1_xm41_weff = @m.x1.xdut.xm41.msky130_fd_pr__nfet_01v8_lvt[weff]
echo OPV XM41 weff $&s1_xm41_weff
let s1_xm41_leff = @m.x1.xdut.xm41.msky130_fd_pr__nfet_01v8_lvt[leff]
echo OPV XM41 leff $&s1_xm41_leff
let s1_xm42_id = @m.x1.xdut.xm42.msky130_fd_pr__pfet_01v8_lvt[id]
echo OPV XM42 id $&s1_xm42_id
let s1_xm42_vgs = @m.x1.xdut.xm42.msky130_fd_pr__pfet_01v8_lvt[vgs]
echo OPV XM42 vgs $&s1_xm42_vgs
let s1_xm42_vds = @m.x1.xdut.xm42.msky130_fd_pr__pfet_01v8_lvt[vds]
echo OPV XM42 vds $&s1_xm42_vds
let s1_xm42_vbs = @m.x1.xdut.xm42.msky130_fd_pr__pfet_01v8_lvt[vbs]
echo OPV XM42 vbs $&s1_xm42_vbs
let s1_xm42_vth = @m.x1.xdut.xm42.msky130_fd_pr__pfet_01v8_lvt[vth]
echo OPV XM42 vth $&s1_xm42_vth
let s1_xm42_vdsat = @m.x1.xdut.xm42.msky130_fd_pr__pfet_01v8_lvt[vdsat]
echo OPV XM42 vdsat $&s1_xm42_vdsat
let s1_xm42_gm = @m.x1.xdut.xm42.msky130_fd_pr__pfet_01v8_lvt[gm]
echo OPV XM42 gm $&s1_xm42_gm
let s1_xm42_gds = @m.x1.xdut.xm42.msky130_fd_pr__pfet_01v8_lvt[gds]
echo OPV XM42 gds $&s1_xm42_gds
let s1_xm42_gmbs = @m.x1.xdut.xm42.msky130_fd_pr__pfet_01v8_lvt[gmbs]
echo OPV XM42 gmbs $&s1_xm42_gmbs
let s1_xm42_cgg = @m.x1.xdut.xm42.msky130_fd_pr__pfet_01v8_lvt[cgg]
echo OPV XM42 cgg $&s1_xm42_cgg
let s1_xm42_cgd = @m.x1.xdut.xm42.msky130_fd_pr__pfet_01v8_lvt[cgd]
echo OPV XM42 cgd $&s1_xm42_cgd
let s1_xm42_cgs = @m.x1.xdut.xm42.msky130_fd_pr__pfet_01v8_lvt[cgs]
echo OPV XM42 cgs $&s1_xm42_cgs
let s1_xm42_cgb = @m.x1.xdut.xm42.msky130_fd_pr__pfet_01v8_lvt[cgb]
echo OPV XM42 cgb $&s1_xm42_cgb
let s1_xm42_cdg = @m.x1.xdut.xm42.msky130_fd_pr__pfet_01v8_lvt[cdg]
echo OPV XM42 cdg $&s1_xm42_cdg
let s1_xm42_cdd = @m.x1.xdut.xm42.msky130_fd_pr__pfet_01v8_lvt[cdd]
echo OPV XM42 cdd $&s1_xm42_cdd
let s1_xm42_cds = @m.x1.xdut.xm42.msky130_fd_pr__pfet_01v8_lvt[cds]
echo OPV XM42 cds $&s1_xm42_cds
let s1_xm42_cdb = @m.x1.xdut.xm42.msky130_fd_pr__pfet_01v8_lvt[cdb]
echo OPV XM42 cdb $&s1_xm42_cdb
let s1_xm42_csg = @m.x1.xdut.xm42.msky130_fd_pr__pfet_01v8_lvt[csg]
echo OPV XM42 csg $&s1_xm42_csg
let s1_xm42_csd = @m.x1.xdut.xm42.msky130_fd_pr__pfet_01v8_lvt[csd]
echo OPV XM42 csd $&s1_xm42_csd
let s1_xm42_css = @m.x1.xdut.xm42.msky130_fd_pr__pfet_01v8_lvt[css]
echo OPV XM42 css $&s1_xm42_css
let s1_xm42_csb = @m.x1.xdut.xm42.msky130_fd_pr__pfet_01v8_lvt[csb]
echo OPV XM42 csb $&s1_xm42_csb
let s1_xm42_cbg = @m.x1.xdut.xm42.msky130_fd_pr__pfet_01v8_lvt[cbg]
echo OPV XM42 cbg $&s1_xm42_cbg
let s1_xm42_cbd = @m.x1.xdut.xm42.msky130_fd_pr__pfet_01v8_lvt[cbd]
echo OPV XM42 cbd $&s1_xm42_cbd
let s1_xm42_cbs = @m.x1.xdut.xm42.msky130_fd_pr__pfet_01v8_lvt[cbs]
echo OPV XM42 cbs $&s1_xm42_cbs
let s1_xm42_cbb = @m.x1.xdut.xm42.msky130_fd_pr__pfet_01v8_lvt[cbb]
echo OPV XM42 cbb $&s1_xm42_cbb
let s1_xm42_capbd = @m.x1.xdut.xm42.msky130_fd_pr__pfet_01v8_lvt[capbd]
echo OPV XM42 capbd $&s1_xm42_capbd
let s1_xm42_capbs = @m.x1.xdut.xm42.msky130_fd_pr__pfet_01v8_lvt[capbs]
echo OPV XM42 capbs $&s1_xm42_capbs
let s1_xm42_cgso = @m.x1.xdut.xm42.msky130_fd_pr__pfet_01v8_lvt[cgso]
echo OPV XM42 cgso $&s1_xm42_cgso
let s1_xm42_cgdo = @m.x1.xdut.xm42.msky130_fd_pr__pfet_01v8_lvt[cgdo]
echo OPV XM42 cgdo $&s1_xm42_cgdo
let s1_xm42_cgbo = @m.x1.xdut.xm42.msky130_fd_pr__pfet_01v8_lvt[cgbo]
echo OPV XM42 cgbo $&s1_xm42_cgbo
let s1_xm42_weff = @m.x1.xdut.xm42.msky130_fd_pr__pfet_01v8_lvt[weff]
echo OPV XM42 weff $&s1_xm42_weff
let s1_xm42_leff = @m.x1.xdut.xm42.msky130_fd_pr__pfet_01v8_lvt[leff]
echo OPV XM42 leff $&s1_xm42_leff
let s1_xm43_id = @m.x1.xdut.xm43.msky130_fd_pr__pfet_01v8_lvt[id]
echo OPV XM43 id $&s1_xm43_id
let s1_xm43_vgs = @m.x1.xdut.xm43.msky130_fd_pr__pfet_01v8_lvt[vgs]
echo OPV XM43 vgs $&s1_xm43_vgs
let s1_xm43_vds = @m.x1.xdut.xm43.msky130_fd_pr__pfet_01v8_lvt[vds]
echo OPV XM43 vds $&s1_xm43_vds
let s1_xm43_vbs = @m.x1.xdut.xm43.msky130_fd_pr__pfet_01v8_lvt[vbs]
echo OPV XM43 vbs $&s1_xm43_vbs
let s1_xm43_vth = @m.x1.xdut.xm43.msky130_fd_pr__pfet_01v8_lvt[vth]
echo OPV XM43 vth $&s1_xm43_vth
let s1_xm43_vdsat = @m.x1.xdut.xm43.msky130_fd_pr__pfet_01v8_lvt[vdsat]
echo OPV XM43 vdsat $&s1_xm43_vdsat
let s1_xm43_gm = @m.x1.xdut.xm43.msky130_fd_pr__pfet_01v8_lvt[gm]
echo OPV XM43 gm $&s1_xm43_gm
let s1_xm43_gds = @m.x1.xdut.xm43.msky130_fd_pr__pfet_01v8_lvt[gds]
echo OPV XM43 gds $&s1_xm43_gds
let s1_xm43_gmbs = @m.x1.xdut.xm43.msky130_fd_pr__pfet_01v8_lvt[gmbs]
echo OPV XM43 gmbs $&s1_xm43_gmbs
let s1_xm43_cgg = @m.x1.xdut.xm43.msky130_fd_pr__pfet_01v8_lvt[cgg]
echo OPV XM43 cgg $&s1_xm43_cgg
let s1_xm43_cgd = @m.x1.xdut.xm43.msky130_fd_pr__pfet_01v8_lvt[cgd]
echo OPV XM43 cgd $&s1_xm43_cgd
let s1_xm43_cgs = @m.x1.xdut.xm43.msky130_fd_pr__pfet_01v8_lvt[cgs]
echo OPV XM43 cgs $&s1_xm43_cgs
let s1_xm43_cgb = @m.x1.xdut.xm43.msky130_fd_pr__pfet_01v8_lvt[cgb]
echo OPV XM43 cgb $&s1_xm43_cgb
let s1_xm43_cdg = @m.x1.xdut.xm43.msky130_fd_pr__pfet_01v8_lvt[cdg]
echo OPV XM43 cdg $&s1_xm43_cdg
let s1_xm43_cdd = @m.x1.xdut.xm43.msky130_fd_pr__pfet_01v8_lvt[cdd]
echo OPV XM43 cdd $&s1_xm43_cdd
let s1_xm43_cds = @m.x1.xdut.xm43.msky130_fd_pr__pfet_01v8_lvt[cds]
echo OPV XM43 cds $&s1_xm43_cds
let s1_xm43_cdb = @m.x1.xdut.xm43.msky130_fd_pr__pfet_01v8_lvt[cdb]
echo OPV XM43 cdb $&s1_xm43_cdb
let s1_xm43_csg = @m.x1.xdut.xm43.msky130_fd_pr__pfet_01v8_lvt[csg]
echo OPV XM43 csg $&s1_xm43_csg
let s1_xm43_csd = @m.x1.xdut.xm43.msky130_fd_pr__pfet_01v8_lvt[csd]
echo OPV XM43 csd $&s1_xm43_csd
let s1_xm43_css = @m.x1.xdut.xm43.msky130_fd_pr__pfet_01v8_lvt[css]
echo OPV XM43 css $&s1_xm43_css
let s1_xm43_csb = @m.x1.xdut.xm43.msky130_fd_pr__pfet_01v8_lvt[csb]
echo OPV XM43 csb $&s1_xm43_csb
let s1_xm43_cbg = @m.x1.xdut.xm43.msky130_fd_pr__pfet_01v8_lvt[cbg]
echo OPV XM43 cbg $&s1_xm43_cbg
let s1_xm43_cbd = @m.x1.xdut.xm43.msky130_fd_pr__pfet_01v8_lvt[cbd]
echo OPV XM43 cbd $&s1_xm43_cbd
let s1_xm43_cbs = @m.x1.xdut.xm43.msky130_fd_pr__pfet_01v8_lvt[cbs]
echo OPV XM43 cbs $&s1_xm43_cbs
let s1_xm43_cbb = @m.x1.xdut.xm43.msky130_fd_pr__pfet_01v8_lvt[cbb]
echo OPV XM43 cbb $&s1_xm43_cbb
let s1_xm43_capbd = @m.x1.xdut.xm43.msky130_fd_pr__pfet_01v8_lvt[capbd]
echo OPV XM43 capbd $&s1_xm43_capbd
let s1_xm43_capbs = @m.x1.xdut.xm43.msky130_fd_pr__pfet_01v8_lvt[capbs]
echo OPV XM43 capbs $&s1_xm43_capbs
let s1_xm43_cgso = @m.x1.xdut.xm43.msky130_fd_pr__pfet_01v8_lvt[cgso]
echo OPV XM43 cgso $&s1_xm43_cgso
let s1_xm43_cgdo = @m.x1.xdut.xm43.msky130_fd_pr__pfet_01v8_lvt[cgdo]
echo OPV XM43 cgdo $&s1_xm43_cgdo
let s1_xm43_cgbo = @m.x1.xdut.xm43.msky130_fd_pr__pfet_01v8_lvt[cgbo]
echo OPV XM43 cgbo $&s1_xm43_cgbo
let s1_xm43_weff = @m.x1.xdut.xm43.msky130_fd_pr__pfet_01v8_lvt[weff]
echo OPV XM43 weff $&s1_xm43_weff
let s1_xm43_leff = @m.x1.xdut.xm43.msky130_fd_pr__pfet_01v8_lvt[leff]
echo OPV XM43 leff $&s1_xm43_leff
let s1_xm44_id = @m.x1.xdut.xm44.msky130_fd_pr__pfet_01v8_lvt[id]
echo OPV XM44 id $&s1_xm44_id
let s1_xm44_vgs = @m.x1.xdut.xm44.msky130_fd_pr__pfet_01v8_lvt[vgs]
echo OPV XM44 vgs $&s1_xm44_vgs
let s1_xm44_vds = @m.x1.xdut.xm44.msky130_fd_pr__pfet_01v8_lvt[vds]
echo OPV XM44 vds $&s1_xm44_vds
let s1_xm44_vbs = @m.x1.xdut.xm44.msky130_fd_pr__pfet_01v8_lvt[vbs]
echo OPV XM44 vbs $&s1_xm44_vbs
let s1_xm44_vth = @m.x1.xdut.xm44.msky130_fd_pr__pfet_01v8_lvt[vth]
echo OPV XM44 vth $&s1_xm44_vth
let s1_xm44_vdsat = @m.x1.xdut.xm44.msky130_fd_pr__pfet_01v8_lvt[vdsat]
echo OPV XM44 vdsat $&s1_xm44_vdsat
let s1_xm44_gm = @m.x1.xdut.xm44.msky130_fd_pr__pfet_01v8_lvt[gm]
echo OPV XM44 gm $&s1_xm44_gm
let s1_xm44_gds = @m.x1.xdut.xm44.msky130_fd_pr__pfet_01v8_lvt[gds]
echo OPV XM44 gds $&s1_xm44_gds
let s1_xm44_gmbs = @m.x1.xdut.xm44.msky130_fd_pr__pfet_01v8_lvt[gmbs]
echo OPV XM44 gmbs $&s1_xm44_gmbs
let s1_xm44_cgg = @m.x1.xdut.xm44.msky130_fd_pr__pfet_01v8_lvt[cgg]
echo OPV XM44 cgg $&s1_xm44_cgg
let s1_xm44_cgd = @m.x1.xdut.xm44.msky130_fd_pr__pfet_01v8_lvt[cgd]
echo OPV XM44 cgd $&s1_xm44_cgd
let s1_xm44_cgs = @m.x1.xdut.xm44.msky130_fd_pr__pfet_01v8_lvt[cgs]
echo OPV XM44 cgs $&s1_xm44_cgs
let s1_xm44_cgb = @m.x1.xdut.xm44.msky130_fd_pr__pfet_01v8_lvt[cgb]
echo OPV XM44 cgb $&s1_xm44_cgb
let s1_xm44_cdg = @m.x1.xdut.xm44.msky130_fd_pr__pfet_01v8_lvt[cdg]
echo OPV XM44 cdg $&s1_xm44_cdg
let s1_xm44_cdd = @m.x1.xdut.xm44.msky130_fd_pr__pfet_01v8_lvt[cdd]
echo OPV XM44 cdd $&s1_xm44_cdd
let s1_xm44_cds = @m.x1.xdut.xm44.msky130_fd_pr__pfet_01v8_lvt[cds]
echo OPV XM44 cds $&s1_xm44_cds
let s1_xm44_cdb = @m.x1.xdut.xm44.msky130_fd_pr__pfet_01v8_lvt[cdb]
echo OPV XM44 cdb $&s1_xm44_cdb
let s1_xm44_csg = @m.x1.xdut.xm44.msky130_fd_pr__pfet_01v8_lvt[csg]
echo OPV XM44 csg $&s1_xm44_csg
let s1_xm44_csd = @m.x1.xdut.xm44.msky130_fd_pr__pfet_01v8_lvt[csd]
echo OPV XM44 csd $&s1_xm44_csd
let s1_xm44_css = @m.x1.xdut.xm44.msky130_fd_pr__pfet_01v8_lvt[css]
echo OPV XM44 css $&s1_xm44_css
let s1_xm44_csb = @m.x1.xdut.xm44.msky130_fd_pr__pfet_01v8_lvt[csb]
echo OPV XM44 csb $&s1_xm44_csb
let s1_xm44_cbg = @m.x1.xdut.xm44.msky130_fd_pr__pfet_01v8_lvt[cbg]
echo OPV XM44 cbg $&s1_xm44_cbg
let s1_xm44_cbd = @m.x1.xdut.xm44.msky130_fd_pr__pfet_01v8_lvt[cbd]
echo OPV XM44 cbd $&s1_xm44_cbd
let s1_xm44_cbs = @m.x1.xdut.xm44.msky130_fd_pr__pfet_01v8_lvt[cbs]
echo OPV XM44 cbs $&s1_xm44_cbs
let s1_xm44_cbb = @m.x1.xdut.xm44.msky130_fd_pr__pfet_01v8_lvt[cbb]
echo OPV XM44 cbb $&s1_xm44_cbb
let s1_xm44_capbd = @m.x1.xdut.xm44.msky130_fd_pr__pfet_01v8_lvt[capbd]
echo OPV XM44 capbd $&s1_xm44_capbd
let s1_xm44_capbs = @m.x1.xdut.xm44.msky130_fd_pr__pfet_01v8_lvt[capbs]
echo OPV XM44 capbs $&s1_xm44_capbs
let s1_xm44_cgso = @m.x1.xdut.xm44.msky130_fd_pr__pfet_01v8_lvt[cgso]
echo OPV XM44 cgso $&s1_xm44_cgso
let s1_xm44_cgdo = @m.x1.xdut.xm44.msky130_fd_pr__pfet_01v8_lvt[cgdo]
echo OPV XM44 cgdo $&s1_xm44_cgdo
let s1_xm44_cgbo = @m.x1.xdut.xm44.msky130_fd_pr__pfet_01v8_lvt[cgbo]
echo OPV XM44 cgbo $&s1_xm44_cgbo
let s1_xm44_weff = @m.x1.xdut.xm44.msky130_fd_pr__pfet_01v8_lvt[weff]
echo OPV XM44 weff $&s1_xm44_weff
let s1_xm44_leff = @m.x1.xdut.xm44.msky130_fd_pr__pfet_01v8_lvt[leff]
echo OPV XM44 leff $&s1_xm44_leff
let s1_xm45_id = @m.x1.xdut.xm45.msky130_fd_pr__pfet_01v8_lvt[id]
echo OPV XM45 id $&s1_xm45_id
let s1_xm45_vgs = @m.x1.xdut.xm45.msky130_fd_pr__pfet_01v8_lvt[vgs]
echo OPV XM45 vgs $&s1_xm45_vgs
let s1_xm45_vds = @m.x1.xdut.xm45.msky130_fd_pr__pfet_01v8_lvt[vds]
echo OPV XM45 vds $&s1_xm45_vds
let s1_xm45_vbs = @m.x1.xdut.xm45.msky130_fd_pr__pfet_01v8_lvt[vbs]
echo OPV XM45 vbs $&s1_xm45_vbs
let s1_xm45_vth = @m.x1.xdut.xm45.msky130_fd_pr__pfet_01v8_lvt[vth]
echo OPV XM45 vth $&s1_xm45_vth
let s1_xm45_vdsat = @m.x1.xdut.xm45.msky130_fd_pr__pfet_01v8_lvt[vdsat]
echo OPV XM45 vdsat $&s1_xm45_vdsat
let s1_xm45_gm = @m.x1.xdut.xm45.msky130_fd_pr__pfet_01v8_lvt[gm]
echo OPV XM45 gm $&s1_xm45_gm
let s1_xm45_gds = @m.x1.xdut.xm45.msky130_fd_pr__pfet_01v8_lvt[gds]
echo OPV XM45 gds $&s1_xm45_gds
let s1_xm45_gmbs = @m.x1.xdut.xm45.msky130_fd_pr__pfet_01v8_lvt[gmbs]
echo OPV XM45 gmbs $&s1_xm45_gmbs
let s1_xm45_cgg = @m.x1.xdut.xm45.msky130_fd_pr__pfet_01v8_lvt[cgg]
echo OPV XM45 cgg $&s1_xm45_cgg
let s1_xm45_cgd = @m.x1.xdut.xm45.msky130_fd_pr__pfet_01v8_lvt[cgd]
echo OPV XM45 cgd $&s1_xm45_cgd
let s1_xm45_cgs = @m.x1.xdut.xm45.msky130_fd_pr__pfet_01v8_lvt[cgs]
echo OPV XM45 cgs $&s1_xm45_cgs
let s1_xm45_cgb = @m.x1.xdut.xm45.msky130_fd_pr__pfet_01v8_lvt[cgb]
echo OPV XM45 cgb $&s1_xm45_cgb
let s1_xm45_cdg = @m.x1.xdut.xm45.msky130_fd_pr__pfet_01v8_lvt[cdg]
echo OPV XM45 cdg $&s1_xm45_cdg
let s1_xm45_cdd = @m.x1.xdut.xm45.msky130_fd_pr__pfet_01v8_lvt[cdd]
echo OPV XM45 cdd $&s1_xm45_cdd
let s1_xm45_cds = @m.x1.xdut.xm45.msky130_fd_pr__pfet_01v8_lvt[cds]
echo OPV XM45 cds $&s1_xm45_cds
let s1_xm45_cdb = @m.x1.xdut.xm45.msky130_fd_pr__pfet_01v8_lvt[cdb]
echo OPV XM45 cdb $&s1_xm45_cdb
let s1_xm45_csg = @m.x1.xdut.xm45.msky130_fd_pr__pfet_01v8_lvt[csg]
echo OPV XM45 csg $&s1_xm45_csg
let s1_xm45_csd = @m.x1.xdut.xm45.msky130_fd_pr__pfet_01v8_lvt[csd]
echo OPV XM45 csd $&s1_xm45_csd
let s1_xm45_css = @m.x1.xdut.xm45.msky130_fd_pr__pfet_01v8_lvt[css]
echo OPV XM45 css $&s1_xm45_css
let s1_xm45_csb = @m.x1.xdut.xm45.msky130_fd_pr__pfet_01v8_lvt[csb]
echo OPV XM45 csb $&s1_xm45_csb
let s1_xm45_cbg = @m.x1.xdut.xm45.msky130_fd_pr__pfet_01v8_lvt[cbg]
echo OPV XM45 cbg $&s1_xm45_cbg
let s1_xm45_cbd = @m.x1.xdut.xm45.msky130_fd_pr__pfet_01v8_lvt[cbd]
echo OPV XM45 cbd $&s1_xm45_cbd
let s1_xm45_cbs = @m.x1.xdut.xm45.msky130_fd_pr__pfet_01v8_lvt[cbs]
echo OPV XM45 cbs $&s1_xm45_cbs
let s1_xm45_cbb = @m.x1.xdut.xm45.msky130_fd_pr__pfet_01v8_lvt[cbb]
echo OPV XM45 cbb $&s1_xm45_cbb
let s1_xm45_capbd = @m.x1.xdut.xm45.msky130_fd_pr__pfet_01v8_lvt[capbd]
echo OPV XM45 capbd $&s1_xm45_capbd
let s1_xm45_capbs = @m.x1.xdut.xm45.msky130_fd_pr__pfet_01v8_lvt[capbs]
echo OPV XM45 capbs $&s1_xm45_capbs
let s1_xm45_cgso = @m.x1.xdut.xm45.msky130_fd_pr__pfet_01v8_lvt[cgso]
echo OPV XM45 cgso $&s1_xm45_cgso
let s1_xm45_cgdo = @m.x1.xdut.xm45.msky130_fd_pr__pfet_01v8_lvt[cgdo]
echo OPV XM45 cgdo $&s1_xm45_cgdo
let s1_xm45_cgbo = @m.x1.xdut.xm45.msky130_fd_pr__pfet_01v8_lvt[cgbo]
echo OPV XM45 cgbo $&s1_xm45_cgbo
let s1_xm45_weff = @m.x1.xdut.xm45.msky130_fd_pr__pfet_01v8_lvt[weff]
echo OPV XM45 weff $&s1_xm45_weff
let s1_xm45_leff = @m.x1.xdut.xm45.msky130_fd_pr__pfet_01v8_lvt[leff]
echo OPV XM45 leff $&s1_xm45_leff
let s1_xm54_id = @m.x1.xdut.xm54.msky130_fd_pr__pfet_01v8_lvt[id]
echo OPV XM54 id $&s1_xm54_id
let s1_xm54_vgs = @m.x1.xdut.xm54.msky130_fd_pr__pfet_01v8_lvt[vgs]
echo OPV XM54 vgs $&s1_xm54_vgs
let s1_xm54_vds = @m.x1.xdut.xm54.msky130_fd_pr__pfet_01v8_lvt[vds]
echo OPV XM54 vds $&s1_xm54_vds
let s1_xm54_vbs = @m.x1.xdut.xm54.msky130_fd_pr__pfet_01v8_lvt[vbs]
echo OPV XM54 vbs $&s1_xm54_vbs
let s1_xm54_vth = @m.x1.xdut.xm54.msky130_fd_pr__pfet_01v8_lvt[vth]
echo OPV XM54 vth $&s1_xm54_vth
let s1_xm54_vdsat = @m.x1.xdut.xm54.msky130_fd_pr__pfet_01v8_lvt[vdsat]
echo OPV XM54 vdsat $&s1_xm54_vdsat
let s1_xm54_gm = @m.x1.xdut.xm54.msky130_fd_pr__pfet_01v8_lvt[gm]
echo OPV XM54 gm $&s1_xm54_gm
let s1_xm54_gds = @m.x1.xdut.xm54.msky130_fd_pr__pfet_01v8_lvt[gds]
echo OPV XM54 gds $&s1_xm54_gds
let s1_xm54_gmbs = @m.x1.xdut.xm54.msky130_fd_pr__pfet_01v8_lvt[gmbs]
echo OPV XM54 gmbs $&s1_xm54_gmbs
let s1_xm54_cgg = @m.x1.xdut.xm54.msky130_fd_pr__pfet_01v8_lvt[cgg]
echo OPV XM54 cgg $&s1_xm54_cgg
let s1_xm54_cgd = @m.x1.xdut.xm54.msky130_fd_pr__pfet_01v8_lvt[cgd]
echo OPV XM54 cgd $&s1_xm54_cgd
let s1_xm54_cgs = @m.x1.xdut.xm54.msky130_fd_pr__pfet_01v8_lvt[cgs]
echo OPV XM54 cgs $&s1_xm54_cgs
let s1_xm54_cgb = @m.x1.xdut.xm54.msky130_fd_pr__pfet_01v8_lvt[cgb]
echo OPV XM54 cgb $&s1_xm54_cgb
let s1_xm54_cdg = @m.x1.xdut.xm54.msky130_fd_pr__pfet_01v8_lvt[cdg]
echo OPV XM54 cdg $&s1_xm54_cdg
let s1_xm54_cdd = @m.x1.xdut.xm54.msky130_fd_pr__pfet_01v8_lvt[cdd]
echo OPV XM54 cdd $&s1_xm54_cdd
let s1_xm54_cds = @m.x1.xdut.xm54.msky130_fd_pr__pfet_01v8_lvt[cds]
echo OPV XM54 cds $&s1_xm54_cds
let s1_xm54_cdb = @m.x1.xdut.xm54.msky130_fd_pr__pfet_01v8_lvt[cdb]
echo OPV XM54 cdb $&s1_xm54_cdb
let s1_xm54_csg = @m.x1.xdut.xm54.msky130_fd_pr__pfet_01v8_lvt[csg]
echo OPV XM54 csg $&s1_xm54_csg
let s1_xm54_csd = @m.x1.xdut.xm54.msky130_fd_pr__pfet_01v8_lvt[csd]
echo OPV XM54 csd $&s1_xm54_csd
let s1_xm54_css = @m.x1.xdut.xm54.msky130_fd_pr__pfet_01v8_lvt[css]
echo OPV XM54 css $&s1_xm54_css
let s1_xm54_csb = @m.x1.xdut.xm54.msky130_fd_pr__pfet_01v8_lvt[csb]
echo OPV XM54 csb $&s1_xm54_csb
let s1_xm54_cbg = @m.x1.xdut.xm54.msky130_fd_pr__pfet_01v8_lvt[cbg]
echo OPV XM54 cbg $&s1_xm54_cbg
let s1_xm54_cbd = @m.x1.xdut.xm54.msky130_fd_pr__pfet_01v8_lvt[cbd]
echo OPV XM54 cbd $&s1_xm54_cbd
let s1_xm54_cbs = @m.x1.xdut.xm54.msky130_fd_pr__pfet_01v8_lvt[cbs]
echo OPV XM54 cbs $&s1_xm54_cbs
let s1_xm54_cbb = @m.x1.xdut.xm54.msky130_fd_pr__pfet_01v8_lvt[cbb]
echo OPV XM54 cbb $&s1_xm54_cbb
let s1_xm54_capbd = @m.x1.xdut.xm54.msky130_fd_pr__pfet_01v8_lvt[capbd]
echo OPV XM54 capbd $&s1_xm54_capbd
let s1_xm54_capbs = @m.x1.xdut.xm54.msky130_fd_pr__pfet_01v8_lvt[capbs]
echo OPV XM54 capbs $&s1_xm54_capbs
let s1_xm54_cgso = @m.x1.xdut.xm54.msky130_fd_pr__pfet_01v8_lvt[cgso]
echo OPV XM54 cgso $&s1_xm54_cgso
let s1_xm54_cgdo = @m.x1.xdut.xm54.msky130_fd_pr__pfet_01v8_lvt[cgdo]
echo OPV XM54 cgdo $&s1_xm54_cgdo
let s1_xm54_cgbo = @m.x1.xdut.xm54.msky130_fd_pr__pfet_01v8_lvt[cgbo]
echo OPV XM54 cgbo $&s1_xm54_cgbo
let s1_xm54_weff = @m.x1.xdut.xm54.msky130_fd_pr__pfet_01v8_lvt[weff]
echo OPV XM54 weff $&s1_xm54_weff
let s1_xm54_leff = @m.x1.xdut.xm54.msky130_fd_pr__pfet_01v8_lvt[leff]
echo OPV XM54 leff $&s1_xm54_leff
let s1_xx1_m5_id = @m.x1.xdut.xx1_m5.msky130_fd_pr__nfet_01v8_lvt[id]
echo OPV XX1_M5 id $&s1_xx1_m5_id
let s1_xx1_m5_vgs = @m.x1.xdut.xx1_m5.msky130_fd_pr__nfet_01v8_lvt[vgs]
echo OPV XX1_M5 vgs $&s1_xx1_m5_vgs
let s1_xx1_m5_vds = @m.x1.xdut.xx1_m5.msky130_fd_pr__nfet_01v8_lvt[vds]
echo OPV XX1_M5 vds $&s1_xx1_m5_vds
let s1_xx1_m5_vbs = @m.x1.xdut.xx1_m5.msky130_fd_pr__nfet_01v8_lvt[vbs]
echo OPV XX1_M5 vbs $&s1_xx1_m5_vbs
let s1_xx1_m5_vth = @m.x1.xdut.xx1_m5.msky130_fd_pr__nfet_01v8_lvt[vth]
echo OPV XX1_M5 vth $&s1_xx1_m5_vth
let s1_xx1_m5_vdsat = @m.x1.xdut.xx1_m5.msky130_fd_pr__nfet_01v8_lvt[vdsat]
echo OPV XX1_M5 vdsat $&s1_xx1_m5_vdsat
let s1_xx1_m5_gm = @m.x1.xdut.xx1_m5.msky130_fd_pr__nfet_01v8_lvt[gm]
echo OPV XX1_M5 gm $&s1_xx1_m5_gm
let s1_xx1_m5_gds = @m.x1.xdut.xx1_m5.msky130_fd_pr__nfet_01v8_lvt[gds]
echo OPV XX1_M5 gds $&s1_xx1_m5_gds
let s1_xx1_m5_gmbs = @m.x1.xdut.xx1_m5.msky130_fd_pr__nfet_01v8_lvt[gmbs]
echo OPV XX1_M5 gmbs $&s1_xx1_m5_gmbs
let s1_xx1_m5_cgg = @m.x1.xdut.xx1_m5.msky130_fd_pr__nfet_01v8_lvt[cgg]
echo OPV XX1_M5 cgg $&s1_xx1_m5_cgg
let s1_xx1_m5_cgd = @m.x1.xdut.xx1_m5.msky130_fd_pr__nfet_01v8_lvt[cgd]
echo OPV XX1_M5 cgd $&s1_xx1_m5_cgd
let s1_xx1_m5_cgs = @m.x1.xdut.xx1_m5.msky130_fd_pr__nfet_01v8_lvt[cgs]
echo OPV XX1_M5 cgs $&s1_xx1_m5_cgs
let s1_xx1_m5_cgb = @m.x1.xdut.xx1_m5.msky130_fd_pr__nfet_01v8_lvt[cgb]
echo OPV XX1_M5 cgb $&s1_xx1_m5_cgb
let s1_xx1_m5_cdg = @m.x1.xdut.xx1_m5.msky130_fd_pr__nfet_01v8_lvt[cdg]
echo OPV XX1_M5 cdg $&s1_xx1_m5_cdg
let s1_xx1_m5_cdd = @m.x1.xdut.xx1_m5.msky130_fd_pr__nfet_01v8_lvt[cdd]
echo OPV XX1_M5 cdd $&s1_xx1_m5_cdd
let s1_xx1_m5_cds = @m.x1.xdut.xx1_m5.msky130_fd_pr__nfet_01v8_lvt[cds]
echo OPV XX1_M5 cds $&s1_xx1_m5_cds
let s1_xx1_m5_cdb = @m.x1.xdut.xx1_m5.msky130_fd_pr__nfet_01v8_lvt[cdb]
echo OPV XX1_M5 cdb $&s1_xx1_m5_cdb
let s1_xx1_m5_csg = @m.x1.xdut.xx1_m5.msky130_fd_pr__nfet_01v8_lvt[csg]
echo OPV XX1_M5 csg $&s1_xx1_m5_csg
let s1_xx1_m5_csd = @m.x1.xdut.xx1_m5.msky130_fd_pr__nfet_01v8_lvt[csd]
echo OPV XX1_M5 csd $&s1_xx1_m5_csd
let s1_xx1_m5_css = @m.x1.xdut.xx1_m5.msky130_fd_pr__nfet_01v8_lvt[css]
echo OPV XX1_M5 css $&s1_xx1_m5_css
let s1_xx1_m5_csb = @m.x1.xdut.xx1_m5.msky130_fd_pr__nfet_01v8_lvt[csb]
echo OPV XX1_M5 csb $&s1_xx1_m5_csb
let s1_xx1_m5_cbg = @m.x1.xdut.xx1_m5.msky130_fd_pr__nfet_01v8_lvt[cbg]
echo OPV XX1_M5 cbg $&s1_xx1_m5_cbg
let s1_xx1_m5_cbd = @m.x1.xdut.xx1_m5.msky130_fd_pr__nfet_01v8_lvt[cbd]
echo OPV XX1_M5 cbd $&s1_xx1_m5_cbd
let s1_xx1_m5_cbs = @m.x1.xdut.xx1_m5.msky130_fd_pr__nfet_01v8_lvt[cbs]
echo OPV XX1_M5 cbs $&s1_xx1_m5_cbs
let s1_xx1_m5_cbb = @m.x1.xdut.xx1_m5.msky130_fd_pr__nfet_01v8_lvt[cbb]
echo OPV XX1_M5 cbb $&s1_xx1_m5_cbb
let s1_xx1_m5_capbd = @m.x1.xdut.xx1_m5.msky130_fd_pr__nfet_01v8_lvt[capbd]
echo OPV XX1_M5 capbd $&s1_xx1_m5_capbd
let s1_xx1_m5_capbs = @m.x1.xdut.xx1_m5.msky130_fd_pr__nfet_01v8_lvt[capbs]
echo OPV XX1_M5 capbs $&s1_xx1_m5_capbs
let s1_xx1_m5_cgso = @m.x1.xdut.xx1_m5.msky130_fd_pr__nfet_01v8_lvt[cgso]
echo OPV XX1_M5 cgso $&s1_xx1_m5_cgso
let s1_xx1_m5_cgdo = @m.x1.xdut.xx1_m5.msky130_fd_pr__nfet_01v8_lvt[cgdo]
echo OPV XX1_M5 cgdo $&s1_xx1_m5_cgdo
let s1_xx1_m5_cgbo = @m.x1.xdut.xx1_m5.msky130_fd_pr__nfet_01v8_lvt[cgbo]
echo OPV XX1_M5 cgbo $&s1_xx1_m5_cgbo
let s1_xx1_m5_weff = @m.x1.xdut.xx1_m5.msky130_fd_pr__nfet_01v8_lvt[weff]
echo OPV XX1_M5 weff $&s1_xx1_m5_weff
let s1_xx1_m5_leff = @m.x1.xdut.xx1_m5.msky130_fd_pr__nfet_01v8_lvt[leff]
echo OPV XX1_M5 leff $&s1_xx1_m5_leff
let s1_xx1_m6_id = @m.x1.xdut.xx1_m6.msky130_fd_pr__nfet_01v8_lvt[id]
echo OPV XX1_M6 id $&s1_xx1_m6_id
let s1_xx1_m6_vgs = @m.x1.xdut.xx1_m6.msky130_fd_pr__nfet_01v8_lvt[vgs]
echo OPV XX1_M6 vgs $&s1_xx1_m6_vgs
let s1_xx1_m6_vds = @m.x1.xdut.xx1_m6.msky130_fd_pr__nfet_01v8_lvt[vds]
echo OPV XX1_M6 vds $&s1_xx1_m6_vds
let s1_xx1_m6_vbs = @m.x1.xdut.xx1_m6.msky130_fd_pr__nfet_01v8_lvt[vbs]
echo OPV XX1_M6 vbs $&s1_xx1_m6_vbs
let s1_xx1_m6_vth = @m.x1.xdut.xx1_m6.msky130_fd_pr__nfet_01v8_lvt[vth]
echo OPV XX1_M6 vth $&s1_xx1_m6_vth
let s1_xx1_m6_vdsat = @m.x1.xdut.xx1_m6.msky130_fd_pr__nfet_01v8_lvt[vdsat]
echo OPV XX1_M6 vdsat $&s1_xx1_m6_vdsat
let s1_xx1_m6_gm = @m.x1.xdut.xx1_m6.msky130_fd_pr__nfet_01v8_lvt[gm]
echo OPV XX1_M6 gm $&s1_xx1_m6_gm
let s1_xx1_m6_gds = @m.x1.xdut.xx1_m6.msky130_fd_pr__nfet_01v8_lvt[gds]
echo OPV XX1_M6 gds $&s1_xx1_m6_gds
let s1_xx1_m6_gmbs = @m.x1.xdut.xx1_m6.msky130_fd_pr__nfet_01v8_lvt[gmbs]
echo OPV XX1_M6 gmbs $&s1_xx1_m6_gmbs
let s1_xx1_m6_cgg = @m.x1.xdut.xx1_m6.msky130_fd_pr__nfet_01v8_lvt[cgg]
echo OPV XX1_M6 cgg $&s1_xx1_m6_cgg
let s1_xx1_m6_cgd = @m.x1.xdut.xx1_m6.msky130_fd_pr__nfet_01v8_lvt[cgd]
echo OPV XX1_M6 cgd $&s1_xx1_m6_cgd
let s1_xx1_m6_cgs = @m.x1.xdut.xx1_m6.msky130_fd_pr__nfet_01v8_lvt[cgs]
echo OPV XX1_M6 cgs $&s1_xx1_m6_cgs
let s1_xx1_m6_cgb = @m.x1.xdut.xx1_m6.msky130_fd_pr__nfet_01v8_lvt[cgb]
echo OPV XX1_M6 cgb $&s1_xx1_m6_cgb
let s1_xx1_m6_cdg = @m.x1.xdut.xx1_m6.msky130_fd_pr__nfet_01v8_lvt[cdg]
echo OPV XX1_M6 cdg $&s1_xx1_m6_cdg
let s1_xx1_m6_cdd = @m.x1.xdut.xx1_m6.msky130_fd_pr__nfet_01v8_lvt[cdd]
echo OPV XX1_M6 cdd $&s1_xx1_m6_cdd
let s1_xx1_m6_cds = @m.x1.xdut.xx1_m6.msky130_fd_pr__nfet_01v8_lvt[cds]
echo OPV XX1_M6 cds $&s1_xx1_m6_cds
let s1_xx1_m6_cdb = @m.x1.xdut.xx1_m6.msky130_fd_pr__nfet_01v8_lvt[cdb]
echo OPV XX1_M6 cdb $&s1_xx1_m6_cdb
let s1_xx1_m6_csg = @m.x1.xdut.xx1_m6.msky130_fd_pr__nfet_01v8_lvt[csg]
echo OPV XX1_M6 csg $&s1_xx1_m6_csg
let s1_xx1_m6_csd = @m.x1.xdut.xx1_m6.msky130_fd_pr__nfet_01v8_lvt[csd]
echo OPV XX1_M6 csd $&s1_xx1_m6_csd
let s1_xx1_m6_css = @m.x1.xdut.xx1_m6.msky130_fd_pr__nfet_01v8_lvt[css]
echo OPV XX1_M6 css $&s1_xx1_m6_css
let s1_xx1_m6_csb = @m.x1.xdut.xx1_m6.msky130_fd_pr__nfet_01v8_lvt[csb]
echo OPV XX1_M6 csb $&s1_xx1_m6_csb
let s1_xx1_m6_cbg = @m.x1.xdut.xx1_m6.msky130_fd_pr__nfet_01v8_lvt[cbg]
echo OPV XX1_M6 cbg $&s1_xx1_m6_cbg
let s1_xx1_m6_cbd = @m.x1.xdut.xx1_m6.msky130_fd_pr__nfet_01v8_lvt[cbd]
echo OPV XX1_M6 cbd $&s1_xx1_m6_cbd
let s1_xx1_m6_cbs = @m.x1.xdut.xx1_m6.msky130_fd_pr__nfet_01v8_lvt[cbs]
echo OPV XX1_M6 cbs $&s1_xx1_m6_cbs
let s1_xx1_m6_cbb = @m.x1.xdut.xx1_m6.msky130_fd_pr__nfet_01v8_lvt[cbb]
echo OPV XX1_M6 cbb $&s1_xx1_m6_cbb
let s1_xx1_m6_capbd = @m.x1.xdut.xx1_m6.msky130_fd_pr__nfet_01v8_lvt[capbd]
echo OPV XX1_M6 capbd $&s1_xx1_m6_capbd
let s1_xx1_m6_capbs = @m.x1.xdut.xx1_m6.msky130_fd_pr__nfet_01v8_lvt[capbs]
echo OPV XX1_M6 capbs $&s1_xx1_m6_capbs
let s1_xx1_m6_cgso = @m.x1.xdut.xx1_m6.msky130_fd_pr__nfet_01v8_lvt[cgso]
echo OPV XX1_M6 cgso $&s1_xx1_m6_cgso
let s1_xx1_m6_cgdo = @m.x1.xdut.xx1_m6.msky130_fd_pr__nfet_01v8_lvt[cgdo]
echo OPV XX1_M6 cgdo $&s1_xx1_m6_cgdo
let s1_xx1_m6_cgbo = @m.x1.xdut.xx1_m6.msky130_fd_pr__nfet_01v8_lvt[cgbo]
echo OPV XX1_M6 cgbo $&s1_xx1_m6_cgbo
let s1_xx1_m6_weff = @m.x1.xdut.xx1_m6.msky130_fd_pr__nfet_01v8_lvt[weff]
echo OPV XX1_M6 weff $&s1_xx1_m6_weff
let s1_xx1_m6_leff = @m.x1.xdut.xx1_m6.msky130_fd_pr__nfet_01v8_lvt[leff]
echo OPV XX1_M6 leff $&s1_xx1_m6_leff
let s1_xx1_m11_id = @m.x1.xdut.xx1_m11.msky130_fd_pr__pfet_01v8_lvt[id]
echo OPV XX1_M11 id $&s1_xx1_m11_id
let s1_xx1_m11_vgs = @m.x1.xdut.xx1_m11.msky130_fd_pr__pfet_01v8_lvt[vgs]
echo OPV XX1_M11 vgs $&s1_xx1_m11_vgs
let s1_xx1_m11_vds = @m.x1.xdut.xx1_m11.msky130_fd_pr__pfet_01v8_lvt[vds]
echo OPV XX1_M11 vds $&s1_xx1_m11_vds
let s1_xx1_m11_vbs = @m.x1.xdut.xx1_m11.msky130_fd_pr__pfet_01v8_lvt[vbs]
echo OPV XX1_M11 vbs $&s1_xx1_m11_vbs
let s1_xx1_m11_vth = @m.x1.xdut.xx1_m11.msky130_fd_pr__pfet_01v8_lvt[vth]
echo OPV XX1_M11 vth $&s1_xx1_m11_vth
let s1_xx1_m11_vdsat = @m.x1.xdut.xx1_m11.msky130_fd_pr__pfet_01v8_lvt[vdsat]
echo OPV XX1_M11 vdsat $&s1_xx1_m11_vdsat
let s1_xx1_m11_gm = @m.x1.xdut.xx1_m11.msky130_fd_pr__pfet_01v8_lvt[gm]
echo OPV XX1_M11 gm $&s1_xx1_m11_gm
let s1_xx1_m11_gds = @m.x1.xdut.xx1_m11.msky130_fd_pr__pfet_01v8_lvt[gds]
echo OPV XX1_M11 gds $&s1_xx1_m11_gds
let s1_xx1_m11_gmbs = @m.x1.xdut.xx1_m11.msky130_fd_pr__pfet_01v8_lvt[gmbs]
echo OPV XX1_M11 gmbs $&s1_xx1_m11_gmbs
let s1_xx1_m11_cgg = @m.x1.xdut.xx1_m11.msky130_fd_pr__pfet_01v8_lvt[cgg]
echo OPV XX1_M11 cgg $&s1_xx1_m11_cgg
let s1_xx1_m11_cgd = @m.x1.xdut.xx1_m11.msky130_fd_pr__pfet_01v8_lvt[cgd]
echo OPV XX1_M11 cgd $&s1_xx1_m11_cgd
let s1_xx1_m11_cgs = @m.x1.xdut.xx1_m11.msky130_fd_pr__pfet_01v8_lvt[cgs]
echo OPV XX1_M11 cgs $&s1_xx1_m11_cgs
let s1_xx1_m11_cgb = @m.x1.xdut.xx1_m11.msky130_fd_pr__pfet_01v8_lvt[cgb]
echo OPV XX1_M11 cgb $&s1_xx1_m11_cgb
let s1_xx1_m11_cdg = @m.x1.xdut.xx1_m11.msky130_fd_pr__pfet_01v8_lvt[cdg]
echo OPV XX1_M11 cdg $&s1_xx1_m11_cdg
let s1_xx1_m11_cdd = @m.x1.xdut.xx1_m11.msky130_fd_pr__pfet_01v8_lvt[cdd]
echo OPV XX1_M11 cdd $&s1_xx1_m11_cdd
let s1_xx1_m11_cds = @m.x1.xdut.xx1_m11.msky130_fd_pr__pfet_01v8_lvt[cds]
echo OPV XX1_M11 cds $&s1_xx1_m11_cds
let s1_xx1_m11_cdb = @m.x1.xdut.xx1_m11.msky130_fd_pr__pfet_01v8_lvt[cdb]
echo OPV XX1_M11 cdb $&s1_xx1_m11_cdb
let s1_xx1_m11_csg = @m.x1.xdut.xx1_m11.msky130_fd_pr__pfet_01v8_lvt[csg]
echo OPV XX1_M11 csg $&s1_xx1_m11_csg
let s1_xx1_m11_csd = @m.x1.xdut.xx1_m11.msky130_fd_pr__pfet_01v8_lvt[csd]
echo OPV XX1_M11 csd $&s1_xx1_m11_csd
let s1_xx1_m11_css = @m.x1.xdut.xx1_m11.msky130_fd_pr__pfet_01v8_lvt[css]
echo OPV XX1_M11 css $&s1_xx1_m11_css
let s1_xx1_m11_csb = @m.x1.xdut.xx1_m11.msky130_fd_pr__pfet_01v8_lvt[csb]
echo OPV XX1_M11 csb $&s1_xx1_m11_csb
let s1_xx1_m11_cbg = @m.x1.xdut.xx1_m11.msky130_fd_pr__pfet_01v8_lvt[cbg]
echo OPV XX1_M11 cbg $&s1_xx1_m11_cbg
let s1_xx1_m11_cbd = @m.x1.xdut.xx1_m11.msky130_fd_pr__pfet_01v8_lvt[cbd]
echo OPV XX1_M11 cbd $&s1_xx1_m11_cbd
let s1_xx1_m11_cbs = @m.x1.xdut.xx1_m11.msky130_fd_pr__pfet_01v8_lvt[cbs]
echo OPV XX1_M11 cbs $&s1_xx1_m11_cbs
let s1_xx1_m11_cbb = @m.x1.xdut.xx1_m11.msky130_fd_pr__pfet_01v8_lvt[cbb]
echo OPV XX1_M11 cbb $&s1_xx1_m11_cbb
let s1_xx1_m11_capbd = @m.x1.xdut.xx1_m11.msky130_fd_pr__pfet_01v8_lvt[capbd]
echo OPV XX1_M11 capbd $&s1_xx1_m11_capbd
let s1_xx1_m11_capbs = @m.x1.xdut.xx1_m11.msky130_fd_pr__pfet_01v8_lvt[capbs]
echo OPV XX1_M11 capbs $&s1_xx1_m11_capbs
let s1_xx1_m11_cgso = @m.x1.xdut.xx1_m11.msky130_fd_pr__pfet_01v8_lvt[cgso]
echo OPV XX1_M11 cgso $&s1_xx1_m11_cgso
let s1_xx1_m11_cgdo = @m.x1.xdut.xx1_m11.msky130_fd_pr__pfet_01v8_lvt[cgdo]
echo OPV XX1_M11 cgdo $&s1_xx1_m11_cgdo
let s1_xx1_m11_cgbo = @m.x1.xdut.xx1_m11.msky130_fd_pr__pfet_01v8_lvt[cgbo]
echo OPV XX1_M11 cgbo $&s1_xx1_m11_cgbo
let s1_xx1_m11_weff = @m.x1.xdut.xx1_m11.msky130_fd_pr__pfet_01v8_lvt[weff]
echo OPV XX1_M11 weff $&s1_xx1_m11_weff
let s1_xx1_m11_leff = @m.x1.xdut.xx1_m11.msky130_fd_pr__pfet_01v8_lvt[leff]
echo OPV XX1_M11 leff $&s1_xx1_m11_leff
let s1_xx1_m12_id = @m.x1.xdut.xx1_m12.msky130_fd_pr__pfet_01v8_lvt[id]
echo OPV XX1_M12 id $&s1_xx1_m12_id
let s1_xx1_m12_vgs = @m.x1.xdut.xx1_m12.msky130_fd_pr__pfet_01v8_lvt[vgs]
echo OPV XX1_M12 vgs $&s1_xx1_m12_vgs
let s1_xx1_m12_vds = @m.x1.xdut.xx1_m12.msky130_fd_pr__pfet_01v8_lvt[vds]
echo OPV XX1_M12 vds $&s1_xx1_m12_vds
let s1_xx1_m12_vbs = @m.x1.xdut.xx1_m12.msky130_fd_pr__pfet_01v8_lvt[vbs]
echo OPV XX1_M12 vbs $&s1_xx1_m12_vbs
let s1_xx1_m12_vth = @m.x1.xdut.xx1_m12.msky130_fd_pr__pfet_01v8_lvt[vth]
echo OPV XX1_M12 vth $&s1_xx1_m12_vth
let s1_xx1_m12_vdsat = @m.x1.xdut.xx1_m12.msky130_fd_pr__pfet_01v8_lvt[vdsat]
echo OPV XX1_M12 vdsat $&s1_xx1_m12_vdsat
let s1_xx1_m12_gm = @m.x1.xdut.xx1_m12.msky130_fd_pr__pfet_01v8_lvt[gm]
echo OPV XX1_M12 gm $&s1_xx1_m12_gm
let s1_xx1_m12_gds = @m.x1.xdut.xx1_m12.msky130_fd_pr__pfet_01v8_lvt[gds]
echo OPV XX1_M12 gds $&s1_xx1_m12_gds
let s1_xx1_m12_gmbs = @m.x1.xdut.xx1_m12.msky130_fd_pr__pfet_01v8_lvt[gmbs]
echo OPV XX1_M12 gmbs $&s1_xx1_m12_gmbs
let s1_xx1_m12_cgg = @m.x1.xdut.xx1_m12.msky130_fd_pr__pfet_01v8_lvt[cgg]
echo OPV XX1_M12 cgg $&s1_xx1_m12_cgg
let s1_xx1_m12_cgd = @m.x1.xdut.xx1_m12.msky130_fd_pr__pfet_01v8_lvt[cgd]
echo OPV XX1_M12 cgd $&s1_xx1_m12_cgd
let s1_xx1_m12_cgs = @m.x1.xdut.xx1_m12.msky130_fd_pr__pfet_01v8_lvt[cgs]
echo OPV XX1_M12 cgs $&s1_xx1_m12_cgs
let s1_xx1_m12_cgb = @m.x1.xdut.xx1_m12.msky130_fd_pr__pfet_01v8_lvt[cgb]
echo OPV XX1_M12 cgb $&s1_xx1_m12_cgb
let s1_xx1_m12_cdg = @m.x1.xdut.xx1_m12.msky130_fd_pr__pfet_01v8_lvt[cdg]
echo OPV XX1_M12 cdg $&s1_xx1_m12_cdg
let s1_xx1_m12_cdd = @m.x1.xdut.xx1_m12.msky130_fd_pr__pfet_01v8_lvt[cdd]
echo OPV XX1_M12 cdd $&s1_xx1_m12_cdd
let s1_xx1_m12_cds = @m.x1.xdut.xx1_m12.msky130_fd_pr__pfet_01v8_lvt[cds]
echo OPV XX1_M12 cds $&s1_xx1_m12_cds
let s1_xx1_m12_cdb = @m.x1.xdut.xx1_m12.msky130_fd_pr__pfet_01v8_lvt[cdb]
echo OPV XX1_M12 cdb $&s1_xx1_m12_cdb
let s1_xx1_m12_csg = @m.x1.xdut.xx1_m12.msky130_fd_pr__pfet_01v8_lvt[csg]
echo OPV XX1_M12 csg $&s1_xx1_m12_csg
let s1_xx1_m12_csd = @m.x1.xdut.xx1_m12.msky130_fd_pr__pfet_01v8_lvt[csd]
echo OPV XX1_M12 csd $&s1_xx1_m12_csd
let s1_xx1_m12_css = @m.x1.xdut.xx1_m12.msky130_fd_pr__pfet_01v8_lvt[css]
echo OPV XX1_M12 css $&s1_xx1_m12_css
let s1_xx1_m12_csb = @m.x1.xdut.xx1_m12.msky130_fd_pr__pfet_01v8_lvt[csb]
echo OPV XX1_M12 csb $&s1_xx1_m12_csb
let s1_xx1_m12_cbg = @m.x1.xdut.xx1_m12.msky130_fd_pr__pfet_01v8_lvt[cbg]
echo OPV XX1_M12 cbg $&s1_xx1_m12_cbg
let s1_xx1_m12_cbd = @m.x1.xdut.xx1_m12.msky130_fd_pr__pfet_01v8_lvt[cbd]
echo OPV XX1_M12 cbd $&s1_xx1_m12_cbd
let s1_xx1_m12_cbs = @m.x1.xdut.xx1_m12.msky130_fd_pr__pfet_01v8_lvt[cbs]
echo OPV XX1_M12 cbs $&s1_xx1_m12_cbs
let s1_xx1_m12_cbb = @m.x1.xdut.xx1_m12.msky130_fd_pr__pfet_01v8_lvt[cbb]
echo OPV XX1_M12 cbb $&s1_xx1_m12_cbb
let s1_xx1_m12_capbd = @m.x1.xdut.xx1_m12.msky130_fd_pr__pfet_01v8_lvt[capbd]
echo OPV XX1_M12 capbd $&s1_xx1_m12_capbd
let s1_xx1_m12_capbs = @m.x1.xdut.xx1_m12.msky130_fd_pr__pfet_01v8_lvt[capbs]
echo OPV XX1_M12 capbs $&s1_xx1_m12_capbs
let s1_xx1_m12_cgso = @m.x1.xdut.xx1_m12.msky130_fd_pr__pfet_01v8_lvt[cgso]
echo OPV XX1_M12 cgso $&s1_xx1_m12_cgso
let s1_xx1_m12_cgdo = @m.x1.xdut.xx1_m12.msky130_fd_pr__pfet_01v8_lvt[cgdo]
echo OPV XX1_M12 cgdo $&s1_xx1_m12_cgdo
let s1_xx1_m12_cgbo = @m.x1.xdut.xx1_m12.msky130_fd_pr__pfet_01v8_lvt[cgbo]
echo OPV XX1_M12 cgbo $&s1_xx1_m12_cgbo
let s1_xx1_m12_weff = @m.x1.xdut.xx1_m12.msky130_fd_pr__pfet_01v8_lvt[weff]
echo OPV XX1_M12 weff $&s1_xx1_m12_weff
let s1_xx1_m12_leff = @m.x1.xdut.xx1_m12.msky130_fd_pr__pfet_01v8_lvt[leff]
echo OPV XX1_M12 leff $&s1_xx1_m12_leff
let s1_xx1_m13_id = @m.x1.xdut.xx1_m13.msky130_fd_pr__pfet_01v8_lvt[id]
echo OPV XX1_M13 id $&s1_xx1_m13_id
let s1_xx1_m13_vgs = @m.x1.xdut.xx1_m13.msky130_fd_pr__pfet_01v8_lvt[vgs]
echo OPV XX1_M13 vgs $&s1_xx1_m13_vgs
let s1_xx1_m13_vds = @m.x1.xdut.xx1_m13.msky130_fd_pr__pfet_01v8_lvt[vds]
echo OPV XX1_M13 vds $&s1_xx1_m13_vds
let s1_xx1_m13_vbs = @m.x1.xdut.xx1_m13.msky130_fd_pr__pfet_01v8_lvt[vbs]
echo OPV XX1_M13 vbs $&s1_xx1_m13_vbs
let s1_xx1_m13_vth = @m.x1.xdut.xx1_m13.msky130_fd_pr__pfet_01v8_lvt[vth]
echo OPV XX1_M13 vth $&s1_xx1_m13_vth
let s1_xx1_m13_vdsat = @m.x1.xdut.xx1_m13.msky130_fd_pr__pfet_01v8_lvt[vdsat]
echo OPV XX1_M13 vdsat $&s1_xx1_m13_vdsat
let s1_xx1_m13_gm = @m.x1.xdut.xx1_m13.msky130_fd_pr__pfet_01v8_lvt[gm]
echo OPV XX1_M13 gm $&s1_xx1_m13_gm
let s1_xx1_m13_gds = @m.x1.xdut.xx1_m13.msky130_fd_pr__pfet_01v8_lvt[gds]
echo OPV XX1_M13 gds $&s1_xx1_m13_gds
let s1_xx1_m13_gmbs = @m.x1.xdut.xx1_m13.msky130_fd_pr__pfet_01v8_lvt[gmbs]
echo OPV XX1_M13 gmbs $&s1_xx1_m13_gmbs
let s1_xx1_m13_cgg = @m.x1.xdut.xx1_m13.msky130_fd_pr__pfet_01v8_lvt[cgg]
echo OPV XX1_M13 cgg $&s1_xx1_m13_cgg
let s1_xx1_m13_cgd = @m.x1.xdut.xx1_m13.msky130_fd_pr__pfet_01v8_lvt[cgd]
echo OPV XX1_M13 cgd $&s1_xx1_m13_cgd
let s1_xx1_m13_cgs = @m.x1.xdut.xx1_m13.msky130_fd_pr__pfet_01v8_lvt[cgs]
echo OPV XX1_M13 cgs $&s1_xx1_m13_cgs
let s1_xx1_m13_cgb = @m.x1.xdut.xx1_m13.msky130_fd_pr__pfet_01v8_lvt[cgb]
echo OPV XX1_M13 cgb $&s1_xx1_m13_cgb
let s1_xx1_m13_cdg = @m.x1.xdut.xx1_m13.msky130_fd_pr__pfet_01v8_lvt[cdg]
echo OPV XX1_M13 cdg $&s1_xx1_m13_cdg
let s1_xx1_m13_cdd = @m.x1.xdut.xx1_m13.msky130_fd_pr__pfet_01v8_lvt[cdd]
echo OPV XX1_M13 cdd $&s1_xx1_m13_cdd
let s1_xx1_m13_cds = @m.x1.xdut.xx1_m13.msky130_fd_pr__pfet_01v8_lvt[cds]
echo OPV XX1_M13 cds $&s1_xx1_m13_cds
let s1_xx1_m13_cdb = @m.x1.xdut.xx1_m13.msky130_fd_pr__pfet_01v8_lvt[cdb]
echo OPV XX1_M13 cdb $&s1_xx1_m13_cdb
let s1_xx1_m13_csg = @m.x1.xdut.xx1_m13.msky130_fd_pr__pfet_01v8_lvt[csg]
echo OPV XX1_M13 csg $&s1_xx1_m13_csg
let s1_xx1_m13_csd = @m.x1.xdut.xx1_m13.msky130_fd_pr__pfet_01v8_lvt[csd]
echo OPV XX1_M13 csd $&s1_xx1_m13_csd
let s1_xx1_m13_css = @m.x1.xdut.xx1_m13.msky130_fd_pr__pfet_01v8_lvt[css]
echo OPV XX1_M13 css $&s1_xx1_m13_css
let s1_xx1_m13_csb = @m.x1.xdut.xx1_m13.msky130_fd_pr__pfet_01v8_lvt[csb]
echo OPV XX1_M13 csb $&s1_xx1_m13_csb
let s1_xx1_m13_cbg = @m.x1.xdut.xx1_m13.msky130_fd_pr__pfet_01v8_lvt[cbg]
echo OPV XX1_M13 cbg $&s1_xx1_m13_cbg
let s1_xx1_m13_cbd = @m.x1.xdut.xx1_m13.msky130_fd_pr__pfet_01v8_lvt[cbd]
echo OPV XX1_M13 cbd $&s1_xx1_m13_cbd
let s1_xx1_m13_cbs = @m.x1.xdut.xx1_m13.msky130_fd_pr__pfet_01v8_lvt[cbs]
echo OPV XX1_M13 cbs $&s1_xx1_m13_cbs
let s1_xx1_m13_cbb = @m.x1.xdut.xx1_m13.msky130_fd_pr__pfet_01v8_lvt[cbb]
echo OPV XX1_M13 cbb $&s1_xx1_m13_cbb
let s1_xx1_m13_capbd = @m.x1.xdut.xx1_m13.msky130_fd_pr__pfet_01v8_lvt[capbd]
echo OPV XX1_M13 capbd $&s1_xx1_m13_capbd
let s1_xx1_m13_capbs = @m.x1.xdut.xx1_m13.msky130_fd_pr__pfet_01v8_lvt[capbs]
echo OPV XX1_M13 capbs $&s1_xx1_m13_capbs
let s1_xx1_m13_cgso = @m.x1.xdut.xx1_m13.msky130_fd_pr__pfet_01v8_lvt[cgso]
echo OPV XX1_M13 cgso $&s1_xx1_m13_cgso
let s1_xx1_m13_cgdo = @m.x1.xdut.xx1_m13.msky130_fd_pr__pfet_01v8_lvt[cgdo]
echo OPV XX1_M13 cgdo $&s1_xx1_m13_cgdo
let s1_xx1_m13_cgbo = @m.x1.xdut.xx1_m13.msky130_fd_pr__pfet_01v8_lvt[cgbo]
echo OPV XX1_M13 cgbo $&s1_xx1_m13_cgbo
let s1_xx1_m13_weff = @m.x1.xdut.xx1_m13.msky130_fd_pr__pfet_01v8_lvt[weff]
echo OPV XX1_M13 weff $&s1_xx1_m13_weff
let s1_xx1_m13_leff = @m.x1.xdut.xx1_m13.msky130_fd_pr__pfet_01v8_lvt[leff]
echo OPV XX1_M13 leff $&s1_xx1_m13_leff
let s1_xx1_m14_id = @m.x1.xdut.xx1_m14.msky130_fd_pr__pfet_01v8_lvt[id]
echo OPV XX1_M14 id $&s1_xx1_m14_id
let s1_xx1_m14_vgs = @m.x1.xdut.xx1_m14.msky130_fd_pr__pfet_01v8_lvt[vgs]
echo OPV XX1_M14 vgs $&s1_xx1_m14_vgs
let s1_xx1_m14_vds = @m.x1.xdut.xx1_m14.msky130_fd_pr__pfet_01v8_lvt[vds]
echo OPV XX1_M14 vds $&s1_xx1_m14_vds
let s1_xx1_m14_vbs = @m.x1.xdut.xx1_m14.msky130_fd_pr__pfet_01v8_lvt[vbs]
echo OPV XX1_M14 vbs $&s1_xx1_m14_vbs
let s1_xx1_m14_vth = @m.x1.xdut.xx1_m14.msky130_fd_pr__pfet_01v8_lvt[vth]
echo OPV XX1_M14 vth $&s1_xx1_m14_vth
let s1_xx1_m14_vdsat = @m.x1.xdut.xx1_m14.msky130_fd_pr__pfet_01v8_lvt[vdsat]
echo OPV XX1_M14 vdsat $&s1_xx1_m14_vdsat
let s1_xx1_m14_gm = @m.x1.xdut.xx1_m14.msky130_fd_pr__pfet_01v8_lvt[gm]
echo OPV XX1_M14 gm $&s1_xx1_m14_gm
let s1_xx1_m14_gds = @m.x1.xdut.xx1_m14.msky130_fd_pr__pfet_01v8_lvt[gds]
echo OPV XX1_M14 gds $&s1_xx1_m14_gds
let s1_xx1_m14_gmbs = @m.x1.xdut.xx1_m14.msky130_fd_pr__pfet_01v8_lvt[gmbs]
echo OPV XX1_M14 gmbs $&s1_xx1_m14_gmbs
let s1_xx1_m14_cgg = @m.x1.xdut.xx1_m14.msky130_fd_pr__pfet_01v8_lvt[cgg]
echo OPV XX1_M14 cgg $&s1_xx1_m14_cgg
let s1_xx1_m14_cgd = @m.x1.xdut.xx1_m14.msky130_fd_pr__pfet_01v8_lvt[cgd]
echo OPV XX1_M14 cgd $&s1_xx1_m14_cgd
let s1_xx1_m14_cgs = @m.x1.xdut.xx1_m14.msky130_fd_pr__pfet_01v8_lvt[cgs]
echo OPV XX1_M14 cgs $&s1_xx1_m14_cgs
let s1_xx1_m14_cgb = @m.x1.xdut.xx1_m14.msky130_fd_pr__pfet_01v8_lvt[cgb]
echo OPV XX1_M14 cgb $&s1_xx1_m14_cgb
let s1_xx1_m14_cdg = @m.x1.xdut.xx1_m14.msky130_fd_pr__pfet_01v8_lvt[cdg]
echo OPV XX1_M14 cdg $&s1_xx1_m14_cdg
let s1_xx1_m14_cdd = @m.x1.xdut.xx1_m14.msky130_fd_pr__pfet_01v8_lvt[cdd]
echo OPV XX1_M14 cdd $&s1_xx1_m14_cdd
let s1_xx1_m14_cds = @m.x1.xdut.xx1_m14.msky130_fd_pr__pfet_01v8_lvt[cds]
echo OPV XX1_M14 cds $&s1_xx1_m14_cds
let s1_xx1_m14_cdb = @m.x1.xdut.xx1_m14.msky130_fd_pr__pfet_01v8_lvt[cdb]
echo OPV XX1_M14 cdb $&s1_xx1_m14_cdb
let s1_xx1_m14_csg = @m.x1.xdut.xx1_m14.msky130_fd_pr__pfet_01v8_lvt[csg]
echo OPV XX1_M14 csg $&s1_xx1_m14_csg
let s1_xx1_m14_csd = @m.x1.xdut.xx1_m14.msky130_fd_pr__pfet_01v8_lvt[csd]
echo OPV XX1_M14 csd $&s1_xx1_m14_csd
let s1_xx1_m14_css = @m.x1.xdut.xx1_m14.msky130_fd_pr__pfet_01v8_lvt[css]
echo OPV XX1_M14 css $&s1_xx1_m14_css
let s1_xx1_m14_csb = @m.x1.xdut.xx1_m14.msky130_fd_pr__pfet_01v8_lvt[csb]
echo OPV XX1_M14 csb $&s1_xx1_m14_csb
let s1_xx1_m14_cbg = @m.x1.xdut.xx1_m14.msky130_fd_pr__pfet_01v8_lvt[cbg]
echo OPV XX1_M14 cbg $&s1_xx1_m14_cbg
let s1_xx1_m14_cbd = @m.x1.xdut.xx1_m14.msky130_fd_pr__pfet_01v8_lvt[cbd]
echo OPV XX1_M14 cbd $&s1_xx1_m14_cbd
let s1_xx1_m14_cbs = @m.x1.xdut.xx1_m14.msky130_fd_pr__pfet_01v8_lvt[cbs]
echo OPV XX1_M14 cbs $&s1_xx1_m14_cbs
let s1_xx1_m14_cbb = @m.x1.xdut.xx1_m14.msky130_fd_pr__pfet_01v8_lvt[cbb]
echo OPV XX1_M14 cbb $&s1_xx1_m14_cbb
let s1_xx1_m14_capbd = @m.x1.xdut.xx1_m14.msky130_fd_pr__pfet_01v8_lvt[capbd]
echo OPV XX1_M14 capbd $&s1_xx1_m14_capbd
let s1_xx1_m14_capbs = @m.x1.xdut.xx1_m14.msky130_fd_pr__pfet_01v8_lvt[capbs]
echo OPV XX1_M14 capbs $&s1_xx1_m14_capbs
let s1_xx1_m14_cgso = @m.x1.xdut.xx1_m14.msky130_fd_pr__pfet_01v8_lvt[cgso]
echo OPV XX1_M14 cgso $&s1_xx1_m14_cgso
let s1_xx1_m14_cgdo = @m.x1.xdut.xx1_m14.msky130_fd_pr__pfet_01v8_lvt[cgdo]
echo OPV XX1_M14 cgdo $&s1_xx1_m14_cgdo
let s1_xx1_m14_cgbo = @m.x1.xdut.xx1_m14.msky130_fd_pr__pfet_01v8_lvt[cgbo]
echo OPV XX1_M14 cgbo $&s1_xx1_m14_cgbo
let s1_xx1_m14_weff = @m.x1.xdut.xx1_m14.msky130_fd_pr__pfet_01v8_lvt[weff]
echo OPV XX1_M14 weff $&s1_xx1_m14_weff
let s1_xx1_m14_leff = @m.x1.xdut.xx1_m14.msky130_fd_pr__pfet_01v8_lvt[leff]
echo OPV XX1_M14 leff $&s1_xx1_m14_leff
let s1_xx1_m19_id = @m.x1.xdut.xx1_m19.msky130_fd_pr__nfet_01v8_lvt[id]
echo OPV XX1_M19 id $&s1_xx1_m19_id
let s1_xx1_m19_vgs = @m.x1.xdut.xx1_m19.msky130_fd_pr__nfet_01v8_lvt[vgs]
echo OPV XX1_M19 vgs $&s1_xx1_m19_vgs
let s1_xx1_m19_vds = @m.x1.xdut.xx1_m19.msky130_fd_pr__nfet_01v8_lvt[vds]
echo OPV XX1_M19 vds $&s1_xx1_m19_vds
let s1_xx1_m19_vbs = @m.x1.xdut.xx1_m19.msky130_fd_pr__nfet_01v8_lvt[vbs]
echo OPV XX1_M19 vbs $&s1_xx1_m19_vbs
let s1_xx1_m19_vth = @m.x1.xdut.xx1_m19.msky130_fd_pr__nfet_01v8_lvt[vth]
echo OPV XX1_M19 vth $&s1_xx1_m19_vth
let s1_xx1_m19_vdsat = @m.x1.xdut.xx1_m19.msky130_fd_pr__nfet_01v8_lvt[vdsat]
echo OPV XX1_M19 vdsat $&s1_xx1_m19_vdsat
let s1_xx1_m19_gm = @m.x1.xdut.xx1_m19.msky130_fd_pr__nfet_01v8_lvt[gm]
echo OPV XX1_M19 gm $&s1_xx1_m19_gm
let s1_xx1_m19_gds = @m.x1.xdut.xx1_m19.msky130_fd_pr__nfet_01v8_lvt[gds]
echo OPV XX1_M19 gds $&s1_xx1_m19_gds
let s1_xx1_m19_gmbs = @m.x1.xdut.xx1_m19.msky130_fd_pr__nfet_01v8_lvt[gmbs]
echo OPV XX1_M19 gmbs $&s1_xx1_m19_gmbs
let s1_xx1_m19_cgg = @m.x1.xdut.xx1_m19.msky130_fd_pr__nfet_01v8_lvt[cgg]
echo OPV XX1_M19 cgg $&s1_xx1_m19_cgg
let s1_xx1_m19_cgd = @m.x1.xdut.xx1_m19.msky130_fd_pr__nfet_01v8_lvt[cgd]
echo OPV XX1_M19 cgd $&s1_xx1_m19_cgd
let s1_xx1_m19_cgs = @m.x1.xdut.xx1_m19.msky130_fd_pr__nfet_01v8_lvt[cgs]
echo OPV XX1_M19 cgs $&s1_xx1_m19_cgs
let s1_xx1_m19_cgb = @m.x1.xdut.xx1_m19.msky130_fd_pr__nfet_01v8_lvt[cgb]
echo OPV XX1_M19 cgb $&s1_xx1_m19_cgb
let s1_xx1_m19_cdg = @m.x1.xdut.xx1_m19.msky130_fd_pr__nfet_01v8_lvt[cdg]
echo OPV XX1_M19 cdg $&s1_xx1_m19_cdg
let s1_xx1_m19_cdd = @m.x1.xdut.xx1_m19.msky130_fd_pr__nfet_01v8_lvt[cdd]
echo OPV XX1_M19 cdd $&s1_xx1_m19_cdd
let s1_xx1_m19_cds = @m.x1.xdut.xx1_m19.msky130_fd_pr__nfet_01v8_lvt[cds]
echo OPV XX1_M19 cds $&s1_xx1_m19_cds
let s1_xx1_m19_cdb = @m.x1.xdut.xx1_m19.msky130_fd_pr__nfet_01v8_lvt[cdb]
echo OPV XX1_M19 cdb $&s1_xx1_m19_cdb
let s1_xx1_m19_csg = @m.x1.xdut.xx1_m19.msky130_fd_pr__nfet_01v8_lvt[csg]
echo OPV XX1_M19 csg $&s1_xx1_m19_csg
let s1_xx1_m19_csd = @m.x1.xdut.xx1_m19.msky130_fd_pr__nfet_01v8_lvt[csd]
echo OPV XX1_M19 csd $&s1_xx1_m19_csd
let s1_xx1_m19_css = @m.x1.xdut.xx1_m19.msky130_fd_pr__nfet_01v8_lvt[css]
echo OPV XX1_M19 css $&s1_xx1_m19_css
let s1_xx1_m19_csb = @m.x1.xdut.xx1_m19.msky130_fd_pr__nfet_01v8_lvt[csb]
echo OPV XX1_M19 csb $&s1_xx1_m19_csb
let s1_xx1_m19_cbg = @m.x1.xdut.xx1_m19.msky130_fd_pr__nfet_01v8_lvt[cbg]
echo OPV XX1_M19 cbg $&s1_xx1_m19_cbg
let s1_xx1_m19_cbd = @m.x1.xdut.xx1_m19.msky130_fd_pr__nfet_01v8_lvt[cbd]
echo OPV XX1_M19 cbd $&s1_xx1_m19_cbd
let s1_xx1_m19_cbs = @m.x1.xdut.xx1_m19.msky130_fd_pr__nfet_01v8_lvt[cbs]
echo OPV XX1_M19 cbs $&s1_xx1_m19_cbs
let s1_xx1_m19_cbb = @m.x1.xdut.xx1_m19.msky130_fd_pr__nfet_01v8_lvt[cbb]
echo OPV XX1_M19 cbb $&s1_xx1_m19_cbb
let s1_xx1_m19_capbd = @m.x1.xdut.xx1_m19.msky130_fd_pr__nfet_01v8_lvt[capbd]
echo OPV XX1_M19 capbd $&s1_xx1_m19_capbd
let s1_xx1_m19_capbs = @m.x1.xdut.xx1_m19.msky130_fd_pr__nfet_01v8_lvt[capbs]
echo OPV XX1_M19 capbs $&s1_xx1_m19_capbs
let s1_xx1_m19_cgso = @m.x1.xdut.xx1_m19.msky130_fd_pr__nfet_01v8_lvt[cgso]
echo OPV XX1_M19 cgso $&s1_xx1_m19_cgso
let s1_xx1_m19_cgdo = @m.x1.xdut.xx1_m19.msky130_fd_pr__nfet_01v8_lvt[cgdo]
echo OPV XX1_M19 cgdo $&s1_xx1_m19_cgdo
let s1_xx1_m19_cgbo = @m.x1.xdut.xx1_m19.msky130_fd_pr__nfet_01v8_lvt[cgbo]
echo OPV XX1_M19 cgbo $&s1_xx1_m19_cgbo
let s1_xx1_m19_weff = @m.x1.xdut.xx1_m19.msky130_fd_pr__nfet_01v8_lvt[weff]
echo OPV XX1_M19 weff $&s1_xx1_m19_weff
let s1_xx1_m19_leff = @m.x1.xdut.xx1_m19.msky130_fd_pr__nfet_01v8_lvt[leff]
echo OPV XX1_M19 leff $&s1_xx1_m19_leff
let s1_xx1_m1_id = @m.x1.xdut.xx1_m1.msky130_fd_pr__nfet_01v8_lvt[id]
echo OPV XX1_M1 id $&s1_xx1_m1_id
let s1_xx1_m1_vgs = @m.x1.xdut.xx1_m1.msky130_fd_pr__nfet_01v8_lvt[vgs]
echo OPV XX1_M1 vgs $&s1_xx1_m1_vgs
let s1_xx1_m1_vds = @m.x1.xdut.xx1_m1.msky130_fd_pr__nfet_01v8_lvt[vds]
echo OPV XX1_M1 vds $&s1_xx1_m1_vds
let s1_xx1_m1_vbs = @m.x1.xdut.xx1_m1.msky130_fd_pr__nfet_01v8_lvt[vbs]
echo OPV XX1_M1 vbs $&s1_xx1_m1_vbs
let s1_xx1_m1_vth = @m.x1.xdut.xx1_m1.msky130_fd_pr__nfet_01v8_lvt[vth]
echo OPV XX1_M1 vth $&s1_xx1_m1_vth
let s1_xx1_m1_vdsat = @m.x1.xdut.xx1_m1.msky130_fd_pr__nfet_01v8_lvt[vdsat]
echo OPV XX1_M1 vdsat $&s1_xx1_m1_vdsat
let s1_xx1_m1_gm = @m.x1.xdut.xx1_m1.msky130_fd_pr__nfet_01v8_lvt[gm]
echo OPV XX1_M1 gm $&s1_xx1_m1_gm
let s1_xx1_m1_gds = @m.x1.xdut.xx1_m1.msky130_fd_pr__nfet_01v8_lvt[gds]
echo OPV XX1_M1 gds $&s1_xx1_m1_gds
let s1_xx1_m1_gmbs = @m.x1.xdut.xx1_m1.msky130_fd_pr__nfet_01v8_lvt[gmbs]
echo OPV XX1_M1 gmbs $&s1_xx1_m1_gmbs
let s1_xx1_m1_cgg = @m.x1.xdut.xx1_m1.msky130_fd_pr__nfet_01v8_lvt[cgg]
echo OPV XX1_M1 cgg $&s1_xx1_m1_cgg
let s1_xx1_m1_cgd = @m.x1.xdut.xx1_m1.msky130_fd_pr__nfet_01v8_lvt[cgd]
echo OPV XX1_M1 cgd $&s1_xx1_m1_cgd
let s1_xx1_m1_cgs = @m.x1.xdut.xx1_m1.msky130_fd_pr__nfet_01v8_lvt[cgs]
echo OPV XX1_M1 cgs $&s1_xx1_m1_cgs
let s1_xx1_m1_cgb = @m.x1.xdut.xx1_m1.msky130_fd_pr__nfet_01v8_lvt[cgb]
echo OPV XX1_M1 cgb $&s1_xx1_m1_cgb
let s1_xx1_m1_cdg = @m.x1.xdut.xx1_m1.msky130_fd_pr__nfet_01v8_lvt[cdg]
echo OPV XX1_M1 cdg $&s1_xx1_m1_cdg
let s1_xx1_m1_cdd = @m.x1.xdut.xx1_m1.msky130_fd_pr__nfet_01v8_lvt[cdd]
echo OPV XX1_M1 cdd $&s1_xx1_m1_cdd
let s1_xx1_m1_cds = @m.x1.xdut.xx1_m1.msky130_fd_pr__nfet_01v8_lvt[cds]
echo OPV XX1_M1 cds $&s1_xx1_m1_cds
let s1_xx1_m1_cdb = @m.x1.xdut.xx1_m1.msky130_fd_pr__nfet_01v8_lvt[cdb]
echo OPV XX1_M1 cdb $&s1_xx1_m1_cdb
let s1_xx1_m1_csg = @m.x1.xdut.xx1_m1.msky130_fd_pr__nfet_01v8_lvt[csg]
echo OPV XX1_M1 csg $&s1_xx1_m1_csg
let s1_xx1_m1_csd = @m.x1.xdut.xx1_m1.msky130_fd_pr__nfet_01v8_lvt[csd]
echo OPV XX1_M1 csd $&s1_xx1_m1_csd
let s1_xx1_m1_css = @m.x1.xdut.xx1_m1.msky130_fd_pr__nfet_01v8_lvt[css]
echo OPV XX1_M1 css $&s1_xx1_m1_css
let s1_xx1_m1_csb = @m.x1.xdut.xx1_m1.msky130_fd_pr__nfet_01v8_lvt[csb]
echo OPV XX1_M1 csb $&s1_xx1_m1_csb
let s1_xx1_m1_cbg = @m.x1.xdut.xx1_m1.msky130_fd_pr__nfet_01v8_lvt[cbg]
echo OPV XX1_M1 cbg $&s1_xx1_m1_cbg
let s1_xx1_m1_cbd = @m.x1.xdut.xx1_m1.msky130_fd_pr__nfet_01v8_lvt[cbd]
echo OPV XX1_M1 cbd $&s1_xx1_m1_cbd
let s1_xx1_m1_cbs = @m.x1.xdut.xx1_m1.msky130_fd_pr__nfet_01v8_lvt[cbs]
echo OPV XX1_M1 cbs $&s1_xx1_m1_cbs
let s1_xx1_m1_cbb = @m.x1.xdut.xx1_m1.msky130_fd_pr__nfet_01v8_lvt[cbb]
echo OPV XX1_M1 cbb $&s1_xx1_m1_cbb
let s1_xx1_m1_capbd = @m.x1.xdut.xx1_m1.msky130_fd_pr__nfet_01v8_lvt[capbd]
echo OPV XX1_M1 capbd $&s1_xx1_m1_capbd
let s1_xx1_m1_capbs = @m.x1.xdut.xx1_m1.msky130_fd_pr__nfet_01v8_lvt[capbs]
echo OPV XX1_M1 capbs $&s1_xx1_m1_capbs
let s1_xx1_m1_cgso = @m.x1.xdut.xx1_m1.msky130_fd_pr__nfet_01v8_lvt[cgso]
echo OPV XX1_M1 cgso $&s1_xx1_m1_cgso
let s1_xx1_m1_cgdo = @m.x1.xdut.xx1_m1.msky130_fd_pr__nfet_01v8_lvt[cgdo]
echo OPV XX1_M1 cgdo $&s1_xx1_m1_cgdo
let s1_xx1_m1_cgbo = @m.x1.xdut.xx1_m1.msky130_fd_pr__nfet_01v8_lvt[cgbo]
echo OPV XX1_M1 cgbo $&s1_xx1_m1_cgbo
let s1_xx1_m1_weff = @m.x1.xdut.xx1_m1.msky130_fd_pr__nfet_01v8_lvt[weff]
echo OPV XX1_M1 weff $&s1_xx1_m1_weff
let s1_xx1_m1_leff = @m.x1.xdut.xx1_m1.msky130_fd_pr__nfet_01v8_lvt[leff]
echo OPV XX1_M1 leff $&s1_xx1_m1_leff
let s1_xx1_m2_id = @m.x1.xdut.xx1_m2.msky130_fd_pr__nfet_01v8_lvt[id]
echo OPV XX1_M2 id $&s1_xx1_m2_id
let s1_xx1_m2_vgs = @m.x1.xdut.xx1_m2.msky130_fd_pr__nfet_01v8_lvt[vgs]
echo OPV XX1_M2 vgs $&s1_xx1_m2_vgs
let s1_xx1_m2_vds = @m.x1.xdut.xx1_m2.msky130_fd_pr__nfet_01v8_lvt[vds]
echo OPV XX1_M2 vds $&s1_xx1_m2_vds
let s1_xx1_m2_vbs = @m.x1.xdut.xx1_m2.msky130_fd_pr__nfet_01v8_lvt[vbs]
echo OPV XX1_M2 vbs $&s1_xx1_m2_vbs
let s1_xx1_m2_vth = @m.x1.xdut.xx1_m2.msky130_fd_pr__nfet_01v8_lvt[vth]
echo OPV XX1_M2 vth $&s1_xx1_m2_vth
let s1_xx1_m2_vdsat = @m.x1.xdut.xx1_m2.msky130_fd_pr__nfet_01v8_lvt[vdsat]
echo OPV XX1_M2 vdsat $&s1_xx1_m2_vdsat
let s1_xx1_m2_gm = @m.x1.xdut.xx1_m2.msky130_fd_pr__nfet_01v8_lvt[gm]
echo OPV XX1_M2 gm $&s1_xx1_m2_gm
let s1_xx1_m2_gds = @m.x1.xdut.xx1_m2.msky130_fd_pr__nfet_01v8_lvt[gds]
echo OPV XX1_M2 gds $&s1_xx1_m2_gds
let s1_xx1_m2_gmbs = @m.x1.xdut.xx1_m2.msky130_fd_pr__nfet_01v8_lvt[gmbs]
echo OPV XX1_M2 gmbs $&s1_xx1_m2_gmbs
let s1_xx1_m2_cgg = @m.x1.xdut.xx1_m2.msky130_fd_pr__nfet_01v8_lvt[cgg]
echo OPV XX1_M2 cgg $&s1_xx1_m2_cgg
let s1_xx1_m2_cgd = @m.x1.xdut.xx1_m2.msky130_fd_pr__nfet_01v8_lvt[cgd]
echo OPV XX1_M2 cgd $&s1_xx1_m2_cgd
let s1_xx1_m2_cgs = @m.x1.xdut.xx1_m2.msky130_fd_pr__nfet_01v8_lvt[cgs]
echo OPV XX1_M2 cgs $&s1_xx1_m2_cgs
let s1_xx1_m2_cgb = @m.x1.xdut.xx1_m2.msky130_fd_pr__nfet_01v8_lvt[cgb]
echo OPV XX1_M2 cgb $&s1_xx1_m2_cgb
let s1_xx1_m2_cdg = @m.x1.xdut.xx1_m2.msky130_fd_pr__nfet_01v8_lvt[cdg]
echo OPV XX1_M2 cdg $&s1_xx1_m2_cdg
let s1_xx1_m2_cdd = @m.x1.xdut.xx1_m2.msky130_fd_pr__nfet_01v8_lvt[cdd]
echo OPV XX1_M2 cdd $&s1_xx1_m2_cdd
let s1_xx1_m2_cds = @m.x1.xdut.xx1_m2.msky130_fd_pr__nfet_01v8_lvt[cds]
echo OPV XX1_M2 cds $&s1_xx1_m2_cds
let s1_xx1_m2_cdb = @m.x1.xdut.xx1_m2.msky130_fd_pr__nfet_01v8_lvt[cdb]
echo OPV XX1_M2 cdb $&s1_xx1_m2_cdb
let s1_xx1_m2_csg = @m.x1.xdut.xx1_m2.msky130_fd_pr__nfet_01v8_lvt[csg]
echo OPV XX1_M2 csg $&s1_xx1_m2_csg
let s1_xx1_m2_csd = @m.x1.xdut.xx1_m2.msky130_fd_pr__nfet_01v8_lvt[csd]
echo OPV XX1_M2 csd $&s1_xx1_m2_csd
let s1_xx1_m2_css = @m.x1.xdut.xx1_m2.msky130_fd_pr__nfet_01v8_lvt[css]
echo OPV XX1_M2 css $&s1_xx1_m2_css
let s1_xx1_m2_csb = @m.x1.xdut.xx1_m2.msky130_fd_pr__nfet_01v8_lvt[csb]
echo OPV XX1_M2 csb $&s1_xx1_m2_csb
let s1_xx1_m2_cbg = @m.x1.xdut.xx1_m2.msky130_fd_pr__nfet_01v8_lvt[cbg]
echo OPV XX1_M2 cbg $&s1_xx1_m2_cbg
let s1_xx1_m2_cbd = @m.x1.xdut.xx1_m2.msky130_fd_pr__nfet_01v8_lvt[cbd]
echo OPV XX1_M2 cbd $&s1_xx1_m2_cbd
let s1_xx1_m2_cbs = @m.x1.xdut.xx1_m2.msky130_fd_pr__nfet_01v8_lvt[cbs]
echo OPV XX1_M2 cbs $&s1_xx1_m2_cbs
let s1_xx1_m2_cbb = @m.x1.xdut.xx1_m2.msky130_fd_pr__nfet_01v8_lvt[cbb]
echo OPV XX1_M2 cbb $&s1_xx1_m2_cbb
let s1_xx1_m2_capbd = @m.x1.xdut.xx1_m2.msky130_fd_pr__nfet_01v8_lvt[capbd]
echo OPV XX1_M2 capbd $&s1_xx1_m2_capbd
let s1_xx1_m2_capbs = @m.x1.xdut.xx1_m2.msky130_fd_pr__nfet_01v8_lvt[capbs]
echo OPV XX1_M2 capbs $&s1_xx1_m2_capbs
let s1_xx1_m2_cgso = @m.x1.xdut.xx1_m2.msky130_fd_pr__nfet_01v8_lvt[cgso]
echo OPV XX1_M2 cgso $&s1_xx1_m2_cgso
let s1_xx1_m2_cgdo = @m.x1.xdut.xx1_m2.msky130_fd_pr__nfet_01v8_lvt[cgdo]
echo OPV XX1_M2 cgdo $&s1_xx1_m2_cgdo
let s1_xx1_m2_cgbo = @m.x1.xdut.xx1_m2.msky130_fd_pr__nfet_01v8_lvt[cgbo]
echo OPV XX1_M2 cgbo $&s1_xx1_m2_cgbo
let s1_xx1_m2_weff = @m.x1.xdut.xx1_m2.msky130_fd_pr__nfet_01v8_lvt[weff]
echo OPV XX1_M2 weff $&s1_xx1_m2_weff
let s1_xx1_m2_leff = @m.x1.xdut.xx1_m2.msky130_fd_pr__nfet_01v8_lvt[leff]
echo OPV XX1_M2 leff $&s1_xx1_m2_leff
let s1_xx1_m3_id = @m.x1.xdut.xx1_m3.msky130_fd_pr__nfet_01v8_lvt[id]
echo OPV XX1_M3 id $&s1_xx1_m3_id
let s1_xx1_m3_vgs = @m.x1.xdut.xx1_m3.msky130_fd_pr__nfet_01v8_lvt[vgs]
echo OPV XX1_M3 vgs $&s1_xx1_m3_vgs
let s1_xx1_m3_vds = @m.x1.xdut.xx1_m3.msky130_fd_pr__nfet_01v8_lvt[vds]
echo OPV XX1_M3 vds $&s1_xx1_m3_vds
let s1_xx1_m3_vbs = @m.x1.xdut.xx1_m3.msky130_fd_pr__nfet_01v8_lvt[vbs]
echo OPV XX1_M3 vbs $&s1_xx1_m3_vbs
let s1_xx1_m3_vth = @m.x1.xdut.xx1_m3.msky130_fd_pr__nfet_01v8_lvt[vth]
echo OPV XX1_M3 vth $&s1_xx1_m3_vth
let s1_xx1_m3_vdsat = @m.x1.xdut.xx1_m3.msky130_fd_pr__nfet_01v8_lvt[vdsat]
echo OPV XX1_M3 vdsat $&s1_xx1_m3_vdsat
let s1_xx1_m3_gm = @m.x1.xdut.xx1_m3.msky130_fd_pr__nfet_01v8_lvt[gm]
echo OPV XX1_M3 gm $&s1_xx1_m3_gm
let s1_xx1_m3_gds = @m.x1.xdut.xx1_m3.msky130_fd_pr__nfet_01v8_lvt[gds]
echo OPV XX1_M3 gds $&s1_xx1_m3_gds
let s1_xx1_m3_gmbs = @m.x1.xdut.xx1_m3.msky130_fd_pr__nfet_01v8_lvt[gmbs]
echo OPV XX1_M3 gmbs $&s1_xx1_m3_gmbs
let s1_xx1_m3_cgg = @m.x1.xdut.xx1_m3.msky130_fd_pr__nfet_01v8_lvt[cgg]
echo OPV XX1_M3 cgg $&s1_xx1_m3_cgg
let s1_xx1_m3_cgd = @m.x1.xdut.xx1_m3.msky130_fd_pr__nfet_01v8_lvt[cgd]
echo OPV XX1_M3 cgd $&s1_xx1_m3_cgd
let s1_xx1_m3_cgs = @m.x1.xdut.xx1_m3.msky130_fd_pr__nfet_01v8_lvt[cgs]
echo OPV XX1_M3 cgs $&s1_xx1_m3_cgs
let s1_xx1_m3_cgb = @m.x1.xdut.xx1_m3.msky130_fd_pr__nfet_01v8_lvt[cgb]
echo OPV XX1_M3 cgb $&s1_xx1_m3_cgb
let s1_xx1_m3_cdg = @m.x1.xdut.xx1_m3.msky130_fd_pr__nfet_01v8_lvt[cdg]
echo OPV XX1_M3 cdg $&s1_xx1_m3_cdg
let s1_xx1_m3_cdd = @m.x1.xdut.xx1_m3.msky130_fd_pr__nfet_01v8_lvt[cdd]
echo OPV XX1_M3 cdd $&s1_xx1_m3_cdd
let s1_xx1_m3_cds = @m.x1.xdut.xx1_m3.msky130_fd_pr__nfet_01v8_lvt[cds]
echo OPV XX1_M3 cds $&s1_xx1_m3_cds
let s1_xx1_m3_cdb = @m.x1.xdut.xx1_m3.msky130_fd_pr__nfet_01v8_lvt[cdb]
echo OPV XX1_M3 cdb $&s1_xx1_m3_cdb
let s1_xx1_m3_csg = @m.x1.xdut.xx1_m3.msky130_fd_pr__nfet_01v8_lvt[csg]
echo OPV XX1_M3 csg $&s1_xx1_m3_csg
let s1_xx1_m3_csd = @m.x1.xdut.xx1_m3.msky130_fd_pr__nfet_01v8_lvt[csd]
echo OPV XX1_M3 csd $&s1_xx1_m3_csd
let s1_xx1_m3_css = @m.x1.xdut.xx1_m3.msky130_fd_pr__nfet_01v8_lvt[css]
echo OPV XX1_M3 css $&s1_xx1_m3_css
let s1_xx1_m3_csb = @m.x1.xdut.xx1_m3.msky130_fd_pr__nfet_01v8_lvt[csb]
echo OPV XX1_M3 csb $&s1_xx1_m3_csb
let s1_xx1_m3_cbg = @m.x1.xdut.xx1_m3.msky130_fd_pr__nfet_01v8_lvt[cbg]
echo OPV XX1_M3 cbg $&s1_xx1_m3_cbg
let s1_xx1_m3_cbd = @m.x1.xdut.xx1_m3.msky130_fd_pr__nfet_01v8_lvt[cbd]
echo OPV XX1_M3 cbd $&s1_xx1_m3_cbd
let s1_xx1_m3_cbs = @m.x1.xdut.xx1_m3.msky130_fd_pr__nfet_01v8_lvt[cbs]
echo OPV XX1_M3 cbs $&s1_xx1_m3_cbs
let s1_xx1_m3_cbb = @m.x1.xdut.xx1_m3.msky130_fd_pr__nfet_01v8_lvt[cbb]
echo OPV XX1_M3 cbb $&s1_xx1_m3_cbb
let s1_xx1_m3_capbd = @m.x1.xdut.xx1_m3.msky130_fd_pr__nfet_01v8_lvt[capbd]
echo OPV XX1_M3 capbd $&s1_xx1_m3_capbd
let s1_xx1_m3_capbs = @m.x1.xdut.xx1_m3.msky130_fd_pr__nfet_01v8_lvt[capbs]
echo OPV XX1_M3 capbs $&s1_xx1_m3_capbs
let s1_xx1_m3_cgso = @m.x1.xdut.xx1_m3.msky130_fd_pr__nfet_01v8_lvt[cgso]
echo OPV XX1_M3 cgso $&s1_xx1_m3_cgso
let s1_xx1_m3_cgdo = @m.x1.xdut.xx1_m3.msky130_fd_pr__nfet_01v8_lvt[cgdo]
echo OPV XX1_M3 cgdo $&s1_xx1_m3_cgdo
let s1_xx1_m3_cgbo = @m.x1.xdut.xx1_m3.msky130_fd_pr__nfet_01v8_lvt[cgbo]
echo OPV XX1_M3 cgbo $&s1_xx1_m3_cgbo
let s1_xx1_m3_weff = @m.x1.xdut.xx1_m3.msky130_fd_pr__nfet_01v8_lvt[weff]
echo OPV XX1_M3 weff $&s1_xx1_m3_weff
let s1_xx1_m3_leff = @m.x1.xdut.xx1_m3.msky130_fd_pr__nfet_01v8_lvt[leff]
echo OPV XX1_M3 leff $&s1_xx1_m3_leff
let s1_xx1_m4_id = @m.x1.xdut.xx1_m4.msky130_fd_pr__nfet_01v8_lvt[id]
echo OPV XX1_M4 id $&s1_xx1_m4_id
let s1_xx1_m4_vgs = @m.x1.xdut.xx1_m4.msky130_fd_pr__nfet_01v8_lvt[vgs]
echo OPV XX1_M4 vgs $&s1_xx1_m4_vgs
let s1_xx1_m4_vds = @m.x1.xdut.xx1_m4.msky130_fd_pr__nfet_01v8_lvt[vds]
echo OPV XX1_M4 vds $&s1_xx1_m4_vds
let s1_xx1_m4_vbs = @m.x1.xdut.xx1_m4.msky130_fd_pr__nfet_01v8_lvt[vbs]
echo OPV XX1_M4 vbs $&s1_xx1_m4_vbs
let s1_xx1_m4_vth = @m.x1.xdut.xx1_m4.msky130_fd_pr__nfet_01v8_lvt[vth]
echo OPV XX1_M4 vth $&s1_xx1_m4_vth
let s1_xx1_m4_vdsat = @m.x1.xdut.xx1_m4.msky130_fd_pr__nfet_01v8_lvt[vdsat]
echo OPV XX1_M4 vdsat $&s1_xx1_m4_vdsat
let s1_xx1_m4_gm = @m.x1.xdut.xx1_m4.msky130_fd_pr__nfet_01v8_lvt[gm]
echo OPV XX1_M4 gm $&s1_xx1_m4_gm
let s1_xx1_m4_gds = @m.x1.xdut.xx1_m4.msky130_fd_pr__nfet_01v8_lvt[gds]
echo OPV XX1_M4 gds $&s1_xx1_m4_gds
let s1_xx1_m4_gmbs = @m.x1.xdut.xx1_m4.msky130_fd_pr__nfet_01v8_lvt[gmbs]
echo OPV XX1_M4 gmbs $&s1_xx1_m4_gmbs
let s1_xx1_m4_cgg = @m.x1.xdut.xx1_m4.msky130_fd_pr__nfet_01v8_lvt[cgg]
echo OPV XX1_M4 cgg $&s1_xx1_m4_cgg
let s1_xx1_m4_cgd = @m.x1.xdut.xx1_m4.msky130_fd_pr__nfet_01v8_lvt[cgd]
echo OPV XX1_M4 cgd $&s1_xx1_m4_cgd
let s1_xx1_m4_cgs = @m.x1.xdut.xx1_m4.msky130_fd_pr__nfet_01v8_lvt[cgs]
echo OPV XX1_M4 cgs $&s1_xx1_m4_cgs
let s1_xx1_m4_cgb = @m.x1.xdut.xx1_m4.msky130_fd_pr__nfet_01v8_lvt[cgb]
echo OPV XX1_M4 cgb $&s1_xx1_m4_cgb
let s1_xx1_m4_cdg = @m.x1.xdut.xx1_m4.msky130_fd_pr__nfet_01v8_lvt[cdg]
echo OPV XX1_M4 cdg $&s1_xx1_m4_cdg
let s1_xx1_m4_cdd = @m.x1.xdut.xx1_m4.msky130_fd_pr__nfet_01v8_lvt[cdd]
echo OPV XX1_M4 cdd $&s1_xx1_m4_cdd
let s1_xx1_m4_cds = @m.x1.xdut.xx1_m4.msky130_fd_pr__nfet_01v8_lvt[cds]
echo OPV XX1_M4 cds $&s1_xx1_m4_cds
let s1_xx1_m4_cdb = @m.x1.xdut.xx1_m4.msky130_fd_pr__nfet_01v8_lvt[cdb]
echo OPV XX1_M4 cdb $&s1_xx1_m4_cdb
let s1_xx1_m4_csg = @m.x1.xdut.xx1_m4.msky130_fd_pr__nfet_01v8_lvt[csg]
echo OPV XX1_M4 csg $&s1_xx1_m4_csg
let s1_xx1_m4_csd = @m.x1.xdut.xx1_m4.msky130_fd_pr__nfet_01v8_lvt[csd]
echo OPV XX1_M4 csd $&s1_xx1_m4_csd
let s1_xx1_m4_css = @m.x1.xdut.xx1_m4.msky130_fd_pr__nfet_01v8_lvt[css]
echo OPV XX1_M4 css $&s1_xx1_m4_css
let s1_xx1_m4_csb = @m.x1.xdut.xx1_m4.msky130_fd_pr__nfet_01v8_lvt[csb]
echo OPV XX1_M4 csb $&s1_xx1_m4_csb
let s1_xx1_m4_cbg = @m.x1.xdut.xx1_m4.msky130_fd_pr__nfet_01v8_lvt[cbg]
echo OPV XX1_M4 cbg $&s1_xx1_m4_cbg
let s1_xx1_m4_cbd = @m.x1.xdut.xx1_m4.msky130_fd_pr__nfet_01v8_lvt[cbd]
echo OPV XX1_M4 cbd $&s1_xx1_m4_cbd
let s1_xx1_m4_cbs = @m.x1.xdut.xx1_m4.msky130_fd_pr__nfet_01v8_lvt[cbs]
echo OPV XX1_M4 cbs $&s1_xx1_m4_cbs
let s1_xx1_m4_cbb = @m.x1.xdut.xx1_m4.msky130_fd_pr__nfet_01v8_lvt[cbb]
echo OPV XX1_M4 cbb $&s1_xx1_m4_cbb
let s1_xx1_m4_capbd = @m.x1.xdut.xx1_m4.msky130_fd_pr__nfet_01v8_lvt[capbd]
echo OPV XX1_M4 capbd $&s1_xx1_m4_capbd
let s1_xx1_m4_capbs = @m.x1.xdut.xx1_m4.msky130_fd_pr__nfet_01v8_lvt[capbs]
echo OPV XX1_M4 capbs $&s1_xx1_m4_capbs
let s1_xx1_m4_cgso = @m.x1.xdut.xx1_m4.msky130_fd_pr__nfet_01v8_lvt[cgso]
echo OPV XX1_M4 cgso $&s1_xx1_m4_cgso
let s1_xx1_m4_cgdo = @m.x1.xdut.xx1_m4.msky130_fd_pr__nfet_01v8_lvt[cgdo]
echo OPV XX1_M4 cgdo $&s1_xx1_m4_cgdo
let s1_xx1_m4_cgbo = @m.x1.xdut.xx1_m4.msky130_fd_pr__nfet_01v8_lvt[cgbo]
echo OPV XX1_M4 cgbo $&s1_xx1_m4_cgbo
let s1_xx1_m4_weff = @m.x1.xdut.xx1_m4.msky130_fd_pr__nfet_01v8_lvt[weff]
echo OPV XX1_M4 weff $&s1_xx1_m4_weff
let s1_xx1_m4_leff = @m.x1.xdut.xx1_m4.msky130_fd_pr__nfet_01v8_lvt[leff]
echo OPV XX1_M4 leff $&s1_xx1_m4_leff
let s1_xx1_m7_id = @m.x1.xdut.xx1_m7.msky130_fd_pr__nfet_01v8_lvt[id]
echo OPV XX1_M7 id $&s1_xx1_m7_id
let s1_xx1_m7_vgs = @m.x1.xdut.xx1_m7.msky130_fd_pr__nfet_01v8_lvt[vgs]
echo OPV XX1_M7 vgs $&s1_xx1_m7_vgs
let s1_xx1_m7_vds = @m.x1.xdut.xx1_m7.msky130_fd_pr__nfet_01v8_lvt[vds]
echo OPV XX1_M7 vds $&s1_xx1_m7_vds
let s1_xx1_m7_vbs = @m.x1.xdut.xx1_m7.msky130_fd_pr__nfet_01v8_lvt[vbs]
echo OPV XX1_M7 vbs $&s1_xx1_m7_vbs
let s1_xx1_m7_vth = @m.x1.xdut.xx1_m7.msky130_fd_pr__nfet_01v8_lvt[vth]
echo OPV XX1_M7 vth $&s1_xx1_m7_vth
let s1_xx1_m7_vdsat = @m.x1.xdut.xx1_m7.msky130_fd_pr__nfet_01v8_lvt[vdsat]
echo OPV XX1_M7 vdsat $&s1_xx1_m7_vdsat
let s1_xx1_m7_gm = @m.x1.xdut.xx1_m7.msky130_fd_pr__nfet_01v8_lvt[gm]
echo OPV XX1_M7 gm $&s1_xx1_m7_gm
let s1_xx1_m7_gds = @m.x1.xdut.xx1_m7.msky130_fd_pr__nfet_01v8_lvt[gds]
echo OPV XX1_M7 gds $&s1_xx1_m7_gds
let s1_xx1_m7_gmbs = @m.x1.xdut.xx1_m7.msky130_fd_pr__nfet_01v8_lvt[gmbs]
echo OPV XX1_M7 gmbs $&s1_xx1_m7_gmbs
let s1_xx1_m7_cgg = @m.x1.xdut.xx1_m7.msky130_fd_pr__nfet_01v8_lvt[cgg]
echo OPV XX1_M7 cgg $&s1_xx1_m7_cgg
let s1_xx1_m7_cgd = @m.x1.xdut.xx1_m7.msky130_fd_pr__nfet_01v8_lvt[cgd]
echo OPV XX1_M7 cgd $&s1_xx1_m7_cgd
let s1_xx1_m7_cgs = @m.x1.xdut.xx1_m7.msky130_fd_pr__nfet_01v8_lvt[cgs]
echo OPV XX1_M7 cgs $&s1_xx1_m7_cgs
let s1_xx1_m7_cgb = @m.x1.xdut.xx1_m7.msky130_fd_pr__nfet_01v8_lvt[cgb]
echo OPV XX1_M7 cgb $&s1_xx1_m7_cgb
let s1_xx1_m7_cdg = @m.x1.xdut.xx1_m7.msky130_fd_pr__nfet_01v8_lvt[cdg]
echo OPV XX1_M7 cdg $&s1_xx1_m7_cdg
let s1_xx1_m7_cdd = @m.x1.xdut.xx1_m7.msky130_fd_pr__nfet_01v8_lvt[cdd]
echo OPV XX1_M7 cdd $&s1_xx1_m7_cdd
let s1_xx1_m7_cds = @m.x1.xdut.xx1_m7.msky130_fd_pr__nfet_01v8_lvt[cds]
echo OPV XX1_M7 cds $&s1_xx1_m7_cds
let s1_xx1_m7_cdb = @m.x1.xdut.xx1_m7.msky130_fd_pr__nfet_01v8_lvt[cdb]
echo OPV XX1_M7 cdb $&s1_xx1_m7_cdb
let s1_xx1_m7_csg = @m.x1.xdut.xx1_m7.msky130_fd_pr__nfet_01v8_lvt[csg]
echo OPV XX1_M7 csg $&s1_xx1_m7_csg
let s1_xx1_m7_csd = @m.x1.xdut.xx1_m7.msky130_fd_pr__nfet_01v8_lvt[csd]
echo OPV XX1_M7 csd $&s1_xx1_m7_csd
let s1_xx1_m7_css = @m.x1.xdut.xx1_m7.msky130_fd_pr__nfet_01v8_lvt[css]
echo OPV XX1_M7 css $&s1_xx1_m7_css
let s1_xx1_m7_csb = @m.x1.xdut.xx1_m7.msky130_fd_pr__nfet_01v8_lvt[csb]
echo OPV XX1_M7 csb $&s1_xx1_m7_csb
let s1_xx1_m7_cbg = @m.x1.xdut.xx1_m7.msky130_fd_pr__nfet_01v8_lvt[cbg]
echo OPV XX1_M7 cbg $&s1_xx1_m7_cbg
let s1_xx1_m7_cbd = @m.x1.xdut.xx1_m7.msky130_fd_pr__nfet_01v8_lvt[cbd]
echo OPV XX1_M7 cbd $&s1_xx1_m7_cbd
let s1_xx1_m7_cbs = @m.x1.xdut.xx1_m7.msky130_fd_pr__nfet_01v8_lvt[cbs]
echo OPV XX1_M7 cbs $&s1_xx1_m7_cbs
let s1_xx1_m7_cbb = @m.x1.xdut.xx1_m7.msky130_fd_pr__nfet_01v8_lvt[cbb]
echo OPV XX1_M7 cbb $&s1_xx1_m7_cbb
let s1_xx1_m7_capbd = @m.x1.xdut.xx1_m7.msky130_fd_pr__nfet_01v8_lvt[capbd]
echo OPV XX1_M7 capbd $&s1_xx1_m7_capbd
let s1_xx1_m7_capbs = @m.x1.xdut.xx1_m7.msky130_fd_pr__nfet_01v8_lvt[capbs]
echo OPV XX1_M7 capbs $&s1_xx1_m7_capbs
let s1_xx1_m7_cgso = @m.x1.xdut.xx1_m7.msky130_fd_pr__nfet_01v8_lvt[cgso]
echo OPV XX1_M7 cgso $&s1_xx1_m7_cgso
let s1_xx1_m7_cgdo = @m.x1.xdut.xx1_m7.msky130_fd_pr__nfet_01v8_lvt[cgdo]
echo OPV XX1_M7 cgdo $&s1_xx1_m7_cgdo
let s1_xx1_m7_cgbo = @m.x1.xdut.xx1_m7.msky130_fd_pr__nfet_01v8_lvt[cgbo]
echo OPV XX1_M7 cgbo $&s1_xx1_m7_cgbo
let s1_xx1_m7_weff = @m.x1.xdut.xx1_m7.msky130_fd_pr__nfet_01v8_lvt[weff]
echo OPV XX1_M7 weff $&s1_xx1_m7_weff
let s1_xx1_m7_leff = @m.x1.xdut.xx1_m7.msky130_fd_pr__nfet_01v8_lvt[leff]
echo OPV XX1_M7 leff $&s1_xx1_m7_leff
let s1_xx1_m8_id = @m.x1.xdut.xx1_m8.msky130_fd_pr__nfet_01v8_lvt[id]
echo OPV XX1_M8 id $&s1_xx1_m8_id
let s1_xx1_m8_vgs = @m.x1.xdut.xx1_m8.msky130_fd_pr__nfet_01v8_lvt[vgs]
echo OPV XX1_M8 vgs $&s1_xx1_m8_vgs
let s1_xx1_m8_vds = @m.x1.xdut.xx1_m8.msky130_fd_pr__nfet_01v8_lvt[vds]
echo OPV XX1_M8 vds $&s1_xx1_m8_vds
let s1_xx1_m8_vbs = @m.x1.xdut.xx1_m8.msky130_fd_pr__nfet_01v8_lvt[vbs]
echo OPV XX1_M8 vbs $&s1_xx1_m8_vbs
let s1_xx1_m8_vth = @m.x1.xdut.xx1_m8.msky130_fd_pr__nfet_01v8_lvt[vth]
echo OPV XX1_M8 vth $&s1_xx1_m8_vth
let s1_xx1_m8_vdsat = @m.x1.xdut.xx1_m8.msky130_fd_pr__nfet_01v8_lvt[vdsat]
echo OPV XX1_M8 vdsat $&s1_xx1_m8_vdsat
let s1_xx1_m8_gm = @m.x1.xdut.xx1_m8.msky130_fd_pr__nfet_01v8_lvt[gm]
echo OPV XX1_M8 gm $&s1_xx1_m8_gm
let s1_xx1_m8_gds = @m.x1.xdut.xx1_m8.msky130_fd_pr__nfet_01v8_lvt[gds]
echo OPV XX1_M8 gds $&s1_xx1_m8_gds
let s1_xx1_m8_gmbs = @m.x1.xdut.xx1_m8.msky130_fd_pr__nfet_01v8_lvt[gmbs]
echo OPV XX1_M8 gmbs $&s1_xx1_m8_gmbs
let s1_xx1_m8_cgg = @m.x1.xdut.xx1_m8.msky130_fd_pr__nfet_01v8_lvt[cgg]
echo OPV XX1_M8 cgg $&s1_xx1_m8_cgg
let s1_xx1_m8_cgd = @m.x1.xdut.xx1_m8.msky130_fd_pr__nfet_01v8_lvt[cgd]
echo OPV XX1_M8 cgd $&s1_xx1_m8_cgd
let s1_xx1_m8_cgs = @m.x1.xdut.xx1_m8.msky130_fd_pr__nfet_01v8_lvt[cgs]
echo OPV XX1_M8 cgs $&s1_xx1_m8_cgs
let s1_xx1_m8_cgb = @m.x1.xdut.xx1_m8.msky130_fd_pr__nfet_01v8_lvt[cgb]
echo OPV XX1_M8 cgb $&s1_xx1_m8_cgb
let s1_xx1_m8_cdg = @m.x1.xdut.xx1_m8.msky130_fd_pr__nfet_01v8_lvt[cdg]
echo OPV XX1_M8 cdg $&s1_xx1_m8_cdg
let s1_xx1_m8_cdd = @m.x1.xdut.xx1_m8.msky130_fd_pr__nfet_01v8_lvt[cdd]
echo OPV XX1_M8 cdd $&s1_xx1_m8_cdd
let s1_xx1_m8_cds = @m.x1.xdut.xx1_m8.msky130_fd_pr__nfet_01v8_lvt[cds]
echo OPV XX1_M8 cds $&s1_xx1_m8_cds
let s1_xx1_m8_cdb = @m.x1.xdut.xx1_m8.msky130_fd_pr__nfet_01v8_lvt[cdb]
echo OPV XX1_M8 cdb $&s1_xx1_m8_cdb
let s1_xx1_m8_csg = @m.x1.xdut.xx1_m8.msky130_fd_pr__nfet_01v8_lvt[csg]
echo OPV XX1_M8 csg $&s1_xx1_m8_csg
let s1_xx1_m8_csd = @m.x1.xdut.xx1_m8.msky130_fd_pr__nfet_01v8_lvt[csd]
echo OPV XX1_M8 csd $&s1_xx1_m8_csd
let s1_xx1_m8_css = @m.x1.xdut.xx1_m8.msky130_fd_pr__nfet_01v8_lvt[css]
echo OPV XX1_M8 css $&s1_xx1_m8_css
let s1_xx1_m8_csb = @m.x1.xdut.xx1_m8.msky130_fd_pr__nfet_01v8_lvt[csb]
echo OPV XX1_M8 csb $&s1_xx1_m8_csb
let s1_xx1_m8_cbg = @m.x1.xdut.xx1_m8.msky130_fd_pr__nfet_01v8_lvt[cbg]
echo OPV XX1_M8 cbg $&s1_xx1_m8_cbg
let s1_xx1_m8_cbd = @m.x1.xdut.xx1_m8.msky130_fd_pr__nfet_01v8_lvt[cbd]
echo OPV XX1_M8 cbd $&s1_xx1_m8_cbd
let s1_xx1_m8_cbs = @m.x1.xdut.xx1_m8.msky130_fd_pr__nfet_01v8_lvt[cbs]
echo OPV XX1_M8 cbs $&s1_xx1_m8_cbs
let s1_xx1_m8_cbb = @m.x1.xdut.xx1_m8.msky130_fd_pr__nfet_01v8_lvt[cbb]
echo OPV XX1_M8 cbb $&s1_xx1_m8_cbb
let s1_xx1_m8_capbd = @m.x1.xdut.xx1_m8.msky130_fd_pr__nfet_01v8_lvt[capbd]
echo OPV XX1_M8 capbd $&s1_xx1_m8_capbd
let s1_xx1_m8_capbs = @m.x1.xdut.xx1_m8.msky130_fd_pr__nfet_01v8_lvt[capbs]
echo OPV XX1_M8 capbs $&s1_xx1_m8_capbs
let s1_xx1_m8_cgso = @m.x1.xdut.xx1_m8.msky130_fd_pr__nfet_01v8_lvt[cgso]
echo OPV XX1_M8 cgso $&s1_xx1_m8_cgso
let s1_xx1_m8_cgdo = @m.x1.xdut.xx1_m8.msky130_fd_pr__nfet_01v8_lvt[cgdo]
echo OPV XX1_M8 cgdo $&s1_xx1_m8_cgdo
let s1_xx1_m8_cgbo = @m.x1.xdut.xx1_m8.msky130_fd_pr__nfet_01v8_lvt[cgbo]
echo OPV XX1_M8 cgbo $&s1_xx1_m8_cgbo
let s1_xx1_m8_weff = @m.x1.xdut.xx1_m8.msky130_fd_pr__nfet_01v8_lvt[weff]
echo OPV XX1_M8 weff $&s1_xx1_m8_weff
let s1_xx1_m8_leff = @m.x1.xdut.xx1_m8.msky130_fd_pr__nfet_01v8_lvt[leff]
echo OPV XX1_M8 leff $&s1_xx1_m8_leff
let s1_xx1_m9_id = @m.x1.xdut.xx1_m9.msky130_fd_pr__nfet_01v8_lvt[id]
echo OPV XX1_M9 id $&s1_xx1_m9_id
let s1_xx1_m9_vgs = @m.x1.xdut.xx1_m9.msky130_fd_pr__nfet_01v8_lvt[vgs]
echo OPV XX1_M9 vgs $&s1_xx1_m9_vgs
let s1_xx1_m9_vds = @m.x1.xdut.xx1_m9.msky130_fd_pr__nfet_01v8_lvt[vds]
echo OPV XX1_M9 vds $&s1_xx1_m9_vds
let s1_xx1_m9_vbs = @m.x1.xdut.xx1_m9.msky130_fd_pr__nfet_01v8_lvt[vbs]
echo OPV XX1_M9 vbs $&s1_xx1_m9_vbs
let s1_xx1_m9_vth = @m.x1.xdut.xx1_m9.msky130_fd_pr__nfet_01v8_lvt[vth]
echo OPV XX1_M9 vth $&s1_xx1_m9_vth
let s1_xx1_m9_vdsat = @m.x1.xdut.xx1_m9.msky130_fd_pr__nfet_01v8_lvt[vdsat]
echo OPV XX1_M9 vdsat $&s1_xx1_m9_vdsat
let s1_xx1_m9_gm = @m.x1.xdut.xx1_m9.msky130_fd_pr__nfet_01v8_lvt[gm]
echo OPV XX1_M9 gm $&s1_xx1_m9_gm
let s1_xx1_m9_gds = @m.x1.xdut.xx1_m9.msky130_fd_pr__nfet_01v8_lvt[gds]
echo OPV XX1_M9 gds $&s1_xx1_m9_gds
let s1_xx1_m9_gmbs = @m.x1.xdut.xx1_m9.msky130_fd_pr__nfet_01v8_lvt[gmbs]
echo OPV XX1_M9 gmbs $&s1_xx1_m9_gmbs
let s1_xx1_m9_cgg = @m.x1.xdut.xx1_m9.msky130_fd_pr__nfet_01v8_lvt[cgg]
echo OPV XX1_M9 cgg $&s1_xx1_m9_cgg
let s1_xx1_m9_cgd = @m.x1.xdut.xx1_m9.msky130_fd_pr__nfet_01v8_lvt[cgd]
echo OPV XX1_M9 cgd $&s1_xx1_m9_cgd
let s1_xx1_m9_cgs = @m.x1.xdut.xx1_m9.msky130_fd_pr__nfet_01v8_lvt[cgs]
echo OPV XX1_M9 cgs $&s1_xx1_m9_cgs
let s1_xx1_m9_cgb = @m.x1.xdut.xx1_m9.msky130_fd_pr__nfet_01v8_lvt[cgb]
echo OPV XX1_M9 cgb $&s1_xx1_m9_cgb
let s1_xx1_m9_cdg = @m.x1.xdut.xx1_m9.msky130_fd_pr__nfet_01v8_lvt[cdg]
echo OPV XX1_M9 cdg $&s1_xx1_m9_cdg
let s1_xx1_m9_cdd = @m.x1.xdut.xx1_m9.msky130_fd_pr__nfet_01v8_lvt[cdd]
echo OPV XX1_M9 cdd $&s1_xx1_m9_cdd
let s1_xx1_m9_cds = @m.x1.xdut.xx1_m9.msky130_fd_pr__nfet_01v8_lvt[cds]
echo OPV XX1_M9 cds $&s1_xx1_m9_cds
let s1_xx1_m9_cdb = @m.x1.xdut.xx1_m9.msky130_fd_pr__nfet_01v8_lvt[cdb]
echo OPV XX1_M9 cdb $&s1_xx1_m9_cdb
let s1_xx1_m9_csg = @m.x1.xdut.xx1_m9.msky130_fd_pr__nfet_01v8_lvt[csg]
echo OPV XX1_M9 csg $&s1_xx1_m9_csg
let s1_xx1_m9_csd = @m.x1.xdut.xx1_m9.msky130_fd_pr__nfet_01v8_lvt[csd]
echo OPV XX1_M9 csd $&s1_xx1_m9_csd
let s1_xx1_m9_css = @m.x1.xdut.xx1_m9.msky130_fd_pr__nfet_01v8_lvt[css]
echo OPV XX1_M9 css $&s1_xx1_m9_css
let s1_xx1_m9_csb = @m.x1.xdut.xx1_m9.msky130_fd_pr__nfet_01v8_lvt[csb]
echo OPV XX1_M9 csb $&s1_xx1_m9_csb
let s1_xx1_m9_cbg = @m.x1.xdut.xx1_m9.msky130_fd_pr__nfet_01v8_lvt[cbg]
echo OPV XX1_M9 cbg $&s1_xx1_m9_cbg
let s1_xx1_m9_cbd = @m.x1.xdut.xx1_m9.msky130_fd_pr__nfet_01v8_lvt[cbd]
echo OPV XX1_M9 cbd $&s1_xx1_m9_cbd
let s1_xx1_m9_cbs = @m.x1.xdut.xx1_m9.msky130_fd_pr__nfet_01v8_lvt[cbs]
echo OPV XX1_M9 cbs $&s1_xx1_m9_cbs
let s1_xx1_m9_cbb = @m.x1.xdut.xx1_m9.msky130_fd_pr__nfet_01v8_lvt[cbb]
echo OPV XX1_M9 cbb $&s1_xx1_m9_cbb
let s1_xx1_m9_capbd = @m.x1.xdut.xx1_m9.msky130_fd_pr__nfet_01v8_lvt[capbd]
echo OPV XX1_M9 capbd $&s1_xx1_m9_capbd
let s1_xx1_m9_capbs = @m.x1.xdut.xx1_m9.msky130_fd_pr__nfet_01v8_lvt[capbs]
echo OPV XX1_M9 capbs $&s1_xx1_m9_capbs
let s1_xx1_m9_cgso = @m.x1.xdut.xx1_m9.msky130_fd_pr__nfet_01v8_lvt[cgso]
echo OPV XX1_M9 cgso $&s1_xx1_m9_cgso
let s1_xx1_m9_cgdo = @m.x1.xdut.xx1_m9.msky130_fd_pr__nfet_01v8_lvt[cgdo]
echo OPV XX1_M9 cgdo $&s1_xx1_m9_cgdo
let s1_xx1_m9_cgbo = @m.x1.xdut.xx1_m9.msky130_fd_pr__nfet_01v8_lvt[cgbo]
echo OPV XX1_M9 cgbo $&s1_xx1_m9_cgbo
let s1_xx1_m9_weff = @m.x1.xdut.xx1_m9.msky130_fd_pr__nfet_01v8_lvt[weff]
echo OPV XX1_M9 weff $&s1_xx1_m9_weff
let s1_xx1_m9_leff = @m.x1.xdut.xx1_m9.msky130_fd_pr__nfet_01v8_lvt[leff]
echo OPV XX1_M9 leff $&s1_xx1_m9_leff
let s1_xx1_m10_id = @m.x1.xdut.xx1_m10.msky130_fd_pr__nfet_01v8_lvt[id]
echo OPV XX1_M10 id $&s1_xx1_m10_id
let s1_xx1_m10_vgs = @m.x1.xdut.xx1_m10.msky130_fd_pr__nfet_01v8_lvt[vgs]
echo OPV XX1_M10 vgs $&s1_xx1_m10_vgs
let s1_xx1_m10_vds = @m.x1.xdut.xx1_m10.msky130_fd_pr__nfet_01v8_lvt[vds]
echo OPV XX1_M10 vds $&s1_xx1_m10_vds
let s1_xx1_m10_vbs = @m.x1.xdut.xx1_m10.msky130_fd_pr__nfet_01v8_lvt[vbs]
echo OPV XX1_M10 vbs $&s1_xx1_m10_vbs
let s1_xx1_m10_vth = @m.x1.xdut.xx1_m10.msky130_fd_pr__nfet_01v8_lvt[vth]
echo OPV XX1_M10 vth $&s1_xx1_m10_vth
let s1_xx1_m10_vdsat = @m.x1.xdut.xx1_m10.msky130_fd_pr__nfet_01v8_lvt[vdsat]
echo OPV XX1_M10 vdsat $&s1_xx1_m10_vdsat
let s1_xx1_m10_gm = @m.x1.xdut.xx1_m10.msky130_fd_pr__nfet_01v8_lvt[gm]
echo OPV XX1_M10 gm $&s1_xx1_m10_gm
let s1_xx1_m10_gds = @m.x1.xdut.xx1_m10.msky130_fd_pr__nfet_01v8_lvt[gds]
echo OPV XX1_M10 gds $&s1_xx1_m10_gds
let s1_xx1_m10_gmbs = @m.x1.xdut.xx1_m10.msky130_fd_pr__nfet_01v8_lvt[gmbs]
echo OPV XX1_M10 gmbs $&s1_xx1_m10_gmbs
let s1_xx1_m10_cgg = @m.x1.xdut.xx1_m10.msky130_fd_pr__nfet_01v8_lvt[cgg]
echo OPV XX1_M10 cgg $&s1_xx1_m10_cgg
let s1_xx1_m10_cgd = @m.x1.xdut.xx1_m10.msky130_fd_pr__nfet_01v8_lvt[cgd]
echo OPV XX1_M10 cgd $&s1_xx1_m10_cgd
let s1_xx1_m10_cgs = @m.x1.xdut.xx1_m10.msky130_fd_pr__nfet_01v8_lvt[cgs]
echo OPV XX1_M10 cgs $&s1_xx1_m10_cgs
let s1_xx1_m10_cgb = @m.x1.xdut.xx1_m10.msky130_fd_pr__nfet_01v8_lvt[cgb]
echo OPV XX1_M10 cgb $&s1_xx1_m10_cgb
let s1_xx1_m10_cdg = @m.x1.xdut.xx1_m10.msky130_fd_pr__nfet_01v8_lvt[cdg]
echo OPV XX1_M10 cdg $&s1_xx1_m10_cdg
let s1_xx1_m10_cdd = @m.x1.xdut.xx1_m10.msky130_fd_pr__nfet_01v8_lvt[cdd]
echo OPV XX1_M10 cdd $&s1_xx1_m10_cdd
let s1_xx1_m10_cds = @m.x1.xdut.xx1_m10.msky130_fd_pr__nfet_01v8_lvt[cds]
echo OPV XX1_M10 cds $&s1_xx1_m10_cds
let s1_xx1_m10_cdb = @m.x1.xdut.xx1_m10.msky130_fd_pr__nfet_01v8_lvt[cdb]
echo OPV XX1_M10 cdb $&s1_xx1_m10_cdb
let s1_xx1_m10_csg = @m.x1.xdut.xx1_m10.msky130_fd_pr__nfet_01v8_lvt[csg]
echo OPV XX1_M10 csg $&s1_xx1_m10_csg
let s1_xx1_m10_csd = @m.x1.xdut.xx1_m10.msky130_fd_pr__nfet_01v8_lvt[csd]
echo OPV XX1_M10 csd $&s1_xx1_m10_csd
let s1_xx1_m10_css = @m.x1.xdut.xx1_m10.msky130_fd_pr__nfet_01v8_lvt[css]
echo OPV XX1_M10 css $&s1_xx1_m10_css
let s1_xx1_m10_csb = @m.x1.xdut.xx1_m10.msky130_fd_pr__nfet_01v8_lvt[csb]
echo OPV XX1_M10 csb $&s1_xx1_m10_csb
let s1_xx1_m10_cbg = @m.x1.xdut.xx1_m10.msky130_fd_pr__nfet_01v8_lvt[cbg]
echo OPV XX1_M10 cbg $&s1_xx1_m10_cbg
let s1_xx1_m10_cbd = @m.x1.xdut.xx1_m10.msky130_fd_pr__nfet_01v8_lvt[cbd]
echo OPV XX1_M10 cbd $&s1_xx1_m10_cbd
let s1_xx1_m10_cbs = @m.x1.xdut.xx1_m10.msky130_fd_pr__nfet_01v8_lvt[cbs]
echo OPV XX1_M10 cbs $&s1_xx1_m10_cbs
let s1_xx1_m10_cbb = @m.x1.xdut.xx1_m10.msky130_fd_pr__nfet_01v8_lvt[cbb]
echo OPV XX1_M10 cbb $&s1_xx1_m10_cbb
let s1_xx1_m10_capbd = @m.x1.xdut.xx1_m10.msky130_fd_pr__nfet_01v8_lvt[capbd]
echo OPV XX1_M10 capbd $&s1_xx1_m10_capbd
let s1_xx1_m10_capbs = @m.x1.xdut.xx1_m10.msky130_fd_pr__nfet_01v8_lvt[capbs]
echo OPV XX1_M10 capbs $&s1_xx1_m10_capbs
let s1_xx1_m10_cgso = @m.x1.xdut.xx1_m10.msky130_fd_pr__nfet_01v8_lvt[cgso]
echo OPV XX1_M10 cgso $&s1_xx1_m10_cgso
let s1_xx1_m10_cgdo = @m.x1.xdut.xx1_m10.msky130_fd_pr__nfet_01v8_lvt[cgdo]
echo OPV XX1_M10 cgdo $&s1_xx1_m10_cgdo
let s1_xx1_m10_cgbo = @m.x1.xdut.xx1_m10.msky130_fd_pr__nfet_01v8_lvt[cgbo]
echo OPV XX1_M10 cgbo $&s1_xx1_m10_cgbo
let s1_xx1_m10_weff = @m.x1.xdut.xx1_m10.msky130_fd_pr__nfet_01v8_lvt[weff]
echo OPV XX1_M10 weff $&s1_xx1_m10_weff
let s1_xx1_m10_leff = @m.x1.xdut.xx1_m10.msky130_fd_pr__nfet_01v8_lvt[leff]
echo OPV XX1_M10 leff $&s1_xx1_m10_leff
let s1_xx1_m17_id = @m.x1.xdut.xx1_m17.msky130_fd_pr__nfet_01v8_lvt[id]
echo OPV XX1_M17 id $&s1_xx1_m17_id
let s1_xx1_m17_vgs = @m.x1.xdut.xx1_m17.msky130_fd_pr__nfet_01v8_lvt[vgs]
echo OPV XX1_M17 vgs $&s1_xx1_m17_vgs
let s1_xx1_m17_vds = @m.x1.xdut.xx1_m17.msky130_fd_pr__nfet_01v8_lvt[vds]
echo OPV XX1_M17 vds $&s1_xx1_m17_vds
let s1_xx1_m17_vbs = @m.x1.xdut.xx1_m17.msky130_fd_pr__nfet_01v8_lvt[vbs]
echo OPV XX1_M17 vbs $&s1_xx1_m17_vbs
let s1_xx1_m17_vth = @m.x1.xdut.xx1_m17.msky130_fd_pr__nfet_01v8_lvt[vth]
echo OPV XX1_M17 vth $&s1_xx1_m17_vth
let s1_xx1_m17_vdsat = @m.x1.xdut.xx1_m17.msky130_fd_pr__nfet_01v8_lvt[vdsat]
echo OPV XX1_M17 vdsat $&s1_xx1_m17_vdsat
let s1_xx1_m17_gm = @m.x1.xdut.xx1_m17.msky130_fd_pr__nfet_01v8_lvt[gm]
echo OPV XX1_M17 gm $&s1_xx1_m17_gm
let s1_xx1_m17_gds = @m.x1.xdut.xx1_m17.msky130_fd_pr__nfet_01v8_lvt[gds]
echo OPV XX1_M17 gds $&s1_xx1_m17_gds
let s1_xx1_m17_gmbs = @m.x1.xdut.xx1_m17.msky130_fd_pr__nfet_01v8_lvt[gmbs]
echo OPV XX1_M17 gmbs $&s1_xx1_m17_gmbs
let s1_xx1_m17_cgg = @m.x1.xdut.xx1_m17.msky130_fd_pr__nfet_01v8_lvt[cgg]
echo OPV XX1_M17 cgg $&s1_xx1_m17_cgg
let s1_xx1_m17_cgd = @m.x1.xdut.xx1_m17.msky130_fd_pr__nfet_01v8_lvt[cgd]
echo OPV XX1_M17 cgd $&s1_xx1_m17_cgd
let s1_xx1_m17_cgs = @m.x1.xdut.xx1_m17.msky130_fd_pr__nfet_01v8_lvt[cgs]
echo OPV XX1_M17 cgs $&s1_xx1_m17_cgs
let s1_xx1_m17_cgb = @m.x1.xdut.xx1_m17.msky130_fd_pr__nfet_01v8_lvt[cgb]
echo OPV XX1_M17 cgb $&s1_xx1_m17_cgb
let s1_xx1_m17_cdg = @m.x1.xdut.xx1_m17.msky130_fd_pr__nfet_01v8_lvt[cdg]
echo OPV XX1_M17 cdg $&s1_xx1_m17_cdg
let s1_xx1_m17_cdd = @m.x1.xdut.xx1_m17.msky130_fd_pr__nfet_01v8_lvt[cdd]
echo OPV XX1_M17 cdd $&s1_xx1_m17_cdd
let s1_xx1_m17_cds = @m.x1.xdut.xx1_m17.msky130_fd_pr__nfet_01v8_lvt[cds]
echo OPV XX1_M17 cds $&s1_xx1_m17_cds
let s1_xx1_m17_cdb = @m.x1.xdut.xx1_m17.msky130_fd_pr__nfet_01v8_lvt[cdb]
echo OPV XX1_M17 cdb $&s1_xx1_m17_cdb
let s1_xx1_m17_csg = @m.x1.xdut.xx1_m17.msky130_fd_pr__nfet_01v8_lvt[csg]
echo OPV XX1_M17 csg $&s1_xx1_m17_csg
let s1_xx1_m17_csd = @m.x1.xdut.xx1_m17.msky130_fd_pr__nfet_01v8_lvt[csd]
echo OPV XX1_M17 csd $&s1_xx1_m17_csd
let s1_xx1_m17_css = @m.x1.xdut.xx1_m17.msky130_fd_pr__nfet_01v8_lvt[css]
echo OPV XX1_M17 css $&s1_xx1_m17_css
let s1_xx1_m17_csb = @m.x1.xdut.xx1_m17.msky130_fd_pr__nfet_01v8_lvt[csb]
echo OPV XX1_M17 csb $&s1_xx1_m17_csb
let s1_xx1_m17_cbg = @m.x1.xdut.xx1_m17.msky130_fd_pr__nfet_01v8_lvt[cbg]
echo OPV XX1_M17 cbg $&s1_xx1_m17_cbg
let s1_xx1_m17_cbd = @m.x1.xdut.xx1_m17.msky130_fd_pr__nfet_01v8_lvt[cbd]
echo OPV XX1_M17 cbd $&s1_xx1_m17_cbd
let s1_xx1_m17_cbs = @m.x1.xdut.xx1_m17.msky130_fd_pr__nfet_01v8_lvt[cbs]
echo OPV XX1_M17 cbs $&s1_xx1_m17_cbs
let s1_xx1_m17_cbb = @m.x1.xdut.xx1_m17.msky130_fd_pr__nfet_01v8_lvt[cbb]
echo OPV XX1_M17 cbb $&s1_xx1_m17_cbb
let s1_xx1_m17_capbd = @m.x1.xdut.xx1_m17.msky130_fd_pr__nfet_01v8_lvt[capbd]
echo OPV XX1_M17 capbd $&s1_xx1_m17_capbd
let s1_xx1_m17_capbs = @m.x1.xdut.xx1_m17.msky130_fd_pr__nfet_01v8_lvt[capbs]
echo OPV XX1_M17 capbs $&s1_xx1_m17_capbs
let s1_xx1_m17_cgso = @m.x1.xdut.xx1_m17.msky130_fd_pr__nfet_01v8_lvt[cgso]
echo OPV XX1_M17 cgso $&s1_xx1_m17_cgso
let s1_xx1_m17_cgdo = @m.x1.xdut.xx1_m17.msky130_fd_pr__nfet_01v8_lvt[cgdo]
echo OPV XX1_M17 cgdo $&s1_xx1_m17_cgdo
let s1_xx1_m17_cgbo = @m.x1.xdut.xx1_m17.msky130_fd_pr__nfet_01v8_lvt[cgbo]
echo OPV XX1_M17 cgbo $&s1_xx1_m17_cgbo
let s1_xx1_m17_weff = @m.x1.xdut.xx1_m17.msky130_fd_pr__nfet_01v8_lvt[weff]
echo OPV XX1_M17 weff $&s1_xx1_m17_weff
let s1_xx1_m17_leff = @m.x1.xdut.xx1_m17.msky130_fd_pr__nfet_01v8_lvt[leff]
echo OPV XX1_M17 leff $&s1_xx1_m17_leff
let s1_xx1_m18_id = @m.x1.xdut.xx1_m18.msky130_fd_pr__nfet_01v8_lvt[id]
echo OPV XX1_M18 id $&s1_xx1_m18_id
let s1_xx1_m18_vgs = @m.x1.xdut.xx1_m18.msky130_fd_pr__nfet_01v8_lvt[vgs]
echo OPV XX1_M18 vgs $&s1_xx1_m18_vgs
let s1_xx1_m18_vds = @m.x1.xdut.xx1_m18.msky130_fd_pr__nfet_01v8_lvt[vds]
echo OPV XX1_M18 vds $&s1_xx1_m18_vds
let s1_xx1_m18_vbs = @m.x1.xdut.xx1_m18.msky130_fd_pr__nfet_01v8_lvt[vbs]
echo OPV XX1_M18 vbs $&s1_xx1_m18_vbs
let s1_xx1_m18_vth = @m.x1.xdut.xx1_m18.msky130_fd_pr__nfet_01v8_lvt[vth]
echo OPV XX1_M18 vth $&s1_xx1_m18_vth
let s1_xx1_m18_vdsat = @m.x1.xdut.xx1_m18.msky130_fd_pr__nfet_01v8_lvt[vdsat]
echo OPV XX1_M18 vdsat $&s1_xx1_m18_vdsat
let s1_xx1_m18_gm = @m.x1.xdut.xx1_m18.msky130_fd_pr__nfet_01v8_lvt[gm]
echo OPV XX1_M18 gm $&s1_xx1_m18_gm
let s1_xx1_m18_gds = @m.x1.xdut.xx1_m18.msky130_fd_pr__nfet_01v8_lvt[gds]
echo OPV XX1_M18 gds $&s1_xx1_m18_gds
let s1_xx1_m18_gmbs = @m.x1.xdut.xx1_m18.msky130_fd_pr__nfet_01v8_lvt[gmbs]
echo OPV XX1_M18 gmbs $&s1_xx1_m18_gmbs
let s1_xx1_m18_cgg = @m.x1.xdut.xx1_m18.msky130_fd_pr__nfet_01v8_lvt[cgg]
echo OPV XX1_M18 cgg $&s1_xx1_m18_cgg
let s1_xx1_m18_cgd = @m.x1.xdut.xx1_m18.msky130_fd_pr__nfet_01v8_lvt[cgd]
echo OPV XX1_M18 cgd $&s1_xx1_m18_cgd
let s1_xx1_m18_cgs = @m.x1.xdut.xx1_m18.msky130_fd_pr__nfet_01v8_lvt[cgs]
echo OPV XX1_M18 cgs $&s1_xx1_m18_cgs
let s1_xx1_m18_cgb = @m.x1.xdut.xx1_m18.msky130_fd_pr__nfet_01v8_lvt[cgb]
echo OPV XX1_M18 cgb $&s1_xx1_m18_cgb
let s1_xx1_m18_cdg = @m.x1.xdut.xx1_m18.msky130_fd_pr__nfet_01v8_lvt[cdg]
echo OPV XX1_M18 cdg $&s1_xx1_m18_cdg
let s1_xx1_m18_cdd = @m.x1.xdut.xx1_m18.msky130_fd_pr__nfet_01v8_lvt[cdd]
echo OPV XX1_M18 cdd $&s1_xx1_m18_cdd
let s1_xx1_m18_cds = @m.x1.xdut.xx1_m18.msky130_fd_pr__nfet_01v8_lvt[cds]
echo OPV XX1_M18 cds $&s1_xx1_m18_cds
let s1_xx1_m18_cdb = @m.x1.xdut.xx1_m18.msky130_fd_pr__nfet_01v8_lvt[cdb]
echo OPV XX1_M18 cdb $&s1_xx1_m18_cdb
let s1_xx1_m18_csg = @m.x1.xdut.xx1_m18.msky130_fd_pr__nfet_01v8_lvt[csg]
echo OPV XX1_M18 csg $&s1_xx1_m18_csg
let s1_xx1_m18_csd = @m.x1.xdut.xx1_m18.msky130_fd_pr__nfet_01v8_lvt[csd]
echo OPV XX1_M18 csd $&s1_xx1_m18_csd
let s1_xx1_m18_css = @m.x1.xdut.xx1_m18.msky130_fd_pr__nfet_01v8_lvt[css]
echo OPV XX1_M18 css $&s1_xx1_m18_css
let s1_xx1_m18_csb = @m.x1.xdut.xx1_m18.msky130_fd_pr__nfet_01v8_lvt[csb]
echo OPV XX1_M18 csb $&s1_xx1_m18_csb
let s1_xx1_m18_cbg = @m.x1.xdut.xx1_m18.msky130_fd_pr__nfet_01v8_lvt[cbg]
echo OPV XX1_M18 cbg $&s1_xx1_m18_cbg
let s1_xx1_m18_cbd = @m.x1.xdut.xx1_m18.msky130_fd_pr__nfet_01v8_lvt[cbd]
echo OPV XX1_M18 cbd $&s1_xx1_m18_cbd
let s1_xx1_m18_cbs = @m.x1.xdut.xx1_m18.msky130_fd_pr__nfet_01v8_lvt[cbs]
echo OPV XX1_M18 cbs $&s1_xx1_m18_cbs
let s1_xx1_m18_cbb = @m.x1.xdut.xx1_m18.msky130_fd_pr__nfet_01v8_lvt[cbb]
echo OPV XX1_M18 cbb $&s1_xx1_m18_cbb
let s1_xx1_m18_capbd = @m.x1.xdut.xx1_m18.msky130_fd_pr__nfet_01v8_lvt[capbd]
echo OPV XX1_M18 capbd $&s1_xx1_m18_capbd
let s1_xx1_m18_capbs = @m.x1.xdut.xx1_m18.msky130_fd_pr__nfet_01v8_lvt[capbs]
echo OPV XX1_M18 capbs $&s1_xx1_m18_capbs
let s1_xx1_m18_cgso = @m.x1.xdut.xx1_m18.msky130_fd_pr__nfet_01v8_lvt[cgso]
echo OPV XX1_M18 cgso $&s1_xx1_m18_cgso
let s1_xx1_m18_cgdo = @m.x1.xdut.xx1_m18.msky130_fd_pr__nfet_01v8_lvt[cgdo]
echo OPV XX1_M18 cgdo $&s1_xx1_m18_cgdo
let s1_xx1_m18_cgbo = @m.x1.xdut.xx1_m18.msky130_fd_pr__nfet_01v8_lvt[cgbo]
echo OPV XX1_M18 cgbo $&s1_xx1_m18_cgbo
let s1_xx1_m18_weff = @m.x1.xdut.xx1_m18.msky130_fd_pr__nfet_01v8_lvt[weff]
echo OPV XX1_M18 weff $&s1_xx1_m18_weff
let s1_xx1_m18_leff = @m.x1.xdut.xx1_m18.msky130_fd_pr__nfet_01v8_lvt[leff]
echo OPV XX1_M18 leff $&s1_xx1_m18_leff
let s1_xx1_m22_id = @m.x1.xdut.xx1_m22.msky130_fd_pr__nfet_01v8_lvt[id]
echo OPV XX1_M22 id $&s1_xx1_m22_id
let s1_xx1_m22_vgs = @m.x1.xdut.xx1_m22.msky130_fd_pr__nfet_01v8_lvt[vgs]
echo OPV XX1_M22 vgs $&s1_xx1_m22_vgs
let s1_xx1_m22_vds = @m.x1.xdut.xx1_m22.msky130_fd_pr__nfet_01v8_lvt[vds]
echo OPV XX1_M22 vds $&s1_xx1_m22_vds
let s1_xx1_m22_vbs = @m.x1.xdut.xx1_m22.msky130_fd_pr__nfet_01v8_lvt[vbs]
echo OPV XX1_M22 vbs $&s1_xx1_m22_vbs
let s1_xx1_m22_vth = @m.x1.xdut.xx1_m22.msky130_fd_pr__nfet_01v8_lvt[vth]
echo OPV XX1_M22 vth $&s1_xx1_m22_vth
let s1_xx1_m22_vdsat = @m.x1.xdut.xx1_m22.msky130_fd_pr__nfet_01v8_lvt[vdsat]
echo OPV XX1_M22 vdsat $&s1_xx1_m22_vdsat
let s1_xx1_m22_gm = @m.x1.xdut.xx1_m22.msky130_fd_pr__nfet_01v8_lvt[gm]
echo OPV XX1_M22 gm $&s1_xx1_m22_gm
let s1_xx1_m22_gds = @m.x1.xdut.xx1_m22.msky130_fd_pr__nfet_01v8_lvt[gds]
echo OPV XX1_M22 gds $&s1_xx1_m22_gds
let s1_xx1_m22_gmbs = @m.x1.xdut.xx1_m22.msky130_fd_pr__nfet_01v8_lvt[gmbs]
echo OPV XX1_M22 gmbs $&s1_xx1_m22_gmbs
let s1_xx1_m22_cgg = @m.x1.xdut.xx1_m22.msky130_fd_pr__nfet_01v8_lvt[cgg]
echo OPV XX1_M22 cgg $&s1_xx1_m22_cgg
let s1_xx1_m22_cgd = @m.x1.xdut.xx1_m22.msky130_fd_pr__nfet_01v8_lvt[cgd]
echo OPV XX1_M22 cgd $&s1_xx1_m22_cgd
let s1_xx1_m22_cgs = @m.x1.xdut.xx1_m22.msky130_fd_pr__nfet_01v8_lvt[cgs]
echo OPV XX1_M22 cgs $&s1_xx1_m22_cgs
let s1_xx1_m22_cgb = @m.x1.xdut.xx1_m22.msky130_fd_pr__nfet_01v8_lvt[cgb]
echo OPV XX1_M22 cgb $&s1_xx1_m22_cgb
let s1_xx1_m22_cdg = @m.x1.xdut.xx1_m22.msky130_fd_pr__nfet_01v8_lvt[cdg]
echo OPV XX1_M22 cdg $&s1_xx1_m22_cdg
let s1_xx1_m22_cdd = @m.x1.xdut.xx1_m22.msky130_fd_pr__nfet_01v8_lvt[cdd]
echo OPV XX1_M22 cdd $&s1_xx1_m22_cdd
let s1_xx1_m22_cds = @m.x1.xdut.xx1_m22.msky130_fd_pr__nfet_01v8_lvt[cds]
echo OPV XX1_M22 cds $&s1_xx1_m22_cds
let s1_xx1_m22_cdb = @m.x1.xdut.xx1_m22.msky130_fd_pr__nfet_01v8_lvt[cdb]
echo OPV XX1_M22 cdb $&s1_xx1_m22_cdb
let s1_xx1_m22_csg = @m.x1.xdut.xx1_m22.msky130_fd_pr__nfet_01v8_lvt[csg]
echo OPV XX1_M22 csg $&s1_xx1_m22_csg
let s1_xx1_m22_csd = @m.x1.xdut.xx1_m22.msky130_fd_pr__nfet_01v8_lvt[csd]
echo OPV XX1_M22 csd $&s1_xx1_m22_csd
let s1_xx1_m22_css = @m.x1.xdut.xx1_m22.msky130_fd_pr__nfet_01v8_lvt[css]
echo OPV XX1_M22 css $&s1_xx1_m22_css
let s1_xx1_m22_csb = @m.x1.xdut.xx1_m22.msky130_fd_pr__nfet_01v8_lvt[csb]
echo OPV XX1_M22 csb $&s1_xx1_m22_csb
let s1_xx1_m22_cbg = @m.x1.xdut.xx1_m22.msky130_fd_pr__nfet_01v8_lvt[cbg]
echo OPV XX1_M22 cbg $&s1_xx1_m22_cbg
let s1_xx1_m22_cbd = @m.x1.xdut.xx1_m22.msky130_fd_pr__nfet_01v8_lvt[cbd]
echo OPV XX1_M22 cbd $&s1_xx1_m22_cbd
let s1_xx1_m22_cbs = @m.x1.xdut.xx1_m22.msky130_fd_pr__nfet_01v8_lvt[cbs]
echo OPV XX1_M22 cbs $&s1_xx1_m22_cbs
let s1_xx1_m22_cbb = @m.x1.xdut.xx1_m22.msky130_fd_pr__nfet_01v8_lvt[cbb]
echo OPV XX1_M22 cbb $&s1_xx1_m22_cbb
let s1_xx1_m22_capbd = @m.x1.xdut.xx1_m22.msky130_fd_pr__nfet_01v8_lvt[capbd]
echo OPV XX1_M22 capbd $&s1_xx1_m22_capbd
let s1_xx1_m22_capbs = @m.x1.xdut.xx1_m22.msky130_fd_pr__nfet_01v8_lvt[capbs]
echo OPV XX1_M22 capbs $&s1_xx1_m22_capbs
let s1_xx1_m22_cgso = @m.x1.xdut.xx1_m22.msky130_fd_pr__nfet_01v8_lvt[cgso]
echo OPV XX1_M22 cgso $&s1_xx1_m22_cgso
let s1_xx1_m22_cgdo = @m.x1.xdut.xx1_m22.msky130_fd_pr__nfet_01v8_lvt[cgdo]
echo OPV XX1_M22 cgdo $&s1_xx1_m22_cgdo
let s1_xx1_m22_cgbo = @m.x1.xdut.xx1_m22.msky130_fd_pr__nfet_01v8_lvt[cgbo]
echo OPV XX1_M22 cgbo $&s1_xx1_m22_cgbo
let s1_xx1_m22_weff = @m.x1.xdut.xx1_m22.msky130_fd_pr__nfet_01v8_lvt[weff]
echo OPV XX1_M22 weff $&s1_xx1_m22_weff
let s1_xx1_m22_leff = @m.x1.xdut.xx1_m22.msky130_fd_pr__nfet_01v8_lvt[leff]
echo OPV XX1_M22 leff $&s1_xx1_m22_leff
let s1_xx1_m20_id = @m.x1.xdut.xx1_m20.msky130_fd_pr__pfet_01v8_lvt[id]
echo OPV XX1_M20 id $&s1_xx1_m20_id
let s1_xx1_m20_vgs = @m.x1.xdut.xx1_m20.msky130_fd_pr__pfet_01v8_lvt[vgs]
echo OPV XX1_M20 vgs $&s1_xx1_m20_vgs
let s1_xx1_m20_vds = @m.x1.xdut.xx1_m20.msky130_fd_pr__pfet_01v8_lvt[vds]
echo OPV XX1_M20 vds $&s1_xx1_m20_vds
let s1_xx1_m20_vbs = @m.x1.xdut.xx1_m20.msky130_fd_pr__pfet_01v8_lvt[vbs]
echo OPV XX1_M20 vbs $&s1_xx1_m20_vbs
let s1_xx1_m20_vth = @m.x1.xdut.xx1_m20.msky130_fd_pr__pfet_01v8_lvt[vth]
echo OPV XX1_M20 vth $&s1_xx1_m20_vth
let s1_xx1_m20_vdsat = @m.x1.xdut.xx1_m20.msky130_fd_pr__pfet_01v8_lvt[vdsat]
echo OPV XX1_M20 vdsat $&s1_xx1_m20_vdsat
let s1_xx1_m20_gm = @m.x1.xdut.xx1_m20.msky130_fd_pr__pfet_01v8_lvt[gm]
echo OPV XX1_M20 gm $&s1_xx1_m20_gm
let s1_xx1_m20_gds = @m.x1.xdut.xx1_m20.msky130_fd_pr__pfet_01v8_lvt[gds]
echo OPV XX1_M20 gds $&s1_xx1_m20_gds
let s1_xx1_m20_gmbs = @m.x1.xdut.xx1_m20.msky130_fd_pr__pfet_01v8_lvt[gmbs]
echo OPV XX1_M20 gmbs $&s1_xx1_m20_gmbs
let s1_xx1_m20_cgg = @m.x1.xdut.xx1_m20.msky130_fd_pr__pfet_01v8_lvt[cgg]
echo OPV XX1_M20 cgg $&s1_xx1_m20_cgg
let s1_xx1_m20_cgd = @m.x1.xdut.xx1_m20.msky130_fd_pr__pfet_01v8_lvt[cgd]
echo OPV XX1_M20 cgd $&s1_xx1_m20_cgd
let s1_xx1_m20_cgs = @m.x1.xdut.xx1_m20.msky130_fd_pr__pfet_01v8_lvt[cgs]
echo OPV XX1_M20 cgs $&s1_xx1_m20_cgs
let s1_xx1_m20_cgb = @m.x1.xdut.xx1_m20.msky130_fd_pr__pfet_01v8_lvt[cgb]
echo OPV XX1_M20 cgb $&s1_xx1_m20_cgb
let s1_xx1_m20_cdg = @m.x1.xdut.xx1_m20.msky130_fd_pr__pfet_01v8_lvt[cdg]
echo OPV XX1_M20 cdg $&s1_xx1_m20_cdg
let s1_xx1_m20_cdd = @m.x1.xdut.xx1_m20.msky130_fd_pr__pfet_01v8_lvt[cdd]
echo OPV XX1_M20 cdd $&s1_xx1_m20_cdd
let s1_xx1_m20_cds = @m.x1.xdut.xx1_m20.msky130_fd_pr__pfet_01v8_lvt[cds]
echo OPV XX1_M20 cds $&s1_xx1_m20_cds
let s1_xx1_m20_cdb = @m.x1.xdut.xx1_m20.msky130_fd_pr__pfet_01v8_lvt[cdb]
echo OPV XX1_M20 cdb $&s1_xx1_m20_cdb
let s1_xx1_m20_csg = @m.x1.xdut.xx1_m20.msky130_fd_pr__pfet_01v8_lvt[csg]
echo OPV XX1_M20 csg $&s1_xx1_m20_csg
let s1_xx1_m20_csd = @m.x1.xdut.xx1_m20.msky130_fd_pr__pfet_01v8_lvt[csd]
echo OPV XX1_M20 csd $&s1_xx1_m20_csd
let s1_xx1_m20_css = @m.x1.xdut.xx1_m20.msky130_fd_pr__pfet_01v8_lvt[css]
echo OPV XX1_M20 css $&s1_xx1_m20_css
let s1_xx1_m20_csb = @m.x1.xdut.xx1_m20.msky130_fd_pr__pfet_01v8_lvt[csb]
echo OPV XX1_M20 csb $&s1_xx1_m20_csb
let s1_xx1_m20_cbg = @m.x1.xdut.xx1_m20.msky130_fd_pr__pfet_01v8_lvt[cbg]
echo OPV XX1_M20 cbg $&s1_xx1_m20_cbg
let s1_xx1_m20_cbd = @m.x1.xdut.xx1_m20.msky130_fd_pr__pfet_01v8_lvt[cbd]
echo OPV XX1_M20 cbd $&s1_xx1_m20_cbd
let s1_xx1_m20_cbs = @m.x1.xdut.xx1_m20.msky130_fd_pr__pfet_01v8_lvt[cbs]
echo OPV XX1_M20 cbs $&s1_xx1_m20_cbs
let s1_xx1_m20_cbb = @m.x1.xdut.xx1_m20.msky130_fd_pr__pfet_01v8_lvt[cbb]
echo OPV XX1_M20 cbb $&s1_xx1_m20_cbb
let s1_xx1_m20_capbd = @m.x1.xdut.xx1_m20.msky130_fd_pr__pfet_01v8_lvt[capbd]
echo OPV XX1_M20 capbd $&s1_xx1_m20_capbd
let s1_xx1_m20_capbs = @m.x1.xdut.xx1_m20.msky130_fd_pr__pfet_01v8_lvt[capbs]
echo OPV XX1_M20 capbs $&s1_xx1_m20_capbs
let s1_xx1_m20_cgso = @m.x1.xdut.xx1_m20.msky130_fd_pr__pfet_01v8_lvt[cgso]
echo OPV XX1_M20 cgso $&s1_xx1_m20_cgso
let s1_xx1_m20_cgdo = @m.x1.xdut.xx1_m20.msky130_fd_pr__pfet_01v8_lvt[cgdo]
echo OPV XX1_M20 cgdo $&s1_xx1_m20_cgdo
let s1_xx1_m20_cgbo = @m.x1.xdut.xx1_m20.msky130_fd_pr__pfet_01v8_lvt[cgbo]
echo OPV XX1_M20 cgbo $&s1_xx1_m20_cgbo
let s1_xx1_m20_weff = @m.x1.xdut.xx1_m20.msky130_fd_pr__pfet_01v8_lvt[weff]
echo OPV XX1_M20 weff $&s1_xx1_m20_weff
let s1_xx1_m20_leff = @m.x1.xdut.xx1_m20.msky130_fd_pr__pfet_01v8_lvt[leff]
echo OPV XX1_M20 leff $&s1_xx1_m20_leff
let s1_xx1_m21_id = @m.x1.xdut.xx1_m21.msky130_fd_pr__pfet_01v8_lvt[id]
echo OPV XX1_M21 id $&s1_xx1_m21_id
let s1_xx1_m21_vgs = @m.x1.xdut.xx1_m21.msky130_fd_pr__pfet_01v8_lvt[vgs]
echo OPV XX1_M21 vgs $&s1_xx1_m21_vgs
let s1_xx1_m21_vds = @m.x1.xdut.xx1_m21.msky130_fd_pr__pfet_01v8_lvt[vds]
echo OPV XX1_M21 vds $&s1_xx1_m21_vds
let s1_xx1_m21_vbs = @m.x1.xdut.xx1_m21.msky130_fd_pr__pfet_01v8_lvt[vbs]
echo OPV XX1_M21 vbs $&s1_xx1_m21_vbs
let s1_xx1_m21_vth = @m.x1.xdut.xx1_m21.msky130_fd_pr__pfet_01v8_lvt[vth]
echo OPV XX1_M21 vth $&s1_xx1_m21_vth
let s1_xx1_m21_vdsat = @m.x1.xdut.xx1_m21.msky130_fd_pr__pfet_01v8_lvt[vdsat]
echo OPV XX1_M21 vdsat $&s1_xx1_m21_vdsat
let s1_xx1_m21_gm = @m.x1.xdut.xx1_m21.msky130_fd_pr__pfet_01v8_lvt[gm]
echo OPV XX1_M21 gm $&s1_xx1_m21_gm
let s1_xx1_m21_gds = @m.x1.xdut.xx1_m21.msky130_fd_pr__pfet_01v8_lvt[gds]
echo OPV XX1_M21 gds $&s1_xx1_m21_gds
let s1_xx1_m21_gmbs = @m.x1.xdut.xx1_m21.msky130_fd_pr__pfet_01v8_lvt[gmbs]
echo OPV XX1_M21 gmbs $&s1_xx1_m21_gmbs
let s1_xx1_m21_cgg = @m.x1.xdut.xx1_m21.msky130_fd_pr__pfet_01v8_lvt[cgg]
echo OPV XX1_M21 cgg $&s1_xx1_m21_cgg
let s1_xx1_m21_cgd = @m.x1.xdut.xx1_m21.msky130_fd_pr__pfet_01v8_lvt[cgd]
echo OPV XX1_M21 cgd $&s1_xx1_m21_cgd
let s1_xx1_m21_cgs = @m.x1.xdut.xx1_m21.msky130_fd_pr__pfet_01v8_lvt[cgs]
echo OPV XX1_M21 cgs $&s1_xx1_m21_cgs
let s1_xx1_m21_cgb = @m.x1.xdut.xx1_m21.msky130_fd_pr__pfet_01v8_lvt[cgb]
echo OPV XX1_M21 cgb $&s1_xx1_m21_cgb
let s1_xx1_m21_cdg = @m.x1.xdut.xx1_m21.msky130_fd_pr__pfet_01v8_lvt[cdg]
echo OPV XX1_M21 cdg $&s1_xx1_m21_cdg
let s1_xx1_m21_cdd = @m.x1.xdut.xx1_m21.msky130_fd_pr__pfet_01v8_lvt[cdd]
echo OPV XX1_M21 cdd $&s1_xx1_m21_cdd
let s1_xx1_m21_cds = @m.x1.xdut.xx1_m21.msky130_fd_pr__pfet_01v8_lvt[cds]
echo OPV XX1_M21 cds $&s1_xx1_m21_cds
let s1_xx1_m21_cdb = @m.x1.xdut.xx1_m21.msky130_fd_pr__pfet_01v8_lvt[cdb]
echo OPV XX1_M21 cdb $&s1_xx1_m21_cdb
let s1_xx1_m21_csg = @m.x1.xdut.xx1_m21.msky130_fd_pr__pfet_01v8_lvt[csg]
echo OPV XX1_M21 csg $&s1_xx1_m21_csg
let s1_xx1_m21_csd = @m.x1.xdut.xx1_m21.msky130_fd_pr__pfet_01v8_lvt[csd]
echo OPV XX1_M21 csd $&s1_xx1_m21_csd
let s1_xx1_m21_css = @m.x1.xdut.xx1_m21.msky130_fd_pr__pfet_01v8_lvt[css]
echo OPV XX1_M21 css $&s1_xx1_m21_css
let s1_xx1_m21_csb = @m.x1.xdut.xx1_m21.msky130_fd_pr__pfet_01v8_lvt[csb]
echo OPV XX1_M21 csb $&s1_xx1_m21_csb
let s1_xx1_m21_cbg = @m.x1.xdut.xx1_m21.msky130_fd_pr__pfet_01v8_lvt[cbg]
echo OPV XX1_M21 cbg $&s1_xx1_m21_cbg
let s1_xx1_m21_cbd = @m.x1.xdut.xx1_m21.msky130_fd_pr__pfet_01v8_lvt[cbd]
echo OPV XX1_M21 cbd $&s1_xx1_m21_cbd
let s1_xx1_m21_cbs = @m.x1.xdut.xx1_m21.msky130_fd_pr__pfet_01v8_lvt[cbs]
echo OPV XX1_M21 cbs $&s1_xx1_m21_cbs
let s1_xx1_m21_cbb = @m.x1.xdut.xx1_m21.msky130_fd_pr__pfet_01v8_lvt[cbb]
echo OPV XX1_M21 cbb $&s1_xx1_m21_cbb
let s1_xx1_m21_capbd = @m.x1.xdut.xx1_m21.msky130_fd_pr__pfet_01v8_lvt[capbd]
echo OPV XX1_M21 capbd $&s1_xx1_m21_capbd
let s1_xx1_m21_capbs = @m.x1.xdut.xx1_m21.msky130_fd_pr__pfet_01v8_lvt[capbs]
echo OPV XX1_M21 capbs $&s1_xx1_m21_capbs
let s1_xx1_m21_cgso = @m.x1.xdut.xx1_m21.msky130_fd_pr__pfet_01v8_lvt[cgso]
echo OPV XX1_M21 cgso $&s1_xx1_m21_cgso
let s1_xx1_m21_cgdo = @m.x1.xdut.xx1_m21.msky130_fd_pr__pfet_01v8_lvt[cgdo]
echo OPV XX1_M21 cgdo $&s1_xx1_m21_cgdo
let s1_xx1_m21_cgbo = @m.x1.xdut.xx1_m21.msky130_fd_pr__pfet_01v8_lvt[cgbo]
echo OPV XX1_M21 cgbo $&s1_xx1_m21_cgbo
let s1_xx1_m21_weff = @m.x1.xdut.xx1_m21.msky130_fd_pr__pfet_01v8_lvt[weff]
echo OPV XX1_M21 weff $&s1_xx1_m21_weff
let s1_xx1_m21_leff = @m.x1.xdut.xx1_m21.msky130_fd_pr__pfet_01v8_lvt[leff]
echo OPV XX1_M21 leff $&s1_xx1_m21_leff
let s1_xx1_m15_id = @m.x1.xdut.xx1_m15.msky130_fd_pr__nfet_01v8_lvt[id]
echo OPV XX1_M15 id $&s1_xx1_m15_id
let s1_xx1_m15_vgs = @m.x1.xdut.xx1_m15.msky130_fd_pr__nfet_01v8_lvt[vgs]
echo OPV XX1_M15 vgs $&s1_xx1_m15_vgs
let s1_xx1_m15_vds = @m.x1.xdut.xx1_m15.msky130_fd_pr__nfet_01v8_lvt[vds]
echo OPV XX1_M15 vds $&s1_xx1_m15_vds
let s1_xx1_m15_vbs = @m.x1.xdut.xx1_m15.msky130_fd_pr__nfet_01v8_lvt[vbs]
echo OPV XX1_M15 vbs $&s1_xx1_m15_vbs
let s1_xx1_m15_vth = @m.x1.xdut.xx1_m15.msky130_fd_pr__nfet_01v8_lvt[vth]
echo OPV XX1_M15 vth $&s1_xx1_m15_vth
let s1_xx1_m15_vdsat = @m.x1.xdut.xx1_m15.msky130_fd_pr__nfet_01v8_lvt[vdsat]
echo OPV XX1_M15 vdsat $&s1_xx1_m15_vdsat
let s1_xx1_m15_gm = @m.x1.xdut.xx1_m15.msky130_fd_pr__nfet_01v8_lvt[gm]
echo OPV XX1_M15 gm $&s1_xx1_m15_gm
let s1_xx1_m15_gds = @m.x1.xdut.xx1_m15.msky130_fd_pr__nfet_01v8_lvt[gds]
echo OPV XX1_M15 gds $&s1_xx1_m15_gds
let s1_xx1_m15_gmbs = @m.x1.xdut.xx1_m15.msky130_fd_pr__nfet_01v8_lvt[gmbs]
echo OPV XX1_M15 gmbs $&s1_xx1_m15_gmbs
let s1_xx1_m15_cgg = @m.x1.xdut.xx1_m15.msky130_fd_pr__nfet_01v8_lvt[cgg]
echo OPV XX1_M15 cgg $&s1_xx1_m15_cgg
let s1_xx1_m15_cgd = @m.x1.xdut.xx1_m15.msky130_fd_pr__nfet_01v8_lvt[cgd]
echo OPV XX1_M15 cgd $&s1_xx1_m15_cgd
let s1_xx1_m15_cgs = @m.x1.xdut.xx1_m15.msky130_fd_pr__nfet_01v8_lvt[cgs]
echo OPV XX1_M15 cgs $&s1_xx1_m15_cgs
let s1_xx1_m15_cgb = @m.x1.xdut.xx1_m15.msky130_fd_pr__nfet_01v8_lvt[cgb]
echo OPV XX1_M15 cgb $&s1_xx1_m15_cgb
let s1_xx1_m15_cdg = @m.x1.xdut.xx1_m15.msky130_fd_pr__nfet_01v8_lvt[cdg]
echo OPV XX1_M15 cdg $&s1_xx1_m15_cdg
let s1_xx1_m15_cdd = @m.x1.xdut.xx1_m15.msky130_fd_pr__nfet_01v8_lvt[cdd]
echo OPV XX1_M15 cdd $&s1_xx1_m15_cdd
let s1_xx1_m15_cds = @m.x1.xdut.xx1_m15.msky130_fd_pr__nfet_01v8_lvt[cds]
echo OPV XX1_M15 cds $&s1_xx1_m15_cds
let s1_xx1_m15_cdb = @m.x1.xdut.xx1_m15.msky130_fd_pr__nfet_01v8_lvt[cdb]
echo OPV XX1_M15 cdb $&s1_xx1_m15_cdb
let s1_xx1_m15_csg = @m.x1.xdut.xx1_m15.msky130_fd_pr__nfet_01v8_lvt[csg]
echo OPV XX1_M15 csg $&s1_xx1_m15_csg
let s1_xx1_m15_csd = @m.x1.xdut.xx1_m15.msky130_fd_pr__nfet_01v8_lvt[csd]
echo OPV XX1_M15 csd $&s1_xx1_m15_csd
let s1_xx1_m15_css = @m.x1.xdut.xx1_m15.msky130_fd_pr__nfet_01v8_lvt[css]
echo OPV XX1_M15 css $&s1_xx1_m15_css
let s1_xx1_m15_csb = @m.x1.xdut.xx1_m15.msky130_fd_pr__nfet_01v8_lvt[csb]
echo OPV XX1_M15 csb $&s1_xx1_m15_csb
let s1_xx1_m15_cbg = @m.x1.xdut.xx1_m15.msky130_fd_pr__nfet_01v8_lvt[cbg]
echo OPV XX1_M15 cbg $&s1_xx1_m15_cbg
let s1_xx1_m15_cbd = @m.x1.xdut.xx1_m15.msky130_fd_pr__nfet_01v8_lvt[cbd]
echo OPV XX1_M15 cbd $&s1_xx1_m15_cbd
let s1_xx1_m15_cbs = @m.x1.xdut.xx1_m15.msky130_fd_pr__nfet_01v8_lvt[cbs]
echo OPV XX1_M15 cbs $&s1_xx1_m15_cbs
let s1_xx1_m15_cbb = @m.x1.xdut.xx1_m15.msky130_fd_pr__nfet_01v8_lvt[cbb]
echo OPV XX1_M15 cbb $&s1_xx1_m15_cbb
let s1_xx1_m15_capbd = @m.x1.xdut.xx1_m15.msky130_fd_pr__nfet_01v8_lvt[capbd]
echo OPV XX1_M15 capbd $&s1_xx1_m15_capbd
let s1_xx1_m15_capbs = @m.x1.xdut.xx1_m15.msky130_fd_pr__nfet_01v8_lvt[capbs]
echo OPV XX1_M15 capbs $&s1_xx1_m15_capbs
let s1_xx1_m15_cgso = @m.x1.xdut.xx1_m15.msky130_fd_pr__nfet_01v8_lvt[cgso]
echo OPV XX1_M15 cgso $&s1_xx1_m15_cgso
let s1_xx1_m15_cgdo = @m.x1.xdut.xx1_m15.msky130_fd_pr__nfet_01v8_lvt[cgdo]
echo OPV XX1_M15 cgdo $&s1_xx1_m15_cgdo
let s1_xx1_m15_cgbo = @m.x1.xdut.xx1_m15.msky130_fd_pr__nfet_01v8_lvt[cgbo]
echo OPV XX1_M15 cgbo $&s1_xx1_m15_cgbo
let s1_xx1_m15_weff = @m.x1.xdut.xx1_m15.msky130_fd_pr__nfet_01v8_lvt[weff]
echo OPV XX1_M15 weff $&s1_xx1_m15_weff
let s1_xx1_m15_leff = @m.x1.xdut.xx1_m15.msky130_fd_pr__nfet_01v8_lvt[leff]
echo OPV XX1_M15 leff $&s1_xx1_m15_leff
let s1_xx1_m16_id = @m.x1.xdut.xx1_m16.msky130_fd_pr__nfet_01v8_lvt[id]
echo OPV XX1_M16 id $&s1_xx1_m16_id
let s1_xx1_m16_vgs = @m.x1.xdut.xx1_m16.msky130_fd_pr__nfet_01v8_lvt[vgs]
echo OPV XX1_M16 vgs $&s1_xx1_m16_vgs
let s1_xx1_m16_vds = @m.x1.xdut.xx1_m16.msky130_fd_pr__nfet_01v8_lvt[vds]
echo OPV XX1_M16 vds $&s1_xx1_m16_vds
let s1_xx1_m16_vbs = @m.x1.xdut.xx1_m16.msky130_fd_pr__nfet_01v8_lvt[vbs]
echo OPV XX1_M16 vbs $&s1_xx1_m16_vbs
let s1_xx1_m16_vth = @m.x1.xdut.xx1_m16.msky130_fd_pr__nfet_01v8_lvt[vth]
echo OPV XX1_M16 vth $&s1_xx1_m16_vth
let s1_xx1_m16_vdsat = @m.x1.xdut.xx1_m16.msky130_fd_pr__nfet_01v8_lvt[vdsat]
echo OPV XX1_M16 vdsat $&s1_xx1_m16_vdsat
let s1_xx1_m16_gm = @m.x1.xdut.xx1_m16.msky130_fd_pr__nfet_01v8_lvt[gm]
echo OPV XX1_M16 gm $&s1_xx1_m16_gm
let s1_xx1_m16_gds = @m.x1.xdut.xx1_m16.msky130_fd_pr__nfet_01v8_lvt[gds]
echo OPV XX1_M16 gds $&s1_xx1_m16_gds
let s1_xx1_m16_gmbs = @m.x1.xdut.xx1_m16.msky130_fd_pr__nfet_01v8_lvt[gmbs]
echo OPV XX1_M16 gmbs $&s1_xx1_m16_gmbs
let s1_xx1_m16_cgg = @m.x1.xdut.xx1_m16.msky130_fd_pr__nfet_01v8_lvt[cgg]
echo OPV XX1_M16 cgg $&s1_xx1_m16_cgg
let s1_xx1_m16_cgd = @m.x1.xdut.xx1_m16.msky130_fd_pr__nfet_01v8_lvt[cgd]
echo OPV XX1_M16 cgd $&s1_xx1_m16_cgd
let s1_xx1_m16_cgs = @m.x1.xdut.xx1_m16.msky130_fd_pr__nfet_01v8_lvt[cgs]
echo OPV XX1_M16 cgs $&s1_xx1_m16_cgs
let s1_xx1_m16_cgb = @m.x1.xdut.xx1_m16.msky130_fd_pr__nfet_01v8_lvt[cgb]
echo OPV XX1_M16 cgb $&s1_xx1_m16_cgb
let s1_xx1_m16_cdg = @m.x1.xdut.xx1_m16.msky130_fd_pr__nfet_01v8_lvt[cdg]
echo OPV XX1_M16 cdg $&s1_xx1_m16_cdg
let s1_xx1_m16_cdd = @m.x1.xdut.xx1_m16.msky130_fd_pr__nfet_01v8_lvt[cdd]
echo OPV XX1_M16 cdd $&s1_xx1_m16_cdd
let s1_xx1_m16_cds = @m.x1.xdut.xx1_m16.msky130_fd_pr__nfet_01v8_lvt[cds]
echo OPV XX1_M16 cds $&s1_xx1_m16_cds
let s1_xx1_m16_cdb = @m.x1.xdut.xx1_m16.msky130_fd_pr__nfet_01v8_lvt[cdb]
echo OPV XX1_M16 cdb $&s1_xx1_m16_cdb
let s1_xx1_m16_csg = @m.x1.xdut.xx1_m16.msky130_fd_pr__nfet_01v8_lvt[csg]
echo OPV XX1_M16 csg $&s1_xx1_m16_csg
let s1_xx1_m16_csd = @m.x1.xdut.xx1_m16.msky130_fd_pr__nfet_01v8_lvt[csd]
echo OPV XX1_M16 csd $&s1_xx1_m16_csd
let s1_xx1_m16_css = @m.x1.xdut.xx1_m16.msky130_fd_pr__nfet_01v8_lvt[css]
echo OPV XX1_M16 css $&s1_xx1_m16_css
let s1_xx1_m16_csb = @m.x1.xdut.xx1_m16.msky130_fd_pr__nfet_01v8_lvt[csb]
echo OPV XX1_M16 csb $&s1_xx1_m16_csb
let s1_xx1_m16_cbg = @m.x1.xdut.xx1_m16.msky130_fd_pr__nfet_01v8_lvt[cbg]
echo OPV XX1_M16 cbg $&s1_xx1_m16_cbg
let s1_xx1_m16_cbd = @m.x1.xdut.xx1_m16.msky130_fd_pr__nfet_01v8_lvt[cbd]
echo OPV XX1_M16 cbd $&s1_xx1_m16_cbd
let s1_xx1_m16_cbs = @m.x1.xdut.xx1_m16.msky130_fd_pr__nfet_01v8_lvt[cbs]
echo OPV XX1_M16 cbs $&s1_xx1_m16_cbs
let s1_xx1_m16_cbb = @m.x1.xdut.xx1_m16.msky130_fd_pr__nfet_01v8_lvt[cbb]
echo OPV XX1_M16 cbb $&s1_xx1_m16_cbb
let s1_xx1_m16_capbd = @m.x1.xdut.xx1_m16.msky130_fd_pr__nfet_01v8_lvt[capbd]
echo OPV XX1_M16 capbd $&s1_xx1_m16_capbd
let s1_xx1_m16_capbs = @m.x1.xdut.xx1_m16.msky130_fd_pr__nfet_01v8_lvt[capbs]
echo OPV XX1_M16 capbs $&s1_xx1_m16_capbs
let s1_xx1_m16_cgso = @m.x1.xdut.xx1_m16.msky130_fd_pr__nfet_01v8_lvt[cgso]
echo OPV XX1_M16 cgso $&s1_xx1_m16_cgso
let s1_xx1_m16_cgdo = @m.x1.xdut.xx1_m16.msky130_fd_pr__nfet_01v8_lvt[cgdo]
echo OPV XX1_M16 cgdo $&s1_xx1_m16_cgdo
let s1_xx1_m16_cgbo = @m.x1.xdut.xx1_m16.msky130_fd_pr__nfet_01v8_lvt[cgbo]
echo OPV XX1_M16 cgbo $&s1_xx1_m16_cgbo
let s1_xx1_m16_weff = @m.x1.xdut.xx1_m16.msky130_fd_pr__nfet_01v8_lvt[weff]
echo OPV XX1_M16 weff $&s1_xx1_m16_weff
let s1_xx1_m16_leff = @m.x1.xdut.xx1_m16.msky130_fd_pr__nfet_01v8_lvt[leff]
echo OPV XX1_M16 leff $&s1_xx1_m16_leff
let s1_xx1_m46_id = @m.x1.xdut.xx1_m46.msky130_fd_pr__nfet_01v8_lvt[id]
echo OPV XX1_M46 id $&s1_xx1_m46_id
let s1_xx1_m46_vgs = @m.x1.xdut.xx1_m46.msky130_fd_pr__nfet_01v8_lvt[vgs]
echo OPV XX1_M46 vgs $&s1_xx1_m46_vgs
let s1_xx1_m46_vds = @m.x1.xdut.xx1_m46.msky130_fd_pr__nfet_01v8_lvt[vds]
echo OPV XX1_M46 vds $&s1_xx1_m46_vds
let s1_xx1_m46_vbs = @m.x1.xdut.xx1_m46.msky130_fd_pr__nfet_01v8_lvt[vbs]
echo OPV XX1_M46 vbs $&s1_xx1_m46_vbs
let s1_xx1_m46_vth = @m.x1.xdut.xx1_m46.msky130_fd_pr__nfet_01v8_lvt[vth]
echo OPV XX1_M46 vth $&s1_xx1_m46_vth
let s1_xx1_m46_vdsat = @m.x1.xdut.xx1_m46.msky130_fd_pr__nfet_01v8_lvt[vdsat]
echo OPV XX1_M46 vdsat $&s1_xx1_m46_vdsat
let s1_xx1_m46_gm = @m.x1.xdut.xx1_m46.msky130_fd_pr__nfet_01v8_lvt[gm]
echo OPV XX1_M46 gm $&s1_xx1_m46_gm
let s1_xx1_m46_gds = @m.x1.xdut.xx1_m46.msky130_fd_pr__nfet_01v8_lvt[gds]
echo OPV XX1_M46 gds $&s1_xx1_m46_gds
let s1_xx1_m46_gmbs = @m.x1.xdut.xx1_m46.msky130_fd_pr__nfet_01v8_lvt[gmbs]
echo OPV XX1_M46 gmbs $&s1_xx1_m46_gmbs
let s1_xx1_m46_cgg = @m.x1.xdut.xx1_m46.msky130_fd_pr__nfet_01v8_lvt[cgg]
echo OPV XX1_M46 cgg $&s1_xx1_m46_cgg
let s1_xx1_m46_cgd = @m.x1.xdut.xx1_m46.msky130_fd_pr__nfet_01v8_lvt[cgd]
echo OPV XX1_M46 cgd $&s1_xx1_m46_cgd
let s1_xx1_m46_cgs = @m.x1.xdut.xx1_m46.msky130_fd_pr__nfet_01v8_lvt[cgs]
echo OPV XX1_M46 cgs $&s1_xx1_m46_cgs
let s1_xx1_m46_cgb = @m.x1.xdut.xx1_m46.msky130_fd_pr__nfet_01v8_lvt[cgb]
echo OPV XX1_M46 cgb $&s1_xx1_m46_cgb
let s1_xx1_m46_cdg = @m.x1.xdut.xx1_m46.msky130_fd_pr__nfet_01v8_lvt[cdg]
echo OPV XX1_M46 cdg $&s1_xx1_m46_cdg
let s1_xx1_m46_cdd = @m.x1.xdut.xx1_m46.msky130_fd_pr__nfet_01v8_lvt[cdd]
echo OPV XX1_M46 cdd $&s1_xx1_m46_cdd
let s1_xx1_m46_cds = @m.x1.xdut.xx1_m46.msky130_fd_pr__nfet_01v8_lvt[cds]
echo OPV XX1_M46 cds $&s1_xx1_m46_cds
let s1_xx1_m46_cdb = @m.x1.xdut.xx1_m46.msky130_fd_pr__nfet_01v8_lvt[cdb]
echo OPV XX1_M46 cdb $&s1_xx1_m46_cdb
let s1_xx1_m46_csg = @m.x1.xdut.xx1_m46.msky130_fd_pr__nfet_01v8_lvt[csg]
echo OPV XX1_M46 csg $&s1_xx1_m46_csg
let s1_xx1_m46_csd = @m.x1.xdut.xx1_m46.msky130_fd_pr__nfet_01v8_lvt[csd]
echo OPV XX1_M46 csd $&s1_xx1_m46_csd
let s1_xx1_m46_css = @m.x1.xdut.xx1_m46.msky130_fd_pr__nfet_01v8_lvt[css]
echo OPV XX1_M46 css $&s1_xx1_m46_css
let s1_xx1_m46_csb = @m.x1.xdut.xx1_m46.msky130_fd_pr__nfet_01v8_lvt[csb]
echo OPV XX1_M46 csb $&s1_xx1_m46_csb
let s1_xx1_m46_cbg = @m.x1.xdut.xx1_m46.msky130_fd_pr__nfet_01v8_lvt[cbg]
echo OPV XX1_M46 cbg $&s1_xx1_m46_cbg
let s1_xx1_m46_cbd = @m.x1.xdut.xx1_m46.msky130_fd_pr__nfet_01v8_lvt[cbd]
echo OPV XX1_M46 cbd $&s1_xx1_m46_cbd
let s1_xx1_m46_cbs = @m.x1.xdut.xx1_m46.msky130_fd_pr__nfet_01v8_lvt[cbs]
echo OPV XX1_M46 cbs $&s1_xx1_m46_cbs
let s1_xx1_m46_cbb = @m.x1.xdut.xx1_m46.msky130_fd_pr__nfet_01v8_lvt[cbb]
echo OPV XX1_M46 cbb $&s1_xx1_m46_cbb
let s1_xx1_m46_capbd = @m.x1.xdut.xx1_m46.msky130_fd_pr__nfet_01v8_lvt[capbd]
echo OPV XX1_M46 capbd $&s1_xx1_m46_capbd
let s1_xx1_m46_capbs = @m.x1.xdut.xx1_m46.msky130_fd_pr__nfet_01v8_lvt[capbs]
echo OPV XX1_M46 capbs $&s1_xx1_m46_capbs
let s1_xx1_m46_cgso = @m.x1.xdut.xx1_m46.msky130_fd_pr__nfet_01v8_lvt[cgso]
echo OPV XX1_M46 cgso $&s1_xx1_m46_cgso
let s1_xx1_m46_cgdo = @m.x1.xdut.xx1_m46.msky130_fd_pr__nfet_01v8_lvt[cgdo]
echo OPV XX1_M46 cgdo $&s1_xx1_m46_cgdo
let s1_xx1_m46_cgbo = @m.x1.xdut.xx1_m46.msky130_fd_pr__nfet_01v8_lvt[cgbo]
echo OPV XX1_M46 cgbo $&s1_xx1_m46_cgbo
let s1_xx1_m46_weff = @m.x1.xdut.xx1_m46.msky130_fd_pr__nfet_01v8_lvt[weff]
echo OPV XX1_M46 weff $&s1_xx1_m46_weff
let s1_xx1_m46_leff = @m.x1.xdut.xx1_m46.msky130_fd_pr__nfet_01v8_lvt[leff]
echo OPV XX1_M46 leff $&s1_xx1_m46_leff
let s1_xx1_m47_id = @m.x1.xdut.xx1_m47.msky130_fd_pr__nfet_01v8_lvt[id]
echo OPV XX1_M47 id $&s1_xx1_m47_id
let s1_xx1_m47_vgs = @m.x1.xdut.xx1_m47.msky130_fd_pr__nfet_01v8_lvt[vgs]
echo OPV XX1_M47 vgs $&s1_xx1_m47_vgs
let s1_xx1_m47_vds = @m.x1.xdut.xx1_m47.msky130_fd_pr__nfet_01v8_lvt[vds]
echo OPV XX1_M47 vds $&s1_xx1_m47_vds
let s1_xx1_m47_vbs = @m.x1.xdut.xx1_m47.msky130_fd_pr__nfet_01v8_lvt[vbs]
echo OPV XX1_M47 vbs $&s1_xx1_m47_vbs
let s1_xx1_m47_vth = @m.x1.xdut.xx1_m47.msky130_fd_pr__nfet_01v8_lvt[vth]
echo OPV XX1_M47 vth $&s1_xx1_m47_vth
let s1_xx1_m47_vdsat = @m.x1.xdut.xx1_m47.msky130_fd_pr__nfet_01v8_lvt[vdsat]
echo OPV XX1_M47 vdsat $&s1_xx1_m47_vdsat
let s1_xx1_m47_gm = @m.x1.xdut.xx1_m47.msky130_fd_pr__nfet_01v8_lvt[gm]
echo OPV XX1_M47 gm $&s1_xx1_m47_gm
let s1_xx1_m47_gds = @m.x1.xdut.xx1_m47.msky130_fd_pr__nfet_01v8_lvt[gds]
echo OPV XX1_M47 gds $&s1_xx1_m47_gds
let s1_xx1_m47_gmbs = @m.x1.xdut.xx1_m47.msky130_fd_pr__nfet_01v8_lvt[gmbs]
echo OPV XX1_M47 gmbs $&s1_xx1_m47_gmbs
let s1_xx1_m47_cgg = @m.x1.xdut.xx1_m47.msky130_fd_pr__nfet_01v8_lvt[cgg]
echo OPV XX1_M47 cgg $&s1_xx1_m47_cgg
let s1_xx1_m47_cgd = @m.x1.xdut.xx1_m47.msky130_fd_pr__nfet_01v8_lvt[cgd]
echo OPV XX1_M47 cgd $&s1_xx1_m47_cgd
let s1_xx1_m47_cgs = @m.x1.xdut.xx1_m47.msky130_fd_pr__nfet_01v8_lvt[cgs]
echo OPV XX1_M47 cgs $&s1_xx1_m47_cgs
let s1_xx1_m47_cgb = @m.x1.xdut.xx1_m47.msky130_fd_pr__nfet_01v8_lvt[cgb]
echo OPV XX1_M47 cgb $&s1_xx1_m47_cgb
let s1_xx1_m47_cdg = @m.x1.xdut.xx1_m47.msky130_fd_pr__nfet_01v8_lvt[cdg]
echo OPV XX1_M47 cdg $&s1_xx1_m47_cdg
let s1_xx1_m47_cdd = @m.x1.xdut.xx1_m47.msky130_fd_pr__nfet_01v8_lvt[cdd]
echo OPV XX1_M47 cdd $&s1_xx1_m47_cdd
let s1_xx1_m47_cds = @m.x1.xdut.xx1_m47.msky130_fd_pr__nfet_01v8_lvt[cds]
echo OPV XX1_M47 cds $&s1_xx1_m47_cds
let s1_xx1_m47_cdb = @m.x1.xdut.xx1_m47.msky130_fd_pr__nfet_01v8_lvt[cdb]
echo OPV XX1_M47 cdb $&s1_xx1_m47_cdb
let s1_xx1_m47_csg = @m.x1.xdut.xx1_m47.msky130_fd_pr__nfet_01v8_lvt[csg]
echo OPV XX1_M47 csg $&s1_xx1_m47_csg
let s1_xx1_m47_csd = @m.x1.xdut.xx1_m47.msky130_fd_pr__nfet_01v8_lvt[csd]
echo OPV XX1_M47 csd $&s1_xx1_m47_csd
let s1_xx1_m47_css = @m.x1.xdut.xx1_m47.msky130_fd_pr__nfet_01v8_lvt[css]
echo OPV XX1_M47 css $&s1_xx1_m47_css
let s1_xx1_m47_csb = @m.x1.xdut.xx1_m47.msky130_fd_pr__nfet_01v8_lvt[csb]
echo OPV XX1_M47 csb $&s1_xx1_m47_csb
let s1_xx1_m47_cbg = @m.x1.xdut.xx1_m47.msky130_fd_pr__nfet_01v8_lvt[cbg]
echo OPV XX1_M47 cbg $&s1_xx1_m47_cbg
let s1_xx1_m47_cbd = @m.x1.xdut.xx1_m47.msky130_fd_pr__nfet_01v8_lvt[cbd]
echo OPV XX1_M47 cbd $&s1_xx1_m47_cbd
let s1_xx1_m47_cbs = @m.x1.xdut.xx1_m47.msky130_fd_pr__nfet_01v8_lvt[cbs]
echo OPV XX1_M47 cbs $&s1_xx1_m47_cbs
let s1_xx1_m47_cbb = @m.x1.xdut.xx1_m47.msky130_fd_pr__nfet_01v8_lvt[cbb]
echo OPV XX1_M47 cbb $&s1_xx1_m47_cbb
let s1_xx1_m47_capbd = @m.x1.xdut.xx1_m47.msky130_fd_pr__nfet_01v8_lvt[capbd]
echo OPV XX1_M47 capbd $&s1_xx1_m47_capbd
let s1_xx1_m47_capbs = @m.x1.xdut.xx1_m47.msky130_fd_pr__nfet_01v8_lvt[capbs]
echo OPV XX1_M47 capbs $&s1_xx1_m47_capbs
let s1_xx1_m47_cgso = @m.x1.xdut.xx1_m47.msky130_fd_pr__nfet_01v8_lvt[cgso]
echo OPV XX1_M47 cgso $&s1_xx1_m47_cgso
let s1_xx1_m47_cgdo = @m.x1.xdut.xx1_m47.msky130_fd_pr__nfet_01v8_lvt[cgdo]
echo OPV XX1_M47 cgdo $&s1_xx1_m47_cgdo
let s1_xx1_m47_cgbo = @m.x1.xdut.xx1_m47.msky130_fd_pr__nfet_01v8_lvt[cgbo]
echo OPV XX1_M47 cgbo $&s1_xx1_m47_cgbo
let s1_xx1_m47_weff = @m.x1.xdut.xx1_m47.msky130_fd_pr__nfet_01v8_lvt[weff]
echo OPV XX1_M47 weff $&s1_xx1_m47_weff
let s1_xx1_m47_leff = @m.x1.xdut.xx1_m47.msky130_fd_pr__nfet_01v8_lvt[leff]
echo OPV XX1_M47 leff $&s1_xx1_m47_leff
let s1_xx1_m23_id = @m.x1.xdut.xx1_m23.msky130_fd_pr__nfet_01v8_lvt[id]
echo OPV XX1_M23 id $&s1_xx1_m23_id
let s1_xx1_m23_vgs = @m.x1.xdut.xx1_m23.msky130_fd_pr__nfet_01v8_lvt[vgs]
echo OPV XX1_M23 vgs $&s1_xx1_m23_vgs
let s1_xx1_m23_vds = @m.x1.xdut.xx1_m23.msky130_fd_pr__nfet_01v8_lvt[vds]
echo OPV XX1_M23 vds $&s1_xx1_m23_vds
let s1_xx1_m23_vbs = @m.x1.xdut.xx1_m23.msky130_fd_pr__nfet_01v8_lvt[vbs]
echo OPV XX1_M23 vbs $&s1_xx1_m23_vbs
let s1_xx1_m23_vth = @m.x1.xdut.xx1_m23.msky130_fd_pr__nfet_01v8_lvt[vth]
echo OPV XX1_M23 vth $&s1_xx1_m23_vth
let s1_xx1_m23_vdsat = @m.x1.xdut.xx1_m23.msky130_fd_pr__nfet_01v8_lvt[vdsat]
echo OPV XX1_M23 vdsat $&s1_xx1_m23_vdsat
let s1_xx1_m23_gm = @m.x1.xdut.xx1_m23.msky130_fd_pr__nfet_01v8_lvt[gm]
echo OPV XX1_M23 gm $&s1_xx1_m23_gm
let s1_xx1_m23_gds = @m.x1.xdut.xx1_m23.msky130_fd_pr__nfet_01v8_lvt[gds]
echo OPV XX1_M23 gds $&s1_xx1_m23_gds
let s1_xx1_m23_gmbs = @m.x1.xdut.xx1_m23.msky130_fd_pr__nfet_01v8_lvt[gmbs]
echo OPV XX1_M23 gmbs $&s1_xx1_m23_gmbs
let s1_xx1_m23_cgg = @m.x1.xdut.xx1_m23.msky130_fd_pr__nfet_01v8_lvt[cgg]
echo OPV XX1_M23 cgg $&s1_xx1_m23_cgg
let s1_xx1_m23_cgd = @m.x1.xdut.xx1_m23.msky130_fd_pr__nfet_01v8_lvt[cgd]
echo OPV XX1_M23 cgd $&s1_xx1_m23_cgd
let s1_xx1_m23_cgs = @m.x1.xdut.xx1_m23.msky130_fd_pr__nfet_01v8_lvt[cgs]
echo OPV XX1_M23 cgs $&s1_xx1_m23_cgs
let s1_xx1_m23_cgb = @m.x1.xdut.xx1_m23.msky130_fd_pr__nfet_01v8_lvt[cgb]
echo OPV XX1_M23 cgb $&s1_xx1_m23_cgb
let s1_xx1_m23_cdg = @m.x1.xdut.xx1_m23.msky130_fd_pr__nfet_01v8_lvt[cdg]
echo OPV XX1_M23 cdg $&s1_xx1_m23_cdg
let s1_xx1_m23_cdd = @m.x1.xdut.xx1_m23.msky130_fd_pr__nfet_01v8_lvt[cdd]
echo OPV XX1_M23 cdd $&s1_xx1_m23_cdd
let s1_xx1_m23_cds = @m.x1.xdut.xx1_m23.msky130_fd_pr__nfet_01v8_lvt[cds]
echo OPV XX1_M23 cds $&s1_xx1_m23_cds
let s1_xx1_m23_cdb = @m.x1.xdut.xx1_m23.msky130_fd_pr__nfet_01v8_lvt[cdb]
echo OPV XX1_M23 cdb $&s1_xx1_m23_cdb
let s1_xx1_m23_csg = @m.x1.xdut.xx1_m23.msky130_fd_pr__nfet_01v8_lvt[csg]
echo OPV XX1_M23 csg $&s1_xx1_m23_csg
let s1_xx1_m23_csd = @m.x1.xdut.xx1_m23.msky130_fd_pr__nfet_01v8_lvt[csd]
echo OPV XX1_M23 csd $&s1_xx1_m23_csd
let s1_xx1_m23_css = @m.x1.xdut.xx1_m23.msky130_fd_pr__nfet_01v8_lvt[css]
echo OPV XX1_M23 css $&s1_xx1_m23_css
let s1_xx1_m23_csb = @m.x1.xdut.xx1_m23.msky130_fd_pr__nfet_01v8_lvt[csb]
echo OPV XX1_M23 csb $&s1_xx1_m23_csb
let s1_xx1_m23_cbg = @m.x1.xdut.xx1_m23.msky130_fd_pr__nfet_01v8_lvt[cbg]
echo OPV XX1_M23 cbg $&s1_xx1_m23_cbg
let s1_xx1_m23_cbd = @m.x1.xdut.xx1_m23.msky130_fd_pr__nfet_01v8_lvt[cbd]
echo OPV XX1_M23 cbd $&s1_xx1_m23_cbd
let s1_xx1_m23_cbs = @m.x1.xdut.xx1_m23.msky130_fd_pr__nfet_01v8_lvt[cbs]
echo OPV XX1_M23 cbs $&s1_xx1_m23_cbs
let s1_xx1_m23_cbb = @m.x1.xdut.xx1_m23.msky130_fd_pr__nfet_01v8_lvt[cbb]
echo OPV XX1_M23 cbb $&s1_xx1_m23_cbb
let s1_xx1_m23_capbd = @m.x1.xdut.xx1_m23.msky130_fd_pr__nfet_01v8_lvt[capbd]
echo OPV XX1_M23 capbd $&s1_xx1_m23_capbd
let s1_xx1_m23_capbs = @m.x1.xdut.xx1_m23.msky130_fd_pr__nfet_01v8_lvt[capbs]
echo OPV XX1_M23 capbs $&s1_xx1_m23_capbs
let s1_xx1_m23_cgso = @m.x1.xdut.xx1_m23.msky130_fd_pr__nfet_01v8_lvt[cgso]
echo OPV XX1_M23 cgso $&s1_xx1_m23_cgso
let s1_xx1_m23_cgdo = @m.x1.xdut.xx1_m23.msky130_fd_pr__nfet_01v8_lvt[cgdo]
echo OPV XX1_M23 cgdo $&s1_xx1_m23_cgdo
let s1_xx1_m23_cgbo = @m.x1.xdut.xx1_m23.msky130_fd_pr__nfet_01v8_lvt[cgbo]
echo OPV XX1_M23 cgbo $&s1_xx1_m23_cgbo
let s1_xx1_m23_weff = @m.x1.xdut.xx1_m23.msky130_fd_pr__nfet_01v8_lvt[weff]
echo OPV XX1_M23 weff $&s1_xx1_m23_weff
let s1_xx1_m23_leff = @m.x1.xdut.xx1_m23.msky130_fd_pr__nfet_01v8_lvt[leff]
echo OPV XX1_M23 leff $&s1_xx1_m23_leff
let s1_xx1_m24_id = @m.x1.xdut.xx1_m24.msky130_fd_pr__nfet_01v8_lvt[id]
echo OPV XX1_M24 id $&s1_xx1_m24_id
let s1_xx1_m24_vgs = @m.x1.xdut.xx1_m24.msky130_fd_pr__nfet_01v8_lvt[vgs]
echo OPV XX1_M24 vgs $&s1_xx1_m24_vgs
let s1_xx1_m24_vds = @m.x1.xdut.xx1_m24.msky130_fd_pr__nfet_01v8_lvt[vds]
echo OPV XX1_M24 vds $&s1_xx1_m24_vds
let s1_xx1_m24_vbs = @m.x1.xdut.xx1_m24.msky130_fd_pr__nfet_01v8_lvt[vbs]
echo OPV XX1_M24 vbs $&s1_xx1_m24_vbs
let s1_xx1_m24_vth = @m.x1.xdut.xx1_m24.msky130_fd_pr__nfet_01v8_lvt[vth]
echo OPV XX1_M24 vth $&s1_xx1_m24_vth
let s1_xx1_m24_vdsat = @m.x1.xdut.xx1_m24.msky130_fd_pr__nfet_01v8_lvt[vdsat]
echo OPV XX1_M24 vdsat $&s1_xx1_m24_vdsat
let s1_xx1_m24_gm = @m.x1.xdut.xx1_m24.msky130_fd_pr__nfet_01v8_lvt[gm]
echo OPV XX1_M24 gm $&s1_xx1_m24_gm
let s1_xx1_m24_gds = @m.x1.xdut.xx1_m24.msky130_fd_pr__nfet_01v8_lvt[gds]
echo OPV XX1_M24 gds $&s1_xx1_m24_gds
let s1_xx1_m24_gmbs = @m.x1.xdut.xx1_m24.msky130_fd_pr__nfet_01v8_lvt[gmbs]
echo OPV XX1_M24 gmbs $&s1_xx1_m24_gmbs
let s1_xx1_m24_cgg = @m.x1.xdut.xx1_m24.msky130_fd_pr__nfet_01v8_lvt[cgg]
echo OPV XX1_M24 cgg $&s1_xx1_m24_cgg
let s1_xx1_m24_cgd = @m.x1.xdut.xx1_m24.msky130_fd_pr__nfet_01v8_lvt[cgd]
echo OPV XX1_M24 cgd $&s1_xx1_m24_cgd
let s1_xx1_m24_cgs = @m.x1.xdut.xx1_m24.msky130_fd_pr__nfet_01v8_lvt[cgs]
echo OPV XX1_M24 cgs $&s1_xx1_m24_cgs
let s1_xx1_m24_cgb = @m.x1.xdut.xx1_m24.msky130_fd_pr__nfet_01v8_lvt[cgb]
echo OPV XX1_M24 cgb $&s1_xx1_m24_cgb
let s1_xx1_m24_cdg = @m.x1.xdut.xx1_m24.msky130_fd_pr__nfet_01v8_lvt[cdg]
echo OPV XX1_M24 cdg $&s1_xx1_m24_cdg
let s1_xx1_m24_cdd = @m.x1.xdut.xx1_m24.msky130_fd_pr__nfet_01v8_lvt[cdd]
echo OPV XX1_M24 cdd $&s1_xx1_m24_cdd
let s1_xx1_m24_cds = @m.x1.xdut.xx1_m24.msky130_fd_pr__nfet_01v8_lvt[cds]
echo OPV XX1_M24 cds $&s1_xx1_m24_cds
let s1_xx1_m24_cdb = @m.x1.xdut.xx1_m24.msky130_fd_pr__nfet_01v8_lvt[cdb]
echo OPV XX1_M24 cdb $&s1_xx1_m24_cdb
let s1_xx1_m24_csg = @m.x1.xdut.xx1_m24.msky130_fd_pr__nfet_01v8_lvt[csg]
echo OPV XX1_M24 csg $&s1_xx1_m24_csg
let s1_xx1_m24_csd = @m.x1.xdut.xx1_m24.msky130_fd_pr__nfet_01v8_lvt[csd]
echo OPV XX1_M24 csd $&s1_xx1_m24_csd
let s1_xx1_m24_css = @m.x1.xdut.xx1_m24.msky130_fd_pr__nfet_01v8_lvt[css]
echo OPV XX1_M24 css $&s1_xx1_m24_css
let s1_xx1_m24_csb = @m.x1.xdut.xx1_m24.msky130_fd_pr__nfet_01v8_lvt[csb]
echo OPV XX1_M24 csb $&s1_xx1_m24_csb
let s1_xx1_m24_cbg = @m.x1.xdut.xx1_m24.msky130_fd_pr__nfet_01v8_lvt[cbg]
echo OPV XX1_M24 cbg $&s1_xx1_m24_cbg
let s1_xx1_m24_cbd = @m.x1.xdut.xx1_m24.msky130_fd_pr__nfet_01v8_lvt[cbd]
echo OPV XX1_M24 cbd $&s1_xx1_m24_cbd
let s1_xx1_m24_cbs = @m.x1.xdut.xx1_m24.msky130_fd_pr__nfet_01v8_lvt[cbs]
echo OPV XX1_M24 cbs $&s1_xx1_m24_cbs
let s1_xx1_m24_cbb = @m.x1.xdut.xx1_m24.msky130_fd_pr__nfet_01v8_lvt[cbb]
echo OPV XX1_M24 cbb $&s1_xx1_m24_cbb
let s1_xx1_m24_capbd = @m.x1.xdut.xx1_m24.msky130_fd_pr__nfet_01v8_lvt[capbd]
echo OPV XX1_M24 capbd $&s1_xx1_m24_capbd
let s1_xx1_m24_capbs = @m.x1.xdut.xx1_m24.msky130_fd_pr__nfet_01v8_lvt[capbs]
echo OPV XX1_M24 capbs $&s1_xx1_m24_capbs
let s1_xx1_m24_cgso = @m.x1.xdut.xx1_m24.msky130_fd_pr__nfet_01v8_lvt[cgso]
echo OPV XX1_M24 cgso $&s1_xx1_m24_cgso
let s1_xx1_m24_cgdo = @m.x1.xdut.xx1_m24.msky130_fd_pr__nfet_01v8_lvt[cgdo]
echo OPV XX1_M24 cgdo $&s1_xx1_m24_cgdo
let s1_xx1_m24_cgbo = @m.x1.xdut.xx1_m24.msky130_fd_pr__nfet_01v8_lvt[cgbo]
echo OPV XX1_M24 cgbo $&s1_xx1_m24_cgbo
let s1_xx1_m24_weff = @m.x1.xdut.xx1_m24.msky130_fd_pr__nfet_01v8_lvt[weff]
echo OPV XX1_M24 weff $&s1_xx1_m24_weff
let s1_xx1_m24_leff = @m.x1.xdut.xx1_m24.msky130_fd_pr__nfet_01v8_lvt[leff]
echo OPV XX1_M24 leff $&s1_xx1_m24_leff
let s1_xx1_m25_id = @m.x1.xdut.xx1_m25.msky130_fd_pr__pfet_01v8_lvt[id]
echo OPV XX1_M25 id $&s1_xx1_m25_id
let s1_xx1_m25_vgs = @m.x1.xdut.xx1_m25.msky130_fd_pr__pfet_01v8_lvt[vgs]
echo OPV XX1_M25 vgs $&s1_xx1_m25_vgs
let s1_xx1_m25_vds = @m.x1.xdut.xx1_m25.msky130_fd_pr__pfet_01v8_lvt[vds]
echo OPV XX1_M25 vds $&s1_xx1_m25_vds
let s1_xx1_m25_vbs = @m.x1.xdut.xx1_m25.msky130_fd_pr__pfet_01v8_lvt[vbs]
echo OPV XX1_M25 vbs $&s1_xx1_m25_vbs
let s1_xx1_m25_vth = @m.x1.xdut.xx1_m25.msky130_fd_pr__pfet_01v8_lvt[vth]
echo OPV XX1_M25 vth $&s1_xx1_m25_vth
let s1_xx1_m25_vdsat = @m.x1.xdut.xx1_m25.msky130_fd_pr__pfet_01v8_lvt[vdsat]
echo OPV XX1_M25 vdsat $&s1_xx1_m25_vdsat
let s1_xx1_m25_gm = @m.x1.xdut.xx1_m25.msky130_fd_pr__pfet_01v8_lvt[gm]
echo OPV XX1_M25 gm $&s1_xx1_m25_gm
let s1_xx1_m25_gds = @m.x1.xdut.xx1_m25.msky130_fd_pr__pfet_01v8_lvt[gds]
echo OPV XX1_M25 gds $&s1_xx1_m25_gds
let s1_xx1_m25_gmbs = @m.x1.xdut.xx1_m25.msky130_fd_pr__pfet_01v8_lvt[gmbs]
echo OPV XX1_M25 gmbs $&s1_xx1_m25_gmbs
let s1_xx1_m25_cgg = @m.x1.xdut.xx1_m25.msky130_fd_pr__pfet_01v8_lvt[cgg]
echo OPV XX1_M25 cgg $&s1_xx1_m25_cgg
let s1_xx1_m25_cgd = @m.x1.xdut.xx1_m25.msky130_fd_pr__pfet_01v8_lvt[cgd]
echo OPV XX1_M25 cgd $&s1_xx1_m25_cgd
let s1_xx1_m25_cgs = @m.x1.xdut.xx1_m25.msky130_fd_pr__pfet_01v8_lvt[cgs]
echo OPV XX1_M25 cgs $&s1_xx1_m25_cgs
let s1_xx1_m25_cgb = @m.x1.xdut.xx1_m25.msky130_fd_pr__pfet_01v8_lvt[cgb]
echo OPV XX1_M25 cgb $&s1_xx1_m25_cgb
let s1_xx1_m25_cdg = @m.x1.xdut.xx1_m25.msky130_fd_pr__pfet_01v8_lvt[cdg]
echo OPV XX1_M25 cdg $&s1_xx1_m25_cdg
let s1_xx1_m25_cdd = @m.x1.xdut.xx1_m25.msky130_fd_pr__pfet_01v8_lvt[cdd]
echo OPV XX1_M25 cdd $&s1_xx1_m25_cdd
let s1_xx1_m25_cds = @m.x1.xdut.xx1_m25.msky130_fd_pr__pfet_01v8_lvt[cds]
echo OPV XX1_M25 cds $&s1_xx1_m25_cds
let s1_xx1_m25_cdb = @m.x1.xdut.xx1_m25.msky130_fd_pr__pfet_01v8_lvt[cdb]
echo OPV XX1_M25 cdb $&s1_xx1_m25_cdb
let s1_xx1_m25_csg = @m.x1.xdut.xx1_m25.msky130_fd_pr__pfet_01v8_lvt[csg]
echo OPV XX1_M25 csg $&s1_xx1_m25_csg
let s1_xx1_m25_csd = @m.x1.xdut.xx1_m25.msky130_fd_pr__pfet_01v8_lvt[csd]
echo OPV XX1_M25 csd $&s1_xx1_m25_csd
let s1_xx1_m25_css = @m.x1.xdut.xx1_m25.msky130_fd_pr__pfet_01v8_lvt[css]
echo OPV XX1_M25 css $&s1_xx1_m25_css
let s1_xx1_m25_csb = @m.x1.xdut.xx1_m25.msky130_fd_pr__pfet_01v8_lvt[csb]
echo OPV XX1_M25 csb $&s1_xx1_m25_csb
let s1_xx1_m25_cbg = @m.x1.xdut.xx1_m25.msky130_fd_pr__pfet_01v8_lvt[cbg]
echo OPV XX1_M25 cbg $&s1_xx1_m25_cbg
let s1_xx1_m25_cbd = @m.x1.xdut.xx1_m25.msky130_fd_pr__pfet_01v8_lvt[cbd]
echo OPV XX1_M25 cbd $&s1_xx1_m25_cbd
let s1_xx1_m25_cbs = @m.x1.xdut.xx1_m25.msky130_fd_pr__pfet_01v8_lvt[cbs]
echo OPV XX1_M25 cbs $&s1_xx1_m25_cbs
let s1_xx1_m25_cbb = @m.x1.xdut.xx1_m25.msky130_fd_pr__pfet_01v8_lvt[cbb]
echo OPV XX1_M25 cbb $&s1_xx1_m25_cbb
let s1_xx1_m25_capbd = @m.x1.xdut.xx1_m25.msky130_fd_pr__pfet_01v8_lvt[capbd]
echo OPV XX1_M25 capbd $&s1_xx1_m25_capbd
let s1_xx1_m25_capbs = @m.x1.xdut.xx1_m25.msky130_fd_pr__pfet_01v8_lvt[capbs]
echo OPV XX1_M25 capbs $&s1_xx1_m25_capbs
let s1_xx1_m25_cgso = @m.x1.xdut.xx1_m25.msky130_fd_pr__pfet_01v8_lvt[cgso]
echo OPV XX1_M25 cgso $&s1_xx1_m25_cgso
let s1_xx1_m25_cgdo = @m.x1.xdut.xx1_m25.msky130_fd_pr__pfet_01v8_lvt[cgdo]
echo OPV XX1_M25 cgdo $&s1_xx1_m25_cgdo
let s1_xx1_m25_cgbo = @m.x1.xdut.xx1_m25.msky130_fd_pr__pfet_01v8_lvt[cgbo]
echo OPV XX1_M25 cgbo $&s1_xx1_m25_cgbo
let s1_xx1_m25_weff = @m.x1.xdut.xx1_m25.msky130_fd_pr__pfet_01v8_lvt[weff]
echo OPV XX1_M25 weff $&s1_xx1_m25_weff
let s1_xx1_m25_leff = @m.x1.xdut.xx1_m25.msky130_fd_pr__pfet_01v8_lvt[leff]
echo OPV XX1_M25 leff $&s1_xx1_m25_leff
let s1_xx2_m9_id = @m.x1.xdut.xx2_m9.msky130_fd_pr__pfet_01v8_lvt[id]
echo OPV XX2_M9 id $&s1_xx2_m9_id
let s1_xx2_m9_vgs = @m.x1.xdut.xx2_m9.msky130_fd_pr__pfet_01v8_lvt[vgs]
echo OPV XX2_M9 vgs $&s1_xx2_m9_vgs
let s1_xx2_m9_vds = @m.x1.xdut.xx2_m9.msky130_fd_pr__pfet_01v8_lvt[vds]
echo OPV XX2_M9 vds $&s1_xx2_m9_vds
let s1_xx2_m9_vbs = @m.x1.xdut.xx2_m9.msky130_fd_pr__pfet_01v8_lvt[vbs]
echo OPV XX2_M9 vbs $&s1_xx2_m9_vbs
let s1_xx2_m9_vth = @m.x1.xdut.xx2_m9.msky130_fd_pr__pfet_01v8_lvt[vth]
echo OPV XX2_M9 vth $&s1_xx2_m9_vth
let s1_xx2_m9_vdsat = @m.x1.xdut.xx2_m9.msky130_fd_pr__pfet_01v8_lvt[vdsat]
echo OPV XX2_M9 vdsat $&s1_xx2_m9_vdsat
let s1_xx2_m9_gm = @m.x1.xdut.xx2_m9.msky130_fd_pr__pfet_01v8_lvt[gm]
echo OPV XX2_M9 gm $&s1_xx2_m9_gm
let s1_xx2_m9_gds = @m.x1.xdut.xx2_m9.msky130_fd_pr__pfet_01v8_lvt[gds]
echo OPV XX2_M9 gds $&s1_xx2_m9_gds
let s1_xx2_m9_gmbs = @m.x1.xdut.xx2_m9.msky130_fd_pr__pfet_01v8_lvt[gmbs]
echo OPV XX2_M9 gmbs $&s1_xx2_m9_gmbs
let s1_xx2_m9_cgg = @m.x1.xdut.xx2_m9.msky130_fd_pr__pfet_01v8_lvt[cgg]
echo OPV XX2_M9 cgg $&s1_xx2_m9_cgg
let s1_xx2_m9_cgd = @m.x1.xdut.xx2_m9.msky130_fd_pr__pfet_01v8_lvt[cgd]
echo OPV XX2_M9 cgd $&s1_xx2_m9_cgd
let s1_xx2_m9_cgs = @m.x1.xdut.xx2_m9.msky130_fd_pr__pfet_01v8_lvt[cgs]
echo OPV XX2_M9 cgs $&s1_xx2_m9_cgs
let s1_xx2_m9_cgb = @m.x1.xdut.xx2_m9.msky130_fd_pr__pfet_01v8_lvt[cgb]
echo OPV XX2_M9 cgb $&s1_xx2_m9_cgb
let s1_xx2_m9_cdg = @m.x1.xdut.xx2_m9.msky130_fd_pr__pfet_01v8_lvt[cdg]
echo OPV XX2_M9 cdg $&s1_xx2_m9_cdg
let s1_xx2_m9_cdd = @m.x1.xdut.xx2_m9.msky130_fd_pr__pfet_01v8_lvt[cdd]
echo OPV XX2_M9 cdd $&s1_xx2_m9_cdd
let s1_xx2_m9_cds = @m.x1.xdut.xx2_m9.msky130_fd_pr__pfet_01v8_lvt[cds]
echo OPV XX2_M9 cds $&s1_xx2_m9_cds
let s1_xx2_m9_cdb = @m.x1.xdut.xx2_m9.msky130_fd_pr__pfet_01v8_lvt[cdb]
echo OPV XX2_M9 cdb $&s1_xx2_m9_cdb
let s1_xx2_m9_csg = @m.x1.xdut.xx2_m9.msky130_fd_pr__pfet_01v8_lvt[csg]
echo OPV XX2_M9 csg $&s1_xx2_m9_csg
let s1_xx2_m9_csd = @m.x1.xdut.xx2_m9.msky130_fd_pr__pfet_01v8_lvt[csd]
echo OPV XX2_M9 csd $&s1_xx2_m9_csd
let s1_xx2_m9_css = @m.x1.xdut.xx2_m9.msky130_fd_pr__pfet_01v8_lvt[css]
echo OPV XX2_M9 css $&s1_xx2_m9_css
let s1_xx2_m9_csb = @m.x1.xdut.xx2_m9.msky130_fd_pr__pfet_01v8_lvt[csb]
echo OPV XX2_M9 csb $&s1_xx2_m9_csb
let s1_xx2_m9_cbg = @m.x1.xdut.xx2_m9.msky130_fd_pr__pfet_01v8_lvt[cbg]
echo OPV XX2_M9 cbg $&s1_xx2_m9_cbg
let s1_xx2_m9_cbd = @m.x1.xdut.xx2_m9.msky130_fd_pr__pfet_01v8_lvt[cbd]
echo OPV XX2_M9 cbd $&s1_xx2_m9_cbd
let s1_xx2_m9_cbs = @m.x1.xdut.xx2_m9.msky130_fd_pr__pfet_01v8_lvt[cbs]
echo OPV XX2_M9 cbs $&s1_xx2_m9_cbs
let s1_xx2_m9_cbb = @m.x1.xdut.xx2_m9.msky130_fd_pr__pfet_01v8_lvt[cbb]
echo OPV XX2_M9 cbb $&s1_xx2_m9_cbb
let s1_xx2_m9_capbd = @m.x1.xdut.xx2_m9.msky130_fd_pr__pfet_01v8_lvt[capbd]
echo OPV XX2_M9 capbd $&s1_xx2_m9_capbd
let s1_xx2_m9_capbs = @m.x1.xdut.xx2_m9.msky130_fd_pr__pfet_01v8_lvt[capbs]
echo OPV XX2_M9 capbs $&s1_xx2_m9_capbs
let s1_xx2_m9_cgso = @m.x1.xdut.xx2_m9.msky130_fd_pr__pfet_01v8_lvt[cgso]
echo OPV XX2_M9 cgso $&s1_xx2_m9_cgso
let s1_xx2_m9_cgdo = @m.x1.xdut.xx2_m9.msky130_fd_pr__pfet_01v8_lvt[cgdo]
echo OPV XX2_M9 cgdo $&s1_xx2_m9_cgdo
let s1_xx2_m9_cgbo = @m.x1.xdut.xx2_m9.msky130_fd_pr__pfet_01v8_lvt[cgbo]
echo OPV XX2_M9 cgbo $&s1_xx2_m9_cgbo
let s1_xx2_m9_weff = @m.x1.xdut.xx2_m9.msky130_fd_pr__pfet_01v8_lvt[weff]
echo OPV XX2_M9 weff $&s1_xx2_m9_weff
let s1_xx2_m9_leff = @m.x1.xdut.xx2_m9.msky130_fd_pr__pfet_01v8_lvt[leff]
echo OPV XX2_M9 leff $&s1_xx2_m9_leff
let s1_xx2_m4_id = @m.x1.xdut.xx2_m4.msky130_fd_pr__pfet_01v8_lvt[id]
echo OPV XX2_M4 id $&s1_xx2_m4_id
let s1_xx2_m4_vgs = @m.x1.xdut.xx2_m4.msky130_fd_pr__pfet_01v8_lvt[vgs]
echo OPV XX2_M4 vgs $&s1_xx2_m4_vgs
let s1_xx2_m4_vds = @m.x1.xdut.xx2_m4.msky130_fd_pr__pfet_01v8_lvt[vds]
echo OPV XX2_M4 vds $&s1_xx2_m4_vds
let s1_xx2_m4_vbs = @m.x1.xdut.xx2_m4.msky130_fd_pr__pfet_01v8_lvt[vbs]
echo OPV XX2_M4 vbs $&s1_xx2_m4_vbs
let s1_xx2_m4_vth = @m.x1.xdut.xx2_m4.msky130_fd_pr__pfet_01v8_lvt[vth]
echo OPV XX2_M4 vth $&s1_xx2_m4_vth
let s1_xx2_m4_vdsat = @m.x1.xdut.xx2_m4.msky130_fd_pr__pfet_01v8_lvt[vdsat]
echo OPV XX2_M4 vdsat $&s1_xx2_m4_vdsat
let s1_xx2_m4_gm = @m.x1.xdut.xx2_m4.msky130_fd_pr__pfet_01v8_lvt[gm]
echo OPV XX2_M4 gm $&s1_xx2_m4_gm
let s1_xx2_m4_gds = @m.x1.xdut.xx2_m4.msky130_fd_pr__pfet_01v8_lvt[gds]
echo OPV XX2_M4 gds $&s1_xx2_m4_gds
let s1_xx2_m4_gmbs = @m.x1.xdut.xx2_m4.msky130_fd_pr__pfet_01v8_lvt[gmbs]
echo OPV XX2_M4 gmbs $&s1_xx2_m4_gmbs
let s1_xx2_m4_cgg = @m.x1.xdut.xx2_m4.msky130_fd_pr__pfet_01v8_lvt[cgg]
echo OPV XX2_M4 cgg $&s1_xx2_m4_cgg
let s1_xx2_m4_cgd = @m.x1.xdut.xx2_m4.msky130_fd_pr__pfet_01v8_lvt[cgd]
echo OPV XX2_M4 cgd $&s1_xx2_m4_cgd
let s1_xx2_m4_cgs = @m.x1.xdut.xx2_m4.msky130_fd_pr__pfet_01v8_lvt[cgs]
echo OPV XX2_M4 cgs $&s1_xx2_m4_cgs
let s1_xx2_m4_cgb = @m.x1.xdut.xx2_m4.msky130_fd_pr__pfet_01v8_lvt[cgb]
echo OPV XX2_M4 cgb $&s1_xx2_m4_cgb
let s1_xx2_m4_cdg = @m.x1.xdut.xx2_m4.msky130_fd_pr__pfet_01v8_lvt[cdg]
echo OPV XX2_M4 cdg $&s1_xx2_m4_cdg
let s1_xx2_m4_cdd = @m.x1.xdut.xx2_m4.msky130_fd_pr__pfet_01v8_lvt[cdd]
echo OPV XX2_M4 cdd $&s1_xx2_m4_cdd
let s1_xx2_m4_cds = @m.x1.xdut.xx2_m4.msky130_fd_pr__pfet_01v8_lvt[cds]
echo OPV XX2_M4 cds $&s1_xx2_m4_cds
let s1_xx2_m4_cdb = @m.x1.xdut.xx2_m4.msky130_fd_pr__pfet_01v8_lvt[cdb]
echo OPV XX2_M4 cdb $&s1_xx2_m4_cdb
let s1_xx2_m4_csg = @m.x1.xdut.xx2_m4.msky130_fd_pr__pfet_01v8_lvt[csg]
echo OPV XX2_M4 csg $&s1_xx2_m4_csg
let s1_xx2_m4_csd = @m.x1.xdut.xx2_m4.msky130_fd_pr__pfet_01v8_lvt[csd]
echo OPV XX2_M4 csd $&s1_xx2_m4_csd
let s1_xx2_m4_css = @m.x1.xdut.xx2_m4.msky130_fd_pr__pfet_01v8_lvt[css]
echo OPV XX2_M4 css $&s1_xx2_m4_css
let s1_xx2_m4_csb = @m.x1.xdut.xx2_m4.msky130_fd_pr__pfet_01v8_lvt[csb]
echo OPV XX2_M4 csb $&s1_xx2_m4_csb
let s1_xx2_m4_cbg = @m.x1.xdut.xx2_m4.msky130_fd_pr__pfet_01v8_lvt[cbg]
echo OPV XX2_M4 cbg $&s1_xx2_m4_cbg
let s1_xx2_m4_cbd = @m.x1.xdut.xx2_m4.msky130_fd_pr__pfet_01v8_lvt[cbd]
echo OPV XX2_M4 cbd $&s1_xx2_m4_cbd
let s1_xx2_m4_cbs = @m.x1.xdut.xx2_m4.msky130_fd_pr__pfet_01v8_lvt[cbs]
echo OPV XX2_M4 cbs $&s1_xx2_m4_cbs
let s1_xx2_m4_cbb = @m.x1.xdut.xx2_m4.msky130_fd_pr__pfet_01v8_lvt[cbb]
echo OPV XX2_M4 cbb $&s1_xx2_m4_cbb
let s1_xx2_m4_capbd = @m.x1.xdut.xx2_m4.msky130_fd_pr__pfet_01v8_lvt[capbd]
echo OPV XX2_M4 capbd $&s1_xx2_m4_capbd
let s1_xx2_m4_capbs = @m.x1.xdut.xx2_m4.msky130_fd_pr__pfet_01v8_lvt[capbs]
echo OPV XX2_M4 capbs $&s1_xx2_m4_capbs
let s1_xx2_m4_cgso = @m.x1.xdut.xx2_m4.msky130_fd_pr__pfet_01v8_lvt[cgso]
echo OPV XX2_M4 cgso $&s1_xx2_m4_cgso
let s1_xx2_m4_cgdo = @m.x1.xdut.xx2_m4.msky130_fd_pr__pfet_01v8_lvt[cgdo]
echo OPV XX2_M4 cgdo $&s1_xx2_m4_cgdo
let s1_xx2_m4_cgbo = @m.x1.xdut.xx2_m4.msky130_fd_pr__pfet_01v8_lvt[cgbo]
echo OPV XX2_M4 cgbo $&s1_xx2_m4_cgbo
let s1_xx2_m4_weff = @m.x1.xdut.xx2_m4.msky130_fd_pr__pfet_01v8_lvt[weff]
echo OPV XX2_M4 weff $&s1_xx2_m4_weff
let s1_xx2_m4_leff = @m.x1.xdut.xx2_m4.msky130_fd_pr__pfet_01v8_lvt[leff]
echo OPV XX2_M4 leff $&s1_xx2_m4_leff
let s1_xx2_m2_id = @m.x1.xdut.xx2_m2.msky130_fd_pr__nfet_01v8_lvt[id]
echo OPV XX2_M2 id $&s1_xx2_m2_id
let s1_xx2_m2_vgs = @m.x1.xdut.xx2_m2.msky130_fd_pr__nfet_01v8_lvt[vgs]
echo OPV XX2_M2 vgs $&s1_xx2_m2_vgs
let s1_xx2_m2_vds = @m.x1.xdut.xx2_m2.msky130_fd_pr__nfet_01v8_lvt[vds]
echo OPV XX2_M2 vds $&s1_xx2_m2_vds
let s1_xx2_m2_vbs = @m.x1.xdut.xx2_m2.msky130_fd_pr__nfet_01v8_lvt[vbs]
echo OPV XX2_M2 vbs $&s1_xx2_m2_vbs
let s1_xx2_m2_vth = @m.x1.xdut.xx2_m2.msky130_fd_pr__nfet_01v8_lvt[vth]
echo OPV XX2_M2 vth $&s1_xx2_m2_vth
let s1_xx2_m2_vdsat = @m.x1.xdut.xx2_m2.msky130_fd_pr__nfet_01v8_lvt[vdsat]
echo OPV XX2_M2 vdsat $&s1_xx2_m2_vdsat
let s1_xx2_m2_gm = @m.x1.xdut.xx2_m2.msky130_fd_pr__nfet_01v8_lvt[gm]
echo OPV XX2_M2 gm $&s1_xx2_m2_gm
let s1_xx2_m2_gds = @m.x1.xdut.xx2_m2.msky130_fd_pr__nfet_01v8_lvt[gds]
echo OPV XX2_M2 gds $&s1_xx2_m2_gds
let s1_xx2_m2_gmbs = @m.x1.xdut.xx2_m2.msky130_fd_pr__nfet_01v8_lvt[gmbs]
echo OPV XX2_M2 gmbs $&s1_xx2_m2_gmbs
let s1_xx2_m2_cgg = @m.x1.xdut.xx2_m2.msky130_fd_pr__nfet_01v8_lvt[cgg]
echo OPV XX2_M2 cgg $&s1_xx2_m2_cgg
let s1_xx2_m2_cgd = @m.x1.xdut.xx2_m2.msky130_fd_pr__nfet_01v8_lvt[cgd]
echo OPV XX2_M2 cgd $&s1_xx2_m2_cgd
let s1_xx2_m2_cgs = @m.x1.xdut.xx2_m2.msky130_fd_pr__nfet_01v8_lvt[cgs]
echo OPV XX2_M2 cgs $&s1_xx2_m2_cgs
let s1_xx2_m2_cgb = @m.x1.xdut.xx2_m2.msky130_fd_pr__nfet_01v8_lvt[cgb]
echo OPV XX2_M2 cgb $&s1_xx2_m2_cgb
let s1_xx2_m2_cdg = @m.x1.xdut.xx2_m2.msky130_fd_pr__nfet_01v8_lvt[cdg]
echo OPV XX2_M2 cdg $&s1_xx2_m2_cdg
let s1_xx2_m2_cdd = @m.x1.xdut.xx2_m2.msky130_fd_pr__nfet_01v8_lvt[cdd]
echo OPV XX2_M2 cdd $&s1_xx2_m2_cdd
let s1_xx2_m2_cds = @m.x1.xdut.xx2_m2.msky130_fd_pr__nfet_01v8_lvt[cds]
echo OPV XX2_M2 cds $&s1_xx2_m2_cds
let s1_xx2_m2_cdb = @m.x1.xdut.xx2_m2.msky130_fd_pr__nfet_01v8_lvt[cdb]
echo OPV XX2_M2 cdb $&s1_xx2_m2_cdb
let s1_xx2_m2_csg = @m.x1.xdut.xx2_m2.msky130_fd_pr__nfet_01v8_lvt[csg]
echo OPV XX2_M2 csg $&s1_xx2_m2_csg
let s1_xx2_m2_csd = @m.x1.xdut.xx2_m2.msky130_fd_pr__nfet_01v8_lvt[csd]
echo OPV XX2_M2 csd $&s1_xx2_m2_csd
let s1_xx2_m2_css = @m.x1.xdut.xx2_m2.msky130_fd_pr__nfet_01v8_lvt[css]
echo OPV XX2_M2 css $&s1_xx2_m2_css
let s1_xx2_m2_csb = @m.x1.xdut.xx2_m2.msky130_fd_pr__nfet_01v8_lvt[csb]
echo OPV XX2_M2 csb $&s1_xx2_m2_csb
let s1_xx2_m2_cbg = @m.x1.xdut.xx2_m2.msky130_fd_pr__nfet_01v8_lvt[cbg]
echo OPV XX2_M2 cbg $&s1_xx2_m2_cbg
let s1_xx2_m2_cbd = @m.x1.xdut.xx2_m2.msky130_fd_pr__nfet_01v8_lvt[cbd]
echo OPV XX2_M2 cbd $&s1_xx2_m2_cbd
let s1_xx2_m2_cbs = @m.x1.xdut.xx2_m2.msky130_fd_pr__nfet_01v8_lvt[cbs]
echo OPV XX2_M2 cbs $&s1_xx2_m2_cbs
let s1_xx2_m2_cbb = @m.x1.xdut.xx2_m2.msky130_fd_pr__nfet_01v8_lvt[cbb]
echo OPV XX2_M2 cbb $&s1_xx2_m2_cbb
let s1_xx2_m2_capbd = @m.x1.xdut.xx2_m2.msky130_fd_pr__nfet_01v8_lvt[capbd]
echo OPV XX2_M2 capbd $&s1_xx2_m2_capbd
let s1_xx2_m2_capbs = @m.x1.xdut.xx2_m2.msky130_fd_pr__nfet_01v8_lvt[capbs]
echo OPV XX2_M2 capbs $&s1_xx2_m2_capbs
let s1_xx2_m2_cgso = @m.x1.xdut.xx2_m2.msky130_fd_pr__nfet_01v8_lvt[cgso]
echo OPV XX2_M2 cgso $&s1_xx2_m2_cgso
let s1_xx2_m2_cgdo = @m.x1.xdut.xx2_m2.msky130_fd_pr__nfet_01v8_lvt[cgdo]
echo OPV XX2_M2 cgdo $&s1_xx2_m2_cgdo
let s1_xx2_m2_cgbo = @m.x1.xdut.xx2_m2.msky130_fd_pr__nfet_01v8_lvt[cgbo]
echo OPV XX2_M2 cgbo $&s1_xx2_m2_cgbo
let s1_xx2_m2_weff = @m.x1.xdut.xx2_m2.msky130_fd_pr__nfet_01v8_lvt[weff]
echo OPV XX2_M2 weff $&s1_xx2_m2_weff
let s1_xx2_m2_leff = @m.x1.xdut.xx2_m2.msky130_fd_pr__nfet_01v8_lvt[leff]
echo OPV XX2_M2 leff $&s1_xx2_m2_leff
let s1_xx2_m1_id = @m.x1.xdut.xx2_m1.msky130_fd_pr__nfet_01v8_lvt[id]
echo OPV XX2_M1 id $&s1_xx2_m1_id
let s1_xx2_m1_vgs = @m.x1.xdut.xx2_m1.msky130_fd_pr__nfet_01v8_lvt[vgs]
echo OPV XX2_M1 vgs $&s1_xx2_m1_vgs
let s1_xx2_m1_vds = @m.x1.xdut.xx2_m1.msky130_fd_pr__nfet_01v8_lvt[vds]
echo OPV XX2_M1 vds $&s1_xx2_m1_vds
let s1_xx2_m1_vbs = @m.x1.xdut.xx2_m1.msky130_fd_pr__nfet_01v8_lvt[vbs]
echo OPV XX2_M1 vbs $&s1_xx2_m1_vbs
let s1_xx2_m1_vth = @m.x1.xdut.xx2_m1.msky130_fd_pr__nfet_01v8_lvt[vth]
echo OPV XX2_M1 vth $&s1_xx2_m1_vth
let s1_xx2_m1_vdsat = @m.x1.xdut.xx2_m1.msky130_fd_pr__nfet_01v8_lvt[vdsat]
echo OPV XX2_M1 vdsat $&s1_xx2_m1_vdsat
let s1_xx2_m1_gm = @m.x1.xdut.xx2_m1.msky130_fd_pr__nfet_01v8_lvt[gm]
echo OPV XX2_M1 gm $&s1_xx2_m1_gm
let s1_xx2_m1_gds = @m.x1.xdut.xx2_m1.msky130_fd_pr__nfet_01v8_lvt[gds]
echo OPV XX2_M1 gds $&s1_xx2_m1_gds
let s1_xx2_m1_gmbs = @m.x1.xdut.xx2_m1.msky130_fd_pr__nfet_01v8_lvt[gmbs]
echo OPV XX2_M1 gmbs $&s1_xx2_m1_gmbs
let s1_xx2_m1_cgg = @m.x1.xdut.xx2_m1.msky130_fd_pr__nfet_01v8_lvt[cgg]
echo OPV XX2_M1 cgg $&s1_xx2_m1_cgg
let s1_xx2_m1_cgd = @m.x1.xdut.xx2_m1.msky130_fd_pr__nfet_01v8_lvt[cgd]
echo OPV XX2_M1 cgd $&s1_xx2_m1_cgd
let s1_xx2_m1_cgs = @m.x1.xdut.xx2_m1.msky130_fd_pr__nfet_01v8_lvt[cgs]
echo OPV XX2_M1 cgs $&s1_xx2_m1_cgs
let s1_xx2_m1_cgb = @m.x1.xdut.xx2_m1.msky130_fd_pr__nfet_01v8_lvt[cgb]
echo OPV XX2_M1 cgb $&s1_xx2_m1_cgb
let s1_xx2_m1_cdg = @m.x1.xdut.xx2_m1.msky130_fd_pr__nfet_01v8_lvt[cdg]
echo OPV XX2_M1 cdg $&s1_xx2_m1_cdg
let s1_xx2_m1_cdd = @m.x1.xdut.xx2_m1.msky130_fd_pr__nfet_01v8_lvt[cdd]
echo OPV XX2_M1 cdd $&s1_xx2_m1_cdd
let s1_xx2_m1_cds = @m.x1.xdut.xx2_m1.msky130_fd_pr__nfet_01v8_lvt[cds]
echo OPV XX2_M1 cds $&s1_xx2_m1_cds
let s1_xx2_m1_cdb = @m.x1.xdut.xx2_m1.msky130_fd_pr__nfet_01v8_lvt[cdb]
echo OPV XX2_M1 cdb $&s1_xx2_m1_cdb
let s1_xx2_m1_csg = @m.x1.xdut.xx2_m1.msky130_fd_pr__nfet_01v8_lvt[csg]
echo OPV XX2_M1 csg $&s1_xx2_m1_csg
let s1_xx2_m1_csd = @m.x1.xdut.xx2_m1.msky130_fd_pr__nfet_01v8_lvt[csd]
echo OPV XX2_M1 csd $&s1_xx2_m1_csd
let s1_xx2_m1_css = @m.x1.xdut.xx2_m1.msky130_fd_pr__nfet_01v8_lvt[css]
echo OPV XX2_M1 css $&s1_xx2_m1_css
let s1_xx2_m1_csb = @m.x1.xdut.xx2_m1.msky130_fd_pr__nfet_01v8_lvt[csb]
echo OPV XX2_M1 csb $&s1_xx2_m1_csb
let s1_xx2_m1_cbg = @m.x1.xdut.xx2_m1.msky130_fd_pr__nfet_01v8_lvt[cbg]
echo OPV XX2_M1 cbg $&s1_xx2_m1_cbg
let s1_xx2_m1_cbd = @m.x1.xdut.xx2_m1.msky130_fd_pr__nfet_01v8_lvt[cbd]
echo OPV XX2_M1 cbd $&s1_xx2_m1_cbd
let s1_xx2_m1_cbs = @m.x1.xdut.xx2_m1.msky130_fd_pr__nfet_01v8_lvt[cbs]
echo OPV XX2_M1 cbs $&s1_xx2_m1_cbs
let s1_xx2_m1_cbb = @m.x1.xdut.xx2_m1.msky130_fd_pr__nfet_01v8_lvt[cbb]
echo OPV XX2_M1 cbb $&s1_xx2_m1_cbb
let s1_xx2_m1_capbd = @m.x1.xdut.xx2_m1.msky130_fd_pr__nfet_01v8_lvt[capbd]
echo OPV XX2_M1 capbd $&s1_xx2_m1_capbd
let s1_xx2_m1_capbs = @m.x1.xdut.xx2_m1.msky130_fd_pr__nfet_01v8_lvt[capbs]
echo OPV XX2_M1 capbs $&s1_xx2_m1_capbs
let s1_xx2_m1_cgso = @m.x1.xdut.xx2_m1.msky130_fd_pr__nfet_01v8_lvt[cgso]
echo OPV XX2_M1 cgso $&s1_xx2_m1_cgso
let s1_xx2_m1_cgdo = @m.x1.xdut.xx2_m1.msky130_fd_pr__nfet_01v8_lvt[cgdo]
echo OPV XX2_M1 cgdo $&s1_xx2_m1_cgdo
let s1_xx2_m1_cgbo = @m.x1.xdut.xx2_m1.msky130_fd_pr__nfet_01v8_lvt[cgbo]
echo OPV XX2_M1 cgbo $&s1_xx2_m1_cgbo
let s1_xx2_m1_weff = @m.x1.xdut.xx2_m1.msky130_fd_pr__nfet_01v8_lvt[weff]
echo OPV XX2_M1 weff $&s1_xx2_m1_weff
let s1_xx2_m1_leff = @m.x1.xdut.xx2_m1.msky130_fd_pr__nfet_01v8_lvt[leff]
echo OPV XX2_M1 leff $&s1_xx2_m1_leff
let s1_xx2_m3_id = @m.x1.xdut.xx2_m3.msky130_fd_pr__pfet_01v8_lvt[id]
echo OPV XX2_M3 id $&s1_xx2_m3_id
let s1_xx2_m3_vgs = @m.x1.xdut.xx2_m3.msky130_fd_pr__pfet_01v8_lvt[vgs]
echo OPV XX2_M3 vgs $&s1_xx2_m3_vgs
let s1_xx2_m3_vds = @m.x1.xdut.xx2_m3.msky130_fd_pr__pfet_01v8_lvt[vds]
echo OPV XX2_M3 vds $&s1_xx2_m3_vds
let s1_xx2_m3_vbs = @m.x1.xdut.xx2_m3.msky130_fd_pr__pfet_01v8_lvt[vbs]
echo OPV XX2_M3 vbs $&s1_xx2_m3_vbs
let s1_xx2_m3_vth = @m.x1.xdut.xx2_m3.msky130_fd_pr__pfet_01v8_lvt[vth]
echo OPV XX2_M3 vth $&s1_xx2_m3_vth
let s1_xx2_m3_vdsat = @m.x1.xdut.xx2_m3.msky130_fd_pr__pfet_01v8_lvt[vdsat]
echo OPV XX2_M3 vdsat $&s1_xx2_m3_vdsat
let s1_xx2_m3_gm = @m.x1.xdut.xx2_m3.msky130_fd_pr__pfet_01v8_lvt[gm]
echo OPV XX2_M3 gm $&s1_xx2_m3_gm
let s1_xx2_m3_gds = @m.x1.xdut.xx2_m3.msky130_fd_pr__pfet_01v8_lvt[gds]
echo OPV XX2_M3 gds $&s1_xx2_m3_gds
let s1_xx2_m3_gmbs = @m.x1.xdut.xx2_m3.msky130_fd_pr__pfet_01v8_lvt[gmbs]
echo OPV XX2_M3 gmbs $&s1_xx2_m3_gmbs
let s1_xx2_m3_cgg = @m.x1.xdut.xx2_m3.msky130_fd_pr__pfet_01v8_lvt[cgg]
echo OPV XX2_M3 cgg $&s1_xx2_m3_cgg
let s1_xx2_m3_cgd = @m.x1.xdut.xx2_m3.msky130_fd_pr__pfet_01v8_lvt[cgd]
echo OPV XX2_M3 cgd $&s1_xx2_m3_cgd
let s1_xx2_m3_cgs = @m.x1.xdut.xx2_m3.msky130_fd_pr__pfet_01v8_lvt[cgs]
echo OPV XX2_M3 cgs $&s1_xx2_m3_cgs
let s1_xx2_m3_cgb = @m.x1.xdut.xx2_m3.msky130_fd_pr__pfet_01v8_lvt[cgb]
echo OPV XX2_M3 cgb $&s1_xx2_m3_cgb
let s1_xx2_m3_cdg = @m.x1.xdut.xx2_m3.msky130_fd_pr__pfet_01v8_lvt[cdg]
echo OPV XX2_M3 cdg $&s1_xx2_m3_cdg
let s1_xx2_m3_cdd = @m.x1.xdut.xx2_m3.msky130_fd_pr__pfet_01v8_lvt[cdd]
echo OPV XX2_M3 cdd $&s1_xx2_m3_cdd
let s1_xx2_m3_cds = @m.x1.xdut.xx2_m3.msky130_fd_pr__pfet_01v8_lvt[cds]
echo OPV XX2_M3 cds $&s1_xx2_m3_cds
let s1_xx2_m3_cdb = @m.x1.xdut.xx2_m3.msky130_fd_pr__pfet_01v8_lvt[cdb]
echo OPV XX2_M3 cdb $&s1_xx2_m3_cdb
let s1_xx2_m3_csg = @m.x1.xdut.xx2_m3.msky130_fd_pr__pfet_01v8_lvt[csg]
echo OPV XX2_M3 csg $&s1_xx2_m3_csg
let s1_xx2_m3_csd = @m.x1.xdut.xx2_m3.msky130_fd_pr__pfet_01v8_lvt[csd]
echo OPV XX2_M3 csd $&s1_xx2_m3_csd
let s1_xx2_m3_css = @m.x1.xdut.xx2_m3.msky130_fd_pr__pfet_01v8_lvt[css]
echo OPV XX2_M3 css $&s1_xx2_m3_css
let s1_xx2_m3_csb = @m.x1.xdut.xx2_m3.msky130_fd_pr__pfet_01v8_lvt[csb]
echo OPV XX2_M3 csb $&s1_xx2_m3_csb
let s1_xx2_m3_cbg = @m.x1.xdut.xx2_m3.msky130_fd_pr__pfet_01v8_lvt[cbg]
echo OPV XX2_M3 cbg $&s1_xx2_m3_cbg
let s1_xx2_m3_cbd = @m.x1.xdut.xx2_m3.msky130_fd_pr__pfet_01v8_lvt[cbd]
echo OPV XX2_M3 cbd $&s1_xx2_m3_cbd
let s1_xx2_m3_cbs = @m.x1.xdut.xx2_m3.msky130_fd_pr__pfet_01v8_lvt[cbs]
echo OPV XX2_M3 cbs $&s1_xx2_m3_cbs
let s1_xx2_m3_cbb = @m.x1.xdut.xx2_m3.msky130_fd_pr__pfet_01v8_lvt[cbb]
echo OPV XX2_M3 cbb $&s1_xx2_m3_cbb
let s1_xx2_m3_capbd = @m.x1.xdut.xx2_m3.msky130_fd_pr__pfet_01v8_lvt[capbd]
echo OPV XX2_M3 capbd $&s1_xx2_m3_capbd
let s1_xx2_m3_capbs = @m.x1.xdut.xx2_m3.msky130_fd_pr__pfet_01v8_lvt[capbs]
echo OPV XX2_M3 capbs $&s1_xx2_m3_capbs
let s1_xx2_m3_cgso = @m.x1.xdut.xx2_m3.msky130_fd_pr__pfet_01v8_lvt[cgso]
echo OPV XX2_M3 cgso $&s1_xx2_m3_cgso
let s1_xx2_m3_cgdo = @m.x1.xdut.xx2_m3.msky130_fd_pr__pfet_01v8_lvt[cgdo]
echo OPV XX2_M3 cgdo $&s1_xx2_m3_cgdo
let s1_xx2_m3_cgbo = @m.x1.xdut.xx2_m3.msky130_fd_pr__pfet_01v8_lvt[cgbo]
echo OPV XX2_M3 cgbo $&s1_xx2_m3_cgbo
let s1_xx2_m3_weff = @m.x1.xdut.xx2_m3.msky130_fd_pr__pfet_01v8_lvt[weff]
echo OPV XX2_M3 weff $&s1_xx2_m3_weff
let s1_xx2_m3_leff = @m.x1.xdut.xx2_m3.msky130_fd_pr__pfet_01v8_lvt[leff]
echo OPV XX2_M3 leff $&s1_xx2_m3_leff
let s1_xx2_m7_id = @m.x1.xdut.xx2_m7.msky130_fd_pr__pfet_01v8_lvt[id]
echo OPV XX2_M7 id $&s1_xx2_m7_id
let s1_xx2_m7_vgs = @m.x1.xdut.xx2_m7.msky130_fd_pr__pfet_01v8_lvt[vgs]
echo OPV XX2_M7 vgs $&s1_xx2_m7_vgs
let s1_xx2_m7_vds = @m.x1.xdut.xx2_m7.msky130_fd_pr__pfet_01v8_lvt[vds]
echo OPV XX2_M7 vds $&s1_xx2_m7_vds
let s1_xx2_m7_vbs = @m.x1.xdut.xx2_m7.msky130_fd_pr__pfet_01v8_lvt[vbs]
echo OPV XX2_M7 vbs $&s1_xx2_m7_vbs
let s1_xx2_m7_vth = @m.x1.xdut.xx2_m7.msky130_fd_pr__pfet_01v8_lvt[vth]
echo OPV XX2_M7 vth $&s1_xx2_m7_vth
let s1_xx2_m7_vdsat = @m.x1.xdut.xx2_m7.msky130_fd_pr__pfet_01v8_lvt[vdsat]
echo OPV XX2_M7 vdsat $&s1_xx2_m7_vdsat
let s1_xx2_m7_gm = @m.x1.xdut.xx2_m7.msky130_fd_pr__pfet_01v8_lvt[gm]
echo OPV XX2_M7 gm $&s1_xx2_m7_gm
let s1_xx2_m7_gds = @m.x1.xdut.xx2_m7.msky130_fd_pr__pfet_01v8_lvt[gds]
echo OPV XX2_M7 gds $&s1_xx2_m7_gds
let s1_xx2_m7_gmbs = @m.x1.xdut.xx2_m7.msky130_fd_pr__pfet_01v8_lvt[gmbs]
echo OPV XX2_M7 gmbs $&s1_xx2_m7_gmbs
let s1_xx2_m7_cgg = @m.x1.xdut.xx2_m7.msky130_fd_pr__pfet_01v8_lvt[cgg]
echo OPV XX2_M7 cgg $&s1_xx2_m7_cgg
let s1_xx2_m7_cgd = @m.x1.xdut.xx2_m7.msky130_fd_pr__pfet_01v8_lvt[cgd]
echo OPV XX2_M7 cgd $&s1_xx2_m7_cgd
let s1_xx2_m7_cgs = @m.x1.xdut.xx2_m7.msky130_fd_pr__pfet_01v8_lvt[cgs]
echo OPV XX2_M7 cgs $&s1_xx2_m7_cgs
let s1_xx2_m7_cgb = @m.x1.xdut.xx2_m7.msky130_fd_pr__pfet_01v8_lvt[cgb]
echo OPV XX2_M7 cgb $&s1_xx2_m7_cgb
let s1_xx2_m7_cdg = @m.x1.xdut.xx2_m7.msky130_fd_pr__pfet_01v8_lvt[cdg]
echo OPV XX2_M7 cdg $&s1_xx2_m7_cdg
let s1_xx2_m7_cdd = @m.x1.xdut.xx2_m7.msky130_fd_pr__pfet_01v8_lvt[cdd]
echo OPV XX2_M7 cdd $&s1_xx2_m7_cdd
let s1_xx2_m7_cds = @m.x1.xdut.xx2_m7.msky130_fd_pr__pfet_01v8_lvt[cds]
echo OPV XX2_M7 cds $&s1_xx2_m7_cds
let s1_xx2_m7_cdb = @m.x1.xdut.xx2_m7.msky130_fd_pr__pfet_01v8_lvt[cdb]
echo OPV XX2_M7 cdb $&s1_xx2_m7_cdb
let s1_xx2_m7_csg = @m.x1.xdut.xx2_m7.msky130_fd_pr__pfet_01v8_lvt[csg]
echo OPV XX2_M7 csg $&s1_xx2_m7_csg
let s1_xx2_m7_csd = @m.x1.xdut.xx2_m7.msky130_fd_pr__pfet_01v8_lvt[csd]
echo OPV XX2_M7 csd $&s1_xx2_m7_csd
let s1_xx2_m7_css = @m.x1.xdut.xx2_m7.msky130_fd_pr__pfet_01v8_lvt[css]
echo OPV XX2_M7 css $&s1_xx2_m7_css
let s1_xx2_m7_csb = @m.x1.xdut.xx2_m7.msky130_fd_pr__pfet_01v8_lvt[csb]
echo OPV XX2_M7 csb $&s1_xx2_m7_csb
let s1_xx2_m7_cbg = @m.x1.xdut.xx2_m7.msky130_fd_pr__pfet_01v8_lvt[cbg]
echo OPV XX2_M7 cbg $&s1_xx2_m7_cbg
let s1_xx2_m7_cbd = @m.x1.xdut.xx2_m7.msky130_fd_pr__pfet_01v8_lvt[cbd]
echo OPV XX2_M7 cbd $&s1_xx2_m7_cbd
let s1_xx2_m7_cbs = @m.x1.xdut.xx2_m7.msky130_fd_pr__pfet_01v8_lvt[cbs]
echo OPV XX2_M7 cbs $&s1_xx2_m7_cbs
let s1_xx2_m7_cbb = @m.x1.xdut.xx2_m7.msky130_fd_pr__pfet_01v8_lvt[cbb]
echo OPV XX2_M7 cbb $&s1_xx2_m7_cbb
let s1_xx2_m7_capbd = @m.x1.xdut.xx2_m7.msky130_fd_pr__pfet_01v8_lvt[capbd]
echo OPV XX2_M7 capbd $&s1_xx2_m7_capbd
let s1_xx2_m7_capbs = @m.x1.xdut.xx2_m7.msky130_fd_pr__pfet_01v8_lvt[capbs]
echo OPV XX2_M7 capbs $&s1_xx2_m7_capbs
let s1_xx2_m7_cgso = @m.x1.xdut.xx2_m7.msky130_fd_pr__pfet_01v8_lvt[cgso]
echo OPV XX2_M7 cgso $&s1_xx2_m7_cgso
let s1_xx2_m7_cgdo = @m.x1.xdut.xx2_m7.msky130_fd_pr__pfet_01v8_lvt[cgdo]
echo OPV XX2_M7 cgdo $&s1_xx2_m7_cgdo
let s1_xx2_m7_cgbo = @m.x1.xdut.xx2_m7.msky130_fd_pr__pfet_01v8_lvt[cgbo]
echo OPV XX2_M7 cgbo $&s1_xx2_m7_cgbo
let s1_xx2_m7_weff = @m.x1.xdut.xx2_m7.msky130_fd_pr__pfet_01v8_lvt[weff]
echo OPV XX2_M7 weff $&s1_xx2_m7_weff
let s1_xx2_m7_leff = @m.x1.xdut.xx2_m7.msky130_fd_pr__pfet_01v8_lvt[leff]
echo OPV XX2_M7 leff $&s1_xx2_m7_leff
let s1_xx2_m8_id = @m.x1.xdut.xx2_m8.msky130_fd_pr__pfet_01v8_lvt[id]
echo OPV XX2_M8 id $&s1_xx2_m8_id
let s1_xx2_m8_vgs = @m.x1.xdut.xx2_m8.msky130_fd_pr__pfet_01v8_lvt[vgs]
echo OPV XX2_M8 vgs $&s1_xx2_m8_vgs
let s1_xx2_m8_vds = @m.x1.xdut.xx2_m8.msky130_fd_pr__pfet_01v8_lvt[vds]
echo OPV XX2_M8 vds $&s1_xx2_m8_vds
let s1_xx2_m8_vbs = @m.x1.xdut.xx2_m8.msky130_fd_pr__pfet_01v8_lvt[vbs]
echo OPV XX2_M8 vbs $&s1_xx2_m8_vbs
let s1_xx2_m8_vth = @m.x1.xdut.xx2_m8.msky130_fd_pr__pfet_01v8_lvt[vth]
echo OPV XX2_M8 vth $&s1_xx2_m8_vth
let s1_xx2_m8_vdsat = @m.x1.xdut.xx2_m8.msky130_fd_pr__pfet_01v8_lvt[vdsat]
echo OPV XX2_M8 vdsat $&s1_xx2_m8_vdsat
let s1_xx2_m8_gm = @m.x1.xdut.xx2_m8.msky130_fd_pr__pfet_01v8_lvt[gm]
echo OPV XX2_M8 gm $&s1_xx2_m8_gm
let s1_xx2_m8_gds = @m.x1.xdut.xx2_m8.msky130_fd_pr__pfet_01v8_lvt[gds]
echo OPV XX2_M8 gds $&s1_xx2_m8_gds
let s1_xx2_m8_gmbs = @m.x1.xdut.xx2_m8.msky130_fd_pr__pfet_01v8_lvt[gmbs]
echo OPV XX2_M8 gmbs $&s1_xx2_m8_gmbs
let s1_xx2_m8_cgg = @m.x1.xdut.xx2_m8.msky130_fd_pr__pfet_01v8_lvt[cgg]
echo OPV XX2_M8 cgg $&s1_xx2_m8_cgg
let s1_xx2_m8_cgd = @m.x1.xdut.xx2_m8.msky130_fd_pr__pfet_01v8_lvt[cgd]
echo OPV XX2_M8 cgd $&s1_xx2_m8_cgd
let s1_xx2_m8_cgs = @m.x1.xdut.xx2_m8.msky130_fd_pr__pfet_01v8_lvt[cgs]
echo OPV XX2_M8 cgs $&s1_xx2_m8_cgs
let s1_xx2_m8_cgb = @m.x1.xdut.xx2_m8.msky130_fd_pr__pfet_01v8_lvt[cgb]
echo OPV XX2_M8 cgb $&s1_xx2_m8_cgb
let s1_xx2_m8_cdg = @m.x1.xdut.xx2_m8.msky130_fd_pr__pfet_01v8_lvt[cdg]
echo OPV XX2_M8 cdg $&s1_xx2_m8_cdg
let s1_xx2_m8_cdd = @m.x1.xdut.xx2_m8.msky130_fd_pr__pfet_01v8_lvt[cdd]
echo OPV XX2_M8 cdd $&s1_xx2_m8_cdd
let s1_xx2_m8_cds = @m.x1.xdut.xx2_m8.msky130_fd_pr__pfet_01v8_lvt[cds]
echo OPV XX2_M8 cds $&s1_xx2_m8_cds
let s1_xx2_m8_cdb = @m.x1.xdut.xx2_m8.msky130_fd_pr__pfet_01v8_lvt[cdb]
echo OPV XX2_M8 cdb $&s1_xx2_m8_cdb
let s1_xx2_m8_csg = @m.x1.xdut.xx2_m8.msky130_fd_pr__pfet_01v8_lvt[csg]
echo OPV XX2_M8 csg $&s1_xx2_m8_csg
let s1_xx2_m8_csd = @m.x1.xdut.xx2_m8.msky130_fd_pr__pfet_01v8_lvt[csd]
echo OPV XX2_M8 csd $&s1_xx2_m8_csd
let s1_xx2_m8_css = @m.x1.xdut.xx2_m8.msky130_fd_pr__pfet_01v8_lvt[css]
echo OPV XX2_M8 css $&s1_xx2_m8_css
let s1_xx2_m8_csb = @m.x1.xdut.xx2_m8.msky130_fd_pr__pfet_01v8_lvt[csb]
echo OPV XX2_M8 csb $&s1_xx2_m8_csb
let s1_xx2_m8_cbg = @m.x1.xdut.xx2_m8.msky130_fd_pr__pfet_01v8_lvt[cbg]
echo OPV XX2_M8 cbg $&s1_xx2_m8_cbg
let s1_xx2_m8_cbd = @m.x1.xdut.xx2_m8.msky130_fd_pr__pfet_01v8_lvt[cbd]
echo OPV XX2_M8 cbd $&s1_xx2_m8_cbd
let s1_xx2_m8_cbs = @m.x1.xdut.xx2_m8.msky130_fd_pr__pfet_01v8_lvt[cbs]
echo OPV XX2_M8 cbs $&s1_xx2_m8_cbs
let s1_xx2_m8_cbb = @m.x1.xdut.xx2_m8.msky130_fd_pr__pfet_01v8_lvt[cbb]
echo OPV XX2_M8 cbb $&s1_xx2_m8_cbb
let s1_xx2_m8_capbd = @m.x1.xdut.xx2_m8.msky130_fd_pr__pfet_01v8_lvt[capbd]
echo OPV XX2_M8 capbd $&s1_xx2_m8_capbd
let s1_xx2_m8_capbs = @m.x1.xdut.xx2_m8.msky130_fd_pr__pfet_01v8_lvt[capbs]
echo OPV XX2_M8 capbs $&s1_xx2_m8_capbs
let s1_xx2_m8_cgso = @m.x1.xdut.xx2_m8.msky130_fd_pr__pfet_01v8_lvt[cgso]
echo OPV XX2_M8 cgso $&s1_xx2_m8_cgso
let s1_xx2_m8_cgdo = @m.x1.xdut.xx2_m8.msky130_fd_pr__pfet_01v8_lvt[cgdo]
echo OPV XX2_M8 cgdo $&s1_xx2_m8_cgdo
let s1_xx2_m8_cgbo = @m.x1.xdut.xx2_m8.msky130_fd_pr__pfet_01v8_lvt[cgbo]
echo OPV XX2_M8 cgbo $&s1_xx2_m8_cgbo
let s1_xx2_m8_weff = @m.x1.xdut.xx2_m8.msky130_fd_pr__pfet_01v8_lvt[weff]
echo OPV XX2_M8 weff $&s1_xx2_m8_weff
let s1_xx2_m8_leff = @m.x1.xdut.xx2_m8.msky130_fd_pr__pfet_01v8_lvt[leff]
echo OPV XX2_M8 leff $&s1_xx2_m8_leff
let s1_xx2_m5_id = @m.x1.xdut.xx2_m5.msky130_fd_pr__nfet_01v8_lvt[id]
echo OPV XX2_M5 id $&s1_xx2_m5_id
let s1_xx2_m5_vgs = @m.x1.xdut.xx2_m5.msky130_fd_pr__nfet_01v8_lvt[vgs]
echo OPV XX2_M5 vgs $&s1_xx2_m5_vgs
let s1_xx2_m5_vds = @m.x1.xdut.xx2_m5.msky130_fd_pr__nfet_01v8_lvt[vds]
echo OPV XX2_M5 vds $&s1_xx2_m5_vds
let s1_xx2_m5_vbs = @m.x1.xdut.xx2_m5.msky130_fd_pr__nfet_01v8_lvt[vbs]
echo OPV XX2_M5 vbs $&s1_xx2_m5_vbs
let s1_xx2_m5_vth = @m.x1.xdut.xx2_m5.msky130_fd_pr__nfet_01v8_lvt[vth]
echo OPV XX2_M5 vth $&s1_xx2_m5_vth
let s1_xx2_m5_vdsat = @m.x1.xdut.xx2_m5.msky130_fd_pr__nfet_01v8_lvt[vdsat]
echo OPV XX2_M5 vdsat $&s1_xx2_m5_vdsat
let s1_xx2_m5_gm = @m.x1.xdut.xx2_m5.msky130_fd_pr__nfet_01v8_lvt[gm]
echo OPV XX2_M5 gm $&s1_xx2_m5_gm
let s1_xx2_m5_gds = @m.x1.xdut.xx2_m5.msky130_fd_pr__nfet_01v8_lvt[gds]
echo OPV XX2_M5 gds $&s1_xx2_m5_gds
let s1_xx2_m5_gmbs = @m.x1.xdut.xx2_m5.msky130_fd_pr__nfet_01v8_lvt[gmbs]
echo OPV XX2_M5 gmbs $&s1_xx2_m5_gmbs
let s1_xx2_m5_cgg = @m.x1.xdut.xx2_m5.msky130_fd_pr__nfet_01v8_lvt[cgg]
echo OPV XX2_M5 cgg $&s1_xx2_m5_cgg
let s1_xx2_m5_cgd = @m.x1.xdut.xx2_m5.msky130_fd_pr__nfet_01v8_lvt[cgd]
echo OPV XX2_M5 cgd $&s1_xx2_m5_cgd
let s1_xx2_m5_cgs = @m.x1.xdut.xx2_m5.msky130_fd_pr__nfet_01v8_lvt[cgs]
echo OPV XX2_M5 cgs $&s1_xx2_m5_cgs
let s1_xx2_m5_cgb = @m.x1.xdut.xx2_m5.msky130_fd_pr__nfet_01v8_lvt[cgb]
echo OPV XX2_M5 cgb $&s1_xx2_m5_cgb
let s1_xx2_m5_cdg = @m.x1.xdut.xx2_m5.msky130_fd_pr__nfet_01v8_lvt[cdg]
echo OPV XX2_M5 cdg $&s1_xx2_m5_cdg
let s1_xx2_m5_cdd = @m.x1.xdut.xx2_m5.msky130_fd_pr__nfet_01v8_lvt[cdd]
echo OPV XX2_M5 cdd $&s1_xx2_m5_cdd
let s1_xx2_m5_cds = @m.x1.xdut.xx2_m5.msky130_fd_pr__nfet_01v8_lvt[cds]
echo OPV XX2_M5 cds $&s1_xx2_m5_cds
let s1_xx2_m5_cdb = @m.x1.xdut.xx2_m5.msky130_fd_pr__nfet_01v8_lvt[cdb]
echo OPV XX2_M5 cdb $&s1_xx2_m5_cdb
let s1_xx2_m5_csg = @m.x1.xdut.xx2_m5.msky130_fd_pr__nfet_01v8_lvt[csg]
echo OPV XX2_M5 csg $&s1_xx2_m5_csg
let s1_xx2_m5_csd = @m.x1.xdut.xx2_m5.msky130_fd_pr__nfet_01v8_lvt[csd]
echo OPV XX2_M5 csd $&s1_xx2_m5_csd
let s1_xx2_m5_css = @m.x1.xdut.xx2_m5.msky130_fd_pr__nfet_01v8_lvt[css]
echo OPV XX2_M5 css $&s1_xx2_m5_css
let s1_xx2_m5_csb = @m.x1.xdut.xx2_m5.msky130_fd_pr__nfet_01v8_lvt[csb]
echo OPV XX2_M5 csb $&s1_xx2_m5_csb
let s1_xx2_m5_cbg = @m.x1.xdut.xx2_m5.msky130_fd_pr__nfet_01v8_lvt[cbg]
echo OPV XX2_M5 cbg $&s1_xx2_m5_cbg
let s1_xx2_m5_cbd = @m.x1.xdut.xx2_m5.msky130_fd_pr__nfet_01v8_lvt[cbd]
echo OPV XX2_M5 cbd $&s1_xx2_m5_cbd
let s1_xx2_m5_cbs = @m.x1.xdut.xx2_m5.msky130_fd_pr__nfet_01v8_lvt[cbs]
echo OPV XX2_M5 cbs $&s1_xx2_m5_cbs
let s1_xx2_m5_cbb = @m.x1.xdut.xx2_m5.msky130_fd_pr__nfet_01v8_lvt[cbb]
echo OPV XX2_M5 cbb $&s1_xx2_m5_cbb
let s1_xx2_m5_capbd = @m.x1.xdut.xx2_m5.msky130_fd_pr__nfet_01v8_lvt[capbd]
echo OPV XX2_M5 capbd $&s1_xx2_m5_capbd
let s1_xx2_m5_capbs = @m.x1.xdut.xx2_m5.msky130_fd_pr__nfet_01v8_lvt[capbs]
echo OPV XX2_M5 capbs $&s1_xx2_m5_capbs
let s1_xx2_m5_cgso = @m.x1.xdut.xx2_m5.msky130_fd_pr__nfet_01v8_lvt[cgso]
echo OPV XX2_M5 cgso $&s1_xx2_m5_cgso
let s1_xx2_m5_cgdo = @m.x1.xdut.xx2_m5.msky130_fd_pr__nfet_01v8_lvt[cgdo]
echo OPV XX2_M5 cgdo $&s1_xx2_m5_cgdo
let s1_xx2_m5_cgbo = @m.x1.xdut.xx2_m5.msky130_fd_pr__nfet_01v8_lvt[cgbo]
echo OPV XX2_M5 cgbo $&s1_xx2_m5_cgbo
let s1_xx2_m5_weff = @m.x1.xdut.xx2_m5.msky130_fd_pr__nfet_01v8_lvt[weff]
echo OPV XX2_M5 weff $&s1_xx2_m5_weff
let s1_xx2_m5_leff = @m.x1.xdut.xx2_m5.msky130_fd_pr__nfet_01v8_lvt[leff]
echo OPV XX2_M5 leff $&s1_xx2_m5_leff
let s1_xx2_m6_id = @m.x1.xdut.xx2_m6.msky130_fd_pr__nfet_01v8_lvt[id]
echo OPV XX2_M6 id $&s1_xx2_m6_id
let s1_xx2_m6_vgs = @m.x1.xdut.xx2_m6.msky130_fd_pr__nfet_01v8_lvt[vgs]
echo OPV XX2_M6 vgs $&s1_xx2_m6_vgs
let s1_xx2_m6_vds = @m.x1.xdut.xx2_m6.msky130_fd_pr__nfet_01v8_lvt[vds]
echo OPV XX2_M6 vds $&s1_xx2_m6_vds
let s1_xx2_m6_vbs = @m.x1.xdut.xx2_m6.msky130_fd_pr__nfet_01v8_lvt[vbs]
echo OPV XX2_M6 vbs $&s1_xx2_m6_vbs
let s1_xx2_m6_vth = @m.x1.xdut.xx2_m6.msky130_fd_pr__nfet_01v8_lvt[vth]
echo OPV XX2_M6 vth $&s1_xx2_m6_vth
let s1_xx2_m6_vdsat = @m.x1.xdut.xx2_m6.msky130_fd_pr__nfet_01v8_lvt[vdsat]
echo OPV XX2_M6 vdsat $&s1_xx2_m6_vdsat
let s1_xx2_m6_gm = @m.x1.xdut.xx2_m6.msky130_fd_pr__nfet_01v8_lvt[gm]
echo OPV XX2_M6 gm $&s1_xx2_m6_gm
let s1_xx2_m6_gds = @m.x1.xdut.xx2_m6.msky130_fd_pr__nfet_01v8_lvt[gds]
echo OPV XX2_M6 gds $&s1_xx2_m6_gds
let s1_xx2_m6_gmbs = @m.x1.xdut.xx2_m6.msky130_fd_pr__nfet_01v8_lvt[gmbs]
echo OPV XX2_M6 gmbs $&s1_xx2_m6_gmbs
let s1_xx2_m6_cgg = @m.x1.xdut.xx2_m6.msky130_fd_pr__nfet_01v8_lvt[cgg]
echo OPV XX2_M6 cgg $&s1_xx2_m6_cgg
let s1_xx2_m6_cgd = @m.x1.xdut.xx2_m6.msky130_fd_pr__nfet_01v8_lvt[cgd]
echo OPV XX2_M6 cgd $&s1_xx2_m6_cgd
let s1_xx2_m6_cgs = @m.x1.xdut.xx2_m6.msky130_fd_pr__nfet_01v8_lvt[cgs]
echo OPV XX2_M6 cgs $&s1_xx2_m6_cgs
let s1_xx2_m6_cgb = @m.x1.xdut.xx2_m6.msky130_fd_pr__nfet_01v8_lvt[cgb]
echo OPV XX2_M6 cgb $&s1_xx2_m6_cgb
let s1_xx2_m6_cdg = @m.x1.xdut.xx2_m6.msky130_fd_pr__nfet_01v8_lvt[cdg]
echo OPV XX2_M6 cdg $&s1_xx2_m6_cdg
let s1_xx2_m6_cdd = @m.x1.xdut.xx2_m6.msky130_fd_pr__nfet_01v8_lvt[cdd]
echo OPV XX2_M6 cdd $&s1_xx2_m6_cdd
let s1_xx2_m6_cds = @m.x1.xdut.xx2_m6.msky130_fd_pr__nfet_01v8_lvt[cds]
echo OPV XX2_M6 cds $&s1_xx2_m6_cds
let s1_xx2_m6_cdb = @m.x1.xdut.xx2_m6.msky130_fd_pr__nfet_01v8_lvt[cdb]
echo OPV XX2_M6 cdb $&s1_xx2_m6_cdb
let s1_xx2_m6_csg = @m.x1.xdut.xx2_m6.msky130_fd_pr__nfet_01v8_lvt[csg]
echo OPV XX2_M6 csg $&s1_xx2_m6_csg
let s1_xx2_m6_csd = @m.x1.xdut.xx2_m6.msky130_fd_pr__nfet_01v8_lvt[csd]
echo OPV XX2_M6 csd $&s1_xx2_m6_csd
let s1_xx2_m6_css = @m.x1.xdut.xx2_m6.msky130_fd_pr__nfet_01v8_lvt[css]
echo OPV XX2_M6 css $&s1_xx2_m6_css
let s1_xx2_m6_csb = @m.x1.xdut.xx2_m6.msky130_fd_pr__nfet_01v8_lvt[csb]
echo OPV XX2_M6 csb $&s1_xx2_m6_csb
let s1_xx2_m6_cbg = @m.x1.xdut.xx2_m6.msky130_fd_pr__nfet_01v8_lvt[cbg]
echo OPV XX2_M6 cbg $&s1_xx2_m6_cbg
let s1_xx2_m6_cbd = @m.x1.xdut.xx2_m6.msky130_fd_pr__nfet_01v8_lvt[cbd]
echo OPV XX2_M6 cbd $&s1_xx2_m6_cbd
let s1_xx2_m6_cbs = @m.x1.xdut.xx2_m6.msky130_fd_pr__nfet_01v8_lvt[cbs]
echo OPV XX2_M6 cbs $&s1_xx2_m6_cbs
let s1_xx2_m6_cbb = @m.x1.xdut.xx2_m6.msky130_fd_pr__nfet_01v8_lvt[cbb]
echo OPV XX2_M6 cbb $&s1_xx2_m6_cbb
let s1_xx2_m6_capbd = @m.x1.xdut.xx2_m6.msky130_fd_pr__nfet_01v8_lvt[capbd]
echo OPV XX2_M6 capbd $&s1_xx2_m6_capbd
let s1_xx2_m6_capbs = @m.x1.xdut.xx2_m6.msky130_fd_pr__nfet_01v8_lvt[capbs]
echo OPV XX2_M6 capbs $&s1_xx2_m6_capbs
let s1_xx2_m6_cgso = @m.x1.xdut.xx2_m6.msky130_fd_pr__nfet_01v8_lvt[cgso]
echo OPV XX2_M6 cgso $&s1_xx2_m6_cgso
let s1_xx2_m6_cgdo = @m.x1.xdut.xx2_m6.msky130_fd_pr__nfet_01v8_lvt[cgdo]
echo OPV XX2_M6 cgdo $&s1_xx2_m6_cgdo
let s1_xx2_m6_cgbo = @m.x1.xdut.xx2_m6.msky130_fd_pr__nfet_01v8_lvt[cgbo]
echo OPV XX2_M6 cgbo $&s1_xx2_m6_cgbo
let s1_xx2_m6_weff = @m.x1.xdut.xx2_m6.msky130_fd_pr__nfet_01v8_lvt[weff]
echo OPV XX2_M6 weff $&s1_xx2_m6_weff
let s1_xx2_m6_leff = @m.x1.xdut.xx2_m6.msky130_fd_pr__nfet_01v8_lvt[leff]
echo OPV XX2_M6 leff $&s1_xx2_m6_leff
let s1_xx2_m10_id = @m.x1.xdut.xx2_m10.msky130_fd_pr__nfet_01v8_lvt[id]
echo OPV XX2_M10 id $&s1_xx2_m10_id
let s1_xx2_m10_vgs = @m.x1.xdut.xx2_m10.msky130_fd_pr__nfet_01v8_lvt[vgs]
echo OPV XX2_M10 vgs $&s1_xx2_m10_vgs
let s1_xx2_m10_vds = @m.x1.xdut.xx2_m10.msky130_fd_pr__nfet_01v8_lvt[vds]
echo OPV XX2_M10 vds $&s1_xx2_m10_vds
let s1_xx2_m10_vbs = @m.x1.xdut.xx2_m10.msky130_fd_pr__nfet_01v8_lvt[vbs]
echo OPV XX2_M10 vbs $&s1_xx2_m10_vbs
let s1_xx2_m10_vth = @m.x1.xdut.xx2_m10.msky130_fd_pr__nfet_01v8_lvt[vth]
echo OPV XX2_M10 vth $&s1_xx2_m10_vth
let s1_xx2_m10_vdsat = @m.x1.xdut.xx2_m10.msky130_fd_pr__nfet_01v8_lvt[vdsat]
echo OPV XX2_M10 vdsat $&s1_xx2_m10_vdsat
let s1_xx2_m10_gm = @m.x1.xdut.xx2_m10.msky130_fd_pr__nfet_01v8_lvt[gm]
echo OPV XX2_M10 gm $&s1_xx2_m10_gm
let s1_xx2_m10_gds = @m.x1.xdut.xx2_m10.msky130_fd_pr__nfet_01v8_lvt[gds]
echo OPV XX2_M10 gds $&s1_xx2_m10_gds
let s1_xx2_m10_gmbs = @m.x1.xdut.xx2_m10.msky130_fd_pr__nfet_01v8_lvt[gmbs]
echo OPV XX2_M10 gmbs $&s1_xx2_m10_gmbs
let s1_xx2_m10_cgg = @m.x1.xdut.xx2_m10.msky130_fd_pr__nfet_01v8_lvt[cgg]
echo OPV XX2_M10 cgg $&s1_xx2_m10_cgg
let s1_xx2_m10_cgd = @m.x1.xdut.xx2_m10.msky130_fd_pr__nfet_01v8_lvt[cgd]
echo OPV XX2_M10 cgd $&s1_xx2_m10_cgd
let s1_xx2_m10_cgs = @m.x1.xdut.xx2_m10.msky130_fd_pr__nfet_01v8_lvt[cgs]
echo OPV XX2_M10 cgs $&s1_xx2_m10_cgs
let s1_xx2_m10_cgb = @m.x1.xdut.xx2_m10.msky130_fd_pr__nfet_01v8_lvt[cgb]
echo OPV XX2_M10 cgb $&s1_xx2_m10_cgb
let s1_xx2_m10_cdg = @m.x1.xdut.xx2_m10.msky130_fd_pr__nfet_01v8_lvt[cdg]
echo OPV XX2_M10 cdg $&s1_xx2_m10_cdg
let s1_xx2_m10_cdd = @m.x1.xdut.xx2_m10.msky130_fd_pr__nfet_01v8_lvt[cdd]
echo OPV XX2_M10 cdd $&s1_xx2_m10_cdd
let s1_xx2_m10_cds = @m.x1.xdut.xx2_m10.msky130_fd_pr__nfet_01v8_lvt[cds]
echo OPV XX2_M10 cds $&s1_xx2_m10_cds
let s1_xx2_m10_cdb = @m.x1.xdut.xx2_m10.msky130_fd_pr__nfet_01v8_lvt[cdb]
echo OPV XX2_M10 cdb $&s1_xx2_m10_cdb
let s1_xx2_m10_csg = @m.x1.xdut.xx2_m10.msky130_fd_pr__nfet_01v8_lvt[csg]
echo OPV XX2_M10 csg $&s1_xx2_m10_csg
let s1_xx2_m10_csd = @m.x1.xdut.xx2_m10.msky130_fd_pr__nfet_01v8_lvt[csd]
echo OPV XX2_M10 csd $&s1_xx2_m10_csd
let s1_xx2_m10_css = @m.x1.xdut.xx2_m10.msky130_fd_pr__nfet_01v8_lvt[css]
echo OPV XX2_M10 css $&s1_xx2_m10_css
let s1_xx2_m10_csb = @m.x1.xdut.xx2_m10.msky130_fd_pr__nfet_01v8_lvt[csb]
echo OPV XX2_M10 csb $&s1_xx2_m10_csb
let s1_xx2_m10_cbg = @m.x1.xdut.xx2_m10.msky130_fd_pr__nfet_01v8_lvt[cbg]
echo OPV XX2_M10 cbg $&s1_xx2_m10_cbg
let s1_xx2_m10_cbd = @m.x1.xdut.xx2_m10.msky130_fd_pr__nfet_01v8_lvt[cbd]
echo OPV XX2_M10 cbd $&s1_xx2_m10_cbd
let s1_xx2_m10_cbs = @m.x1.xdut.xx2_m10.msky130_fd_pr__nfet_01v8_lvt[cbs]
echo OPV XX2_M10 cbs $&s1_xx2_m10_cbs
let s1_xx2_m10_cbb = @m.x1.xdut.xx2_m10.msky130_fd_pr__nfet_01v8_lvt[cbb]
echo OPV XX2_M10 cbb $&s1_xx2_m10_cbb
let s1_xx2_m10_capbd = @m.x1.xdut.xx2_m10.msky130_fd_pr__nfet_01v8_lvt[capbd]
echo OPV XX2_M10 capbd $&s1_xx2_m10_capbd
let s1_xx2_m10_capbs = @m.x1.xdut.xx2_m10.msky130_fd_pr__nfet_01v8_lvt[capbs]
echo OPV XX2_M10 capbs $&s1_xx2_m10_capbs
let s1_xx2_m10_cgso = @m.x1.xdut.xx2_m10.msky130_fd_pr__nfet_01v8_lvt[cgso]
echo OPV XX2_M10 cgso $&s1_xx2_m10_cgso
let s1_xx2_m10_cgdo = @m.x1.xdut.xx2_m10.msky130_fd_pr__nfet_01v8_lvt[cgdo]
echo OPV XX2_M10 cgdo $&s1_xx2_m10_cgdo
let s1_xx2_m10_cgbo = @m.x1.xdut.xx2_m10.msky130_fd_pr__nfet_01v8_lvt[cgbo]
echo OPV XX2_M10 cgbo $&s1_xx2_m10_cgbo
let s1_xx2_m10_weff = @m.x1.xdut.xx2_m10.msky130_fd_pr__nfet_01v8_lvt[weff]
echo OPV XX2_M10 weff $&s1_xx2_m10_weff
let s1_xx2_m10_leff = @m.x1.xdut.xx2_m10.msky130_fd_pr__nfet_01v8_lvt[leff]
echo OPV XX2_M10 leff $&s1_xx2_m10_leff
let s1_xx2_m11_id = @m.x1.xdut.xx2_m11.msky130_fd_pr__nfet_01v8_lvt[id]
echo OPV XX2_M11 id $&s1_xx2_m11_id
let s1_xx2_m11_vgs = @m.x1.xdut.xx2_m11.msky130_fd_pr__nfet_01v8_lvt[vgs]
echo OPV XX2_M11 vgs $&s1_xx2_m11_vgs
let s1_xx2_m11_vds = @m.x1.xdut.xx2_m11.msky130_fd_pr__nfet_01v8_lvt[vds]
echo OPV XX2_M11 vds $&s1_xx2_m11_vds
let s1_xx2_m11_vbs = @m.x1.xdut.xx2_m11.msky130_fd_pr__nfet_01v8_lvt[vbs]
echo OPV XX2_M11 vbs $&s1_xx2_m11_vbs
let s1_xx2_m11_vth = @m.x1.xdut.xx2_m11.msky130_fd_pr__nfet_01v8_lvt[vth]
echo OPV XX2_M11 vth $&s1_xx2_m11_vth
let s1_xx2_m11_vdsat = @m.x1.xdut.xx2_m11.msky130_fd_pr__nfet_01v8_lvt[vdsat]
echo OPV XX2_M11 vdsat $&s1_xx2_m11_vdsat
let s1_xx2_m11_gm = @m.x1.xdut.xx2_m11.msky130_fd_pr__nfet_01v8_lvt[gm]
echo OPV XX2_M11 gm $&s1_xx2_m11_gm
let s1_xx2_m11_gds = @m.x1.xdut.xx2_m11.msky130_fd_pr__nfet_01v8_lvt[gds]
echo OPV XX2_M11 gds $&s1_xx2_m11_gds
let s1_xx2_m11_gmbs = @m.x1.xdut.xx2_m11.msky130_fd_pr__nfet_01v8_lvt[gmbs]
echo OPV XX2_M11 gmbs $&s1_xx2_m11_gmbs
let s1_xx2_m11_cgg = @m.x1.xdut.xx2_m11.msky130_fd_pr__nfet_01v8_lvt[cgg]
echo OPV XX2_M11 cgg $&s1_xx2_m11_cgg
let s1_xx2_m11_cgd = @m.x1.xdut.xx2_m11.msky130_fd_pr__nfet_01v8_lvt[cgd]
echo OPV XX2_M11 cgd $&s1_xx2_m11_cgd
let s1_xx2_m11_cgs = @m.x1.xdut.xx2_m11.msky130_fd_pr__nfet_01v8_lvt[cgs]
echo OPV XX2_M11 cgs $&s1_xx2_m11_cgs
let s1_xx2_m11_cgb = @m.x1.xdut.xx2_m11.msky130_fd_pr__nfet_01v8_lvt[cgb]
echo OPV XX2_M11 cgb $&s1_xx2_m11_cgb
let s1_xx2_m11_cdg = @m.x1.xdut.xx2_m11.msky130_fd_pr__nfet_01v8_lvt[cdg]
echo OPV XX2_M11 cdg $&s1_xx2_m11_cdg
let s1_xx2_m11_cdd = @m.x1.xdut.xx2_m11.msky130_fd_pr__nfet_01v8_lvt[cdd]
echo OPV XX2_M11 cdd $&s1_xx2_m11_cdd
let s1_xx2_m11_cds = @m.x1.xdut.xx2_m11.msky130_fd_pr__nfet_01v8_lvt[cds]
echo OPV XX2_M11 cds $&s1_xx2_m11_cds
let s1_xx2_m11_cdb = @m.x1.xdut.xx2_m11.msky130_fd_pr__nfet_01v8_lvt[cdb]
echo OPV XX2_M11 cdb $&s1_xx2_m11_cdb
let s1_xx2_m11_csg = @m.x1.xdut.xx2_m11.msky130_fd_pr__nfet_01v8_lvt[csg]
echo OPV XX2_M11 csg $&s1_xx2_m11_csg
let s1_xx2_m11_csd = @m.x1.xdut.xx2_m11.msky130_fd_pr__nfet_01v8_lvt[csd]
echo OPV XX2_M11 csd $&s1_xx2_m11_csd
let s1_xx2_m11_css = @m.x1.xdut.xx2_m11.msky130_fd_pr__nfet_01v8_lvt[css]
echo OPV XX2_M11 css $&s1_xx2_m11_css
let s1_xx2_m11_csb = @m.x1.xdut.xx2_m11.msky130_fd_pr__nfet_01v8_lvt[csb]
echo OPV XX2_M11 csb $&s1_xx2_m11_csb
let s1_xx2_m11_cbg = @m.x1.xdut.xx2_m11.msky130_fd_pr__nfet_01v8_lvt[cbg]
echo OPV XX2_M11 cbg $&s1_xx2_m11_cbg
let s1_xx2_m11_cbd = @m.x1.xdut.xx2_m11.msky130_fd_pr__nfet_01v8_lvt[cbd]
echo OPV XX2_M11 cbd $&s1_xx2_m11_cbd
let s1_xx2_m11_cbs = @m.x1.xdut.xx2_m11.msky130_fd_pr__nfet_01v8_lvt[cbs]
echo OPV XX2_M11 cbs $&s1_xx2_m11_cbs
let s1_xx2_m11_cbb = @m.x1.xdut.xx2_m11.msky130_fd_pr__nfet_01v8_lvt[cbb]
echo OPV XX2_M11 cbb $&s1_xx2_m11_cbb
let s1_xx2_m11_capbd = @m.x1.xdut.xx2_m11.msky130_fd_pr__nfet_01v8_lvt[capbd]
echo OPV XX2_M11 capbd $&s1_xx2_m11_capbd
let s1_xx2_m11_capbs = @m.x1.xdut.xx2_m11.msky130_fd_pr__nfet_01v8_lvt[capbs]
echo OPV XX2_M11 capbs $&s1_xx2_m11_capbs
let s1_xx2_m11_cgso = @m.x1.xdut.xx2_m11.msky130_fd_pr__nfet_01v8_lvt[cgso]
echo OPV XX2_M11 cgso $&s1_xx2_m11_cgso
let s1_xx2_m11_cgdo = @m.x1.xdut.xx2_m11.msky130_fd_pr__nfet_01v8_lvt[cgdo]
echo OPV XX2_M11 cgdo $&s1_xx2_m11_cgdo
let s1_xx2_m11_cgbo = @m.x1.xdut.xx2_m11.msky130_fd_pr__nfet_01v8_lvt[cgbo]
echo OPV XX2_M11 cgbo $&s1_xx2_m11_cgbo
let s1_xx2_m11_weff = @m.x1.xdut.xx2_m11.msky130_fd_pr__nfet_01v8_lvt[weff]
echo OPV XX2_M11 weff $&s1_xx2_m11_weff
let s1_xx2_m11_leff = @m.x1.xdut.xx2_m11.msky130_fd_pr__nfet_01v8_lvt[leff]
echo OPV XX2_M11 leff $&s1_xx2_m11_leff
let s1_xx2_m12_id = @m.x1.xdut.xx2_m12.msky130_fd_pr__pfet_01v8_lvt[id]
echo OPV XX2_M12 id $&s1_xx2_m12_id
let s1_xx2_m12_vgs = @m.x1.xdut.xx2_m12.msky130_fd_pr__pfet_01v8_lvt[vgs]
echo OPV XX2_M12 vgs $&s1_xx2_m12_vgs
let s1_xx2_m12_vds = @m.x1.xdut.xx2_m12.msky130_fd_pr__pfet_01v8_lvt[vds]
echo OPV XX2_M12 vds $&s1_xx2_m12_vds
let s1_xx2_m12_vbs = @m.x1.xdut.xx2_m12.msky130_fd_pr__pfet_01v8_lvt[vbs]
echo OPV XX2_M12 vbs $&s1_xx2_m12_vbs
let s1_xx2_m12_vth = @m.x1.xdut.xx2_m12.msky130_fd_pr__pfet_01v8_lvt[vth]
echo OPV XX2_M12 vth $&s1_xx2_m12_vth
let s1_xx2_m12_vdsat = @m.x1.xdut.xx2_m12.msky130_fd_pr__pfet_01v8_lvt[vdsat]
echo OPV XX2_M12 vdsat $&s1_xx2_m12_vdsat
let s1_xx2_m12_gm = @m.x1.xdut.xx2_m12.msky130_fd_pr__pfet_01v8_lvt[gm]
echo OPV XX2_M12 gm $&s1_xx2_m12_gm
let s1_xx2_m12_gds = @m.x1.xdut.xx2_m12.msky130_fd_pr__pfet_01v8_lvt[gds]
echo OPV XX2_M12 gds $&s1_xx2_m12_gds
let s1_xx2_m12_gmbs = @m.x1.xdut.xx2_m12.msky130_fd_pr__pfet_01v8_lvt[gmbs]
echo OPV XX2_M12 gmbs $&s1_xx2_m12_gmbs
let s1_xx2_m12_cgg = @m.x1.xdut.xx2_m12.msky130_fd_pr__pfet_01v8_lvt[cgg]
echo OPV XX2_M12 cgg $&s1_xx2_m12_cgg
let s1_xx2_m12_cgd = @m.x1.xdut.xx2_m12.msky130_fd_pr__pfet_01v8_lvt[cgd]
echo OPV XX2_M12 cgd $&s1_xx2_m12_cgd
let s1_xx2_m12_cgs = @m.x1.xdut.xx2_m12.msky130_fd_pr__pfet_01v8_lvt[cgs]
echo OPV XX2_M12 cgs $&s1_xx2_m12_cgs
let s1_xx2_m12_cgb = @m.x1.xdut.xx2_m12.msky130_fd_pr__pfet_01v8_lvt[cgb]
echo OPV XX2_M12 cgb $&s1_xx2_m12_cgb
let s1_xx2_m12_cdg = @m.x1.xdut.xx2_m12.msky130_fd_pr__pfet_01v8_lvt[cdg]
echo OPV XX2_M12 cdg $&s1_xx2_m12_cdg
let s1_xx2_m12_cdd = @m.x1.xdut.xx2_m12.msky130_fd_pr__pfet_01v8_lvt[cdd]
echo OPV XX2_M12 cdd $&s1_xx2_m12_cdd
let s1_xx2_m12_cds = @m.x1.xdut.xx2_m12.msky130_fd_pr__pfet_01v8_lvt[cds]
echo OPV XX2_M12 cds $&s1_xx2_m12_cds
let s1_xx2_m12_cdb = @m.x1.xdut.xx2_m12.msky130_fd_pr__pfet_01v8_lvt[cdb]
echo OPV XX2_M12 cdb $&s1_xx2_m12_cdb
let s1_xx2_m12_csg = @m.x1.xdut.xx2_m12.msky130_fd_pr__pfet_01v8_lvt[csg]
echo OPV XX2_M12 csg $&s1_xx2_m12_csg
let s1_xx2_m12_csd = @m.x1.xdut.xx2_m12.msky130_fd_pr__pfet_01v8_lvt[csd]
echo OPV XX2_M12 csd $&s1_xx2_m12_csd
let s1_xx2_m12_css = @m.x1.xdut.xx2_m12.msky130_fd_pr__pfet_01v8_lvt[css]
echo OPV XX2_M12 css $&s1_xx2_m12_css
let s1_xx2_m12_csb = @m.x1.xdut.xx2_m12.msky130_fd_pr__pfet_01v8_lvt[csb]
echo OPV XX2_M12 csb $&s1_xx2_m12_csb
let s1_xx2_m12_cbg = @m.x1.xdut.xx2_m12.msky130_fd_pr__pfet_01v8_lvt[cbg]
echo OPV XX2_M12 cbg $&s1_xx2_m12_cbg
let s1_xx2_m12_cbd = @m.x1.xdut.xx2_m12.msky130_fd_pr__pfet_01v8_lvt[cbd]
echo OPV XX2_M12 cbd $&s1_xx2_m12_cbd
let s1_xx2_m12_cbs = @m.x1.xdut.xx2_m12.msky130_fd_pr__pfet_01v8_lvt[cbs]
echo OPV XX2_M12 cbs $&s1_xx2_m12_cbs
let s1_xx2_m12_cbb = @m.x1.xdut.xx2_m12.msky130_fd_pr__pfet_01v8_lvt[cbb]
echo OPV XX2_M12 cbb $&s1_xx2_m12_cbb
let s1_xx2_m12_capbd = @m.x1.xdut.xx2_m12.msky130_fd_pr__pfet_01v8_lvt[capbd]
echo OPV XX2_M12 capbd $&s1_xx2_m12_capbd
let s1_xx2_m12_capbs = @m.x1.xdut.xx2_m12.msky130_fd_pr__pfet_01v8_lvt[capbs]
echo OPV XX2_M12 capbs $&s1_xx2_m12_capbs
let s1_xx2_m12_cgso = @m.x1.xdut.xx2_m12.msky130_fd_pr__pfet_01v8_lvt[cgso]
echo OPV XX2_M12 cgso $&s1_xx2_m12_cgso
let s1_xx2_m12_cgdo = @m.x1.xdut.xx2_m12.msky130_fd_pr__pfet_01v8_lvt[cgdo]
echo OPV XX2_M12 cgdo $&s1_xx2_m12_cgdo
let s1_xx2_m12_cgbo = @m.x1.xdut.xx2_m12.msky130_fd_pr__pfet_01v8_lvt[cgbo]
echo OPV XX2_M12 cgbo $&s1_xx2_m12_cgbo
let s1_xx2_m12_weff = @m.x1.xdut.xx2_m12.msky130_fd_pr__pfet_01v8_lvt[weff]
echo OPV XX2_M12 weff $&s1_xx2_m12_weff
let s1_xx2_m12_leff = @m.x1.xdut.xx2_m12.msky130_fd_pr__pfet_01v8_lvt[leff]
echo OPV XX2_M12 leff $&s1_xx2_m12_leff
let s1i = i(vsup)
echo OPI isup $&s1i
let s1o = v(OUTP) - v(OUTN)
let s1cm = (v(OUTP) + v(OUTN)) / 2
echo OPI voutcm $&s1cm
echo OPI vout $&s1o
quit 0
.endc
**.ends

.subckt dut_amp INP INN OUTN VDD VSS OUTP
XDUT OUTP INN VDD VSS OUTN INP ttsky25a_fd
.ends

.subckt ttsky25a_fd Vop Vm Vdd Vss Vom Vp
Cbud_s2_0 NBias Vss 138.682f
Cbud_s2_1 Rgm Vss 26.6481f
Cbud_s2_2 Vom Vss 17.9979f
Cbud_s2_3 Vom1 Vss 45.5318f
Cbud_s2_4 Vop Vss 17.9979f
Cbud_s2_5 Vop1 Vss 45.5318f
Cbud_s2_6 net1 Vss 100.632f
Cbud_s2_7 net2 Vss 84.3145f
Cbud_s2_8 net4 Vss 723.633f
Cbud_s2_9 net5 Vss 128.428f
Cbud_s2_10 net6 Vss 53.0761f
Cbud_s2_11 x1_Vout Vss 290.581f
Cbud_s2_12 x1_Vtest2 Vss 6.7871f
Cbud_s2_13 x1_net1 Vss 6.7871f
Cbud_s2_14 x1_net3 Vss 15.1475f
Cbud_s2_15 x1_net4 Vss 15.1475f
Cbud_s2_16 x1_net5 Vss 15.1475f
Cbud_s2_17 x1_net6 Vss 15.1475f
Cbud_s2_18 x1_net7 Vss 10.9764f
Cbud_s2_19 x1_net8 Vss 10.9764f
Cbud_s2_20 x1_net9 Vss 248.442f
Cbud_s2_21 x2_Vbiasp Vss 105.1f
Cbud_s2_22 x2_Vout Vss 150.98f
Cbud_s2_23 x2_Vtest Vss 349.829f
Cbud_s2_24 x2_net1 Vss 30.6534f
Cbud_s2_25 x2_x1_net1 Vss 6.26438f
Cbud_s2_26 x2_x1_net10 Vss 6.26438f
Cbud_s2_27 x2_x1_net11 Vss 6.26438f
Cbud_s2_28 x2_x1_net12 Vss 6.26438f
Cbud_s2_29 x2_x1_net13 Vss 6.26438f
Cbud_s2_30 x2_x1_net14 Vss 6.26438f
Cbud_s2_31 x2_x1_net15 Vss 7.55001f
Cbud_s2_32 x2_x1_net16 Vss 40.5949f
Cbud_s2_33 x2_x1_net17 Vss 40.5949f
Cbud_s2_34 x2_x1_net18 Vss 30.2f
Cbud_s2_35 x2_x1_net19 Vss 16.9875f
Cbud_s2_36 x2_x1_net2 Vss 6.26438f
Cbud_s2_37 x2_x1_net3 Vss 10.872f
Cbud_s2_38 x2_x1_net4 Vss 6.26438f
Cbud_s2_39 x2_x1_net5 Vss 6.26438f
Cbud_s2_40 x2_x1_net6 Vss 6.26438f
Cbud_s2_41 x2_x1_net7 Vss 6.26438f
Cbud_s2_42 x2_x1_net8 Vss 6.26438f
Cbud_s2_43 x2_x1_net9 Vss 6.26438f
Cbud_s2_44 x2_x2_net1 Vss 10.872f
Cbud_s2_45 x2_x2_net10 Vss 6.26438f
Cbud_s2_46 x2_x2_net11 Vss 7.55001f
Cbud_s2_47 x2_x2_net12 Vss 6.26438f
Cbud_s2_48 x2_x2_net13 Vss 6.26438f
Cbud_s2_49 x2_x2_net14 Vss 6.26438f
Cbud_s2_50 x2_x2_net15 Vss 6.26438f
Cbud_s2_51 x2_x2_net16 Vss 6.26438f
Cbud_s2_52 x2_x2_net17 Vss 6.26438f
Cbud_s2_53 x2_x2_net18 Vss 6.26438f
Cbud_s2_54 x2_x2_net19 Vss 6.26438f
Cbud_s2_55 x2_x2_net2 Vss 6.26438f
Cbud_s2_56 x2_x2_net3 Vss 6.26438f
Cbud_s2_57 x2_x2_net4 Vss 40.5949f
Cbud_s2_58 x2_x2_net5 Vss 40.5949f
Cbud_s2_59 x2_x2_net6 Vss 30.2f
Cbud_s2_60 x2_x2_net7 Vss 16.9875f
Cbud_s2_61 x2_x2_net8 Vss 6.26438f
Cbud_s2_62 x2_x2_net9 Vss 6.26438f
Cbud_s2_63 NBias PBias 19.5657f
Cbud_s2_64 NBias Rgm 1.8284f
Cbud_s2_65 NBias Vom 0.988991f
Cbud_s2_66 NBias Vom1 0.988991f
Cbud_s2_67 NBias Vop 0.988991f
Cbud_s2_68 NBias Vop1 0.988991f
Cbud_s2_69 NBias net1 6.00207f
Cbud_s2_70 NBias net2 4.64822f
Cbud_s2_71 NBias net3 13.7423f
Cbud_s2_72 NBias net6 2.65975f
Cbud_s2_73 NBias x1_Vbias 5.10867f
Cbud_s2_74 NBias x1_Vout 6.40893f
Cbud_s2_75 NBias x1_Vtest2 0.565278f
Cbud_s2_76 NBias x1_net1 0.565278f
Cbud_s2_77 NBias x1_net2 3.50591f
Cbud_s2_78 NBias x1_net4 1.75295f
Cbud_s2_79 NBias x1_net5 1.75295f
Cbud_s2_80 NBias x1_net6 1.75295f
Cbud_s2_81 NBias x1_net7 1.73817f
Cbud_s2_82 NBias x1_net8 1.73817f
Cbud_s2_83 NBias x1_net9 6.40893f
Cbud_s2_84 NBias x2_Vbiasp 3.95719f
Cbud_s2_85 NBias x2_Vcm 6.40893f
Cbud_s2_86 NBias x2_Vout 6.23194f
Cbud_s2_87 NBias x2_net1 3.31341f
Cbud_s2_88 NBias x2_x1_net1 1.208f
Cbud_s2_89 NBias x2_x1_net10 1.60829f
Cbud_s2_90 NBias x2_x1_net11 1.38674f
Cbud_s2_91 NBias x2_x1_net12 3.35556f
Cbud_s2_92 NBias x2_x1_net13 4.24689f
Cbud_s2_93 NBias x2_x1_net14 5.54695f
Cbud_s2_94 NBias x2_x1_net15 6.40893f
Cbud_s2_95 NBias x2_x1_net16 6.40893f
Cbud_s2_96 NBias x2_x1_net17 6.40893f
Cbud_s2_97 NBias x2_x1_net18 6.40893f
Cbud_s2_98 NBias x2_x1_net19 6.40893f
Cbud_s2_99 NBias x2_x1_net2 2.71801f
Cbud_s2_100 NBias x2_x1_net3 6.40893f
Cbud_s2_101 NBias x2_x1_net4 0.988991f
Cbud_s2_102 NBias x2_x1_net5 0.988991f
Cbud_s2_103 NBias x2_x1_net6 0.988991f
Cbud_s2_104 NBias x2_x1_net7 1.06172f
Cbud_s2_105 NBias x2_x1_net8 2.24629f
Cbud_s2_106 NBias x2_x1_net9 1.88751f
Cbud_s2_107 NBias x2_x2_net1 6.40893f
Cbud_s2_108 NBias x2_x2_net10 5.54695f
Cbud_s2_109 NBias x2_x2_net11 6.40893f
Cbud_s2_110 NBias x2_x2_net12 2.24629f
Cbud_s2_111 NBias x2_x2_net13 1.88751f
Cbud_s2_112 NBias x2_x2_net14 1.60829f
Cbud_s2_113 NBias x2_x2_net15 1.38674f
Cbud_s2_114 NBias x2_x2_net16 0.988991f
Cbud_s2_115 NBias x2_x2_net17 0.988991f
Cbud_s2_116 NBias x2_x2_net18 0.988991f
Cbud_s2_117 NBias x2_x2_net19 1.06172f
Cbud_s2_118 NBias x2_x2_net2 2.71801f
Cbud_s2_119 NBias x2_x2_net3 1.208f
Cbud_s2_120 NBias x2_x2_net4 6.40893f
Cbud_s2_121 NBias x2_x2_net5 6.40893f
Cbud_s2_122 NBias x2_x2_net6 6.40893f
Cbud_s2_123 NBias x2_x2_net7 6.40893f
Cbud_s2_124 NBias x2_x2_net8 3.35556f
Cbud_s2_125 NBias x2_x2_net9 4.24689f
Cbud_s2_126 NBias Vm 1.19379f
Cbud_s2_127 NBias Vp 1.19379f
Cbud_s2_128 PBias Vom 1.50247f
Cbud_s2_129 PBias Vom1 1.50247f
Cbud_s2_130 PBias Vop 1.50247f
Cbud_s2_131 PBias Vop1 1.50247f
Cbud_s2_132 PBias net1 11.4497f
Cbud_s2_133 PBias net4 15.184f
Cbud_s2_134 PBias net5 10.4054f
Cbud_s2_135 PBias net6 8.10735f
Cbud_s2_136 PBias x1_Vbias 5.10867f
Cbud_s2_137 PBias x1_Vout 9.06586f
Cbud_s2_138 PBias x1_Vtest2 0.565278f
Cbud_s2_139 PBias x1_net1 0.565278f
Cbud_s2_140 PBias x1_net2 3.50591f
Cbud_s2_141 PBias x1_net3 1.75295f
Cbud_s2_142 PBias x1_net5 1.75295f
Cbud_s2_143 PBias x1_net6 1.75295f
Cbud_s2_144 PBias x1_net7 1.73817f
Cbud_s2_145 PBias x1_net8 1.73817f
Cbud_s2_146 PBias x1_net9 8.59201f
Cbud_s2_147 PBias x2_Vbiasp 3.95719f
Cbud_s2_148 PBias x2_Vcm 7.97714f
Cbud_s2_149 PBias x2_net1 3.31341f
Cbud_s2_150 PBias x2_x1_net1 1.208f
Cbud_s2_151 PBias x2_x1_net10 1.60829f
Cbud_s2_152 PBias x2_x1_net11 1.38674f
Cbud_s2_153 PBias x2_x1_net12 3.35556f
Cbud_s2_154 PBias x2_x1_net13 4.24688f
Cbud_s2_155 PBias x2_x1_net14 5.54695f
Cbud_s2_156 PBias x2_x1_net15 6.75515f
Cbud_s2_157 PBias x2_x1_net16 6.75515f
Cbud_s2_158 PBias x2_x1_net17 6.75515f
Cbud_s2_159 PBias x2_x1_net18 6.75515f
Cbud_s2_160 PBias x2_x1_net19 6.75515f
Cbud_s2_161 PBias x2_x1_net2 2.718f
Cbud_s2_162 PBias x2_x1_net3 6.75515f
Cbud_s2_163 PBias x2_x1_net4 1.04242f
Cbud_s2_164 PBias x2_x1_net5 1.04242f
Cbud_s2_165 PBias x2_x1_net6 1.04242f
Cbud_s2_166 PBias x2_x1_net7 1.06172f
Cbud_s2_167 PBias x2_x1_net8 2.24628f
Cbud_s2_168 PBias x2_x1_net9 1.8875f
Cbud_s2_169 PBias x2_x2_net1 6.75515f
Cbud_s2_170 PBias x2_x2_net10 5.54695f
Cbud_s2_171 PBias x2_x2_net11 6.75515f
Cbud_s2_172 PBias x2_x2_net12 2.24628f
Cbud_s2_173 PBias x2_x2_net13 1.8875f
Cbud_s2_174 PBias x2_x2_net14 1.60829f
Cbud_s2_175 PBias x2_x2_net15 1.38674f
Cbud_s2_176 PBias x2_x2_net16 1.04242f
Cbud_s2_177 PBias x2_x2_net17 1.04242f
Cbud_s2_178 PBias x2_x2_net18 1.04242f
Cbud_s2_179 PBias x2_x2_net19 1.06172f
Cbud_s2_180 PBias x2_x2_net2 2.718f
Cbud_s2_181 PBias x2_x2_net3 1.208f
Cbud_s2_182 PBias x2_x2_net4 6.75515f
Cbud_s2_183 PBias x2_x2_net5 6.75515f
Cbud_s2_184 PBias x2_x2_net6 6.75515f
Cbud_s2_185 PBias x2_x2_net7 6.75515f
Cbud_s2_186 PBias x2_x2_net8 3.35556f
Cbud_s2_187 PBias x2_x2_net9 4.24688f
Cbud_s2_188 PBias Vp 1.19379f
Cbud_s2_189 Rgm Vom 0.679501f
Cbud_s2_190 Rgm Vom1 0.855627f
Cbud_s2_191 Rgm Vop 0.679501f
Cbud_s2_192 Rgm Vop1 0.855627f
Cbud_s2_193 Rgm net1 18.6198f
Cbud_s2_194 Rgm net3 1.8284f
Cbud_s2_195 Rgm net5 1.8284f
Cbud_s2_196 Rgm x1_Vbias 1.8284f
Cbud_s2_197 Rgm x1_Vout 1.8284f
Cbud_s2_198 Rgm x1_Vtest2 0.282149f
Cbud_s2_199 Rgm x1_net1 0.282149f
Cbud_s2_200 Rgm x1_net2 1.8284f
Cbud_s2_201 Rgm x1_net3 1.75295f
Cbud_s2_202 Rgm x1_net5 1.75295f
Cbud_s2_203 Rgm x1_net6 1.75295f
Cbud_s2_204 Rgm x1_net7 1.73817f
Cbud_s2_205 Rgm x1_net8 1.73817f
Cbud_s2_206 Rgm x2_Vbiasp 1.8284f
Cbud_s2_207 Rgm x2_Vout 1.8284f
Cbud_s2_208 Rgm x2_Vtest 1.8284f
Cbud_s2_209 Rgm x2_x1_net1 1.208f
Cbud_s2_210 Rgm x2_x1_net10 1.60829f
Cbud_s2_211 Rgm x2_x1_net11 1.38674f
Cbud_s2_212 Rgm x2_x1_net12 1.8284f
Cbud_s2_213 Rgm x2_x1_net13 1.8284f
Cbud_s2_214 Rgm x2_x1_net14 1.8284f
Cbud_s2_215 Rgm x2_x1_net15 1.8284f
Cbud_s2_216 Rgm x2_x1_net16 1.8284f
Cbud_s2_217 Rgm x2_x1_net17 1.8284f
Cbud_s2_218 Rgm x2_x1_net18 1.8284f
Cbud_s2_219 Rgm x2_x1_net19 1.8284f
Cbud_s2_220 Rgm x2_x1_net2 1.8284f
Cbud_s2_221 Rgm x2_x1_net3 1.8284f
Cbud_s2_222 Rgm x2_x1_net4 0.75291f
Cbud_s2_223 Rgm x2_x1_net5 0.83889f
Cbud_s2_224 Rgm x2_x1_net6 0.940486f
Cbud_s2_225 Rgm x2_x1_net7 1.06172f
Cbud_s2_226 Rgm x2_x1_net8 1.8284f
Cbud_s2_227 Rgm x2_x1_net9 1.8284f
Cbud_s2_228 Rgm x2_x2_net1 1.8284f
Cbud_s2_229 Rgm x2_x2_net10 1.8284f
Cbud_s2_230 Rgm x2_x2_net11 1.8284f
Cbud_s2_231 Rgm x2_x2_net12 1.8284f
Cbud_s2_232 Rgm x2_x2_net13 1.8284f
Cbud_s2_233 Rgm x2_x2_net14 1.60829f
Cbud_s2_234 Rgm x2_x2_net15 1.38674f
Cbud_s2_235 Rgm x2_x2_net16 0.75291f
Cbud_s2_236 Rgm x2_x2_net17 0.83889f
Cbud_s2_237 Rgm x2_x2_net18 0.940486f
Cbud_s2_238 Rgm x2_x2_net19 1.06172f
Cbud_s2_239 Rgm x2_x2_net2 1.8284f
Cbud_s2_240 Rgm x2_x2_net3 1.208f
Cbud_s2_241 Rgm x2_x2_net4 1.8284f
Cbud_s2_242 Rgm x2_x2_net5 1.8284f
Cbud_s2_243 Rgm x2_x2_net6 1.8284f
Cbud_s2_244 Rgm x2_x2_net7 1.8284f
Cbud_s2_245 Rgm x2_x2_net8 1.8284f
Cbud_s2_246 Rgm x2_x2_net9 1.8284f
Cbud_s2_247 Vom Vom1 5.32462f
Cbud_s2_248 Vom Vop 2.04098f
Cbud_s2_249 Vom Vop1 3.42236f
Cbud_s2_250 Vom net1 0.926207f
Cbud_s2_251 Vom net2 0.717288f
Cbud_s2_252 Vom net3 0.853412f
Cbud_s2_253 Vom net4 1.69496f
Cbud_s2_254 Vom net5 0.765056f
Cbud_s2_255 Vom net6 0.679501f
Cbud_s2_256 Vom net7 0.679501f
Cbud_s2_257 Vom x1_Vbias 0.788342f
Cbud_s2_258 Vom x1_Vout 1.39899f
Cbud_s2_259 Vom x1_Vtest2 0.565278f
Cbud_s2_260 Vom x1_net1 1.587f
Cbud_s2_261 Vom x1_net2 0.679501f
Cbud_s2_262 Vom x1_net3 0.679501f
Cbud_s2_263 Vom x1_net4 0.679501f
Cbud_s2_264 Vom x1_net5 0.270506f
Cbud_s2_265 Vom x1_net6 0.759437f
Cbud_s2_266 Vom x1_net7 6.82495f
Cbud_s2_267 Vom x1_net8 1.05319f
Cbud_s2_268 Vom x1_net9 1.32587f
Cbud_s2_269 Vom x2_Vbiasp 0.679501f
Cbud_s2_270 Vom x2_Vcm 1.23099f
Cbud_s2_271 Vom x2_Vout 1.73498f
Cbud_s2_272 Vom x2_Vtest 1.03502f
Cbud_s2_273 Vom x2_net1 0.679569f
Cbud_s2_274 Vom x2_x1_net1 1.04242f
Cbud_s2_275 Vom x2_x1_net10 1.04242f
Cbud_s2_276 Vom x2_x1_net11 1.04242f
Cbud_s2_277 Vom x2_x1_net12 1.04242f
Cbud_s2_278 Vom x2_x1_net13 1.04242f
Cbud_s2_279 Vom x2_x1_net14 1.04242f
Cbud_s2_280 Vom x2_x1_net15 1.04242f
Cbud_s2_281 Vom x2_x1_net16 1.04242f
Cbud_s2_282 Vom x2_x1_net17 1.04242f
Cbud_s2_283 Vom x2_x1_net18 1.04242f
Cbud_s2_284 Vom x2_x1_net19 1.04242f
Cbud_s2_285 Vom x2_x1_net2 1.04242f
Cbud_s2_286 Vom x2_x1_net3 1.04242f
Cbud_s2_287 Vom x2_x1_net4 1.04242f
Cbud_s2_288 Vom x2_x1_net5 1.04242f
Cbud_s2_289 Vom x2_x1_net6 1.04242f
Cbud_s2_290 Vom x2_x1_net7 1.04242f
Cbud_s2_291 Vom x2_x1_net8 1.04242f
Cbud_s2_292 Vom x2_x1_net9 1.04242f
Cbud_s2_293 Vom x2_x2_net1 1.208f
Cbud_s2_294 Vom x2_x2_net10 1.60829f
Cbud_s2_295 Vom x2_x2_net11 1.38674f
Cbud_s2_296 Vom x2_x2_net12 3.35556f
Cbud_s2_297 Vom x2_x2_net13 4.24688f
Cbud_s2_298 Vom x2_x2_net14 5.54695f
Cbud_s2_299 Vom x2_x2_net15 6.75515f
Cbud_s2_300 Vom x2_x2_net16 6.75515f
Cbud_s2_301 Vom x2_x2_net17 6.75515f
Cbud_s2_302 Vom x2_x2_net18 6.75515f
Cbud_s2_303 Vom x2_x2_net19 6.75515f
Cbud_s2_304 Vom x2_x2_net2 2.718f
Cbud_s2_305 Vom x2_x2_net3 6.75515f
Cbud_s2_306 Vom x2_x2_net4 1.04242f
Cbud_s2_307 Vom x2_x2_net5 1.04242f
Cbud_s2_308 Vom x2_x2_net6 1.04242f
Cbud_s2_309 Vom x2_x2_net7 1.06172f
Cbud_s2_310 Vom x2_x2_net8 2.24628f
Cbud_s2_311 Vom x2_x2_net9 1.8875f
Cbud_s2_312 Vom Vm 0.571088f
Cbud_s2_313 Vom Vp 0.664585f
Cbud_s2_314 Vom1 Vop 3.42236f
Cbud_s2_315 Vom1 Vop1 1.89659f
Cbud_s2_316 Vom1 net1 0.926207f
Cbud_s2_317 Vom1 net2 0.855627f
Cbud_s2_318 Vom1 net3 0.855627f
Cbud_s2_319 Vom1 net4 1.69496f
Cbud_s2_320 Vom1 net5 0.936901f
Cbud_s2_321 Vom1 net6 0.855627f
Cbud_s2_322 Vom1 net7 0.855627f
Cbud_s2_323 Vom1 x1_Vbias 1.31363f
Cbud_s2_324 Vom1 x1_Vout 1.39899f
Cbud_s2_325 Vom1 x1_Vtest2 0.565278f
Cbud_s2_326 Vom1 x1_net1 0.607498f
Cbud_s2_327 Vom1 x1_net2 0.855627f
Cbud_s2_328 Vom1 x1_net3 0.855627f
Cbud_s2_329 Vom1 x1_net4 0.855627f
Cbud_s2_330 Vom1 x1_net5 0.430794f
Cbud_s2_331 Vom1 x1_net6 2.35275f
Cbud_s2_332 Vom1 x1_net7 5.35001f
Cbud_s2_333 Vom1 x1_net8 1.05319f
Cbud_s2_334 Vom1 x1_net9 2.68616f
Cbud_s2_335 Vom1 x2_Vbiasp 0.855627f
Cbud_s2_336 Vom1 x2_Vcm 1.23099f
Cbud_s2_337 Vom1 x2_Vout 0.961679f
Cbud_s2_338 Vom1 x2_Vtest 1.03502f
Cbud_s2_339 Vom1 x2_net1 0.855556f
Cbud_s2_340 Vom1 x2_x1_net1 1.04242f
Cbud_s2_341 Vom1 x2_x1_net10 1.04242f
Cbud_s2_342 Vom1 x2_x1_net11 1.04242f
Cbud_s2_343 Vom1 x2_x1_net12 1.04242f
Cbud_s2_344 Vom1 x2_x1_net13 1.04242f
Cbud_s2_345 Vom1 x2_x1_net14 1.04242f
Cbud_s2_346 Vom1 x2_x1_net15 1.04242f
Cbud_s2_347 Vom1 x2_x1_net16 1.04242f
Cbud_s2_348 Vom1 x2_x1_net17 1.04242f
Cbud_s2_349 Vom1 x2_x1_net18 1.04242f
Cbud_s2_350 Vom1 x2_x1_net19 1.04242f
Cbud_s2_351 Vom1 x2_x1_net2 1.04242f
Cbud_s2_352 Vom1 x2_x1_net3 1.04242f
Cbud_s2_353 Vom1 x2_x1_net4 1.04242f
Cbud_s2_354 Vom1 x2_x1_net5 1.04242f
Cbud_s2_355 Vom1 x2_x1_net6 1.04242f
Cbud_s2_356 Vom1 x2_x1_net7 1.04242f
Cbud_s2_357 Vom1 x2_x1_net8 1.04242f
Cbud_s2_358 Vom1 x2_x1_net9 1.04242f
Cbud_s2_359 Vom1 x2_x2_net1 2.92655f
Cbud_s2_360 Vom1 x2_x2_net10 2.92655f
Cbud_s2_361 Vom1 x2_x2_net11 2.92655f
Cbud_s2_362 Vom1 x2_x2_net12 2.92655f
Cbud_s2_363 Vom1 x2_x2_net13 2.92655f
Cbud_s2_364 Vom1 x2_x2_net14 2.92655f
Cbud_s2_365 Vom1 x2_x2_net15 2.92655f
Cbud_s2_366 Vom1 x2_x2_net16 2.92655f
Cbud_s2_367 Vom1 x2_x2_net17 2.92655f
Cbud_s2_368 Vom1 x2_x2_net18 2.92655f
Cbud_s2_369 Vom1 x2_x2_net19 2.92655f
Cbud_s2_370 Vom1 x2_x2_net2 2.92655f
Cbud_s2_371 Vom1 x2_x2_net3 2.92655f
Cbud_s2_372 Vom1 x2_x2_net4 1.04242f
Cbud_s2_373 Vom1 x2_x2_net5 2.92655f
Cbud_s2_374 Vom1 x2_x2_net6 2.92655f
Cbud_s2_375 Vom1 x2_x2_net7 2.92655f
Cbud_s2_376 Vom1 x2_x2_net8 2.92655f
Cbud_s2_377 Vom1 x2_x2_net9 2.92655f
Cbud_s2_378 Vom1 Vm 0.56846f
Cbud_s2_379 Vom1 Vp 0.517187f
Cbud_s2_380 Vop Vop1 5.32462f
Cbud_s2_381 Vop net1 0.926207f
Cbud_s2_382 Vop net2 0.717288f
Cbud_s2_383 Vop net3 0.853412f
Cbud_s2_384 Vop net4 1.69496f
Cbud_s2_385 Vop net5 0.765056f
Cbud_s2_386 Vop net6 0.679501f
Cbud_s2_387 Vop net7 0.679501f
Cbud_s2_388 Vop x1_Vbias 0.788342f
Cbud_s2_389 Vop x1_Vout 1.39899f
Cbud_s2_390 Vop x1_Vtest2 1.587f
Cbud_s2_391 Vop x1_net1 0.565278f
Cbud_s2_392 Vop x1_net2 0.679501f
Cbud_s2_393 Vop x1_net3 0.679501f
Cbud_s2_394 Vop x1_net4 0.679501f
Cbud_s2_395 Vop x1_net5 0.759437f
Cbud_s2_396 Vop x1_net6 0.270506f
Cbud_s2_397 Vop x1_net7 1.05319f
Cbud_s2_398 Vop x1_net8 6.82495f
Cbud_s2_399 Vop x1_net9 1.32587f
Cbud_s2_400 Vop x2_Vbiasp 0.679501f
Cbud_s2_401 Vop x2_Vcm 1.23099f
Cbud_s2_402 Vop x2_Vout 1.73498f
Cbud_s2_403 Vop x2_Vtest 1.03502f
Cbud_s2_404 Vop x2_net1 0.679569f
Cbud_s2_405 Vop x2_x1_net1 6.75515f
Cbud_s2_406 Vop x2_x1_net10 5.54695f
Cbud_s2_407 Vop x2_x1_net11 6.75515f
Cbud_s2_408 Vop x2_x1_net12 2.24628f
Cbud_s2_409 Vop x2_x1_net13 1.8875f
Cbud_s2_410 Vop x2_x1_net14 1.60829f
Cbud_s2_411 Vop x2_x1_net15 1.38674f
Cbud_s2_412 Vop x2_x1_net16 1.04242f
Cbud_s2_413 Vop x2_x1_net17 1.04242f
Cbud_s2_414 Vop x2_x1_net18 1.04242f
Cbud_s2_415 Vop x2_x1_net19 1.06172f
Cbud_s2_416 Vop x2_x1_net2 2.718f
Cbud_s2_417 Vop x2_x1_net3 1.208f
Cbud_s2_418 Vop x2_x1_net4 6.75515f
Cbud_s2_419 Vop x2_x1_net5 6.75515f
Cbud_s2_420 Vop x2_x1_net6 6.75515f
Cbud_s2_421 Vop x2_x1_net7 6.75515f
Cbud_s2_422 Vop x2_x1_net8 3.35556f
Cbud_s2_423 Vop x2_x1_net9 4.24688f
Cbud_s2_424 Vop x2_x2_net1 1.04242f
Cbud_s2_425 Vop x2_x2_net10 1.04242f
Cbud_s2_426 Vop x2_x2_net11 1.04242f
Cbud_s2_427 Vop x2_x2_net12 1.04242f
Cbud_s2_428 Vop x2_x2_net13 1.04242f
Cbud_s2_429 Vop x2_x2_net14 1.04242f
Cbud_s2_430 Vop x2_x2_net15 1.04242f
Cbud_s2_431 Vop x2_x2_net16 1.04242f
Cbud_s2_432 Vop x2_x2_net17 1.04242f
Cbud_s2_433 Vop x2_x2_net18 1.04242f
Cbud_s2_434 Vop x2_x2_net19 1.04242f
Cbud_s2_435 Vop x2_x2_net2 1.04242f
Cbud_s2_436 Vop x2_x2_net3 1.04242f
Cbud_s2_437 Vop x2_x2_net4 1.04242f
Cbud_s2_438 Vop x2_x2_net5 1.04242f
Cbud_s2_439 Vop x2_x2_net6 1.04242f
Cbud_s2_440 Vop x2_x2_net7 1.04242f
Cbud_s2_441 Vop x2_x2_net8 1.04242f
Cbud_s2_442 Vop x2_x2_net9 1.04242f
Cbud_s2_443 Vop Vm 0.664585f
Cbud_s2_444 Vop Vp 0.571088f
Cbud_s2_445 Vop1 net1 0.926207f
Cbud_s2_446 Vop1 net2 0.855627f
Cbud_s2_447 Vop1 net3 0.855627f
Cbud_s2_448 Vop1 net4 1.69496f
Cbud_s2_449 Vop1 net5 0.936901f
Cbud_s2_450 Vop1 net6 0.855627f
Cbud_s2_451 Vop1 net7 0.855627f
Cbud_s2_452 Vop1 x1_Vbias 1.31363f
Cbud_s2_453 Vop1 x1_Vout 1.39899f
Cbud_s2_454 Vop1 x1_Vtest2 0.607498f
Cbud_s2_455 Vop1 x1_net1 0.565278f
Cbud_s2_456 Vop1 x1_net2 0.855627f
Cbud_s2_457 Vop1 x1_net3 0.855627f
Cbud_s2_458 Vop1 x1_net4 0.855627f
Cbud_s2_459 Vop1 x1_net5 2.35275f
Cbud_s2_460 Vop1 x1_net6 0.430794f
Cbud_s2_461 Vop1 x1_net7 1.05319f
Cbud_s2_462 Vop1 x1_net8 5.35001f
Cbud_s2_463 Vop1 x1_net9 2.68616f
Cbud_s2_464 Vop1 x2_Vbiasp 0.855627f
Cbud_s2_465 Vop1 x2_Vcm 1.23099f
Cbud_s2_466 Vop1 x2_Vout 0.961679f
Cbud_s2_467 Vop1 x2_Vtest 1.03502f
Cbud_s2_468 Vop1 x2_net1 0.855556f
Cbud_s2_469 Vop1 x2_x1_net1 2.92655f
Cbud_s2_470 Vop1 x2_x1_net10 2.92655f
Cbud_s2_471 Vop1 x2_x1_net11 2.92655f
Cbud_s2_472 Vop1 x2_x1_net12 2.92655f
Cbud_s2_473 Vop1 x2_x1_net13 2.92655f
Cbud_s2_474 Vop1 x2_x1_net14 2.92655f
Cbud_s2_475 Vop1 x2_x1_net15 2.92655f
Cbud_s2_476 Vop1 x2_x1_net16 1.04242f
Cbud_s2_477 Vop1 x2_x1_net17 2.92655f
Cbud_s2_478 Vop1 x2_x1_net18 2.92655f
Cbud_s2_479 Vop1 x2_x1_net19 2.92655f
Cbud_s2_480 Vop1 x2_x1_net2 2.92655f
Cbud_s2_481 Vop1 x2_x1_net3 2.92655f
Cbud_s2_482 Vop1 x2_x1_net4 2.92655f
Cbud_s2_483 Vop1 x2_x1_net5 2.92655f
Cbud_s2_484 Vop1 x2_x1_net6 2.92655f
Cbud_s2_485 Vop1 x2_x1_net7 2.92655f
Cbud_s2_486 Vop1 x2_x1_net8 2.92655f
Cbud_s2_487 Vop1 x2_x1_net9 2.92655f
Cbud_s2_488 Vop1 x2_x2_net1 1.04242f
Cbud_s2_489 Vop1 x2_x2_net10 1.04242f
Cbud_s2_490 Vop1 x2_x2_net11 1.04242f
Cbud_s2_491 Vop1 x2_x2_net12 1.04242f
Cbud_s2_492 Vop1 x2_x2_net13 1.04242f
Cbud_s2_493 Vop1 x2_x2_net14 1.04242f
Cbud_s2_494 Vop1 x2_x2_net15 1.04242f
Cbud_s2_495 Vop1 x2_x2_net16 1.04242f
Cbud_s2_496 Vop1 x2_x2_net17 1.04242f
Cbud_s2_497 Vop1 x2_x2_net18 1.04242f
Cbud_s2_498 Vop1 x2_x2_net19 1.04242f
Cbud_s2_499 Vop1 x2_x2_net2 1.04242f
Cbud_s2_500 Vop1 x2_x2_net3 1.04242f
Cbud_s2_501 Vop1 x2_x2_net4 1.04242f
Cbud_s2_502 Vop1 x2_x2_net5 1.04242f
Cbud_s2_503 Vop1 x2_x2_net6 1.04242f
Cbud_s2_504 Vop1 x2_x2_net7 1.04242f
Cbud_s2_505 Vop1 x2_x2_net8 1.04242f
Cbud_s2_506 Vop1 x2_x2_net9 1.04242f
Cbud_s2_507 Vop1 Vm 0.517187f
Cbud_s2_508 Vop1 Vp 0.56846f
Cbud_s2_509 net1 net4 6.00207f
Cbud_s2_510 net1 net5 4.95777f
Cbud_s2_511 net1 net6 2.65975f
Cbud_s2_512 net1 net7 2.65975f
Cbud_s2_513 net1 x1_Vbias 5.10867f
Cbud_s2_514 net1 x1_Vtest2 0.565278f
Cbud_s2_515 net1 x1_net1 0.565278f
Cbud_s2_516 net1 x1_net3 1.75295f
Cbud_s2_517 net1 x1_net4 1.75295f
Cbud_s2_518 net1 x1_net5 1.75295f
Cbud_s2_519 net1 x1_net6 1.75295f
Cbud_s2_520 net1 x1_net7 1.73817f
Cbud_s2_521 net1 x1_net8 1.73817f
Cbud_s2_522 net1 x1_net9 6.00207f
Cbud_s2_523 net1 x2_Vout 6.00207f
Cbud_s2_524 net1 x2_Vtest 6.00207f
Cbud_s2_525 net1 x2_net1 3.31341f
Cbud_s2_526 net1 x2_x1_net1 1.208f
Cbud_s2_527 net1 x2_x1_net10 1.60829f
Cbud_s2_528 net1 x2_x1_net11 1.38674f
Cbud_s2_529 net1 x2_x1_net12 3.35556f
Cbud_s2_530 net1 x2_x1_net13 4.24688f
Cbud_s2_531 net1 x2_x1_net14 5.54695f
Cbud_s2_532 net1 x2_x1_net15 6.00207f
Cbud_s2_533 net1 x2_x1_net16 6.00207f
Cbud_s2_534 net1 x2_x1_net17 6.00207f
Cbud_s2_535 net1 x2_x1_net18 6.00207f
Cbud_s2_536 net1 x2_x1_net19 6.00207f
Cbud_s2_537 net1 x2_x1_net2 2.71801f
Cbud_s2_538 net1 x2_x1_net3 6.00207f
Cbud_s2_539 net1 x2_x1_net4 0.926207f
Cbud_s2_540 net1 x2_x1_net5 0.926207f
Cbud_s2_541 net1 x2_x1_net6 0.940487f
Cbud_s2_542 net1 x2_x1_net7 1.06172f
Cbud_s2_543 net1 x2_x1_net8 2.24629f
Cbud_s2_544 net1 x2_x1_net9 1.8875f
Cbud_s2_545 net1 x2_x2_net1 6.00207f
Cbud_s2_546 net1 x2_x2_net10 5.54695f
Cbud_s2_547 net1 x2_x2_net11 6.00207f
Cbud_s2_548 net1 x2_x2_net12 2.24629f
Cbud_s2_549 net1 x2_x2_net13 1.8875f
Cbud_s2_550 net1 x2_x2_net14 1.60829f
Cbud_s2_551 net1 x2_x2_net15 1.38674f
Cbud_s2_552 net1 x2_x2_net16 0.926207f
Cbud_s2_553 net1 x2_x2_net17 0.926207f
Cbud_s2_554 net1 x2_x2_net18 0.940487f
Cbud_s2_555 net1 x2_x2_net19 1.06172f
Cbud_s2_556 net1 x2_x2_net2 2.71801f
Cbud_s2_557 net1 x2_x2_net3 1.208f
Cbud_s2_558 net1 x2_x2_net4 6.00207f
Cbud_s2_559 net1 x2_x2_net5 6.00207f
Cbud_s2_560 net1 x2_x2_net6 6.00207f
Cbud_s2_561 net1 x2_x2_net7 6.00207f
Cbud_s2_562 net1 x2_x2_net8 3.35556f
Cbud_s2_563 net1 x2_x2_net9 4.24688f
Cbud_s2_564 net1 Vm 1.19379f
Cbud_s2_565 net1 Vp 1.19379f
Cbud_s2_566 net2 net3 4.64822f
Cbud_s2_567 net2 net4 4.64822f
Cbud_s2_568 net2 x1_Vout 4.64822f
Cbud_s2_569 net2 x1_Vtest2 0.565278f
Cbud_s2_570 net2 x1_net1 0.565278f
Cbud_s2_571 net2 x1_net2 3.50591f
Cbud_s2_572 net2 x1_net4 1.75295f
Cbud_s2_573 net2 x1_net5 1.75295f
Cbud_s2_574 net2 x1_net6 1.75295f
Cbud_s2_575 net2 x1_net7 1.73817f
Cbud_s2_576 net2 x1_net8 1.73817f
Cbud_s2_577 net2 x1_net9 4.64822f
Cbud_s2_578 net2 x2_Vcm 4.64822f
Cbud_s2_579 net2 x2_Vtest 4.64822f
Cbud_s2_580 net2 x2_x1_net1 1.208f
Cbud_s2_581 net2 x2_x1_net10 1.60829f
Cbud_s2_582 net2 x2_x1_net11 1.38674f
Cbud_s2_583 net2 x2_x1_net12 3.35556f
Cbud_s2_584 net2 x2_x1_net13 4.24688f
Cbud_s2_585 net2 x2_x1_net14 4.64822f
Cbud_s2_586 net2 x2_x1_net15 4.64822f
Cbud_s2_587 net2 x2_x1_net16 4.64822f
Cbud_s2_588 net2 x2_x1_net17 4.64822f
Cbud_s2_589 net2 x2_x1_net18 4.64822f
Cbud_s2_590 net2 x2_x1_net19 4.64822f
Cbud_s2_591 net2 x2_x1_net2 2.718f
Cbud_s2_592 net2 x2_x1_net3 4.64822f
Cbud_s2_593 net2 x2_x1_net4 0.75291f
Cbud_s2_594 net2 x2_x1_net5 0.83889f
Cbud_s2_595 net2 x2_x1_net6 0.940486f
Cbud_s2_596 net2 x2_x1_net7 1.06172f
Cbud_s2_597 net2 x2_x1_net8 2.24628f
Cbud_s2_598 net2 x2_x1_net9 1.8875f
Cbud_s2_599 net2 x2_x2_net1 4.64822f
Cbud_s2_600 net2 x2_x2_net10 4.64822f
Cbud_s2_601 net2 x2_x2_net11 4.64822f
Cbud_s2_602 net2 x2_x2_net12 2.24628f
Cbud_s2_603 net2 x2_x2_net13 1.8875f
Cbud_s2_604 net2 x2_x2_net14 1.60829f
Cbud_s2_605 net2 x2_x2_net15 1.38674f
Cbud_s2_606 net2 x2_x2_net16 0.75291f
Cbud_s2_607 net2 x2_x2_net17 0.83889f
Cbud_s2_608 net2 x2_x2_net18 0.940486f
Cbud_s2_609 net2 x2_x2_net19 1.06172f
Cbud_s2_610 net2 x2_x2_net2 2.718f
Cbud_s2_611 net2 x2_x2_net3 1.208f
Cbud_s2_612 net2 x2_x2_net4 4.64822f
Cbud_s2_613 net2 x2_x2_net5 4.64822f
Cbud_s2_614 net2 x2_x2_net6 4.64822f
Cbud_s2_615 net2 x2_x2_net7 4.64822f
Cbud_s2_616 net2 x2_x2_net8 3.35556f
Cbud_s2_617 net2 x2_x2_net9 4.24688f
Cbud_s2_618 net2 Vm 1.19379f
Cbud_s2_619 net2 Vp 1.19379f
Cbud_s2_620 net3 net4 5.53033f
Cbud_s2_621 net3 net5 4.95777f
Cbud_s2_622 net3 net6 2.65975f
Cbud_s2_623 net3 x1_Vtest2 0.565278f
Cbud_s2_624 net3 x1_net1 0.565278f
Cbud_s2_625 net3 x1_net2 3.50591f
Cbud_s2_626 net3 x1_net3 1.75295f
Cbud_s2_627 net3 x1_net5 1.75295f
Cbud_s2_628 net3 x1_net6 1.75295f
Cbud_s2_629 net3 x1_net7 1.73817f
Cbud_s2_630 net3 x1_net8 1.73817f
Cbud_s2_631 net3 x1_net9 5.53033f
Cbud_s2_632 net3 x2_Vout 5.53033f
Cbud_s2_633 net3 x2_Vtest 5.53033f
Cbud_s2_634 net3 x2_net1 3.31341f
Cbud_s2_635 net3 x2_x1_net1 1.20801f
Cbud_s2_636 net3 x2_x1_net10 1.60829f
Cbud_s2_637 net3 x2_x1_net11 1.38674f
Cbud_s2_638 net3 x2_x1_net12 3.35557f
Cbud_s2_639 net3 x2_x1_net13 4.2469f
Cbud_s2_640 net3 x2_x1_net14 5.53033f
Cbud_s2_641 net3 x2_x1_net15 5.53033f
Cbud_s2_642 net3 x2_x1_net16 5.53033f
Cbud_s2_643 net3 x2_x1_net17 5.53033f
Cbud_s2_644 net3 x2_x1_net18 5.53033f
Cbud_s2_645 net3 x2_x1_net19 5.53033f
Cbud_s2_646 net3 x2_x1_net2 2.71801f
Cbud_s2_647 net3 x2_x1_net3 5.53033f
Cbud_s2_648 net3 x2_x1_net4 0.853412f
Cbud_s2_649 net3 x2_x1_net5 0.853412f
Cbud_s2_650 net3 x2_x1_net6 0.940489f
Cbud_s2_651 net3 x2_x1_net7 1.06172f
Cbud_s2_652 net3 x2_x1_net8 2.24629f
Cbud_s2_653 net3 x2_x1_net9 1.88751f
Cbud_s2_654 net3 x2_x2_net1 5.53033f
Cbud_s2_655 net3 x2_x2_net10 5.53033f
Cbud_s2_656 net3 x2_x2_net11 5.53033f
Cbud_s2_657 net3 x2_x2_net12 2.24629f
Cbud_s2_658 net3 x2_x2_net13 1.88751f
Cbud_s2_659 net3 x2_x2_net14 1.60829f
Cbud_s2_660 net3 x2_x2_net15 1.38674f
Cbud_s2_661 net3 x2_x2_net16 0.853412f
Cbud_s2_662 net3 x2_x2_net17 0.853412f
Cbud_s2_663 net3 x2_x2_net18 0.940489f
Cbud_s2_664 net3 x2_x2_net19 1.06172f
Cbud_s2_665 net3 x2_x2_net2 2.71801f
Cbud_s2_666 net3 x2_x2_net3 1.20801f
Cbud_s2_667 net3 x2_x2_net4 5.53033f
Cbud_s2_668 net3 x2_x2_net5 5.53033f
Cbud_s2_669 net3 x2_x2_net6 5.53033f
Cbud_s2_670 net3 x2_x2_net7 5.53033f
Cbud_s2_671 net3 x2_x2_net8 3.35557f
Cbud_s2_672 net3 x2_x2_net9 4.2469f
Cbud_s2_673 net4 net6 2.65975f
Cbud_s2_674 net4 x1_Vbias 5.10867f
Cbud_s2_675 net4 x1_Vtest2 0.565278f
Cbud_s2_676 net4 x1_net1 0.565278f
Cbud_s2_677 net4 x1_net2 3.50591f
Cbud_s2_678 net4 x1_net3 3.54835f
Cbud_s2_679 net4 x1_net4 3.54835f
Cbud_s2_680 net4 x1_net5 3.54835f
Cbud_s2_681 net4 x1_net6 3.54835f
Cbud_s2_682 net4 x1_net7 1.73817f
Cbud_s2_683 net4 x1_net8 1.73817f
Cbud_s2_684 net4 x1_net9 8.59201f
Cbud_s2_685 net4 x2_Vcm 7.97714f
Cbud_s2_686 net4 x2_Vout 6.23194f
Cbud_s2_687 net4 x2_Vtest 6.7072f
Cbud_s2_688 net4 x2_net1 3.31341f
Cbud_s2_689 net4 x2_x1_net1 1.208f
Cbud_s2_690 net4 x2_x1_net10 1.60829f
Cbud_s2_691 net4 x2_x1_net11 1.38674f
Cbud_s2_692 net4 x2_x1_net12 3.35556f
Cbud_s2_693 net4 x2_x1_net13 4.24688f
Cbud_s2_694 net4 x2_x1_net14 5.54695f
Cbud_s2_695 net4 x2_x1_net15 6.75515f
Cbud_s2_696 net4 x2_x1_net16 6.75515f
Cbud_s2_697 net4 x2_x1_net17 6.75515f
Cbud_s2_698 net4 x2_x1_net18 6.75515f
Cbud_s2_699 net4 x2_x1_net19 6.75515f
Cbud_s2_700 net4 x2_x1_net2 2.718f
Cbud_s2_701 net4 x2_x1_net3 6.75515f
Cbud_s2_702 net4 x2_x1_net4 1.04242f
Cbud_s2_703 net4 x2_x1_net5 1.04242f
Cbud_s2_704 net4 x2_x1_net6 1.04242f
Cbud_s2_705 net4 x2_x1_net7 1.06172f
Cbud_s2_706 net4 x2_x1_net8 2.24628f
Cbud_s2_707 net4 x2_x1_net9 1.8875f
Cbud_s2_708 net4 x2_x2_net1 6.75515f
Cbud_s2_709 net4 x2_x2_net10 5.54695f
Cbud_s2_710 net4 x2_x2_net11 6.75515f
Cbud_s2_711 net4 x2_x2_net12 2.24628f
Cbud_s2_712 net4 x2_x2_net13 1.8875f
Cbud_s2_713 net4 x2_x2_net14 1.60829f
Cbud_s2_714 net4 x2_x2_net15 1.38674f
Cbud_s2_715 net4 x2_x2_net16 1.04242f
Cbud_s2_716 net4 x2_x2_net17 1.04242f
Cbud_s2_717 net4 x2_x2_net18 1.04242f
Cbud_s2_718 net4 x2_x2_net19 1.06172f
Cbud_s2_719 net4 x2_x2_net2 2.718f
Cbud_s2_720 net4 x2_x2_net3 1.208f
Cbud_s2_721 net4 x2_x2_net4 6.75515f
Cbud_s2_722 net4 x2_x2_net5 6.75515f
Cbud_s2_723 net4 x2_x2_net6 6.75515f
Cbud_s2_724 net4 x2_x2_net7 6.75515f
Cbud_s2_725 net4 x2_x2_net8 3.35556f
Cbud_s2_726 net4 x2_x2_net9 4.24688f
Cbud_s2_727 net4 Vm 1.19379f
Cbud_s2_728 net4 Vp 1.19379f
Cbud_s2_729 net5 x1_Vbias 4.95777f
Cbud_s2_730 net5 x1_Vout 4.95777f
Cbud_s2_731 net5 x1_Vtest2 0.565278f
Cbud_s2_732 net5 x1_net1 0.565278f
Cbud_s2_733 net5 x1_net5 2.86655f
Cbud_s2_734 net5 x1_net6 2.86655f
Cbud_s2_735 net5 x1_net7 1.73817f
Cbud_s2_736 net5 x1_net8 1.73817f
Cbud_s2_737 net5 x2_Vbiasp 3.95719f
Cbud_s2_738 net5 x2_Vcm 4.95777f
Cbud_s2_739 net5 x2_Vout 4.95777f
Cbud_s2_740 net5 x2_Vtest 4.95777f
Cbud_s2_741 net5 x2_x1_net1 1.208f
Cbud_s2_742 net5 x2_x1_net10 1.60829f
Cbud_s2_743 net5 x2_x1_net11 1.38674f
Cbud_s2_744 net5 x2_x1_net12 3.35556f
Cbud_s2_745 net5 x2_x1_net13 4.24689f
Cbud_s2_746 net5 x2_x1_net14 4.95777f
Cbud_s2_747 net5 x2_x1_net15 4.95777f
Cbud_s2_748 net5 x2_x1_net16 4.95777f
Cbud_s2_749 net5 x2_x1_net17 4.95777f
Cbud_s2_750 net5 x2_x1_net18 4.95777f
Cbud_s2_751 net5 x2_x1_net19 4.95777f
Cbud_s2_752 net5 x2_x1_net2 2.71801f
Cbud_s2_753 net5 x2_x1_net3 4.95777f
Cbud_s2_754 net5 x2_x1_net4 0.765056f
Cbud_s2_755 net5 x2_x1_net5 0.838891f
Cbud_s2_756 net5 x2_x1_net6 0.940487f
Cbud_s2_757 net5 x2_x1_net7 1.06172f
Cbud_s2_758 net5 x2_x1_net8 2.24629f
Cbud_s2_759 net5 x2_x1_net9 1.8875f
Cbud_s2_760 net5 x2_x2_net1 4.95777f
Cbud_s2_761 net5 x2_x2_net10 4.95777f
Cbud_s2_762 net5 x2_x2_net11 4.95777f
Cbud_s2_763 net5 x2_x2_net12 2.24629f
Cbud_s2_764 net5 x2_x2_net13 1.8875f
Cbud_s2_765 net5 x2_x2_net14 1.60829f
Cbud_s2_766 net5 x2_x2_net15 1.38674f
Cbud_s2_767 net5 x2_x2_net16 0.765056f
Cbud_s2_768 net5 x2_x2_net17 0.838891f
Cbud_s2_769 net5 x2_x2_net18 0.940487f
Cbud_s2_770 net5 x2_x2_net19 1.06172f
Cbud_s2_771 net5 x2_x2_net2 2.71801f
Cbud_s2_772 net5 x2_x2_net3 1.208f
Cbud_s2_773 net5 x2_x2_net4 4.95777f
Cbud_s2_774 net5 x2_x2_net5 4.95777f
Cbud_s2_775 net5 x2_x2_net6 4.95777f
Cbud_s2_776 net5 x2_x2_net7 4.95777f
Cbud_s2_777 net5 x2_x2_net8 3.35556f
Cbud_s2_778 net5 x2_x2_net9 4.24689f
Cbud_s2_779 net5 Vm 1.19379f
Cbud_s2_780 net5 Vp 1.19379f
Cbud_s2_781 net6 net7 2.65975f
Cbud_s2_782 net6 x1_Vbias 3.33995f
Cbud_s2_783 net6 x1_Vout 2.65975f
Cbud_s2_784 net6 x1_Vtest2 0.410438f
Cbud_s2_785 net6 x1_net1 0.410438f
Cbud_s2_786 net6 x1_net2 2.65975f
Cbud_s2_787 net6 x1_net3 1.75295f
Cbud_s2_788 net6 x1_net4 1.75295f
Cbud_s2_789 net6 x1_net5 1.75295f
Cbud_s2_790 net6 x1_net6 1.75295f
Cbud_s2_791 net6 x1_net7 1.73817f
Cbud_s2_792 net6 x1_net8 1.73817f
Cbud_s2_793 net6 x1_net9 2.65975f
Cbud_s2_794 net6 x2_Vbiasp 2.65975f
Cbud_s2_795 net6 x2_Vcm 2.65975f
Cbud_s2_796 net6 x2_Vout 2.65975f
Cbud_s2_797 net6 x2_Vtest 2.65975f
Cbud_s2_798 net6 x2_net1 2.65975f
Cbud_s2_799 net6 x2_x1_net1 1.208f
Cbud_s2_800 net6 x2_x1_net10 1.60829f
Cbud_s2_801 net6 x2_x1_net11 1.38674f
Cbud_s2_802 net6 x2_x1_net12 2.65975f
Cbud_s2_803 net6 x2_x1_net13 2.65975f
Cbud_s2_804 net6 x2_x1_net14 2.65975f
Cbud_s2_805 net6 x2_x1_net15 2.65975f
Cbud_s2_806 net6 x2_x1_net16 2.65975f
Cbud_s2_807 net6 x2_x1_net17 2.65975f
Cbud_s2_808 net6 x2_x1_net18 2.65975f
Cbud_s2_809 net6 x2_x1_net19 2.65975f
Cbud_s2_810 net6 x2_x1_net2 2.65975f
Cbud_s2_811 net6 x2_x1_net3 2.65975f
Cbud_s2_812 net6 x2_x1_net4 0.75291f
Cbud_s2_813 net6 x2_x1_net5 0.83889f
Cbud_s2_814 net6 x2_x1_net6 0.940486f
Cbud_s2_815 net6 x2_x1_net7 1.06172f
Cbud_s2_816 net6 x2_x1_net8 2.24629f
Cbud_s2_817 net6 x2_x1_net9 1.8875f
Cbud_s2_818 net6 x2_x2_net1 2.65975f
Cbud_s2_819 net6 x2_x2_net10 2.65975f
Cbud_s2_820 net6 x2_x2_net11 2.65975f
Cbud_s2_821 net6 x2_x2_net12 2.24629f
Cbud_s2_822 net6 x2_x2_net13 1.8875f
Cbud_s2_823 net6 x2_x2_net14 1.60829f
Cbud_s2_824 net6 x2_x2_net15 1.38674f
Cbud_s2_825 net6 x2_x2_net16 0.75291f
Cbud_s2_826 net6 x2_x2_net17 0.83889f
Cbud_s2_827 net6 x2_x2_net18 0.940486f
Cbud_s2_828 net6 x2_x2_net19 1.06172f
Cbud_s2_829 net6 x2_x2_net2 2.65975f
Cbud_s2_830 net6 x2_x2_net3 1.208f
Cbud_s2_831 net6 x2_x2_net4 2.65975f
Cbud_s2_832 net6 x2_x2_net5 2.65975f
Cbud_s2_833 net6 x2_x2_net6 2.65975f
Cbud_s2_834 net6 x2_x2_net7 2.65975f
Cbud_s2_835 net6 x2_x2_net8 2.65975f
Cbud_s2_836 net6 x2_x2_net9 2.65975f
Cbud_s2_837 net6 Vm 1.19379f
Cbud_s2_838 net6 Vp 1.19379f
Cbud_s2_839 net7 x1_Vbias 2.65975f
Cbud_s2_840 net7 x1_Vtest2 0.410438f
Cbud_s2_841 net7 x1_net1 0.410438f
Cbud_s2_842 net7 x1_net2 2.65975f
Cbud_s2_843 net7 x1_net3 1.75295f
Cbud_s2_844 net7 x1_net4 1.75295f
Cbud_s2_845 net7 x1_net5 1.75295f
Cbud_s2_846 net7 x1_net6 1.75295f
Cbud_s2_847 net7 x1_net7 1.73817f
Cbud_s2_848 net7 x1_net8 1.73817f
Cbud_s2_849 net7 x2_Vbiasp 3.33995f
Cbud_s2_850 net7 x2_Vout 2.65975f
Cbud_s2_851 net7 x2_net1 2.65975f
Cbud_s2_852 net7 x2_x1_net1 1.208f
Cbud_s2_853 net7 x2_x1_net10 1.60829f
Cbud_s2_854 net7 x2_x1_net11 1.38674f
Cbud_s2_855 net7 x2_x1_net12 2.65975f
Cbud_s2_856 net7 x2_x1_net13 2.65975f
Cbud_s2_857 net7 x2_x1_net14 2.65975f
Cbud_s2_858 net7 x2_x1_net15 2.65975f
Cbud_s2_859 net7 x2_x1_net16 2.65975f
Cbud_s2_860 net7 x2_x1_net17 2.65975f
Cbud_s2_861 net7 x2_x1_net18 2.65975f
Cbud_s2_862 net7 x2_x1_net19 2.65975f
Cbud_s2_863 net7 x2_x1_net2 2.65975f
Cbud_s2_864 net7 x2_x1_net3 2.65975f
Cbud_s2_865 net7 x2_x1_net4 0.75291f
Cbud_s2_866 net7 x2_x1_net5 0.838891f
Cbud_s2_867 net7 x2_x1_net6 0.940486f
Cbud_s2_868 net7 x2_x1_net7 1.06172f
Cbud_s2_869 net7 x2_x1_net8 2.24629f
Cbud_s2_870 net7 x2_x1_net9 1.8875f
Cbud_s2_871 net7 x2_x2_net1 2.65975f
Cbud_s2_872 net7 x2_x2_net10 2.65975f
Cbud_s2_873 net7 x2_x2_net11 2.65975f
Cbud_s2_874 net7 x2_x2_net12 2.24629f
Cbud_s2_875 net7 x2_x2_net13 1.8875f
Cbud_s2_876 net7 x2_x2_net14 1.60829f
Cbud_s2_877 net7 x2_x2_net15 1.38674f
Cbud_s2_878 net7 x2_x2_net16 0.75291f
Cbud_s2_879 net7 x2_x2_net17 0.838891f
Cbud_s2_880 net7 x2_x2_net18 0.940486f
Cbud_s2_881 net7 x2_x2_net19 1.06172f
Cbud_s2_882 net7 x2_x2_net2 2.65975f
Cbud_s2_883 net7 x2_x2_net3 1.208f
Cbud_s2_884 net7 x2_x2_net4 2.65975f
Cbud_s2_885 net7 x2_x2_net5 2.65975f
Cbud_s2_886 net7 x2_x2_net6 2.65975f
Cbud_s2_887 net7 x2_x2_net7 2.65975f
Cbud_s2_888 net7 x2_x2_net8 2.65975f
Cbud_s2_889 net7 x2_x2_net9 2.65975f
Cbud_s2_890 x1_Vbias x1_Vtest2 1.09056f
Cbud_s2_891 x1_Vbias x1_net1 1.09056f
Cbud_s2_892 x1_Vbias x1_net2 3.50591f
Cbud_s2_893 x1_Vbias x1_net3 1.75295f
Cbud_s2_894 x1_Vbias x1_net5 1.75295f
Cbud_s2_895 x1_Vbias x1_net6 1.75295f
Cbud_s2_896 x1_Vbias x1_net7 1.73817f
Cbud_s2_897 x1_Vbias x1_net8 1.73817f
Cbud_s2_898 x1_Vbias x1_net9 5.10867f
Cbud_s2_899 x1_Vbias x2_Vcm 5.10867f
Cbud_s2_900 x1_Vbias x2_Vout 5.10867f
Cbud_s2_901 x1_Vbias x2_Vtest 5.10867f
Cbud_s2_902 x1_Vbias x2_net1 3.31341f
Cbud_s2_903 x1_Vbias x2_x1_net1 1.208f
Cbud_s2_904 x1_Vbias x2_x1_net10 1.60829f
Cbud_s2_905 x1_Vbias x2_x1_net11 1.38674f
Cbud_s2_906 x1_Vbias x2_x1_net12 3.35557f
Cbud_s2_907 x1_Vbias x2_x1_net13 4.24689f
Cbud_s2_908 x1_Vbias x2_x1_net14 5.10867f
Cbud_s2_909 x1_Vbias x2_x1_net15 5.10867f
Cbud_s2_910 x1_Vbias x2_x1_net16 5.10867f
Cbud_s2_911 x1_Vbias x2_x1_net17 5.10867f
Cbud_s2_912 x1_Vbias x2_x1_net18 5.10867f
Cbud_s2_913 x1_Vbias x2_x1_net19 5.10867f
Cbud_s2_914 x1_Vbias x2_x1_net2 2.71801f
Cbud_s2_915 x1_Vbias x2_x1_net3 5.10867f
Cbud_s2_916 x1_Vbias x2_x1_net4 0.788342f
Cbud_s2_917 x1_Vbias x2_x1_net5 0.838891f
Cbud_s2_918 x1_Vbias x2_x1_net6 0.940487f
Cbud_s2_919 x1_Vbias x2_x1_net7 1.06172f
Cbud_s2_920 x1_Vbias x2_x1_net8 2.24629f
Cbud_s2_921 x1_Vbias x2_x1_net9 1.88751f
Cbud_s2_922 x1_Vbias x2_x2_net1 5.10867f
Cbud_s2_923 x1_Vbias x2_x2_net10 5.10867f
Cbud_s2_924 x1_Vbias x2_x2_net11 5.10867f
Cbud_s2_925 x1_Vbias x2_x2_net12 2.24629f
Cbud_s2_926 x1_Vbias x2_x2_net13 1.88751f
Cbud_s2_927 x1_Vbias x2_x2_net14 1.60829f
Cbud_s2_928 x1_Vbias x2_x2_net15 1.38674f
Cbud_s2_929 x1_Vbias x2_x2_net16 0.788342f
Cbud_s2_930 x1_Vbias x2_x2_net17 0.838891f
Cbud_s2_931 x1_Vbias x2_x2_net18 0.940487f
Cbud_s2_932 x1_Vbias x2_x2_net19 1.06172f
Cbud_s2_933 x1_Vbias x2_x2_net2 2.71801f
Cbud_s2_934 x1_Vbias x2_x2_net3 1.208f
Cbud_s2_935 x1_Vbias x2_x2_net4 5.10867f
Cbud_s2_936 x1_Vbias x2_x2_net5 5.10867f
Cbud_s2_937 x1_Vbias x2_x2_net6 5.10867f
Cbud_s2_938 x1_Vbias x2_x2_net7 5.10867f
Cbud_s2_939 x1_Vbias x2_x2_net8 3.35557f
Cbud_s2_940 x1_Vbias x2_x2_net9 4.24689f
Cbud_s2_941 x1_Vbias Vm 1.19379f
Cbud_s2_942 x1_Vbias Vp 1.19379f
Cbud_s2_943 x1_Vout x1_Vtest2 1.61585f
Cbud_s2_944 x1_Vout x1_net1 1.61585f
Cbud_s2_945 x1_Vout x1_net2 3.50591f
Cbud_s2_946 x1_Vout x1_net3 1.75295f
Cbud_s2_947 x1_Vout x1_net4 1.75295f
Cbud_s2_948 x1_Vout x1_net5 1.75295f
Cbud_s2_949 x1_Vout x1_net6 1.75295f
Cbud_s2_950 x1_Vout x1_net7 1.73817f
Cbud_s2_951 x1_Vout x1_net8 1.73817f
Cbud_s2_952 x1_Vout x1_net9 10.3874f
Cbud_s2_953 x1_Vout x2_Vbiasp 3.95719f
Cbud_s2_954 x1_Vout x2_Vcm 7.97714f
Cbud_s2_955 x1_Vout x2_Vout 6.23194f
Cbud_s2_956 x1_Vout x2_Vtest 6.7072f
Cbud_s2_957 x1_Vout x2_net1 3.31341f
Cbud_s2_958 x1_Vout x2_x1_net1 1.208f
Cbud_s2_959 x1_Vout x2_x1_net10 1.60829f
Cbud_s2_960 x1_Vout x2_x1_net11 1.38674f
Cbud_s2_961 x1_Vout x2_x1_net12 3.35557f
Cbud_s2_962 x1_Vout x2_x1_net13 4.24689f
Cbud_s2_963 x1_Vout x2_x1_net14 5.54696f
Cbud_s2_964 x1_Vout x2_x1_net15 6.75515f
Cbud_s2_965 x1_Vout x2_x1_net16 6.75515f
Cbud_s2_966 x1_Vout x2_x1_net17 6.75515f
Cbud_s2_967 x1_Vout x2_x1_net18 6.75515f
Cbud_s2_968 x1_Vout x2_x1_net19 6.75515f
Cbud_s2_969 x1_Vout x2_x1_net2 2.71801f
Cbud_s2_970 x1_Vout x2_x1_net3 6.75515f
Cbud_s2_971 x1_Vout x2_x1_net4 1.04242f
Cbud_s2_972 x1_Vout x2_x1_net5 1.04242f
Cbud_s2_973 x1_Vout x2_x1_net6 1.04242f
Cbud_s2_974 x1_Vout x2_x1_net7 1.06172f
Cbud_s2_975 x1_Vout x2_x1_net8 2.24629f
Cbud_s2_976 x1_Vout x2_x1_net9 1.88751f
Cbud_s2_977 x1_Vout x2_x2_net1 6.75515f
Cbud_s2_978 x1_Vout x2_x2_net10 5.54696f
Cbud_s2_979 x1_Vout x2_x2_net11 6.75515f
Cbud_s2_980 x1_Vout x2_x2_net12 2.24629f
Cbud_s2_981 x1_Vout x2_x2_net13 1.88751f
Cbud_s2_982 x1_Vout x2_x2_net14 1.60829f
Cbud_s2_983 x1_Vout x2_x2_net15 1.38674f
Cbud_s2_984 x1_Vout x2_x2_net16 1.04242f
Cbud_s2_985 x1_Vout x2_x2_net17 1.04242f
Cbud_s2_986 x1_Vout x2_x2_net18 1.04242f
Cbud_s2_987 x1_Vout x2_x2_net19 1.06172f
Cbud_s2_988 x1_Vout x2_x2_net2 2.71801f
Cbud_s2_989 x1_Vout x2_x2_net3 1.208f
Cbud_s2_990 x1_Vout x2_x2_net4 6.75515f
Cbud_s2_991 x1_Vout x2_x2_net5 6.75515f
Cbud_s2_992 x1_Vout x2_x2_net6 6.75515f
Cbud_s2_993 x1_Vout x2_x2_net7 6.75515f
Cbud_s2_994 x1_Vout x2_x2_net8 3.35557f
Cbud_s2_995 x1_Vout x2_x2_net9 4.24689f
Cbud_s2_996 x1_Vtest2 x1_net1 0.565278f
Cbud_s2_997 x1_Vtest2 x1_net2 0.645545f
Cbud_s2_998 x1_Vtest2 x1_net3 0.270506f
Cbud_s2_999 x1_Vtest2 x1_net4 0.270506f
Cbud_s2_1000 x1_Vtest2 x1_net5 0.654174f
Cbud_s2_1001 x1_Vtest2 x1_net6 0.270506f
Cbud_s2_1002 x1_Vtest2 x1_net7 1.587f
Cbud_s2_1003 x1_Vtest2 x1_net8 0.565278f
Cbud_s2_1004 x1_Vtest2 x1_net9 0.565278f
Cbud_s2_1005 x1_Vtest2 x2_Vbiasp 0.565278f
Cbud_s2_1006 x1_Vtest2 x2_Vcm 0.565278f
Cbud_s2_1007 x1_Vtest2 x2_Vout 0.565278f
Cbud_s2_1008 x1_Vtest2 x2_Vtest 0.565278f
Cbud_s2_1009 x1_Vtest2 x2_net1 0.511307f
Cbud_s2_1010 x1_Vtest2 x2_x1_net1 1.587f
Cbud_s2_1011 x1_Vtest2 x2_x1_net10 1.587f
Cbud_s2_1012 x1_Vtest2 x2_x1_net11 1.587f
Cbud_s2_1013 x1_Vtest2 x2_x1_net12 1.587f
Cbud_s2_1014 x1_Vtest2 x2_x1_net13 1.587f
Cbud_s2_1015 x1_Vtest2 x2_x1_net14 1.587f
Cbud_s2_1016 x1_Vtest2 x2_x1_net15 1.587f
Cbud_s2_1017 x1_Vtest2 x2_x1_net16 0.565278f
Cbud_s2_1018 x1_Vtest2 x2_x1_net17 0.565278f
Cbud_s2_1019 x1_Vtest2 x2_x1_net18 0.565278f
Cbud_s2_1020 x1_Vtest2 x2_x1_net19 1.587f
Cbud_s2_1021 x1_Vtest2 x2_x1_net2 1.587f
Cbud_s2_1022 x1_Vtest2 x2_x1_net3 1.587f
Cbud_s2_1023 x1_Vtest2 x2_x1_net4 1.587f
Cbud_s2_1024 x1_Vtest2 x2_x1_net5 1.587f
Cbud_s2_1025 x1_Vtest2 x2_x1_net6 1.587f
Cbud_s2_1026 x1_Vtest2 x2_x1_net7 1.587f
Cbud_s2_1027 x1_Vtest2 x2_x1_net8 1.587f
Cbud_s2_1028 x1_Vtest2 x2_x1_net9 1.587f
Cbud_s2_1029 x1_Vtest2 x2_x2_net1 0.565278f
Cbud_s2_1030 x1_Vtest2 x2_x2_net10 0.565278f
Cbud_s2_1031 x1_Vtest2 x2_x2_net11 0.565278f
Cbud_s2_1032 x1_Vtest2 x2_x2_net12 0.565278f
Cbud_s2_1033 x1_Vtest2 x2_x2_net13 0.565278f
Cbud_s2_1034 x1_Vtest2 x2_x2_net14 0.565278f
Cbud_s2_1035 x1_Vtest2 x2_x2_net15 0.565278f
Cbud_s2_1036 x1_Vtest2 x2_x2_net16 0.565278f
Cbud_s2_1037 x1_Vtest2 x2_x2_net17 0.565278f
Cbud_s2_1038 x1_Vtest2 x2_x2_net18 0.565278f
Cbud_s2_1039 x1_Vtest2 x2_x2_net19 0.565278f
Cbud_s2_1040 x1_Vtest2 x2_x2_net2 0.565278f
Cbud_s2_1041 x1_Vtest2 x2_x2_net3 0.565278f
Cbud_s2_1042 x1_Vtest2 x2_x2_net4 0.565278f
Cbud_s2_1043 x1_Vtest2 x2_x2_net5 0.565278f
Cbud_s2_1044 x1_Vtest2 x2_x2_net6 0.565278f
Cbud_s2_1045 x1_Vtest2 x2_x2_net7 0.565278f
Cbud_s2_1046 x1_Vtest2 x2_x2_net8 0.565278f
Cbud_s2_1047 x1_Vtest2 x2_x2_net9 0.565278f
Cbud_s2_1048 x1_Vtest2 Vm 1.19915f
Cbud_s2_1049 x1_Vtest2 Vp 0.184219f
Cbud_s2_1050 x1_net1 x1_net2 0.645545f
Cbud_s2_1051 x1_net1 x1_net3 0.270506f
Cbud_s2_1052 x1_net1 x1_net4 0.270506f
Cbud_s2_1053 x1_net1 x1_net5 0.270506f
Cbud_s2_1054 x1_net1 x1_net6 0.654174f
Cbud_s2_1055 x1_net1 x1_net7 0.565278f
Cbud_s2_1056 x1_net1 x1_net8 1.587f
Cbud_s2_1057 x1_net1 x1_net9 0.565278f
Cbud_s2_1058 x1_net1 x2_Vbiasp 0.565278f
Cbud_s2_1059 x1_net1 x2_Vcm 0.565278f
Cbud_s2_1060 x1_net1 x2_Vout 0.565278f
Cbud_s2_1061 x1_net1 x2_Vtest 0.565278f
Cbud_s2_1062 x1_net1 x2_net1 0.511307f
Cbud_s2_1063 x1_net1 x2_x1_net1 0.565278f
Cbud_s2_1064 x1_net1 x2_x1_net10 0.565278f
Cbud_s2_1065 x1_net1 x2_x1_net11 0.565278f
Cbud_s2_1066 x1_net1 x2_x1_net12 0.565278f
Cbud_s2_1067 x1_net1 x2_x1_net13 0.565278f
Cbud_s2_1068 x1_net1 x2_x1_net14 0.565278f
Cbud_s2_1069 x1_net1 x2_x1_net15 0.565278f
Cbud_s2_1070 x1_net1 x2_x1_net16 0.565278f
Cbud_s2_1071 x1_net1 x2_x1_net17 0.565278f
Cbud_s2_1072 x1_net1 x2_x1_net18 0.565278f
Cbud_s2_1073 x1_net1 x2_x1_net19 0.565278f
Cbud_s2_1074 x1_net1 x2_x1_net2 0.565278f
Cbud_s2_1075 x1_net1 x2_x1_net3 0.565278f
Cbud_s2_1076 x1_net1 x2_x1_net4 0.565278f
Cbud_s2_1077 x1_net1 x2_x1_net5 0.565278f
Cbud_s2_1078 x1_net1 x2_x1_net6 0.565278f
Cbud_s2_1079 x1_net1 x2_x1_net7 0.565278f
Cbud_s2_1080 x1_net1 x2_x1_net8 0.565278f
Cbud_s2_1081 x1_net1 x2_x1_net9 0.565278f
Cbud_s2_1082 x1_net1 x2_x2_net1 1.587f
Cbud_s2_1083 x1_net1 x2_x2_net10 1.587f
Cbud_s2_1084 x1_net1 x2_x2_net11 1.587f
Cbud_s2_1085 x1_net1 x2_x2_net12 1.587f
Cbud_s2_1086 x1_net1 x2_x2_net13 1.587f
Cbud_s2_1087 x1_net1 x2_x2_net14 1.587f
Cbud_s2_1088 x1_net1 x2_x2_net15 1.587f
Cbud_s2_1089 x1_net1 x2_x2_net16 1.587f
Cbud_s2_1090 x1_net1 x2_x2_net17 1.587f
Cbud_s2_1091 x1_net1 x2_x2_net18 1.587f
Cbud_s2_1092 x1_net1 x2_x2_net19 1.587f
Cbud_s2_1093 x1_net1 x2_x2_net2 1.587f
Cbud_s2_1094 x1_net1 x2_x2_net3 1.587f
Cbud_s2_1095 x1_net1 x2_x2_net4 0.565278f
Cbud_s2_1096 x1_net1 x2_x2_net5 0.565278f
Cbud_s2_1097 x1_net1 x2_x2_net6 0.565278f
Cbud_s2_1098 x1_net1 x2_x2_net7 1.587f
Cbud_s2_1099 x1_net1 x2_x2_net8 1.587f
Cbud_s2_1100 x1_net1 x2_x2_net9 1.587f
Cbud_s2_1101 x1_net1 Vm 0.184219f
Cbud_s2_1102 x1_net1 Vp 1.19915f
Cbud_s2_1103 x1_net2 x1_net3 2.35275f
Cbud_s2_1104 x1_net2 x1_net4 2.35275f
Cbud_s2_1105 x1_net2 x1_net5 1.75295f
Cbud_s2_1106 x1_net2 x1_net6 1.75295f
Cbud_s2_1107 x1_net2 x1_net7 1.73817f
Cbud_s2_1108 x1_net2 x1_net8 1.73817f
Cbud_s2_1109 x1_net2 x1_net9 3.50591f
Cbud_s2_1110 x1_net2 x2_Vbiasp 3.50591f
Cbud_s2_1111 x1_net2 x2_Vtest 3.50591f
Cbud_s2_1112 x1_net2 x2_net1 3.31341f
Cbud_s2_1113 x1_net2 x2_x1_net1 1.208f
Cbud_s2_1114 x1_net2 x2_x1_net10 1.60829f
Cbud_s2_1115 x1_net2 x2_x1_net11 1.38674f
Cbud_s2_1116 x1_net2 x2_x1_net12 3.35556f
Cbud_s2_1117 x1_net2 x2_x1_net13 3.50591f
Cbud_s2_1118 x1_net2 x2_x1_net14 3.50591f
Cbud_s2_1119 x1_net2 x2_x1_net15 3.50591f
Cbud_s2_1120 x1_net2 x2_x1_net16 3.50591f
Cbud_s2_1121 x1_net2 x2_x1_net17 3.50591f
Cbud_s2_1122 x1_net2 x2_x1_net18 3.50591f
Cbud_s2_1123 x1_net2 x2_x1_net19 3.50591f
Cbud_s2_1124 x1_net2 x2_x1_net2 2.71801f
Cbud_s2_1125 x1_net2 x2_x1_net3 3.50591f
Cbud_s2_1126 x1_net2 x2_x1_net4 0.75291f
Cbud_s2_1127 x1_net2 x2_x1_net5 0.83889f
Cbud_s2_1128 x1_net2 x2_x1_net6 0.940486f
Cbud_s2_1129 x1_net2 x2_x1_net7 1.06172f
Cbud_s2_1130 x1_net2 x2_x1_net8 2.24629f
Cbud_s2_1131 x1_net2 x2_x1_net9 1.8875f
Cbud_s2_1132 x1_net2 x2_x2_net1 3.50591f
Cbud_s2_1133 x1_net2 x2_x2_net10 3.50591f
Cbud_s2_1134 x1_net2 x2_x2_net11 3.50591f
Cbud_s2_1135 x1_net2 x2_x2_net12 2.24629f
Cbud_s2_1136 x1_net2 x2_x2_net13 1.8875f
Cbud_s2_1137 x1_net2 x2_x2_net14 1.60829f
Cbud_s2_1138 x1_net2 x2_x2_net15 1.38674f
Cbud_s2_1139 x1_net2 x2_x2_net16 0.75291f
Cbud_s2_1140 x1_net2 x2_x2_net17 0.83889f
Cbud_s2_1141 x1_net2 x2_x2_net18 0.940486f
Cbud_s2_1142 x1_net2 x2_x2_net19 1.06172f
Cbud_s2_1143 x1_net2 x2_x2_net2 2.71801f
Cbud_s2_1144 x1_net2 x2_x2_net3 1.208f
Cbud_s2_1145 x1_net2 x2_x2_net4 3.50591f
Cbud_s2_1146 x1_net2 x2_x2_net5 3.50591f
Cbud_s2_1147 x1_net2 x2_x2_net6 3.50591f
Cbud_s2_1148 x1_net2 x2_x2_net7 3.50591f
Cbud_s2_1149 x1_net2 x2_x2_net8 3.35556f
Cbud_s2_1150 x1_net2 x2_x2_net9 3.50591f
Cbud_s2_1151 x1_net2 Vm 7.77079f
Cbud_s2_1152 x1_net2 Vp 7.77079f
Cbud_s2_1153 x1_net3 x1_net4 1.75295f
Cbud_s2_1154 x1_net3 x1_net5 1.75295f
Cbud_s2_1155 x1_net3 x1_net6 1.75295f
Cbud_s2_1156 x1_net3 x1_net7 1.73817f
Cbud_s2_1157 x1_net3 x1_net8 1.73817f
Cbud_s2_1158 x1_net3 x2_Vbiasp 1.75295f
Cbud_s2_1159 x1_net3 x2_Vcm 1.75295f
Cbud_s2_1160 x1_net3 x2_Vout 1.75295f
Cbud_s2_1161 x1_net3 x2_net1 1.75295f
Cbud_s2_1162 x1_net3 x2_x1_net1 1.208f
Cbud_s2_1163 x1_net3 x2_x1_net10 1.60829f
Cbud_s2_1164 x1_net3 x2_x1_net11 1.38674f
Cbud_s2_1165 x1_net3 x2_x1_net12 1.75295f
Cbud_s2_1166 x1_net3 x2_x1_net13 1.75295f
Cbud_s2_1167 x1_net3 x2_x1_net14 1.75295f
Cbud_s2_1168 x1_net3 x2_x1_net15 1.75295f
Cbud_s2_1169 x1_net3 x2_x1_net16 1.75295f
Cbud_s2_1170 x1_net3 x2_x1_net17 1.75295f
Cbud_s2_1171 x1_net3 x2_x1_net18 1.75295f
Cbud_s2_1172 x1_net3 x2_x1_net19 1.75295f
Cbud_s2_1173 x1_net3 x2_x1_net2 1.75295f
Cbud_s2_1174 x1_net3 x2_x1_net3 1.75295f
Cbud_s2_1175 x1_net3 x2_x1_net4 0.75291f
Cbud_s2_1176 x1_net3 x2_x1_net5 0.838891f
Cbud_s2_1177 x1_net3 x2_x1_net6 0.940487f
Cbud_s2_1178 x1_net3 x2_x1_net7 1.06172f
Cbud_s2_1179 x1_net3 x2_x1_net8 1.75295f
Cbud_s2_1180 x1_net3 x2_x1_net9 1.75295f
Cbud_s2_1181 x1_net3 x2_x2_net1 1.75295f
Cbud_s2_1182 x1_net3 x2_x2_net10 1.75295f
Cbud_s2_1183 x1_net3 x2_x2_net11 1.75295f
Cbud_s2_1184 x1_net3 x2_x2_net12 1.75295f
Cbud_s2_1185 x1_net3 x2_x2_net13 1.75295f
Cbud_s2_1186 x1_net3 x2_x2_net14 1.60829f
Cbud_s2_1187 x1_net3 x2_x2_net15 1.38674f
Cbud_s2_1188 x1_net3 x2_x2_net16 0.75291f
Cbud_s2_1189 x1_net3 x2_x2_net17 0.838891f
Cbud_s2_1190 x1_net3 x2_x2_net18 0.940487f
Cbud_s2_1191 x1_net3 x2_x2_net19 1.06172f
Cbud_s2_1192 x1_net3 x2_x2_net2 1.75295f
Cbud_s2_1193 x1_net3 x2_x2_net3 1.208f
Cbud_s2_1194 x1_net3 x2_x2_net4 1.75295f
Cbud_s2_1195 x1_net3 x2_x2_net5 1.75295f
Cbud_s2_1196 x1_net3 x2_x2_net6 1.75295f
Cbud_s2_1197 x1_net3 x2_x2_net7 1.75295f
Cbud_s2_1198 x1_net3 x2_x2_net8 1.75295f
Cbud_s2_1199 x1_net3 x2_x2_net9 1.75295f
Cbud_s2_1200 x1_net3 Vm 1.19379f
Cbud_s2_1201 x1_net4 x1_net5 1.75295f
Cbud_s2_1202 x1_net4 x1_net6 1.75295f
Cbud_s2_1203 x1_net4 x1_net7 1.73817f
Cbud_s2_1204 x1_net4 x1_net8 1.73817f
Cbud_s2_1205 x1_net4 x1_net9 1.75295f
Cbud_s2_1206 x1_net4 x2_Vbiasp 1.75295f
Cbud_s2_1207 x1_net4 x2_Vcm 1.75295f
Cbud_s2_1208 x1_net4 x2_Vout 1.75295f
Cbud_s2_1209 x1_net4 x2_Vtest 1.75295f
Cbud_s2_1210 x1_net4 x2_net1 1.75295f
Cbud_s2_1211 x1_net4 x2_x1_net1 1.208f
Cbud_s2_1212 x1_net4 x2_x1_net10 1.60829f
Cbud_s2_1213 x1_net4 x2_x1_net11 1.38674f
Cbud_s2_1214 x1_net4 x2_x1_net12 1.75295f
Cbud_s2_1215 x1_net4 x2_x1_net13 1.75295f
Cbud_s2_1216 x1_net4 x2_x1_net14 1.75295f
Cbud_s2_1217 x1_net4 x2_x1_net15 1.75295f
Cbud_s2_1218 x1_net4 x2_x1_net16 1.75295f
Cbud_s2_1219 x1_net4 x2_x1_net17 1.75295f
Cbud_s2_1220 x1_net4 x2_x1_net18 1.75295f
Cbud_s2_1221 x1_net4 x2_x1_net19 1.75295f
Cbud_s2_1222 x1_net4 x2_x1_net2 1.75295f
Cbud_s2_1223 x1_net4 x2_x1_net3 1.75295f
Cbud_s2_1224 x1_net4 x2_x1_net4 0.75291f
Cbud_s2_1225 x1_net4 x2_x1_net5 0.838891f
Cbud_s2_1226 x1_net4 x2_x1_net6 0.940487f
Cbud_s2_1227 x1_net4 x2_x1_net7 1.06172f
Cbud_s2_1228 x1_net4 x2_x1_net8 1.75295f
Cbud_s2_1229 x1_net4 x2_x1_net9 1.75295f
Cbud_s2_1230 x1_net4 x2_x2_net1 1.75295f
Cbud_s2_1231 x1_net4 x2_x2_net10 1.75295f
Cbud_s2_1232 x1_net4 x2_x2_net11 1.75295f
Cbud_s2_1233 x1_net4 x2_x2_net12 1.75295f
Cbud_s2_1234 x1_net4 x2_x2_net13 1.75295f
Cbud_s2_1235 x1_net4 x2_x2_net14 1.60829f
Cbud_s2_1236 x1_net4 x2_x2_net15 1.38674f
Cbud_s2_1237 x1_net4 x2_x2_net16 0.75291f
Cbud_s2_1238 x1_net4 x2_x2_net17 0.838891f
Cbud_s2_1239 x1_net4 x2_x2_net18 0.940487f
Cbud_s2_1240 x1_net4 x2_x2_net19 1.06172f
Cbud_s2_1241 x1_net4 x2_x2_net2 1.75295f
Cbud_s2_1242 x1_net4 x2_x2_net3 1.208f
Cbud_s2_1243 x1_net4 x2_x2_net4 1.75295f
Cbud_s2_1244 x1_net4 x2_x2_net5 1.75295f
Cbud_s2_1245 x1_net4 x2_x2_net6 1.75295f
Cbud_s2_1246 x1_net4 x2_x2_net7 1.75295f
Cbud_s2_1247 x1_net4 x2_x2_net8 1.75295f
Cbud_s2_1248 x1_net4 x2_x2_net9 1.75295f
Cbud_s2_1249 x1_net5 x1_net6 1.75295f
Cbud_s2_1250 x1_net5 x1_net7 0.929828f
Cbud_s2_1251 x1_net5 x1_net8 1.75295f
Cbud_s2_1252 x1_net5 x1_net9 1.75295f
Cbud_s2_1253 x1_net5 x2_Vbiasp 1.75295f
Cbud_s2_1254 x1_net5 x2_Vcm 1.75295f
Cbud_s2_1255 x1_net5 x2_Vout 1.75295f
Cbud_s2_1256 x1_net5 x2_Vtest 1.75295f
Cbud_s2_1257 x1_net5 x2_net1 1.75295f
Cbud_s2_1258 x1_net5 x2_x1_net1 0.759437f
Cbud_s2_1259 x1_net5 x2_x1_net10 0.759437f
Cbud_s2_1260 x1_net5 x2_x1_net11 0.759437f
Cbud_s2_1261 x1_net5 x2_x1_net12 0.759437f
Cbud_s2_1262 x1_net5 x2_x1_net13 0.759437f
Cbud_s2_1263 x1_net5 x2_x1_net14 0.759437f
Cbud_s2_1264 x1_net5 x2_x1_net15 0.759437f
Cbud_s2_1265 x1_net5 x2_x1_net16 1.6774f
Cbud_s2_1266 x1_net5 x2_x1_net17 0.839004f
Cbud_s2_1267 x1_net5 x2_x1_net18 0.759437f
Cbud_s2_1268 x1_net5 x2_x1_net19 0.759437f
Cbud_s2_1269 x1_net5 x2_x1_net2 0.759437f
Cbud_s2_1270 x1_net5 x2_x1_net3 0.759437f
Cbud_s2_1271 x1_net5 x2_x1_net4 0.759437f
Cbud_s2_1272 x1_net5 x2_x1_net5 0.759437f
Cbud_s2_1273 x1_net5 x2_x1_net6 0.759437f
Cbud_s2_1274 x1_net5 x2_x1_net7 0.759437f
Cbud_s2_1275 x1_net5 x2_x1_net8 0.759437f
Cbud_s2_1276 x1_net5 x2_x1_net9 0.759437f
Cbud_s2_1277 x1_net5 x2_x2_net1 0.555265f
Cbud_s2_1278 x1_net5 x2_x2_net10 0.396912f
Cbud_s2_1279 x1_net5 x2_x2_net11 0.462928f
Cbud_s2_1280 x1_net5 x2_x2_net12 0.270506f
Cbud_s2_1281 x1_net5 x2_x2_net13 0.270506f
Cbud_s2_1282 x1_net5 x2_x2_net14 0.270506f
Cbud_s2_1283 x1_net5 x2_x2_net15 0.270506f
Cbud_s2_1284 x1_net5 x2_x2_net16 0.270506f
Cbud_s2_1285 x1_net5 x2_x2_net17 0.270506f
Cbud_s2_1286 x1_net5 x2_x2_net18 0.270506f
Cbud_s2_1287 x1_net5 x2_x2_net19 0.270506f
Cbud_s2_1288 x1_net5 x2_x2_net2 0.277958f
Cbud_s2_1289 x1_net5 x2_x2_net3 0.270506f
Cbud_s2_1290 x1_net5 x2_x2_net4 1.75295f
Cbud_s2_1291 x1_net5 x2_x2_net5 1.38192f
Cbud_s2_1292 x1_net5 x2_x2_net6 0.923639f
Cbud_s2_1293 x1_net5 x2_x2_net7 0.693589f
Cbud_s2_1294 x1_net5 x2_x2_net8 0.308814f
Cbud_s2_1295 x1_net5 x2_x2_net9 0.347368f
Cbud_s2_1296 x1_net5 Vm 0.517187f
Cbud_s2_1297 x1_net5 Vp 0.849546f
Cbud_s2_1298 x1_net6 x1_net7 1.75295f
Cbud_s2_1299 x1_net6 x1_net8 0.929828f
Cbud_s2_1300 x1_net6 x1_net9 1.75295f
Cbud_s2_1301 x1_net6 x2_Vbiasp 1.75295f
Cbud_s2_1302 x1_net6 x2_Vcm 1.75295f
Cbud_s2_1303 x1_net6 x2_Vout 1.75295f
Cbud_s2_1304 x1_net6 x2_Vtest 1.75295f
Cbud_s2_1305 x1_net6 x2_net1 1.75295f
Cbud_s2_1306 x1_net6 x2_x1_net1 0.270506f
Cbud_s2_1307 x1_net6 x2_x1_net10 0.270506f
Cbud_s2_1308 x1_net6 x2_x1_net11 0.270506f
Cbud_s2_1309 x1_net6 x2_x1_net12 0.308814f
Cbud_s2_1310 x1_net6 x2_x1_net13 0.347368f
Cbud_s2_1311 x1_net6 x2_x1_net14 0.396912f
Cbud_s2_1312 x1_net6 x2_x1_net15 0.462928f
Cbud_s2_1313 x1_net6 x2_x1_net16 1.75295f
Cbud_s2_1314 x1_net6 x2_x1_net17 1.38192f
Cbud_s2_1315 x1_net6 x2_x1_net18 0.923639f
Cbud_s2_1316 x1_net6 x2_x1_net19 0.693589f
Cbud_s2_1317 x1_net6 x2_x1_net2 0.277958f
Cbud_s2_1318 x1_net6 x2_x1_net3 0.555265f
Cbud_s2_1319 x1_net6 x2_x1_net4 0.270506f
Cbud_s2_1320 x1_net6 x2_x1_net5 0.270506f
Cbud_s2_1321 x1_net6 x2_x1_net6 0.270506f
Cbud_s2_1322 x1_net6 x2_x1_net7 0.270506f
Cbud_s2_1323 x1_net6 x2_x1_net8 0.270506f
Cbud_s2_1324 x1_net6 x2_x1_net9 0.270506f
Cbud_s2_1325 x1_net6 x2_x2_net1 0.759437f
Cbud_s2_1326 x1_net6 x2_x2_net10 0.759437f
Cbud_s2_1327 x1_net6 x2_x2_net11 0.759437f
Cbud_s2_1328 x1_net6 x2_x2_net12 0.759437f
Cbud_s2_1329 x1_net6 x2_x2_net13 0.759437f
Cbud_s2_1330 x1_net6 x2_x2_net14 0.759437f
Cbud_s2_1331 x1_net6 x2_x2_net15 0.759437f
Cbud_s2_1332 x1_net6 x2_x2_net16 0.759437f
Cbud_s2_1333 x1_net6 x2_x2_net17 0.759437f
Cbud_s2_1334 x1_net6 x2_x2_net18 0.759437f
Cbud_s2_1335 x1_net6 x2_x2_net19 0.759437f
Cbud_s2_1336 x1_net6 x2_x2_net2 0.759437f
Cbud_s2_1337 x1_net6 x2_x2_net3 0.759437f
Cbud_s2_1338 x1_net6 x2_x2_net4 1.6774f
Cbud_s2_1339 x1_net6 x2_x2_net5 0.839003f
Cbud_s2_1340 x1_net6 x2_x2_net6 0.759437f
Cbud_s2_1341 x1_net6 x2_x2_net7 0.759437f
Cbud_s2_1342 x1_net6 x2_x2_net8 0.759437f
Cbud_s2_1343 x1_net6 x2_x2_net9 0.759437f
Cbud_s2_1344 x1_net6 Vm 0.849546f
Cbud_s2_1345 x1_net6 Vp 0.517187f
Cbud_s2_1346 x1_net7 x1_net8 1.05319f
Cbud_s2_1347 x1_net7 x1_net9 1.73818f
Cbud_s2_1348 x1_net7 x2_Vbiasp 1.73817f
Cbud_s2_1349 x1_net7 x2_Vcm 1.73817f
Cbud_s2_1350 x1_net7 x2_Vout 1.73801f
Cbud_s2_1351 x1_net7 x2_Vtest 1.73816f
Cbud_s2_1352 x1_net7 x2_net1 1.73815f
Cbud_s2_1353 x1_net7 x2_x1_net1 1.04242f
Cbud_s2_1354 x1_net7 x2_x1_net10 1.04242f
Cbud_s2_1355 x1_net7 x2_x1_net11 1.04242f
Cbud_s2_1356 x1_net7 x2_x1_net12 1.04242f
Cbud_s2_1357 x1_net7 x2_x1_net13 1.04242f
Cbud_s2_1358 x1_net7 x2_x1_net14 1.04242f
Cbud_s2_1359 x1_net7 x2_x1_net15 1.04242f
Cbud_s2_1360 x1_net7 x2_x1_net16 1.04242f
Cbud_s2_1361 x1_net7 x2_x1_net17 1.04242f
Cbud_s2_1362 x1_net7 x2_x1_net18 1.04242f
Cbud_s2_1363 x1_net7 x2_x1_net19 1.04242f
Cbud_s2_1364 x1_net7 x2_x1_net2 1.04242f
Cbud_s2_1365 x1_net7 x2_x1_net3 1.04242f
Cbud_s2_1366 x1_net7 x2_x1_net4 1.04242f
Cbud_s2_1367 x1_net7 x2_x1_net5 1.04242f
Cbud_s2_1368 x1_net7 x2_x1_net6 1.04242f
Cbud_s2_1369 x1_net7 x2_x1_net7 1.04242f
Cbud_s2_1370 x1_net7 x2_x1_net8 1.04242f
Cbud_s2_1371 x1_net7 x2_x1_net9 1.04242f
Cbud_s2_1372 x1_net7 x2_x2_net1 6.75515f
Cbud_s2_1373 x1_net7 x2_x2_net10 6.75515f
Cbud_s2_1374 x1_net7 x2_x2_net11 6.75515f
Cbud_s2_1375 x1_net7 x2_x2_net12 6.75515f
Cbud_s2_1376 x1_net7 x2_x2_net13 6.75515f
Cbud_s2_1377 x1_net7 x2_x2_net14 6.75515f
Cbud_s2_1378 x1_net7 x2_x2_net15 6.75515f
Cbud_s2_1379 x1_net7 x2_x2_net16 6.75515f
Cbud_s2_1380 x1_net7 x2_x2_net17 6.75515f
Cbud_s2_1381 x1_net7 x2_x2_net18 6.75515f
Cbud_s2_1382 x1_net7 x2_x2_net19 6.75515f
Cbud_s2_1383 x1_net7 x2_x2_net2 6.75515f
Cbud_s2_1384 x1_net7 x2_x2_net3 6.75515f
Cbud_s2_1385 x1_net7 x2_x2_net4 4.41145f
Cbud_s2_1386 x1_net7 x2_x2_net5 6.75515f
Cbud_s2_1387 x1_net7 x2_x2_net6 6.75515f
Cbud_s2_1388 x1_net7 x2_x2_net7 6.75515f
Cbud_s2_1389 x1_net7 x2_x2_net8 6.75515f
Cbud_s2_1390 x1_net7 x2_x2_net9 6.75515f
Cbud_s2_1391 x1_net7 Vm 0.312215f
Cbud_s2_1392 x1_net7 Vp 0.517187f
Cbud_s2_1393 x1_net8 x1_net9 1.73818f
Cbud_s2_1394 x1_net8 x2_Vbiasp 1.73817f
Cbud_s2_1395 x1_net8 x2_Vcm 1.73817f
Cbud_s2_1396 x1_net8 x2_Vout 1.73801f
Cbud_s2_1397 x1_net8 x2_Vtest 1.73816f
Cbud_s2_1398 x1_net8 x2_net1 1.73815f
Cbud_s2_1399 x1_net8 x2_x1_net1 6.75515f
Cbud_s2_1400 x1_net8 x2_x1_net10 6.75515f
Cbud_s2_1401 x1_net8 x2_x1_net11 6.75515f
Cbud_s2_1402 x1_net8 x2_x1_net12 6.75515f
Cbud_s2_1403 x1_net8 x2_x1_net13 6.75515f
Cbud_s2_1404 x1_net8 x2_x1_net14 6.75515f
Cbud_s2_1405 x1_net8 x2_x1_net15 6.75515f
Cbud_s2_1406 x1_net8 x2_x1_net16 4.41145f
Cbud_s2_1407 x1_net8 x2_x1_net17 6.75515f
Cbud_s2_1408 x1_net8 x2_x1_net18 6.75515f
Cbud_s2_1409 x1_net8 x2_x1_net19 6.75515f
Cbud_s2_1410 x1_net8 x2_x1_net2 6.75515f
Cbud_s2_1411 x1_net8 x2_x1_net3 6.75515f
Cbud_s2_1412 x1_net8 x2_x1_net4 6.75515f
Cbud_s2_1413 x1_net8 x2_x1_net5 6.75515f
Cbud_s2_1414 x1_net8 x2_x1_net6 6.75515f
Cbud_s2_1415 x1_net8 x2_x1_net7 6.75515f
Cbud_s2_1416 x1_net8 x2_x1_net8 6.75515f
Cbud_s2_1417 x1_net8 x2_x1_net9 6.75515f
Cbud_s2_1418 x1_net8 x2_x2_net1 1.04242f
Cbud_s2_1419 x1_net8 x2_x2_net10 1.04242f
Cbud_s2_1420 x1_net8 x2_x2_net11 1.04242f
Cbud_s2_1421 x1_net8 x2_x2_net12 1.04242f
Cbud_s2_1422 x1_net8 x2_x2_net13 1.04242f
Cbud_s2_1423 x1_net8 x2_x2_net14 1.04242f
Cbud_s2_1424 x1_net8 x2_x2_net15 1.04242f
Cbud_s2_1425 x1_net8 x2_x2_net16 1.04242f
Cbud_s2_1426 x1_net8 x2_x2_net17 1.04242f
Cbud_s2_1427 x1_net8 x2_x2_net18 1.04242f
Cbud_s2_1428 x1_net8 x2_x2_net19 1.04242f
Cbud_s2_1429 x1_net8 x2_x2_net2 1.04242f
Cbud_s2_1430 x1_net8 x2_x2_net3 1.04242f
Cbud_s2_1431 x1_net8 x2_x2_net4 1.04242f
Cbud_s2_1432 x1_net8 x2_x2_net5 1.04242f
Cbud_s2_1433 x1_net8 x2_x2_net6 1.04242f
Cbud_s2_1434 x1_net8 x2_x2_net7 1.04242f
Cbud_s2_1435 x1_net8 x2_x2_net8 1.04242f
Cbud_s2_1436 x1_net8 x2_x2_net9 1.04242f
Cbud_s2_1437 x1_net8 Vm 0.517187f
Cbud_s2_1438 x1_net8 Vp 0.312215f
Cbud_s2_1439 x1_net9 x2_Vbiasp 3.95719f
Cbud_s2_1440 x1_net9 x2_Vcm 7.97714f
Cbud_s2_1441 x1_net9 x2_Vtest 6.7072f
Cbud_s2_1442 x1_net9 x2_net1 3.31341f
Cbud_s2_1443 x1_net9 x2_x1_net1 1.208f
Cbud_s2_1444 x1_net9 x2_x1_net10 1.60829f
Cbud_s2_1445 x1_net9 x2_x1_net11 1.38674f
Cbud_s2_1446 x1_net9 x2_x1_net12 3.35557f
Cbud_s2_1447 x1_net9 x2_x1_net13 4.24689f
Cbud_s2_1448 x1_net9 x2_x1_net14 5.54696f
Cbud_s2_1449 x1_net9 x2_x1_net15 6.75515f
Cbud_s2_1450 x1_net9 x2_x1_net16 6.75515f
Cbud_s2_1451 x1_net9 x2_x1_net17 6.75515f
Cbud_s2_1452 x1_net9 x2_x1_net18 6.75515f
Cbud_s2_1453 x1_net9 x2_x1_net19 6.75515f
Cbud_s2_1454 x1_net9 x2_x1_net2 2.71801f
Cbud_s2_1455 x1_net9 x2_x1_net3 6.75515f
Cbud_s2_1456 x1_net9 x2_x1_net4 1.04242f
Cbud_s2_1457 x1_net9 x2_x1_net5 1.04242f
Cbud_s2_1458 x1_net9 x2_x1_net6 1.04242f
Cbud_s2_1459 x1_net9 x2_x1_net7 1.06172f
Cbud_s2_1460 x1_net9 x2_x1_net8 2.24629f
Cbud_s2_1461 x1_net9 x2_x1_net9 1.88751f
Cbud_s2_1462 x1_net9 x2_x2_net1 6.75515f
Cbud_s2_1463 x1_net9 x2_x2_net10 5.54696f
Cbud_s2_1464 x1_net9 x2_x2_net11 6.75515f
Cbud_s2_1465 x1_net9 x2_x2_net12 2.24629f
Cbud_s2_1466 x1_net9 x2_x2_net13 1.88751f
Cbud_s2_1467 x1_net9 x2_x2_net14 1.60829f
Cbud_s2_1468 x1_net9 x2_x2_net15 1.38674f
Cbud_s2_1469 x1_net9 x2_x2_net16 1.04242f
Cbud_s2_1470 x1_net9 x2_x2_net17 1.04242f
Cbud_s2_1471 x1_net9 x2_x2_net18 1.04242f
Cbud_s2_1472 x1_net9 x2_x2_net19 1.06172f
Cbud_s2_1473 x1_net9 x2_x2_net2 2.71801f
Cbud_s2_1474 x1_net9 x2_x2_net3 1.208f
Cbud_s2_1475 x1_net9 x2_x2_net4 6.75515f
Cbud_s2_1476 x1_net9 x2_x2_net5 6.75515f
Cbud_s2_1477 x1_net9 x2_x2_net6 6.75515f
Cbud_s2_1478 x1_net9 x2_x2_net7 6.75515f
Cbud_s2_1479 x1_net9 x2_x2_net8 3.35557f
Cbud_s2_1480 x1_net9 x2_x2_net9 4.24689f
Cbud_s2_1481 x1_net9 Vm 1.19379f
Cbud_s2_1482 x1_net9 Vp 1.19379f
Cbud_s2_1483 x2_Vbiasp x2_Vcm 3.95719f
Cbud_s2_1484 x2_Vbiasp x2_Vtest 3.95719f
Cbud_s2_1485 x2_Vbiasp x2_net1 5.03521f
Cbud_s2_1486 x2_Vbiasp x2_x1_net1 1.208f
Cbud_s2_1487 x2_Vbiasp x2_x1_net10 1.60829f
Cbud_s2_1488 x2_Vbiasp x2_x1_net11 1.38674f
Cbud_s2_1489 x2_Vbiasp x2_x1_net12 3.35556f
Cbud_s2_1490 x2_Vbiasp x2_x1_net13 3.95719f
Cbud_s2_1491 x2_Vbiasp x2_x1_net14 3.95719f
Cbud_s2_1492 x2_Vbiasp x2_x1_net15 3.95719f
Cbud_s2_1493 x2_Vbiasp x2_x1_net16 3.95719f
Cbud_s2_1494 x2_Vbiasp x2_x1_net17 3.95719f
Cbud_s2_1495 x2_Vbiasp x2_x1_net18 3.95719f
Cbud_s2_1496 x2_Vbiasp x2_x1_net19 3.95719f
Cbud_s2_1497 x2_Vbiasp x2_x1_net2 2.718f
Cbud_s2_1498 x2_Vbiasp x2_x1_net3 3.95719f
Cbud_s2_1499 x2_Vbiasp x2_x1_net4 0.75291f
Cbud_s2_1500 x2_Vbiasp x2_x1_net5 0.83889f
Cbud_s2_1501 x2_Vbiasp x2_x1_net6 0.940486f
Cbud_s2_1502 x2_Vbiasp x2_x1_net7 1.06172f
Cbud_s2_1503 x2_Vbiasp x2_x1_net8 2.24628f
Cbud_s2_1504 x2_Vbiasp x2_x1_net9 1.8875f
Cbud_s2_1505 x2_Vbiasp x2_x2_net1 3.95719f
Cbud_s2_1506 x2_Vbiasp x2_x2_net10 3.95719f
Cbud_s2_1507 x2_Vbiasp x2_x2_net11 3.95719f
Cbud_s2_1508 x2_Vbiasp x2_x2_net12 2.24628f
Cbud_s2_1509 x2_Vbiasp x2_x2_net13 1.8875f
Cbud_s2_1510 x2_Vbiasp x2_x2_net14 1.60829f
Cbud_s2_1511 x2_Vbiasp x2_x2_net15 1.38674f
Cbud_s2_1512 x2_Vbiasp x2_x2_net16 0.75291f
Cbud_s2_1513 x2_Vbiasp x2_x2_net17 0.83889f
Cbud_s2_1514 x2_Vbiasp x2_x2_net18 0.940486f
Cbud_s2_1515 x2_Vbiasp x2_x2_net19 1.06172f
Cbud_s2_1516 x2_Vbiasp x2_x2_net2 2.718f
Cbud_s2_1517 x2_Vbiasp x2_x2_net3 1.208f
Cbud_s2_1518 x2_Vbiasp x2_x2_net4 3.95719f
Cbud_s2_1519 x2_Vbiasp x2_x2_net5 3.95719f
Cbud_s2_1520 x2_Vbiasp x2_x2_net6 3.95719f
Cbud_s2_1521 x2_Vbiasp x2_x2_net7 3.95719f
Cbud_s2_1522 x2_Vbiasp x2_x2_net8 3.35556f
Cbud_s2_1523 x2_Vbiasp x2_x2_net9 3.95719f
Cbud_s2_1524 x2_Vbiasp Vm 1.19379f
Cbud_s2_1525 x2_Vbiasp Vp 1.19379f
Cbud_s2_1526 x2_Vcm x2_Vtest 8.5026f
Cbud_s2_1527 x2_Vcm x2_x1_net1 1.208f
Cbud_s2_1528 x2_Vcm x2_x1_net10 1.60829f
Cbud_s2_1529 x2_Vcm x2_x1_net11 1.38674f
Cbud_s2_1530 x2_Vcm x2_x1_net12 3.35556f
Cbud_s2_1531 x2_Vcm x2_x1_net13 4.24688f
Cbud_s2_1532 x2_Vcm x2_x1_net14 5.54695f
Cbud_s2_1533 x2_Vcm x2_x1_net15 6.75515f
Cbud_s2_1534 x2_Vcm x2_x1_net16 6.75515f
Cbud_s2_1535 x2_Vcm x2_x1_net17 6.75515f
Cbud_s2_1536 x2_Vcm x2_x1_net18 6.75515f
Cbud_s2_1537 x2_Vcm x2_x1_net19 6.75515f
Cbud_s2_1538 x2_Vcm x2_x1_net2 2.718f
Cbud_s2_1539 x2_Vcm x2_x1_net3 6.75515f
Cbud_s2_1540 x2_Vcm x2_x1_net4 1.04242f
Cbud_s2_1541 x2_Vcm x2_x1_net5 1.04242f
Cbud_s2_1542 x2_Vcm x2_x1_net6 1.04242f
Cbud_s2_1543 x2_Vcm x2_x1_net7 1.06172f
Cbud_s2_1544 x2_Vcm x2_x1_net8 2.24628f
Cbud_s2_1545 x2_Vcm x2_x1_net9 1.8875f
Cbud_s2_1546 x2_Vcm x2_x2_net1 6.75515f
Cbud_s2_1547 x2_Vcm x2_x2_net10 5.54695f
Cbud_s2_1548 x2_Vcm x2_x2_net11 6.75515f
Cbud_s2_1549 x2_Vcm x2_x2_net12 2.24628f
Cbud_s2_1550 x2_Vcm x2_x2_net13 1.8875f
Cbud_s2_1551 x2_Vcm x2_x2_net14 1.60829f
Cbud_s2_1552 x2_Vcm x2_x2_net15 1.38674f
Cbud_s2_1553 x2_Vcm x2_x2_net16 1.04242f
Cbud_s2_1554 x2_Vcm x2_x2_net17 1.04242f
Cbud_s2_1555 x2_Vcm x2_x2_net18 1.04242f
Cbud_s2_1556 x2_Vcm x2_x2_net19 1.06172f
Cbud_s2_1557 x2_Vcm x2_x2_net2 2.718f
Cbud_s2_1558 x2_Vcm x2_x2_net3 1.208f
Cbud_s2_1559 x2_Vcm x2_x2_net4 6.75515f
Cbud_s2_1560 x2_Vcm x2_x2_net5 6.75515f
Cbud_s2_1561 x2_Vcm x2_x2_net6 6.75515f
Cbud_s2_1562 x2_Vcm x2_x2_net7 6.75515f
Cbud_s2_1563 x2_Vcm x2_x2_net8 3.35556f
Cbud_s2_1564 x2_Vcm x2_x2_net9 4.24688f
Cbud_s2_1565 x2_Vout x2_Vtest 7.14994f
Cbud_s2_1566 x2_Vout x2_x1_net1 1.20851f
Cbud_s2_1567 x2_Vout x2_x1_net10 1.60896f
Cbud_s2_1568 x2_Vout x2_x1_net11 1.38732f
Cbud_s2_1569 x2_Vout x2_x1_net12 3.35698f
Cbud_s2_1570 x2_Vout x2_x1_net13 4.24868f
Cbud_s2_1571 x2_Vout x2_x1_net14 5.54929f
Cbud_s2_1572 x2_Vout x2_x1_net15 6.23194f
Cbud_s2_1573 x2_Vout x2_x1_net16 6.23194f
Cbud_s2_1574 x2_Vout x2_x1_net17 6.23194f
Cbud_s2_1575 x2_Vout x2_x1_net18 6.23194f
Cbud_s2_1576 x2_Vout x2_x1_net19 6.23194f
Cbud_s2_1577 x2_Vout x2_x1_net2 2.71915f
Cbud_s2_1578 x2_Vout x2_x1_net3 6.23194f
Cbud_s2_1579 x2_Vout x2_x1_net4 0.961679f
Cbud_s2_1580 x2_Vout x2_x1_net5 0.961679f
Cbud_s2_1581 x2_Vout x2_x1_net6 0.96168f
Cbud_s2_1582 x2_Vout x2_x1_net7 1.06216f
Cbud_s2_1583 x2_Vout x2_x1_net8 2.24723f
Cbud_s2_1584 x2_Vout x2_x1_net9 1.8883f
Cbud_s2_1585 x2_Vout x2_x2_net1 6.23194f
Cbud_s2_1586 x2_Vout x2_x2_net10 5.54929f
Cbud_s2_1587 x2_Vout x2_x2_net11 6.23194f
Cbud_s2_1588 x2_Vout x2_x2_net12 2.24723f
Cbud_s2_1589 x2_Vout x2_x2_net13 1.8883f
Cbud_s2_1590 x2_Vout x2_x2_net14 1.60896f
Cbud_s2_1591 x2_Vout x2_x2_net15 1.38732f
Cbud_s2_1592 x2_Vout x2_x2_net16 0.961679f
Cbud_s2_1593 x2_Vout x2_x2_net17 0.961679f
Cbud_s2_1594 x2_Vout x2_x2_net18 0.96168f
Cbud_s2_1595 x2_Vout x2_x2_net19 1.06216f
Cbud_s2_1596 x2_Vout x2_x2_net2 2.71915f
Cbud_s2_1597 x2_Vout x2_x2_net3 1.20851f
Cbud_s2_1598 x2_Vout x2_x2_net4 6.23194f
Cbud_s2_1599 x2_Vout x2_x2_net5 6.23194f
Cbud_s2_1600 x2_Vout x2_x2_net6 6.23194f
Cbud_s2_1601 x2_Vout x2_x2_net7 6.23194f
Cbud_s2_1602 x2_Vout x2_x2_net8 3.35698f
Cbud_s2_1603 x2_Vout x2_x2_net9 4.24868f
Cbud_s2_1604 x2_Vout Vm 1.19379f
Cbud_s2_1605 x2_Vout Vp 1.19379f
Cbud_s2_1606 x2_Vtest x2_x1_net1 1.20801f
Cbud_s2_1607 x2_Vtest x2_x1_net10 1.6083f
Cbud_s2_1608 x2_Vtest x2_x1_net11 1.38675f
Cbud_s2_1609 x2_Vtest x2_x1_net12 3.3556f
Cbud_s2_1610 x2_Vtest x2_x1_net13 4.24693f
Cbud_s2_1611 x2_Vtest x2_x1_net14 5.54702f
Cbud_s2_1612 x2_Vtest x2_x1_net15 6.7072f
Cbud_s2_1613 x2_Vtest x2_x1_net16 6.7072f
Cbud_s2_1614 x2_Vtest x2_x1_net17 6.7072f
Cbud_s2_1615 x2_Vtest x2_x1_net18 6.7072f
Cbud_s2_1616 x2_Vtest x2_x1_net19 6.7072f
Cbud_s2_1617 x2_Vtest x2_x1_net2 2.71804f
Cbud_s2_1618 x2_Vtest x2_x1_net3 6.7072f
Cbud_s2_1619 x2_Vtest x2_x1_net4 1.03502f
Cbud_s2_1620 x2_Vtest x2_x1_net5 1.03502f
Cbud_s2_1621 x2_Vtest x2_x1_net6 1.03502f
Cbud_s2_1622 x2_Vtest x2_x1_net7 1.06173f
Cbud_s2_1623 x2_Vtest x2_x1_net8 2.24631f
Cbud_s2_1624 x2_Vtest x2_x1_net9 1.88752f
Cbud_s2_1625 x2_Vtest x2_x2_net1 6.7072f
Cbud_s2_1626 x2_Vtest x2_x2_net10 5.54702f
Cbud_s2_1627 x2_Vtest x2_x2_net11 6.7072f
Cbud_s2_1628 x2_Vtest x2_x2_net12 2.24631f
Cbud_s2_1629 x2_Vtest x2_x2_net13 1.88752f
Cbud_s2_1630 x2_Vtest x2_x2_net14 1.6083f
Cbud_s2_1631 x2_Vtest x2_x2_net15 1.38675f
Cbud_s2_1632 x2_Vtest x2_x2_net16 1.03502f
Cbud_s2_1633 x2_Vtest x2_x2_net17 1.03502f
Cbud_s2_1634 x2_Vtest x2_x2_net18 1.03502f
Cbud_s2_1635 x2_Vtest x2_x2_net19 1.06173f
Cbud_s2_1636 x2_Vtest x2_x2_net2 2.71804f
Cbud_s2_1637 x2_Vtest x2_x2_net3 1.20801f
Cbud_s2_1638 x2_Vtest x2_x2_net4 6.7072f
Cbud_s2_1639 x2_Vtest x2_x2_net5 6.7072f
Cbud_s2_1640 x2_Vtest x2_x2_net6 6.7072f
Cbud_s2_1641 x2_Vtest x2_x2_net7 6.7072f
Cbud_s2_1642 x2_Vtest x2_x2_net8 3.3556f
Cbud_s2_1643 x2_Vtest x2_x2_net9 4.24693f
Cbud_s2_1644 x2_Vtest Vm 1.19379f
Cbud_s2_1645 x2_Vtest Vp 1.19379f
Cbud_s2_1646 x2_net1 x2_x1_net1 1.20813f
Cbud_s2_1647 x2_net1 x2_x1_net10 1.60845f
Cbud_s2_1648 x2_net1 x2_x1_net11 1.38688f
Cbud_s2_1649 x2_net1 x2_x1_net12 3.31341f
Cbud_s2_1650 x2_net1 x2_x1_net13 3.31341f
Cbud_s2_1651 x2_net1 x2_x1_net14 3.31341f
Cbud_s2_1652 x2_net1 x2_x1_net15 3.31341f
Cbud_s2_1653 x2_net1 x2_x1_net16 3.31341f
Cbud_s2_1654 x2_net1 x2_x1_net17 3.31341f
Cbud_s2_1655 x2_net1 x2_x1_net18 3.31341f
Cbud_s2_1656 x2_net1 x2_x1_net19 3.31341f
Cbud_s2_1657 x2_net1 x2_x1_net2 2.71828f
Cbud_s2_1658 x2_net1 x2_x1_net3 3.31341f
Cbud_s2_1659 x2_net1 x2_x1_net4 0.752986f
Cbud_s2_1660 x2_net1 x2_x1_net5 0.838975f
Cbud_s2_1661 x2_net1 x2_x1_net6 0.940582f
Cbud_s2_1662 x2_net1 x2_x1_net7 1.06183f
Cbud_s2_1663 x2_net1 x2_x1_net8 2.24652f
Cbud_s2_1664 x2_net1 x2_x1_net9 1.8877f
Cbud_s2_1665 x2_net1 x2_x2_net1 3.31341f
Cbud_s2_1666 x2_net1 x2_x2_net10 3.31341f
Cbud_s2_1667 x2_net1 x2_x2_net11 3.31341f
Cbud_s2_1668 x2_net1 x2_x2_net12 2.24652f
Cbud_s2_1669 x2_net1 x2_x2_net13 1.8877f
Cbud_s2_1670 x2_net1 x2_x2_net14 1.60845f
Cbud_s2_1671 x2_net1 x2_x2_net15 1.38688f
Cbud_s2_1672 x2_net1 x2_x2_net16 0.752986f
Cbud_s2_1673 x2_net1 x2_x2_net17 0.838975f
Cbud_s2_1674 x2_net1 x2_x2_net18 0.940582f
Cbud_s2_1675 x2_net1 x2_x2_net19 1.06183f
Cbud_s2_1676 x2_net1 x2_x2_net2 2.71828f
Cbud_s2_1677 x2_net1 x2_x2_net3 1.20813f
Cbud_s2_1678 x2_net1 x2_x2_net4 3.31341f
Cbud_s2_1679 x2_net1 x2_x2_net5 3.31341f
Cbud_s2_1680 x2_net1 x2_x2_net6 3.31341f
Cbud_s2_1681 x2_net1 x2_x2_net7 3.31341f
Cbud_s2_1682 x2_net1 x2_x2_net8 3.31341f
Cbud_s2_1683 x2_net1 x2_x2_net9 3.31341f
Cbud_s2_1684 x2_net1 Vm 1.19379f
Cbud_s2_1685 x2_x1_net1 x2_x1_net10 6.75515f
Cbud_s2_1686 x2_x1_net1 x2_x1_net11 6.75515f
Cbud_s2_1687 x2_x1_net1 x2_x1_net12 6.75515f
Cbud_s2_1688 x2_x1_net1 x2_x1_net13 5.54695f
Cbud_s2_1689 x2_x1_net1 x2_x1_net14 4.24688f
Cbud_s2_1690 x2_x1_net1 x2_x1_net15 3.35556f
Cbud_s2_1691 x2_x1_net1 x2_x1_net16 1.38674f
Cbud_s2_1692 x2_x1_net1 x2_x1_net17 1.60829f
Cbud_s2_1693 x2_x1_net1 x2_x1_net18 1.8875f
Cbud_s2_1694 x2_x1_net1 x2_x1_net19 2.24628f
Cbud_s2_1695 x2_x1_net1 x2_x1_net2 6.75515f
Cbud_s2_1696 x2_x1_net1 x2_x1_net3 2.718f
Cbud_s2_1697 x2_x1_net1 x2_x1_net4 6.75515f
Cbud_s2_1698 x2_x1_net1 x2_x1_net5 6.75515f
Cbud_s2_1699 x2_x1_net1 x2_x1_net6 6.75515f
Cbud_s2_1700 x2_x1_net1 x2_x1_net7 6.75515f
Cbud_s2_1701 x2_x1_net1 x2_x1_net8 6.75515f
Cbud_s2_1702 x2_x1_net1 x2_x1_net9 6.75515f
Cbud_s2_1703 x2_x1_net1 x2_x2_net1 1.04242f
Cbud_s2_1704 x2_x1_net1 x2_x2_net10 1.04242f
Cbud_s2_1705 x2_x1_net1 x2_x2_net11 1.04242f
Cbud_s2_1706 x2_x1_net1 x2_x2_net12 1.04242f
Cbud_s2_1707 x2_x1_net1 x2_x2_net13 1.04242f
Cbud_s2_1708 x2_x1_net1 x2_x2_net14 1.04242f
Cbud_s2_1709 x2_x1_net1 x2_x2_net15 1.04242f
Cbud_s2_1710 x2_x1_net1 x2_x2_net16 1.04242f
Cbud_s2_1711 x2_x1_net1 x2_x2_net17 1.04242f
Cbud_s2_1712 x2_x1_net1 x2_x2_net18 1.04242f
Cbud_s2_1713 x2_x1_net1 x2_x2_net19 1.04242f
Cbud_s2_1714 x2_x1_net1 x2_x2_net2 1.04242f
Cbud_s2_1715 x2_x1_net1 x2_x2_net3 1.04242f
Cbud_s2_1716 x2_x1_net1 x2_x2_net4 1.06172f
Cbud_s2_1717 x2_x1_net1 x2_x2_net5 1.04242f
Cbud_s2_1718 x2_x1_net1 x2_x2_net6 1.04242f
Cbud_s2_1719 x2_x1_net1 x2_x2_net7 1.04242f
Cbud_s2_1720 x2_x1_net1 x2_x2_net8 1.04242f
Cbud_s2_1721 x2_x1_net1 x2_x2_net9 1.04242f
Cbud_s2_1722 x2_x1_net1 Vm 1.1698f
Cbud_s2_1723 x2_x1_net1 Vp 0.964f
Cbud_s2_1724 x2_x1_net10 x2_x1_net11 6.75515f
Cbud_s2_1725 x2_x1_net10 x2_x1_net12 6.75515f
Cbud_s2_1726 x2_x1_net10 x2_x1_net13 6.75515f
Cbud_s2_1727 x2_x1_net10 x2_x1_net14 6.75515f
Cbud_s2_1728 x2_x1_net10 x2_x1_net15 5.54695f
Cbud_s2_1729 x2_x1_net10 x2_x1_net16 1.8875f
Cbud_s2_1730 x2_x1_net10 x2_x1_net17 2.24628f
Cbud_s2_1731 x2_x1_net10 x2_x1_net18 2.718f
Cbud_s2_1732 x2_x1_net10 x2_x1_net19 3.35556f
Cbud_s2_1733 x2_x1_net10 x2_x1_net2 6.75515f
Cbud_s2_1734 x2_x1_net10 x2_x1_net3 4.24688f
Cbud_s2_1735 x2_x1_net10 x2_x1_net4 6.75515f
Cbud_s2_1736 x2_x1_net10 x2_x1_net5 6.75515f
Cbud_s2_1737 x2_x1_net10 x2_x1_net6 6.75515f
Cbud_s2_1738 x2_x1_net10 x2_x1_net7 6.75515f
Cbud_s2_1739 x2_x1_net10 x2_x1_net8 6.75515f
Cbud_s2_1740 x2_x1_net10 x2_x1_net9 6.75515f
Cbud_s2_1741 x2_x1_net10 x2_x2_net1 1.04242f
Cbud_s2_1742 x2_x1_net10 x2_x2_net10 1.04242f
Cbud_s2_1743 x2_x1_net10 x2_x2_net11 1.04242f
Cbud_s2_1744 x2_x1_net10 x2_x2_net12 1.04242f
Cbud_s2_1745 x2_x1_net10 x2_x2_net13 1.04242f
Cbud_s2_1746 x2_x1_net10 x2_x2_net14 1.04242f
Cbud_s2_1747 x2_x1_net10 x2_x2_net15 1.04242f
Cbud_s2_1748 x2_x1_net10 x2_x2_net16 1.04242f
Cbud_s2_1749 x2_x1_net10 x2_x2_net17 1.04242f
Cbud_s2_1750 x2_x1_net10 x2_x2_net18 1.04242f
Cbud_s2_1751 x2_x1_net10 x2_x2_net19 1.04242f
Cbud_s2_1752 x2_x1_net10 x2_x2_net2 1.04242f
Cbud_s2_1753 x2_x1_net10 x2_x2_net3 1.04242f
Cbud_s2_1754 x2_x1_net10 x2_x2_net4 1.38674f
Cbud_s2_1755 x2_x1_net10 x2_x2_net5 1.208f
Cbud_s2_1756 x2_x1_net10 x2_x2_net6 1.06172f
Cbud_s2_1757 x2_x1_net10 x2_x2_net7 1.04242f
Cbud_s2_1758 x2_x1_net10 x2_x2_net8 1.04242f
Cbud_s2_1759 x2_x1_net10 x2_x2_net9 1.04242f
Cbud_s2_1760 x2_x1_net10 Vm 1.19379f
Cbud_s2_1761 x2_x1_net10 Vp 1.19379f
Cbud_s2_1762 x2_x1_net11 x2_x1_net12 6.75515f
Cbud_s2_1763 x2_x1_net11 x2_x1_net13 6.75515f
Cbud_s2_1764 x2_x1_net11 x2_x1_net14 5.54695f
Cbud_s2_1765 x2_x1_net11 x2_x1_net15 4.24688f
Cbud_s2_1766 x2_x1_net11 x2_x1_net16 1.60829f
Cbud_s2_1767 x2_x1_net11 x2_x1_net17 1.8875f
Cbud_s2_1768 x2_x1_net11 x2_x1_net18 2.24628f
Cbud_s2_1769 x2_x1_net11 x2_x1_net19 2.718f
Cbud_s2_1770 x2_x1_net11 x2_x1_net2 6.75515f
Cbud_s2_1771 x2_x1_net11 x2_x1_net3 3.35556f
Cbud_s2_1772 x2_x1_net11 x2_x1_net4 6.75515f
Cbud_s2_1773 x2_x1_net11 x2_x1_net5 6.75515f
Cbud_s2_1774 x2_x1_net11 x2_x1_net6 6.75515f
Cbud_s2_1775 x2_x1_net11 x2_x1_net7 6.75515f
Cbud_s2_1776 x2_x1_net11 x2_x1_net8 6.75515f
Cbud_s2_1777 x2_x1_net11 x2_x1_net9 6.75515f
Cbud_s2_1778 x2_x1_net11 x2_x2_net1 1.04242f
Cbud_s2_1779 x2_x1_net11 x2_x2_net10 1.04242f
Cbud_s2_1780 x2_x1_net11 x2_x2_net11 1.04242f
Cbud_s2_1781 x2_x1_net11 x2_x2_net12 1.04242f
Cbud_s2_1782 x2_x1_net11 x2_x2_net13 1.04242f
Cbud_s2_1783 x2_x1_net11 x2_x2_net14 1.04242f
Cbud_s2_1784 x2_x1_net11 x2_x2_net15 1.04242f
Cbud_s2_1785 x2_x1_net11 x2_x2_net16 1.04242f
Cbud_s2_1786 x2_x1_net11 x2_x2_net17 1.04242f
Cbud_s2_1787 x2_x1_net11 x2_x2_net18 1.04242f
Cbud_s2_1788 x2_x1_net11 x2_x2_net19 1.04242f
Cbud_s2_1789 x2_x1_net11 x2_x2_net2 1.04242f
Cbud_s2_1790 x2_x1_net11 x2_x2_net3 1.04242f
Cbud_s2_1791 x2_x1_net11 x2_x2_net4 1.208f
Cbud_s2_1792 x2_x1_net11 x2_x2_net5 1.06172f
Cbud_s2_1793 x2_x1_net11 x2_x2_net6 1.04242f
Cbud_s2_1794 x2_x1_net11 x2_x2_net7 1.04242f
Cbud_s2_1795 x2_x1_net11 x2_x2_net8 1.04242f
Cbud_s2_1796 x2_x1_net11 x2_x2_net9 1.04242f
Cbud_s2_1797 x2_x1_net11 Vm 1.19379f
Cbud_s2_1798 x2_x1_net11 Vp 1.09089f
Cbud_s2_1799 x2_x1_net12 x2_x1_net13 6.75515f
Cbud_s2_1800 x2_x1_net12 x2_x1_net14 6.75515f
Cbud_s2_1801 x2_x1_net12 x2_x1_net15 6.75515f
Cbud_s2_1802 x2_x1_net12 x2_x1_net16 4.24688f
Cbud_s2_1803 x2_x1_net12 x2_x1_net17 5.54695f
Cbud_s2_1804 x2_x1_net12 x2_x1_net18 6.75515f
Cbud_s2_1805 x2_x1_net12 x2_x1_net19 6.75515f
Cbud_s2_1806 x2_x1_net12 x2_x1_net2 6.75515f
Cbud_s2_1807 x2_x1_net12 x2_x1_net3 6.75515f
Cbud_s2_1808 x2_x1_net12 x2_x1_net4 2.718f
Cbud_s2_1809 x2_x1_net12 x2_x1_net5 3.35556f
Cbud_s2_1810 x2_x1_net12 x2_x1_net6 4.24688f
Cbud_s2_1811 x2_x1_net12 x2_x1_net7 5.54695f
Cbud_s2_1812 x2_x1_net12 x2_x1_net8 6.75515f
Cbud_s2_1813 x2_x1_net12 x2_x1_net9 6.75515f
Cbud_s2_1814 x2_x1_net12 x2_x2_net1 1.38674f
Cbud_s2_1815 x2_x1_net12 x2_x2_net10 1.06172f
Cbud_s2_1816 x2_x1_net12 x2_x2_net11 1.208f
Cbud_s2_1817 x2_x1_net12 x2_x2_net12 1.04242f
Cbud_s2_1818 x2_x1_net12 x2_x2_net13 1.04242f
Cbud_s2_1819 x2_x1_net12 x2_x2_net14 1.04242f
Cbud_s2_1820 x2_x1_net12 x2_x2_net15 1.04242f
Cbud_s2_1821 x2_x1_net12 x2_x2_net16 1.04242f
Cbud_s2_1822 x2_x1_net12 x2_x2_net17 1.04242f
Cbud_s2_1823 x2_x1_net12 x2_x2_net18 1.04242f
Cbud_s2_1824 x2_x1_net12 x2_x2_net19 1.04242f
Cbud_s2_1825 x2_x1_net12 x2_x2_net2 1.04242f
Cbud_s2_1826 x2_x1_net12 x2_x2_net3 1.04242f
Cbud_s2_1827 x2_x1_net12 x2_x2_net4 2.718f
Cbud_s2_1828 x2_x1_net12 x2_x2_net5 2.24628f
Cbud_s2_1829 x2_x1_net12 x2_x2_net6 1.8875f
Cbud_s2_1830 x2_x1_net12 x2_x2_net7 1.60829f
Cbud_s2_1831 x2_x1_net12 x2_x2_net8 1.04242f
Cbud_s2_1832 x2_x1_net12 x2_x2_net9 1.04242f
Cbud_s2_1833 x2_x1_net12 Vm 1.19379f
Cbud_s2_1834 x2_x1_net12 Vp 1.19379f
Cbud_s2_1835 x2_x1_net13 x2_x1_net14 6.75515f
Cbud_s2_1836 x2_x1_net13 x2_x1_net15 6.75515f
Cbud_s2_1837 x2_x1_net13 x2_x1_net16 5.54695f
Cbud_s2_1838 x2_x1_net13 x2_x1_net17 6.75515f
Cbud_s2_1839 x2_x1_net13 x2_x1_net18 6.75515f
Cbud_s2_1840 x2_x1_net13 x2_x1_net19 6.75515f
Cbud_s2_1841 x2_x1_net13 x2_x1_net2 6.75515f
Cbud_s2_1842 x2_x1_net13 x2_x1_net3 6.75515f
Cbud_s2_1843 x2_x1_net13 x2_x1_net4 2.24628f
Cbud_s2_1844 x2_x1_net13 x2_x1_net5 2.718f
Cbud_s2_1845 x2_x1_net13 x2_x1_net6 3.35556f
Cbud_s2_1846 x2_x1_net13 x2_x1_net7 4.24688f
Cbud_s2_1847 x2_x1_net13 x2_x1_net8 6.75515f
Cbud_s2_1848 x2_x1_net13 x2_x1_net9 6.75515f
Cbud_s2_1849 x2_x1_net13 x2_x2_net1 1.60829f
Cbud_s2_1850 x2_x1_net13 x2_x2_net10 1.208f
Cbud_s2_1851 x2_x1_net13 x2_x2_net11 1.38674f
Cbud_s2_1852 x2_x1_net13 x2_x2_net12 1.04242f
Cbud_s2_1853 x2_x1_net13 x2_x2_net13 1.04242f
Cbud_s2_1854 x2_x1_net13 x2_x2_net14 1.04242f
Cbud_s2_1855 x2_x1_net13 x2_x2_net15 1.04242f
Cbud_s2_1856 x2_x1_net13 x2_x2_net16 1.04242f
Cbud_s2_1857 x2_x1_net13 x2_x2_net17 1.04242f
Cbud_s2_1858 x2_x1_net13 x2_x2_net18 1.04242f
Cbud_s2_1859 x2_x1_net13 x2_x2_net19 1.04242f
Cbud_s2_1860 x2_x1_net13 x2_x2_net2 1.04242f
Cbud_s2_1861 x2_x1_net13 x2_x2_net3 1.04242f
Cbud_s2_1862 x2_x1_net13 x2_x2_net4 3.35556f
Cbud_s2_1863 x2_x1_net13 x2_x2_net5 2.718f
Cbud_s2_1864 x2_x1_net13 x2_x2_net6 2.24628f
Cbud_s2_1865 x2_x1_net13 x2_x2_net7 1.8875f
Cbud_s2_1866 x2_x1_net13 x2_x2_net8 1.04242f
Cbud_s2_1867 x2_x1_net13 x2_x2_net9 1.06172f
Cbud_s2_1868 x2_x1_net13 Vm 1.19379f
Cbud_s2_1869 x2_x1_net13 Vp 1.19379f
Cbud_s2_1870 x2_x1_net14 x2_x1_net15 6.75515f
Cbud_s2_1871 x2_x1_net14 x2_x1_net16 6.75515f
Cbud_s2_1872 x2_x1_net14 x2_x1_net17 6.75515f
Cbud_s2_1873 x2_x1_net14 x2_x1_net18 6.75515f
Cbud_s2_1874 x2_x1_net14 x2_x1_net19 6.75515f
Cbud_s2_1875 x2_x1_net14 x2_x1_net2 6.75515f
Cbud_s2_1876 x2_x1_net14 x2_x1_net3 6.75515f
Cbud_s2_1877 x2_x1_net14 x2_x1_net4 1.8875f
Cbud_s2_1878 x2_x1_net14 x2_x1_net5 2.24628f
Cbud_s2_1879 x2_x1_net14 x2_x1_net6 2.718f
Cbud_s2_1880 x2_x1_net14 x2_x1_net7 3.35556f
Cbud_s2_1881 x2_x1_net14 x2_x1_net8 6.75515f
Cbud_s2_1882 x2_x1_net14 x2_x1_net9 6.75515f
Cbud_s2_1883 x2_x1_net14 x2_x2_net1 1.8875f
Cbud_s2_1884 x2_x1_net14 x2_x2_net10 1.38674f
Cbud_s2_1885 x2_x1_net14 x2_x2_net11 1.60829f
Cbud_s2_1886 x2_x1_net14 x2_x2_net12 1.04242f
Cbud_s2_1887 x2_x1_net14 x2_x2_net13 1.04242f
Cbud_s2_1888 x2_x1_net14 x2_x2_net14 1.04242f
Cbud_s2_1889 x2_x1_net14 x2_x2_net15 1.04242f
Cbud_s2_1890 x2_x1_net14 x2_x2_net16 1.04242f
Cbud_s2_1891 x2_x1_net14 x2_x2_net17 1.04242f
Cbud_s2_1892 x2_x1_net14 x2_x2_net18 1.04242f
Cbud_s2_1893 x2_x1_net14 x2_x2_net19 1.04242f
Cbud_s2_1894 x2_x1_net14 x2_x2_net2 1.04242f
Cbud_s2_1895 x2_x1_net14 x2_x2_net3 1.04242f
Cbud_s2_1896 x2_x1_net14 x2_x2_net4 4.24688f
Cbud_s2_1897 x2_x1_net14 x2_x2_net5 3.35556f
Cbud_s2_1898 x2_x1_net14 x2_x2_net6 2.718f
Cbud_s2_1899 x2_x1_net14 x2_x2_net7 2.24628f
Cbud_s2_1900 x2_x1_net14 x2_x2_net8 1.06172f
Cbud_s2_1901 x2_x1_net14 x2_x2_net9 1.208f
Cbud_s2_1902 x2_x1_net14 Vm 1.19379f
Cbud_s2_1903 x2_x1_net14 Vp 1.19379f
Cbud_s2_1904 x2_x1_net15 x2_x1_net16 6.75515f
Cbud_s2_1905 x2_x1_net15 x2_x1_net17 6.75515f
Cbud_s2_1906 x2_x1_net15 x2_x1_net18 6.75515f
Cbud_s2_1907 x2_x1_net15 x2_x1_net19 6.75515f
Cbud_s2_1908 x2_x1_net15 x2_x1_net2 6.75515f
Cbud_s2_1909 x2_x1_net15 x2_x1_net3 6.75515f
Cbud_s2_1910 x2_x1_net15 x2_x1_net4 1.60829f
Cbud_s2_1911 x2_x1_net15 x2_x1_net5 1.8875f
Cbud_s2_1912 x2_x1_net15 x2_x1_net6 2.24628f
Cbud_s2_1913 x2_x1_net15 x2_x1_net7 2.718f
Cbud_s2_1914 x2_x1_net15 x2_x1_net8 6.75515f
Cbud_s2_1915 x2_x1_net15 x2_x1_net9 6.75515f
Cbud_s2_1916 x2_x1_net15 x2_x2_net1 2.24628f
Cbud_s2_1917 x2_x1_net15 x2_x2_net10 1.60829f
Cbud_s2_1918 x2_x1_net15 x2_x2_net11 1.8875f
Cbud_s2_1919 x2_x1_net15 x2_x2_net12 1.04242f
Cbud_s2_1920 x2_x1_net15 x2_x2_net13 1.04242f
Cbud_s2_1921 x2_x1_net15 x2_x2_net14 1.04242f
Cbud_s2_1922 x2_x1_net15 x2_x2_net15 1.04242f
Cbud_s2_1923 x2_x1_net15 x2_x2_net16 1.04242f
Cbud_s2_1924 x2_x1_net15 x2_x2_net17 1.04242f
Cbud_s2_1925 x2_x1_net15 x2_x2_net18 1.04242f
Cbud_s2_1926 x2_x1_net15 x2_x2_net19 1.04242f
Cbud_s2_1927 x2_x1_net15 x2_x2_net2 1.06172f
Cbud_s2_1928 x2_x1_net15 x2_x2_net3 1.04242f
Cbud_s2_1929 x2_x1_net15 x2_x2_net4 5.54695f
Cbud_s2_1930 x2_x1_net15 x2_x2_net5 4.24688f
Cbud_s2_1931 x2_x1_net15 x2_x2_net6 3.35556f
Cbud_s2_1932 x2_x1_net15 x2_x2_net7 2.718f
Cbud_s2_1933 x2_x1_net15 x2_x2_net8 1.208f
Cbud_s2_1934 x2_x1_net15 x2_x2_net9 1.38674f
Cbud_s2_1935 x2_x1_net15 Vm 1.19379f
Cbud_s2_1936 x2_x1_net15 Vp 1.19379f
Cbud_s2_1937 x2_x1_net16 x2_x1_net17 6.75515f
Cbud_s2_1938 x2_x1_net16 x2_x1_net18 6.75515f
Cbud_s2_1939 x2_x1_net16 x2_x1_net19 6.75515f
Cbud_s2_1940 x2_x1_net16 x2_x1_net2 3.35556f
Cbud_s2_1941 x2_x1_net16 x2_x1_net3 6.75515f
Cbud_s2_1942 x2_x1_net16 x2_x1_net4 1.04242f
Cbud_s2_1943 x2_x1_net16 x2_x1_net5 1.04242f
Cbud_s2_1944 x2_x1_net16 x2_x1_net6 1.06172f
Cbud_s2_1945 x2_x1_net16 x2_x1_net7 1.208f
Cbud_s2_1946 x2_x1_net16 x2_x1_net8 2.718f
Cbud_s2_1947 x2_x1_net16 x2_x1_net9 2.24628f
Cbud_s2_1948 x2_x1_net16 x2_x2_net1 6.75515f
Cbud_s2_1949 x2_x1_net16 x2_x2_net10 4.24688f
Cbud_s2_1950 x2_x1_net16 x2_x2_net11 5.54695f
Cbud_s2_1951 x2_x1_net16 x2_x2_net12 1.8875f
Cbud_s2_1952 x2_x1_net16 x2_x2_net13 1.60829f
Cbud_s2_1953 x2_x1_net16 x2_x2_net14 1.38674f
Cbud_s2_1954 x2_x1_net16 x2_x2_net15 1.208f
Cbud_s2_1955 x2_x1_net16 x2_x2_net16 1.04242f
Cbud_s2_1956 x2_x1_net16 x2_x2_net17 1.04242f
Cbud_s2_1957 x2_x1_net16 x2_x2_net18 1.04242f
Cbud_s2_1958 x2_x1_net16 x2_x2_net19 1.04242f
Cbud_s2_1959 x2_x1_net16 x2_x2_net2 2.24628f
Cbud_s2_1960 x2_x1_net16 x2_x2_net3 1.06172f
Cbud_s2_1961 x2_x1_net16 x2_x2_net4 6.75515f
Cbud_s2_1962 x2_x1_net16 x2_x2_net5 6.75515f
Cbud_s2_1963 x2_x1_net16 x2_x2_net6 6.75515f
Cbud_s2_1964 x2_x1_net16 x2_x2_net7 6.75515f
Cbud_s2_1965 x2_x1_net16 x2_x2_net8 2.718f
Cbud_s2_1966 x2_x1_net16 x2_x2_net9 3.35556f
Cbud_s2_1967 x2_x1_net16 Vm 1.19379f
Cbud_s2_1968 x2_x1_net16 Vp 1.19379f
Cbud_s2_1969 x2_x1_net17 x2_x1_net18 6.75515f
Cbud_s2_1970 x2_x1_net17 x2_x1_net19 6.75515f
Cbud_s2_1971 x2_x1_net17 x2_x1_net2 4.24688f
Cbud_s2_1972 x2_x1_net17 x2_x1_net3 6.75515f
Cbud_s2_1973 x2_x1_net17 x2_x1_net4 1.04242f
Cbud_s2_1974 x2_x1_net17 x2_x1_net5 1.06172f
Cbud_s2_1975 x2_x1_net17 x2_x1_net6 1.208f
Cbud_s2_1976 x2_x1_net17 x2_x1_net7 1.38674f
Cbud_s2_1977 x2_x1_net17 x2_x1_net8 3.35556f
Cbud_s2_1978 x2_x1_net17 x2_x1_net9 2.718f
Cbud_s2_1979 x2_x1_net17 x2_x2_net1 5.54695f
Cbud_s2_1980 x2_x1_net17 x2_x2_net10 3.35556f
Cbud_s2_1981 x2_x1_net17 x2_x2_net11 4.24688f
Cbud_s2_1982 x2_x1_net17 x2_x2_net12 1.60829f
Cbud_s2_1983 x2_x1_net17 x2_x2_net13 1.38674f
Cbud_s2_1984 x2_x1_net17 x2_x2_net14 1.208f
Cbud_s2_1985 x2_x1_net17 x2_x2_net15 1.06172f
Cbud_s2_1986 x2_x1_net17 x2_x2_net16 1.04242f
Cbud_s2_1987 x2_x1_net17 x2_x2_net17 1.04242f
Cbud_s2_1988 x2_x1_net17 x2_x2_net18 1.04242f
Cbud_s2_1989 x2_x1_net17 x2_x2_net19 1.04242f
Cbud_s2_1990 x2_x1_net17 x2_x2_net2 1.8875f
Cbud_s2_1991 x2_x1_net17 x2_x2_net3 1.04242f
Cbud_s2_1992 x2_x1_net17 x2_x2_net4 6.75515f
Cbud_s2_1993 x2_x1_net17 x2_x2_net5 6.75515f
Cbud_s2_1994 x2_x1_net17 x2_x2_net6 6.75515f
Cbud_s2_1995 x2_x1_net17 x2_x2_net7 6.75515f
Cbud_s2_1996 x2_x1_net17 x2_x2_net8 2.24628f
Cbud_s2_1997 x2_x1_net17 x2_x2_net9 2.718f
Cbud_s2_1998 x2_x1_net17 Vm 1.19379f
Cbud_s2_1999 x2_x1_net17 Vp 1.19379f
Cbud_s2_2000 x2_x1_net18 x2_x1_net19 6.75515f
Cbud_s2_2001 x2_x1_net18 x2_x1_net2 5.54695f
Cbud_s2_2002 x2_x1_net18 x2_x1_net3 6.75515f
Cbud_s2_2003 x2_x1_net18 x2_x1_net4 1.06172f
Cbud_s2_2004 x2_x1_net18 x2_x1_net5 1.208f
Cbud_s2_2005 x2_x1_net18 x2_x1_net6 1.38674f
Cbud_s2_2006 x2_x1_net18 x2_x1_net7 1.60829f
Cbud_s2_2007 x2_x1_net18 x2_x1_net8 4.24688f
Cbud_s2_2008 x2_x1_net18 x2_x1_net9 3.35556f
Cbud_s2_2009 x2_x1_net18 x2_x2_net1 4.24688f
Cbud_s2_2010 x2_x1_net18 x2_x2_net10 2.718f
Cbud_s2_2011 x2_x1_net18 x2_x2_net11 3.35556f
Cbud_s2_2012 x2_x1_net18 x2_x2_net12 1.38674f
Cbud_s2_2013 x2_x1_net18 x2_x2_net13 1.208f
Cbud_s2_2014 x2_x1_net18 x2_x2_net14 1.06172f
Cbud_s2_2015 x2_x1_net18 x2_x2_net15 1.04242f
Cbud_s2_2016 x2_x1_net18 x2_x2_net16 1.04242f
Cbud_s2_2017 x2_x1_net18 x2_x2_net17 1.04242f
Cbud_s2_2018 x2_x1_net18 x2_x2_net18 1.04242f
Cbud_s2_2019 x2_x1_net18 x2_x2_net19 1.04242f
Cbud_s2_2020 x2_x1_net18 x2_x2_net2 1.60829f
Cbud_s2_2021 x2_x1_net18 x2_x2_net3 1.04242f
Cbud_s2_2022 x2_x1_net18 x2_x2_net4 6.75515f
Cbud_s2_2023 x2_x1_net18 x2_x2_net5 6.75515f
Cbud_s2_2024 x2_x1_net18 x2_x2_net6 6.75515f
Cbud_s2_2025 x2_x1_net18 x2_x2_net7 5.54695f
Cbud_s2_2026 x2_x1_net18 x2_x2_net8 1.8875f
Cbud_s2_2027 x2_x1_net18 x2_x2_net9 2.24628f
Cbud_s2_2028 x2_x1_net18 Vm 1.19379f
Cbud_s2_2029 x2_x1_net18 Vp 1.19379f
Cbud_s2_2030 x2_x1_net19 x2_x1_net2 6.75515f
Cbud_s2_2031 x2_x1_net19 x2_x1_net3 6.75515f
Cbud_s2_2032 x2_x1_net19 x2_x1_net4 1.208f
Cbud_s2_2033 x2_x1_net19 x2_x1_net5 1.38674f
Cbud_s2_2034 x2_x1_net19 x2_x1_net6 1.60829f
Cbud_s2_2035 x2_x1_net19 x2_x1_net7 1.8875f
Cbud_s2_2036 x2_x1_net19 x2_x1_net8 5.54695f
Cbud_s2_2037 x2_x1_net19 x2_x1_net9 4.24688f
Cbud_s2_2038 x2_x1_net19 x2_x2_net1 3.35556f
Cbud_s2_2039 x2_x1_net19 x2_x2_net10 2.24628f
Cbud_s2_2040 x2_x1_net19 x2_x2_net11 2.718f
Cbud_s2_2041 x2_x1_net19 x2_x2_net12 1.208f
Cbud_s2_2042 x2_x1_net19 x2_x2_net13 1.06172f
Cbud_s2_2043 x2_x1_net19 x2_x2_net14 1.04242f
Cbud_s2_2044 x2_x1_net19 x2_x2_net15 1.04242f
Cbud_s2_2045 x2_x1_net19 x2_x2_net16 1.04242f
Cbud_s2_2046 x2_x1_net19 x2_x2_net17 1.04242f
Cbud_s2_2047 x2_x1_net19 x2_x2_net18 1.04242f
Cbud_s2_2048 x2_x1_net19 x2_x2_net19 1.04242f
Cbud_s2_2049 x2_x1_net19 x2_x2_net2 1.38674f
Cbud_s2_2050 x2_x1_net19 x2_x2_net3 1.04242f
Cbud_s2_2051 x2_x1_net19 x2_x2_net4 6.75515f
Cbud_s2_2052 x2_x1_net19 x2_x2_net5 6.75515f
Cbud_s2_2053 x2_x1_net19 x2_x2_net6 5.54695f
Cbud_s2_2054 x2_x1_net19 x2_x2_net7 4.24688f
Cbud_s2_2055 x2_x1_net19 x2_x2_net8 1.60829f
Cbud_s2_2056 x2_x1_net19 x2_x2_net9 1.8875f
Cbud_s2_2057 x2_x1_net19 Vm 1.19379f
Cbud_s2_2058 x2_x1_net19 Vp 1.19379f
Cbud_s2_2059 x2_x1_net2 x2_x1_net3 6.75515f
Cbud_s2_2060 x2_x1_net2 x2_x1_net4 3.35556f
Cbud_s2_2061 x2_x1_net2 x2_x1_net5 4.24688f
Cbud_s2_2062 x2_x1_net2 x2_x1_net6 5.54695f
Cbud_s2_2063 x2_x1_net2 x2_x1_net7 6.75515f
Cbud_s2_2064 x2_x1_net2 x2_x1_net8 6.75515f
Cbud_s2_2065 x2_x1_net2 x2_x1_net9 6.75515f
Cbud_s2_2066 x2_x1_net2 x2_x2_net1 1.208f
Cbud_s2_2067 x2_x1_net2 x2_x2_net10 1.04242f
Cbud_s2_2068 x2_x1_net2 x2_x2_net11 1.06172f
Cbud_s2_2069 x2_x1_net2 x2_x2_net12 1.04242f
Cbud_s2_2070 x2_x1_net2 x2_x2_net13 1.04242f
Cbud_s2_2071 x2_x1_net2 x2_x2_net14 1.04242f
Cbud_s2_2072 x2_x1_net2 x2_x2_net15 1.04242f
Cbud_s2_2073 x2_x1_net2 x2_x2_net16 1.04242f
Cbud_s2_2074 x2_x1_net2 x2_x2_net17 1.04242f
Cbud_s2_2075 x2_x1_net2 x2_x2_net18 1.04242f
Cbud_s2_2076 x2_x1_net2 x2_x2_net19 1.04242f
Cbud_s2_2077 x2_x1_net2 x2_x2_net2 1.04242f
Cbud_s2_2078 x2_x1_net2 x2_x2_net3 1.04242f
Cbud_s2_2079 x2_x1_net2 x2_x2_net4 2.24628f
Cbud_s2_2080 x2_x1_net2 x2_x2_net5 1.8875f
Cbud_s2_2081 x2_x1_net2 x2_x2_net6 1.60829f
Cbud_s2_2082 x2_x1_net2 x2_x2_net7 1.38674f
Cbud_s2_2083 x2_x1_net2 x2_x2_net8 1.04242f
Cbud_s2_2084 x2_x1_net2 x2_x2_net9 1.04242f
Cbud_s2_2085 x2_x1_net2 Vm 1.19379f
Cbud_s2_2086 x2_x1_net2 Vp 1.19379f
Cbud_s2_2087 x2_x1_net3 x2_x1_net4 1.38674f
Cbud_s2_2088 x2_x1_net3 x2_x1_net5 1.60829f
Cbud_s2_2089 x2_x1_net3 x2_x1_net6 1.8875f
Cbud_s2_2090 x2_x1_net3 x2_x1_net7 2.24628f
Cbud_s2_2091 x2_x1_net3 x2_x1_net8 6.75515f
Cbud_s2_2092 x2_x1_net3 x2_x1_net9 5.54695f
Cbud_s2_2093 x2_x1_net3 x2_x2_net1 2.718f
Cbud_s2_2094 x2_x1_net3 x2_x2_net10 1.8875f
Cbud_s2_2095 x2_x1_net3 x2_x2_net11 2.24628f
Cbud_s2_2096 x2_x1_net3 x2_x2_net12 1.06172f
Cbud_s2_2097 x2_x1_net3 x2_x2_net13 1.04242f
Cbud_s2_2098 x2_x1_net3 x2_x2_net14 1.04242f
Cbud_s2_2099 x2_x1_net3 x2_x2_net15 1.04242f
Cbud_s2_2100 x2_x1_net3 x2_x2_net16 1.04242f
Cbud_s2_2101 x2_x1_net3 x2_x2_net17 1.04242f
Cbud_s2_2102 x2_x1_net3 x2_x2_net18 1.04242f
Cbud_s2_2103 x2_x1_net3 x2_x2_net19 1.04242f
Cbud_s2_2104 x2_x1_net3 x2_x2_net2 1.208f
Cbud_s2_2105 x2_x1_net3 x2_x2_net3 1.04242f
Cbud_s2_2106 x2_x1_net3 x2_x2_net4 6.75515f
Cbud_s2_2107 x2_x1_net3 x2_x2_net5 5.54695f
Cbud_s2_2108 x2_x1_net3 x2_x2_net6 4.24688f
Cbud_s2_2109 x2_x1_net3 x2_x2_net7 3.35556f
Cbud_s2_2110 x2_x1_net3 x2_x2_net8 1.38674f
Cbud_s2_2111 x2_x1_net3 x2_x2_net9 1.60829f
Cbud_s2_2112 x2_x1_net3 Vm 1.19379f
Cbud_s2_2113 x2_x1_net3 Vp 1.19379f
Cbud_s2_2114 x2_x1_net4 x2_x1_net5 6.75515f
Cbud_s2_2115 x2_x1_net4 x2_x1_net6 6.75515f
Cbud_s2_2116 x2_x1_net4 x2_x1_net7 6.75515f
Cbud_s2_2117 x2_x1_net4 x2_x1_net8 4.24688f
Cbud_s2_2118 x2_x1_net4 x2_x1_net9 5.54695f
Cbud_s2_2119 x2_x1_net4 x2_x2_net1 1.04242f
Cbud_s2_2120 x2_x1_net4 x2_x2_net10 1.04242f
Cbud_s2_2121 x2_x1_net4 x2_x2_net11 1.04242f
Cbud_s2_2122 x2_x1_net4 x2_x2_net12 1.04242f
Cbud_s2_2123 x2_x1_net4 x2_x2_net13 1.04242f
Cbud_s2_2124 x2_x1_net4 x2_x2_net14 1.04242f
Cbud_s2_2125 x2_x1_net4 x2_x2_net15 1.04242f
Cbud_s2_2126 x2_x1_net4 x2_x2_net16 1.04242f
Cbud_s2_2127 x2_x1_net4 x2_x2_net17 1.04242f
Cbud_s2_2128 x2_x1_net4 x2_x2_net18 1.04242f
Cbud_s2_2129 x2_x1_net4 x2_x2_net19 1.04242f
Cbud_s2_2130 x2_x1_net4 x2_x2_net2 1.04242f
Cbud_s2_2131 x2_x1_net4 x2_x2_net3 1.04242f
Cbud_s2_2132 x2_x1_net4 x2_x2_net4 1.04242f
Cbud_s2_2133 x2_x1_net4 x2_x2_net5 1.04242f
Cbud_s2_2134 x2_x1_net4 x2_x2_net6 1.04242f
Cbud_s2_2135 x2_x1_net4 x2_x2_net7 1.04242f
Cbud_s2_2136 x2_x1_net4 x2_x2_net8 1.04242f
Cbud_s2_2137 x2_x1_net4 x2_x2_net9 1.04242f
Cbud_s2_2138 x2_x1_net4 Vm 0.735222f
Cbud_s2_2139 x2_x1_net4 Vp 0.627515f
Cbud_s2_2140 x2_x1_net5 x2_x1_net6 6.75515f
Cbud_s2_2141 x2_x1_net5 x2_x1_net7 6.75515f
Cbud_s2_2142 x2_x1_net5 x2_x1_net8 5.54695f
Cbud_s2_2143 x2_x1_net5 x2_x1_net9 6.75515f
Cbud_s2_2144 x2_x1_net5 x2_x2_net1 1.04242f
Cbud_s2_2145 x2_x1_net5 x2_x2_net10 1.04242f
Cbud_s2_2146 x2_x1_net5 x2_x2_net11 1.04242f
Cbud_s2_2147 x2_x1_net5 x2_x2_net12 1.04242f
Cbud_s2_2148 x2_x1_net5 x2_x2_net13 1.04242f
Cbud_s2_2149 x2_x1_net5 x2_x2_net14 1.04242f
Cbud_s2_2150 x2_x1_net5 x2_x2_net15 1.04242f
Cbud_s2_2151 x2_x1_net5 x2_x2_net16 1.04242f
Cbud_s2_2152 x2_x1_net5 x2_x2_net17 1.04242f
Cbud_s2_2153 x2_x1_net5 x2_x2_net18 1.04242f
Cbud_s2_2154 x2_x1_net5 x2_x2_net19 1.04242f
Cbud_s2_2155 x2_x1_net5 x2_x2_net2 1.04242f
Cbud_s2_2156 x2_x1_net5 x2_x2_net3 1.04242f
Cbud_s2_2157 x2_x1_net5 x2_x2_net4 1.04242f
Cbud_s2_2158 x2_x1_net5 x2_x2_net5 1.04242f
Cbud_s2_2159 x2_x1_net5 x2_x2_net6 1.04242f
Cbud_s2_2160 x2_x1_net5 x2_x2_net7 1.04242f
Cbud_s2_2161 x2_x1_net5 x2_x2_net8 1.04242f
Cbud_s2_2162 x2_x1_net5 x2_x2_net9 1.04242f
Cbud_s2_2163 x2_x1_net5 Vm 0.817752f
Cbud_s2_2164 x2_x1_net5 Vp 0.692766f
Cbud_s2_2165 x2_x1_net6 x2_x1_net7 6.75515f
Cbud_s2_2166 x2_x1_net6 x2_x1_net8 6.75515f
Cbud_s2_2167 x2_x1_net6 x2_x1_net9 6.75515f
Cbud_s2_2168 x2_x1_net6 x2_x2_net1 1.04242f
Cbud_s2_2169 x2_x1_net6 x2_x2_net10 1.04242f
Cbud_s2_2170 x2_x1_net6 x2_x2_net11 1.04242f
Cbud_s2_2171 x2_x1_net6 x2_x2_net12 1.04242f
Cbud_s2_2172 x2_x1_net6 x2_x2_net13 1.04242f
Cbud_s2_2173 x2_x1_net6 x2_x2_net14 1.04242f
Cbud_s2_2174 x2_x1_net6 x2_x2_net15 1.04242f
Cbud_s2_2175 x2_x1_net6 x2_x2_net16 1.04242f
Cbud_s2_2176 x2_x1_net6 x2_x2_net17 1.04242f
Cbud_s2_2177 x2_x1_net6 x2_x2_net18 1.04242f
Cbud_s2_2178 x2_x1_net6 x2_x2_net19 1.04242f
Cbud_s2_2179 x2_x1_net6 x2_x2_net2 1.04242f
Cbud_s2_2180 x2_x1_net6 x2_x2_net3 1.04242f
Cbud_s2_2181 x2_x1_net6 x2_x2_net4 1.04242f
Cbud_s2_2182 x2_x1_net6 x2_x2_net5 1.04242f
Cbud_s2_2183 x2_x1_net6 x2_x2_net6 1.04242f
Cbud_s2_2184 x2_x1_net6 x2_x2_net7 1.04242f
Cbud_s2_2185 x2_x1_net6 x2_x2_net8 1.04242f
Cbud_s2_2186 x2_x1_net6 x2_x2_net9 1.04242f
Cbud_s2_2187 x2_x1_net6 Vm 0.915002f
Cbud_s2_2188 x2_x1_net6 Vp 0.768788f
Cbud_s2_2189 x2_x1_net7 x2_x1_net8 6.75515f
Cbud_s2_2190 x2_x1_net7 x2_x1_net9 6.75515f
Cbud_s2_2191 x2_x1_net7 x2_x2_net1 1.04242f
Cbud_s2_2192 x2_x1_net7 x2_x2_net10 1.04242f
Cbud_s2_2193 x2_x1_net7 x2_x2_net11 1.04242f
Cbud_s2_2194 x2_x1_net7 x2_x2_net12 1.04242f
Cbud_s2_2195 x2_x1_net7 x2_x2_net13 1.04242f
Cbud_s2_2196 x2_x1_net7 x2_x2_net14 1.04242f
Cbud_s2_2197 x2_x1_net7 x2_x2_net15 1.04242f
Cbud_s2_2198 x2_x1_net7 x2_x2_net16 1.04242f
Cbud_s2_2199 x2_x1_net7 x2_x2_net17 1.04242f
Cbud_s2_2200 x2_x1_net7 x2_x2_net18 1.04242f
Cbud_s2_2201 x2_x1_net7 x2_x2_net19 1.04242f
Cbud_s2_2202 x2_x1_net7 x2_x2_net2 1.04242f
Cbud_s2_2203 x2_x1_net7 x2_x2_net3 1.04242f
Cbud_s2_2204 x2_x1_net7 x2_x2_net4 1.04242f
Cbud_s2_2205 x2_x1_net7 x2_x2_net5 1.04242f
Cbud_s2_2206 x2_x1_net7 x2_x2_net6 1.04242f
Cbud_s2_2207 x2_x1_net7 x2_x2_net7 1.04242f
Cbud_s2_2208 x2_x1_net7 x2_x2_net8 1.04242f
Cbud_s2_2209 x2_x1_net7 x2_x2_net9 1.04242f
Cbud_s2_2210 x2_x1_net7 Vm 1.03069f
Cbud_s2_2211 x2_x1_net7 Vp 0.858099f
Cbud_s2_2212 x2_x1_net8 x2_x1_net9 6.75515f
Cbud_s2_2213 x2_x1_net8 x2_x2_net1 1.06172f
Cbud_s2_2214 x2_x1_net8 x2_x2_net10 1.04242f
Cbud_s2_2215 x2_x1_net8 x2_x2_net11 1.04242f
Cbud_s2_2216 x2_x1_net8 x2_x2_net12 1.04242f
Cbud_s2_2217 x2_x1_net8 x2_x2_net13 1.04242f
Cbud_s2_2218 x2_x1_net8 x2_x2_net14 1.04242f
Cbud_s2_2219 x2_x1_net8 x2_x2_net15 1.04242f
Cbud_s2_2220 x2_x1_net8 x2_x2_net16 1.04242f
Cbud_s2_2221 x2_x1_net8 x2_x2_net17 1.04242f
Cbud_s2_2222 x2_x1_net8 x2_x2_net18 1.04242f
Cbud_s2_2223 x2_x1_net8 x2_x2_net19 1.04242f
Cbud_s2_2224 x2_x1_net8 x2_x2_net2 1.04242f
Cbud_s2_2225 x2_x1_net8 x2_x2_net3 1.04242f
Cbud_s2_2226 x2_x1_net8 x2_x2_net4 1.8875f
Cbud_s2_2227 x2_x1_net8 x2_x2_net5 1.60829f
Cbud_s2_2228 x2_x1_net8 x2_x2_net6 1.38674f
Cbud_s2_2229 x2_x1_net8 x2_x2_net7 1.208f
Cbud_s2_2230 x2_x1_net8 x2_x2_net8 1.04242f
Cbud_s2_2231 x2_x1_net8 x2_x2_net9 1.04242f
Cbud_s2_2232 x2_x1_net8 Vm 1.19379f
Cbud_s2_2233 x2_x1_net8 Vp 1.19379f
Cbud_s2_2234 x2_x1_net9 x2_x2_net1 1.04242f
Cbud_s2_2235 x2_x1_net9 x2_x2_net10 1.04242f
Cbud_s2_2236 x2_x1_net9 x2_x2_net11 1.04242f
Cbud_s2_2237 x2_x1_net9 x2_x2_net12 1.04242f
Cbud_s2_2238 x2_x1_net9 x2_x2_net13 1.04242f
Cbud_s2_2239 x2_x1_net9 x2_x2_net14 1.04242f
Cbud_s2_2240 x2_x1_net9 x2_x2_net15 1.04242f
Cbud_s2_2241 x2_x1_net9 x2_x2_net16 1.04242f
Cbud_s2_2242 x2_x1_net9 x2_x2_net17 1.04242f
Cbud_s2_2243 x2_x1_net9 x2_x2_net18 1.04242f
Cbud_s2_2244 x2_x1_net9 x2_x2_net19 1.04242f
Cbud_s2_2245 x2_x1_net9 x2_x2_net2 1.04242f
Cbud_s2_2246 x2_x1_net9 x2_x2_net3 1.04242f
Cbud_s2_2247 x2_x1_net9 x2_x2_net4 1.60829f
Cbud_s2_2248 x2_x1_net9 x2_x2_net5 1.38674f
Cbud_s2_2249 x2_x1_net9 x2_x2_net6 1.208f
Cbud_s2_2250 x2_x1_net9 x2_x2_net7 1.06172f
Cbud_s2_2251 x2_x1_net9 x2_x2_net8 1.04242f
Cbud_s2_2252 x2_x1_net9 x2_x2_net9 1.04242f
Cbud_s2_2253 x2_x1_net9 Vm 1.19379f
Cbud_s2_2254 x2_x1_net9 Vp 1.19379f
Cbud_s2_2255 x2_x2_net1 x2_x2_net10 6.75515f
Cbud_s2_2256 x2_x2_net1 x2_x2_net11 6.75515f
Cbud_s2_2257 x2_x2_net1 x2_x2_net12 6.75515f
Cbud_s2_2258 x2_x2_net1 x2_x2_net13 5.54695f
Cbud_s2_2259 x2_x2_net1 x2_x2_net14 4.24688f
Cbud_s2_2260 x2_x2_net1 x2_x2_net15 3.35556f
Cbud_s2_2261 x2_x2_net1 x2_x2_net16 1.38674f
Cbud_s2_2262 x2_x2_net1 x2_x2_net17 1.60829f
Cbud_s2_2263 x2_x2_net1 x2_x2_net18 1.8875f
Cbud_s2_2264 x2_x2_net1 x2_x2_net19 2.24628f
Cbud_s2_2265 x2_x2_net1 x2_x2_net2 6.75515f
Cbud_s2_2266 x2_x2_net1 x2_x2_net3 2.718f
Cbud_s2_2267 x2_x2_net1 x2_x2_net4 6.75515f
Cbud_s2_2268 x2_x2_net1 x2_x2_net5 6.75515f
Cbud_s2_2269 x2_x2_net1 x2_x2_net6 6.75515f
Cbud_s2_2270 x2_x2_net1 x2_x2_net7 6.75515f
Cbud_s2_2271 x2_x2_net1 x2_x2_net8 6.75515f
Cbud_s2_2272 x2_x2_net1 x2_x2_net9 6.75515f
Cbud_s2_2273 x2_x2_net1 Vm 1.19379f
Cbud_s2_2274 x2_x2_net1 Vp 1.19379f
Cbud_s2_2275 x2_x2_net10 x2_x2_net11 6.75515f
Cbud_s2_2276 x2_x2_net10 x2_x2_net12 6.75515f
Cbud_s2_2277 x2_x2_net10 x2_x2_net13 6.75515f
Cbud_s2_2278 x2_x2_net10 x2_x2_net14 6.75515f
Cbud_s2_2279 x2_x2_net10 x2_x2_net15 5.54695f
Cbud_s2_2280 x2_x2_net10 x2_x2_net16 1.8875f
Cbud_s2_2281 x2_x2_net10 x2_x2_net17 2.24628f
Cbud_s2_2282 x2_x2_net10 x2_x2_net18 2.718f
Cbud_s2_2283 x2_x2_net10 x2_x2_net19 3.35556f
Cbud_s2_2284 x2_x2_net10 x2_x2_net2 6.75515f
Cbud_s2_2285 x2_x2_net10 x2_x2_net3 4.24688f
Cbud_s2_2286 x2_x2_net10 x2_x2_net4 6.75515f
Cbud_s2_2287 x2_x2_net10 x2_x2_net5 6.75515f
Cbud_s2_2288 x2_x2_net10 x2_x2_net6 6.75515f
Cbud_s2_2289 x2_x2_net10 x2_x2_net7 6.75515f
Cbud_s2_2290 x2_x2_net10 x2_x2_net8 6.75515f
Cbud_s2_2291 x2_x2_net10 x2_x2_net9 6.75515f
Cbud_s2_2292 x2_x2_net10 Vm 1.19379f
Cbud_s2_2293 x2_x2_net10 Vp 1.19379f
Cbud_s2_2294 x2_x2_net11 x2_x2_net12 6.75515f
Cbud_s2_2295 x2_x2_net11 x2_x2_net13 6.75515f
Cbud_s2_2296 x2_x2_net11 x2_x2_net14 5.54695f
Cbud_s2_2297 x2_x2_net11 x2_x2_net15 4.24688f
Cbud_s2_2298 x2_x2_net11 x2_x2_net16 1.60829f
Cbud_s2_2299 x2_x2_net11 x2_x2_net17 1.8875f
Cbud_s2_2300 x2_x2_net11 x2_x2_net18 2.24628f
Cbud_s2_2301 x2_x2_net11 x2_x2_net19 2.718f
Cbud_s2_2302 x2_x2_net11 x2_x2_net2 6.75515f
Cbud_s2_2303 x2_x2_net11 x2_x2_net3 3.35556f
Cbud_s2_2304 x2_x2_net11 x2_x2_net4 6.75515f
Cbud_s2_2305 x2_x2_net11 x2_x2_net5 6.75515f
Cbud_s2_2306 x2_x2_net11 x2_x2_net6 6.75515f
Cbud_s2_2307 x2_x2_net11 x2_x2_net7 6.75515f
Cbud_s2_2308 x2_x2_net11 x2_x2_net8 6.75515f
Cbud_s2_2309 x2_x2_net11 x2_x2_net9 6.75515f
Cbud_s2_2310 x2_x2_net11 Vm 1.19379f
Cbud_s2_2311 x2_x2_net11 Vp 1.19379f
Cbud_s2_2312 x2_x2_net12 x2_x2_net13 6.75515f
Cbud_s2_2313 x2_x2_net12 x2_x2_net14 6.75515f
Cbud_s2_2314 x2_x2_net12 x2_x2_net15 6.75515f
Cbud_s2_2315 x2_x2_net12 x2_x2_net16 4.24688f
Cbud_s2_2316 x2_x2_net12 x2_x2_net17 5.54695f
Cbud_s2_2317 x2_x2_net12 x2_x2_net18 6.75515f
Cbud_s2_2318 x2_x2_net12 x2_x2_net19 6.75515f
Cbud_s2_2319 x2_x2_net12 x2_x2_net2 6.75515f
Cbud_s2_2320 x2_x2_net12 x2_x2_net3 6.75515f
Cbud_s2_2321 x2_x2_net12 x2_x2_net4 2.718f
Cbud_s2_2322 x2_x2_net12 x2_x2_net5 3.35556f
Cbud_s2_2323 x2_x2_net12 x2_x2_net6 4.24688f
Cbud_s2_2324 x2_x2_net12 x2_x2_net7 5.54695f
Cbud_s2_2325 x2_x2_net12 x2_x2_net8 6.75515f
Cbud_s2_2326 x2_x2_net12 x2_x2_net9 6.75515f
Cbud_s2_2327 x2_x2_net12 Vm 1.19379f
Cbud_s2_2328 x2_x2_net12 Vp 1.19379f
Cbud_s2_2329 x2_x2_net13 x2_x2_net14 6.75515f
Cbud_s2_2330 x2_x2_net13 x2_x2_net15 6.75515f
Cbud_s2_2331 x2_x2_net13 x2_x2_net16 5.54695f
Cbud_s2_2332 x2_x2_net13 x2_x2_net17 6.75515f
Cbud_s2_2333 x2_x2_net13 x2_x2_net18 6.75515f
Cbud_s2_2334 x2_x2_net13 x2_x2_net19 6.75515f
Cbud_s2_2335 x2_x2_net13 x2_x2_net2 6.75515f
Cbud_s2_2336 x2_x2_net13 x2_x2_net3 6.75515f
Cbud_s2_2337 x2_x2_net13 x2_x2_net4 2.24628f
Cbud_s2_2338 x2_x2_net13 x2_x2_net5 2.718f
Cbud_s2_2339 x2_x2_net13 x2_x2_net6 3.35556f
Cbud_s2_2340 x2_x2_net13 x2_x2_net7 4.24688f
Cbud_s2_2341 x2_x2_net13 x2_x2_net8 6.75515f
Cbud_s2_2342 x2_x2_net13 x2_x2_net9 6.75515f
Cbud_s2_2343 x2_x2_net13 Vm 1.19379f
Cbud_s2_2344 x2_x2_net13 Vp 1.19379f
Cbud_s2_2345 x2_x2_net14 x2_x2_net15 6.75515f
Cbud_s2_2346 x2_x2_net14 x2_x2_net16 6.75515f
Cbud_s2_2347 x2_x2_net14 x2_x2_net17 6.75515f
Cbud_s2_2348 x2_x2_net14 x2_x2_net18 6.75515f
Cbud_s2_2349 x2_x2_net14 x2_x2_net19 6.75515f
Cbud_s2_2350 x2_x2_net14 x2_x2_net2 6.75515f
Cbud_s2_2351 x2_x2_net14 x2_x2_net3 6.75515f
Cbud_s2_2352 x2_x2_net14 x2_x2_net4 1.8875f
Cbud_s2_2353 x2_x2_net14 x2_x2_net5 2.24628f
Cbud_s2_2354 x2_x2_net14 x2_x2_net6 2.718f
Cbud_s2_2355 x2_x2_net14 x2_x2_net7 3.35556f
Cbud_s2_2356 x2_x2_net14 x2_x2_net8 6.75515f
Cbud_s2_2357 x2_x2_net14 x2_x2_net9 6.75515f
Cbud_s2_2358 x2_x2_net14 Vm 1.19379f
Cbud_s2_2359 x2_x2_net14 Vp 1.19379f
Cbud_s2_2360 x2_x2_net15 x2_x2_net16 6.75515f
Cbud_s2_2361 x2_x2_net15 x2_x2_net17 6.75515f
Cbud_s2_2362 x2_x2_net15 x2_x2_net18 6.75515f
Cbud_s2_2363 x2_x2_net15 x2_x2_net19 6.75515f
Cbud_s2_2364 x2_x2_net15 x2_x2_net2 6.75515f
Cbud_s2_2365 x2_x2_net15 x2_x2_net3 6.75515f
Cbud_s2_2366 x2_x2_net15 x2_x2_net4 1.60829f
Cbud_s2_2367 x2_x2_net15 x2_x2_net5 1.8875f
Cbud_s2_2368 x2_x2_net15 x2_x2_net6 2.24628f
Cbud_s2_2369 x2_x2_net15 x2_x2_net7 2.718f
Cbud_s2_2370 x2_x2_net15 x2_x2_net8 6.75515f
Cbud_s2_2371 x2_x2_net15 x2_x2_net9 6.75515f
Cbud_s2_2372 x2_x2_net15 Vm 1.09089f
Cbud_s2_2373 x2_x2_net15 Vp 1.19379f
Cbud_s2_2374 x2_x2_net16 x2_x2_net17 6.75515f
Cbud_s2_2375 x2_x2_net16 x2_x2_net18 6.75515f
Cbud_s2_2376 x2_x2_net16 x2_x2_net19 6.75515f
Cbud_s2_2377 x2_x2_net16 x2_x2_net2 3.35556f
Cbud_s2_2378 x2_x2_net16 x2_x2_net3 6.75515f
Cbud_s2_2379 x2_x2_net16 x2_x2_net4 1.04242f
Cbud_s2_2380 x2_x2_net16 x2_x2_net5 1.04242f
Cbud_s2_2381 x2_x2_net16 x2_x2_net6 1.06172f
Cbud_s2_2382 x2_x2_net16 x2_x2_net7 1.208f
Cbud_s2_2383 x2_x2_net16 x2_x2_net8 2.718f
Cbud_s2_2384 x2_x2_net16 x2_x2_net9 2.24628f
Cbud_s2_2385 x2_x2_net16 Vm 0.627515f
Cbud_s2_2386 x2_x2_net16 Vp 0.735222f
Cbud_s2_2387 x2_x2_net17 x2_x2_net18 6.75515f
Cbud_s2_2388 x2_x2_net17 x2_x2_net19 6.75515f
Cbud_s2_2389 x2_x2_net17 x2_x2_net2 4.24688f
Cbud_s2_2390 x2_x2_net17 x2_x2_net3 6.75515f
Cbud_s2_2391 x2_x2_net17 x2_x2_net4 1.04242f
Cbud_s2_2392 x2_x2_net17 x2_x2_net5 1.06172f
Cbud_s2_2393 x2_x2_net17 x2_x2_net6 1.208f
Cbud_s2_2394 x2_x2_net17 x2_x2_net7 1.38674f
Cbud_s2_2395 x2_x2_net17 x2_x2_net8 3.35556f
Cbud_s2_2396 x2_x2_net17 x2_x2_net9 2.718f
Cbud_s2_2397 x2_x2_net17 Vm 0.692766f
Cbud_s2_2398 x2_x2_net17 Vp 0.817752f
Cbud_s2_2399 x2_x2_net18 x2_x2_net19 6.75515f
Cbud_s2_2400 x2_x2_net18 x2_x2_net2 5.54695f
Cbud_s2_2401 x2_x2_net18 x2_x2_net3 6.75515f
Cbud_s2_2402 x2_x2_net18 x2_x2_net4 1.06172f
Cbud_s2_2403 x2_x2_net18 x2_x2_net5 1.208f
Cbud_s2_2404 x2_x2_net18 x2_x2_net6 1.38674f
Cbud_s2_2405 x2_x2_net18 x2_x2_net7 1.60829f
Cbud_s2_2406 x2_x2_net18 x2_x2_net8 4.24688f
Cbud_s2_2407 x2_x2_net18 x2_x2_net9 3.35556f
Cbud_s2_2408 x2_x2_net18 Vm 0.768788f
Cbud_s2_2409 x2_x2_net18 Vp 0.915002f
Cbud_s2_2410 x2_x2_net19 x2_x2_net2 6.75515f
Cbud_s2_2411 x2_x2_net19 x2_x2_net3 6.75515f
Cbud_s2_2412 x2_x2_net19 x2_x2_net4 1.208f
Cbud_s2_2413 x2_x2_net19 x2_x2_net5 1.38674f
Cbud_s2_2414 x2_x2_net19 x2_x2_net6 1.60829f
Cbud_s2_2415 x2_x2_net19 x2_x2_net7 1.8875f
Cbud_s2_2416 x2_x2_net19 x2_x2_net8 5.54695f
Cbud_s2_2417 x2_x2_net19 x2_x2_net9 4.24688f
Cbud_s2_2418 x2_x2_net19 Vm 0.858099f
Cbud_s2_2419 x2_x2_net19 Vp 1.03069f
Cbud_s2_2420 x2_x2_net2 x2_x2_net3 6.75515f
Cbud_s2_2421 x2_x2_net2 x2_x2_net4 3.35556f
Cbud_s2_2422 x2_x2_net2 x2_x2_net5 4.24688f
Cbud_s2_2423 x2_x2_net2 x2_x2_net6 5.54695f
Cbud_s2_2424 x2_x2_net2 x2_x2_net7 6.75515f
Cbud_s2_2425 x2_x2_net2 x2_x2_net8 6.75515f
Cbud_s2_2426 x2_x2_net2 x2_x2_net9 6.75515f
Cbud_s2_2427 x2_x2_net2 Vm 1.19379f
Cbud_s2_2428 x2_x2_net2 Vp 1.19379f
Cbud_s2_2429 x2_x2_net3 x2_x2_net4 1.38674f
Cbud_s2_2430 x2_x2_net3 x2_x2_net5 1.60829f
Cbud_s2_2431 x2_x2_net3 x2_x2_net6 1.8875f
Cbud_s2_2432 x2_x2_net3 x2_x2_net7 2.24628f
Cbud_s2_2433 x2_x2_net3 x2_x2_net8 6.75515f
Cbud_s2_2434 x2_x2_net3 x2_x2_net9 5.54695f
Cbud_s2_2435 x2_x2_net3 Vm 0.964f
Cbud_s2_2436 x2_x2_net3 Vp 1.1698f
Cbud_s2_2437 x2_x2_net4 x2_x2_net5 6.75515f
Cbud_s2_2438 x2_x2_net4 x2_x2_net6 6.75515f
Cbud_s2_2439 x2_x2_net4 x2_x2_net7 6.75515f
Cbud_s2_2440 x2_x2_net4 x2_x2_net8 4.24688f
Cbud_s2_2441 x2_x2_net4 x2_x2_net9 5.54695f
Cbud_s2_2442 x2_x2_net4 Vm 1.19379f
Cbud_s2_2443 x2_x2_net4 Vp 1.19379f
Cbud_s2_2444 x2_x2_net5 x2_x2_net6 6.75515f
Cbud_s2_2445 x2_x2_net5 x2_x2_net7 6.75515f
Cbud_s2_2446 x2_x2_net5 x2_x2_net8 5.54695f
Cbud_s2_2447 x2_x2_net5 x2_x2_net9 6.75515f
Cbud_s2_2448 x2_x2_net5 Vm 1.19379f
Cbud_s2_2449 x2_x2_net5 Vp 1.19379f
Cbud_s2_2450 x2_x2_net6 x2_x2_net7 6.75515f
Cbud_s2_2451 x2_x2_net6 x2_x2_net8 6.75515f
Cbud_s2_2452 x2_x2_net6 x2_x2_net9 6.75515f
Cbud_s2_2453 x2_x2_net6 Vm 1.19379f
Cbud_s2_2454 x2_x2_net6 Vp 1.19379f
Cbud_s2_2455 x2_x2_net7 x2_x2_net8 6.75515f
Cbud_s2_2456 x2_x2_net7 x2_x2_net9 6.75515f
Cbud_s2_2457 x2_x2_net7 Vm 1.19379f
Cbud_s2_2458 x2_x2_net7 Vp 1.19379f
Cbud_s2_2459 x2_x2_net8 x2_x2_net9 6.75515f
Cbud_s2_2460 x2_x2_net8 Vm 1.19379f
Cbud_s2_2461 x2_x2_net8 Vp 1.19379f
Cbud_s2_2462 x2_x2_net9 Vm 1.19379f
Cbud_s2_2463 x2_x2_net9 Vp 1.19379f
XM32 s1r_XM32_d PBias s1r_XM32_s Vdd sky130_fd_pr__pfet_01v8_lvt L=1 W=5 NF=1 AD=1.45 AS=1.45 PD=10.58 PS=10.58 NRD=0.058 NRS=0.058 SA=0 SB=0 SD=0 MULT=2 M=2
Rpar_s1_XM32_s s1r_XM32_s Vdd 44.702
Rpar_s1_XM32_d s1r_XM32_d NBias 82.5537
XM33 s1r_XM33_d NBias s1r_XM33_s Vss sky130_fd_pr__nfet_01v8_lvt L=2 W=5 NF=1 AD=1.45 AS=1.45 PD=10.58 PS=10.58 NRD=0.058 NRS=0.058 SA=0 SB=0 SD=0 MULT=2 M=2
Rpar_s1_XM33_s s1r_XM33_s Vss 64.7693
Rpar_s1_XM33_d s1r_XM33_d NBias 70.8957
XM34 s1r_XM34_d PBias s1r_XM34_s Vdd sky130_fd_pr__pfet_01v8_lvt L=1 W=5 NF=1 AD=1.45 AS=1.45 PD=10.58 PS=10.58 NRD=0.058 NRS=0.058 SA=0 SB=0 SD=0 MULT=2 M=2
Rpar_s1_XM34_s s1r_XM34_s Vdd 125.499
Rpar_s1_XM34_d s1r_XM34_d net1 125.499
XM35 s1r_XM35_d net1 s1r_XM35_s Vss sky130_fd_pr__nfet_01v8_lvt L=1 W=10 NF=1 AD=2.9 AS=2.9 PD=20.58 PS=20.58 NRD=0.029 NRS=0.029 SA=0 SB=0 SD=0 MULT=2 M=2
Rpar_s1_XM35_s s1r_XM35_s Rgm 24.4489
Rpar_s1_XM35_d s1r_XM35_d net1 60.4052
XM36 s1r_XM36_d net1 s1r_XM36_s Vss sky130_fd_pr__nfet_01v8_lvt L=2 W=5 NF=1 AD=1.45 AS=1.45 PD=10.58 PS=10.58 NRD=0.058 NRS=0.058 SA=0 SB=0 SD=0 MULT=2 M=2
Rpar_s1_XM36_s s1r_XM36_s Vss 64.7693
Rpar_s1_XM36_d s1r_XM36_d net2 70.8957
XM37 s1r_XM37_d NBias s1r_XM37_s Vss sky130_fd_pr__nfet_01v8_lvt L=2 W=5 NF=1 AD=1.45 AS=1.45 PD=10.58 PS=10.58 NRD=0.058 NRS=0.058 SA=0 SB=0 SD=0 MULT=2 M=2
Rpar_s1_XM37_s s1r_XM37_s Vss 23.0704
Rpar_s1_XM37_d s1r_XM37_d PBias 79.8907
XM38 s1r_XM38_d net2 s1r_XM38_s Vdd sky130_fd_pr__pfet_01v8_lvt L=1 W=5 NF=1 AD=1.45 AS=1.45 PD=10.58 PS=10.58 NRD=0.058 NRS=0.058 SA=0 SB=0 SD=0 MULT=2 M=2
Rpar_s1_XM38_s s1r_XM38_s Vdd 125.499
Rpar_s1_XM38_d s1r_XM38_d PBias 289.681
XM39 s1r_XM39_d net2 s1r_XM39_s Vdd sky130_fd_pr__pfet_01v8_lvt L=1 W=5 NF=1 AD=1.45 AS=1.45 PD=10.58 PS=10.58 NRD=0.058 NRS=0.058 SA=0 SB=0 SD=0 MULT=2 M=2
Rpar_s1_XM39_s s1r_XM39_s Vdd 125.499
Rpar_s1_XM39_d s1r_XM39_d net2 289.681
XM40 PBias net3 NBias Vss sky130_fd_pr__nfet_01v8_lvt L=1 W=2 NF=1 AD=0.58 AS=0.58 PD=4.58 PS=4.58 NRD=0.145 NRS=0.145 SA=0 SB=0 SD=0 MULT=1
XM41 s1r_XM41_d NBias s1r_XM41_s Vss sky130_fd_pr__nfet_01v8_lvt L=2 W=5 NF=1 AD=1.45 AS=1.45 PD=10.58 PS=10.58 NRD=0.058 NRS=0.058 SA=0 SB=0 SD=0 MULT=2 M=2
Rpar_s1_XM41_s s1r_XM41_s Vss 149.502
Rpar_s1_XM41_d s1r_XM41_d net3 149.502
XM42 s1r_XM42_d net3 s1r_XM42_s Vdd sky130_fd_pr__pfet_01v8_lvt L=20 W=1 NF=1 AD=0.29 AS=0.29 PD=2.58 PS=2.58 NRD=0.29 NRS=0.29 SA=0 SB=0 SD=0 MULT=2 M=2
Rpar_s1_XM42_s s1r_XM42_s Vdd 1121.16
Rpar_s1_XM42_d s1r_XM42_d net3 1121.16
XM43 s1r_XM43_d PBias s1r_XM43_s Vdd sky130_fd_pr__pfet_01v8_lvt L=1 W=5 NF=1 AD=1.45 AS=1.45 PD=10.58 PS=10.58 NRD=0.058 NRS=0.058 SA=0 SB=0 SD=0 MULT=2 M=2
Rpar_s1_XM43_s s1r_XM43_s Vdd 44.702
Rpar_s1_XM43_d s1r_XM43_d net4 120.81
XM44 s1r_XM44_d PBias s1r_XM44_s Vdd sky130_fd_pr__pfet_01v8_lvt L=1 W=5 NF=1 AD=1.45 AS=1.45 PD=10.58 PS=10.58 NRD=0.058 NRS=0.058 SA=0 SB=0 SD=0 MULT=2 M=2
Rpar_s1_XM44_s s1r_XM44_s Vdd 44.702
Rpar_s1_XM44_d s1r_XM44_d net5 81.843
XM45 s1r_XM45_d PBias s1r_XM45_s Vdd sky130_fd_pr__pfet_01v8_lvt L=1 W=5 NF=1 AD=1.45 AS=1.45 PD=10.58 PS=10.58 NRD=0.058 NRS=0.058 SA=0 SB=0 SD=0 MULT=2 M=2
Rpar_s1_XM45_s s1r_XM45_s Vdd 44.702
Rpar_s1_XM45_d s1r_XM45_d net6 206.384
XM54 s1r_XM54_d PBias s1r_XM54_s Vdd sky130_fd_pr__pfet_01v8_lvt L=1 W=5 NF=1 AD=1.45 AS=1.45 PD=10.58 PS=10.58 NRD=0.058 NRS=0.058 SA=0 SB=0 SD=0 MULT=2 M=2
Rpar_s1_XM54_s s1r_XM54_s Vdd 289.681
Rpar_s1_XM54_d s1r_XM54_d net7 289.681
XX1_M5 s1r_XX1_M5_d s1r_XX1_M5_g s1r_XX1_M5_s Vss sky130_fd_pr__nfet_01v8_lvt L=4 W=4 NF=1 AD=1.16 AS=1.16 PD=8.58 PS=8.58 NRD=0.0725 NRS=0.0725 SA=0 SB=0 SD=0 MULT=2 M=2
Rpar_s1_XX1_M5_s s1r_XX1_M5_s x1_net2 25.8511
Rpar_s1_XX1_M5_g s1r_XX1_M5_g Vm 20.4193
Rpar_s1_XX1_M5_d s1r_XX1_M5_d x1_Vtest2 167.522
XX1_M6 s1r_XX1_M6_d s1r_XX1_M6_g s1r_XX1_M6_s Vss sky130_fd_pr__nfet_01v8_lvt L=4 W=4 NF=1 AD=1.16 AS=1.16 PD=8.58 PS=8.58 NRD=0.0725 NRS=0.0725 SA=0 SB=0 SD=0 MULT=2 M=2
Rpar_s1_XX1_M6_s s1r_XX1_M6_s x1_net2 25.8511
Rpar_s1_XX1_M6_g s1r_XX1_M6_g Vp 20.4193
Rpar_s1_XX1_M6_d s1r_XX1_M6_d x1_net1 167.522
XX1_M11 s1r_XX1_M11_d x1_Vbias s1r_XX1_M11_s Vdd sky130_fd_pr__pfet_01v8_lvt L=5 W=2 NF=1 AD=0.58 AS=0.58 PD=4.58 PS=4.58 NRD=0.145 NRS=0.145 SA=0 SB=0 SD=0 MULT=2 M=2
Rpar_s1_XX1_M11_s s1r_XX1_M11_s x1_Vtest2 86.8151
Rpar_s1_XX1_M11_d s1r_XX1_M11_d Vop1 243.73
XX1_M12 s1r_XX1_M12_d x1_Vbias s1r_XX1_M12_s Vdd sky130_fd_pr__pfet_01v8_lvt L=5 W=2 NF=1 AD=0.58 AS=0.58 PD=4.58 PS=4.58 NRD=0.145 NRS=0.145 SA=0 SB=0 SD=0 MULT=2 M=2
Rpar_s1_XX1_M12_s s1r_XX1_M12_s x1_net1 86.8151
Rpar_s1_XX1_M12_d s1r_XX1_M12_d Vom1 243.73
XX1_M13 s1r_XX1_M13_d x1_Vout s1r_XX1_M13_s Vdd sky130_fd_pr__pfet_01v8_lvt L=5 W=2 NF=1 AD=0.58 AS=0.58 PD=4.58 PS=4.58 NRD=0.145 NRS=0.145 SA=0 SB=0 SD=0 MULT=4 M=4
Rpar_s1_XX1_M13_s s1r_XX1_M13_s Vdd 341.672
Rpar_s1_XX1_M13_d s1r_XX1_M13_d x1_Vtest2 225.146
XX1_M14 s1r_XX1_M14_d x1_Vout s1r_XX1_M14_s Vdd sky130_fd_pr__pfet_01v8_lvt L=5 W=2 NF=1 AD=0.58 AS=0.58 PD=4.58 PS=4.58 NRD=0.145 NRS=0.145 SA=0 SB=0 SD=0 MULT=4 M=4
Rpar_s1_XX1_M14_s s1r_XX1_M14_s Vdd 341.672
Rpar_s1_XX1_M14_d s1r_XX1_M14_d x1_net1 225.146
XX1_M19 s1r_XX1_M19_d net5 s1r_XX1_M19_s Vss sky130_fd_pr__nfet_01v8_lvt L=1 W=1 NF=1 AD=0.29 AS=0.29 PD=2.58 PS=2.58 NRD=0.29 NRS=0.29 SA=0 SB=0 SD=0 MULT=2 M=2
Rpar_s1_XX1_M19_s s1r_XX1_M19_s x1_net3 201.45
Rpar_s1_XX1_M19_d s1r_XX1_M19_d x1_net2 367.891
XX1_M1 s1r_XX1_M1_d net4 s1r_XX1_M1_s Vss sky130_fd_pr__nfet_01v8_lvt L=10 W=1 NF=1 AD=0.29 AS=0.29 PD=2.58 PS=2.58 NRD=0.29 NRS=0.29 SA=0 SB=0 SD=0 MULT=2 M=2
Rpar_s1_XX1_M1_s s1r_XX1_M1_s Vss 62.9711
Rpar_s1_XX1_M1_d s1r_XX1_M1_d x1_net3 201.45
XX1_M2 s1r_XX1_M2_d net4 s1r_XX1_M2_s Vss sky130_fd_pr__nfet_01v8_lvt L=10 W=1 NF=1 AD=0.29 AS=0.29 PD=2.58 PS=2.58 NRD=0.29 NRS=0.29 SA=0 SB=0 SD=0 MULT=2 M=2
Rpar_s1_XX1_M2_s s1r_XX1_M2_s Vss 62.9711
Rpar_s1_XX1_M2_d s1r_XX1_M2_d x1_net4 201.45
XX1_M3 s1r_XX1_M3_d net5 s1r_XX1_M3_s Vss sky130_fd_pr__nfet_01v8_lvt L=1 W=1 NF=1 AD=0.29 AS=0.29 PD=2.58 PS=2.58 NRD=0.29 NRS=0.29 SA=0 SB=0 SD=0 MULT=2 M=2
Rpar_s1_XX1_M3_s s1r_XX1_M3_s x1_net4 201.45
Rpar_s1_XX1_M3_d s1r_XX1_M3_d x1_net2 367.891
XX1_M4 s1r_XX1_M4_d net5 s1r_XX1_M4_s Vss sky130_fd_pr__nfet_01v8_lvt L=1 W=1 NF=1 AD=0.29 AS=0.29 PD=2.58 PS=2.58 NRD=0.29 NRS=0.29 SA=0 SB=0 SD=0 MULT=2 M=2
Rpar_s1_XX1_M4_s s1r_XX1_M4_s x1_net5 159.383
Rpar_s1_XX1_M4_d s1r_XX1_M4_d Vop1 367.891
XX1_M7 s1r_XX1_M7_d net4 s1r_XX1_M7_s Vss sky130_fd_pr__nfet_01v8_lvt L=10 W=1 NF=1 AD=0.29 AS=0.29 PD=2.58 PS=2.58 NRD=0.29 NRS=0.29 SA=0 SB=0 SD=0 MULT=2 M=2
Rpar_s1_XX1_M7_s s1r_XX1_M7_s Vss 408.069
Rpar_s1_XX1_M7_d s1r_XX1_M7_d x1_net5 176.789
XX1_M8 s1r_XX1_M8_d net5 s1r_XX1_M8_s Vss sky130_fd_pr__nfet_01v8_lvt L=1 W=1 NF=1 AD=0.29 AS=0.29 PD=2.58 PS=2.58 NRD=0.29 NRS=0.29 SA=0 SB=0 SD=0 MULT=2 M=2
Rpar_s1_XX1_M8_s s1r_XX1_M8_s x1_net6 159.383
Rpar_s1_XX1_M8_d s1r_XX1_M8_d Vom1 367.891
XX1_M9 s1r_XX1_M9_d net4 s1r_XX1_M9_s Vss sky130_fd_pr__nfet_01v8_lvt L=10 W=1 NF=1 AD=0.29 AS=0.29 PD=2.58 PS=2.58 NRD=0.29 NRS=0.29 SA=0 SB=0 SD=0 MULT=2 M=2
Rpar_s1_XX1_M9_s s1r_XX1_M9_s Vss 408.069
Rpar_s1_XX1_M9_d s1r_XX1_M9_d x1_net6 176.789
XX1_M10 s1r_XX1_M10_d s1r_XX1_M10_g s1r_XX1_M10_s Vss sky130_fd_pr__nfet_01v8_lvt L=20 W=5 NF=1 AD=1.45 AS=1.45 PD=10.58 PS=10.58 NRD=0.058 NRS=0.058 SA=0 SB=0 SD=0 MULT=2 M=2
Rpar_s1_XX1_M10_s s1r_XX1_M10_s x1_net8 229.859
Rpar_s1_XX1_M10_g s1r_XX1_M10_g Vref 167.933
Rpar_s1_XX1_M10_d s1r_XX1_M10_d x1_Vout 229.859
XX1_M17 s1r_XX1_M17_d s1r_XX1_M17_g s1r_XX1_M17_s Vss sky130_fd_pr__nfet_01v8_lvt L=20 W=5 NF=1 AD=1.45 AS=1.45 PD=10.58 PS=10.58 NRD=0.058 NRS=0.058 SA=0 SB=0 SD=0 MULT=2 M=2
Rpar_s1_XX1_M17_s s1r_XX1_M17_s x1_net8 229.859
Rpar_s1_XX1_M17_g s1r_XX1_M17_g Vop1 167.933
Rpar_s1_XX1_M17_d s1r_XX1_M17_d x1_net9 229.859
XX1_M18 s1r_XX1_M18_d s1r_XX1_M18_g s1r_XX1_M18_s Vss sky130_fd_pr__nfet_01v8_lvt L=20 W=5 NF=1 AD=1.45 AS=1.45 PD=10.58 PS=10.58 NRD=0.058 NRS=0.058 SA=0 SB=0 SD=0 MULT=2 M=2
Rpar_s1_XX1_M18_s s1r_XX1_M18_s x1_net7 229.859
Rpar_s1_XX1_M18_g s1r_XX1_M18_g Vom1 167.933
Rpar_s1_XX1_M18_d s1r_XX1_M18_d x1_net9 229.859
XX1_M22 s1r_XX1_M22_d net4 s1r_XX1_M22_s Vss sky130_fd_pr__nfet_01v8_lvt L=20 W=1 NF=1 AD=0.29 AS=0.29 PD=2.58 PS=2.58 NRD=0.29 NRS=0.29 SA=0 SB=0 SD=0 MULT=2 M=2
Rpar_s1_XX1_M22_s s1r_XX1_M22_s Vss 452.712
Rpar_s1_XX1_M22_d s1r_XX1_M22_d x1_net7 452.712
XX1_M20 s1r_XX1_M20_d x1_net9 s1r_XX1_M20_s Vdd sky130_fd_pr__pfet_01v8_lvt L=10 W=1 NF=1 AD=0.29 AS=0.29 PD=2.58 PS=2.58 NRD=0.29 NRS=0.29 SA=0 SB=0 SD=0 MULT=2 M=2
Rpar_s1_XX1_M20_s s1r_XX1_M20_s Vdd 1076.52
Rpar_s1_XX1_M20_d s1r_XX1_M20_d x1_net9 1076.52
XX1_M21 s1r_XX1_M21_d x1_net9 s1r_XX1_M21_s Vdd sky130_fd_pr__pfet_01v8_lvt L=10 W=1 NF=1 AD=0.29 AS=0.29 PD=2.58 PS=2.58 NRD=0.29 NRS=0.29 SA=0 SB=0 SD=0 MULT=2 M=2
Rpar_s1_XX1_M21_s s1r_XX1_M21_s Vdd 1076.52
Rpar_s1_XX1_M21_d s1r_XX1_M21_d x1_Vout 1076.52
XX1_M15 s1r_XX1_M15_d net4 s1r_XX1_M15_s Vss sky130_fd_pr__nfet_01v8_lvt L=20 W=1 NF=1 AD=0.29 AS=0.29 PD=2.58 PS=2.58 NRD=0.29 NRS=0.29 SA=0 SB=0 SD=0 MULT=2 M=2
Rpar_s1_XX1_M15_s s1r_XX1_M15_s Vss 452.712
Rpar_s1_XX1_M15_d s1r_XX1_M15_d x1_net8 452.712
XX1_M16 s1r_XX1_M16_d s1r_XX1_M16_g s1r_XX1_M16_s Vss sky130_fd_pr__nfet_01v8_lvt L=20 W=5 NF=1 AD=1.45 AS=1.45 PD=10.58 PS=10.58 NRD=0.058 NRS=0.058 SA=0 SB=0 SD=0 MULT=2 M=2
Rpar_s1_XX1_M16_s s1r_XX1_M16_s x1_net7 229.859
Rpar_s1_XX1_M16_g s1r_XX1_M16_g Vref 167.933
Rpar_s1_XX1_M16_d s1r_XX1_M16_d x1_Vout 229.859
XX1_M46 s1r_XX1_M46_d net4 s1r_XX1_M46_s Vss sky130_fd_pr__nfet_01v8_lvt L=2 W=1 NF=1 AD=0.29 AS=0.29 PD=2.58 PS=2.58 NRD=0.29 NRS=0.29 SA=0 SB=0 SD=0 MULT=2 M=2
Rpar_s1_XX1_M46_s s1r_XX1_M46_s Vss 161.317
Rpar_s1_XX1_M46_d s1r_XX1_M46_d net4 161.317
XX1_M47 s1r_XX1_M47_d net5 s1r_XX1_M47_s Vss sky130_fd_pr__nfet_01v8_lvt L=5 W=0.6 NF=1 AD=0.174 AS=0.174 PD=1.78 PS=1.78 NRD=0.483333 NRS=0.483333 SA=0 SB=0 SD=0 MULT=2 M=2
Rpar_s1_XX1_M47_s s1r_XX1_M47_s Vss 1021.73
Rpar_s1_XX1_M47_d s1r_XX1_M47_d net5 1021.73
XX1_M23 s1r_XX1_M23_d net6 s1r_XX1_M23_s Vss sky130_fd_pr__nfet_01v8_lvt L=1 W=0.6 NF=1 AD=0.174 AS=0.174 PD=1.78 PS=1.78 NRD=0.483333 NRS=0.483333 SA=0 SB=0 SD=0 MULT=2 M=2
Rpar_s1_XX1_M23_s s1r_XX1_M23_s Vss 154.912
Rpar_s1_XX1_M23_d s1r_XX1_M23_d net6 1003.87
XX1_M24 s1r_XX1_M24_d net6 s1r_XX1_M24_s Vss sky130_fd_pr__nfet_01v8_lvt L=1 W=0.6 NF=1 AD=0.174 AS=0.174 PD=1.78 PS=1.78 NRD=0.483333 NRS=0.483333 SA=0 SB=0 SD=0 MULT=2 M=2
Rpar_s1_XX1_M24_s s1r_XX1_M24_s Vss 154.912
Rpar_s1_XX1_M24_d s1r_XX1_M24_d x1_Vbias 1003.87
XX1_M25 s1r_XX1_M25_d x1_Vbias s1r_XX1_M25_s Vdd sky130_fd_pr__pfet_01v8_lvt L=10 W=1.5 NF=1 AD=0.435 AS=0.435 PD=3.58 PS=3.58 NRD=0.193333 NRS=0.193333 SA=0 SB=0 SD=0 MULT=2 M=2
Rpar_s1_XX1_M25_s s1r_XX1_M25_s Vdd 779.853
Rpar_s1_XX1_M25_d s1r_XX1_M25_d x1_Vbias 826.064
XX2_M9 s1r_XX2_M9_d s1r_XX2_M9_g s1r_XX2_M9_s Vdd sky130_fd_pr__pfet_01v8_lvt L=1 W=2 NF=1 AD=0.58 AS=0.58 PD=4.58 PS=4.58 NRD=0.145 NRS=0.145 SA=0 SB=0 SD=0 MULT=9 M=9
Rpar_s1_XX2_M9_s s1r_XX2_M9_s Vdd 39.5499
Rpar_s1_XX2_M9_g s1r_XX2_M9_g Vom1 148.543
Rpar_s1_XX2_M9_d s1r_XX2_M9_d Vop 39.5499
XX2_M4 s1r_XX2_M4_d s1r_XX2_M4_g s1r_XX2_M4_s Vdd sky130_fd_pr__pfet_01v8_lvt L=1 W=2 NF=1 AD=0.58 AS=0.58 PD=4.58 PS=4.58 NRD=0.145 NRS=0.145 SA=0 SB=0 SD=0 MULT=9 M=9
Rpar_s1_XX2_M4_s s1r_XX2_M4_s Vdd 39.5499
Rpar_s1_XX2_M4_g s1r_XX2_M4_g Vop1 148.543
Rpar_s1_XX2_M4_d s1r_XX2_M4_d Vom 39.5499
XX2_M2 s1r_XX2_M2_d x2_Vout s1r_XX2_M2_s Vss sky130_fd_pr__nfet_01v8_lvt L=1 W=1 NF=1 AD=0.29 AS=0.29 PD=2.58 PS=2.58 NRD=0.29 NRS=0.29 SA=0 SB=0 SD=0 MULT=9 M=9
Rpar_s1_XX2_M2_s s1r_XX2_M2_s Vss 174.601
Rpar_s1_XX2_M2_d s1r_XX2_M2_d Vop 51.4112
XX2_M1 s1r_XX2_M1_d x2_Vout s1r_XX2_M1_s Vss sky130_fd_pr__nfet_01v8_lvt L=1 W=1 NF=1 AD=0.29 AS=0.29 PD=2.58 PS=2.58 NRD=0.29 NRS=0.29 SA=0 SB=0 SD=0 MULT=9 M=9
Rpar_s1_XX2_M1_s s1r_XX2_M1_s Vss 174.601
Rpar_s1_XX2_M1_d s1r_XX2_M1_d Vom 51.4112
XX2_M3 s1r_XX2_M3_d x2_Vbiasp s1r_XX2_M3_s Vdd sky130_fd_pr__pfet_01v8_lvt L=5 W=1 NF=1 AD=0.29 AS=0.29 PD=2.58 PS=2.58 NRD=0.29 NRS=0.29 SA=0 SB=0 SD=0 MULT=2 M=2
Rpar_s1_XX2_M3_s s1r_XX2_M3_s Vdd 1054.2
Rpar_s1_XX2_M3_d s1r_XX2_M3_d x2_net1 1054.2
XX2_M7 s1r_XX2_M7_d x2_Vcm s1r_XX2_M7_s Vdd sky130_fd_pr__pfet_01v8_lvt L=10 W=1 NF=1 AD=0.29 AS=0.29 PD=2.58 PS=2.58 NRD=0.29 NRS=0.29 SA=0 SB=0 SD=0 MULT=2 M=2
Rpar_s1_XX2_M7_s s1r_XX2_M7_s x2_net1 1076.52
Rpar_s1_XX2_M7_d s1r_XX2_M7_d x2_Vtest 1076.52
XX2_M8 s1r_XX2_M8_d Vref s1r_XX2_M8_s Vdd sky130_fd_pr__pfet_01v8_lvt L=10 W=1 NF=1 AD=0.29 AS=0.29 PD=2.58 PS=2.58 NRD=0.29 NRS=0.29 SA=0 SB=0 SD=0 MULT=2 M=2
Rpar_s1_XX2_M8_s s1r_XX2_M8_s x2_net1 1076.52
Rpar_s1_XX2_M8_d s1r_XX2_M8_d x2_Vout 1076.52
XX2_M5 s1r_XX2_M5_d x2_Vtest s1r_XX2_M5_s Vss sky130_fd_pr__nfet_01v8_lvt L=20 W=0.5 NF=1 AD=0.145 AS=0.145 PD=1.58 PS=1.58 NRD=0.58 NRS=0.58 SA=0 SB=0 SD=0 MULT=2 M=2
Rpar_s1_XX2_M5_s s1r_XX2_M5_s Vss 1087.71
Rpar_s1_XX2_M5_d s1r_XX2_M5_d x2_Vtest 1087.71
XX2_M6 s1r_XX2_M6_d x2_Vtest s1r_XX2_M6_s Vss sky130_fd_pr__nfet_01v8_lvt L=20 W=0.5 NF=1 AD=0.145 AS=0.145 PD=1.58 PS=1.58 NRD=0.58 NRS=0.58 SA=0 SB=0 SD=0 MULT=2 M=2
Rpar_s1_XX2_M6_s s1r_XX2_M6_s Vss 1087.71
Rpar_s1_XX2_M6_d s1r_XX2_M6_d x2_Vout 1087.71
XX2_M10 s1r_XX2_M10_d net7 s1r_XX2_M10_s Vss sky130_fd_pr__nfet_01v8_lvt L=1 W=0.6 NF=1 AD=0.174 AS=0.174 PD=1.78 PS=1.78 NRD=0.483333 NRS=0.483333 SA=0 SB=0 SD=0 MULT=2 M=2
Rpar_s1_XX2_M10_s s1r_XX2_M10_s Vss 1003.87
Rpar_s1_XX2_M10_d s1r_XX2_M10_d net7 1003.87
XX2_M11 s1r_XX2_M11_d net7 s1r_XX2_M11_s Vss sky130_fd_pr__nfet_01v8_lvt L=1 W=0.6 NF=1 AD=0.174 AS=0.174 PD=1.78 PS=1.78 NRD=0.483333 NRS=0.483333 SA=0 SB=0 SD=0 MULT=2 M=2
Rpar_s1_XX2_M11_s s1r_XX2_M11_s Vss 1003.87
Rpar_s1_XX2_M11_d s1r_XX2_M11_d x2_Vbiasp 1003.87
XX2_M12 s1r_XX2_M12_d x2_Vbiasp s1r_XX2_M12_s Vdd sky130_fd_pr__pfet_01v8_lvt L=1 W=6 NF=1 AD=1.74 AS=1.74 PD=12.58 PS=12.58 NRD=0.0483333 NRS=0.0483333 SA=0 SB=0 SD=0 MULT=2 M=2
Rpar_s1_XX2_M12_s s1r_XX2_M12_s Vdd 262.23
Rpar_s1_XX2_M12_d s1r_XX2_M12_d x2_Vbiasp 262.23
Vref_ext Vref Vss 0.9
XC1 Vop1 Vom sky130_fd_pr__cap_mim_m3_1 W=10 L=10 MF=5 M=5
XC2 Vom1 Vop sky130_fd_pr__cap_mim_m3_1 W=10 L=10 MF=5 M=5
XX2_X1_R1 x2_x1_net4 Vop sky130_fd_pr__res_generic_po W=0.5 L=40
XX2_X1_R2 x2_x1_net5 x2_x1_net4 sky130_fd_pr__res_generic_po W=0.5 L=40
XX2_X1_R3 x2_x1_net6 x2_x1_net5 sky130_fd_pr__res_generic_po W=0.5 L=40
XX2_X1_R4 x2_x1_net7 x2_x1_net6 sky130_fd_pr__res_generic_po W=0.5 L=40
XX2_X1_R5 x2_x1_net1 x2_x1_net7 sky130_fd_pr__res_generic_po W=0.5 L=40
XX2_X1_R6 x2_x1_net8 x2_x1_net2 sky130_fd_pr__res_generic_po W=0.5 L=40
XX2_X1_R7 x2_x1_net9 x2_x1_net8 sky130_fd_pr__res_generic_po W=0.5 L=40
XX2_X1_R8 x2_x1_net10 x2_x1_net9 sky130_fd_pr__res_generic_po W=0.5 L=40
XX2_X1_R9 x2_x1_net11 x2_x1_net10 sky130_fd_pr__res_generic_po W=0.5 L=40
XX2_X1_R10 x2_x1_net1 x2_x1_net11 sky130_fd_pr__res_generic_po W=0.5 L=40
XX2_X1_R11 x2_x1_net12 x2_x1_net2 sky130_fd_pr__res_generic_po W=0.5 L=40
XX2_X1_R12 x2_x1_net13 x2_x1_net12 sky130_fd_pr__res_generic_po W=0.5 L=40
XX2_X1_R13 x2_x1_net14 x2_x1_net13 sky130_fd_pr__res_generic_po W=0.5 L=40
XX2_X1_R14 x2_x1_net15 x2_x1_net14 sky130_fd_pr__res_generic_po W=0.5 L=40
XX2_X1_R16 x2_x1_net16 x2_Vcm sky130_fd_pr__res_generic_po W=0.5 L=40
XX2_X1_R17 x2_x1_net17 x2_x1_net16 sky130_fd_pr__res_generic_po W=0.5 L=40
XX2_X1_R18 x2_x1_net18 x2_x1_net17 sky130_fd_pr__res_generic_po W=0.5 L=40
XX2_X1_R19 x2_x1_net19 x2_x1_net18 sky130_fd_pr__res_generic_po W=0.5 L=40
XX2_X1_R20 x2_x1_net3 x2_x1_net19 sky130_fd_pr__res_generic_po W=0.5 L=40
XX2_X1_R15 x2_x1_net3 x2_x1_net15 sky130_fd_pr__res_generic_po W=0.5 L=40
XX2_X2_R1 x2_x2_net4 x2_Vcm sky130_fd_pr__res_generic_po W=0.5 L=40
XX2_X2_R2 x2_x2_net5 x2_x2_net4 sky130_fd_pr__res_generic_po W=0.5 L=40
XX2_X2_R3 x2_x2_net6 x2_x2_net5 sky130_fd_pr__res_generic_po W=0.5 L=40
XX2_X2_R4 x2_x2_net7 x2_x2_net6 sky130_fd_pr__res_generic_po W=0.5 L=40
XX2_X2_R5 x2_x2_net1 x2_x2_net7 sky130_fd_pr__res_generic_po W=0.5 L=40
XX2_X2_R6 x2_x2_net8 x2_x2_net2 sky130_fd_pr__res_generic_po W=0.5 L=40
XX2_X2_R7 x2_x2_net9 x2_x2_net8 sky130_fd_pr__res_generic_po W=0.5 L=40
XX2_X2_R8 x2_x2_net10 x2_x2_net9 sky130_fd_pr__res_generic_po W=0.5 L=40
XX2_X2_R9 x2_x2_net11 x2_x2_net10 sky130_fd_pr__res_generic_po W=0.5 L=40
XX2_X2_R10 x2_x2_net1 x2_x2_net11 sky130_fd_pr__res_generic_po W=0.5 L=40
XX2_X2_R11 x2_x2_net12 x2_x2_net2 sky130_fd_pr__res_generic_po W=0.5 L=40
XX2_X2_R12 x2_x2_net13 x2_x2_net12 sky130_fd_pr__res_generic_po W=0.5 L=40
XX2_X2_R13 x2_x2_net14 x2_x2_net13 sky130_fd_pr__res_generic_po W=0.5 L=40
XX2_X2_R14 x2_x2_net15 x2_x2_net14 sky130_fd_pr__res_generic_po W=0.5 L=40
XX2_X2_R16 x2_x2_net16 Vom sky130_fd_pr__res_generic_po W=0.5 L=40
XX2_X2_R17 x2_x2_net17 x2_x2_net16 sky130_fd_pr__res_generic_po W=0.5 L=40
XX2_X2_R18 x2_x2_net18 x2_x2_net17 sky130_fd_pr__res_generic_po W=0.5 L=40
XX2_X2_R19 x2_x2_net19 x2_x2_net18 sky130_fd_pr__res_generic_po W=0.5 L=40
XX2_X2_R20 x2_x2_net3 x2_x2_net19 sky130_fd_pr__res_generic_po W=0.5 L=40
XX2_X2_R15 x2_x2_net3 x2_x2_net15 sky130_fd_pr__res_generic_po W=0.5 L=40
Rgm_ext Rgm Vss 12000
.ends ttsky25a_fd
.end
