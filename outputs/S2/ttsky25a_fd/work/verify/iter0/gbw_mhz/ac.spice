* ttsky25a_fd on dido_amp_AC
.lib $PDK_ROOT/sky130A/libs.tech/combined/sky130.lib.spice tt
.param VDD_V=1.8 VCM_V=0.9 CL_F=529f
.temp 27

**.subckt dido_amp_AC
x1 INP INN OUTN VDD 0 OUTP dut_amp
Vsup VDD 0 'VDD_V'
* AC drive through 1 F couplers; DC set by unity feedback through 1 GH chokes (OUTP->INN, OUTN->INP)
Vacp ACP 0 dc 0 ac 0.5
Vacn ACN 0 dc 0 ac -0.5
Cinp ACP INP 1
Cinn ACN INN 1
Lfbp OUTP INN 1G
Lfbn OUTN INP 1G
Cloadp OUTP 0 'CL_F'
Cloadn OUTN 0 'CL_F'
.control
  save all
  ac dec 40 1 1G
  let hsig = v(OUTP) - v(OUTN)
  let hdb = db(hsig)
  let gph_deg = 180/pi * cph(hsig)
  meas ac gain_db find hdb at=1
  meas ac gbw_hz  when hdb=0
  meas ac ph_dc   find gph_deg at=1
  meas ac ph_ugb  find gph_deg when hdb=0
  let gbw_mhz = gbw_hz / 1e6
  let pm_deg  = 180 + (ph_ugb - ph_dc)
  echo MEAS gain_db $&gain_db
  echo MEAS gbw_mhz $&gbw_mhz
  echo MEAS pm_deg $&pm_deg
  write
  quit 0
.endc
**.ends

.subckt dut_amp INP INN OUTN VDD VSS OUTP
XDUT OUTP INN VDD VSS OUTN INP ttsky25a_fd
.ends

.subckt ttsky25a_fd Vop Vm Vdd Vss Vom Vp
Cbud_s2_0 NBias Vss 138.682f
Cbud_s2_1 Rgm Vss 26.6481f
Cbud_s2_2 Vom Vss 17.9979f
Cbud_s2_3 Vom1 Vss 45.5318f
Cbud_s2_4 Vop Vss 17.9979f
Cbud_s2_5 Vop1 Vss 45.5318f
Cbud_s2_6 net1 Vss 100.632f
Cbud_s2_7 net2 Vss 84.3145f
Cbud_s2_8 net4 Vss 723.633f
Cbud_s2_9 net5 Vss 128.428f
Cbud_s2_10 net6 Vss 53.0761f
Cbud_s2_11 x1_Vout Vss 290.581f
Cbud_s2_12 x1_Vtest2 Vss 6.7871f
Cbud_s2_13 x1_net1 Vss 6.7871f
Cbud_s2_14 x1_net5 Vss 15.1475f
Cbud_s2_15 x1_net6 Vss 15.1475f
Cbud_s2_16 x1_net7 Vss 10.9764f
Cbud_s2_17 x1_net8 Vss 10.9764f
Cbud_s2_18 x2_Vbiasp Vss 105.1f
Cbud_s2_19 x2_Vtest Vss 349.829f
Cbud_s2_20 x2_net1 Vss 30.6534f
Cbud_s2_21 x2_x1_net1 Vss 6.26438f
Cbud_s2_22 x2_x1_net10 Vss 6.26438f
Cbud_s2_23 x2_x1_net11 Vss 6.26438f
Cbud_s2_24 x2_x1_net12 Vss 6.26438f
Cbud_s2_25 x2_x1_net13 Vss 6.26438f
Cbud_s2_26 x2_x1_net14 Vss 6.26438f
Cbud_s2_27 x2_x1_net15 Vss 7.55001f
Cbud_s2_28 x2_x1_net16 Vss 40.5949f
Cbud_s2_29 x2_x1_net17 Vss 40.5949f
Cbud_s2_30 x2_x1_net18 Vss 30.2f
Cbud_s2_31 x2_x1_net19 Vss 16.9875f
Cbud_s2_32 x2_x1_net2 Vss 6.26438f
Cbud_s2_33 x2_x1_net3 Vss 10.872f
Cbud_s2_34 x2_x1_net4 Vss 6.26438f
Cbud_s2_35 x2_x1_net5 Vss 6.26438f
Cbud_s2_36 x2_x1_net6 Vss 6.26438f
Cbud_s2_37 x2_x1_net7 Vss 6.26438f
Cbud_s2_38 x2_x1_net8 Vss 6.26438f
Cbud_s2_39 x2_x1_net9 Vss 6.26438f
Cbud_s2_40 x2_x2_net1 Vss 10.872f
Cbud_s2_41 x2_x2_net10 Vss 6.26438f
Cbud_s2_42 x2_x2_net11 Vss 7.55001f
Cbud_s2_43 x2_x2_net12 Vss 6.26438f
Cbud_s2_44 x2_x2_net13 Vss 6.26438f
Cbud_s2_45 x2_x2_net14 Vss 6.26438f
Cbud_s2_46 x2_x2_net15 Vss 6.26438f
Cbud_s2_47 x2_x2_net16 Vss 6.26438f
Cbud_s2_48 x2_x2_net17 Vss 6.26438f
Cbud_s2_49 x2_x2_net18 Vss 6.26438f
Cbud_s2_50 x2_x2_net19 Vss 6.26438f
Cbud_s2_51 x2_x2_net2 Vss 6.26438f
Cbud_s2_52 x2_x2_net3 Vss 6.26438f
Cbud_s2_53 x2_x2_net4 Vss 40.5949f
Cbud_s2_54 x2_x2_net5 Vss 40.5949f
Cbud_s2_55 x2_x2_net6 Vss 30.2f
Cbud_s2_56 x2_x2_net7 Vss 16.9875f
Cbud_s2_57 x2_x2_net8 Vss 6.26438f
Cbud_s2_58 x2_x2_net9 Vss 6.26438f
Cbud_s2_59 NBias Rgm 1.8284f
Cbud_s2_60 NBias Vom 0.988991f
Cbud_s2_61 NBias Vom1 0.988991f
Cbud_s2_62 NBias Vop 0.988991f
Cbud_s2_63 NBias Vop1 0.988991f
Cbud_s2_64 NBias net1 6.00207f
Cbud_s2_65 NBias net2 4.64822f
Cbud_s2_66 NBias net6 2.65975f
Cbud_s2_67 NBias x1_Vbias 5.10867f
Cbud_s2_68 NBias x1_Vout 6.40893f
Cbud_s2_69 NBias x1_Vtest2 0.565278f
Cbud_s2_70 NBias x1_net1 0.565278f
Cbud_s2_71 NBias x1_net2 3.50591f
Cbud_s2_72 NBias x1_net4 1.75295f
Cbud_s2_73 NBias x1_net5 1.75295f
Cbud_s2_74 NBias x1_net6 1.75295f
Cbud_s2_75 NBias x1_net7 1.73817f
Cbud_s2_76 NBias x1_net8 1.73817f
Cbud_s2_77 NBias x2_Vbiasp 3.95719f
Cbud_s2_78 NBias x2_Vout 6.23194f
Cbud_s2_79 NBias x2_net1 3.31341f
Cbud_s2_80 NBias x2_x1_net1 1.208f
Cbud_s2_81 NBias x2_x1_net10 1.60829f
Cbud_s2_82 NBias x2_x1_net11 1.38674f
Cbud_s2_83 NBias x2_x1_net12 3.35556f
Cbud_s2_84 NBias x2_x1_net13 4.24689f
Cbud_s2_85 NBias x2_x1_net14 5.54695f
Cbud_s2_86 NBias x2_x1_net15 6.40893f
Cbud_s2_87 NBias x2_x1_net16 6.40893f
Cbud_s2_88 NBias x2_x1_net17 6.40893f
Cbud_s2_89 NBias x2_x1_net18 6.40893f
Cbud_s2_90 NBias x2_x1_net19 6.40893f
Cbud_s2_91 NBias x2_x1_net2 2.71801f
Cbud_s2_92 NBias x2_x1_net3 6.40893f
Cbud_s2_93 NBias x2_x1_net4 0.988991f
Cbud_s2_94 NBias x2_x1_net5 0.988991f
Cbud_s2_95 NBias x2_x1_net6 0.988991f
Cbud_s2_96 NBias x2_x1_net7 1.06172f
Cbud_s2_97 NBias x2_x1_net8 2.24629f
Cbud_s2_98 NBias x2_x1_net9 1.88751f
Cbud_s2_99 NBias x2_x2_net1 6.40893f
Cbud_s2_100 NBias x2_x2_net10 5.54695f
Cbud_s2_101 NBias x2_x2_net11 6.40893f
Cbud_s2_102 NBias x2_x2_net12 2.24629f
Cbud_s2_103 NBias x2_x2_net13 1.88751f
Cbud_s2_104 NBias x2_x2_net14 1.60829f
Cbud_s2_105 NBias x2_x2_net15 1.38674f
Cbud_s2_106 NBias x2_x2_net16 0.988991f
Cbud_s2_107 NBias x2_x2_net17 0.988991f
Cbud_s2_108 NBias x2_x2_net18 0.988991f
Cbud_s2_109 NBias x2_x2_net19 1.06172f
Cbud_s2_110 NBias x2_x2_net2 2.71801f
Cbud_s2_111 NBias x2_x2_net3 1.208f
Cbud_s2_112 NBias x2_x2_net4 6.40893f
Cbud_s2_113 NBias x2_x2_net5 6.40893f
Cbud_s2_114 NBias x2_x2_net6 6.40893f
Cbud_s2_115 NBias x2_x2_net7 6.40893f
Cbud_s2_116 NBias x2_x2_net8 3.35556f
Cbud_s2_117 NBias x2_x2_net9 4.24689f
Cbud_s2_118 NBias Vm 1.19379f
Cbud_s2_119 NBias Vp 1.19379f
Cbud_s2_120 PBias Vom 1.50247f
Cbud_s2_121 PBias Vom1 1.50247f
Cbud_s2_122 PBias Vop 1.50247f
Cbud_s2_123 PBias Vop1 1.50247f
Cbud_s2_124 PBias net4 15.184f
Cbud_s2_125 PBias net5 10.4054f
Cbud_s2_126 PBias net6 8.10735f
Cbud_s2_127 PBias x1_Vbias 5.10867f
Cbud_s2_128 PBias x1_Vtest2 0.565278f
Cbud_s2_129 PBias x1_net1 0.565278f
Cbud_s2_130 PBias x1_net2 3.50591f
Cbud_s2_131 PBias x1_net3 1.75295f
Cbud_s2_132 PBias x1_net5 1.75295f
Cbud_s2_133 PBias x1_net6 1.75295f
Cbud_s2_134 PBias x1_net7 1.73817f
Cbud_s2_135 PBias x1_net8 1.73817f
Cbud_s2_136 PBias x2_Vbiasp 3.95719f
Cbud_s2_137 PBias x2_net1 3.31341f
Cbud_s2_138 PBias x2_x1_net1 1.208f
Cbud_s2_139 PBias x2_x1_net10 1.60829f
Cbud_s2_140 PBias x2_x1_net11 1.38674f
Cbud_s2_141 PBias x2_x1_net12 3.35556f
Cbud_s2_142 PBias x2_x1_net13 4.24688f
Cbud_s2_143 PBias x2_x1_net14 5.54695f
Cbud_s2_144 PBias x2_x1_net15 6.75515f
Cbud_s2_145 PBias x2_x1_net16 6.75515f
Cbud_s2_146 PBias x2_x1_net17 6.75515f
Cbud_s2_147 PBias x2_x1_net18 6.75515f
Cbud_s2_148 PBias x2_x1_net19 6.75515f
Cbud_s2_149 PBias x2_x1_net2 2.718f
Cbud_s2_150 PBias x2_x1_net3 6.75515f
Cbud_s2_151 PBias x2_x1_net4 1.04242f
Cbud_s2_152 PBias x2_x1_net5 1.04242f
Cbud_s2_153 PBias x2_x1_net6 1.04242f
Cbud_s2_154 PBias x2_x1_net7 1.06172f
Cbud_s2_155 PBias x2_x1_net8 2.24628f
Cbud_s2_156 PBias x2_x1_net9 1.8875f
Cbud_s2_157 PBias x2_x2_net1 6.75515f
Cbud_s2_158 PBias x2_x2_net10 5.54695f
Cbud_s2_159 PBias x2_x2_net11 6.75515f
Cbud_s2_160 PBias x2_x2_net12 2.24628f
Cbud_s2_161 PBias x2_x2_net13 1.8875f
Cbud_s2_162 PBias x2_x2_net14 1.60829f
Cbud_s2_163 PBias x2_x2_net15 1.38674f
Cbud_s2_164 PBias x2_x2_net16 1.04242f
Cbud_s2_165 PBias x2_x2_net17 1.04242f
Cbud_s2_166 PBias x2_x2_net18 1.04242f
Cbud_s2_167 PBias x2_x2_net19 1.06172f
Cbud_s2_168 PBias x2_x2_net2 2.718f
Cbud_s2_169 PBias x2_x2_net3 1.208f
Cbud_s2_170 PBias x2_x2_net4 6.75515f
Cbud_s2_171 PBias x2_x2_net5 6.75515f
Cbud_s2_172 PBias x2_x2_net6 6.75515f
Cbud_s2_173 PBias x2_x2_net7 6.75515f
Cbud_s2_174 PBias x2_x2_net8 3.35556f
Cbud_s2_175 PBias x2_x2_net9 4.24688f
Cbud_s2_176 PBias Vp 1.19379f
Cbud_s2_177 Rgm Vom 0.679501f
Cbud_s2_178 Rgm Vom1 0.855627f
Cbud_s2_179 Rgm Vop 0.679501f
Cbud_s2_180 Rgm Vop1 0.855627f
Cbud_s2_181 Rgm net5 1.8284f
Cbud_s2_182 Rgm x1_Vout 1.8284f
Cbud_s2_183 Rgm x1_Vtest2 0.282149f
Cbud_s2_184 Rgm x1_net1 0.282149f
Cbud_s2_185 Rgm x1_net2 1.8284f
Cbud_s2_186 Rgm x1_net5 1.75295f
Cbud_s2_187 Rgm x1_net6 1.75295f
Cbud_s2_188 Rgm x1_net7 1.73817f
Cbud_s2_189 Rgm x1_net8 1.73817f
Cbud_s2_190 Rgm x2_Vbiasp 1.8284f
Cbud_s2_191 Rgm x2_Vout 1.8284f
Cbud_s2_192 Rgm x2_x1_net1 1.208f
Cbud_s2_193 Rgm x2_x1_net10 1.60829f
Cbud_s2_194 Rgm x2_x1_net11 1.38674f
Cbud_s2_195 Rgm x2_x1_net12 1.8284f
Cbud_s2_196 Rgm x2_x1_net13 1.8284f
Cbud_s2_197 Rgm x2_x1_net14 1.8284f
Cbud_s2_198 Rgm x2_x1_net15 1.8284f
Cbud_s2_199 Rgm x2_x1_net16 1.8284f
Cbud_s2_200 Rgm x2_x1_net17 1.8284f
Cbud_s2_201 Rgm x2_x1_net18 1.8284f
Cbud_s2_202 Rgm x2_x1_net19 1.8284f
Cbud_s2_203 Rgm x2_x1_net2 1.8284f
Cbud_s2_204 Rgm x2_x1_net3 1.8284f
Cbud_s2_205 Rgm x2_x1_net4 0.75291f
Cbud_s2_206 Rgm x2_x1_net5 0.83889f
Cbud_s2_207 Rgm x2_x1_net6 0.940486f
Cbud_s2_208 Rgm x2_x1_net7 1.06172f
Cbud_s2_209 Rgm x2_x1_net8 1.8284f
Cbud_s2_210 Rgm x2_x1_net9 1.8284f
Cbud_s2_211 Rgm x2_x2_net1 1.8284f
Cbud_s2_212 Rgm x2_x2_net10 1.8284f
Cbud_s2_213 Rgm x2_x2_net11 1.8284f
Cbud_s2_214 Rgm x2_x2_net12 1.8284f
Cbud_s2_215 Rgm x2_x2_net13 1.8284f
Cbud_s2_216 Rgm x2_x2_net14 1.60829f
Cbud_s2_217 Rgm x2_x2_net15 1.38674f
Cbud_s2_218 Rgm x2_x2_net16 0.75291f
Cbud_s2_219 Rgm x2_x2_net17 0.83889f
Cbud_s2_220 Rgm x2_x2_net18 0.940486f
Cbud_s2_221 Rgm x2_x2_net19 1.06172f
Cbud_s2_222 Rgm x2_x2_net2 1.8284f
Cbud_s2_223 Rgm x2_x2_net3 1.208f
Cbud_s2_224 Rgm x2_x2_net4 1.8284f
Cbud_s2_225 Rgm x2_x2_net5 1.8284f
Cbud_s2_226 Rgm x2_x2_net6 1.8284f
Cbud_s2_227 Rgm x2_x2_net7 1.8284f
Cbud_s2_228 Rgm x2_x2_net8 1.8284f
Cbud_s2_229 Rgm x2_x2_net9 1.8284f
Cbud_s2_230 Vom Vop 2.04098f
Cbud_s2_231 Vom Vop1 3.42236f
Cbud_s2_232 Vom net1 0.926207f
Cbud_s2_233 Vom net2 0.717288f
Cbud_s2_234 Vom net3 0.853412f
Cbud_s2_235 Vom net4 1.69496f
Cbud_s2_236 Vom net5 0.765056f
Cbud_s2_237 Vom net6 0.679501f
Cbud_s2_238 Vom net7 0.679501f
Cbud_s2_239 Vom x1_Vbias 0.788342f
Cbud_s2_240 Vom x1_Vout 1.39899f
Cbud_s2_241 Vom x1_Vtest2 0.565278f
Cbud_s2_242 Vom x1_net2 0.679501f
Cbud_s2_243 Vom x1_net3 0.679501f
Cbud_s2_244 Vom x1_net4 0.679501f
Cbud_s2_245 Vom x1_net5 0.270506f
Cbud_s2_246 Vom x1_net8 1.05319f
Cbud_s2_247 Vom x1_net9 1.32587f
Cbud_s2_248 Vom x2_Vbiasp 0.679501f
Cbud_s2_249 Vom x2_Vcm 1.23099f
Cbud_s2_250 Vom x2_Vout 1.73498f
Cbud_s2_251 Vom x2_Vtest 1.03502f
Cbud_s2_252 Vom x2_net1 0.679569f
Cbud_s2_253 Vom x2_x1_net1 1.04242f
Cbud_s2_254 Vom x2_x1_net10 1.04242f
Cbud_s2_255 Vom x2_x1_net11 1.04242f
Cbud_s2_256 Vom x2_x1_net12 1.04242f
Cbud_s2_257 Vom x2_x1_net13 1.04242f
Cbud_s2_258 Vom x2_x1_net14 1.04242f
Cbud_s2_259 Vom x2_x1_net15 1.04242f
Cbud_s2_260 Vom x2_x1_net16 1.04242f
Cbud_s2_261 Vom x2_x1_net17 1.04242f
Cbud_s2_262 Vom x2_x1_net18 1.04242f
Cbud_s2_263 Vom x2_x1_net19 1.04242f
Cbud_s2_264 Vom x2_x1_net2 1.04242f
Cbud_s2_265 Vom x2_x1_net3 1.04242f
Cbud_s2_266 Vom x2_x1_net4 1.04242f
Cbud_s2_267 Vom x2_x1_net5 1.04242f
Cbud_s2_268 Vom x2_x1_net6 1.04242f
Cbud_s2_269 Vom x2_x1_net7 1.04242f
Cbud_s2_270 Vom x2_x1_net8 1.04242f
Cbud_s2_271 Vom x2_x1_net9 1.04242f
Cbud_s2_272 Vom x2_x2_net1 1.208f
Cbud_s2_273 Vom x2_x2_net10 1.60829f
Cbud_s2_274 Vom x2_x2_net11 1.38674f
Cbud_s2_275 Vom x2_x2_net12 3.35556f
Cbud_s2_276 Vom x2_x2_net13 4.24688f
Cbud_s2_277 Vom x2_x2_net14 5.54695f
Cbud_s2_278 Vom x2_x2_net15 6.75515f
Cbud_s2_279 Vom x2_x2_net16 6.75515f
Cbud_s2_280 Vom x2_x2_net17 6.75515f
Cbud_s2_281 Vom x2_x2_net18 6.75515f
Cbud_s2_282 Vom x2_x2_net19 6.75515f
Cbud_s2_283 Vom x2_x2_net2 2.718f
Cbud_s2_284 Vom x2_x2_net3 6.75515f
Cbud_s2_285 Vom x2_x2_net4 1.04242f
Cbud_s2_286 Vom x2_x2_net5 1.04242f
Cbud_s2_287 Vom x2_x2_net6 1.04242f
Cbud_s2_288 Vom x2_x2_net7 1.06172f
Cbud_s2_289 Vom x2_x2_net8 2.24628f
Cbud_s2_290 Vom x2_x2_net9 1.8875f
Cbud_s2_291 Vom Vm 0.571088f
Cbud_s2_292 Vom1 Vop 3.42236f
Cbud_s2_293 Vom1 Vop1 1.89659f
Cbud_s2_294 Vom1 net1 0.926207f
Cbud_s2_295 Vom1 net2 0.855627f
Cbud_s2_296 Vom1 net3 0.855627f
Cbud_s2_297 Vom1 net4 1.69496f
Cbud_s2_298 Vom1 net5 0.936901f
Cbud_s2_299 Vom1 net6 0.855627f
Cbud_s2_300 Vom1 net7 0.855627f
Cbud_s2_301 Vom1 x1_Vbias 1.31363f
Cbud_s2_302 Vom1 x1_Vout 1.39899f
Cbud_s2_303 Vom1 x1_Vtest2 0.565278f
Cbud_s2_304 Vom1 x1_net1 0.607498f
Cbud_s2_305 Vom1 x1_net2 0.855627f
Cbud_s2_306 Vom1 x1_net3 0.855627f
Cbud_s2_307 Vom1 x1_net4 0.855627f
Cbud_s2_308 Vom1 x1_net5 0.430794f
Cbud_s2_309 Vom1 x1_net7 5.35001f
Cbud_s2_310 Vom1 x1_net8 1.05319f
Cbud_s2_311 Vom1 x1_net9 2.68616f
Cbud_s2_312 Vom1 x2_Vbiasp 0.855627f
Cbud_s2_313 Vom1 x2_Vcm 1.23099f
Cbud_s2_314 Vom1 x2_Vout 0.961679f
Cbud_s2_315 Vom1 x2_Vtest 1.03502f
Cbud_s2_316 Vom1 x2_net1 0.855556f
Cbud_s2_317 Vom1 x2_x1_net1 1.04242f
Cbud_s2_318 Vom1 x2_x1_net10 1.04242f
Cbud_s2_319 Vom1 x2_x1_net11 1.04242f
Cbud_s2_320 Vom1 x2_x1_net12 1.04242f
Cbud_s2_321 Vom1 x2_x1_net13 1.04242f
Cbud_s2_322 Vom1 x2_x1_net14 1.04242f
Cbud_s2_323 Vom1 x2_x1_net15 1.04242f
Cbud_s2_324 Vom1 x2_x1_net16 1.04242f
Cbud_s2_325 Vom1 x2_x1_net17 1.04242f
Cbud_s2_326 Vom1 x2_x1_net18 1.04242f
Cbud_s2_327 Vom1 x2_x1_net19 1.04242f
Cbud_s2_328 Vom1 x2_x1_net2 1.04242f
Cbud_s2_329 Vom1 x2_x1_net3 1.04242f
Cbud_s2_330 Vom1 x2_x1_net4 1.04242f
Cbud_s2_331 Vom1 x2_x1_net5 1.04242f
Cbud_s2_332 Vom1 x2_x1_net6 1.04242f
Cbud_s2_333 Vom1 x2_x1_net7 1.04242f
Cbud_s2_334 Vom1 x2_x1_net8 1.04242f
Cbud_s2_335 Vom1 x2_x1_net9 1.04242f
Cbud_s2_336 Vom1 x2_x2_net4 1.04242f
Cbud_s2_337 Vom1 Vm 0.56846f
Cbud_s2_338 Vop net1 0.926207f
Cbud_s2_339 Vop net2 0.717288f
Cbud_s2_340 Vop net3 0.853412f
Cbud_s2_341 Vop net4 1.69496f
Cbud_s2_342 Vop net5 0.765056f
Cbud_s2_343 Vop net6 0.679501f
Cbud_s2_344 Vop net7 0.679501f
Cbud_s2_345 Vop x1_Vbias 0.788342f
Cbud_s2_346 Vop x1_Vout 1.39899f
Cbud_s2_347 Vop x1_net1 0.565278f
Cbud_s2_348 Vop x1_net2 0.679501f
Cbud_s2_349 Vop x1_net3 0.679501f
Cbud_s2_350 Vop x1_net4 0.679501f
Cbud_s2_351 Vop x1_net6 0.270506f
Cbud_s2_352 Vop x1_net7 1.05319f
Cbud_s2_353 Vop x1_net9 1.32587f
Cbud_s2_354 Vop x2_Vbiasp 0.679501f
Cbud_s2_355 Vop x2_Vcm 1.23099f
Cbud_s2_356 Vop x2_Vout 1.73498f
Cbud_s2_357 Vop x2_Vtest 1.03502f
Cbud_s2_358 Vop x2_net1 0.679569f
Cbud_s2_359 Vop x2_x1_net1 6.75515f
Cbud_s2_360 Vop x2_x1_net10 5.54695f
Cbud_s2_361 Vop x2_x1_net11 6.75515f
Cbud_s2_362 Vop x2_x1_net12 2.24628f
Cbud_s2_363 Vop x2_x1_net13 1.8875f
Cbud_s2_364 Vop x2_x1_net14 1.60829f
Cbud_s2_365 Vop x2_x1_net15 1.38674f
Cbud_s2_366 Vop x2_x1_net16 1.04242f
Cbud_s2_367 Vop x2_x1_net17 1.04242f
Cbud_s2_368 Vop x2_x1_net18 1.04242f
Cbud_s2_369 Vop x2_x1_net19 1.06172f
Cbud_s2_370 Vop x2_x1_net2 2.718f
Cbud_s2_371 Vop x2_x1_net3 1.208f
Cbud_s2_372 Vop x2_x1_net4 6.75515f
Cbud_s2_373 Vop x2_x1_net5 6.75515f
Cbud_s2_374 Vop x2_x1_net6 6.75515f
Cbud_s2_375 Vop x2_x1_net7 6.75515f
Cbud_s2_376 Vop x2_x1_net8 3.35556f
Cbud_s2_377 Vop x2_x1_net9 4.24688f
Cbud_s2_378 Vop x2_x2_net1 1.04242f
Cbud_s2_379 Vop x2_x2_net10 1.04242f
Cbud_s2_380 Vop x2_x2_net11 1.04242f
Cbud_s2_381 Vop x2_x2_net12 1.04242f
Cbud_s2_382 Vop x2_x2_net13 1.04242f
Cbud_s2_383 Vop x2_x2_net14 1.04242f
Cbud_s2_384 Vop x2_x2_net15 1.04242f
Cbud_s2_385 Vop x2_x2_net16 1.04242f
Cbud_s2_386 Vop x2_x2_net17 1.04242f
Cbud_s2_387 Vop x2_x2_net18 1.04242f
Cbud_s2_388 Vop x2_x2_net19 1.04242f
Cbud_s2_389 Vop x2_x2_net2 1.04242f
Cbud_s2_390 Vop x2_x2_net3 1.04242f
Cbud_s2_391 Vop x2_x2_net4 1.04242f
Cbud_s2_392 Vop x2_x2_net5 1.04242f
Cbud_s2_393 Vop x2_x2_net6 1.04242f
Cbud_s2_394 Vop x2_x2_net7 1.04242f
Cbud_s2_395 Vop x2_x2_net8 1.04242f
Cbud_s2_396 Vop x2_x2_net9 1.04242f
Cbud_s2_397 Vop Vp 0.571088f
Cbud_s2_398 Vop1 net1 0.926207f
Cbud_s2_399 Vop1 net2 0.855627f
Cbud_s2_400 Vop1 net3 0.855627f
Cbud_s2_401 Vop1 net4 1.69496f
Cbud_s2_402 Vop1 net5 0.936901f
Cbud_s2_403 Vop1 net6 0.855627f
Cbud_s2_404 Vop1 net7 0.855627f
Cbud_s2_405 Vop1 x1_Vbias 1.31363f
Cbud_s2_406 Vop1 x1_Vout 1.39899f
Cbud_s2_407 Vop1 x1_Vtest2 0.607498f
Cbud_s2_408 Vop1 x1_net1 0.565278f
Cbud_s2_409 Vop1 x1_net2 0.855627f
Cbud_s2_410 Vop1 x1_net3 0.855627f
Cbud_s2_411 Vop1 x1_net4 0.855627f
Cbud_s2_412 Vop1 x1_net6 0.430794f
Cbud_s2_413 Vop1 x1_net7 1.05319f
Cbud_s2_414 Vop1 x1_net8 5.35001f
Cbud_s2_415 Vop1 x1_net9 2.68616f
Cbud_s2_416 Vop1 x2_Vbiasp 0.855627f
Cbud_s2_417 Vop1 x2_Vcm 1.23099f
Cbud_s2_418 Vop1 x2_Vout 0.961679f
Cbud_s2_419 Vop1 x2_Vtest 1.03502f
Cbud_s2_420 Vop1 x2_net1 0.855556f
Cbud_s2_421 Vop1 x2_x1_net16 1.04242f
Cbud_s2_422 Vop1 x2_x2_net1 1.04242f
Cbud_s2_423 Vop1 x2_x2_net10 1.04242f
Cbud_s2_424 Vop1 x2_x2_net11 1.04242f
Cbud_s2_425 Vop1 x2_x2_net12 1.04242f
Cbud_s2_426 Vop1 x2_x2_net13 1.04242f
Cbud_s2_427 Vop1 x2_x2_net14 1.04242f
Cbud_s2_428 Vop1 x2_x2_net15 1.04242f
Cbud_s2_429 Vop1 x2_x2_net16 1.04242f
Cbud_s2_430 Vop1 x2_x2_net17 1.04242f
Cbud_s2_431 Vop1 x2_x2_net18 1.04242f
Cbud_s2_432 Vop1 x2_x2_net19 1.04242f
Cbud_s2_433 Vop1 x2_x2_net2 1.04242f
Cbud_s2_434 Vop1 x2_x2_net3 1.04242f
Cbud_s2_435 Vop1 x2_x2_net4 1.04242f
Cbud_s2_436 Vop1 x2_x2_net5 1.04242f
Cbud_s2_437 Vop1 x2_x2_net6 1.04242f
Cbud_s2_438 Vop1 x2_x2_net7 1.04242f
Cbud_s2_439 Vop1 x2_x2_net8 1.04242f
Cbud_s2_440 Vop1 x2_x2_net9 1.04242f
Cbud_s2_441 Vop1 Vp 0.56846f
Cbud_s2_442 net1 net4 6.00207f
Cbud_s2_443 net1 net5 4.95777f
Cbud_s2_444 net1 net6 2.65975f
Cbud_s2_445 net1 x1_Vbias 5.10867f
Cbud_s2_446 net1 x1_Vtest2 0.565278f
Cbud_s2_447 net1 x1_net1 0.565278f
Cbud_s2_448 net1 x1_net5 1.75295f
Cbud_s2_449 net1 x1_net6 1.75295f
Cbud_s2_450 net1 x1_net7 1.73817f
Cbud_s2_451 net1 x1_net8 1.73817f
Cbud_s2_452 net1 x2_Vout 6.00207f
Cbud_s2_453 net1 x2_net1 3.31341f
Cbud_s2_454 net1 x2_x1_net1 1.208f
Cbud_s2_455 net1 x2_x1_net10 1.60829f
Cbud_s2_456 net1 x2_x1_net11 1.38674f
Cbud_s2_457 net1 x2_x1_net12 3.35556f
Cbud_s2_458 net1 x2_x1_net13 4.24688f
Cbud_s2_459 net1 x2_x1_net14 5.54695f
Cbud_s2_460 net1 x2_x1_net15 6.00207f
Cbud_s2_461 net1 x2_x1_net16 6.00207f
Cbud_s2_462 net1 x2_x1_net17 6.00207f
Cbud_s2_463 net1 x2_x1_net18 6.00207f
Cbud_s2_464 net1 x2_x1_net19 6.00207f
Cbud_s2_465 net1 x2_x1_net2 2.71801f
Cbud_s2_466 net1 x2_x1_net3 6.00207f
Cbud_s2_467 net1 x2_x1_net4 0.926207f
Cbud_s2_468 net1 x2_x1_net5 0.926207f
Cbud_s2_469 net1 x2_x1_net6 0.940487f
Cbud_s2_470 net1 x2_x1_net7 1.06172f
Cbud_s2_471 net1 x2_x1_net8 2.24629f
Cbud_s2_472 net1 x2_x1_net9 1.8875f
Cbud_s2_473 net1 x2_x2_net1 6.00207f
Cbud_s2_474 net1 x2_x2_net10 5.54695f
Cbud_s2_475 net1 x2_x2_net11 6.00207f
Cbud_s2_476 net1 x2_x2_net12 2.24629f
Cbud_s2_477 net1 x2_x2_net13 1.8875f
Cbud_s2_478 net1 x2_x2_net14 1.60829f
Cbud_s2_479 net1 x2_x2_net15 1.38674f
Cbud_s2_480 net1 x2_x2_net16 0.926207f
Cbud_s2_481 net1 x2_x2_net17 0.926207f
Cbud_s2_482 net1 x2_x2_net18 0.940487f
Cbud_s2_483 net1 x2_x2_net19 1.06172f
Cbud_s2_484 net1 x2_x2_net2 2.71801f
Cbud_s2_485 net1 x2_x2_net3 1.208f
Cbud_s2_486 net1 x2_x2_net4 6.00207f
Cbud_s2_487 net1 x2_x2_net5 6.00207f
Cbud_s2_488 net1 x2_x2_net6 6.00207f
Cbud_s2_489 net1 x2_x2_net7 6.00207f
Cbud_s2_490 net1 x2_x2_net8 3.35556f
Cbud_s2_491 net1 x2_x2_net9 4.24688f
Cbud_s2_492 net1 Vm 1.19379f
Cbud_s2_493 net1 Vp 1.19379f
Cbud_s2_494 net2 net3 4.64822f
Cbud_s2_495 net2 net4 4.64822f
Cbud_s2_496 net2 x1_Vout 4.64822f
Cbud_s2_497 net2 x1_Vtest2 0.565278f
Cbud_s2_498 net2 x1_net1 0.565278f
Cbud_s2_499 net2 x1_net4 1.75295f
Cbud_s2_500 net2 x1_net5 1.75295f
Cbud_s2_501 net2 x1_net6 1.75295f
Cbud_s2_502 net2 x1_net7 1.73817f
Cbud_s2_503 net2 x1_net8 1.73817f
Cbud_s2_504 net2 x2_Vcm 4.64822f
Cbud_s2_505 net2 x2_x1_net1 1.208f
Cbud_s2_506 net2 x2_x1_net10 1.60829f
Cbud_s2_507 net2 x2_x1_net11 1.38674f
Cbud_s2_508 net2 x2_x1_net12 3.35556f
Cbud_s2_509 net2 x2_x1_net13 4.24688f
Cbud_s2_510 net2 x2_x1_net14 4.64822f
Cbud_s2_511 net2 x2_x1_net15 4.64822f
Cbud_s2_512 net2 x2_x1_net16 4.64822f
Cbud_s2_513 net2 x2_x1_net17 4.64822f
Cbud_s2_514 net2 x2_x1_net18 4.64822f
Cbud_s2_515 net2 x2_x1_net19 4.64822f
Cbud_s2_516 net2 x2_x1_net2 2.718f
Cbud_s2_517 net2 x2_x1_net3 4.64822f
Cbud_s2_518 net2 x2_x1_net4 0.75291f
Cbud_s2_519 net2 x2_x1_net5 0.83889f
Cbud_s2_520 net2 x2_x1_net6 0.940486f
Cbud_s2_521 net2 x2_x1_net7 1.06172f
Cbud_s2_522 net2 x2_x1_net8 2.24628f
Cbud_s2_523 net2 x2_x1_net9 1.8875f
Cbud_s2_524 net2 x2_x2_net1 4.64822f
Cbud_s2_525 net2 x2_x2_net10 4.64822f
Cbud_s2_526 net2 x2_x2_net11 4.64822f
Cbud_s2_527 net2 x2_x2_net12 2.24628f
Cbud_s2_528 net2 x2_x2_net13 1.8875f
Cbud_s2_529 net2 x2_x2_net14 1.60829f
Cbud_s2_530 net2 x2_x2_net15 1.38674f
Cbud_s2_531 net2 x2_x2_net16 0.75291f
Cbud_s2_532 net2 x2_x2_net17 0.83889f
Cbud_s2_533 net2 x2_x2_net18 0.940486f
Cbud_s2_534 net2 x2_x2_net19 1.06172f
Cbud_s2_535 net2 x2_x2_net2 2.718f
Cbud_s2_536 net2 x2_x2_net3 1.208f
Cbud_s2_537 net2 x2_x2_net4 4.64822f
Cbud_s2_538 net2 x2_x2_net5 4.64822f
Cbud_s2_539 net2 x2_x2_net6 4.64822f
Cbud_s2_540 net2 x2_x2_net7 4.64822f
Cbud_s2_541 net2 x2_x2_net8 3.35556f
Cbud_s2_542 net2 x2_x2_net9 4.24688f
Cbud_s2_543 net2 Vm 1.19379f
Cbud_s2_544 net2 Vp 1.19379f
Cbud_s2_545 net3 net4 5.53033f
Cbud_s2_546 net3 net5 4.95777f
Cbud_s2_547 net3 x1_Vtest2 0.565278f
Cbud_s2_548 net3 x1_net1 0.565278f
Cbud_s2_549 net3 x1_net5 1.75295f
Cbud_s2_550 net3 x1_net6 1.75295f
Cbud_s2_551 net3 x1_net7 1.73817f
Cbud_s2_552 net3 x1_net8 1.73817f
Cbud_s2_553 net3 x2_net1 3.31341f
Cbud_s2_554 net3 x2_x1_net1 1.20801f
Cbud_s2_555 net3 x2_x1_net10 1.60829f
Cbud_s2_556 net3 x2_x1_net11 1.38674f
Cbud_s2_557 net3 x2_x1_net12 3.35557f
Cbud_s2_558 net3 x2_x1_net13 4.2469f
Cbud_s2_559 net3 x2_x1_net14 5.53033f
Cbud_s2_560 net3 x2_x1_net15 5.53033f
Cbud_s2_561 net3 x2_x1_net16 5.53033f
Cbud_s2_562 net3 x2_x1_net17 5.53033f
Cbud_s2_563 net3 x2_x1_net18 5.53033f
Cbud_s2_564 net3 x2_x1_net19 5.53033f
Cbud_s2_565 net3 x2_x1_net2 2.71801f
Cbud_s2_566 net3 x2_x1_net3 5.53033f
Cbud_s2_567 net3 x2_x1_net4 0.853412f
Cbud_s2_568 net3 x2_x1_net5 0.853412f
Cbud_s2_569 net3 x2_x1_net6 0.940489f
Cbud_s2_570 net3 x2_x1_net7 1.06172f
Cbud_s2_571 net3 x2_x1_net8 2.24629f
Cbud_s2_572 net3 x2_x1_net9 1.88751f
Cbud_s2_573 net3 x2_x2_net1 5.53033f
Cbud_s2_574 net3 x2_x2_net10 5.53033f
Cbud_s2_575 net3 x2_x2_net11 5.53033f
Cbud_s2_576 net3 x2_x2_net12 2.24629f
Cbud_s2_577 net3 x2_x2_net13 1.88751f
Cbud_s2_578 net3 x2_x2_net14 1.60829f
Cbud_s2_579 net3 x2_x2_net15 1.38674f
Cbud_s2_580 net3 x2_x2_net16 0.853412f
Cbud_s2_581 net3 x2_x2_net17 0.853412f
Cbud_s2_582 net3 x2_x2_net18 0.940489f
Cbud_s2_583 net3 x2_x2_net19 1.06172f
Cbud_s2_584 net3 x2_x2_net2 2.71801f
Cbud_s2_585 net3 x2_x2_net3 1.20801f
Cbud_s2_586 net3 x2_x2_net4 5.53033f
Cbud_s2_587 net3 x2_x2_net5 5.53033f
Cbud_s2_588 net3 x2_x2_net6 5.53033f
Cbud_s2_589 net3 x2_x2_net7 5.53033f
Cbud_s2_590 net3 x2_x2_net8 3.35557f
Cbud_s2_591 net3 x2_x2_net9 4.2469f
Cbud_s2_592 net4 net6 2.65975f
Cbud_s2_593 net4 x1_Vbias 5.10867f
Cbud_s2_594 net4 x1_Vtest2 0.565278f
Cbud_s2_595 net4 x1_net1 0.565278f
Cbud_s2_596 net4 x1_net5 3.54835f
Cbud_s2_597 net4 x1_net6 3.54835f
Cbud_s2_598 net4 x1_net7 1.73817f
Cbud_s2_599 net4 x1_net8 1.73817f
Cbud_s2_600 net4 x1_net9 8.59201f
Cbud_s2_601 net4 x2_Vcm 7.97714f
Cbud_s2_602 net4 x2_Vtest 6.7072f
Cbud_s2_603 net4 x2_net1 3.31341f
Cbud_s2_604 net4 x2_x1_net1 1.208f
Cbud_s2_605 net4 x2_x1_net10 1.60829f
Cbud_s2_606 net4 x2_x1_net11 1.38674f
Cbud_s2_607 net4 x2_x1_net12 3.35556f
Cbud_s2_608 net4 x2_x1_net13 4.24688f
Cbud_s2_609 net4 x2_x1_net14 5.54695f
Cbud_s2_610 net4 x2_x1_net15 6.75515f
Cbud_s2_611 net4 x2_x1_net16 6.75515f
Cbud_s2_612 net4 x2_x1_net17 6.75515f
Cbud_s2_613 net4 x2_x1_net18 6.75515f
Cbud_s2_614 net4 x2_x1_net19 6.75515f
Cbud_s2_615 net4 x2_x1_net2 2.718f
Cbud_s2_616 net4 x2_x1_net3 6.75515f
Cbud_s2_617 net4 x2_x1_net4 1.04242f
Cbud_s2_618 net4 x2_x1_net5 1.04242f
Cbud_s2_619 net4 x2_x1_net6 1.04242f
Cbud_s2_620 net4 x2_x1_net7 1.06172f
Cbud_s2_621 net4 x2_x1_net8 2.24628f
Cbud_s2_622 net4 x2_x1_net9 1.8875f
Cbud_s2_623 net4 x2_x2_net1 6.75515f
Cbud_s2_624 net4 x2_x2_net10 5.54695f
Cbud_s2_625 net4 x2_x2_net11 6.75515f
Cbud_s2_626 net4 x2_x2_net12 2.24628f
Cbud_s2_627 net4 x2_x2_net13 1.8875f
Cbud_s2_628 net4 x2_x2_net14 1.60829f
Cbud_s2_629 net4 x2_x2_net15 1.38674f
Cbud_s2_630 net4 x2_x2_net16 1.04242f
Cbud_s2_631 net4 x2_x2_net17 1.04242f
Cbud_s2_632 net4 x2_x2_net18 1.04242f
Cbud_s2_633 net4 x2_x2_net19 1.06172f
Cbud_s2_634 net4 x2_x2_net2 2.718f
Cbud_s2_635 net4 x2_x2_net3 1.208f
Cbud_s2_636 net4 x2_x2_net4 6.75515f
Cbud_s2_637 net4 x2_x2_net5 6.75515f
Cbud_s2_638 net4 x2_x2_net6 6.75515f
Cbud_s2_639 net4 x2_x2_net7 6.75515f
Cbud_s2_640 net4 x2_x2_net8 3.35556f
Cbud_s2_641 net4 x2_x2_net9 4.24688f
Cbud_s2_642 net4 Vm 1.19379f
Cbud_s2_643 net4 Vp 1.19379f
Cbud_s2_644 net5 x1_Vbias 4.95777f
Cbud_s2_645 net5 x1_Vtest2 0.565278f
Cbud_s2_646 net5 x1_net1 0.565278f
Cbud_s2_647 net5 x1_net5 2.86655f
Cbud_s2_648 net5 x1_net6 2.86655f
Cbud_s2_649 net5 x1_net7 1.73817f
Cbud_s2_650 net5 x1_net8 1.73817f
Cbud_s2_651 net5 x2_Vbiasp 3.95719f
Cbud_s2_652 net5 x2_Vcm 4.95777f
Cbud_s2_653 net5 x2_Vout 4.95777f
Cbud_s2_654 net5 x2_Vtest 4.95777f
Cbud_s2_655 net5 x2_x1_net1 1.208f
Cbud_s2_656 net5 x2_x1_net10 1.60829f
Cbud_s2_657 net5 x2_x1_net11 1.38674f
Cbud_s2_658 net5 x2_x1_net12 3.35556f
Cbud_s2_659 net5 x2_x1_net13 4.24689f
Cbud_s2_660 net5 x2_x1_net14 4.95777f
Cbud_s2_661 net5 x2_x1_net15 4.95777f
Cbud_s2_662 net5 x2_x1_net16 4.95777f
Cbud_s2_663 net5 x2_x1_net17 4.95777f
Cbud_s2_664 net5 x2_x1_net18 4.95777f
Cbud_s2_665 net5 x2_x1_net19 4.95777f
Cbud_s2_666 net5 x2_x1_net2 2.71801f
Cbud_s2_667 net5 x2_x1_net3 4.95777f
Cbud_s2_668 net5 x2_x1_net4 0.765056f
Cbud_s2_669 net5 x2_x1_net5 0.838891f
Cbud_s2_670 net5 x2_x1_net6 0.940487f
Cbud_s2_671 net5 x2_x1_net7 1.06172f
Cbud_s2_672 net5 x2_x1_net8 2.24629f
Cbud_s2_673 net5 x2_x1_net9 1.8875f
Cbud_s2_674 net5 x2_x2_net1 4.95777f
Cbud_s2_675 net5 x2_x2_net10 4.95777f
Cbud_s2_676 net5 x2_x2_net11 4.95777f
Cbud_s2_677 net5 x2_x2_net12 2.24629f
Cbud_s2_678 net5 x2_x2_net13 1.8875f
Cbud_s2_679 net5 x2_x2_net14 1.60829f
Cbud_s2_680 net5 x2_x2_net15 1.38674f
Cbud_s2_681 net5 x2_x2_net16 0.765056f
Cbud_s2_682 net5 x2_x2_net17 0.838891f
Cbud_s2_683 net5 x2_x2_net18 0.940487f
Cbud_s2_684 net5 x2_x2_net19 1.06172f
Cbud_s2_685 net5 x2_x2_net2 2.71801f
Cbud_s2_686 net5 x2_x2_net3 1.208f
Cbud_s2_687 net5 x2_x2_net4 4.95777f
Cbud_s2_688 net5 x2_x2_net5 4.95777f
Cbud_s2_689 net5 x2_x2_net6 4.95777f
Cbud_s2_690 net5 x2_x2_net7 4.95777f
Cbud_s2_691 net5 x2_x2_net8 3.35556f
Cbud_s2_692 net5 x2_x2_net9 4.24689f
Cbud_s2_693 net5 Vm 1.19379f
Cbud_s2_694 net5 Vp 1.19379f
Cbud_s2_695 net6 net7 2.65975f
Cbud_s2_696 net6 x1_Vbias 3.33995f
Cbud_s2_697 net6 x1_Vout 2.65975f
Cbud_s2_698 net6 x1_Vtest2 0.410438f
Cbud_s2_699 net6 x1_net1 0.410438f
Cbud_s2_700 net6 x1_net2 2.65975f
Cbud_s2_701 net6 x1_net3 1.75295f
Cbud_s2_702 net6 x1_net4 1.75295f
Cbud_s2_703 net6 x1_net5 1.75295f
Cbud_s2_704 net6 x1_net6 1.75295f
Cbud_s2_705 net6 x1_net7 1.73817f
Cbud_s2_706 net6 x1_net8 1.73817f
Cbud_s2_707 net6 x2_Vbiasp 2.65975f
Cbud_s2_708 net6 x2_Vcm 2.65975f
Cbud_s2_709 net6 x2_Vtest 2.65975f
Cbud_s2_710 net6 x2_net1 2.65975f
Cbud_s2_711 net6 x2_x1_net1 1.208f
Cbud_s2_712 net6 x2_x1_net10 1.60829f
Cbud_s2_713 net6 x2_x1_net11 1.38674f
Cbud_s2_714 net6 x2_x1_net12 2.65975f
Cbud_s2_715 net6 x2_x1_net13 2.65975f
Cbud_s2_716 net6 x2_x1_net14 2.65975f
Cbud_s2_717 net6 x2_x1_net15 2.65975f
Cbud_s2_718 net6 x2_x1_net16 2.65975f
Cbud_s2_719 net6 x2_x1_net17 2.65975f
Cbud_s2_720 net6 x2_x1_net18 2.65975f
Cbud_s2_721 net6 x2_x1_net19 2.65975f
Cbud_s2_722 net6 x2_x1_net2 2.65975f
Cbud_s2_723 net6 x2_x1_net3 2.65975f
Cbud_s2_724 net6 x2_x1_net4 0.75291f
Cbud_s2_725 net6 x2_x1_net5 0.83889f
Cbud_s2_726 net6 x2_x1_net6 0.940486f
Cbud_s2_727 net6 x2_x1_net7 1.06172f
Cbud_s2_728 net6 x2_x1_net8 2.24629f
Cbud_s2_729 net6 x2_x1_net9 1.8875f
Cbud_s2_730 net6 x2_x2_net1 2.65975f
Cbud_s2_731 net6 x2_x2_net10 2.65975f
Cbud_s2_732 net6 x2_x2_net11 2.65975f
Cbud_s2_733 net6 x2_x2_net12 2.24629f
Cbud_s2_734 net6 x2_x2_net13 1.8875f
Cbud_s2_735 net6 x2_x2_net14 1.60829f
Cbud_s2_736 net6 x2_x2_net15 1.38674f
Cbud_s2_737 net6 x2_x2_net16 0.75291f
Cbud_s2_738 net6 x2_x2_net17 0.83889f
Cbud_s2_739 net6 x2_x2_net18 0.940486f
Cbud_s2_740 net6 x2_x2_net19 1.06172f
Cbud_s2_741 net6 x2_x2_net2 2.65975f
Cbud_s2_742 net6 x2_x2_net3 1.208f
Cbud_s2_743 net6 x2_x2_net4 2.65975f
Cbud_s2_744 net6 x2_x2_net5 2.65975f
Cbud_s2_745 net6 x2_x2_net6 2.65975f
Cbud_s2_746 net6 x2_x2_net7 2.65975f
Cbud_s2_747 net6 x2_x2_net8 2.65975f
Cbud_s2_748 net6 x2_x2_net9 2.65975f
Cbud_s2_749 net6 Vm 1.19379f
Cbud_s2_750 net6 Vp 1.19379f
Cbud_s2_751 net7 x1_Vbias 2.65975f
Cbud_s2_752 net7 x1_Vtest2 0.410438f
Cbud_s2_753 net7 x1_net1 0.410438f
Cbud_s2_754 net7 x1_net2 2.65975f
Cbud_s2_755 net7 x1_net5 1.75295f
Cbud_s2_756 net7 x1_net6 1.75295f
Cbud_s2_757 net7 x1_net7 1.73817f
Cbud_s2_758 net7 x1_net8 1.73817f
Cbud_s2_759 net7 x2_x1_net1 1.208f
Cbud_s2_760 net7 x2_x1_net10 1.60829f
Cbud_s2_761 net7 x2_x1_net11 1.38674f
Cbud_s2_762 net7 x2_x1_net12 2.65975f
Cbud_s2_763 net7 x2_x1_net13 2.65975f
Cbud_s2_764 net7 x2_x1_net14 2.65975f
Cbud_s2_765 net7 x2_x1_net15 2.65975f
Cbud_s2_766 net7 x2_x1_net16 2.65975f
Cbud_s2_767 net7 x2_x1_net17 2.65975f
Cbud_s2_768 net7 x2_x1_net18 2.65975f
Cbud_s2_769 net7 x2_x1_net19 2.65975f
Cbud_s2_770 net7 x2_x1_net2 2.65975f
Cbud_s2_771 net7 x2_x1_net3 2.65975f
Cbud_s2_772 net7 x2_x1_net4 0.75291f
Cbud_s2_773 net7 x2_x1_net5 0.838891f
Cbud_s2_774 net7 x2_x1_net6 0.940486f
Cbud_s2_775 net7 x2_x1_net7 1.06172f
Cbud_s2_776 net7 x2_x1_net8 2.24629f
Cbud_s2_777 net7 x2_x1_net9 1.8875f
Cbud_s2_778 net7 x2_x2_net1 2.65975f
Cbud_s2_779 net7 x2_x2_net10 2.65975f
Cbud_s2_780 net7 x2_x2_net11 2.65975f
Cbud_s2_781 net7 x2_x2_net12 2.24629f
Cbud_s2_782 net7 x2_x2_net13 1.8875f
Cbud_s2_783 net7 x2_x2_net14 1.60829f
Cbud_s2_784 net7 x2_x2_net15 1.38674f
Cbud_s2_785 net7 x2_x2_net16 0.75291f
Cbud_s2_786 net7 x2_x2_net17 0.838891f
Cbud_s2_787 net7 x2_x2_net18 0.940486f
Cbud_s2_788 net7 x2_x2_net19 1.06172f
Cbud_s2_789 net7 x2_x2_net2 2.65975f
Cbud_s2_790 net7 x2_x2_net3 1.208f
Cbud_s2_791 net7 x2_x2_net4 2.65975f
Cbud_s2_792 net7 x2_x2_net5 2.65975f
Cbud_s2_793 net7 x2_x2_net6 2.65975f
Cbud_s2_794 net7 x2_x2_net7 2.65975f
Cbud_s2_795 net7 x2_x2_net8 2.65975f
Cbud_s2_796 net7 x2_x2_net9 2.65975f
Cbud_s2_797 x1_Vbias x1_Vtest2 1.09056f
Cbud_s2_798 x1_Vbias x1_net1 1.09056f
Cbud_s2_799 x1_Vbias x1_net2 3.50591f
Cbud_s2_800 x1_Vbias x1_net3 1.75295f
Cbud_s2_801 x1_Vbias x1_net5 1.75295f
Cbud_s2_802 x1_Vbias x1_net6 1.75295f
Cbud_s2_803 x1_Vbias x1_net7 1.73817f
Cbud_s2_804 x1_Vbias x1_net8 1.73817f
Cbud_s2_805 x1_Vbias x1_net9 5.10867f
Cbud_s2_806 x1_Vbias x2_Vcm 5.10867f
Cbud_s2_807 x1_Vbias x2_Vout 5.10867f
Cbud_s2_808 x1_Vbias x2_Vtest 5.10867f
Cbud_s2_809 x1_Vbias x2_net1 3.31341f
Cbud_s2_810 x1_Vbias x2_x1_net1 1.208f
Cbud_s2_811 x1_Vbias x2_x1_net10 1.60829f
Cbud_s2_812 x1_Vbias x2_x1_net11 1.38674f
Cbud_s2_813 x1_Vbias x2_x1_net12 3.35557f
Cbud_s2_814 x1_Vbias x2_x1_net13 4.24689f
Cbud_s2_815 x1_Vbias x2_x1_net14 5.10867f
Cbud_s2_816 x1_Vbias x2_x1_net15 5.10867f
Cbud_s2_817 x1_Vbias x2_x1_net16 5.10867f
Cbud_s2_818 x1_Vbias x2_x1_net17 5.10867f
Cbud_s2_819 x1_Vbias x2_x1_net18 5.10867f
Cbud_s2_820 x1_Vbias x2_x1_net19 5.10867f
Cbud_s2_821 x1_Vbias x2_x1_net2 2.71801f
Cbud_s2_822 x1_Vbias x2_x1_net3 5.10867f
Cbud_s2_823 x1_Vbias x2_x1_net4 0.788342f
Cbud_s2_824 x1_Vbias x2_x1_net5 0.838891f
Cbud_s2_825 x1_Vbias x2_x1_net6 0.940487f
Cbud_s2_826 x1_Vbias x2_x1_net7 1.06172f
Cbud_s2_827 x1_Vbias x2_x1_net8 2.24629f
Cbud_s2_828 x1_Vbias x2_x1_net9 1.88751f
Cbud_s2_829 x1_Vbias x2_x2_net1 5.10867f
Cbud_s2_830 x1_Vbias x2_x2_net10 5.10867f
Cbud_s2_831 x1_Vbias x2_x2_net11 5.10867f
Cbud_s2_832 x1_Vbias x2_x2_net12 2.24629f
Cbud_s2_833 x1_Vbias x2_x2_net13 1.88751f
Cbud_s2_834 x1_Vbias x2_x2_net14 1.60829f
Cbud_s2_835 x1_Vbias x2_x2_net15 1.38674f
Cbud_s2_836 x1_Vbias x2_x2_net16 0.788342f
Cbud_s2_837 x1_Vbias x2_x2_net17 0.838891f
Cbud_s2_838 x1_Vbias x2_x2_net18 0.940487f
Cbud_s2_839 x1_Vbias x2_x2_net19 1.06172f
Cbud_s2_840 x1_Vbias x2_x2_net2 2.71801f
Cbud_s2_841 x1_Vbias x2_x2_net3 1.208f
Cbud_s2_842 x1_Vbias x2_x2_net4 5.10867f
Cbud_s2_843 x1_Vbias x2_x2_net5 5.10867f
Cbud_s2_844 x1_Vbias x2_x2_net6 5.10867f
Cbud_s2_845 x1_Vbias x2_x2_net7 5.10867f
Cbud_s2_846 x1_Vbias x2_x2_net8 3.35557f
Cbud_s2_847 x1_Vbias x2_x2_net9 4.24689f
Cbud_s2_848 x1_Vbias Vm 1.19379f
Cbud_s2_849 x1_Vbias Vp 1.19379f
Cbud_s2_850 x1_Vout x1_Vtest2 1.61585f
Cbud_s2_851 x1_Vout x1_net1 1.61585f
Cbud_s2_852 x1_Vout x1_net3 1.75295f
Cbud_s2_853 x1_Vout x1_net4 1.75295f
Cbud_s2_854 x1_Vout x1_net5 1.75295f
Cbud_s2_855 x1_Vout x1_net6 1.75295f
Cbud_s2_856 x1_Vout x1_net7 1.73817f
Cbud_s2_857 x1_Vout x1_net8 1.73817f
Cbud_s2_858 x1_Vout x1_net9 10.3874f
Cbud_s2_859 x1_Vout x2_Vout 6.23194f
Cbud_s2_860 x1_Vout x2_Vtest 6.7072f
Cbud_s2_861 x1_Vout x2_x1_net1 1.208f
Cbud_s2_862 x1_Vout x2_x1_net10 1.60829f
Cbud_s2_863 x1_Vout x2_x1_net11 1.38674f
Cbud_s2_864 x1_Vout x2_x1_net12 3.35557f
Cbud_s2_865 x1_Vout x2_x1_net13 4.24689f
Cbud_s2_866 x1_Vout x2_x1_net14 5.54696f
Cbud_s2_867 x1_Vout x2_x1_net15 6.75515f
Cbud_s2_868 x1_Vout x2_x1_net16 6.75515f
Cbud_s2_869 x1_Vout x2_x1_net17 6.75515f
Cbud_s2_870 x1_Vout x2_x1_net18 6.75515f
Cbud_s2_871 x1_Vout x2_x1_net19 6.75515f
Cbud_s2_872 x1_Vout x2_x1_net2 2.71801f
Cbud_s2_873 x1_Vout x2_x1_net3 6.75515f
Cbud_s2_874 x1_Vout x2_x1_net4 1.04242f
Cbud_s2_875 x1_Vout x2_x1_net5 1.04242f
Cbud_s2_876 x1_Vout x2_x1_net6 1.04242f
Cbud_s2_877 x1_Vout x2_x1_net7 1.06172f
Cbud_s2_878 x1_Vout x2_x1_net8 2.24629f
Cbud_s2_879 x1_Vout x2_x1_net9 1.88751f
Cbud_s2_880 x1_Vout x2_x2_net1 6.75515f
Cbud_s2_881 x1_Vout x2_x2_net10 5.54696f
Cbud_s2_882 x1_Vout x2_x2_net11 6.75515f
Cbud_s2_883 x1_Vout x2_x2_net12 2.24629f
Cbud_s2_884 x1_Vout x2_x2_net13 1.88751f
Cbud_s2_885 x1_Vout x2_x2_net14 1.60829f
Cbud_s2_886 x1_Vout x2_x2_net15 1.38674f
Cbud_s2_887 x1_Vout x2_x2_net16 1.04242f
Cbud_s2_888 x1_Vout x2_x2_net17 1.04242f
Cbud_s2_889 x1_Vout x2_x2_net18 1.04242f
Cbud_s2_890 x1_Vout x2_x2_net19 1.06172f
Cbud_s2_891 x1_Vout x2_x2_net2 2.71801f
Cbud_s2_892 x1_Vout x2_x2_net3 1.208f
Cbud_s2_893 x1_Vout x2_x2_net4 6.75515f
Cbud_s2_894 x1_Vout x2_x2_net5 6.75515f
Cbud_s2_895 x1_Vout x2_x2_net6 6.75515f
Cbud_s2_896 x1_Vout x2_x2_net7 6.75515f
Cbud_s2_897 x1_Vout x2_x2_net8 3.35557f
Cbud_s2_898 x1_Vout x2_x2_net9 4.24689f
Cbud_s2_899 x1_Vtest2 x1_net1 0.565278f
Cbud_s2_900 x1_Vtest2 x1_net2 0.645545f
Cbud_s2_901 x1_Vtest2 x1_net3 0.270506f
Cbud_s2_902 x1_Vtest2 x1_net4 0.270506f
Cbud_s2_903 x1_Vtest2 x1_net5 0.654174f
Cbud_s2_904 x1_Vtest2 x1_net6 0.270506f
Cbud_s2_905 x1_Vtest2 x1_net8 0.565278f
Cbud_s2_906 x1_Vtest2 x1_net9 0.565278f
Cbud_s2_907 x1_Vtest2 x2_Vbiasp 0.565278f
Cbud_s2_908 x1_Vtest2 x2_Vcm 0.565278f
Cbud_s2_909 x1_Vtest2 x2_Vout 0.565278f
Cbud_s2_910 x1_Vtest2 x2_Vtest 0.565278f
Cbud_s2_911 x1_Vtest2 x2_net1 0.511307f
Cbud_s2_912 x1_Vtest2 x2_x1_net16 0.565278f
Cbud_s2_913 x1_Vtest2 x2_x1_net17 0.565278f
Cbud_s2_914 x1_Vtest2 x2_x1_net18 0.565278f
Cbud_s2_915 x1_Vtest2 x2_x2_net1 0.565278f
Cbud_s2_916 x1_Vtest2 x2_x2_net10 0.565278f
Cbud_s2_917 x1_Vtest2 x2_x2_net11 0.565278f
Cbud_s2_918 x1_Vtest2 x2_x2_net12 0.565278f
Cbud_s2_919 x1_Vtest2 x2_x2_net13 0.565278f
Cbud_s2_920 x1_Vtest2 x2_x2_net14 0.565278f
Cbud_s2_921 x1_Vtest2 x2_x2_net15 0.565278f
Cbud_s2_922 x1_Vtest2 x2_x2_net16 0.565278f
Cbud_s2_923 x1_Vtest2 x2_x2_net17 0.565278f
Cbud_s2_924 x1_Vtest2 x2_x2_net18 0.565278f
Cbud_s2_925 x1_Vtest2 x2_x2_net19 0.565278f
Cbud_s2_926 x1_Vtest2 x2_x2_net2 0.565278f
Cbud_s2_927 x1_Vtest2 x2_x2_net3 0.565278f
Cbud_s2_928 x1_Vtest2 x2_x2_net4 0.565278f
Cbud_s2_929 x1_Vtest2 x2_x2_net5 0.565278f
Cbud_s2_930 x1_Vtest2 x2_x2_net6 0.565278f
Cbud_s2_931 x1_Vtest2 x2_x2_net7 0.565278f
Cbud_s2_932 x1_Vtest2 x2_x2_net8 0.565278f
Cbud_s2_933 x1_Vtest2 x2_x2_net9 0.565278f
Cbud_s2_934 x1_Vtest2 Vm 1.19915f
Cbud_s2_935 x1_Vtest2 Vp 0.184219f
Cbud_s2_936 x1_net1 x1_net2 0.645545f
Cbud_s2_937 x1_net1 x1_net3 0.270506f
Cbud_s2_938 x1_net1 x1_net4 0.270506f
Cbud_s2_939 x1_net1 x1_net5 0.270506f
Cbud_s2_940 x1_net1 x1_net6 0.654174f
Cbud_s2_941 x1_net1 x1_net7 0.565278f
Cbud_s2_942 x1_net1 x1_net9 0.565278f
Cbud_s2_943 x1_net1 x2_Vbiasp 0.565278f
Cbud_s2_944 x1_net1 x2_Vcm 0.565278f
Cbud_s2_945 x1_net1 x2_Vout 0.565278f
Cbud_s2_946 x1_net1 x2_Vtest 0.565278f
Cbud_s2_947 x1_net1 x2_net1 0.511307f
Cbud_s2_948 x1_net1 x2_x1_net1 0.565278f
Cbud_s2_949 x1_net1 x2_x1_net10 0.565278f
Cbud_s2_950 x1_net1 x2_x1_net11 0.565278f
Cbud_s2_951 x1_net1 x2_x1_net12 0.565278f
Cbud_s2_952 x1_net1 x2_x1_net13 0.565278f
Cbud_s2_953 x1_net1 x2_x1_net14 0.565278f
Cbud_s2_954 x1_net1 x2_x1_net15 0.565278f
Cbud_s2_955 x1_net1 x2_x1_net16 0.565278f
Cbud_s2_956 x1_net1 x2_x1_net17 0.565278f
Cbud_s2_957 x1_net1 x2_x1_net18 0.565278f
Cbud_s2_958 x1_net1 x2_x1_net19 0.565278f
Cbud_s2_959 x1_net1 x2_x1_net2 0.565278f
Cbud_s2_960 x1_net1 x2_x1_net3 0.565278f
Cbud_s2_961 x1_net1 x2_x1_net4 0.565278f
Cbud_s2_962 x1_net1 x2_x1_net5 0.565278f
Cbud_s2_963 x1_net1 x2_x1_net6 0.565278f
Cbud_s2_964 x1_net1 x2_x1_net7 0.565278f
Cbud_s2_965 x1_net1 x2_x1_net8 0.565278f
Cbud_s2_966 x1_net1 x2_x1_net9 0.565278f
Cbud_s2_967 x1_net1 x2_x2_net4 0.565278f
Cbud_s2_968 x1_net1 x2_x2_net5 0.565278f
Cbud_s2_969 x1_net1 x2_x2_net6 0.565278f
Cbud_s2_970 x1_net1 Vm 0.184219f
Cbud_s2_971 x1_net1 Vp 1.19915f
Cbud_s2_972 x1_net2 x1_net5 1.75295f
Cbud_s2_973 x1_net2 x1_net6 1.75295f
Cbud_s2_974 x1_net2 x1_net7 1.73817f
Cbud_s2_975 x1_net2 x1_net8 1.73817f
Cbud_s2_976 x1_net2 x2_Vbiasp 3.50591f
Cbud_s2_977 x1_net2 x2_x1_net1 1.208f
Cbud_s2_978 x1_net2 x2_x1_net10 1.60829f
Cbud_s2_979 x1_net2 x2_x1_net11 1.38674f
Cbud_s2_980 x1_net2 x2_x1_net12 3.35556f
Cbud_s2_981 x1_net2 x2_x1_net13 3.50591f
Cbud_s2_982 x1_net2 x2_x1_net14 3.50591f
Cbud_s2_983 x1_net2 x2_x1_net15 3.50591f
Cbud_s2_984 x1_net2 x2_x1_net16 3.50591f
Cbud_s2_985 x1_net2 x2_x1_net17 3.50591f
Cbud_s2_986 x1_net2 x2_x1_net18 3.50591f
Cbud_s2_987 x1_net2 x2_x1_net19 3.50591f
Cbud_s2_988 x1_net2 x2_x1_net2 2.71801f
Cbud_s2_989 x1_net2 x2_x1_net3 3.50591f
Cbud_s2_990 x1_net2 x2_x1_net4 0.75291f
Cbud_s2_991 x1_net2 x2_x1_net5 0.83889f
Cbud_s2_992 x1_net2 x2_x1_net6 0.940486f
Cbud_s2_993 x1_net2 x2_x1_net7 1.06172f
Cbud_s2_994 x1_net2 x2_x1_net8 2.24629f
Cbud_s2_995 x1_net2 x2_x1_net9 1.8875f
Cbud_s2_996 x1_net2 x2_x2_net1 3.50591f
Cbud_s2_997 x1_net2 x2_x2_net10 3.50591f
Cbud_s2_998 x1_net2 x2_x2_net11 3.50591f
Cbud_s2_999 x1_net2 x2_x2_net12 2.24629f
Cbud_s2_1000 x1_net2 x2_x2_net13 1.8875f
Cbud_s2_1001 x1_net2 x2_x2_net14 1.60829f
Cbud_s2_1002 x1_net2 x2_x2_net15 1.38674f
Cbud_s2_1003 x1_net2 x2_x2_net16 0.75291f
Cbud_s2_1004 x1_net2 x2_x2_net17 0.83889f
Cbud_s2_1005 x1_net2 x2_x2_net18 0.940486f
Cbud_s2_1006 x1_net2 x2_x2_net19 1.06172f
Cbud_s2_1007 x1_net2 x2_x2_net2 2.71801f
Cbud_s2_1008 x1_net2 x2_x2_net3 1.208f
Cbud_s2_1009 x1_net2 x2_x2_net4 3.50591f
Cbud_s2_1010 x1_net2 x2_x2_net5 3.50591f
Cbud_s2_1011 x1_net2 x2_x2_net6 3.50591f
Cbud_s2_1012 x1_net2 x2_x2_net7 3.50591f
Cbud_s2_1013 x1_net2 x2_x2_net8 3.35556f
Cbud_s2_1014 x1_net2 x2_x2_net9 3.50591f
Cbud_s2_1015 x1_net3 x1_net5 1.75295f
Cbud_s2_1016 x1_net3 x1_net6 1.75295f
Cbud_s2_1017 x1_net3 x1_net7 1.73817f
Cbud_s2_1018 x1_net3 x1_net8 1.73817f
Cbud_s2_1019 x1_net3 x2_Vbiasp 1.75295f
Cbud_s2_1020 x1_net3 x2_net1 1.75295f
Cbud_s2_1021 x1_net3 x2_x1_net1 1.208f
Cbud_s2_1022 x1_net3 x2_x1_net10 1.60829f
Cbud_s2_1023 x1_net3 x2_x1_net11 1.38674f
Cbud_s2_1024 x1_net3 x2_x1_net12 1.75295f
Cbud_s2_1025 x1_net3 x2_x1_net13 1.75295f
Cbud_s2_1026 x1_net3 x2_x1_net14 1.75295f
Cbud_s2_1027 x1_net3 x2_x1_net15 1.75295f
Cbud_s2_1028 x1_net3 x2_x1_net16 1.75295f
Cbud_s2_1029 x1_net3 x2_x1_net17 1.75295f
Cbud_s2_1030 x1_net3 x2_x1_net18 1.75295f
Cbud_s2_1031 x1_net3 x2_x1_net19 1.75295f
Cbud_s2_1032 x1_net3 x2_x1_net2 1.75295f
Cbud_s2_1033 x1_net3 x2_x1_net3 1.75295f
Cbud_s2_1034 x1_net3 x2_x1_net4 0.75291f
Cbud_s2_1035 x1_net3 x2_x1_net5 0.838891f
Cbud_s2_1036 x1_net3 x2_x1_net6 0.940487f
Cbud_s2_1037 x1_net3 x2_x1_net7 1.06172f
Cbud_s2_1038 x1_net3 x2_x1_net8 1.75295f
Cbud_s2_1039 x1_net3 x2_x1_net9 1.75295f
Cbud_s2_1040 x1_net3 x2_x2_net1 1.75295f
Cbud_s2_1041 x1_net3 x2_x2_net10 1.75295f
Cbud_s2_1042 x1_net3 x2_x2_net11 1.75295f
Cbud_s2_1043 x1_net3 x2_x2_net12 1.75295f
Cbud_s2_1044 x1_net3 x2_x2_net13 1.75295f
Cbud_s2_1045 x1_net3 x2_x2_net14 1.60829f
Cbud_s2_1046 x1_net3 x2_x2_net15 1.38674f
Cbud_s2_1047 x1_net3 x2_x2_net16 0.75291f
Cbud_s2_1048 x1_net3 x2_x2_net17 0.838891f
Cbud_s2_1049 x1_net3 x2_x2_net18 0.940487f
Cbud_s2_1050 x1_net3 x2_x2_net19 1.06172f
Cbud_s2_1051 x1_net3 x2_x2_net2 1.75295f
Cbud_s2_1052 x1_net3 x2_x2_net3 1.208f
Cbud_s2_1053 x1_net3 x2_x2_net4 1.75295f
Cbud_s2_1054 x1_net3 x2_x2_net5 1.75295f
Cbud_s2_1055 x1_net3 x2_x2_net6 1.75295f
Cbud_s2_1056 x1_net3 x2_x2_net7 1.75295f
Cbud_s2_1057 x1_net3 x2_x2_net8 1.75295f
Cbud_s2_1058 x1_net3 x2_x2_net9 1.75295f
Cbud_s2_1059 x1_net3 Vm 1.19379f
Cbud_s2_1060 x1_net4 x1_net5 1.75295f
Cbud_s2_1061 x1_net4 x1_net6 1.75295f
Cbud_s2_1062 x1_net4 x1_net7 1.73817f
Cbud_s2_1063 x1_net4 x1_net8 1.73817f
Cbud_s2_1064 x1_net4 x2_Vbiasp 1.75295f
Cbud_s2_1065 x1_net4 x2_Vtest 1.75295f
Cbud_s2_1066 x1_net4 x2_net1 1.75295f
Cbud_s2_1067 x1_net4 x2_x1_net1 1.208f
Cbud_s2_1068 x1_net4 x2_x1_net10 1.60829f
Cbud_s2_1069 x1_net4 x2_x1_net11 1.38674f
Cbud_s2_1070 x1_net4 x2_x1_net12 1.75295f
Cbud_s2_1071 x1_net4 x2_x1_net13 1.75295f
Cbud_s2_1072 x1_net4 x2_x1_net14 1.75295f
Cbud_s2_1073 x1_net4 x2_x1_net15 1.75295f
Cbud_s2_1074 x1_net4 x2_x1_net16 1.75295f
Cbud_s2_1075 x1_net4 x2_x1_net17 1.75295f
Cbud_s2_1076 x1_net4 x2_x1_net18 1.75295f
Cbud_s2_1077 x1_net4 x2_x1_net19 1.75295f
Cbud_s2_1078 x1_net4 x2_x1_net2 1.75295f
Cbud_s2_1079 x1_net4 x2_x1_net3 1.75295f
Cbud_s2_1080 x1_net4 x2_x1_net4 0.75291f
Cbud_s2_1081 x1_net4 x2_x1_net5 0.838891f
Cbud_s2_1082 x1_net4 x2_x1_net6 0.940487f
Cbud_s2_1083 x1_net4 x2_x1_net7 1.06172f
Cbud_s2_1084 x1_net4 x2_x1_net8 1.75295f
Cbud_s2_1085 x1_net4 x2_x1_net9 1.75295f
Cbud_s2_1086 x1_net4 x2_x2_net1 1.75295f
Cbud_s2_1087 x1_net4 x2_x2_net10 1.75295f
Cbud_s2_1088 x1_net4 x2_x2_net11 1.75295f
Cbud_s2_1089 x1_net4 x2_x2_net12 1.75295f
Cbud_s2_1090 x1_net4 x2_x2_net13 1.75295f
Cbud_s2_1091 x1_net4 x2_x2_net14 1.60829f
Cbud_s2_1092 x1_net4 x2_x2_net15 1.38674f
Cbud_s2_1093 x1_net4 x2_x2_net16 0.75291f
Cbud_s2_1094 x1_net4 x2_x2_net17 0.838891f
Cbud_s2_1095 x1_net4 x2_x2_net18 0.940487f
Cbud_s2_1096 x1_net4 x2_x2_net19 1.06172f
Cbud_s2_1097 x1_net4 x2_x2_net2 1.75295f
Cbud_s2_1098 x1_net4 x2_x2_net3 1.208f
Cbud_s2_1099 x1_net4 x2_x2_net4 1.75295f
Cbud_s2_1100 x1_net4 x2_x2_net5 1.75295f
Cbud_s2_1101 x1_net4 x2_x2_net6 1.75295f
Cbud_s2_1102 x1_net4 x2_x2_net7 1.75295f
Cbud_s2_1103 x1_net4 x2_x2_net8 1.75295f
Cbud_s2_1104 x1_net4 x2_x2_net9 1.75295f
Cbud_s2_1105 x1_net5 x1_net6 1.75295f
Cbud_s2_1106 x1_net5 x1_net7 0.929828f
Cbud_s2_1107 x1_net5 x1_net9 1.75295f
Cbud_s2_1108 x1_net5 x2_Vbiasp 1.75295f
Cbud_s2_1109 x1_net5 x2_Vcm 1.75295f
Cbud_s2_1110 x1_net5 x2_Vout 1.75295f
Cbud_s2_1111 x1_net5 x2_Vtest 1.75295f
Cbud_s2_1112 x1_net5 x2_net1 1.75295f
Cbud_s2_1113 x1_net5 x2_x2_net1 0.555265f
Cbud_s2_1114 x1_net5 x2_x2_net10 0.396912f
Cbud_s2_1115 x1_net5 x2_x2_net11 0.462928f
Cbud_s2_1116 x1_net5 x2_x2_net12 0.270506f
Cbud_s2_1117 x1_net5 x2_x2_net13 0.270506f
Cbud_s2_1118 x1_net5 x2_x2_net14 0.270506f
Cbud_s2_1119 x1_net5 x2_x2_net15 0.270506f
Cbud_s2_1120 x1_net5 x2_x2_net16 0.270506f
Cbud_s2_1121 x1_net5 x2_x2_net17 0.270506f
Cbud_s2_1122 x1_net5 x2_x2_net18 0.270506f
Cbud_s2_1123 x1_net5 x2_x2_net19 0.270506f
Cbud_s2_1124 x1_net5 x2_x2_net2 0.277958f
Cbud_s2_1125 x1_net5 x2_x2_net3 0.270506f
Cbud_s2_1126 x1_net5 x2_x2_net4 1.75295f
Cbud_s2_1127 x1_net5 x2_x2_net5 1.38192f
Cbud_s2_1128 x1_net5 x2_x2_net6 0.923639f
Cbud_s2_1129 x1_net5 x2_x2_net7 0.693589f
Cbud_s2_1130 x1_net5 x2_x2_net8 0.308814f
Cbud_s2_1131 x1_net5 x2_x2_net9 0.347368f
Cbud_s2_1132 x1_net5 Vp 0.849546f
Cbud_s2_1133 x1_net6 x1_net8 0.929828f
Cbud_s2_1134 x1_net6 x1_net9 1.75295f
Cbud_s2_1135 x1_net6 x2_Vbiasp 1.75295f
Cbud_s2_1136 x1_net6 x2_Vcm 1.75295f
Cbud_s2_1137 x1_net6 x2_Vout 1.75295f
Cbud_s2_1138 x1_net6 x2_Vtest 1.75295f
Cbud_s2_1139 x1_net6 x2_net1 1.75295f
Cbud_s2_1140 x1_net6 x2_x1_net1 0.270506f
Cbud_s2_1141 x1_net6 x2_x1_net10 0.270506f
Cbud_s2_1142 x1_net6 x2_x1_net11 0.270506f
Cbud_s2_1143 x1_net6 x2_x1_net12 0.308814f
Cbud_s2_1144 x1_net6 x2_x1_net13 0.347368f
Cbud_s2_1145 x1_net6 x2_x1_net14 0.396912f
Cbud_s2_1146 x1_net6 x2_x1_net15 0.462928f
Cbud_s2_1147 x1_net6 x2_x1_net16 1.75295f
Cbud_s2_1148 x1_net6 x2_x1_net17 1.38192f
Cbud_s2_1149 x1_net6 x2_x1_net18 0.923639f
Cbud_s2_1150 x1_net6 x2_x1_net19 0.693589f
Cbud_s2_1151 x1_net6 x2_x1_net2 0.277958f
Cbud_s2_1152 x1_net6 x2_x1_net3 0.555265f
Cbud_s2_1153 x1_net6 x2_x1_net4 0.270506f
Cbud_s2_1154 x1_net6 x2_x1_net5 0.270506f
Cbud_s2_1155 x1_net6 x2_x1_net6 0.270506f
Cbud_s2_1156 x1_net6 x2_x1_net7 0.270506f
Cbud_s2_1157 x1_net6 x2_x1_net8 0.270506f
Cbud_s2_1158 x1_net6 x2_x1_net9 0.270506f
Cbud_s2_1159 x1_net6 Vm 0.849546f
Cbud_s2_1160 x1_net7 x1_net8 1.05319f
Cbud_s2_1161 x1_net7 x1_net9 1.73818f
Cbud_s2_1162 x1_net7 x2_Vbiasp 1.73817f
Cbud_s2_1163 x1_net7 x2_Vcm 1.73817f
Cbud_s2_1164 x1_net7 x2_Vout 1.73801f
Cbud_s2_1165 x1_net7 x2_Vtest 1.73816f
Cbud_s2_1166 x1_net7 x2_net1 1.73815f
Cbud_s2_1167 x1_net7 x2_x1_net1 1.04242f
Cbud_s2_1168 x1_net7 x2_x1_net10 1.04242f
Cbud_s2_1169 x1_net7 x2_x1_net11 1.04242f
Cbud_s2_1170 x1_net7 x2_x1_net12 1.04242f
Cbud_s2_1171 x1_net7 x2_x1_net13 1.04242f
Cbud_s2_1172 x1_net7 x2_x1_net14 1.04242f
Cbud_s2_1173 x1_net7 x2_x1_net15 1.04242f
Cbud_s2_1174 x1_net7 x2_x1_net16 1.04242f
Cbud_s2_1175 x1_net7 x2_x1_net17 1.04242f
Cbud_s2_1176 x1_net7 x2_x1_net18 1.04242f
Cbud_s2_1177 x1_net7 x2_x1_net19 1.04242f
Cbud_s2_1178 x1_net7 x2_x1_net2 1.04242f
Cbud_s2_1179 x1_net7 x2_x1_net3 1.04242f
Cbud_s2_1180 x1_net7 x2_x1_net4 1.04242f
Cbud_s2_1181 x1_net7 x2_x1_net5 1.04242f
Cbud_s2_1182 x1_net7 x2_x1_net6 1.04242f
Cbud_s2_1183 x1_net7 x2_x1_net7 1.04242f
Cbud_s2_1184 x1_net7 x2_x1_net8 1.04242f
Cbud_s2_1185 x1_net7 x2_x1_net9 1.04242f
Cbud_s2_1186 x1_net7 Vm 0.312215f
Cbud_s2_1187 x1_net8 x1_net9 1.73818f
Cbud_s2_1188 x1_net8 x2_Vbiasp 1.73817f
Cbud_s2_1189 x1_net8 x2_Vcm 1.73817f
Cbud_s2_1190 x1_net8 x2_Vout 1.73801f
Cbud_s2_1191 x1_net8 x2_Vtest 1.73816f
Cbud_s2_1192 x1_net8 x2_net1 1.73815f
Cbud_s2_1193 x1_net8 x2_x2_net1 1.04242f
Cbud_s2_1194 x1_net8 x2_x2_net10 1.04242f
Cbud_s2_1195 x1_net8 x2_x2_net11 1.04242f
Cbud_s2_1196 x1_net8 x2_x2_net12 1.04242f
Cbud_s2_1197 x1_net8 x2_x2_net13 1.04242f
Cbud_s2_1198 x1_net8 x2_x2_net14 1.04242f
Cbud_s2_1199 x1_net8 x2_x2_net15 1.04242f
Cbud_s2_1200 x1_net8 x2_x2_net16 1.04242f
Cbud_s2_1201 x1_net8 x2_x2_net17 1.04242f
Cbud_s2_1202 x1_net8 x2_x2_net18 1.04242f
Cbud_s2_1203 x1_net8 x2_x2_net19 1.04242f
Cbud_s2_1204 x1_net8 x2_x2_net2 1.04242f
Cbud_s2_1205 x1_net8 x2_x2_net3 1.04242f
Cbud_s2_1206 x1_net8 x2_x2_net4 1.04242f
Cbud_s2_1207 x1_net8 x2_x2_net5 1.04242f
Cbud_s2_1208 x1_net8 x2_x2_net6 1.04242f
Cbud_s2_1209 x1_net8 x2_x2_net7 1.04242f
Cbud_s2_1210 x1_net8 x2_x2_net8 1.04242f
Cbud_s2_1211 x1_net8 x2_x2_net9 1.04242f
Cbud_s2_1212 x1_net8 Vp 0.312215f
Cbud_s2_1213 x1_net9 x2_Vcm 7.97714f
Cbud_s2_1214 x1_net9 x2_Vtest 6.7072f
Cbud_s2_1215 x1_net9 x2_x1_net1 1.208f
Cbud_s2_1216 x1_net9 x2_x1_net10 1.60829f
Cbud_s2_1217 x1_net9 x2_x1_net11 1.38674f
Cbud_s2_1218 x1_net9 x2_x1_net12 3.35557f
Cbud_s2_1219 x1_net9 x2_x1_net13 4.24689f
Cbud_s2_1220 x1_net9 x2_x1_net14 5.54696f
Cbud_s2_1221 x1_net9 x2_x1_net15 6.75515f
Cbud_s2_1222 x1_net9 x2_x1_net16 6.75515f
Cbud_s2_1223 x1_net9 x2_x1_net17 6.75515f
Cbud_s2_1224 x1_net9 x2_x1_net18 6.75515f
Cbud_s2_1225 x1_net9 x2_x1_net19 6.75515f
Cbud_s2_1226 x1_net9 x2_x1_net2 2.71801f
Cbud_s2_1227 x1_net9 x2_x1_net3 6.75515f
Cbud_s2_1228 x1_net9 x2_x1_net4 1.04242f
Cbud_s2_1229 x1_net9 x2_x1_net5 1.04242f
Cbud_s2_1230 x1_net9 x2_x1_net6 1.04242f
Cbud_s2_1231 x1_net9 x2_x1_net7 1.06172f
Cbud_s2_1232 x1_net9 x2_x1_net8 2.24629f
Cbud_s2_1233 x1_net9 x2_x1_net9 1.88751f
Cbud_s2_1234 x1_net9 x2_x2_net1 6.75515f
Cbud_s2_1235 x1_net9 x2_x2_net10 5.54696f
Cbud_s2_1236 x1_net9 x2_x2_net11 6.75515f
Cbud_s2_1237 x1_net9 x2_x2_net12 2.24629f
Cbud_s2_1238 x1_net9 x2_x2_net13 1.88751f
Cbud_s2_1239 x1_net9 x2_x2_net14 1.60829f
Cbud_s2_1240 x1_net9 x2_x2_net15 1.38674f
Cbud_s2_1241 x1_net9 x2_x2_net16 1.04242f
Cbud_s2_1242 x1_net9 x2_x2_net17 1.04242f
Cbud_s2_1243 x1_net9 x2_x2_net18 1.04242f
Cbud_s2_1244 x1_net9 x2_x2_net19 1.06172f
Cbud_s2_1245 x1_net9 x2_x2_net2 2.71801f
Cbud_s2_1246 x1_net9 x2_x2_net3 1.208f
Cbud_s2_1247 x1_net9 x2_x2_net4 6.75515f
Cbud_s2_1248 x1_net9 x2_x2_net5 6.75515f
Cbud_s2_1249 x1_net9 x2_x2_net6 6.75515f
Cbud_s2_1250 x1_net9 x2_x2_net7 6.75515f
Cbud_s2_1251 x1_net9 x2_x2_net8 3.35557f
Cbud_s2_1252 x1_net9 x2_x2_net9 4.24689f
Cbud_s2_1253 x1_net9 Vm 1.19379f
Cbud_s2_1254 x1_net9 Vp 1.19379f
Cbud_s2_1255 x2_Vbiasp x2_Vcm 3.95719f
Cbud_s2_1256 x2_Vbiasp x2_x1_net1 1.208f
Cbud_s2_1257 x2_Vbiasp x2_x1_net10 1.60829f
Cbud_s2_1258 x2_Vbiasp x2_x1_net11 1.38674f
Cbud_s2_1259 x2_Vbiasp x2_x1_net12 3.35556f
Cbud_s2_1260 x2_Vbiasp x2_x1_net13 3.95719f
Cbud_s2_1261 x2_Vbiasp x2_x1_net14 3.95719f
Cbud_s2_1262 x2_Vbiasp x2_x1_net15 3.95719f
Cbud_s2_1263 x2_Vbiasp x2_x1_net16 3.95719f
Cbud_s2_1264 x2_Vbiasp x2_x1_net17 3.95719f
Cbud_s2_1265 x2_Vbiasp x2_x1_net18 3.95719f
Cbud_s2_1266 x2_Vbiasp x2_x1_net19 3.95719f
Cbud_s2_1267 x2_Vbiasp x2_x1_net2 2.718f
Cbud_s2_1268 x2_Vbiasp x2_x1_net3 3.95719f
Cbud_s2_1269 x2_Vbiasp x2_x1_net4 0.75291f
Cbud_s2_1270 x2_Vbiasp x2_x1_net5 0.83889f
Cbud_s2_1271 x2_Vbiasp x2_x1_net6 0.940486f
Cbud_s2_1272 x2_Vbiasp x2_x1_net7 1.06172f
Cbud_s2_1273 x2_Vbiasp x2_x1_net8 2.24628f
Cbud_s2_1274 x2_Vbiasp x2_x1_net9 1.8875f
Cbud_s2_1275 x2_Vbiasp x2_x2_net1 3.95719f
Cbud_s2_1276 x2_Vbiasp x2_x2_net10 3.95719f
Cbud_s2_1277 x2_Vbiasp x2_x2_net11 3.95719f
Cbud_s2_1278 x2_Vbiasp x2_x2_net12 2.24628f
Cbud_s2_1279 x2_Vbiasp x2_x2_net13 1.8875f
Cbud_s2_1280 x2_Vbiasp x2_x2_net14 1.60829f
Cbud_s2_1281 x2_Vbiasp x2_x2_net15 1.38674f
Cbud_s2_1282 x2_Vbiasp x2_x2_net16 0.75291f
Cbud_s2_1283 x2_Vbiasp x2_x2_net17 0.83889f
Cbud_s2_1284 x2_Vbiasp x2_x2_net18 0.940486f
Cbud_s2_1285 x2_Vbiasp x2_x2_net19 1.06172f
Cbud_s2_1286 x2_Vbiasp x2_x2_net2 2.718f
Cbud_s2_1287 x2_Vbiasp x2_x2_net3 1.208f
Cbud_s2_1288 x2_Vbiasp x2_x2_net4 3.95719f
Cbud_s2_1289 x2_Vbiasp x2_x2_net5 3.95719f
Cbud_s2_1290 x2_Vbiasp x2_x2_net6 3.95719f
Cbud_s2_1291 x2_Vbiasp x2_x2_net7 3.95719f
Cbud_s2_1292 x2_Vbiasp x2_x2_net8 3.35556f
Cbud_s2_1293 x2_Vbiasp x2_x2_net9 3.95719f
Cbud_s2_1294 x2_Vbiasp Vm 1.19379f
Cbud_s2_1295 x2_Vbiasp Vp 1.19379f
Cbud_s2_1296 x2_Vcm x2_Vtest 8.5026f
Cbud_s2_1297 x2_Vcm x2_x1_net1 1.208f
Cbud_s2_1298 x2_Vcm x2_x1_net10 1.60829f
Cbud_s2_1299 x2_Vcm x2_x1_net11 1.38674f
Cbud_s2_1300 x2_Vcm x2_x1_net12 3.35556f
Cbud_s2_1301 x2_Vcm x2_x1_net13 4.24688f
Cbud_s2_1302 x2_Vcm x2_x1_net14 5.54695f
Cbud_s2_1303 x2_Vcm x2_x1_net15 6.75515f
Cbud_s2_1304 x2_Vcm x2_x1_net16 6.75515f
Cbud_s2_1305 x2_Vcm x2_x1_net17 6.75515f
Cbud_s2_1306 x2_Vcm x2_x1_net18 6.75515f
Cbud_s2_1307 x2_Vcm x2_x1_net19 6.75515f
Cbud_s2_1308 x2_Vcm x2_x1_net2 2.718f
Cbud_s2_1309 x2_Vcm x2_x1_net3 6.75515f
Cbud_s2_1310 x2_Vcm x2_x1_net4 1.04242f
Cbud_s2_1311 x2_Vcm x2_x1_net5 1.04242f
Cbud_s2_1312 x2_Vcm x2_x1_net6 1.04242f
Cbud_s2_1313 x2_Vcm x2_x1_net7 1.06172f
Cbud_s2_1314 x2_Vcm x2_x1_net8 2.24628f
Cbud_s2_1315 x2_Vcm x2_x1_net9 1.8875f
Cbud_s2_1316 x2_Vcm x2_x2_net1 6.75515f
Cbud_s2_1317 x2_Vcm x2_x2_net10 5.54695f
Cbud_s2_1318 x2_Vcm x2_x2_net11 6.75515f
Cbud_s2_1319 x2_Vcm x2_x2_net12 2.24628f
Cbud_s2_1320 x2_Vcm x2_x2_net13 1.8875f
Cbud_s2_1321 x2_Vcm x2_x2_net14 1.60829f
Cbud_s2_1322 x2_Vcm x2_x2_net15 1.38674f
Cbud_s2_1323 x2_Vcm x2_x2_net16 1.04242f
Cbud_s2_1324 x2_Vcm x2_x2_net17 1.04242f
Cbud_s2_1325 x2_Vcm x2_x2_net18 1.04242f
Cbud_s2_1326 x2_Vcm x2_x2_net19 1.06172f
Cbud_s2_1327 x2_Vcm x2_x2_net2 2.718f
Cbud_s2_1328 x2_Vcm x2_x2_net3 1.208f
Cbud_s2_1329 x2_Vcm x2_x2_net4 6.75515f
Cbud_s2_1330 x2_Vcm x2_x2_net5 6.75515f
Cbud_s2_1331 x2_Vcm x2_x2_net6 6.75515f
Cbud_s2_1332 x2_Vcm x2_x2_net7 6.75515f
Cbud_s2_1333 x2_Vcm x2_x2_net8 3.35556f
Cbud_s2_1334 x2_Vcm x2_x2_net9 4.24688f
Cbud_s2_1335 x2_Vout x2_x1_net1 1.20851f
Cbud_s2_1336 x2_Vout x2_x1_net10 1.60896f
Cbud_s2_1337 x2_Vout x2_x1_net11 1.38732f
Cbud_s2_1338 x2_Vout x2_x1_net12 3.35698f
Cbud_s2_1339 x2_Vout x2_x1_net13 4.24868f
Cbud_s2_1340 x2_Vout x2_x1_net14 5.54929f
Cbud_s2_1341 x2_Vout x2_x1_net15 6.23194f
Cbud_s2_1342 x2_Vout x2_x1_net16 6.23194f
Cbud_s2_1343 x2_Vout x2_x1_net17 6.23194f
Cbud_s2_1344 x2_Vout x2_x1_net18 6.23194f
Cbud_s2_1345 x2_Vout x2_x1_net19 6.23194f
Cbud_s2_1346 x2_Vout x2_x1_net2 2.71915f
Cbud_s2_1347 x2_Vout x2_x1_net3 6.23194f
Cbud_s2_1348 x2_Vout x2_x1_net4 0.961679f
Cbud_s2_1349 x2_Vout x2_x1_net5 0.961679f
Cbud_s2_1350 x2_Vout x2_x1_net6 0.96168f
Cbud_s2_1351 x2_Vout x2_x1_net7 1.06216f
Cbud_s2_1352 x2_Vout x2_x1_net8 2.24723f
Cbud_s2_1353 x2_Vout x2_x1_net9 1.8883f
Cbud_s2_1354 x2_Vout x2_x2_net1 6.23194f
Cbud_s2_1355 x2_Vout x2_x2_net10 5.54929f
Cbud_s2_1356 x2_Vout x2_x2_net11 6.23194f
Cbud_s2_1357 x2_Vout x2_x2_net12 2.24723f
Cbud_s2_1358 x2_Vout x2_x2_net13 1.8883f
Cbud_s2_1359 x2_Vout x2_x2_net14 1.60896f
Cbud_s2_1360 x2_Vout x2_x2_net15 1.38732f
Cbud_s2_1361 x2_Vout x2_x2_net16 0.961679f
Cbud_s2_1362 x2_Vout x2_x2_net17 0.961679f
Cbud_s2_1363 x2_Vout x2_x2_net18 0.96168f
Cbud_s2_1364 x2_Vout x2_x2_net19 1.06216f
Cbud_s2_1365 x2_Vout x2_x2_net2 2.71915f
Cbud_s2_1366 x2_Vout x2_x2_net3 1.20851f
Cbud_s2_1367 x2_Vout x2_x2_net4 6.23194f
Cbud_s2_1368 x2_Vout x2_x2_net5 6.23194f
Cbud_s2_1369 x2_Vout x2_x2_net6 6.23194f
Cbud_s2_1370 x2_Vout x2_x2_net7 6.23194f
Cbud_s2_1371 x2_Vout x2_x2_net8 3.35698f
Cbud_s2_1372 x2_Vout x2_x2_net9 4.24868f
Cbud_s2_1373 x2_Vout Vm 1.19379f
Cbud_s2_1374 x2_Vtest x2_x1_net1 1.20801f
Cbud_s2_1375 x2_Vtest x2_x1_net10 1.6083f
Cbud_s2_1376 x2_Vtest x2_x1_net11 1.38675f
Cbud_s2_1377 x2_Vtest x2_x1_net12 3.3556f
Cbud_s2_1378 x2_Vtest x2_x1_net13 4.24693f
Cbud_s2_1379 x2_Vtest x2_x1_net14 5.54702f
Cbud_s2_1380 x2_Vtest x2_x1_net15 6.7072f
Cbud_s2_1381 x2_Vtest x2_x1_net16 6.7072f
Cbud_s2_1382 x2_Vtest x2_x1_net17 6.7072f
Cbud_s2_1383 x2_Vtest x2_x1_net18 6.7072f
Cbud_s2_1384 x2_Vtest x2_x1_net19 6.7072f
Cbud_s2_1385 x2_Vtest x2_x1_net2 2.71804f
Cbud_s2_1386 x2_Vtest x2_x1_net3 6.7072f
Cbud_s2_1387 x2_Vtest x2_x1_net4 1.03502f
Cbud_s2_1388 x2_Vtest x2_x1_net5 1.03502f
Cbud_s2_1389 x2_Vtest x2_x1_net6 1.03502f
Cbud_s2_1390 x2_Vtest x2_x1_net7 1.06173f
Cbud_s2_1391 x2_Vtest x2_x1_net8 2.24631f
Cbud_s2_1392 x2_Vtest x2_x1_net9 1.88752f
Cbud_s2_1393 x2_Vtest x2_x2_net1 6.7072f
Cbud_s2_1394 x2_Vtest x2_x2_net10 5.54702f
Cbud_s2_1395 x2_Vtest x2_x2_net11 6.7072f
Cbud_s2_1396 x2_Vtest x2_x2_net12 2.24631f
Cbud_s2_1397 x2_Vtest x2_x2_net13 1.88752f
Cbud_s2_1398 x2_Vtest x2_x2_net14 1.6083f
Cbud_s2_1399 x2_Vtest x2_x2_net15 1.38675f
Cbud_s2_1400 x2_Vtest x2_x2_net16 1.03502f
Cbud_s2_1401 x2_Vtest x2_x2_net17 1.03502f
Cbud_s2_1402 x2_Vtest x2_x2_net18 1.03502f
Cbud_s2_1403 x2_Vtest x2_x2_net19 1.06173f
Cbud_s2_1404 x2_Vtest x2_x2_net2 2.71804f
Cbud_s2_1405 x2_Vtest x2_x2_net3 1.20801f
Cbud_s2_1406 x2_Vtest x2_x2_net4 6.7072f
Cbud_s2_1407 x2_Vtest x2_x2_net5 6.7072f
Cbud_s2_1408 x2_Vtest x2_x2_net6 6.7072f
Cbud_s2_1409 x2_Vtest x2_x2_net7 6.7072f
Cbud_s2_1410 x2_Vtest x2_x2_net8 3.3556f
Cbud_s2_1411 x2_Vtest x2_x2_net9 4.24693f
Cbud_s2_1412 x2_net1 x2_x1_net1 1.20813f
Cbud_s2_1413 x2_net1 x2_x1_net10 1.60845f
Cbud_s2_1414 x2_net1 x2_x1_net11 1.38688f
Cbud_s2_1415 x2_net1 x2_x1_net12 3.31341f
Cbud_s2_1416 x2_net1 x2_x1_net13 3.31341f
Cbud_s2_1417 x2_net1 x2_x1_net14 3.31341f
Cbud_s2_1418 x2_net1 x2_x1_net15 3.31341f
Cbud_s2_1419 x2_net1 x2_x1_net16 3.31341f
Cbud_s2_1420 x2_net1 x2_x1_net17 3.31341f
Cbud_s2_1421 x2_net1 x2_x1_net18 3.31341f
Cbud_s2_1422 x2_net1 x2_x1_net19 3.31341f
Cbud_s2_1423 x2_net1 x2_x1_net2 2.71828f
Cbud_s2_1424 x2_net1 x2_x1_net3 3.31341f
Cbud_s2_1425 x2_net1 x2_x1_net4 0.752986f
Cbud_s2_1426 x2_net1 x2_x1_net5 0.838975f
Cbud_s2_1427 x2_net1 x2_x1_net6 0.940582f
Cbud_s2_1428 x2_net1 x2_x1_net7 1.06183f
Cbud_s2_1429 x2_net1 x2_x1_net8 2.24652f
Cbud_s2_1430 x2_net1 x2_x1_net9 1.8877f
Cbud_s2_1431 x2_net1 x2_x2_net1 3.31341f
Cbud_s2_1432 x2_net1 x2_x2_net10 3.31341f
Cbud_s2_1433 x2_net1 x2_x2_net11 3.31341f
Cbud_s2_1434 x2_net1 x2_x2_net12 2.24652f
Cbud_s2_1435 x2_net1 x2_x2_net13 1.8877f
Cbud_s2_1436 x2_net1 x2_x2_net14 1.60845f
Cbud_s2_1437 x2_net1 x2_x2_net15 1.38688f
Cbud_s2_1438 x2_net1 x2_x2_net16 0.752986f
Cbud_s2_1439 x2_net1 x2_x2_net17 0.838975f
Cbud_s2_1440 x2_net1 x2_x2_net18 0.940582f
Cbud_s2_1441 x2_net1 x2_x2_net19 1.06183f
Cbud_s2_1442 x2_net1 x2_x2_net2 2.71828f
Cbud_s2_1443 x2_net1 x2_x2_net3 1.20813f
Cbud_s2_1444 x2_net1 x2_x2_net4 3.31341f
Cbud_s2_1445 x2_net1 x2_x2_net5 3.31341f
Cbud_s2_1446 x2_net1 x2_x2_net6 3.31341f
Cbud_s2_1447 x2_net1 x2_x2_net7 3.31341f
Cbud_s2_1448 x2_net1 x2_x2_net8 3.31341f
Cbud_s2_1449 x2_net1 x2_x2_net9 3.31341f
Cbud_s2_1450 x2_net1 Vm 1.19379f
Cbud_s2_1451 x2_x1_net1 x2_x1_net10 6.75515f
Cbud_s2_1452 x2_x1_net1 x2_x1_net11 6.75515f
Cbud_s2_1453 x2_x1_net1 x2_x1_net12 6.75515f
Cbud_s2_1454 x2_x1_net1 x2_x1_net13 5.54695f
Cbud_s2_1455 x2_x1_net1 x2_x1_net14 4.24688f
Cbud_s2_1456 x2_x1_net1 x2_x1_net15 3.35556f
Cbud_s2_1457 x2_x1_net1 x2_x1_net16 1.38674f
Cbud_s2_1458 x2_x1_net1 x2_x1_net17 1.60829f
Cbud_s2_1459 x2_x1_net1 x2_x1_net18 1.8875f
Cbud_s2_1460 x2_x1_net1 x2_x1_net19 2.24628f
Cbud_s2_1461 x2_x1_net1 x2_x1_net2 6.75515f
Cbud_s2_1462 x2_x1_net1 x2_x1_net3 2.718f
Cbud_s2_1463 x2_x1_net1 x2_x1_net4 6.75515f
Cbud_s2_1464 x2_x1_net1 x2_x1_net5 6.75515f
Cbud_s2_1465 x2_x1_net1 x2_x1_net6 6.75515f
Cbud_s2_1466 x2_x1_net1 x2_x1_net7 6.75515f
Cbud_s2_1467 x2_x1_net1 x2_x1_net8 6.75515f
Cbud_s2_1468 x2_x1_net1 x2_x1_net9 6.75515f
Cbud_s2_1469 x2_x1_net1 x2_x2_net1 1.04242f
Cbud_s2_1470 x2_x1_net1 x2_x2_net10 1.04242f
Cbud_s2_1471 x2_x1_net1 x2_x2_net11 1.04242f
Cbud_s2_1472 x2_x1_net1 x2_x2_net12 1.04242f
Cbud_s2_1473 x2_x1_net1 x2_x2_net13 1.04242f
Cbud_s2_1474 x2_x1_net1 x2_x2_net14 1.04242f
Cbud_s2_1475 x2_x1_net1 x2_x2_net15 1.04242f
Cbud_s2_1476 x2_x1_net1 x2_x2_net16 1.04242f
Cbud_s2_1477 x2_x1_net1 x2_x2_net17 1.04242f
Cbud_s2_1478 x2_x1_net1 x2_x2_net18 1.04242f
Cbud_s2_1479 x2_x1_net1 x2_x2_net19 1.04242f
Cbud_s2_1480 x2_x1_net1 x2_x2_net2 1.04242f
Cbud_s2_1481 x2_x1_net1 x2_x2_net3 1.04242f
Cbud_s2_1482 x2_x1_net1 x2_x2_net4 1.06172f
Cbud_s2_1483 x2_x1_net1 x2_x2_net5 1.04242f
Cbud_s2_1484 x2_x1_net1 x2_x2_net6 1.04242f
Cbud_s2_1485 x2_x1_net1 x2_x2_net7 1.04242f
Cbud_s2_1486 x2_x1_net1 x2_x2_net8 1.04242f
Cbud_s2_1487 x2_x1_net1 x2_x2_net9 1.04242f
Cbud_s2_1488 x2_x1_net1 Vp 0.964f
Cbud_s2_1489 x2_x1_net10 x2_x1_net11 6.75515f
Cbud_s2_1490 x2_x1_net10 x2_x1_net12 6.75515f
Cbud_s2_1491 x2_x1_net10 x2_x1_net13 6.75515f
Cbud_s2_1492 x2_x1_net10 x2_x1_net14 6.75515f
Cbud_s2_1493 x2_x1_net10 x2_x1_net15 5.54695f
Cbud_s2_1494 x2_x1_net10 x2_x1_net16 1.8875f
Cbud_s2_1495 x2_x1_net10 x2_x1_net17 2.24628f
Cbud_s2_1496 x2_x1_net10 x2_x1_net18 2.718f
Cbud_s2_1497 x2_x1_net10 x2_x1_net19 3.35556f
Cbud_s2_1498 x2_x1_net10 x2_x1_net2 6.75515f
Cbud_s2_1499 x2_x1_net10 x2_x1_net3 4.24688f
Cbud_s2_1500 x2_x1_net10 x2_x1_net4 6.75515f
Cbud_s2_1501 x2_x1_net10 x2_x1_net5 6.75515f
Cbud_s2_1502 x2_x1_net10 x2_x1_net6 6.75515f
Cbud_s2_1503 x2_x1_net10 x2_x1_net7 6.75515f
Cbud_s2_1504 x2_x1_net10 x2_x1_net8 6.75515f
Cbud_s2_1505 x2_x1_net10 x2_x1_net9 6.75515f
Cbud_s2_1506 x2_x1_net10 x2_x2_net1 1.04242f
Cbud_s2_1507 x2_x1_net10 x2_x2_net10 1.04242f
Cbud_s2_1508 x2_x1_net10 x2_x2_net11 1.04242f
Cbud_s2_1509 x2_x1_net10 x2_x2_net12 1.04242f
Cbud_s2_1510 x2_x1_net10 x2_x2_net13 1.04242f
Cbud_s2_1511 x2_x1_net10 x2_x2_net14 1.04242f
Cbud_s2_1512 x2_x1_net10 x2_x2_net15 1.04242f
Cbud_s2_1513 x2_x1_net10 x2_x2_net16 1.04242f
Cbud_s2_1514 x2_x1_net10 x2_x2_net17 1.04242f
Cbud_s2_1515 x2_x1_net10 x2_x2_net18 1.04242f
Cbud_s2_1516 x2_x1_net10 x2_x2_net19 1.04242f
Cbud_s2_1517 x2_x1_net10 x2_x2_net2 1.04242f
Cbud_s2_1518 x2_x1_net10 x2_x2_net3 1.04242f
Cbud_s2_1519 x2_x1_net10 x2_x2_net4 1.38674f
Cbud_s2_1520 x2_x1_net10 x2_x2_net5 1.208f
Cbud_s2_1521 x2_x1_net10 x2_x2_net6 1.06172f
Cbud_s2_1522 x2_x1_net10 x2_x2_net7 1.04242f
Cbud_s2_1523 x2_x1_net10 x2_x2_net8 1.04242f
Cbud_s2_1524 x2_x1_net10 x2_x2_net9 1.04242f
Cbud_s2_1525 x2_x1_net10 Vp 1.19379f
Cbud_s2_1526 x2_x1_net11 x2_x1_net12 6.75515f
Cbud_s2_1527 x2_x1_net11 x2_x1_net13 6.75515f
Cbud_s2_1528 x2_x1_net11 x2_x1_net14 5.54695f
Cbud_s2_1529 x2_x1_net11 x2_x1_net15 4.24688f
Cbud_s2_1530 x2_x1_net11 x2_x1_net16 1.60829f
Cbud_s2_1531 x2_x1_net11 x2_x1_net17 1.8875f
Cbud_s2_1532 x2_x1_net11 x2_x1_net18 2.24628f
Cbud_s2_1533 x2_x1_net11 x2_x1_net19 2.718f
Cbud_s2_1534 x2_x1_net11 x2_x1_net2 6.75515f
Cbud_s2_1535 x2_x1_net11 x2_x1_net3 3.35556f
Cbud_s2_1536 x2_x1_net11 x2_x1_net4 6.75515f
Cbud_s2_1537 x2_x1_net11 x2_x1_net5 6.75515f
Cbud_s2_1538 x2_x1_net11 x2_x1_net6 6.75515f
Cbud_s2_1539 x2_x1_net11 x2_x1_net7 6.75515f
Cbud_s2_1540 x2_x1_net11 x2_x1_net8 6.75515f
Cbud_s2_1541 x2_x1_net11 x2_x1_net9 6.75515f
Cbud_s2_1542 x2_x1_net11 x2_x2_net1 1.04242f
Cbud_s2_1543 x2_x1_net11 x2_x2_net10 1.04242f
Cbud_s2_1544 x2_x1_net11 x2_x2_net11 1.04242f
Cbud_s2_1545 x2_x1_net11 x2_x2_net12 1.04242f
Cbud_s2_1546 x2_x1_net11 x2_x2_net13 1.04242f
Cbud_s2_1547 x2_x1_net11 x2_x2_net14 1.04242f
Cbud_s2_1548 x2_x1_net11 x2_x2_net15 1.04242f
Cbud_s2_1549 x2_x1_net11 x2_x2_net16 1.04242f
Cbud_s2_1550 x2_x1_net11 x2_x2_net17 1.04242f
Cbud_s2_1551 x2_x1_net11 x2_x2_net18 1.04242f
Cbud_s2_1552 x2_x1_net11 x2_x2_net19 1.04242f
Cbud_s2_1553 x2_x1_net11 x2_x2_net2 1.04242f
Cbud_s2_1554 x2_x1_net11 x2_x2_net3 1.04242f
Cbud_s2_1555 x2_x1_net11 x2_x2_net4 1.208f
Cbud_s2_1556 x2_x1_net11 x2_x2_net5 1.06172f
Cbud_s2_1557 x2_x1_net11 x2_x2_net6 1.04242f
Cbud_s2_1558 x2_x1_net11 x2_x2_net7 1.04242f
Cbud_s2_1559 x2_x1_net11 x2_x2_net8 1.04242f
Cbud_s2_1560 x2_x1_net11 x2_x2_net9 1.04242f
Cbud_s2_1561 x2_x1_net11 Vp 1.09089f
Cbud_s2_1562 x2_x1_net12 x2_x1_net13 6.75515f
Cbud_s2_1563 x2_x1_net12 x2_x1_net14 6.75515f
Cbud_s2_1564 x2_x1_net12 x2_x1_net15 6.75515f
Cbud_s2_1565 x2_x1_net12 x2_x1_net16 4.24688f
Cbud_s2_1566 x2_x1_net12 x2_x1_net17 5.54695f
Cbud_s2_1567 x2_x1_net12 x2_x1_net18 6.75515f
Cbud_s2_1568 x2_x1_net12 x2_x1_net19 6.75515f
Cbud_s2_1569 x2_x1_net12 x2_x1_net2 6.75515f
Cbud_s2_1570 x2_x1_net12 x2_x1_net3 6.75515f
Cbud_s2_1571 x2_x1_net12 x2_x1_net4 2.718f
Cbud_s2_1572 x2_x1_net12 x2_x1_net5 3.35556f
Cbud_s2_1573 x2_x1_net12 x2_x1_net6 4.24688f
Cbud_s2_1574 x2_x1_net12 x2_x1_net7 5.54695f
Cbud_s2_1575 x2_x1_net12 x2_x1_net8 6.75515f
Cbud_s2_1576 x2_x1_net12 x2_x1_net9 6.75515f
Cbud_s2_1577 x2_x1_net12 x2_x2_net1 1.38674f
Cbud_s2_1578 x2_x1_net12 x2_x2_net10 1.06172f
Cbud_s2_1579 x2_x1_net12 x2_x2_net11 1.208f
Cbud_s2_1580 x2_x1_net12 x2_x2_net12 1.04242f
Cbud_s2_1581 x2_x1_net12 x2_x2_net13 1.04242f
Cbud_s2_1582 x2_x1_net12 x2_x2_net14 1.04242f
Cbud_s2_1583 x2_x1_net12 x2_x2_net15 1.04242f
Cbud_s2_1584 x2_x1_net12 x2_x2_net16 1.04242f
Cbud_s2_1585 x2_x1_net12 x2_x2_net17 1.04242f
Cbud_s2_1586 x2_x1_net12 x2_x2_net18 1.04242f
Cbud_s2_1587 x2_x1_net12 x2_x2_net19 1.04242f
Cbud_s2_1588 x2_x1_net12 x2_x2_net2 1.04242f
Cbud_s2_1589 x2_x1_net12 x2_x2_net3 1.04242f
Cbud_s2_1590 x2_x1_net12 x2_x2_net4 2.718f
Cbud_s2_1591 x2_x1_net12 x2_x2_net5 2.24628f
Cbud_s2_1592 x2_x1_net12 x2_x2_net6 1.8875f
Cbud_s2_1593 x2_x1_net12 x2_x2_net7 1.60829f
Cbud_s2_1594 x2_x1_net12 x2_x2_net8 1.04242f
Cbud_s2_1595 x2_x1_net12 x2_x2_net9 1.04242f
Cbud_s2_1596 x2_x1_net12 Vp 1.19379f
Cbud_s2_1597 x2_x1_net13 x2_x1_net14 6.75515f
Cbud_s2_1598 x2_x1_net13 x2_x1_net15 6.75515f
Cbud_s2_1599 x2_x1_net13 x2_x1_net16 5.54695f
Cbud_s2_1600 x2_x1_net13 x2_x1_net17 6.75515f
Cbud_s2_1601 x2_x1_net13 x2_x1_net18 6.75515f
Cbud_s2_1602 x2_x1_net13 x2_x1_net19 6.75515f
Cbud_s2_1603 x2_x1_net13 x2_x1_net2 6.75515f
Cbud_s2_1604 x2_x1_net13 x2_x1_net3 6.75515f
Cbud_s2_1605 x2_x1_net13 x2_x1_net4 2.24628f
Cbud_s2_1606 x2_x1_net13 x2_x1_net5 2.718f
Cbud_s2_1607 x2_x1_net13 x2_x1_net6 3.35556f
Cbud_s2_1608 x2_x1_net13 x2_x1_net7 4.24688f
Cbud_s2_1609 x2_x1_net13 x2_x1_net8 6.75515f
Cbud_s2_1610 x2_x1_net13 x2_x1_net9 6.75515f
Cbud_s2_1611 x2_x1_net13 x2_x2_net1 1.60829f
Cbud_s2_1612 x2_x1_net13 x2_x2_net10 1.208f
Cbud_s2_1613 x2_x1_net13 x2_x2_net11 1.38674f
Cbud_s2_1614 x2_x1_net13 x2_x2_net12 1.04242f
Cbud_s2_1615 x2_x1_net13 x2_x2_net13 1.04242f
Cbud_s2_1616 x2_x1_net13 x2_x2_net14 1.04242f
Cbud_s2_1617 x2_x1_net13 x2_x2_net15 1.04242f
Cbud_s2_1618 x2_x1_net13 x2_x2_net16 1.04242f
Cbud_s2_1619 x2_x1_net13 x2_x2_net17 1.04242f
Cbud_s2_1620 x2_x1_net13 x2_x2_net18 1.04242f
Cbud_s2_1621 x2_x1_net13 x2_x2_net19 1.04242f
Cbud_s2_1622 x2_x1_net13 x2_x2_net2 1.04242f
Cbud_s2_1623 x2_x1_net13 x2_x2_net3 1.04242f
Cbud_s2_1624 x2_x1_net13 x2_x2_net4 3.35556f
Cbud_s2_1625 x2_x1_net13 x2_x2_net5 2.718f
Cbud_s2_1626 x2_x1_net13 x2_x2_net6 2.24628f
Cbud_s2_1627 x2_x1_net13 x2_x2_net7 1.8875f
Cbud_s2_1628 x2_x1_net13 x2_x2_net8 1.04242f
Cbud_s2_1629 x2_x1_net13 x2_x2_net9 1.06172f
Cbud_s2_1630 x2_x1_net13 Vp 1.19379f
Cbud_s2_1631 x2_x1_net14 x2_x1_net15 6.75515f
Cbud_s2_1632 x2_x1_net14 x2_x1_net16 6.75515f
Cbud_s2_1633 x2_x1_net14 x2_x1_net17 6.75515f
Cbud_s2_1634 x2_x1_net14 x2_x1_net18 6.75515f
Cbud_s2_1635 x2_x1_net14 x2_x1_net19 6.75515f
Cbud_s2_1636 x2_x1_net14 x2_x1_net2 6.75515f
Cbud_s2_1637 x2_x1_net14 x2_x1_net3 6.75515f
Cbud_s2_1638 x2_x1_net14 x2_x1_net4 1.8875f
Cbud_s2_1639 x2_x1_net14 x2_x1_net5 2.24628f
Cbud_s2_1640 x2_x1_net14 x2_x1_net6 2.718f
Cbud_s2_1641 x2_x1_net14 x2_x1_net7 3.35556f
Cbud_s2_1642 x2_x1_net14 x2_x1_net8 6.75515f
Cbud_s2_1643 x2_x1_net14 x2_x1_net9 6.75515f
Cbud_s2_1644 x2_x1_net14 x2_x2_net1 1.8875f
Cbud_s2_1645 x2_x1_net14 x2_x2_net10 1.38674f
Cbud_s2_1646 x2_x1_net14 x2_x2_net11 1.60829f
Cbud_s2_1647 x2_x1_net14 x2_x2_net12 1.04242f
Cbud_s2_1648 x2_x1_net14 x2_x2_net13 1.04242f
Cbud_s2_1649 x2_x1_net14 x2_x2_net14 1.04242f
Cbud_s2_1650 x2_x1_net14 x2_x2_net15 1.04242f
Cbud_s2_1651 x2_x1_net14 x2_x2_net16 1.04242f
Cbud_s2_1652 x2_x1_net14 x2_x2_net17 1.04242f
Cbud_s2_1653 x2_x1_net14 x2_x2_net18 1.04242f
Cbud_s2_1654 x2_x1_net14 x2_x2_net19 1.04242f
Cbud_s2_1655 x2_x1_net14 x2_x2_net2 1.04242f
Cbud_s2_1656 x2_x1_net14 x2_x2_net3 1.04242f
Cbud_s2_1657 x2_x1_net14 x2_x2_net4 4.24688f
Cbud_s2_1658 x2_x1_net14 x2_x2_net5 3.35556f
Cbud_s2_1659 x2_x1_net14 x2_x2_net6 2.718f
Cbud_s2_1660 x2_x1_net14 x2_x2_net7 2.24628f
Cbud_s2_1661 x2_x1_net14 x2_x2_net8 1.06172f
Cbud_s2_1662 x2_x1_net14 x2_x2_net9 1.208f
Cbud_s2_1663 x2_x1_net14 Vp 1.19379f
Cbud_s2_1664 x2_x1_net15 x2_x1_net16 6.75515f
Cbud_s2_1665 x2_x1_net15 x2_x1_net17 6.75515f
Cbud_s2_1666 x2_x1_net15 x2_x1_net18 6.75515f
Cbud_s2_1667 x2_x1_net15 x2_x1_net19 6.75515f
Cbud_s2_1668 x2_x1_net15 x2_x1_net2 6.75515f
Cbud_s2_1669 x2_x1_net15 x2_x1_net3 6.75515f
Cbud_s2_1670 x2_x1_net15 x2_x1_net4 1.60829f
Cbud_s2_1671 x2_x1_net15 x2_x1_net5 1.8875f
Cbud_s2_1672 x2_x1_net15 x2_x1_net6 2.24628f
Cbud_s2_1673 x2_x1_net15 x2_x1_net7 2.718f
Cbud_s2_1674 x2_x1_net15 x2_x1_net8 6.75515f
Cbud_s2_1675 x2_x1_net15 x2_x1_net9 6.75515f
Cbud_s2_1676 x2_x1_net15 x2_x2_net1 2.24628f
Cbud_s2_1677 x2_x1_net15 x2_x2_net10 1.60829f
Cbud_s2_1678 x2_x1_net15 x2_x2_net11 1.8875f
Cbud_s2_1679 x2_x1_net15 x2_x2_net12 1.04242f
Cbud_s2_1680 x2_x1_net15 x2_x2_net13 1.04242f
Cbud_s2_1681 x2_x1_net15 x2_x2_net14 1.04242f
Cbud_s2_1682 x2_x1_net15 x2_x2_net15 1.04242f
Cbud_s2_1683 x2_x1_net15 x2_x2_net16 1.04242f
Cbud_s2_1684 x2_x1_net15 x2_x2_net17 1.04242f
Cbud_s2_1685 x2_x1_net15 x2_x2_net18 1.04242f
Cbud_s2_1686 x2_x1_net15 x2_x2_net19 1.04242f
Cbud_s2_1687 x2_x1_net15 x2_x2_net2 1.06172f
Cbud_s2_1688 x2_x1_net15 x2_x2_net3 1.04242f
Cbud_s2_1689 x2_x1_net15 x2_x2_net4 5.54695f
Cbud_s2_1690 x2_x1_net15 x2_x2_net5 4.24688f
Cbud_s2_1691 x2_x1_net15 x2_x2_net6 3.35556f
Cbud_s2_1692 x2_x1_net15 x2_x2_net7 2.718f
Cbud_s2_1693 x2_x1_net15 x2_x2_net8 1.208f
Cbud_s2_1694 x2_x1_net15 x2_x2_net9 1.38674f
Cbud_s2_1695 x2_x1_net15 Vp 1.19379f
Cbud_s2_1696 x2_x1_net16 x2_x1_net17 6.75515f
Cbud_s2_1697 x2_x1_net16 x2_x1_net18 6.75515f
Cbud_s2_1698 x2_x1_net16 x2_x1_net19 6.75515f
Cbud_s2_1699 x2_x1_net16 x2_x1_net2 3.35556f
Cbud_s2_1700 x2_x1_net16 x2_x1_net3 6.75515f
Cbud_s2_1701 x2_x1_net16 x2_x1_net4 1.04242f
Cbud_s2_1702 x2_x1_net16 x2_x1_net5 1.04242f
Cbud_s2_1703 x2_x1_net16 x2_x1_net6 1.06172f
Cbud_s2_1704 x2_x1_net16 x2_x1_net7 1.208f
Cbud_s2_1705 x2_x1_net16 x2_x1_net8 2.718f
Cbud_s2_1706 x2_x1_net16 x2_x1_net9 2.24628f
Cbud_s2_1707 x2_x1_net16 x2_x2_net1 6.75515f
Cbud_s2_1708 x2_x1_net16 x2_x2_net10 4.24688f
Cbud_s2_1709 x2_x1_net16 x2_x2_net11 5.54695f
Cbud_s2_1710 x2_x1_net16 x2_x2_net12 1.8875f
Cbud_s2_1711 x2_x1_net16 x2_x2_net13 1.60829f
Cbud_s2_1712 x2_x1_net16 x2_x2_net14 1.38674f
Cbud_s2_1713 x2_x1_net16 x2_x2_net15 1.208f
Cbud_s2_1714 x2_x1_net16 x2_x2_net16 1.04242f
Cbud_s2_1715 x2_x1_net16 x2_x2_net17 1.04242f
Cbud_s2_1716 x2_x1_net16 x2_x2_net18 1.04242f
Cbud_s2_1717 x2_x1_net16 x2_x2_net19 1.04242f
Cbud_s2_1718 x2_x1_net16 x2_x2_net2 2.24628f
Cbud_s2_1719 x2_x1_net16 x2_x2_net3 1.06172f
Cbud_s2_1720 x2_x1_net16 x2_x2_net4 6.75515f
Cbud_s2_1721 x2_x1_net16 x2_x2_net5 6.75515f
Cbud_s2_1722 x2_x1_net16 x2_x2_net6 6.75515f
Cbud_s2_1723 x2_x1_net16 x2_x2_net7 6.75515f
Cbud_s2_1724 x2_x1_net16 x2_x2_net8 2.718f
Cbud_s2_1725 x2_x1_net16 x2_x2_net9 3.35556f
Cbud_s2_1726 x2_x1_net16 Vp 1.19379f
Cbud_s2_1727 x2_x1_net17 x2_x1_net18 6.75515f
Cbud_s2_1728 x2_x1_net17 x2_x1_net19 6.75515f
Cbud_s2_1729 x2_x1_net17 x2_x1_net2 4.24688f
Cbud_s2_1730 x2_x1_net17 x2_x1_net3 6.75515f
Cbud_s2_1731 x2_x1_net17 x2_x1_net4 1.04242f
Cbud_s2_1732 x2_x1_net17 x2_x1_net5 1.06172f
Cbud_s2_1733 x2_x1_net17 x2_x1_net6 1.208f
Cbud_s2_1734 x2_x1_net17 x2_x1_net7 1.38674f
Cbud_s2_1735 x2_x1_net17 x2_x1_net8 3.35556f
Cbud_s2_1736 x2_x1_net17 x2_x1_net9 2.718f
Cbud_s2_1737 x2_x1_net17 x2_x2_net1 5.54695f
Cbud_s2_1738 x2_x1_net17 x2_x2_net10 3.35556f
Cbud_s2_1739 x2_x1_net17 x2_x2_net11 4.24688f
Cbud_s2_1740 x2_x1_net17 x2_x2_net12 1.60829f
Cbud_s2_1741 x2_x1_net17 x2_x2_net13 1.38674f
Cbud_s2_1742 x2_x1_net17 x2_x2_net14 1.208f
Cbud_s2_1743 x2_x1_net17 x2_x2_net15 1.06172f
Cbud_s2_1744 x2_x1_net17 x2_x2_net16 1.04242f
Cbud_s2_1745 x2_x1_net17 x2_x2_net17 1.04242f
Cbud_s2_1746 x2_x1_net17 x2_x2_net18 1.04242f
Cbud_s2_1747 x2_x1_net17 x2_x2_net19 1.04242f
Cbud_s2_1748 x2_x1_net17 x2_x2_net2 1.8875f
Cbud_s2_1749 x2_x1_net17 x2_x2_net3 1.04242f
Cbud_s2_1750 x2_x1_net17 x2_x2_net4 6.75515f
Cbud_s2_1751 x2_x1_net17 x2_x2_net5 6.75515f
Cbud_s2_1752 x2_x1_net17 x2_x2_net6 6.75515f
Cbud_s2_1753 x2_x1_net17 x2_x2_net7 6.75515f
Cbud_s2_1754 x2_x1_net17 x2_x2_net8 2.24628f
Cbud_s2_1755 x2_x1_net17 x2_x2_net9 2.718f
Cbud_s2_1756 x2_x1_net17 Vp 1.19379f
Cbud_s2_1757 x2_x1_net18 x2_x1_net19 6.75515f
Cbud_s2_1758 x2_x1_net18 x2_x1_net2 5.54695f
Cbud_s2_1759 x2_x1_net18 x2_x1_net3 6.75515f
Cbud_s2_1760 x2_x1_net18 x2_x1_net4 1.06172f
Cbud_s2_1761 x2_x1_net18 x2_x1_net5 1.208f
Cbud_s2_1762 x2_x1_net18 x2_x1_net6 1.38674f
Cbud_s2_1763 x2_x1_net18 x2_x1_net7 1.60829f
Cbud_s2_1764 x2_x1_net18 x2_x1_net8 4.24688f
Cbud_s2_1765 x2_x1_net18 x2_x1_net9 3.35556f
Cbud_s2_1766 x2_x1_net18 x2_x2_net1 4.24688f
Cbud_s2_1767 x2_x1_net18 x2_x2_net10 2.718f
Cbud_s2_1768 x2_x1_net18 x2_x2_net11 3.35556f
Cbud_s2_1769 x2_x1_net18 x2_x2_net12 1.38674f
Cbud_s2_1770 x2_x1_net18 x2_x2_net13 1.208f
Cbud_s2_1771 x2_x1_net18 x2_x2_net14 1.06172f
Cbud_s2_1772 x2_x1_net18 x2_x2_net15 1.04242f
Cbud_s2_1773 x2_x1_net18 x2_x2_net16 1.04242f
Cbud_s2_1774 x2_x1_net18 x2_x2_net17 1.04242f
Cbud_s2_1775 x2_x1_net18 x2_x2_net18 1.04242f
Cbud_s2_1776 x2_x1_net18 x2_x2_net19 1.04242f
Cbud_s2_1777 x2_x1_net18 x2_x2_net2 1.60829f
Cbud_s2_1778 x2_x1_net18 x2_x2_net3 1.04242f
Cbud_s2_1779 x2_x1_net18 x2_x2_net4 6.75515f
Cbud_s2_1780 x2_x1_net18 x2_x2_net5 6.75515f
Cbud_s2_1781 x2_x1_net18 x2_x2_net6 6.75515f
Cbud_s2_1782 x2_x1_net18 x2_x2_net7 5.54695f
Cbud_s2_1783 x2_x1_net18 x2_x2_net8 1.8875f
Cbud_s2_1784 x2_x1_net18 x2_x2_net9 2.24628f
Cbud_s2_1785 x2_x1_net18 Vp 1.19379f
Cbud_s2_1786 x2_x1_net19 x2_x1_net2 6.75515f
Cbud_s2_1787 x2_x1_net19 x2_x1_net3 6.75515f
Cbud_s2_1788 x2_x1_net19 x2_x1_net4 1.208f
Cbud_s2_1789 x2_x1_net19 x2_x1_net5 1.38674f
Cbud_s2_1790 x2_x1_net19 x2_x1_net6 1.60829f
Cbud_s2_1791 x2_x1_net19 x2_x1_net7 1.8875f
Cbud_s2_1792 x2_x1_net19 x2_x1_net8 5.54695f
Cbud_s2_1793 x2_x1_net19 x2_x1_net9 4.24688f
Cbud_s2_1794 x2_x1_net19 x2_x2_net1 3.35556f
Cbud_s2_1795 x2_x1_net19 x2_x2_net10 2.24628f
Cbud_s2_1796 x2_x1_net19 x2_x2_net11 2.718f
Cbud_s2_1797 x2_x1_net19 x2_x2_net12 1.208f
Cbud_s2_1798 x2_x1_net19 x2_x2_net13 1.06172f
Cbud_s2_1799 x2_x1_net19 x2_x2_net14 1.04242f
Cbud_s2_1800 x2_x1_net19 x2_x2_net15 1.04242f
Cbud_s2_1801 x2_x1_net19 x2_x2_net16 1.04242f
Cbud_s2_1802 x2_x1_net19 x2_x2_net17 1.04242f
Cbud_s2_1803 x2_x1_net19 x2_x2_net18 1.04242f
Cbud_s2_1804 x2_x1_net19 x2_x2_net19 1.04242f
Cbud_s2_1805 x2_x1_net19 x2_x2_net2 1.38674f
Cbud_s2_1806 x2_x1_net19 x2_x2_net3 1.04242f
Cbud_s2_1807 x2_x1_net19 x2_x2_net4 6.75515f
Cbud_s2_1808 x2_x1_net19 x2_x2_net5 6.75515f
Cbud_s2_1809 x2_x1_net19 x2_x2_net6 5.54695f
Cbud_s2_1810 x2_x1_net19 x2_x2_net7 4.24688f
Cbud_s2_1811 x2_x1_net19 x2_x2_net8 1.60829f
Cbud_s2_1812 x2_x1_net19 x2_x2_net9 1.8875f
Cbud_s2_1813 x2_x1_net19 Vp 1.19379f
Cbud_s2_1814 x2_x1_net2 x2_x1_net3 6.75515f
Cbud_s2_1815 x2_x1_net2 x2_x1_net4 3.35556f
Cbud_s2_1816 x2_x1_net2 x2_x1_net5 4.24688f
Cbud_s2_1817 x2_x1_net2 x2_x1_net6 5.54695f
Cbud_s2_1818 x2_x1_net2 x2_x1_net7 6.75515f
Cbud_s2_1819 x2_x1_net2 x2_x1_net8 6.75515f
Cbud_s2_1820 x2_x1_net2 x2_x1_net9 6.75515f
Cbud_s2_1821 x2_x1_net2 x2_x2_net1 1.208f
Cbud_s2_1822 x2_x1_net2 x2_x2_net10 1.04242f
Cbud_s2_1823 x2_x1_net2 x2_x2_net11 1.06172f
Cbud_s2_1824 x2_x1_net2 x2_x2_net12 1.04242f
Cbud_s2_1825 x2_x1_net2 x2_x2_net13 1.04242f
Cbud_s2_1826 x2_x1_net2 x2_x2_net14 1.04242f
Cbud_s2_1827 x2_x1_net2 x2_x2_net15 1.04242f
Cbud_s2_1828 x2_x1_net2 x2_x2_net16 1.04242f
Cbud_s2_1829 x2_x1_net2 x2_x2_net17 1.04242f
Cbud_s2_1830 x2_x1_net2 x2_x2_net18 1.04242f
Cbud_s2_1831 x2_x1_net2 x2_x2_net19 1.04242f
Cbud_s2_1832 x2_x1_net2 x2_x2_net2 1.04242f
Cbud_s2_1833 x2_x1_net2 x2_x2_net3 1.04242f
Cbud_s2_1834 x2_x1_net2 x2_x2_net4 2.24628f
Cbud_s2_1835 x2_x1_net2 x2_x2_net5 1.8875f
Cbud_s2_1836 x2_x1_net2 x2_x2_net6 1.60829f
Cbud_s2_1837 x2_x1_net2 x2_x2_net7 1.38674f
Cbud_s2_1838 x2_x1_net2 x2_x2_net8 1.04242f
Cbud_s2_1839 x2_x1_net2 x2_x2_net9 1.04242f
Cbud_s2_1840 x2_x1_net2 Vp 1.19379f
Cbud_s2_1841 x2_x1_net3 x2_x1_net4 1.38674f
Cbud_s2_1842 x2_x1_net3 x2_x1_net5 1.60829f
Cbud_s2_1843 x2_x1_net3 x2_x1_net6 1.8875f
Cbud_s2_1844 x2_x1_net3 x2_x1_net7 2.24628f
Cbud_s2_1845 x2_x1_net3 x2_x1_net8 6.75515f
Cbud_s2_1846 x2_x1_net3 x2_x1_net9 5.54695f
Cbud_s2_1847 x2_x1_net3 x2_x2_net1 2.718f
Cbud_s2_1848 x2_x1_net3 x2_x2_net10 1.8875f
Cbud_s2_1849 x2_x1_net3 x2_x2_net11 2.24628f
Cbud_s2_1850 x2_x1_net3 x2_x2_net12 1.06172f
Cbud_s2_1851 x2_x1_net3 x2_x2_net13 1.04242f
Cbud_s2_1852 x2_x1_net3 x2_x2_net14 1.04242f
Cbud_s2_1853 x2_x1_net3 x2_x2_net15 1.04242f
Cbud_s2_1854 x2_x1_net3 x2_x2_net16 1.04242f
Cbud_s2_1855 x2_x1_net3 x2_x2_net17 1.04242f
Cbud_s2_1856 x2_x1_net3 x2_x2_net18 1.04242f
Cbud_s2_1857 x2_x1_net3 x2_x2_net19 1.04242f
Cbud_s2_1858 x2_x1_net3 x2_x2_net2 1.208f
Cbud_s2_1859 x2_x1_net3 x2_x2_net3 1.04242f
Cbud_s2_1860 x2_x1_net3 x2_x2_net4 6.75515f
Cbud_s2_1861 x2_x1_net3 x2_x2_net5 5.54695f
Cbud_s2_1862 x2_x1_net3 x2_x2_net6 4.24688f
Cbud_s2_1863 x2_x1_net3 x2_x2_net7 3.35556f
Cbud_s2_1864 x2_x1_net3 x2_x2_net8 1.38674f
Cbud_s2_1865 x2_x1_net3 x2_x2_net9 1.60829f
Cbud_s2_1866 x2_x1_net3 Vp 1.19379f
Cbud_s2_1867 x2_x1_net4 x2_x1_net5 6.75515f
Cbud_s2_1868 x2_x1_net4 x2_x1_net6 6.75515f
Cbud_s2_1869 x2_x1_net4 x2_x1_net7 6.75515f
Cbud_s2_1870 x2_x1_net4 x2_x1_net8 4.24688f
Cbud_s2_1871 x2_x1_net4 x2_x1_net9 5.54695f
Cbud_s2_1872 x2_x1_net4 x2_x2_net1 1.04242f
Cbud_s2_1873 x2_x1_net4 x2_x2_net10 1.04242f
Cbud_s2_1874 x2_x1_net4 x2_x2_net11 1.04242f
Cbud_s2_1875 x2_x1_net4 x2_x2_net12 1.04242f
Cbud_s2_1876 x2_x1_net4 x2_x2_net13 1.04242f
Cbud_s2_1877 x2_x1_net4 x2_x2_net14 1.04242f
Cbud_s2_1878 x2_x1_net4 x2_x2_net15 1.04242f
Cbud_s2_1879 x2_x1_net4 x2_x2_net16 1.04242f
Cbud_s2_1880 x2_x1_net4 x2_x2_net17 1.04242f
Cbud_s2_1881 x2_x1_net4 x2_x2_net18 1.04242f
Cbud_s2_1882 x2_x1_net4 x2_x2_net19 1.04242f
Cbud_s2_1883 x2_x1_net4 x2_x2_net2 1.04242f
Cbud_s2_1884 x2_x1_net4 x2_x2_net3 1.04242f
Cbud_s2_1885 x2_x1_net4 x2_x2_net4 1.04242f
Cbud_s2_1886 x2_x1_net4 x2_x2_net5 1.04242f
Cbud_s2_1887 x2_x1_net4 x2_x2_net6 1.04242f
Cbud_s2_1888 x2_x1_net4 x2_x2_net7 1.04242f
Cbud_s2_1889 x2_x1_net4 x2_x2_net8 1.04242f
Cbud_s2_1890 x2_x1_net4 x2_x2_net9 1.04242f
Cbud_s2_1891 x2_x1_net4 Vp 0.627515f
Cbud_s2_1892 x2_x1_net5 x2_x1_net6 6.75515f
Cbud_s2_1893 x2_x1_net5 x2_x1_net7 6.75515f
Cbud_s2_1894 x2_x1_net5 x2_x1_net8 5.54695f
Cbud_s2_1895 x2_x1_net5 x2_x1_net9 6.75515f
Cbud_s2_1896 x2_x1_net5 x2_x2_net1 1.04242f
Cbud_s2_1897 x2_x1_net5 x2_x2_net10 1.04242f
Cbud_s2_1898 x2_x1_net5 x2_x2_net11 1.04242f
Cbud_s2_1899 x2_x1_net5 x2_x2_net12 1.04242f
Cbud_s2_1900 x2_x1_net5 x2_x2_net13 1.04242f
Cbud_s2_1901 x2_x1_net5 x2_x2_net14 1.04242f
Cbud_s2_1902 x2_x1_net5 x2_x2_net15 1.04242f
Cbud_s2_1903 x2_x1_net5 x2_x2_net16 1.04242f
Cbud_s2_1904 x2_x1_net5 x2_x2_net17 1.04242f
Cbud_s2_1905 x2_x1_net5 x2_x2_net18 1.04242f
Cbud_s2_1906 x2_x1_net5 x2_x2_net19 1.04242f
Cbud_s2_1907 x2_x1_net5 x2_x2_net2 1.04242f
Cbud_s2_1908 x2_x1_net5 x2_x2_net3 1.04242f
Cbud_s2_1909 x2_x1_net5 x2_x2_net4 1.04242f
Cbud_s2_1910 x2_x1_net5 x2_x2_net5 1.04242f
Cbud_s2_1911 x2_x1_net5 x2_x2_net6 1.04242f
Cbud_s2_1912 x2_x1_net5 x2_x2_net7 1.04242f
Cbud_s2_1913 x2_x1_net5 x2_x2_net8 1.04242f
Cbud_s2_1914 x2_x1_net5 x2_x2_net9 1.04242f
Cbud_s2_1915 x2_x1_net5 Vp 0.692766f
Cbud_s2_1916 x2_x1_net6 x2_x1_net7 6.75515f
Cbud_s2_1917 x2_x1_net6 x2_x1_net8 6.75515f
Cbud_s2_1918 x2_x1_net6 x2_x1_net9 6.75515f
Cbud_s2_1919 x2_x1_net6 x2_x2_net1 1.04242f
Cbud_s2_1920 x2_x1_net6 x2_x2_net10 1.04242f
Cbud_s2_1921 x2_x1_net6 x2_x2_net11 1.04242f
Cbud_s2_1922 x2_x1_net6 x2_x2_net12 1.04242f
Cbud_s2_1923 x2_x1_net6 x2_x2_net13 1.04242f
Cbud_s2_1924 x2_x1_net6 x2_x2_net14 1.04242f
Cbud_s2_1925 x2_x1_net6 x2_x2_net15 1.04242f
Cbud_s2_1926 x2_x1_net6 x2_x2_net16 1.04242f
Cbud_s2_1927 x2_x1_net6 x2_x2_net17 1.04242f
Cbud_s2_1928 x2_x1_net6 x2_x2_net18 1.04242f
Cbud_s2_1929 x2_x1_net6 x2_x2_net19 1.04242f
Cbud_s2_1930 x2_x1_net6 x2_x2_net2 1.04242f
Cbud_s2_1931 x2_x1_net6 x2_x2_net3 1.04242f
Cbud_s2_1932 x2_x1_net6 x2_x2_net4 1.04242f
Cbud_s2_1933 x2_x1_net6 x2_x2_net5 1.04242f
Cbud_s2_1934 x2_x1_net6 x2_x2_net6 1.04242f
Cbud_s2_1935 x2_x1_net6 x2_x2_net7 1.04242f
Cbud_s2_1936 x2_x1_net6 x2_x2_net8 1.04242f
Cbud_s2_1937 x2_x1_net6 x2_x2_net9 1.04242f
Cbud_s2_1938 x2_x1_net6 Vp 0.768788f
Cbud_s2_1939 x2_x1_net7 x2_x1_net8 6.75515f
Cbud_s2_1940 x2_x1_net7 x2_x1_net9 6.75515f
Cbud_s2_1941 x2_x1_net7 x2_x2_net1 1.04242f
Cbud_s2_1942 x2_x1_net7 x2_x2_net10 1.04242f
Cbud_s2_1943 x2_x1_net7 x2_x2_net11 1.04242f
Cbud_s2_1944 x2_x1_net7 x2_x2_net12 1.04242f
Cbud_s2_1945 x2_x1_net7 x2_x2_net13 1.04242f
Cbud_s2_1946 x2_x1_net7 x2_x2_net14 1.04242f
Cbud_s2_1947 x2_x1_net7 x2_x2_net15 1.04242f
Cbud_s2_1948 x2_x1_net7 x2_x2_net16 1.04242f
Cbud_s2_1949 x2_x1_net7 x2_x2_net17 1.04242f
Cbud_s2_1950 x2_x1_net7 x2_x2_net18 1.04242f
Cbud_s2_1951 x2_x1_net7 x2_x2_net19 1.04242f
Cbud_s2_1952 x2_x1_net7 x2_x2_net2 1.04242f
Cbud_s2_1953 x2_x1_net7 x2_x2_net3 1.04242f
Cbud_s2_1954 x2_x1_net7 x2_x2_net4 1.04242f
Cbud_s2_1955 x2_x1_net7 x2_x2_net5 1.04242f
Cbud_s2_1956 x2_x1_net7 x2_x2_net6 1.04242f
Cbud_s2_1957 x2_x1_net7 x2_x2_net7 1.04242f
Cbud_s2_1958 x2_x1_net7 x2_x2_net8 1.04242f
Cbud_s2_1959 x2_x1_net7 x2_x2_net9 1.04242f
Cbud_s2_1960 x2_x1_net7 Vp 0.858099f
Cbud_s2_1961 x2_x1_net8 x2_x1_net9 6.75515f
Cbud_s2_1962 x2_x1_net8 x2_x2_net1 1.06172f
Cbud_s2_1963 x2_x1_net8 x2_x2_net10 1.04242f
Cbud_s2_1964 x2_x1_net8 x2_x2_net11 1.04242f
Cbud_s2_1965 x2_x1_net8 x2_x2_net12 1.04242f
Cbud_s2_1966 x2_x1_net8 x2_x2_net13 1.04242f
Cbud_s2_1967 x2_x1_net8 x2_x2_net14 1.04242f
Cbud_s2_1968 x2_x1_net8 x2_x2_net15 1.04242f
Cbud_s2_1969 x2_x1_net8 x2_x2_net16 1.04242f
Cbud_s2_1970 x2_x1_net8 x2_x2_net17 1.04242f
Cbud_s2_1971 x2_x1_net8 x2_x2_net18 1.04242f
Cbud_s2_1972 x2_x1_net8 x2_x2_net19 1.04242f
Cbud_s2_1973 x2_x1_net8 x2_x2_net2 1.04242f
Cbud_s2_1974 x2_x1_net8 x2_x2_net3 1.04242f
Cbud_s2_1975 x2_x1_net8 x2_x2_net4 1.8875f
Cbud_s2_1976 x2_x1_net8 x2_x2_net5 1.60829f
Cbud_s2_1977 x2_x1_net8 x2_x2_net6 1.38674f
Cbud_s2_1978 x2_x1_net8 x2_x2_net7 1.208f
Cbud_s2_1979 x2_x1_net8 x2_x2_net8 1.04242f
Cbud_s2_1980 x2_x1_net8 x2_x2_net9 1.04242f
Cbud_s2_1981 x2_x1_net8 Vp 1.19379f
Cbud_s2_1982 x2_x1_net9 x2_x2_net1 1.04242f
Cbud_s2_1983 x2_x1_net9 x2_x2_net10 1.04242f
Cbud_s2_1984 x2_x1_net9 x2_x2_net11 1.04242f
Cbud_s2_1985 x2_x1_net9 x2_x2_net12 1.04242f
Cbud_s2_1986 x2_x1_net9 x2_x2_net13 1.04242f
Cbud_s2_1987 x2_x1_net9 x2_x2_net14 1.04242f
Cbud_s2_1988 x2_x1_net9 x2_x2_net15 1.04242f
Cbud_s2_1989 x2_x1_net9 x2_x2_net16 1.04242f
Cbud_s2_1990 x2_x1_net9 x2_x2_net17 1.04242f
Cbud_s2_1991 x2_x1_net9 x2_x2_net18 1.04242f
Cbud_s2_1992 x2_x1_net9 x2_x2_net19 1.04242f
Cbud_s2_1993 x2_x1_net9 x2_x2_net2 1.04242f
Cbud_s2_1994 x2_x1_net9 x2_x2_net3 1.04242f
Cbud_s2_1995 x2_x1_net9 x2_x2_net4 1.60829f
Cbud_s2_1996 x2_x1_net9 x2_x2_net5 1.38674f
Cbud_s2_1997 x2_x1_net9 x2_x2_net6 1.208f
Cbud_s2_1998 x2_x1_net9 x2_x2_net7 1.06172f
Cbud_s2_1999 x2_x1_net9 x2_x2_net8 1.04242f
Cbud_s2_2000 x2_x1_net9 x2_x2_net9 1.04242f
Cbud_s2_2001 x2_x1_net9 Vp 1.19379f
Cbud_s2_2002 x2_x2_net1 x2_x2_net10 6.75515f
Cbud_s2_2003 x2_x2_net1 x2_x2_net11 6.75515f
Cbud_s2_2004 x2_x2_net1 x2_x2_net12 6.75515f
Cbud_s2_2005 x2_x2_net1 x2_x2_net13 5.54695f
Cbud_s2_2006 x2_x2_net1 x2_x2_net14 4.24688f
Cbud_s2_2007 x2_x2_net1 x2_x2_net15 3.35556f
Cbud_s2_2008 x2_x2_net1 x2_x2_net16 1.38674f
Cbud_s2_2009 x2_x2_net1 x2_x2_net17 1.60829f
Cbud_s2_2010 x2_x2_net1 x2_x2_net18 1.8875f
Cbud_s2_2011 x2_x2_net1 x2_x2_net19 2.24628f
Cbud_s2_2012 x2_x2_net1 x2_x2_net2 6.75515f
Cbud_s2_2013 x2_x2_net1 x2_x2_net3 2.718f
Cbud_s2_2014 x2_x2_net1 x2_x2_net4 6.75515f
Cbud_s2_2015 x2_x2_net1 x2_x2_net5 6.75515f
Cbud_s2_2016 x2_x2_net1 x2_x2_net6 6.75515f
Cbud_s2_2017 x2_x2_net1 x2_x2_net7 6.75515f
Cbud_s2_2018 x2_x2_net1 x2_x2_net8 6.75515f
Cbud_s2_2019 x2_x2_net1 x2_x2_net9 6.75515f
Cbud_s2_2020 x2_x2_net1 Vm 1.19379f
Cbud_s2_2021 x2_x2_net10 x2_x2_net11 6.75515f
Cbud_s2_2022 x2_x2_net10 x2_x2_net12 6.75515f
Cbud_s2_2023 x2_x2_net10 x2_x2_net13 6.75515f
Cbud_s2_2024 x2_x2_net10 x2_x2_net14 6.75515f
Cbud_s2_2025 x2_x2_net10 x2_x2_net15 5.54695f
Cbud_s2_2026 x2_x2_net10 x2_x2_net16 1.8875f
Cbud_s2_2027 x2_x2_net10 x2_x2_net17 2.24628f
Cbud_s2_2028 x2_x2_net10 x2_x2_net18 2.718f
Cbud_s2_2029 x2_x2_net10 x2_x2_net19 3.35556f
Cbud_s2_2030 x2_x2_net10 x2_x2_net2 6.75515f
Cbud_s2_2031 x2_x2_net10 x2_x2_net3 4.24688f
Cbud_s2_2032 x2_x2_net10 x2_x2_net4 6.75515f
Cbud_s2_2033 x2_x2_net10 x2_x2_net5 6.75515f
Cbud_s2_2034 x2_x2_net10 x2_x2_net6 6.75515f
Cbud_s2_2035 x2_x2_net10 x2_x2_net7 6.75515f
Cbud_s2_2036 x2_x2_net10 x2_x2_net8 6.75515f
Cbud_s2_2037 x2_x2_net10 x2_x2_net9 6.75515f
Cbud_s2_2038 x2_x2_net10 Vm 1.19379f
Cbud_s2_2039 x2_x2_net11 x2_x2_net12 6.75515f
Cbud_s2_2040 x2_x2_net11 x2_x2_net13 6.75515f
Cbud_s2_2041 x2_x2_net11 x2_x2_net14 5.54695f
Cbud_s2_2042 x2_x2_net11 x2_x2_net15 4.24688f
Cbud_s2_2043 x2_x2_net11 x2_x2_net16 1.60829f
Cbud_s2_2044 x2_x2_net11 x2_x2_net17 1.8875f
Cbud_s2_2045 x2_x2_net11 x2_x2_net18 2.24628f
Cbud_s2_2046 x2_x2_net11 x2_x2_net19 2.718f
Cbud_s2_2047 x2_x2_net11 x2_x2_net2 6.75515f
Cbud_s2_2048 x2_x2_net11 x2_x2_net3 3.35556f
Cbud_s2_2049 x2_x2_net11 x2_x2_net4 6.75515f
Cbud_s2_2050 x2_x2_net11 x2_x2_net5 6.75515f
Cbud_s2_2051 x2_x2_net11 x2_x2_net6 6.75515f
Cbud_s2_2052 x2_x2_net11 x2_x2_net7 6.75515f
Cbud_s2_2053 x2_x2_net11 x2_x2_net8 6.75515f
Cbud_s2_2054 x2_x2_net11 x2_x2_net9 6.75515f
Cbud_s2_2055 x2_x2_net11 Vm 1.19379f
Cbud_s2_2056 x2_x2_net12 x2_x2_net13 6.75515f
Cbud_s2_2057 x2_x2_net12 x2_x2_net14 6.75515f
Cbud_s2_2058 x2_x2_net12 x2_x2_net15 6.75515f
Cbud_s2_2059 x2_x2_net12 x2_x2_net16 4.24688f
Cbud_s2_2060 x2_x2_net12 x2_x2_net17 5.54695f
Cbud_s2_2061 x2_x2_net12 x2_x2_net18 6.75515f
Cbud_s2_2062 x2_x2_net12 x2_x2_net19 6.75515f
Cbud_s2_2063 x2_x2_net12 x2_x2_net2 6.75515f
Cbud_s2_2064 x2_x2_net12 x2_x2_net3 6.75515f
Cbud_s2_2065 x2_x2_net12 x2_x2_net4 2.718f
Cbud_s2_2066 x2_x2_net12 x2_x2_net5 3.35556f
Cbud_s2_2067 x2_x2_net12 x2_x2_net6 4.24688f
Cbud_s2_2068 x2_x2_net12 x2_x2_net7 5.54695f
Cbud_s2_2069 x2_x2_net12 x2_x2_net8 6.75515f
Cbud_s2_2070 x2_x2_net12 x2_x2_net9 6.75515f
Cbud_s2_2071 x2_x2_net12 Vm 1.19379f
Cbud_s2_2072 x2_x2_net13 x2_x2_net14 6.75515f
Cbud_s2_2073 x2_x2_net13 x2_x2_net15 6.75515f
Cbud_s2_2074 x2_x2_net13 x2_x2_net16 5.54695f
Cbud_s2_2075 x2_x2_net13 x2_x2_net17 6.75515f
Cbud_s2_2076 x2_x2_net13 x2_x2_net18 6.75515f
Cbud_s2_2077 x2_x2_net13 x2_x2_net19 6.75515f
Cbud_s2_2078 x2_x2_net13 x2_x2_net2 6.75515f
Cbud_s2_2079 x2_x2_net13 x2_x2_net3 6.75515f
Cbud_s2_2080 x2_x2_net13 x2_x2_net4 2.24628f
Cbud_s2_2081 x2_x2_net13 x2_x2_net5 2.718f
Cbud_s2_2082 x2_x2_net13 x2_x2_net6 3.35556f
Cbud_s2_2083 x2_x2_net13 x2_x2_net7 4.24688f
Cbud_s2_2084 x2_x2_net13 x2_x2_net8 6.75515f
Cbud_s2_2085 x2_x2_net13 x2_x2_net9 6.75515f
Cbud_s2_2086 x2_x2_net13 Vm 1.19379f
Cbud_s2_2087 x2_x2_net14 x2_x2_net15 6.75515f
Cbud_s2_2088 x2_x2_net14 x2_x2_net16 6.75515f
Cbud_s2_2089 x2_x2_net14 x2_x2_net17 6.75515f
Cbud_s2_2090 x2_x2_net14 x2_x2_net18 6.75515f
Cbud_s2_2091 x2_x2_net14 x2_x2_net19 6.75515f
Cbud_s2_2092 x2_x2_net14 x2_x2_net2 6.75515f
Cbud_s2_2093 x2_x2_net14 x2_x2_net3 6.75515f
Cbud_s2_2094 x2_x2_net14 x2_x2_net4 1.8875f
Cbud_s2_2095 x2_x2_net14 x2_x2_net5 2.24628f
Cbud_s2_2096 x2_x2_net14 x2_x2_net6 2.718f
Cbud_s2_2097 x2_x2_net14 x2_x2_net7 3.35556f
Cbud_s2_2098 x2_x2_net14 x2_x2_net8 6.75515f
Cbud_s2_2099 x2_x2_net14 x2_x2_net9 6.75515f
Cbud_s2_2100 x2_x2_net14 Vm 1.19379f
Cbud_s2_2101 x2_x2_net15 x2_x2_net16 6.75515f
Cbud_s2_2102 x2_x2_net15 x2_x2_net17 6.75515f
Cbud_s2_2103 x2_x2_net15 x2_x2_net18 6.75515f
Cbud_s2_2104 x2_x2_net15 x2_x2_net19 6.75515f
Cbud_s2_2105 x2_x2_net15 x2_x2_net2 6.75515f
Cbud_s2_2106 x2_x2_net15 x2_x2_net3 6.75515f
Cbud_s2_2107 x2_x2_net15 x2_x2_net4 1.60829f
Cbud_s2_2108 x2_x2_net15 x2_x2_net5 1.8875f
Cbud_s2_2109 x2_x2_net15 x2_x2_net6 2.24628f
Cbud_s2_2110 x2_x2_net15 x2_x2_net7 2.718f
Cbud_s2_2111 x2_x2_net15 x2_x2_net8 6.75515f
Cbud_s2_2112 x2_x2_net15 x2_x2_net9 6.75515f
Cbud_s2_2113 x2_x2_net15 Vm 1.09089f
Cbud_s2_2114 x2_x2_net16 x2_x2_net17 6.75515f
Cbud_s2_2115 x2_x2_net16 x2_x2_net18 6.75515f
Cbud_s2_2116 x2_x2_net16 x2_x2_net19 6.75515f
Cbud_s2_2117 x2_x2_net16 x2_x2_net2 3.35556f
Cbud_s2_2118 x2_x2_net16 x2_x2_net3 6.75515f
Cbud_s2_2119 x2_x2_net16 x2_x2_net4 1.04242f
Cbud_s2_2120 x2_x2_net16 x2_x2_net5 1.04242f
Cbud_s2_2121 x2_x2_net16 x2_x2_net6 1.06172f
Cbud_s2_2122 x2_x2_net16 x2_x2_net7 1.208f
Cbud_s2_2123 x2_x2_net16 x2_x2_net8 2.718f
Cbud_s2_2124 x2_x2_net16 x2_x2_net9 2.24628f
Cbud_s2_2125 x2_x2_net16 Vm 0.627515f
Cbud_s2_2126 x2_x2_net17 x2_x2_net18 6.75515f
Cbud_s2_2127 x2_x2_net17 x2_x2_net19 6.75515f
Cbud_s2_2128 x2_x2_net17 x2_x2_net2 4.24688f
Cbud_s2_2129 x2_x2_net17 x2_x2_net3 6.75515f
Cbud_s2_2130 x2_x2_net17 x2_x2_net4 1.04242f
Cbud_s2_2131 x2_x2_net17 x2_x2_net5 1.06172f
Cbud_s2_2132 x2_x2_net17 x2_x2_net6 1.208f
Cbud_s2_2133 x2_x2_net17 x2_x2_net7 1.38674f
Cbud_s2_2134 x2_x2_net17 x2_x2_net8 3.35556f
Cbud_s2_2135 x2_x2_net17 x2_x2_net9 2.718f
Cbud_s2_2136 x2_x2_net17 Vm 0.692766f
Cbud_s2_2137 x2_x2_net18 x2_x2_net19 6.75515f
Cbud_s2_2138 x2_x2_net18 x2_x2_net2 5.54695f
Cbud_s2_2139 x2_x2_net18 x2_x2_net3 6.75515f
Cbud_s2_2140 x2_x2_net18 x2_x2_net4 1.06172f
Cbud_s2_2141 x2_x2_net18 x2_x2_net5 1.208f
Cbud_s2_2142 x2_x2_net18 x2_x2_net6 1.38674f
Cbud_s2_2143 x2_x2_net18 x2_x2_net7 1.60829f
Cbud_s2_2144 x2_x2_net18 x2_x2_net8 4.24688f
Cbud_s2_2145 x2_x2_net18 x2_x2_net9 3.35556f
Cbud_s2_2146 x2_x2_net18 Vm 0.768788f
Cbud_s2_2147 x2_x2_net19 x2_x2_net2 6.75515f
Cbud_s2_2148 x2_x2_net19 x2_x2_net3 6.75515f
Cbud_s2_2149 x2_x2_net19 x2_x2_net4 1.208f
Cbud_s2_2150 x2_x2_net19 x2_x2_net5 1.38674f
Cbud_s2_2151 x2_x2_net19 x2_x2_net6 1.60829f
Cbud_s2_2152 x2_x2_net19 x2_x2_net7 1.8875f
Cbud_s2_2153 x2_x2_net19 x2_x2_net8 5.54695f
Cbud_s2_2154 x2_x2_net19 x2_x2_net9 4.24688f
Cbud_s2_2155 x2_x2_net19 Vm 0.858099f
Cbud_s2_2156 x2_x2_net2 x2_x2_net3 6.75515f
Cbud_s2_2157 x2_x2_net2 x2_x2_net4 3.35556f
Cbud_s2_2158 x2_x2_net2 x2_x2_net5 4.24688f
Cbud_s2_2159 x2_x2_net2 x2_x2_net6 5.54695f
Cbud_s2_2160 x2_x2_net2 x2_x2_net7 6.75515f
Cbud_s2_2161 x2_x2_net2 x2_x2_net8 6.75515f
Cbud_s2_2162 x2_x2_net2 x2_x2_net9 6.75515f
Cbud_s2_2163 x2_x2_net2 Vm 1.19379f
Cbud_s2_2164 x2_x2_net3 x2_x2_net4 1.38674f
Cbud_s2_2165 x2_x2_net3 x2_x2_net5 1.60829f
Cbud_s2_2166 x2_x2_net3 x2_x2_net6 1.8875f
Cbud_s2_2167 x2_x2_net3 x2_x2_net7 2.24628f
Cbud_s2_2168 x2_x2_net3 x2_x2_net8 6.75515f
Cbud_s2_2169 x2_x2_net3 x2_x2_net9 5.54695f
Cbud_s2_2170 x2_x2_net3 Vm 0.964f
Cbud_s2_2171 x2_x2_net4 x2_x2_net5 6.75515f
Cbud_s2_2172 x2_x2_net4 x2_x2_net6 6.75515f
Cbud_s2_2173 x2_x2_net4 x2_x2_net7 6.75515f
Cbud_s2_2174 x2_x2_net4 x2_x2_net8 4.24688f
Cbud_s2_2175 x2_x2_net4 x2_x2_net9 5.54695f
Cbud_s2_2176 x2_x2_net4 Vm 1.19379f
Cbud_s2_2177 x2_x2_net5 x2_x2_net6 6.75515f
Cbud_s2_2178 x2_x2_net5 x2_x2_net7 6.75515f
Cbud_s2_2179 x2_x2_net5 x2_x2_net8 5.54695f
Cbud_s2_2180 x2_x2_net5 x2_x2_net9 6.75515f
Cbud_s2_2181 x2_x2_net5 Vm 1.19379f
Cbud_s2_2182 x2_x2_net6 x2_x2_net7 6.75515f
Cbud_s2_2183 x2_x2_net6 x2_x2_net8 6.75515f
Cbud_s2_2184 x2_x2_net6 x2_x2_net9 6.75515f
Cbud_s2_2185 x2_x2_net6 Vm 1.19379f
Cbud_s2_2186 x2_x2_net7 x2_x2_net8 6.75515f
Cbud_s2_2187 x2_x2_net7 x2_x2_net9 6.75515f
Cbud_s2_2188 x2_x2_net7 Vm 1.19379f
Cbud_s2_2189 x2_x2_net8 x2_x2_net9 6.75515f
Cbud_s2_2190 x2_x2_net8 Vm 1.19379f
Cbud_s2_2191 x2_x2_net9 Vm 1.19379f
XM32 s1r_XM32_d PBias s1r_XM32_s Vdd sky130_fd_pr__pfet_01v8_lvt L=1 W=5 NF=1 AD=1.45 AS=1.45 PD=10.58 PS=10.58 NRD=0.058 NRS=0.058 SA=0 SB=0 SD=0 MULT=2 M=2
Rpar_s1_XM32_s s1r_XM32_s Vdd 44.702
Rpar_s1_XM32_d s1r_XM32_d NBias 82.5537
XM33 NBias NBias Vss Vss sky130_fd_pr__nfet_01v8_lvt L=2 W=5 NF=1 AD=1.45 AS=1.45 PD=10.58 PS=10.58 NRD=0.058 NRS=0.058 SA=0 SB=0 SD=0 MULT=2 M=2
XM34 net1 PBias Vdd Vdd sky130_fd_pr__pfet_01v8_lvt L=1 W=5 NF=1 AD=1.45 AS=1.45 PD=10.58 PS=10.58 NRD=0.058 NRS=0.058 SA=0 SB=0 SD=0 MULT=2 M=2
XM35 s1r_XM35_d net1 s1r_XM35_s Vss sky130_fd_pr__nfet_01v8_lvt L=1 W=10 NF=1 AD=2.9 AS=2.9 PD=20.58 PS=20.58 NRD=0.029 NRS=0.029 SA=0 SB=0 SD=0 MULT=2 M=2
Rpar_s1_XM35_s s1r_XM35_s Rgm 24.4489
Rpar_s1_XM35_d s1r_XM35_d net1 60.4052
XM36 net2 net1 Vss Vss sky130_fd_pr__nfet_01v8_lvt L=2 W=5 NF=1 AD=1.45 AS=1.45 PD=10.58 PS=10.58 NRD=0.058 NRS=0.058 SA=0 SB=0 SD=0 MULT=2 M=2
XM37 s1r_XM37_d NBias s1r_XM37_s Vss sky130_fd_pr__nfet_01v8_lvt L=2 W=5 NF=1 AD=1.45 AS=1.45 PD=10.58 PS=10.58 NRD=0.058 NRS=0.058 SA=0 SB=0 SD=0 MULT=2 M=2
Rpar_s1_XM37_s s1r_XM37_s Vss 23.0704
Rpar_s1_XM37_d s1r_XM37_d PBias 79.8907
XM38 PBias net2 Vdd Vdd sky130_fd_pr__pfet_01v8_lvt L=1 W=5 NF=1 AD=1.45 AS=1.45 PD=10.58 PS=10.58 NRD=0.058 NRS=0.058 SA=0 SB=0 SD=0 MULT=2 M=2
XM39 net2 net2 Vdd Vdd sky130_fd_pr__pfet_01v8_lvt L=1 W=5 NF=1 AD=1.45 AS=1.45 PD=10.58 PS=10.58 NRD=0.058 NRS=0.058 SA=0 SB=0 SD=0 MULT=2 M=2
XM40 PBias net3 NBias Vss sky130_fd_pr__nfet_01v8_lvt L=1 W=2 NF=1 AD=0.58 AS=0.58 PD=4.58 PS=4.58 NRD=0.145 NRS=0.145 SA=0 SB=0 SD=0 MULT=1
XM41 net3 NBias Vss Vss sky130_fd_pr__nfet_01v8_lvt L=2 W=5 NF=1 AD=1.45 AS=1.45 PD=10.58 PS=10.58 NRD=0.058 NRS=0.058 SA=0 SB=0 SD=0 MULT=2 M=2
XM42 net3 net3 Vdd Vdd sky130_fd_pr__pfet_01v8_lvt L=20 W=1 NF=1 AD=0.29 AS=0.29 PD=2.58 PS=2.58 NRD=0.29 NRS=0.29 SA=0 SB=0 SD=0 MULT=2 M=2
XM43 s1r_XM43_d PBias s1r_XM43_s Vdd sky130_fd_pr__pfet_01v8_lvt L=1 W=5 NF=1 AD=1.45 AS=1.45 PD=10.58 PS=10.58 NRD=0.058 NRS=0.058 SA=0 SB=0 SD=0 MULT=2 M=2
Rpar_s1_XM43_s s1r_XM43_s Vdd 44.702
Rpar_s1_XM43_d s1r_XM43_d net4 120.81
XM44 s1r_XM44_d PBias s1r_XM44_s Vdd sky130_fd_pr__pfet_01v8_lvt L=1 W=5 NF=1 AD=1.45 AS=1.45 PD=10.58 PS=10.58 NRD=0.058 NRS=0.058 SA=0 SB=0 SD=0 MULT=2 M=2
Rpar_s1_XM44_s s1r_XM44_s Vdd 44.702
Rpar_s1_XM44_d s1r_XM44_d net5 81.843
XM45 s1r_XM45_d PBias s1r_XM45_s Vdd sky130_fd_pr__pfet_01v8_lvt L=1 W=5 NF=1 AD=1.45 AS=1.45 PD=10.58 PS=10.58 NRD=0.058 NRS=0.058 SA=0 SB=0 SD=0 MULT=2 M=2
Rpar_s1_XM45_s s1r_XM45_s Vdd 44.702
Rpar_s1_XM45_d s1r_XM45_d net6 206.384
XM54 net7 PBias Vdd Vdd sky130_fd_pr__pfet_01v8_lvt L=1 W=5 NF=1 AD=1.45 AS=1.45 PD=10.58 PS=10.58 NRD=0.058 NRS=0.058 SA=0 SB=0 SD=0 MULT=2 M=2
XX1_M5 s1r_XX1_M5_d s1r_XX1_M5_g s1r_XX1_M5_s Vss sky130_fd_pr__nfet_01v8_lvt L=4 W=4 NF=1 AD=1.16 AS=1.16 PD=8.58 PS=8.58 NRD=0.0725 NRS=0.0725 SA=0 SB=0 SD=0 MULT=2 M=2
Rpar_s1_XX1_M5_s s1r_XX1_M5_s x1_net2 25.8511
Rpar_s1_XX1_M5_g s1r_XX1_M5_g Vm 20.4193
Rpar_s1_XX1_M5_d s1r_XX1_M5_d x1_Vtest2 167.522
XX1_M6 s1r_XX1_M6_d s1r_XX1_M6_g s1r_XX1_M6_s Vss sky130_fd_pr__nfet_01v8_lvt L=4 W=4 NF=1 AD=1.16 AS=1.16 PD=8.58 PS=8.58 NRD=0.0725 NRS=0.0725 SA=0 SB=0 SD=0 MULT=2 M=2
Rpar_s1_XX1_M6_s s1r_XX1_M6_s x1_net2 25.8511
Rpar_s1_XX1_M6_g s1r_XX1_M6_g Vp 20.4193
Rpar_s1_XX1_M6_d s1r_XX1_M6_d x1_net1 167.522
XX1_M11 Vop1 x1_Vbias s1r_XX1_M11_s Vdd sky130_fd_pr__pfet_01v8_lvt L=5 W=2 NF=1 AD=0.58 AS=0.58 PD=4.58 PS=4.58 NRD=0.145 NRS=0.145 SA=0 SB=0 SD=0 MULT=2 M=2
Rpar_s1_XX1_M11_s s1r_XX1_M11_s x1_Vtest2 86.8151
XX1_M12 Vom1 x1_Vbias s1r_XX1_M12_s Vdd sky130_fd_pr__pfet_01v8_lvt L=5 W=2 NF=1 AD=0.58 AS=0.58 PD=4.58 PS=4.58 NRD=0.145 NRS=0.145 SA=0 SB=0 SD=0 MULT=2 M=2
Rpar_s1_XX1_M12_s s1r_XX1_M12_s x1_net1 86.8151
XX1_M13 s1r_XX1_M13_d x1_Vout Vdd Vdd sky130_fd_pr__pfet_01v8_lvt L=5 W=2 NF=1 AD=0.58 AS=0.58 PD=4.58 PS=4.58 NRD=0.145 NRS=0.145 SA=0 SB=0 SD=0 MULT=4 M=4
Rpar_s1_XX1_M13_d s1r_XX1_M13_d x1_Vtest2 225.146
XX1_M14 s1r_XX1_M14_d x1_Vout Vdd Vdd sky130_fd_pr__pfet_01v8_lvt L=5 W=2 NF=1 AD=0.58 AS=0.58 PD=4.58 PS=4.58 NRD=0.145 NRS=0.145 SA=0 SB=0 SD=0 MULT=4 M=4
Rpar_s1_XX1_M14_d s1r_XX1_M14_d x1_net1 225.146
XX1_M19 x1_net2 net5 s1r_XX1_M19_s Vss sky130_fd_pr__nfet_01v8_lvt L=1 W=1 NF=1 AD=0.29 AS=0.29 PD=2.58 PS=2.58 NRD=0.29 NRS=0.29 SA=0 SB=0 SD=0 MULT=2 M=2
Rpar_s1_XX1_M19_s s1r_XX1_M19_s x1_net3 201.45
XX1_M1 s1r_XX1_M1_d net4 s1r_XX1_M1_s Vss sky130_fd_pr__nfet_01v8_lvt L=10 W=1 NF=1 AD=0.29 AS=0.29 PD=2.58 PS=2.58 NRD=0.29 NRS=0.29 SA=0 SB=0 SD=0 MULT=2 M=2
Rpar_s1_XX1_M1_s s1r_XX1_M1_s Vss 62.9711
Rpar_s1_XX1_M1_d s1r_XX1_M1_d x1_net3 201.45
XX1_M2 s1r_XX1_M2_d net4 s1r_XX1_M2_s Vss sky130_fd_pr__nfet_01v8_lvt L=10 W=1 NF=1 AD=0.29 AS=0.29 PD=2.58 PS=2.58 NRD=0.29 NRS=0.29 SA=0 SB=0 SD=0 MULT=2 M=2
Rpar_s1_XX1_M2_s s1r_XX1_M2_s Vss 62.9711
Rpar_s1_XX1_M2_d s1r_XX1_M2_d x1_net4 201.45
XX1_M3 x1_net2 net5 s1r_XX1_M3_s Vss sky130_fd_pr__nfet_01v8_lvt L=1 W=1 NF=1 AD=0.29 AS=0.29 PD=2.58 PS=2.58 NRD=0.29 NRS=0.29 SA=0 SB=0 SD=0 MULT=2 M=2
Rpar_s1_XX1_M3_s s1r_XX1_M3_s x1_net4 201.45
XX1_M4 Vop1 net5 x1_net5 Vss sky130_fd_pr__nfet_01v8_lvt L=1 W=1 NF=1 AD=0.29 AS=0.29 PD=2.58 PS=2.58 NRD=0.29 NRS=0.29 SA=0 SB=0 SD=0 MULT=2 M=2
XX1_M7 x1_net5 net4 Vss Vss sky130_fd_pr__nfet_01v8_lvt L=10 W=1 NF=1 AD=0.29 AS=0.29 PD=2.58 PS=2.58 NRD=0.29 NRS=0.29 SA=0 SB=0 SD=0 MULT=2 M=2
XX1_M8 Vom1 net5 x1_net6 Vss sky130_fd_pr__nfet_01v8_lvt L=1 W=1 NF=1 AD=0.29 AS=0.29 PD=2.58 PS=2.58 NRD=0.29 NRS=0.29 SA=0 SB=0 SD=0 MULT=2 M=2
XX1_M9 x1_net6 net4 Vss Vss sky130_fd_pr__nfet_01v8_lvt L=10 W=1 NF=1 AD=0.29 AS=0.29 PD=2.58 PS=2.58 NRD=0.29 NRS=0.29 SA=0 SB=0 SD=0 MULT=2 M=2
XX1_M10 x1_Vout s1r_XX1_M10_g x1_net8 Vss sky130_fd_pr__nfet_01v8_lvt L=20 W=5 NF=1 AD=1.45 AS=1.45 PD=10.58 PS=10.58 NRD=0.058 NRS=0.058 SA=0 SB=0 SD=0 MULT=2 M=2
Rpar_s1_XX1_M10_g s1r_XX1_M10_g Vref 167.933
XX1_M17 x1_net9 s1r_XX1_M17_g x1_net8 Vss sky130_fd_pr__nfet_01v8_lvt L=20 W=5 NF=1 AD=1.45 AS=1.45 PD=10.58 PS=10.58 NRD=0.058 NRS=0.058 SA=0 SB=0 SD=0 MULT=2 M=2
Rpar_s1_XX1_M17_g s1r_XX1_M17_g Vop1 167.933
XX1_M18 x1_net9 s1r_XX1_M18_g x1_net7 Vss sky130_fd_pr__nfet_01v8_lvt L=20 W=5 NF=1 AD=1.45 AS=1.45 PD=10.58 PS=10.58 NRD=0.058 NRS=0.058 SA=0 SB=0 SD=0 MULT=2 M=2
Rpar_s1_XX1_M18_g s1r_XX1_M18_g Vom1 167.933
XX1_M22 x1_net7 net4 Vss Vss sky130_fd_pr__nfet_01v8_lvt L=20 W=1 NF=1 AD=0.29 AS=0.29 PD=2.58 PS=2.58 NRD=0.29 NRS=0.29 SA=0 SB=0 SD=0 MULT=2 M=2
XX1_M20 x1_net9 x1_net9 Vdd Vdd sky130_fd_pr__pfet_01v8_lvt L=10 W=1 NF=1 AD=0.29 AS=0.29 PD=2.58 PS=2.58 NRD=0.29 NRS=0.29 SA=0 SB=0 SD=0 MULT=2 M=2
XX1_M21 x1_Vout x1_net9 Vdd Vdd sky130_fd_pr__pfet_01v8_lvt L=10 W=1 NF=1 AD=0.29 AS=0.29 PD=2.58 PS=2.58 NRD=0.29 NRS=0.29 SA=0 SB=0 SD=0 MULT=2 M=2
XX1_M15 x1_net8 net4 Vss Vss sky130_fd_pr__nfet_01v8_lvt L=20 W=1 NF=1 AD=0.29 AS=0.29 PD=2.58 PS=2.58 NRD=0.29 NRS=0.29 SA=0 SB=0 SD=0 MULT=2 M=2
XX1_M16 x1_Vout s1r_XX1_M16_g x1_net7 Vss sky130_fd_pr__nfet_01v8_lvt L=20 W=5 NF=1 AD=1.45 AS=1.45 PD=10.58 PS=10.58 NRD=0.058 NRS=0.058 SA=0 SB=0 SD=0 MULT=2 M=2
Rpar_s1_XX1_M16_g s1r_XX1_M16_g Vref 167.933
XX1_M46 net4 net4 Vss Vss sky130_fd_pr__nfet_01v8_lvt L=2 W=1 NF=1 AD=0.29 AS=0.29 PD=2.58 PS=2.58 NRD=0.29 NRS=0.29 SA=0 SB=0 SD=0 MULT=2 M=2
XX1_M47 net5 net5 Vss Vss sky130_fd_pr__nfet_01v8_lvt L=5 W=0.6 NF=1 AD=0.174 AS=0.174 PD=1.78 PS=1.78 NRD=0.483333 NRS=0.483333 SA=0 SB=0 SD=0 MULT=2 M=2
XX1_M23 net6 net6 s1r_XX1_M23_s Vss sky130_fd_pr__nfet_01v8_lvt L=1 W=0.6 NF=1 AD=0.174 AS=0.174 PD=1.78 PS=1.78 NRD=0.483333 NRS=0.483333 SA=0 SB=0 SD=0 MULT=2 M=2
Rpar_s1_XX1_M23_s s1r_XX1_M23_s Vss 154.912
XX1_M24 x1_Vbias net6 s1r_XX1_M24_s Vss sky130_fd_pr__nfet_01v8_lvt L=1 W=0.6 NF=1 AD=0.174 AS=0.174 PD=1.78 PS=1.78 NRD=0.483333 NRS=0.483333 SA=0 SB=0 SD=0 MULT=2 M=2
Rpar_s1_XX1_M24_s s1r_XX1_M24_s Vss 154.912
XX1_M25 x1_Vbias x1_Vbias Vdd Vdd sky130_fd_pr__pfet_01v8_lvt L=10 W=1.5 NF=1 AD=0.435 AS=0.435 PD=3.58 PS=3.58 NRD=0.193333 NRS=0.193333 SA=0 SB=0 SD=0 MULT=2 M=2
XX2_M9 s1r_XX2_M9_d Vom1 s1r_XX2_M9_s Vdd sky130_fd_pr__pfet_01v8_lvt L=1 W=2 NF=1 AD=0.58 AS=0.58 PD=4.58 PS=4.58 NRD=0.145 NRS=0.145 SA=0 SB=0 SD=0 MULT=9 M=9
Rpar_s1_XX2_M9_s s1r_XX2_M9_s Vdd 39.5499
Rpar_s1_XX2_M9_d s1r_XX2_M9_d Vop 39.5499
XX2_M4 s1r_XX2_M4_d Vop1 s1r_XX2_M4_s Vdd sky130_fd_pr__pfet_01v8_lvt L=1 W=2 NF=1 AD=0.58 AS=0.58 PD=4.58 PS=4.58 NRD=0.145 NRS=0.145 SA=0 SB=0 SD=0 MULT=9 M=9
Rpar_s1_XX2_M4_s s1r_XX2_M4_s Vdd 39.5499
Rpar_s1_XX2_M4_d s1r_XX2_M4_d Vom 39.5499
XX2_M2 s1r_XX2_M2_d x2_Vout Vss Vss sky130_fd_pr__nfet_01v8_lvt L=1 W=1 NF=1 AD=0.29 AS=0.29 PD=2.58 PS=2.58 NRD=0.29 NRS=0.29 SA=0 SB=0 SD=0 MULT=9 M=9
Rpar_s1_XX2_M2_d s1r_XX2_M2_d Vop 51.4112
XX2_M1 s1r_XX2_M1_d x2_Vout Vss Vss sky130_fd_pr__nfet_01v8_lvt L=1 W=1 NF=1 AD=0.29 AS=0.29 PD=2.58 PS=2.58 NRD=0.29 NRS=0.29 SA=0 SB=0 SD=0 MULT=9 M=9
Rpar_s1_XX2_M1_d s1r_XX2_M1_d Vom 51.4112
XX2_M3 x2_net1 x2_Vbiasp Vdd Vdd sky130_fd_pr__pfet_01v8_lvt L=5 W=1 NF=1 AD=0.29 AS=0.29 PD=2.58 PS=2.58 NRD=0.29 NRS=0.29 SA=0 SB=0 SD=0 MULT=2 M=2
XX2_M7 x2_Vtest x2_Vcm x2_net1 Vdd sky130_fd_pr__pfet_01v8_lvt L=10 W=1 NF=1 AD=0.29 AS=0.29 PD=2.58 PS=2.58 NRD=0.29 NRS=0.29 SA=0 SB=0 SD=0 MULT=2 M=2
XX2_M8 x2_Vout Vref x2_net1 Vdd sky130_fd_pr__pfet_01v8_lvt L=10 W=1 NF=1 AD=0.29 AS=0.29 PD=2.58 PS=2.58 NRD=0.29 NRS=0.29 SA=0 SB=0 SD=0 MULT=2 M=2
XX2_M5 x2_Vtest x2_Vtest Vss Vss sky130_fd_pr__nfet_01v8_lvt L=20 W=0.5 NF=1 AD=0.145 AS=0.145 PD=1.58 PS=1.58 NRD=0.58 NRS=0.58 SA=0 SB=0 SD=0 MULT=2 M=2
XX2_M6 x2_Vout x2_Vtest Vss Vss sky130_fd_pr__nfet_01v8_lvt L=20 W=0.5 NF=1 AD=0.145 AS=0.145 PD=1.58 PS=1.58 NRD=0.58 NRS=0.58 SA=0 SB=0 SD=0 MULT=2 M=2
XX2_M10 net7 net7 Vss Vss sky130_fd_pr__nfet_01v8_lvt L=1 W=0.6 NF=1 AD=0.174 AS=0.174 PD=1.78 PS=1.78 NRD=0.483333 NRS=0.483333 SA=0 SB=0 SD=0 MULT=2 M=2
XX2_M11 x2_Vbiasp net7 Vss Vss sky130_fd_pr__nfet_01v8_lvt L=1 W=0.6 NF=1 AD=0.174 AS=0.174 PD=1.78 PS=1.78 NRD=0.483333 NRS=0.483333 SA=0 SB=0 SD=0 MULT=2 M=2
XX2_M12 x2_Vbiasp x2_Vbiasp Vdd Vdd sky130_fd_pr__pfet_01v8_lvt L=1 W=6 NF=1 AD=1.74 AS=1.74 PD=12.58 PS=12.58 NRD=0.0483333 NRS=0.0483333 SA=0 SB=0 SD=0 MULT=2 M=2
Vref_ext Vref Vss 0.9
XC1 Vop1 Vom sky130_fd_pr__cap_mim_m3_1 W=10 L=10 MF=5 M=5
XC2 Vom1 Vop sky130_fd_pr__cap_mim_m3_1 W=10 L=10 MF=5 M=5
XX2_X1_R1 x2_x1_net4 Vop sky130_fd_pr__res_generic_po W=0.5 L=40
XX2_X1_R2 x2_x1_net5 x2_x1_net4 sky130_fd_pr__res_generic_po W=0.5 L=40
XX2_X1_R3 x2_x1_net6 x2_x1_net5 sky130_fd_pr__res_generic_po W=0.5 L=40
XX2_X1_R4 x2_x1_net7 x2_x1_net6 sky130_fd_pr__res_generic_po W=0.5 L=40
XX2_X1_R5 x2_x1_net1 x2_x1_net7 sky130_fd_pr__res_generic_po W=0.5 L=40
XX2_X1_R6 x2_x1_net8 x2_x1_net2 sky130_fd_pr__res_generic_po W=0.5 L=40
XX2_X1_R7 x2_x1_net9 x2_x1_net8 sky130_fd_pr__res_generic_po W=0.5 L=40
XX2_X1_R8 x2_x1_net10 x2_x1_net9 sky130_fd_pr__res_generic_po W=0.5 L=40
XX2_X1_R9 x2_x1_net11 x2_x1_net10 sky130_fd_pr__res_generic_po W=0.5 L=40
XX2_X1_R10 x2_x1_net1 x2_x1_net11 sky130_fd_pr__res_generic_po W=0.5 L=40
XX2_X1_R11 x2_x1_net12 x2_x1_net2 sky130_fd_pr__res_generic_po W=0.5 L=40
XX2_X1_R12 x2_x1_net13 x2_x1_net12 sky130_fd_pr__res_generic_po W=0.5 L=40
XX2_X1_R13 x2_x1_net14 x2_x1_net13 sky130_fd_pr__res_generic_po W=0.5 L=40
XX2_X1_R14 x2_x1_net15 x2_x1_net14 sky130_fd_pr__res_generic_po W=0.5 L=40
XX2_X1_R16 x2_x1_net16 x2_Vcm sky130_fd_pr__res_generic_po W=0.5 L=40
XX2_X1_R17 x2_x1_net17 x2_x1_net16 sky130_fd_pr__res_generic_po W=0.5 L=40
XX2_X1_R18 x2_x1_net18 x2_x1_net17 sky130_fd_pr__res_generic_po W=0.5 L=40
XX2_X1_R19 x2_x1_net19 x2_x1_net18 sky130_fd_pr__res_generic_po W=0.5 L=40
XX2_X1_R20 x2_x1_net3 x2_x1_net19 sky130_fd_pr__res_generic_po W=0.5 L=40
XX2_X1_R15 x2_x1_net3 x2_x1_net15 sky130_fd_pr__res_generic_po W=0.5 L=40
XX2_X2_R1 x2_x2_net4 x2_Vcm sky130_fd_pr__res_generic_po W=0.5 L=40
XX2_X2_R2 x2_x2_net5 x2_x2_net4 sky130_fd_pr__res_generic_po W=0.5 L=40
XX2_X2_R3 x2_x2_net6 x2_x2_net5 sky130_fd_pr__res_generic_po W=0.5 L=40
XX2_X2_R4 x2_x2_net7 x2_x2_net6 sky130_fd_pr__res_generic_po W=0.5 L=40
XX2_X2_R5 x2_x2_net1 x2_x2_net7 sky130_fd_pr__res_generic_po W=0.5 L=40
XX2_X2_R6 x2_x2_net8 x2_x2_net2 sky130_fd_pr__res_generic_po W=0.5 L=40
XX2_X2_R7 x2_x2_net9 x2_x2_net8 sky130_fd_pr__res_generic_po W=0.5 L=40
XX2_X2_R8 x2_x2_net10 x2_x2_net9 sky130_fd_pr__res_generic_po W=0.5 L=40
XX2_X2_R9 x2_x2_net11 x2_x2_net10 sky130_fd_pr__res_generic_po W=0.5 L=40
XX2_X2_R10 x2_x2_net1 x2_x2_net11 sky130_fd_pr__res_generic_po W=0.5 L=40
XX2_X2_R11 x2_x2_net12 x2_x2_net2 sky130_fd_pr__res_generic_po W=0.5 L=40
XX2_X2_R12 x2_x2_net13 x2_x2_net12 sky130_fd_pr__res_generic_po W=0.5 L=40
XX2_X2_R13 x2_x2_net14 x2_x2_net13 sky130_fd_pr__res_generic_po W=0.5 L=40
XX2_X2_R14 x2_x2_net15 x2_x2_net14 sky130_fd_pr__res_generic_po W=0.5 L=40
XX2_X2_R16 x2_x2_net16 Vom sky130_fd_pr__res_generic_po W=0.5 L=40
XX2_X2_R17 x2_x2_net17 x2_x2_net16 sky130_fd_pr__res_generic_po W=0.5 L=40
XX2_X2_R18 x2_x2_net18 x2_x2_net17 sky130_fd_pr__res_generic_po W=0.5 L=40
XX2_X2_R19 x2_x2_net19 x2_x2_net18 sky130_fd_pr__res_generic_po W=0.5 L=40
XX2_X2_R20 x2_x2_net3 x2_x2_net19 sky130_fd_pr__res_generic_po W=0.5 L=40
XX2_X2_R15 x2_x2_net3 x2_x2_net15 sky130_fd_pr__res_generic_po W=0.5 L=40
Rgm_ext Rgm Vss 12000
.ends ttsky25a_fd
.end
