* example_ota_5t on diso_amp_AC
.lib $PDK_ROOT/sky130A/libs.tech/combined/sky130.lib.spice tt
.param VDD_V=1.98 VCM_V=0.9 CL_F=200f
.temp -40

** sch_path: /foss/designs/PROJECTS/llm-analog-sizing/testbenches/diso_amp_AC.sch
**.subckt diso_amp_AC
x1 INP INN net1 VDD 0 OUT dut_amp
Vsup VDD 0 'VDD_V'
Vinp INP 0 dc 'VCM_V' ac 0.5
Vinn INN 0 dc 'VCM_V' ac -0.5
Cload OUT 0 'CL_F'
* noconn #net1
**** begin user architecture code

.control
  save all
  ac dec 40 1 1G

  * open-loop gain [dB], gain-bandwidth product [MHz], phase margin [deg].
  * Phase is measured RELATIVE to its low-frequency value, so an inverting
  * stage -- whose phase starts at 180 deg -- reports the same margin as a
  * non-inverting one. cph is the unwrapped phase, so a sweep that crosses
  * +/-180 deg does not jump.
  let gph_deg = 180/pi * cph(v(OUT))
  meas ac gain_db find vdb(OUT) at=1
  meas ac gbw_hz  when vdb(OUT)=0
  meas ac ph_dc   find gph_deg at=1
  meas ac ph_ugb  find gph_deg when vdb(OUT)=0
  let gbw_mhz = gbw_hz / 1e6
  let pm_deg  = 180 + (ph_ugb - ph_dc)

  echo MEAS gain_db $&gain_db
  echo MEAS gbw_mhz $&gbw_mhz
  echo MEAS pm_deg $&pm_deg

  write
  quit 0
.endc

**** end user architecture code
**.ends

* expanding   symbol:  dut_amp.sym # of pins=6
** sym_path: /foss/designs/PROJECTS/llm-analog-sizing/testbenches/dut_amp.sym
** sch_path: /foss/designs/PROJECTS/llm-analog-sizing/testbenches/dut_amp.sch
.subckt dut_amp INP INN OUTN VDD VSS OUTP
XDUT VDD OUTP INP INN VSS example_ota_5t_sized
.ends

.subckt example_ota_5t_sized VDD OUTP INP INN VSS
Cbud_s2_0 OUTP VSS 0.307226f
Cbud_s2_1 net1 VSS 58.4575f
Cbud_s2_2 net3 VSS 0.415972f
Cbud_s2_3 OUTP net1 0.475381f
Cbud_s2_4 OUTP net3 0.119269f
Cbud_s2_5 OUTP INP 0.250829f
Cbud_s2_6 OUTP INN 0.396331f
Cbud_s2_7 net1 net3 0.41702f
Cbud_s2_8 net1 INP 1.97312f
Cbud_s2_9 net3 INP 0.338953f
Cbud_s2_10 net3 INN 0.538277f
XM3 s1r_XM3_d s1r_XM3_g s1r_XM3_s VDD sky130_fd_pr__pfet_01v8 L=1 W=8 NF=1 AD=2.32 AS=2.32 PD=16.58 PS=16.58 NRD=0.03625 NRS=0.03625 SA=0 SB=0 SD=0 MULT=1
Rpar_s1_XM3_s s1r_XM3_s VDD 12.0667
Rpar_s1_XM3_g s1r_XM3_g net3 293.464
Rpar_s1_XM3_d s1r_XM3_d net3 331.773
XM4 s1r_XM4_d s1r_XM4_g s1r_XM4_s VDD sky130_fd_pr__pfet_01v8 L=1 W=8 NF=1 AD=2.32 AS=2.32 PD=16.58 PS=16.58 NRD=0.03625 NRS=0.03625 SA=0 SB=0 SD=0 MULT=1
Rpar_s1_XM4_s s1r_XM4_s VDD 12.0667
Rpar_s1_XM4_g s1r_XM4_g net3 293.464
Rpar_s1_XM4_d s1r_XM4_d OUTP 331.773
XM1 s1r_XM1_d s1r_XM1_g s1r_XM1_s VSS sky130_fd_pr__nfet_01v8 L=0.5 W=24 NF=1 AD=6.96 AS=6.96 PD=48.58 PS=48.58 NRD=0.0120833333333333 NRS=0.0120833333333333 SA=0 SB=0 SD=0 MULT=1
Rpar_s1_XM1_s s1r_XM1_s net1 1.70914
Rpar_s1_XM1_g s1r_XM1_g INP 19.7231
Rpar_s1_XM1_d s1r_XM1_d net3 14.6475
XM2 s1r_XM2_d s1r_XM2_g s1r_XM2_s VSS sky130_fd_pr__nfet_01v8 L=0.5 W=24 NF=1 AD=6.96 AS=6.96 PD=48.58 PS=48.58 NRD=0.0120833333333333 NRS=0.0120833333333333 SA=0 SB=0 SD=0 MULT=1
Rpar_s1_XM2_s s1r_XM2_s net1 1.70914
Rpar_s1_XM2_g s1r_XM2_g INN 19.7231
Rpar_s1_XM2_d s1r_XM2_d OUTP 14.6475
XM5 s1r_XM5_d s1r_XM5_g s1r_XM5_s VSS sky130_fd_pr__nfet_01v8 L=1 W=24 NF=1 AD=6.96 AS=6.96 PD=48.58 PS=48.58 NRD=0.0120833333333333 NRS=0.0120833333333333 SA=0 SB=0 SD=0 MULT=1
Rpar_s1_XM5_s s1r_XM5_s VSS 1.43913
Rpar_s1_XM5_g s1r_XM5_g net2 571.375
Rpar_s1_XM5_d s1r_XM5_d net1 19.335
V1 net2 VSS 0.75
.ends example_ota_5t_sized
.end
