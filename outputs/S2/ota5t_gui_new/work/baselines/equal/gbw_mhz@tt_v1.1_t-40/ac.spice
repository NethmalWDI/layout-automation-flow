* ota5t_gui_new on diso_amp_AC
.lib $PDK_ROOT/sky130A/libs.tech/combined/sky130.lib.spice tt
.param VDD_V=1.98 VCM_V=0.9 CL_F=1p
.temp -40

**.subckt diso_amp_AC
x1 INP INN net1 VDD 0 OUT dut_amp
Vsup VDD 0 'VDD_V'
Vinp INP 0 dc 'VCM_V' ac 1
* DC unity feedback through a 1 GH choke, INN held at AC ground by 1 F (loop open from 1 Hz up)
Lfb OUT INN 1G
Cfb INN 0 1
Cload OUT 0 'CL_F'
.control
  save all
  ac dec 40 1 1G
  let hsig = v(OUT)
  let hdb = db(hsig)
  let gph_deg = 180/pi * cph(hsig)
  meas ac gain_db find hdb at=1
  meas ac gbw_hz  when hdb=0
  meas ac ph_dc   find gph_deg at=1
  meas ac ph_ugb  find gph_deg when hdb=0
  let gbw_mhz = gbw_hz / 1e6
  let ph_ref  = 180 * floor(ph_dc / 180 + 0.5)
  let pm_deg  = 180 + (ph_ugb - ph_ref)
  echo MEAS gain_db $&gain_db
  echo MEAS gbw_mhz $&gbw_mhz
  echo MEAS pm_deg $&pm_deg
  write
  quit 0
.endc
**.ends

.subckt dut_amp INP INN OUTN VDD VSS OUTP
XDUT VDD OUTP INP INN VSS example_ota_5t_sized
.ends

.subckt example_ota_5t_sized VDD OUTP INP INN VSS
Cbud_s2_0 OUTP VSS 0.0840343f
Cbud_s2_1 net3 VSS 0.134135f
Cbud_s2_2 OUTP net1 0.090389f
Cbud_s2_3 OUTP net3 0.0318164f
Cbud_s2_4 OUTP INP 0.0705105f
Cbud_s2_5 OUTP INN 0.0840343f
Cbud_s2_6 net1 net3 0.203687f
Cbud_s2_7 net1 INP 0.89386f
Cbud_s2_8 net3 INP 0.110476f
Cbud_s2_9 net3 INN 0.134135f
XM3 net3 net3 VDD VDD sky130_fd_pr__pfet_01v8 L=1 W=8 NF=1 AD=2.32 AS=2.32 PD=16.58 PS=16.58 NRD=0.03625 NRS=0.03625 SA=0 SB=0 SD=0 MULT=1
XM4 s1r_XM4_d s1r_XM4_g s1r_XM4_s VDD sky130_fd_pr__pfet_01v8 L=1 W=8 NF=1 AD=2.32 AS=2.32 PD=16.58 PS=16.58 NRD=0.03625 NRS=0.03625 SA=0 SB=0 SD=0 MULT=1
Rpar_s1_XM4_s s1r_XM4_s VDD 0.428754
Rpar_s1_XM4_g s1r_XM4_g net3 23.98
Rpar_s1_XM4_d s1r_XM4_d OUTP 9.34211
XM1 s1r_XM1_d s1r_XM1_g s1r_XM1_s VSS sky130_fd_pr__nfet_01v8 L=0.5 W=24 NF=1 AD=6.96 AS=6.96 PD=48.58 PS=48.58 NRD=0.0120833333333333 NRS=0.0120833333333333 SA=0 SB=0 SD=0 MULT=1
Rpar_s1_XM1_s s1r_XM1_s net1 0.19563
Rpar_s1_XM1_g s1r_XM1_g INP 72.521
Rpar_s1_XM1_d s1r_XM1_d net3 3.12117
XM2 s1r_XM2_d s1r_XM2_g s1r_XM2_s VSS sky130_fd_pr__nfet_01v8 L=0.5 W=24 NF=1 AD=6.96 AS=6.96 PD=48.58 PS=48.58 NRD=0.0120833333333333 NRS=0.0120833333333333 SA=0 SB=0 SD=0 MULT=1
Rpar_s1_XM2_s s1r_XM2_s net1 0.229848
Rpar_s1_XM2_g s1r_XM2_g INN 21.4757
Rpar_s1_XM2_d s1r_XM2_d OUTP 4.12583
XM5 s1r_XM5_d net2 s1r_XM5_s VSS sky130_fd_pr__nfet_01v8 L=1 W=24 NF=1 AD=6.96 AS=6.96 PD=48.58 PS=48.58 NRD=0.0120833333333333 NRS=0.0120833333333333 SA=0 SB=0 SD=0 MULT=1
Rpar_s1_XM5_s s1r_XM5_s VSS 0.0998159
Rpar_s1_XM5_d s1r_XM5_d net1 1.20814
V1 net2 VSS 0.75
.ends example_ota_5t_sized
.end
