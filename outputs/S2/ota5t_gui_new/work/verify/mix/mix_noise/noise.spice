* ota5t_gui_new on diso_amp_NOISE
.lib $PDK_ROOT/sky130A/libs.tech/combined/sky130.lib.spice tt
.param VDD_V=1.8 VCM_V=0.9 CL_F=1p
.temp 27

**.subckt diso_amp_NOISE
x1 INP INN net1 VDD 0 OUT dut_amp
Vsup VDD 0 'VDD_V'
Vinp INP 0 dc 'VCM_V' ac 1
* DC unity feedback through a 1 GH choke, INN held at AC ground by 1 F (loop open from 1 Hz up)
Lfb OUT INN 1G
Cfb INN 0 1
Cload OUT 0 'CL_F'
.control
  save all
  let npd    = 20
  let fstart = 1
  let fspot  = 1e3
  noise v(OUT) Vinp dec 20 1 1e9
  setplot noise1
  let idx = npd * log10(fspot/fstart)
  let vnoise_nv_rthz = inoise_spectrum[$&idx] * 1e9
  echo MEAS vnoise_nv_rthz $&vnoise_nv_rthz
  write
  set appendwrite
  setplot noise2
  let vnoise_rms_uv_rms = inoise_total * 1e6
  echo MEAS vnoise_rms_uv_rms $&vnoise_rms_uv_rms
  write
  quit 0
.endc
**.ends

.subckt dut_amp INP INN OUTN VDD VSS OUTP
XDUT VDD OUTP INP INN VSS example_ota_5t_sized
.ends

.subckt example_ota_5t_sized VDD OUTP INP INN VSS
Cbud_s2_0 OUTP VSS 0.129077f
Cbud_s2_1 net1 VSS 77.7624f
Cbud_s2_2 net3 VSS 0.239173f
Cbud_s2_3 OUTP net1 0.030186f
Cbud_s2_4 OUTP net3 0.0249774f
Cbud_s2_5 OUTP INP 0.00686124f
Cbud_s2_6 OUTP INN 0.0215829f
Cbud_s2_7 net1 net3 0.0365534f
Cbud_s2_8 net1 INP 0.0215829f
Cbud_s2_9 net1 INN 6.28604f
Cbud_s2_10 net3 INP 0.0215829f
Cbud_s2_11 net3 INN 0.00686124f
XM3 s1r_XM3_d s1r_XM3_g s1r_XM3_s VDD sky130_fd_pr__pfet_01v8 L=1 W=8 NF=1 AD=2.32 AS=2.32 PD=16.58 PS=16.58 NRD=0.03625 NRS=0.03625 SA=0 SB=0 SD=0 MULT=1
Rpar_s1_XM3_s s1r_XM3_s VDD 331.773
Rpar_s1_XM3_g s1r_XM3_g net3 783.289
Rpar_s1_XM3_d s1r_XM3_d net3 331.773
XM4 s1r_XM4_d s1r_XM4_g s1r_XM4_s VDD sky130_fd_pr__pfet_01v8 L=1 W=8 NF=1 AD=2.32 AS=2.32 PD=16.58 PS=16.58 NRD=0.03625 NRS=0.03625 SA=0 SB=0 SD=0 MULT=1
Rpar_s1_XM4_s s1r_XM4_s VDD 1.13913
Rpar_s1_XM4_g s1r_XM4_g net3 2.6894
Rpar_s1_XM4_d s1r_XM4_d OUTP 1.13913
XM1 s1r_XM1_d s1r_XM1_g s1r_XM1_s VSS sky130_fd_pr__nfet_01v8 L=0.5 W=24 NF=1 AD=6.96 AS=6.96 PD=48.58 PS=48.58 NRD=0.0120833333333333 NRS=0.0120833333333333 SA=0 SB=0 SD=0 MULT=1
Rpar_s1_XM1_s s1r_XM1_s net1 0.709187
Rpar_s1_XM1_g s1r_XM1_g INP 9.82323
Rpar_s1_XM1_d s1r_XM1_d net3 0.709187
XM2 s1r_XM2_d s1r_XM2_g s1r_XM2_s VSS sky130_fd_pr__nfet_01v8 L=0.5 W=24 NF=1 AD=6.96 AS=6.96 PD=48.58 PS=48.58 NRD=0.0120833333333333 NRS=0.0120833333333333 SA=0 SB=0 SD=0 MULT=1
Rpar_s1_XM2_s s1r_XM2_s net1 0.709187
Rpar_s1_XM2_g s1r_XM2_g INN 9.82323
Rpar_s1_XM2_d s1r_XM2_d OUTP 0.709188
XM5 s1r_XM5_d s1r_XM5_g s1r_XM5_s VSS sky130_fd_pr__nfet_01v8 L=1 W=24 NF=1 AD=6.96 AS=6.96 PD=48.58 PS=48.58 NRD=0.0120833333333333 NRS=0.0120833333333333 SA=0 SB=0 SD=0 MULT=1
Rpar_s1_XM5_s s1r_XM5_s VSS 0.483744
Rpar_s1_XM5_g s1r_XM5_g net2 523.562
Rpar_s1_XM5_d s1r_XM5_d net1 0.689591
V1 net2 VSS 0.75
.ends example_ota_5t_sized
.end
