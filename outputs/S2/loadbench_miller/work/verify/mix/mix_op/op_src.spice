* loadbench_miller on diso_amp_OP
.lib $PDK_ROOT/sky130A/libs.tech/combined/sky130.lib.spice tt
.param VDD_V=1.8 VCM_V=0.9 CL_F=1p
.temp 27

**.subckt diso_amp_OP
x1 INP INN net1 VDD 0 OUT dut_amp
Vsup VDD 0 'VDD_V'
Vinp INP 0 dc 'VCM_V' ac 0
* DC unity feedback, AC open loop: a 1 GH choke from OUT to INN and a 1 F capacitor from INN to
* ground. At DC the amplifier is a follower, so OUT sits at VCM as in LOADBench's offset-corrected
* open-loop bench; from 1 Hz up INN is an AC ground and the loop is open (corner ~5 uHz).
Lfb OUT INN 1G
Cfb INN 0 1
Cload OUT 0 'CL_F'
* noconn #net1
.control
  save all
  op
  let isup    = abs(i(vsup))
  let isup_ua = isup * 1e6
  let power_uw = isup * v(VDD) * 1e6
  let vout_v  = v(OUT)
  echo MEAS isup_ua $&isup_ua
  echo MEAS power_uw $&power_uw
  echo MEAS vout_v $&vout_v
  write
  quit 0
.endc
**.ends

.subckt dut_amp INP INN OUTN VDD VSS OUTP
XDUT INN INP OUTP VSS VDD loadbench_miller
.ends

.subckt loadbench_miller in1 in2 out sourceNmos sourcePmos
Cbud_s2_0 out sourceNmos 12.0266f
Cbud_s2_1 outFirstStage sourceNmos 2.7848f
Cbud_s2_2 FirstStageYout1 FirstStageYsourceTransconductance 4.00774f
Cbud_s2_3 FirstStageYout1 outFirstStage 0.459665f
Cbud_s2_4 FirstStageYsourceTransconductance out 0.558929f
Cbud_s2_5 FirstStageYsourceTransconductance outFirstStage 0.406008f
Cbud_s2_6 ibias outFirstStage 2.98705f
Cbud_s2_7 out outFirstStage 0.320016f
Cbud_s2_8 out in1 1.35738f
Cbud_s2_9 out in2 1.35738f
Cbud_s2_10 outFirstStage in1 1.35738f
Cbud_s2_11 outFirstStage in2 0.162689f
Cbud_s2_12 FirstStageYout1 sourceNmos 2.1334f
Cbud_s2_13 FirstStageYout1 ibias 1.4657f
Cbud_s2_14 FirstStageYout1 out 0.212824f
Cbud_s2_15 FirstStageYout1 in1 1.51126f
Cbud_s2_16 FirstStageYsourceTransconductance in2 1.68652f
Cbud_s2_17 ibias out 3.71778f
Cbud_s2_18 FirstStageYsourceTransconductance sourceNmos 46.3345f
Cbud_s2_19 ibias sourceNmos 653.976f
Cbud_s2_20 FirstStageYsourceTransconductance ibias 8.14286f
Cbud_s2_21 FirstStageYsourceTransconductance in1 2.364f
Cbud_s2_22 ibias in1 1.35738f
XDiodeTransistorNmos1 s1r_XDiodeTransistorNmos1_d s1r_XDiodeTransistorNmos1_g s1r_XDiodeTransistorNmos1_s sourceNmos sky130_fd_pr__nfet_01v8_lvt L=2.03 W=66.13 NF=1 AD=19.1777 AS=19.1777 PD=132.84 PS=132.84 NRD=0.0043853 NRS=0.0043853 SA=0 SB=0 SD=0 MULT=1
Rpar_s1_XDiodeTransistorNmos1_s s1r_XDiodeTransistorNmos1_s sourceNmos 11.3307
Rpar_s1_XDiodeTransistorNmos1_g s1r_XDiodeTransistorNmos1_g FirstStageYout1 125.11
Rpar_s1_XDiodeTransistorNmos1_d s1r_XDiodeTransistorNmos1_d FirstStageYout1 79.3486
XDiodeTransistorPmos2 s1r_XDiodeTransistorPmos2_d ibias s1r_XDiodeTransistorPmos2_s sourcePmos sky130_fd_pr__pfet_01v8_lvt L=0.74 W=37.3 NF=1 AD=10.817 AS=10.817 PD=75.18 PS=75.18 NRD=0.0077748 NRS=0.0077748 SA=0 SB=0 SD=0 MULT=1
Rpar_s1_XDiodeTransistorPmos2_s s1r_XDiodeTransistorPmos2_s sourcePmos 310.493
Rpar_s1_XDiodeTransistorPmos2_d s1r_XDiodeTransistorPmos2_d ibias 310.493
XNormalTransistorNmos3 s1r_XNormalTransistorNmos3_d s1r_XNormalTransistorNmos3_g s1r_XNormalTransistorNmos3_s sourceNmos sky130_fd_pr__nfet_01v8_lvt L=0.24 W=484.2 NF=1 AD=140.418 AS=140.418 PD=968.98 PS=968.98 NRD=0.000598926 NRS=0.000598926 SA=0 SB=0 SD=0 MULT=1
Rpar_s1_XNormalTransistorNmos3_g s1r_XNormalTransistorNmos3_g outFirstStage 646.049
Rpar_s1_XNormalTransistorNmos3_s s1r_XNormalTransistorNmos3_s sourceNmos 15.7617
Rpar_s1_XNormalTransistorNmos3_d s1r_XNormalTransistorNmos3_d out 15.7617
XNormalTransistorNmos4 s1r_XNormalTransistorNmos4_d s1r_XNormalTransistorNmos4_g s1r_XNormalTransistorNmos4_s sourceNmos sky130_fd_pr__nfet_01v8_lvt L=2.03 W=66.13 NF=1 AD=19.1777 AS=19.1777 PD=132.84 PS=132.84 NRD=0.0043853 NRS=0.0043853 SA=0 SB=0 SD=0 MULT=1
Rpar_s1_XNormalTransistorNmos4_s s1r_XNormalTransistorNmos4_s sourceNmos 11.3307
Rpar_s1_XNormalTransistorNmos4_g s1r_XNormalTransistorNmos4_g FirstStageYout1 125.11
Rpar_s1_XNormalTransistorNmos4_d s1r_XNormalTransistorNmos4_d outFirstStage 79.3486
XNormalTransistorPmos5 s1r_XNormalTransistorPmos5_d s1r_XNormalTransistorPmos5_g s1r_XNormalTransistorPmos5_s sourcePmos sky130_fd_pr__pfet_01v8_lvt L=0.74 W=887.03 NF=1 AD=257.239 AS=257.239 PD=1774.64 PS=1774.64 NRD=0.000326934 NRS=0.000326934 SA=0 SB=0 SD=0 MULT=1
Rpar_s1_XNormalTransistorPmos5_g s1r_XNormalTransistorPmos5_g ibias 7750.85
Rpar_s1_XNormalTransistorPmos5_s s1r_XNormalTransistorPmos5_s sourcePmos 43.013
Rpar_s1_XNormalTransistorPmos5_d s1r_XNormalTransistorPmos5_d out 48.4709
XNormalTransistorPmos6 s1r_XNormalTransistorPmos6_d s1r_XNormalTransistorPmos6_g s1r_XNormalTransistorPmos6_s FirstStageYsourceTransconductance sky130_fd_pr__pfet_01v8_lvt L=0.89 W=14.21 NF=1 AD=4.1209 AS=4.1209 PD=29 PS=29 NRD=0.0204082 NRS=0.0204082 SA=0 SB=0 SD=0 MULT=1
Rpar_s1_XNormalTransistorPmos6_g s1r_XNormalTransistorPmos6_g in2 37.8978
Rpar_s1_XNormalTransistorPmos6_s s1r_XNormalTransistorPmos6_s FirstStageYsourceTransconductance 3.29814
Rpar_s1_XNormalTransistorPmos6_d s1r_XNormalTransistorPmos6_d outFirstStage 191.294
XNormalTransistorPmos7 s1r_XNormalTransistorPmos7_d s1r_XNormalTransistorPmos7_g s1r_XNormalTransistorPmos7_s FirstStageYsourceTransconductance sky130_fd_pr__pfet_01v8_lvt L=0.89 W=14.21 NF=1 AD=4.1209 AS=4.1209 PD=29 PS=29 NRD=0.0204082 NRS=0.0204082 SA=0 SB=0 SD=0 MULT=1
Rpar_s1_XNormalTransistorPmos7_g s1r_XNormalTransistorPmos7_g in1 37.8978
Rpar_s1_XNormalTransistorPmos7_s s1r_XNormalTransistorPmos7_s FirstStageYsourceTransconductance 3.29814
Rpar_s1_XNormalTransistorPmos7_d s1r_XNormalTransistorPmos7_d FirstStageYout1 191.294
XNormalTransistorPmos8 s1r_XNormalTransistorPmos8_d s1r_XNormalTransistorPmos8_g s1r_XNormalTransistorPmos8_s sourcePmos sky130_fd_pr__pfet_01v8_lvt L=0.74 W=90.63 NF=1 AD=26.2827 AS=26.2827 PD=181.84 PS=181.84 NRD=0.00319982 NRS=0.00319982 SA=0 SB=0 SD=0 MULT=1
Rpar_s1_XNormalTransistorPmos8_s s1r_XNormalTransistorPmos8_s sourcePmos 90.4411
Rpar_s1_XNormalTransistorPmos8_d s1r_XNormalTransistorPmos8_d FirstStageYsourceTransconductance 90.4411
Rpar_s1_XNormalTransistorPmos8_g s1r_XNormalTransistorPmos8_g ibias 3105.63
Ibias ibias sourceNmos 1e-05
Capacitor2 outFirstStage out 5e-13
.ends loadbench_miller
.end
