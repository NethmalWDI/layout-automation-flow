* NGSPICE file created from w_metal3_plane_50.ext - technology: sky130A

C0 A P 7.05668f
C1 A VSUBS 2.91742f
C2 P VSUBS 8.46632f
