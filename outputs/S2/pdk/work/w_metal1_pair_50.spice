* NGSPICE file created from w_metal1_pair_50.ext - technology: sky130A

C0 A B 2.82051f
C1 B VSUBS 2.31337f
C2 A VSUBS 2.31337f
