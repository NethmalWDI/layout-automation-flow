* NGSPICE file created from w_locali_pair_100.ext - technology: sky130A

C0 A B 4.1129f
C1 B VSUBS 5.03682f
C2 A VSUBS 5.03682f
