* NGSPICE file created from w_metal4_plane_100.ext - technology: sky130A

C0 A P 14.0626f
C1 A VSUBS 5.83629f
C2 P VSUBS 14.4103f
