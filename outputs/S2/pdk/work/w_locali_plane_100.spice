* NGSPICE file created from w_locali_plane_100.ext - technology: sky130A

C0 P A 10.2719f
C1 A VSUBS 3.08531f
C2 P VSUBS 57.9836f
