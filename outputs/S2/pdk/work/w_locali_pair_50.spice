* NGSPICE file created from w_locali_pair_50.ext - technology: sky130A

C0 B A 2.05645f
C1 B VSUBS 2.52533f
C2 A VSUBS 2.52533f
