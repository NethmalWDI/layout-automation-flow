* NGSPICE file created from w_metal2_pair_100.ext - technology: sky130A

C0 B A 5.68182f
C1 B VSUBS 4.14926f
C2 A VSUBS 4.14926f
