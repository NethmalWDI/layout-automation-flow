* NGSPICE file created from w_metal1_plane_50.ext - technology: sky130A

C0 P A 5.94727f
C1 A VSUBS 1.99446f
C2 P VSUBS 13.0021f
