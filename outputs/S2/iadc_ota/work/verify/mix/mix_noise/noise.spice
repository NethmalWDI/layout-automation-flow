* iadc_ota on dido_amp_NOISE
.lib $PDK_ROOT/sky130A/libs.tech/combined/sky130.lib.spice tt
.param VDD_V=1.8 VCM_V=0.9 CL_F=0.3p
.temp 27

**.subckt dido_amp_NOISE
x1 INP INN OUTN VDD 0 OUTP dut_amp
Vsup VDD 0 'VDD_V'
* AC drive through 1 F couplers; DC set by unity feedback through 1 GH chokes (OUTP->INN, OUTN->INP)
Vacp ACP 0 dc 0 ac 1
Vacn ACN 0 dc 0 ac 0
Cinp ACP INP 1
Cinn ACN INN 1
Lfbp OUTP INN 1G
Lfbn OUTN INP 1G
Cloadp OUTP 0 'CL_F'
Cloadn OUTN 0 'CL_F'
.control
  save all
  let npd    = 20
  let fstart = 1
  let fspot  = 1e3
  noise v(OUTP,OUTN) Vacp dec 20 1 1e9
  setplot noise1
  let idx = npd * log10(fspot/fstart)
  let vnoise_nv_rthz = inoise_spectrum[$&idx] * 1e9
  echo MEAS vnoise_nv_rthz $&vnoise_nv_rthz
  write
  set appendwrite
  setplot noise2
  let vnoise_rms_uv_rms = inoise_total * 1e6
  echo MEAS vnoise_rms_uv_rms $&vnoise_rms_uv_rms
  write
  quit 0
.endc
**.ends

.subckt dut_amp INP INN OUTN VDD VSS OUTP
XDUT INP INN OUTP OUTN VDD VSS cmc_w cm_w bias_a_w iadc_ota
* ideal CMFB: the steady-state law of the upstream switched-capacitor CMFB (ASSUMPTION)
Bcmfb cmc_w VSS V = v(bias_a_w) + (v(OUTP) + v(OUTN))/2 - v(cm_w)
.ends

.subckt iadc_ota ip in op on VDD VSS cmc cm bias_a
Cbud_s2_0 bias_d VSS 186.508f
Cbud_s2_1 cm VSS 190.729f
Cbud_s2_2 i_bias VSS 71.8249f
Cbud_s2_3 on VSS 1.29781f
Cbud_s2_4 op VSS 1.29781f
Cbud_s2_5 x1_m25d VSS 38.3405f
Cbud_s2_6 x1_m2d VSS 134.243f
Cbud_s2_7 x1_m31d VSS 30.9419f
Cbud_s2_8 x1_net1 VSS 7.73815f
Cbud_s2_9 x1_net10 VSS 7.73815f
Cbud_s2_10 x1_net13 VSS 7.73815f
Cbud_s2_11 x1_net7 VSS 7.73815f
Cbud_s2_12 x2_foldn VSS 1.06079f
Cbud_s2_13 x2_foldp VSS 1.06079f
Cbud_s2_14 x2_m3d VSS 6.75332f
Cbud_s2_15 x2_m4d VSS 6.70789f
Cbud_s2_16 x2_tail VSS 246.349f
Cbud_s2_17 bias_a bias_d 31.0356f
Cbud_s2_18 bias_a on 0.215961f
Cbud_s2_19 bias_a op 0.215961f
Cbud_s2_20 bias_a x1_m25d 6.38002f
Cbud_s2_21 bias_a x1_m2d 22.3385f
Cbud_s2_22 bias_a x1_m5d 11.952f
Cbud_s2_23 bias_a x2_foldn 0.239116f
Cbud_s2_24 bias_a x2_foldp 0.235835f
Cbud_s2_25 bias_a x2_m3d 6.77241f
Cbud_s2_26 bias_a x2_m4d 6.68909f
Cbud_s2_27 bias_a ip 1.17686f
Cbud_s2_28 bias_a in 1.17686f
Cbud_s2_29 bias_b bias_c 31.96f
Cbud_s2_30 bias_b bias_d 31.0356f
Cbud_s2_31 bias_b on 0.215961f
Cbud_s2_32 bias_b op 0.215961f
Cbud_s2_33 bias_b x1_m25d 6.38002f
Cbud_s2_34 bias_b x1_m2d 22.3385f
Cbud_s2_35 bias_b x1_m31d 5.14886f
Cbud_s2_36 bias_b x2_foldn 0.236733f
Cbud_s2_37 bias_b x2_foldp 0.2382f
Cbud_s2_38 bias_b x2_m3d 6.75285f
Cbud_s2_39 bias_b x2_m4d 6.70828f
Cbud_s2_40 bias_b x2_tail 40.2841f
Cbud_s2_41 bias_b ip 1.17686f
Cbud_s2_42 bias_c bias_d 31.0356f
Cbud_s2_43 bias_c on 0.215961f
Cbud_s2_44 bias_c op 0.215961f
Cbud_s2_45 bias_c x1_m25d 6.38002f
Cbud_s2_46 bias_c x1_m2d 22.3385f
Cbud_s2_47 bias_c x2_foldn 0.236684f
Cbud_s2_48 bias_c x2_foldp 0.238243f
Cbud_s2_49 bias_c x2_m3d 6.75322f
Cbud_s2_50 bias_c x2_m4d 6.70792f
Cbud_s2_51 bias_c x2_tail 31.96f
Cbud_s2_52 bias_c ip 1.17686f
Cbud_s2_53 bias_d cm 17.1763f
Cbud_s2_54 bias_d i_bias 11.952f
Cbud_s2_55 bias_d on 0.215961f
Cbud_s2_56 bias_d op 0.215961f
Cbud_s2_57 bias_d x1_m21d 6.38002f
Cbud_s2_58 bias_d x1_m25d 6.38002f
Cbud_s2_59 bias_d x1_m2d 22.3385f
Cbud_s2_60 bias_d x1_m31d 5.14886f
Cbud_s2_61 bias_d x1_m5d 11.952f
Cbud_s2_62 bias_d x1_net1 0.823592f
Cbud_s2_63 bias_d x1_net10 0.823592f
Cbud_s2_64 bias_d x1_net11 0.823592f
Cbud_s2_65 bias_d x1_net12 0.823592f
Cbud_s2_66 bias_d x1_net13 0.823592f
Cbud_s2_67 bias_d x1_net14 0.823592f
Cbud_s2_68 bias_d x1_net15 0.823592f
Cbud_s2_69 bias_d x1_net2 0.823592f
Cbud_s2_70 bias_d x1_net3 0.823592f
Cbud_s2_71 bias_d x1_net4 0.823592f
Cbud_s2_72 bias_d x1_net5 0.823592f
Cbud_s2_73 bias_d x1_net6 0.823592f
Cbud_s2_74 bias_d x1_net7 0.823592f
Cbud_s2_75 bias_d x1_net8 0.823592f
Cbud_s2_76 bias_d x1_net9 0.823592f
Cbud_s2_77 bias_d x2_foldn 0.233391f
Cbud_s2_78 bias_d x2_foldp 0.241696f
Cbud_s2_79 bias_d x2_m3d 6.70849f
Cbud_s2_80 bias_d x2_m4d 6.75267f
Cbud_s2_81 bias_d x2_tail 31.0356f
Cbud_s2_82 bias_d ip 1.17686f
Cbud_s2_83 bias_d in 1.17686f
Cbud_s2_84 cm i_bias 11.952f
Cbud_s2_85 cm on 0.215961f
Cbud_s2_86 cm op 0.215961f
Cbud_s2_87 cm x1_m25d 6.38002f
Cbud_s2_88 cm x1_m2d 17.1763f
Cbud_s2_89 cm x1_m31d 5.14886f
Cbud_s2_90 cm x1_net10 2.58509f
Cbud_s2_91 cm x1_net11 1.97519f
Cbud_s2_92 cm x1_net12 1.97519f
Cbud_s2_93 cm x1_net14 1.97519f
Cbud_s2_94 cm x1_net15 1.97519f
Cbud_s2_95 cm x1_net2 1.97519f
Cbud_s2_96 cm x1_net3 1.97519f
Cbud_s2_97 cm x1_net5 1.97519f
Cbud_s2_98 cm x1_net6 1.97519f
Cbud_s2_99 cm x1_net7 2.58509f
Cbud_s2_100 cm x1_net8 1.97519f
Cbud_s2_101 cm x1_net9 1.97519f
Cbud_s2_102 cm x2_foldn 0.237518f
Cbud_s2_103 cm x2_foldp 0.237523f
Cbud_s2_104 cm x2_m3d 6.75332f
Cbud_s2_105 cm x2_m4d 6.70787f
Cbud_s2_106 cm x2_tail 17.1763f
Cbud_s2_107 cm ip 1.17686f
Cbud_s2_108 i_bias on 0.153546f
Cbud_s2_109 i_bias op 0.153546f
Cbud_s2_110 i_bias x1_m25d 6.38002f
Cbud_s2_111 i_bias x1_m2d 11.952f
Cbud_s2_112 i_bias x1_net1 0.823592f
Cbud_s2_113 i_bias x1_net10 0.823592f
Cbud_s2_114 i_bias x1_net11 0.823592f
Cbud_s2_115 i_bias x1_net12 0.823592f
Cbud_s2_116 i_bias x1_net13 0.823592f
Cbud_s2_117 i_bias x1_net14 0.823592f
Cbud_s2_118 i_bias x1_net15 0.823592f
Cbud_s2_119 i_bias x1_net2 0.823592f
Cbud_s2_120 i_bias x1_net3 0.823592f
Cbud_s2_121 i_bias x1_net4 0.823592f
Cbud_s2_122 i_bias x1_net5 0.823592f
Cbud_s2_123 i_bias x1_net6 0.823592f
Cbud_s2_124 i_bias x1_net7 0.823592f
Cbud_s2_125 i_bias x1_net8 0.823592f
Cbud_s2_126 i_bias x1_net9 0.823592f
Cbud_s2_127 i_bias x2_foldn 0.238152f
Cbud_s2_128 i_bias x2_foldp 0.236794f
Cbud_s2_129 i_bias x2_m3d 6.75458f
Cbud_s2_130 i_bias x2_m4d 6.70674f
Cbud_s2_131 i_bias ip 1.17686f
Cbud_s2_132 i_bias in 1.17686f
Cbud_s2_133 on op 0.215961f
Cbud_s2_134 on x1_m21d 0.0819638f
Cbud_s2_135 on x1_m25d 0.0819638f
Cbud_s2_136 on x1_m2d 0.215961f
Cbud_s2_137 on x1_m31d 0.0661471f
Cbud_s2_138 on x1_m5d 0.153546f
Cbud_s2_139 on x1_net1 0.028682f
Cbud_s2_140 on x1_net10 0.028682f
Cbud_s2_141 on x1_net11 0.0286807f
Cbud_s2_142 on x1_net12 0.0286783f
Cbud_s2_143 on x1_net13 0.028682f
Cbud_s2_144 on x1_net14 0.0286807f
Cbud_s2_145 on x1_net15 0.0286783f
Cbud_s2_146 on x1_net2 0.0286807f
Cbud_s2_147 on x1_net3 0.0286783f
Cbud_s2_148 on x1_net4 0.028682f
Cbud_s2_149 on x1_net5 0.0286807f
Cbud_s2_150 on x1_net6 0.0286783f
Cbud_s2_151 on x1_net7 0.028682f
Cbud_s2_152 on x1_net8 0.0286807f
Cbud_s2_153 on x1_net9 0.0286783f
Cbud_s2_154 on x2_foldn 0.176519f
Cbud_s2_155 on x2_foldp 0.176519f
Cbud_s2_156 on x2_m3d 0.262614f
Cbud_s2_157 on x2_m4d 0.185044f
Cbud_s2_158 on x2_tail 0.215961f
Cbud_s2_159 on ip 0.0360386f
Cbud_s2_160 on in 0.0233734f
Cbud_s2_161 op x1_m21d 0.0819638f
Cbud_s2_162 op x1_m25d 0.0819638f
Cbud_s2_163 op x1_m2d 0.215961f
Cbud_s2_164 op x1_m31d 0.0661471f
Cbud_s2_165 op x1_m5d 0.153546f
Cbud_s2_166 op x1_net1 0.0286745f
Cbud_s2_167 op x1_net10 0.0286745f
Cbud_s2_168 op x1_net11 0.0286732f
Cbud_s2_169 op x1_net12 0.0286709f
Cbud_s2_170 op x1_net13 0.0286745f
Cbud_s2_171 op x1_net14 0.0286732f
Cbud_s2_172 op x1_net15 0.0286709f
Cbud_s2_173 op x1_net2 0.0286732f
Cbud_s2_174 op x1_net3 0.0286709f
Cbud_s2_175 op x1_net4 0.0286745f
Cbud_s2_176 op x1_net5 0.0286732f
Cbud_s2_177 op x1_net6 0.0286709f
Cbud_s2_178 op x1_net7 0.0286745f
Cbud_s2_179 op x1_net8 0.0286732f
Cbud_s2_180 op x1_net9 0.0286709f
Cbud_s2_181 op x2_foldn 0.176519f
Cbud_s2_182 op x2_foldp 0.176519f
Cbud_s2_183 op x2_m3d 0.189555f
Cbud_s2_184 op x2_m4d 0.266672f
Cbud_s2_185 op x2_tail 0.215961f
Cbud_s2_186 op ip 0.0233665f
Cbud_s2_187 op in 0.0360313f
Cbud_s2_188 x1_m21d x1_m25d 6.38002f
Cbud_s2_189 x1_m21d x1_m2d 6.38002f
Cbud_s2_190 x1_m21d x2_foldn 0.237021f
Cbud_s2_191 x1_m21d x2_foldp 0.237925f
Cbud_s2_192 x1_m21d x2_m3d 6.38002f
Cbud_s2_193 x1_m21d x2_m4d 6.38002f
Cbud_s2_194 x1_m21d x2_tail 6.38002f
Cbud_s2_195 x1_m21d ip 1.17686f
Cbud_s2_196 x1_m21d in 1.17686f
Cbud_s2_197 x1_m25d x1_m2d 6.38002f
Cbud_s2_198 x1_m25d x1_m31d 5.14886f
Cbud_s2_199 x1_m25d x1_net1 0.823592f
Cbud_s2_200 x1_m25d x1_net10 0.823592f
Cbud_s2_201 x1_m25d x1_net11 0.823592f
Cbud_s2_202 x1_m25d x1_net12 0.823592f
Cbud_s2_203 x1_m25d x1_net13 0.823592f
Cbud_s2_204 x1_m25d x1_net14 0.823592f
Cbud_s2_205 x1_m25d x1_net15 0.823592f
Cbud_s2_206 x1_m25d x1_net2 0.823592f
Cbud_s2_207 x1_m25d x1_net3 0.823592f
Cbud_s2_208 x1_m25d x1_net4 0.823592f
Cbud_s2_209 x1_m25d x1_net5 0.823592f
Cbud_s2_210 x1_m25d x1_net6 0.823592f
Cbud_s2_211 x1_m25d x1_net7 0.823592f
Cbud_s2_212 x1_m25d x1_net8 0.823592f
Cbud_s2_213 x1_m25d x1_net9 0.823592f
Cbud_s2_214 x1_m25d x2_foldn 0.23662f
Cbud_s2_215 x1_m25d x2_foldp 0.238335f
Cbud_s2_216 x1_m25d x2_m3d 6.38002f
Cbud_s2_217 x1_m25d x2_m4d 6.38002f
Cbud_s2_218 x1_m25d x2_tail 6.38002f
Cbud_s2_219 x1_m25d ip 1.17686f
Cbud_s2_220 x1_m25d in 1.17686f
Cbud_s2_221 x1_m2d x1_m31d 5.14886f
Cbud_s2_222 x1_m2d x1_m5d 11.952f
Cbud_s2_223 x1_m2d x1_net1 0.823592f
Cbud_s2_224 x1_m2d x1_net10 0.823592f
Cbud_s2_225 x1_m2d x1_net11 0.823592f
Cbud_s2_226 x1_m2d x1_net12 0.823592f
Cbud_s2_227 x1_m2d x1_net13 0.823592f
Cbud_s2_228 x1_m2d x1_net14 0.823592f
Cbud_s2_229 x1_m2d x1_net15 0.823592f
Cbud_s2_230 x1_m2d x1_net2 0.823592f
Cbud_s2_231 x1_m2d x1_net3 0.823592f
Cbud_s2_232 x1_m2d x1_net4 0.823592f
Cbud_s2_233 x1_m2d x1_net5 0.823592f
Cbud_s2_234 x1_m2d x1_net6 0.823592f
Cbud_s2_235 x1_m2d x1_net7 0.823592f
Cbud_s2_236 x1_m2d x1_net8 0.823592f
Cbud_s2_237 x1_m2d x1_net9 0.823592f
Cbud_s2_238 x1_m2d x2_foldn 0.235221f
Cbud_s2_239 x1_m2d x2_foldp 0.239779f
Cbud_s2_240 x1_m2d x2_m3d 6.73184f
Cbud_s2_241 x1_m2d x2_m4d 6.72915f
Cbud_s2_242 x1_m2d x2_tail 22.3385f
Cbud_s2_243 x1_m2d ip 1.17686f
Cbud_s2_244 x1_m2d in 1.17686f
Cbud_s2_245 x1_m31d x1_net1 0.823592f
Cbud_s2_246 x1_m31d x1_net10 0.823592f
Cbud_s2_247 x1_m31d x1_net11 0.823592f
Cbud_s2_248 x1_m31d x1_net12 0.823592f
Cbud_s2_249 x1_m31d x1_net13 0.823592f
Cbud_s2_250 x1_m31d x1_net14 0.823592f
Cbud_s2_251 x1_m31d x1_net15 0.823592f
Cbud_s2_252 x1_m31d x1_net2 0.823592f
Cbud_s2_253 x1_m31d x1_net3 0.823592f
Cbud_s2_254 x1_m31d x1_net4 0.823592f
Cbud_s2_255 x1_m31d x1_net5 0.823592f
Cbud_s2_256 x1_m31d x1_net6 0.823592f
Cbud_s2_257 x1_m31d x1_net7 0.823592f
Cbud_s2_258 x1_m31d x1_net8 0.823592f
Cbud_s2_259 x1_m31d x1_net9 0.823592f
Cbud_s2_260 x1_m31d x2_foldn 0.237468f
Cbud_s2_261 x1_m31d x2_foldp 0.237467f
Cbud_s2_262 x1_m31d x2_m3d 5.14886f
Cbud_s2_263 x1_m31d x2_m4d 5.14886f
Cbud_s2_264 x1_m31d x2_tail 5.14886f
Cbud_s2_265 x1_m31d ip 1.17686f
Cbud_s2_266 x1_m31d in 1.17686f
Cbud_s2_267 x1_m5d x2_foldn 0.234689f
Cbud_s2_268 x1_m5d x2_foldp 0.240312f
Cbud_s2_269 x1_m5d x2_m3d 6.76648f
Cbud_s2_270 x1_m5d x2_m4d 6.69495f
Cbud_s2_271 x1_m5d ip 1.17686f
Cbud_s2_272 x1_net1 x1_net11 0.823592f
Cbud_s2_273 x1_net1 x1_net3 0.823592f
Cbud_s2_274 x1_net1 x1_net4 0.823592f
Cbud_s2_275 x1_net1 x1_net5 0.823592f
Cbud_s2_276 x1_net1 x1_net7 0.823592f
Cbud_s2_277 x1_net1 x2_foldn 0.237614f
Cbud_s2_278 x1_net1 x2_foldp 0.237618f
Cbud_s2_279 x1_net1 x2_m3d 0.823592f
Cbud_s2_280 x1_net1 x2_m4d 0.823592f
Cbud_s2_281 x1_net1 x2_tail 0.823592f
Cbud_s2_282 x1_net1 ip 0.823592f
Cbud_s2_283 x1_net10 x1_net12 0.823592f
Cbud_s2_284 x1_net10 x1_net4 0.823592f
Cbud_s2_285 x1_net10 x1_net6 0.823592f
Cbud_s2_286 x1_net10 x1_net7 0.823592f
Cbud_s2_287 x1_net10 x1_net8 0.823592f
Cbud_s2_288 x1_net10 x1_net9 0.823592f
Cbud_s2_289 x1_net10 x2_foldn 0.237614f
Cbud_s2_290 x1_net10 x2_foldp 0.237618f
Cbud_s2_291 x1_net10 x2_m3d 0.823592f
Cbud_s2_292 x1_net10 x2_m4d 0.823592f
Cbud_s2_293 x1_net10 x2_tail 0.823592f
Cbud_s2_294 x1_net10 ip 0.823592f
Cbud_s2_295 x1_net11 x1_net15 0.823592f
Cbud_s2_296 x1_net11 x1_net3 0.823592f
Cbud_s2_297 x1_net11 x1_net6 0.823592f
Cbud_s2_298 x1_net11 x1_net8 0.823592f
Cbud_s2_299 x1_net11 x1_net9 0.823592f
Cbud_s2_300 x1_net11 x2_foldn 0.237567f
Cbud_s2_301 x1_net11 x2_foldp 0.23757f
Cbud_s2_302 x1_net11 x2_m3d 0.823592f
Cbud_s2_303 x1_net11 x2_m4d 0.823592f
Cbud_s2_304 x1_net11 x2_tail 0.823592f
Cbud_s2_305 x1_net11 ip 0.823592f
Cbud_s2_306 x1_net12 x1_net14 0.823592f
Cbud_s2_307 x1_net12 x1_net2 0.823592f
Cbud_s2_308 x1_net12 x1_net5 0.823592f
Cbud_s2_309 x1_net12 x1_net6 0.823592f
Cbud_s2_310 x1_net12 x1_net9 0.823592f
Cbud_s2_311 x1_net12 x2_foldn 0.23749f
Cbud_s2_312 x1_net12 x2_foldp 0.237493f
Cbud_s2_313 x1_net12 x2_m3d 0.823592f
Cbud_s2_314 x1_net12 x2_m4d 0.823592f
Cbud_s2_315 x1_net12 x2_tail 0.823592f
Cbud_s2_316 x1_net12 ip 0.823592f
Cbud_s2_317 x1_net13 x1_net15 0.823592f
Cbud_s2_318 x1_net13 x1_net5 0.823592f
Cbud_s2_319 x1_net13 x2_foldn 0.237614f
Cbud_s2_320 x1_net13 x2_foldp 0.237618f
Cbud_s2_321 x1_net13 x2_m3d 0.823592f
Cbud_s2_322 x1_net13 x2_m4d 0.823592f
Cbud_s2_323 x1_net13 x2_tail 0.823592f
Cbud_s2_324 x1_net13 ip 0.823592f
Cbud_s2_325 x1_net14 x1_net3 0.823592f
Cbud_s2_326 x1_net14 x1_net6 0.823592f
Cbud_s2_327 x1_net14 x1_net7 0.823592f
Cbud_s2_328 x1_net14 x1_net9 0.823592f
Cbud_s2_329 x1_net14 x2_foldn 0.237567f
Cbud_s2_330 x1_net14 x2_foldp 0.23757f
Cbud_s2_331 x1_net14 x2_m3d 0.823592f
Cbud_s2_332 x1_net14 x2_m4d 0.823592f
Cbud_s2_333 x1_net14 x2_tail 0.823592f
Cbud_s2_334 x1_net14 ip 0.823592f
Cbud_s2_335 x1_net15 x1_net2 0.823592f
Cbud_s2_336 x1_net15 x1_net5 0.823592f
Cbud_s2_337 x1_net15 x1_net6 0.823592f
Cbud_s2_338 x1_net15 x1_net9 0.823592f
Cbud_s2_339 x1_net15 x2_foldn 0.23749f
Cbud_s2_340 x1_net15 x2_foldp 0.237493f
Cbud_s2_341 x1_net15 x2_m3d 0.823592f
Cbud_s2_342 x1_net15 x2_m4d 0.823592f
Cbud_s2_343 x1_net15 x2_tail 0.823592f
Cbud_s2_344 x1_net15 ip 0.823592f
Cbud_s2_345 x1_net2 x1_net6 0.823592f
Cbud_s2_346 x1_net2 x1_net7 0.823592f
Cbud_s2_347 x1_net2 x1_net9 0.823592f
Cbud_s2_348 x1_net2 x2_foldn 0.237567f
Cbud_s2_349 x1_net2 x2_foldp 0.23757f
Cbud_s2_350 x1_net2 x2_m3d 0.823592f
Cbud_s2_351 x1_net2 x2_m4d 0.823592f
Cbud_s2_352 x1_net2 x2_tail 0.823592f
Cbud_s2_353 x1_net2 ip 0.823592f
Cbud_s2_354 x1_net3 x1_net5 0.823592f
Cbud_s2_355 x1_net3 x1_net6 0.823592f
Cbud_s2_356 x1_net3 x1_net9 0.823592f
Cbud_s2_357 x1_net3 x2_foldn 0.23749f
Cbud_s2_358 x1_net3 x2_foldp 0.237493f
Cbud_s2_359 x1_net3 x2_m3d 0.823592f
Cbud_s2_360 x1_net3 x2_m4d 0.823592f
Cbud_s2_361 x1_net3 x2_tail 0.823592f
Cbud_s2_362 x1_net3 ip 0.823592f
Cbud_s2_363 x1_net4 x1_net8 0.823592f
Cbud_s2_364 x1_net4 x2_foldn 0.237614f
Cbud_s2_365 x1_net4 x2_foldp 0.237618f
Cbud_s2_366 x1_net4 x2_m3d 0.823592f
Cbud_s2_367 x1_net4 x2_m4d 0.823592f
Cbud_s2_368 x1_net4 x2_tail 0.823592f
Cbud_s2_369 x1_net4 ip 0.823592f
Cbud_s2_370 x1_net5 x1_net8 0.823592f
Cbud_s2_371 x1_net5 x2_foldn 0.237567f
Cbud_s2_372 x1_net5 x2_foldp 0.23757f
Cbud_s2_373 x1_net5 x2_m3d 0.823592f
Cbud_s2_374 x1_net5 x2_m4d 0.823592f
Cbud_s2_375 x1_net5 x2_tail 0.823592f
Cbud_s2_376 x1_net5 ip 0.823592f
Cbud_s2_377 x1_net6 x2_foldn 0.23749f
Cbud_s2_378 x1_net6 x2_foldp 0.237493f
Cbud_s2_379 x1_net6 x2_m3d 0.823592f
Cbud_s2_380 x1_net6 x2_m4d 0.823592f
Cbud_s2_381 x1_net6 x2_tail 0.823592f
Cbud_s2_382 x1_net6 ip 0.823592f
Cbud_s2_383 x1_net7 x1_net9 0.823592f
Cbud_s2_384 x1_net7 x2_foldn 0.237614f
Cbud_s2_385 x1_net7 x2_foldp 0.237618f
Cbud_s2_386 x1_net7 x2_m3d 0.823592f
Cbud_s2_387 x1_net7 x2_m4d 0.823592f
Cbud_s2_388 x1_net7 x2_tail 0.823592f
Cbud_s2_389 x1_net7 ip 0.823592f
Cbud_s2_390 x1_net8 x2_foldn 0.237567f
Cbud_s2_391 x1_net8 x2_foldp 0.23757f
Cbud_s2_392 x1_net8 x2_m3d 0.823592f
Cbud_s2_393 x1_net8 x2_m4d 0.823592f
Cbud_s2_394 x1_net8 x2_tail 0.823592f
Cbud_s2_395 x1_net8 ip 0.823592f
Cbud_s2_396 x1_net9 x2_foldn 0.23749f
Cbud_s2_397 x1_net9 x2_foldp 0.237493f
Cbud_s2_398 x1_net9 x2_m3d 0.823592f
Cbud_s2_399 x1_net9 x2_m4d 0.823592f
Cbud_s2_400 x1_net9 x2_tail 0.823592f
Cbud_s2_401 x1_net9 ip 0.823592f
Cbud_s2_402 x2_foldn x2_foldp 0.176519f
Cbud_s2_403 x2_foldn x2_m3d 0.176519f
Cbud_s2_404 x2_foldn x2_tail 0.237586f
Cbud_s2_405 x2_foldn ip 0.266242f
Cbud_s2_406 x2_foldn in 0.214287f
Cbud_s2_407 x2_foldp x2_m4d 0.176519f
Cbud_s2_408 x2_foldp x2_tail 0.237326f
Cbud_s2_409 x2_foldp ip 0.214275f
Cbud_s2_410 x2_foldp in 0.266264f
Cbud_s2_411 x2_m3d x2_m4d 1.68263f
Cbud_s2_412 x2_m3d x2_tail 6.75401f
Cbud_s2_413 x2_m3d ip 0.227588f
Cbud_s2_414 x2_m4d x2_tail 6.70722f
Cbud_s2_415 x2_m4d in 0.235703f
Cbud_s2_416 x2_tail in 1.17686f
XX1_M22 s1r_XX1_M22_d bias_c s1r_XX1_M22_s VDD sky130_fd_pr__pfet_01v8 L=0.6 W=1.4 NF=1 AD=0.406 AS=0.406 PD=3.38 PS=3.38 NRD=0.207143 NRS=0.207143 SA=0 SB=0 SD=0 MULT=6 M=6
Rpar_s1_XX1_M22_s s1r_XX1_M22_s x1_m21d 81.7913
Rpar_s1_XX1_M22_d s1r_XX1_M22_d bias_b 163.538
XX1_M26 s1r_XX1_M26_d bias_c s1r_XX1_M26_s VDD sky130_fd_pr__pfet_01v8 L=0.6 W=1.4 NF=1 AD=0.406 AS=0.406 PD=3.38 PS=3.38 NRD=0.207143 NRS=0.207143 SA=0 SB=0 SD=0 MULT=6 M=6
Rpar_s1_XX1_M26_s s1r_XX1_M26_s x1_m25d 1031.45
Rpar_s1_XX1_M26_d s1r_XX1_M26_d x1_m2d 1031.45
XX1_M32 s1r_XX1_M32_d bias_c s1r_XX1_M32_s VDD sky130_fd_pr__pfet_01v8 L=0.6 W=1.4 NF=1 AD=0.406 AS=0.406 PD=3.38 PS=3.38 NRD=0.207143 NRS=0.207143 SA=0 SB=0 SD=0 MULT=6 M=6
Rpar_s1_XX1_M32_s s1r_XX1_M32_s x1_m31d 544.378
Rpar_s1_XX1_M32_d s1r_XX1_M32_d cm 1547.54
XX1_M21 s1r_XX1_M21_d bias_b s1r_XX1_M21_s VDD sky130_fd_pr__pfet_01v8_lvt L=0.6 W=1.4 NF=1 AD=0.406 AS=0.406 PD=3.38 PS=3.38 NRD=0.207143 NRS=0.207143 SA=0 SB=0 SD=0 MULT=6 M=6
Rpar_s1_XX1_M21_s s1r_XX1_M21_s VDD 81.7913
Rpar_s1_XX1_M21_d s1r_XX1_M21_d x1_m21d 81.7913
XX1_M25 s1r_XX1_M25_d bias_b s1r_XX1_M25_s VDD sky130_fd_pr__pfet_01v8_lvt L=0.6 W=1.4 NF=1 AD=0.406 AS=0.406 PD=3.38 PS=3.38 NRD=0.207143 NRS=0.207143 SA=0 SB=0 SD=0 MULT=6 M=6
Rpar_s1_XX1_M25_s s1r_XX1_M25_s VDD 1031.45
Rpar_s1_XX1_M25_d s1r_XX1_M25_d x1_m25d 1031.45
XX1_M31 s1r_XX1_M31_d bias_b s1r_XX1_M31_s VDD sky130_fd_pr__pfet_01v8_lvt L=0.6 W=1.4 NF=1 AD=0.406 AS=0.406 PD=3.38 PS=3.38 NRD=0.207143 NRS=0.207143 SA=0 SB=0 SD=0 MULT=6 M=6
Rpar_s1_XX1_M31_s s1r_XX1_M31_s VDD 1031.45
Rpar_s1_XX1_M31_d s1r_XX1_M31_d x1_m31d 544.378
XX1_M1 s1r_XX1_M1_d bias_b s1r_XX1_M1_s VSS sky130_fd_pr__nfet_01v8_lvt L=0.6 W=1.4 NF=1 AD=0.406 AS=0.406 PD=3.38 PS=3.38 NRD=0.207143 NRS=0.207143 SA=0 SB=0 SD=0 MULT=56 M=56
Rpar_s1_XX1_M1_s s1r_XX1_M1_s bias_c 733.127
Rpar_s1_XX1_M1_d s1r_XX1_M1_d bias_b 919.334
XX1_M2 s1r_XX1_M2_d x1_m2d s1r_XX1_M2_s VSS sky130_fd_pr__nfet_01v8 L=0.6 W=1.4 NF=1 AD=0.406 AS=0.406 PD=3.38 PS=3.38 NRD=0.207143 NRS=0.207143 SA=0 SB=0 SD=0 MULT=50 M=50
Rpar_s1_XX1_M2_s s1r_XX1_M2_s bias_d 54.6101
Rpar_s1_XX1_M2_d s1r_XX1_M2_d x1_m2d 452.301
XX1_M3 s1r_XX1_M3_d x1_m2d s1r_XX1_M3_s VSS sky130_fd_pr__nfet_01v8 L=0.6 W=1.4 NF=1 AD=0.406 AS=0.406 PD=3.38 PS=3.38 NRD=0.207143 NRS=0.207143 SA=0 SB=0 SD=0 MULT=2 M=2
Rpar_s1_XX1_M3_s s1r_XX1_M3_s bias_a 333.045
Rpar_s1_XX1_M3_d s1r_XX1_M3_d bias_d 32.9279
XX1_M4 s1r_XX1_M4_d bias_d s1r_XX1_M4_s VSS sky130_fd_pr__nfet_01v8 L=0.6 W=1.4 NF=1 AD=0.406 AS=0.406 PD=3.38 PS=3.38 NRD=0.207143 NRS=0.207143 SA=0 SB=0 SD=0 MULT=18 M=18
Rpar_s1_XX1_M4_s s1r_XX1_M4_s x1_m5d 8.70438
Rpar_s1_XX1_M4_d s1r_XX1_M4_d bias_a 677.545
XX1_M5 s1r_XX1_M5_d bias_a s1r_XX1_M5_s VSS sky130_fd_pr__nfet_01v8 L=0.6 W=1.4 NF=1 AD=0.406 AS=0.406 PD=3.38 PS=3.38 NRD=0.207143 NRS=0.207143 SA=0 SB=0 SD=0 MULT=18 M=18
Rpar_s1_XX1_M5_s s1r_XX1_M5_s VSS 8.70438
Rpar_s1_XX1_M5_d s1r_XX1_M5_d x1_m5d 8.70438
XX1_M6 s1r_XX1_M6_d i_bias s1r_XX1_M6_s VSS sky130_fd_pr__nfet_01v8 L=0.6 W=1.4 NF=1 AD=0.406 AS=0.406 PD=3.38 PS=3.38 NRD=0.207143 NRS=0.207143 SA=0 SB=0 SD=0 MULT=18 M=18
Rpar_s1_XX1_M6_s s1r_XX1_M6_s VSS 35.8098
Rpar_s1_XX1_M6_d s1r_XX1_M6_d bias_c 36.3212
XX1_M7 s1r_XX1_M7_d i_bias s1r_XX1_M7_s VSS sky130_fd_pr__nfet_01v8 L=0.6 W=1.4 NF=1 AD=0.406 AS=0.406 PD=3.38 PS=3.38 NRD=0.207143 NRS=0.207143 SA=0 SB=0 SD=0 MULT=18 M=18
Rpar_s1_XX1_M7_s s1r_XX1_M7_s VSS 35.8098
Rpar_s1_XX1_M7_d s1r_XX1_M7_d i_bias 36.3212
XX1_M33 s1r_XX1_M33_d cm s1r_XX1_M33_s VSS sky130_fd_pr__nfet_01v8 L=0.6 W=1.4 NF=1 AD=0.406 AS=0.406 PD=3.38 PS=3.38 NRD=0.207143 NRS=0.207143 SA=0 SB=0 SD=0 MULT=1 M=1
Rpar_s1_XX1_M33_s s1r_XX1_M33_s x1_net1 192.678
Rpar_s1_XX1_M33_d s1r_XX1_M33_d cm 514.358
XX1_M49 s1r_XX1_M49_d cm s1r_XX1_M49_s VSS sky130_fd_pr__nfet_01v8 L=0.6 W=1.4 NF=1 AD=0.406 AS=0.406 PD=3.38 PS=3.38 NRD=0.207143 NRS=0.207143 SA=0 SB=0 SD=0 MULT=1 M=1
Rpar_s1_XX1_M49_s s1r_XX1_M49_s x1_net2 89.2897
Rpar_s1_XX1_M49_d s1r_XX1_M49_d x1_net1 192.678
XX1_M50 s1r_XX1_M50_d cm s1r_XX1_M50_s VSS sky130_fd_pr__nfet_01v8 L=0.6 W=1.4 NF=1 AD=0.406 AS=0.406 PD=3.38 PS=3.38 NRD=0.207143 NRS=0.207143 SA=0 SB=0 SD=0 MULT=1 M=1
Rpar_s1_XX1_M50_s s1r_XX1_M50_s x1_net3 93.8687
Rpar_s1_XX1_M50_d s1r_XX1_M50_d x1_net2 89.2897
XX1_M63 s1r_XX1_M63_d cm s1r_XX1_M63_s VSS sky130_fd_pr__nfet_01v8 L=0.6 W=1.4 NF=1 AD=0.406 AS=0.406 PD=3.38 PS=3.38 NRD=0.207143 NRS=0.207143 SA=0 SB=0 SD=0 MULT=1 M=1
Rpar_s1_XX1_M63_s s1r_XX1_M63_s VSS 59.0464
Rpar_s1_XX1_M63_d s1r_XX1_M63_d x1_net3 93.8687
XX1_M68 s1r_XX1_M68_d cm s1r_XX1_M68_s VSS sky130_fd_pr__nfet_01v8 L=0.6 W=1.4 NF=1 AD=0.406 AS=0.406 PD=3.38 PS=3.38 NRD=0.207143 NRS=0.207143 SA=0 SB=0 SD=0 MULT=1 M=1
Rpar_s1_XX1_M68_s s1r_XX1_M68_s x1_net4 192.678
Rpar_s1_XX1_M68_d s1r_XX1_M68_d cm 514.358
XX1_M69 s1r_XX1_M69_d cm s1r_XX1_M69_s VSS sky130_fd_pr__nfet_01v8 L=0.6 W=1.4 NF=1 AD=0.406 AS=0.406 PD=3.38 PS=3.38 NRD=0.207143 NRS=0.207143 SA=0 SB=0 SD=0 MULT=1 M=1
Rpar_s1_XX1_M69_s s1r_XX1_M69_s x1_net5 89.2897
Rpar_s1_XX1_M69_d s1r_XX1_M69_d x1_net4 192.678
XX1_M70 s1r_XX1_M70_d cm s1r_XX1_M70_s VSS sky130_fd_pr__nfet_01v8 L=0.6 W=1.4 NF=1 AD=0.406 AS=0.406 PD=3.38 PS=3.38 NRD=0.207143 NRS=0.207143 SA=0 SB=0 SD=0 MULT=1 M=1
Rpar_s1_XX1_M70_s s1r_XX1_M70_s x1_net6 93.8687
Rpar_s1_XX1_M70_d s1r_XX1_M70_d x1_net5 89.2897
XX1_M71 s1r_XX1_M71_d cm s1r_XX1_M71_s VSS sky130_fd_pr__nfet_01v8 L=0.6 W=1.4 NF=1 AD=0.406 AS=0.406 PD=3.38 PS=3.38 NRD=0.207143 NRS=0.207143 SA=0 SB=0 SD=0 MULT=1 M=1
Rpar_s1_XX1_M71_s s1r_XX1_M71_s VSS 59.0464
Rpar_s1_XX1_M71_d s1r_XX1_M71_d x1_net6 93.8687
XX1_M72 s1r_XX1_M72_d cm s1r_XX1_M72_s VSS sky130_fd_pr__nfet_01v8 L=0.6 W=1.4 NF=1 AD=0.406 AS=0.406 PD=3.38 PS=3.38 NRD=0.207143 NRS=0.207143 SA=0 SB=0 SD=0 MULT=1 M=1
Rpar_s1_XX1_M72_s s1r_XX1_M72_s x1_net7 192.678
Rpar_s1_XX1_M72_d s1r_XX1_M72_d cm 514.358
XX1_M73 s1r_XX1_M73_d cm s1r_XX1_M73_s VSS sky130_fd_pr__nfet_01v8 L=0.6 W=1.4 NF=1 AD=0.406 AS=0.406 PD=3.38 PS=3.38 NRD=0.207143 NRS=0.207143 SA=0 SB=0 SD=0 MULT=1 M=1
Rpar_s1_XX1_M73_s s1r_XX1_M73_s x1_net8 89.2897
Rpar_s1_XX1_M73_d s1r_XX1_M73_d x1_net7 192.678
XX1_M74 s1r_XX1_M74_d cm s1r_XX1_M74_s VSS sky130_fd_pr__nfet_01v8 L=0.6 W=1.4 NF=1 AD=0.406 AS=0.406 PD=3.38 PS=3.38 NRD=0.207143 NRS=0.207143 SA=0 SB=0 SD=0 MULT=1 M=1
Rpar_s1_XX1_M74_s s1r_XX1_M74_s x1_net9 93.8687
Rpar_s1_XX1_M74_d s1r_XX1_M74_d x1_net8 89.2897
XX1_M75 s1r_XX1_M75_d cm s1r_XX1_M75_s VSS sky130_fd_pr__nfet_01v8 L=0.6 W=1.4 NF=1 AD=0.406 AS=0.406 PD=3.38 PS=3.38 NRD=0.207143 NRS=0.207143 SA=0 SB=0 SD=0 MULT=1 M=1
Rpar_s1_XX1_M75_s s1r_XX1_M75_s VSS 59.0464
Rpar_s1_XX1_M75_d s1r_XX1_M75_d x1_net9 93.8687
XX1_M76 s1r_XX1_M76_d cm s1r_XX1_M76_s VSS sky130_fd_pr__nfet_01v8 L=0.6 W=1.4 NF=1 AD=0.406 AS=0.406 PD=3.38 PS=3.38 NRD=0.207143 NRS=0.207143 SA=0 SB=0 SD=0 MULT=1 M=1
Rpar_s1_XX1_M76_s s1r_XX1_M76_s x1_net10 192.678
Rpar_s1_XX1_M76_d s1r_XX1_M76_d cm 514.358
XX1_M77 s1r_XX1_M77_d cm s1r_XX1_M77_s VSS sky130_fd_pr__nfet_01v8 L=0.6 W=1.4 NF=1 AD=0.406 AS=0.406 PD=3.38 PS=3.38 NRD=0.207143 NRS=0.207143 SA=0 SB=0 SD=0 MULT=1 M=1
Rpar_s1_XX1_M77_s s1r_XX1_M77_s x1_net11 89.2897
Rpar_s1_XX1_M77_d s1r_XX1_M77_d x1_net10 192.678
XX1_M78 s1r_XX1_M78_d cm s1r_XX1_M78_s VSS sky130_fd_pr__nfet_01v8 L=0.6 W=1.4 NF=1 AD=0.406 AS=0.406 PD=3.38 PS=3.38 NRD=0.207143 NRS=0.207143 SA=0 SB=0 SD=0 MULT=1 M=1
Rpar_s1_XX1_M78_s s1r_XX1_M78_s x1_net12 93.8687
Rpar_s1_XX1_M78_d s1r_XX1_M78_d x1_net11 89.2897
XX1_M79 s1r_XX1_M79_d cm s1r_XX1_M79_s VSS sky130_fd_pr__nfet_01v8 L=0.6 W=1.4 NF=1 AD=0.406 AS=0.406 PD=3.38 PS=3.38 NRD=0.207143 NRS=0.207143 SA=0 SB=0 SD=0 MULT=1 M=1
Rpar_s1_XX1_M79_s s1r_XX1_M79_s VSS 59.0464
Rpar_s1_XX1_M79_d s1r_XX1_M79_d x1_net12 93.8687
XX1_M64 s1r_XX1_M64_d cm s1r_XX1_M64_s VSS sky130_fd_pr__nfet_01v8 L=0.6 W=1.4 NF=1 AD=0.406 AS=0.406 PD=3.38 PS=3.38 NRD=0.207143 NRS=0.207143 SA=0 SB=0 SD=0 MULT=1 M=1
Rpar_s1_XX1_M64_s s1r_XX1_M64_s x1_net13 192.678
Rpar_s1_XX1_M64_d s1r_XX1_M64_d cm 514.358
XX1_M65 s1r_XX1_M65_d cm s1r_XX1_M65_s VSS sky130_fd_pr__nfet_01v8 L=0.6 W=1.4 NF=1 AD=0.406 AS=0.406 PD=3.38 PS=3.38 NRD=0.207143 NRS=0.207143 SA=0 SB=0 SD=0 MULT=1 M=1
Rpar_s1_XX1_M65_s s1r_XX1_M65_s x1_net14 89.2897
Rpar_s1_XX1_M65_d s1r_XX1_M65_d x1_net13 192.678
XX1_M66 s1r_XX1_M66_d cm s1r_XX1_M66_s VSS sky130_fd_pr__nfet_01v8 L=0.6 W=1.4 NF=1 AD=0.406 AS=0.406 PD=3.38 PS=3.38 NRD=0.207143 NRS=0.207143 SA=0 SB=0 SD=0 MULT=1 M=1
Rpar_s1_XX1_M66_s s1r_XX1_M66_s x1_net15 93.8687
Rpar_s1_XX1_M66_d s1r_XX1_M66_d x1_net14 89.2897
XX1_M67 s1r_XX1_M67_d cm s1r_XX1_M67_s VSS sky130_fd_pr__nfet_01v8 L=0.6 W=1.4 NF=1 AD=0.406 AS=0.406 PD=3.38 PS=3.38 NRD=0.207143 NRS=0.207143 SA=0 SB=0 SD=0 MULT=1 M=1
Rpar_s1_XX1_M67_s s1r_XX1_M67_s VSS 59.0464
Rpar_s1_XX1_M67_d s1r_XX1_M67_d x1_net15 93.8687
XX1_M57 bias_b VDD VDD VDD sky130_fd_pr__pfet_01v8 L=0.6 W=1.4 NF=1 AD=0.406 AS=0.406 PD=3.38 PS=3.38 NRD=0.207143 NRS=0.207143 SA=0 SB=0 SD=0 MULT=2 M=2
XX1_M58 x1_m2d VDD VDD VDD sky130_fd_pr__pfet_01v8 L=0.6 W=1.4 NF=1 AD=0.406 AS=0.406 PD=3.38 PS=3.38 NRD=0.207143 NRS=0.207143 SA=0 SB=0 SD=0 MULT=2 M=2
XX1_M59 cm VDD VDD VDD sky130_fd_pr__pfet_01v8 L=0.6 W=1.4 NF=1 AD=0.406 AS=0.406 PD=3.38 PS=3.38 NRD=0.207143 NRS=0.207143 SA=0 SB=0 SD=0 MULT=2 M=2
XX1_M60 x1_m31d VDD VDD VDD sky130_fd_pr__pfet_01v8 L=0.6 W=1.4 NF=1 AD=0.406 AS=0.406 PD=3.38 PS=3.38 NRD=0.207143 NRS=0.207143 SA=0 SB=0 SD=0 MULT=2 M=2
XX1_M42 x1_m5d VSS VSS VSS sky130_fd_pr__nfet_01v8 L=0.6 W=1.4 NF=1 AD=0.406 AS=0.406 PD=3.38 PS=3.38 NRD=0.207143 NRS=0.207143 SA=0 SB=0 SD=0 MULT=6 M=6
XX1_M44 bias_c bias_c bias_c VSS sky130_fd_pr__nfet_01v8 L=0.6 W=1.4 NF=1 AD=0.406 AS=0.406 PD=3.38 PS=3.38 NRD=0.207143 NRS=0.207143 SA=0 SB=0 SD=0 MULT=2 M=2
XX1_M34 bias_d bias_d bias_d VSS sky130_fd_pr__nfet_01v8 L=0.6 W=1.4 NF=1 AD=0.406 AS=0.406 PD=3.38 PS=3.38 NRD=0.207143 NRS=0.207143 SA=0 SB=0 SD=0 MULT=8 M=8
XX1_M35 x1_m2d x1_m2d x1_m2d VSS sky130_fd_pr__nfet_01v8 L=0.6 W=1.4 NF=1 AD=0.406 AS=0.406 PD=3.38 PS=3.38 NRD=0.207143 NRS=0.207143 SA=0 SB=0 SD=0 MULT=2 M=2
XX1_M36 bias_a bias_a bias_a VSS sky130_fd_pr__nfet_01v8 L=0.6 W=1.4 NF=1 AD=0.406 AS=0.406 PD=3.38 PS=3.38 NRD=0.207143 NRS=0.207143 SA=0 SB=0 SD=0 MULT=4 M=4
XX1_M37 cm cm cm VSS sky130_fd_pr__nfet_01v8 L=0.6 W=1.4 NF=1 AD=0.406 AS=0.406 PD=3.38 PS=3.38 NRD=0.207143 NRS=0.207143 SA=0 SB=0 SD=0 MULT=8 M=8
XX1_M54 x1_m25d x1_m25d x1_m25d VDD sky130_fd_pr__pfet_01v8 L=0.6 W=1.4 NF=1 AD=0.406 AS=0.406 PD=3.38 PS=3.38 NRD=0.207143 NRS=0.207143 SA=0 SB=0 SD=0 MULT=2 M=2
XX1_M29 x1_m5d x1_m5d x1_m5d VSS sky130_fd_pr__nfet_01v8 L=0.6 W=1.4 NF=1 AD=0.406 AS=0.406 PD=3.38 PS=3.38 NRD=0.207143 NRS=0.207143 SA=0 SB=0 SD=0 MULT=6 M=6
XX1_M8 i_bias i_bias i_bias VSS sky130_fd_pr__nfet_01v8 L=0.6 W=1.4 NF=1 AD=0.406 AS=0.406 PD=3.38 PS=3.38 NRD=0.207143 NRS=0.207143 SA=0 SB=0 SD=0 MULT=2 M=2
XX1_M10 bias_c bias_c bias_c VSS sky130_fd_pr__nfet_01v8_lvt L=0.6 W=1.4 NF=1 AD=0.406 AS=0.406 PD=3.38 PS=3.38 NRD=0.207143 NRS=0.207143 SA=0 SB=0 SD=0 MULT=8 M=8
XX1_M27 bias_b bias_b bias_b VSS sky130_fd_pr__nfet_01v8_lvt L=0.6 W=1.4 NF=1 AD=0.406 AS=0.406 PD=3.38 PS=3.38 NRD=0.207143 NRS=0.207143 SA=0 SB=0 SD=0 MULT=8 M=8
XX1_M46 x1_m21d x1_m21d x1_m21d VDD sky130_fd_pr__pfet_01v8_lvt L=0.6 W=1.4 NF=1 AD=0.406 AS=0.406 PD=3.38 PS=3.38 NRD=0.207143 NRS=0.207143 SA=0 SB=0 SD=0 MULT=2 M=2
XX1_M47 x1_m25d x1_m25d x1_m25d VDD sky130_fd_pr__pfet_01v8_lvt L=0.6 W=1.4 NF=1 AD=0.406 AS=0.406 PD=3.38 PS=3.38 NRD=0.207143 NRS=0.207143 SA=0 SB=0 SD=0 MULT=2 M=2
XX1_M48 x1_m31d x1_m31d x1_m31d VDD sky130_fd_pr__pfet_01v8_lvt L=0.6 W=1.4 NF=1 AD=0.406 AS=0.406 PD=3.38 PS=3.38 NRD=0.207143 NRS=0.207143 SA=0 SB=0 SD=0 MULT=2 M=2
XX1_M51 x1_m21d x1_m21d x1_m21d VDD sky130_fd_pr__pfet_01v8 L=0.6 W=1.4 NF=1 AD=0.406 AS=0.406 PD=3.38 PS=3.38 NRD=0.207143 NRS=0.207143 SA=0 SB=0 SD=0 MULT=2 M=2
XX2_M1 s1r_XX2_M1_d s1r_XX2_M1_g s1r_XX2_M1_s VSS sky130_fd_pr__nfet_01v8_lvt L=0.2 W=1.2 NF=1 AD=0.348 AS=0.348 PD=2.98 PS=2.98 NRD=0.241667 NRS=0.241667 SA=0 SB=0 SD=0 MULT=6 M=6
Rpar_s1_XX2_M1_s s1r_XX2_M1_s x2_tail 6.89893
Rpar_s1_XX2_M1_g s1r_XX2_M1_g ip 27.7274
Rpar_s1_XX2_M1_d s1r_XX2_M1_d x2_foldp 6.89893
XX2_M2 s1r_XX2_M2_d s1r_XX2_M2_g s1r_XX2_M2_s VSS sky130_fd_pr__nfet_01v8_lvt L=0.2 W=1.2 NF=1 AD=0.348 AS=0.348 PD=2.98 PS=2.98 NRD=0.241667 NRS=0.241667 SA=0 SB=0 SD=0 MULT=6 M=6
Rpar_s1_XX2_M2_s s1r_XX2_M2_s x2_tail 6.89893
Rpar_s1_XX2_M2_g s1r_XX2_M2_g in 27.7274
Rpar_s1_XX2_M2_d s1r_XX2_M2_d x2_foldn 6.89893
XX2_M6 s1r_XX2_M6_d cmc s1r_XX2_M6_s VSS sky130_fd_pr__nfet_01v8 L=0.6 W=1.4 NF=1 AD=0.406 AS=0.406 PD=3.38 PS=3.38 NRD=0.207143 NRS=0.207143 SA=0 SB=0 SD=0 MULT=96 M=96
Rpar_s1_XX2_M6_s s1r_XX2_M6_s VSS 19.8434
Rpar_s1_XX2_M6_d s1r_XX2_M6_d x2_tail 23.9195
XX2_M5 s1r_XX2_M5_d bias_a s1r_XX2_M5_s VSS sky130_fd_pr__nfet_01v8 L=0.6 W=1.4 NF=1 AD=0.406 AS=0.406 PD=3.38 PS=3.38 NRD=0.207143 NRS=0.207143 SA=0 SB=0 SD=0 MULT=96 M=96
Rpar_s1_XX2_M5_s s1r_XX2_M5_s VSS 19.8434
Rpar_s1_XX2_M5_d s1r_XX2_M5_d x2_tail 22.7773
XX2_M11 s1r_XX2_M11_d s1r_XX2_M11_g s1r_XX2_M11_s VDD sky130_fd_pr__pfet_01v8_lvt L=0.6 W=1.4 NF=1 AD=0.406 AS=0.406 PD=3.38 PS=3.38 NRD=0.207143 NRS=0.207143 SA=0 SB=0 SD=0 MULT=24 M=24
Rpar_s1_XX2_M11_s s1r_XX2_M11_s VDD 22.5447
Rpar_s1_XX2_M11_g s1r_XX2_M11_g bias_b 24.3976
Rpar_s1_XX2_M11_d s1r_XX2_M11_d x2_foldp 22.5447
XX2_M12 s1r_XX2_M12_d s1r_XX2_M12_g s1r_XX2_M12_s VDD sky130_fd_pr__pfet_01v8_lvt L=0.6 W=1.4 NF=1 AD=0.406 AS=0.406 PD=3.38 PS=3.38 NRD=0.207143 NRS=0.207143 SA=0 SB=0 SD=0 MULT=24 M=24
Rpar_s1_XX2_M12_s s1r_XX2_M12_s VDD 22.5447
Rpar_s1_XX2_M12_g s1r_XX2_M12_g bias_b 24.3976
Rpar_s1_XX2_M12_d s1r_XX2_M12_d x2_foldn 22.5447
XX2_M1A s1r_XX2_M1A_d s1r_XX2_M1A_g s1r_XX2_M1A_s VDD sky130_fd_pr__pfet_01v8 L=0.6 W=1.4 NF=1 AD=0.406 AS=0.406 PD=3.38 PS=3.38 NRD=0.207143 NRS=0.207143 SA=0 SB=0 SD=0 MULT=20 M=20
Rpar_s1_XX2_M1A_s s1r_XX2_M1A_s x2_foldp 21.9528
Rpar_s1_XX2_M1A_g s1r_XX2_M1A_g bias_c 25.0554
Rpar_s1_XX2_M1A_d s1r_XX2_M1A_d on 21.9528
XX2_M8 s1r_XX2_M8_d s1r_XX2_M8_g s1r_XX2_M8_s VDD sky130_fd_pr__pfet_01v8 L=0.6 W=1.4 NF=1 AD=0.406 AS=0.406 PD=3.38 PS=3.38 NRD=0.207143 NRS=0.207143 SA=0 SB=0 SD=0 MULT=20 M=20
Rpar_s1_XX2_M8_s s1r_XX2_M8_s x2_foldn 21.9528
Rpar_s1_XX2_M8_g s1r_XX2_M8_g bias_c 25.0554
Rpar_s1_XX2_M8_d s1r_XX2_M8_d op 21.9528
XX2_M3A s1r_XX2_M3A_d s1r_XX2_M3A_g s1r_XX2_M3A_s VSS sky130_fd_pr__nfet_01v8 L=0.6 W=1.4 NF=1 AD=0.406 AS=0.406 PD=3.38 PS=3.38 NRD=0.207143 NRS=0.207143 SA=0 SB=0 SD=0 MULT=36 M=36
Rpar_s1_XX2_M3A_s s1r_XX2_M3A_s x2_m3d 46.385
Rpar_s1_XX2_M3A_g s1r_XX2_M3A_g bias_d 34.1822
Rpar_s1_XX2_M3A_d s1r_XX2_M3A_d on 50.0776
XX2_M7 s1r_XX2_M7_d s1r_XX2_M7_g s1r_XX2_M7_s VSS sky130_fd_pr__nfet_01v8 L=0.6 W=1.4 NF=1 AD=0.406 AS=0.406 PD=3.38 PS=3.38 NRD=0.207143 NRS=0.207143 SA=0 SB=0 SD=0 MULT=36 M=36
Rpar_s1_XX2_M7_s s1r_XX2_M7_s x2_m4d 46.385
Rpar_s1_XX2_M7_g s1r_XX2_M7_g bias_d 34.1766
Rpar_s1_XX2_M7_d s1r_XX2_M7_d op 50.0775
XX2_M3 s1r_XX2_M3_d s1r_XX2_M3_g s1r_XX2_M3_s VSS sky130_fd_pr__nfet_01v8 L=0.6 W=1.4 NF=1 AD=0.406 AS=0.406 PD=3.38 PS=3.38 NRD=0.207143 NRS=0.207143 SA=0 SB=0 SD=0 MULT=36 M=36
Rpar_s1_XX2_M3_s s1r_XX2_M3_s VSS 584.949
Rpar_s1_XX2_M3_g s1r_XX2_M3_g bias_a 96.1627
Rpar_s1_XX2_M3_d s1r_XX2_M3_d x2_m3d 46.385
XX2_M4 s1r_XX2_M4_d s1r_XX2_M4_g s1r_XX2_M4_s VSS sky130_fd_pr__nfet_01v8 L=0.6 W=1.4 NF=1 AD=0.406 AS=0.406 PD=3.38 PS=3.38 NRD=0.207143 NRS=0.207143 SA=0 SB=0 SD=0 MULT=36 M=36
Rpar_s1_XX2_M4_s s1r_XX2_M4_s VSS 584.949
Rpar_s1_XX2_M4_g s1r_XX2_M4_g bias_a 96.1627
Rpar_s1_XX2_M4_d s1r_XX2_M4_d x2_m4d 46.385
XX2_M82 x2_foldn x2_foldn x2_foldn VDD sky130_fd_pr__pfet_01v8 L=0.6 W=1.4 NF=1 AD=0.406 AS=0.406 PD=3.38 PS=3.38 NRD=0.207143 NRS=0.207143 SA=0 SB=0 SD=0 MULT=2 M=2
XX2_M83 x2_foldp x2_foldp x2_foldp VDD sky130_fd_pr__pfet_01v8 L=0.6 W=1.4 NF=1 AD=0.406 AS=0.406 PD=3.38 PS=3.38 NRD=0.207143 NRS=0.207143 SA=0 SB=0 SD=0 MULT=2 M=2
XX2_M55 x2_foldn VDD VDD VDD sky130_fd_pr__pfet_01v8 L=0.6 W=1.4 NF=1 AD=0.406 AS=0.406 PD=3.38 PS=3.38 NRD=0.207143 NRS=0.207143 SA=0 SB=0 SD=0 MULT=2 M=2
XX2_M56 op VDD VDD VDD sky130_fd_pr__pfet_01v8 L=0.6 W=1.4 NF=1 AD=0.406 AS=0.406 PD=3.38 PS=3.38 NRD=0.207143 NRS=0.207143 SA=0 SB=0 SD=0 MULT=4 M=4
XX2_M61 x2_foldp VDD VDD VDD sky130_fd_pr__pfet_01v8 L=0.6 W=1.4 NF=1 AD=0.406 AS=0.406 PD=3.38 PS=3.38 NRD=0.207143 NRS=0.207143 SA=0 SB=0 SD=0 MULT=2 M=2
XX2_M62 on VDD VDD VDD sky130_fd_pr__pfet_01v8 L=0.6 W=1.4 NF=1 AD=0.406 AS=0.406 PD=3.38 PS=3.38 NRD=0.207143 NRS=0.207143 SA=0 SB=0 SD=0 MULT=4 M=4
XX2_M40 x2_m4d VSS VSS VSS sky130_fd_pr__nfet_01v8 L=0.6 W=1.4 NF=1 AD=0.406 AS=0.406 PD=3.38 PS=3.38 NRD=0.207143 NRS=0.207143 SA=0 SB=0 SD=0 MULT=6 M=6
XX2_M41 x2_m3d VSS VSS VSS sky130_fd_pr__nfet_01v8 L=0.6 W=1.4 NF=1 AD=0.406 AS=0.406 PD=3.38 PS=3.38 NRD=0.207143 NRS=0.207143 SA=0 SB=0 SD=0 MULT=8 M=8
XX2_M38 op op op VSS sky130_fd_pr__nfet_01v8 L=0.6 W=1.4 NF=1 AD=0.406 AS=0.406 PD=3.38 PS=3.38 NRD=0.207143 NRS=0.207143 SA=0 SB=0 SD=0 MULT=2 M=2
XX2_M39 on on on VSS sky130_fd_pr__nfet_01v8 L=0.6 W=1.4 NF=1 AD=0.406 AS=0.406 PD=3.38 PS=3.38 NRD=0.207143 NRS=0.207143 SA=0 SB=0 SD=0 MULT=2 M=2
XX2_M30 x2_tail VSS VSS VSS sky130_fd_pr__nfet_01v8 L=0.6 W=1.4 NF=1 AD=0.406 AS=0.406 PD=3.38 PS=3.38 NRD=0.207143 NRS=0.207143 SA=0 SB=0 SD=0 MULT=2 M=2
XX2_M23 x2_foldp x2_foldp x2_foldp VSS sky130_fd_pr__nfet_01v8_lvt L=0.2 W=1.2 NF=1 AD=0.348 AS=0.348 PD=2.98 PS=2.98 NRD=0.241667 NRS=0.241667 SA=0 SB=0 SD=0 MULT=2 M=2
XX2_M24 x2_foldn x2_foldn x2_foldn VSS sky130_fd_pr__nfet_01v8_lvt L=0.2 W=1.2 NF=1 AD=0.348 AS=0.348 PD=2.98 PS=2.98 NRD=0.241667 NRS=0.241667 SA=0 SB=0 SD=0 MULT=2 M=2
XX2_M80 op VSS VSS VSS sky130_fd_pr__nfet_01v8 L=0.6 W=1.4 NF=1 AD=0.406 AS=0.406 PD=3.38 PS=3.38 NRD=0.207143 NRS=0.207143 SA=0 SB=0 SD=0 MULT=2 M=2
XX2_M81 on VSS VSS VSS sky130_fd_pr__nfet_01v8 L=0.6 W=1.4 NF=1 AD=0.406 AS=0.406 PD=3.38 PS=3.38 NRD=0.207143 NRS=0.207143 SA=0 SB=0 SD=0 MULT=2 M=2
XX2_M28 x2_tail x2_tail x2_tail VSS sky130_fd_pr__nfet_01v8 L=0.6 W=1.4 NF=1 AD=0.406 AS=0.406 PD=3.38 PS=3.38 NRD=0.207143 NRS=0.207143 SA=0 SB=0 SD=0 MULT=6 M=6
XM43 VDD VDD VDD VDD sky130_fd_pr__pfet_01v8_lvt L=0.6 W=1.4 NF=1 AD=0.406 AS=0.406 PD=3.38 PS=3.38 NRD=0.207143 NRS=0.207143 SA=0 SB=0 SD=0 MULT=8 M=8
XM45 VDD VDD VDD VDD sky130_fd_pr__pfet_01v8 L=0.6 W=1.4 NF=1 AD=0.406 AS=0.406 PD=3.38 PS=3.38 NRD=0.207143 NRS=0.207143 SA=0 SB=0 SD=0 MULT=6 M=6
XM9 VSS VSS VSS VSS sky130_fd_pr__nfet_01v8 L=0.6 W=1.4 NF=1 AD=0.406 AS=0.406 PD=3.38 PS=3.38 NRD=0.207143 NRS=0.207143 SA=0 SB=0 SD=0 MULT=23 M=23
Ibias_ext VDD i_bias 3e-05
XC3 op cmc sky130_fd_pr__cap_mim_m3_1 W=4.8 L=4.8 MF=4 M=4
XC4 on cmc sky130_fd_pr__cap_mim_m3_1 W=4.8 L=4.8 MF=4 M=4
.ends iadc_ota
.end
