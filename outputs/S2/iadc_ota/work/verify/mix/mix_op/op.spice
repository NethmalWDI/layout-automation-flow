* iadc_ota on dido_amp_OP
.lib $PDK_ROOT/sky130A/libs.tech/combined/sky130.lib.spice tt
.param VDD_V=1.8 VCM_V=0.9 CL_F=0.3p
.temp 27

**.subckt dido_amp_OP
x1 INP INN OUTN VDD 0 OUTP dut_amp
Vsup VDD 0 'VDD_V'
* AC drive through 1 F couplers; DC set by unity feedback through 1 GH chokes (OUTP->INN, OUTN->INP)
Vacp ACP 0 dc 0 ac 0
Vacn ACN 0 dc 0 ac 0
Cinp ACP INP 1
Cinn ACN INN 1
Lfbp OUTP INN 1G
Lfbn OUTN INP 1G
Cloadp OUTP 0 'CL_F'
Cloadn OUTN 0 'CL_F'
.control
set numdgt=12
op
let s1_xx1_m22_id = @m.x1.xdut.xx1_m22.msky130_fd_pr__pfet_01v8[id]
echo OPV XX1_M22 id $&s1_xx1_m22_id
let s1_xx1_m22_vgs = @m.x1.xdut.xx1_m22.msky130_fd_pr__pfet_01v8[vgs]
echo OPV XX1_M22 vgs $&s1_xx1_m22_vgs
let s1_xx1_m22_vds = @m.x1.xdut.xx1_m22.msky130_fd_pr__pfet_01v8[vds]
echo OPV XX1_M22 vds $&s1_xx1_m22_vds
let s1_xx1_m22_vbs = @m.x1.xdut.xx1_m22.msky130_fd_pr__pfet_01v8[vbs]
echo OPV XX1_M22 vbs $&s1_xx1_m22_vbs
let s1_xx1_m22_vth = @m.x1.xdut.xx1_m22.msky130_fd_pr__pfet_01v8[vth]
echo OPV XX1_M22 vth $&s1_xx1_m22_vth
let s1_xx1_m22_vdsat = @m.x1.xdut.xx1_m22.msky130_fd_pr__pfet_01v8[vdsat]
echo OPV XX1_M22 vdsat $&s1_xx1_m22_vdsat
let s1_xx1_m22_gm = @m.x1.xdut.xx1_m22.msky130_fd_pr__pfet_01v8[gm]
echo OPV XX1_M22 gm $&s1_xx1_m22_gm
let s1_xx1_m22_gds = @m.x1.xdut.xx1_m22.msky130_fd_pr__pfet_01v8[gds]
echo OPV XX1_M22 gds $&s1_xx1_m22_gds
let s1_xx1_m22_gmbs = @m.x1.xdut.xx1_m22.msky130_fd_pr__pfet_01v8[gmbs]
echo OPV XX1_M22 gmbs $&s1_xx1_m22_gmbs
let s1_xx1_m22_cgg = @m.x1.xdut.xx1_m22.msky130_fd_pr__pfet_01v8[cgg]
echo OPV XX1_M22 cgg $&s1_xx1_m22_cgg
let s1_xx1_m22_cgd = @m.x1.xdut.xx1_m22.msky130_fd_pr__pfet_01v8[cgd]
echo OPV XX1_M22 cgd $&s1_xx1_m22_cgd
let s1_xx1_m22_cgs = @m.x1.xdut.xx1_m22.msky130_fd_pr__pfet_01v8[cgs]
echo OPV XX1_M22 cgs $&s1_xx1_m22_cgs
let s1_xx1_m22_cgb = @m.x1.xdut.xx1_m22.msky130_fd_pr__pfet_01v8[cgb]
echo OPV XX1_M22 cgb $&s1_xx1_m22_cgb
let s1_xx1_m22_cdg = @m.x1.xdut.xx1_m22.msky130_fd_pr__pfet_01v8[cdg]
echo OPV XX1_M22 cdg $&s1_xx1_m22_cdg
let s1_xx1_m22_cdd = @m.x1.xdut.xx1_m22.msky130_fd_pr__pfet_01v8[cdd]
echo OPV XX1_M22 cdd $&s1_xx1_m22_cdd
let s1_xx1_m22_cds = @m.x1.xdut.xx1_m22.msky130_fd_pr__pfet_01v8[cds]
echo OPV XX1_M22 cds $&s1_xx1_m22_cds
let s1_xx1_m22_cdb = @m.x1.xdut.xx1_m22.msky130_fd_pr__pfet_01v8[cdb]
echo OPV XX1_M22 cdb $&s1_xx1_m22_cdb
let s1_xx1_m22_csg = @m.x1.xdut.xx1_m22.msky130_fd_pr__pfet_01v8[csg]
echo OPV XX1_M22 csg $&s1_xx1_m22_csg
let s1_xx1_m22_csd = @m.x1.xdut.xx1_m22.msky130_fd_pr__pfet_01v8[csd]
echo OPV XX1_M22 csd $&s1_xx1_m22_csd
let s1_xx1_m22_css = @m.x1.xdut.xx1_m22.msky130_fd_pr__pfet_01v8[css]
echo OPV XX1_M22 css $&s1_xx1_m22_css
let s1_xx1_m22_csb = @m.x1.xdut.xx1_m22.msky130_fd_pr__pfet_01v8[csb]
echo OPV XX1_M22 csb $&s1_xx1_m22_csb
let s1_xx1_m22_cbg = @m.x1.xdut.xx1_m22.msky130_fd_pr__pfet_01v8[cbg]
echo OPV XX1_M22 cbg $&s1_xx1_m22_cbg
let s1_xx1_m22_cbd = @m.x1.xdut.xx1_m22.msky130_fd_pr__pfet_01v8[cbd]
echo OPV XX1_M22 cbd $&s1_xx1_m22_cbd
let s1_xx1_m22_cbs = @m.x1.xdut.xx1_m22.msky130_fd_pr__pfet_01v8[cbs]
echo OPV XX1_M22 cbs $&s1_xx1_m22_cbs
let s1_xx1_m22_cbb = @m.x1.xdut.xx1_m22.msky130_fd_pr__pfet_01v8[cbb]
echo OPV XX1_M22 cbb $&s1_xx1_m22_cbb
let s1_xx1_m22_capbd = @m.x1.xdut.xx1_m22.msky130_fd_pr__pfet_01v8[capbd]
echo OPV XX1_M22 capbd $&s1_xx1_m22_capbd
let s1_xx1_m22_capbs = @m.x1.xdut.xx1_m22.msky130_fd_pr__pfet_01v8[capbs]
echo OPV XX1_M22 capbs $&s1_xx1_m22_capbs
let s1_xx1_m22_cgso = @m.x1.xdut.xx1_m22.msky130_fd_pr__pfet_01v8[cgso]
echo OPV XX1_M22 cgso $&s1_xx1_m22_cgso
let s1_xx1_m22_cgdo = @m.x1.xdut.xx1_m22.msky130_fd_pr__pfet_01v8[cgdo]
echo OPV XX1_M22 cgdo $&s1_xx1_m22_cgdo
let s1_xx1_m22_cgbo = @m.x1.xdut.xx1_m22.msky130_fd_pr__pfet_01v8[cgbo]
echo OPV XX1_M22 cgbo $&s1_xx1_m22_cgbo
let s1_xx1_m22_weff = @m.x1.xdut.xx1_m22.msky130_fd_pr__pfet_01v8[weff]
echo OPV XX1_M22 weff $&s1_xx1_m22_weff
let s1_xx1_m22_leff = @m.x1.xdut.xx1_m22.msky130_fd_pr__pfet_01v8[leff]
echo OPV XX1_M22 leff $&s1_xx1_m22_leff
let s1_xx1_m26_id = @m.x1.xdut.xx1_m26.msky130_fd_pr__pfet_01v8[id]
echo OPV XX1_M26 id $&s1_xx1_m26_id
let s1_xx1_m26_vgs = @m.x1.xdut.xx1_m26.msky130_fd_pr__pfet_01v8[vgs]
echo OPV XX1_M26 vgs $&s1_xx1_m26_vgs
let s1_xx1_m26_vds = @m.x1.xdut.xx1_m26.msky130_fd_pr__pfet_01v8[vds]
echo OPV XX1_M26 vds $&s1_xx1_m26_vds
let s1_xx1_m26_vbs = @m.x1.xdut.xx1_m26.msky130_fd_pr__pfet_01v8[vbs]
echo OPV XX1_M26 vbs $&s1_xx1_m26_vbs
let s1_xx1_m26_vth = @m.x1.xdut.xx1_m26.msky130_fd_pr__pfet_01v8[vth]
echo OPV XX1_M26 vth $&s1_xx1_m26_vth
let s1_xx1_m26_vdsat = @m.x1.xdut.xx1_m26.msky130_fd_pr__pfet_01v8[vdsat]
echo OPV XX1_M26 vdsat $&s1_xx1_m26_vdsat
let s1_xx1_m26_gm = @m.x1.xdut.xx1_m26.msky130_fd_pr__pfet_01v8[gm]
echo OPV XX1_M26 gm $&s1_xx1_m26_gm
let s1_xx1_m26_gds = @m.x1.xdut.xx1_m26.msky130_fd_pr__pfet_01v8[gds]
echo OPV XX1_M26 gds $&s1_xx1_m26_gds
let s1_xx1_m26_gmbs = @m.x1.xdut.xx1_m26.msky130_fd_pr__pfet_01v8[gmbs]
echo OPV XX1_M26 gmbs $&s1_xx1_m26_gmbs
let s1_xx1_m26_cgg = @m.x1.xdut.xx1_m26.msky130_fd_pr__pfet_01v8[cgg]
echo OPV XX1_M26 cgg $&s1_xx1_m26_cgg
let s1_xx1_m26_cgd = @m.x1.xdut.xx1_m26.msky130_fd_pr__pfet_01v8[cgd]
echo OPV XX1_M26 cgd $&s1_xx1_m26_cgd
let s1_xx1_m26_cgs = @m.x1.xdut.xx1_m26.msky130_fd_pr__pfet_01v8[cgs]
echo OPV XX1_M26 cgs $&s1_xx1_m26_cgs
let s1_xx1_m26_cgb = @m.x1.xdut.xx1_m26.msky130_fd_pr__pfet_01v8[cgb]
echo OPV XX1_M26 cgb $&s1_xx1_m26_cgb
let s1_xx1_m26_cdg = @m.x1.xdut.xx1_m26.msky130_fd_pr__pfet_01v8[cdg]
echo OPV XX1_M26 cdg $&s1_xx1_m26_cdg
let s1_xx1_m26_cdd = @m.x1.xdut.xx1_m26.msky130_fd_pr__pfet_01v8[cdd]
echo OPV XX1_M26 cdd $&s1_xx1_m26_cdd
let s1_xx1_m26_cds = @m.x1.xdut.xx1_m26.msky130_fd_pr__pfet_01v8[cds]
echo OPV XX1_M26 cds $&s1_xx1_m26_cds
let s1_xx1_m26_cdb = @m.x1.xdut.xx1_m26.msky130_fd_pr__pfet_01v8[cdb]
echo OPV XX1_M26 cdb $&s1_xx1_m26_cdb
let s1_xx1_m26_csg = @m.x1.xdut.xx1_m26.msky130_fd_pr__pfet_01v8[csg]
echo OPV XX1_M26 csg $&s1_xx1_m26_csg
let s1_xx1_m26_csd = @m.x1.xdut.xx1_m26.msky130_fd_pr__pfet_01v8[csd]
echo OPV XX1_M26 csd $&s1_xx1_m26_csd
let s1_xx1_m26_css = @m.x1.xdut.xx1_m26.msky130_fd_pr__pfet_01v8[css]
echo OPV XX1_M26 css $&s1_xx1_m26_css
let s1_xx1_m26_csb = @m.x1.xdut.xx1_m26.msky130_fd_pr__pfet_01v8[csb]
echo OPV XX1_M26 csb $&s1_xx1_m26_csb
let s1_xx1_m26_cbg = @m.x1.xdut.xx1_m26.msky130_fd_pr__pfet_01v8[cbg]
echo OPV XX1_M26 cbg $&s1_xx1_m26_cbg
let s1_xx1_m26_cbd = @m.x1.xdut.xx1_m26.msky130_fd_pr__pfet_01v8[cbd]
echo OPV XX1_M26 cbd $&s1_xx1_m26_cbd
let s1_xx1_m26_cbs = @m.x1.xdut.xx1_m26.msky130_fd_pr__pfet_01v8[cbs]
echo OPV XX1_M26 cbs $&s1_xx1_m26_cbs
let s1_xx1_m26_cbb = @m.x1.xdut.xx1_m26.msky130_fd_pr__pfet_01v8[cbb]
echo OPV XX1_M26 cbb $&s1_xx1_m26_cbb
let s1_xx1_m26_capbd = @m.x1.xdut.xx1_m26.msky130_fd_pr__pfet_01v8[capbd]
echo OPV XX1_M26 capbd $&s1_xx1_m26_capbd
let s1_xx1_m26_capbs = @m.x1.xdut.xx1_m26.msky130_fd_pr__pfet_01v8[capbs]
echo OPV XX1_M26 capbs $&s1_xx1_m26_capbs
let s1_xx1_m26_cgso = @m.x1.xdut.xx1_m26.msky130_fd_pr__pfet_01v8[cgso]
echo OPV XX1_M26 cgso $&s1_xx1_m26_cgso
let s1_xx1_m26_cgdo = @m.x1.xdut.xx1_m26.msky130_fd_pr__pfet_01v8[cgdo]
echo OPV XX1_M26 cgdo $&s1_xx1_m26_cgdo
let s1_xx1_m26_cgbo = @m.x1.xdut.xx1_m26.msky130_fd_pr__pfet_01v8[cgbo]
echo OPV XX1_M26 cgbo $&s1_xx1_m26_cgbo
let s1_xx1_m26_weff = @m.x1.xdut.xx1_m26.msky130_fd_pr__pfet_01v8[weff]
echo OPV XX1_M26 weff $&s1_xx1_m26_weff
let s1_xx1_m26_leff = @m.x1.xdut.xx1_m26.msky130_fd_pr__pfet_01v8[leff]
echo OPV XX1_M26 leff $&s1_xx1_m26_leff
let s1_xx1_m32_id = @m.x1.xdut.xx1_m32.msky130_fd_pr__pfet_01v8[id]
echo OPV XX1_M32 id $&s1_xx1_m32_id
let s1_xx1_m32_vgs = @m.x1.xdut.xx1_m32.msky130_fd_pr__pfet_01v8[vgs]
echo OPV XX1_M32 vgs $&s1_xx1_m32_vgs
let s1_xx1_m32_vds = @m.x1.xdut.xx1_m32.msky130_fd_pr__pfet_01v8[vds]
echo OPV XX1_M32 vds $&s1_xx1_m32_vds
let s1_xx1_m32_vbs = @m.x1.xdut.xx1_m32.msky130_fd_pr__pfet_01v8[vbs]
echo OPV XX1_M32 vbs $&s1_xx1_m32_vbs
let s1_xx1_m32_vth = @m.x1.xdut.xx1_m32.msky130_fd_pr__pfet_01v8[vth]
echo OPV XX1_M32 vth $&s1_xx1_m32_vth
let s1_xx1_m32_vdsat = @m.x1.xdut.xx1_m32.msky130_fd_pr__pfet_01v8[vdsat]
echo OPV XX1_M32 vdsat $&s1_xx1_m32_vdsat
let s1_xx1_m32_gm = @m.x1.xdut.xx1_m32.msky130_fd_pr__pfet_01v8[gm]
echo OPV XX1_M32 gm $&s1_xx1_m32_gm
let s1_xx1_m32_gds = @m.x1.xdut.xx1_m32.msky130_fd_pr__pfet_01v8[gds]
echo OPV XX1_M32 gds $&s1_xx1_m32_gds
let s1_xx1_m32_gmbs = @m.x1.xdut.xx1_m32.msky130_fd_pr__pfet_01v8[gmbs]
echo OPV XX1_M32 gmbs $&s1_xx1_m32_gmbs
let s1_xx1_m32_cgg = @m.x1.xdut.xx1_m32.msky130_fd_pr__pfet_01v8[cgg]
echo OPV XX1_M32 cgg $&s1_xx1_m32_cgg
let s1_xx1_m32_cgd = @m.x1.xdut.xx1_m32.msky130_fd_pr__pfet_01v8[cgd]
echo OPV XX1_M32 cgd $&s1_xx1_m32_cgd
let s1_xx1_m32_cgs = @m.x1.xdut.xx1_m32.msky130_fd_pr__pfet_01v8[cgs]
echo OPV XX1_M32 cgs $&s1_xx1_m32_cgs
let s1_xx1_m32_cgb = @m.x1.xdut.xx1_m32.msky130_fd_pr__pfet_01v8[cgb]
echo OPV XX1_M32 cgb $&s1_xx1_m32_cgb
let s1_xx1_m32_cdg = @m.x1.xdut.xx1_m32.msky130_fd_pr__pfet_01v8[cdg]
echo OPV XX1_M32 cdg $&s1_xx1_m32_cdg
let s1_xx1_m32_cdd = @m.x1.xdut.xx1_m32.msky130_fd_pr__pfet_01v8[cdd]
echo OPV XX1_M32 cdd $&s1_xx1_m32_cdd
let s1_xx1_m32_cds = @m.x1.xdut.xx1_m32.msky130_fd_pr__pfet_01v8[cds]
echo OPV XX1_M32 cds $&s1_xx1_m32_cds
let s1_xx1_m32_cdb = @m.x1.xdut.xx1_m32.msky130_fd_pr__pfet_01v8[cdb]
echo OPV XX1_M32 cdb $&s1_xx1_m32_cdb
let s1_xx1_m32_csg = @m.x1.xdut.xx1_m32.msky130_fd_pr__pfet_01v8[csg]
echo OPV XX1_M32 csg $&s1_xx1_m32_csg
let s1_xx1_m32_csd = @m.x1.xdut.xx1_m32.msky130_fd_pr__pfet_01v8[csd]
echo OPV XX1_M32 csd $&s1_xx1_m32_csd
let s1_xx1_m32_css = @m.x1.xdut.xx1_m32.msky130_fd_pr__pfet_01v8[css]
echo OPV XX1_M32 css $&s1_xx1_m32_css
let s1_xx1_m32_csb = @m.x1.xdut.xx1_m32.msky130_fd_pr__pfet_01v8[csb]
echo OPV XX1_M32 csb $&s1_xx1_m32_csb
let s1_xx1_m32_cbg = @m.x1.xdut.xx1_m32.msky130_fd_pr__pfet_01v8[cbg]
echo OPV XX1_M32 cbg $&s1_xx1_m32_cbg
let s1_xx1_m32_cbd = @m.x1.xdut.xx1_m32.msky130_fd_pr__pfet_01v8[cbd]
echo OPV XX1_M32 cbd $&s1_xx1_m32_cbd
let s1_xx1_m32_cbs = @m.x1.xdut.xx1_m32.msky130_fd_pr__pfet_01v8[cbs]
echo OPV XX1_M32 cbs $&s1_xx1_m32_cbs
let s1_xx1_m32_cbb = @m.x1.xdut.xx1_m32.msky130_fd_pr__pfet_01v8[cbb]
echo OPV XX1_M32 cbb $&s1_xx1_m32_cbb
let s1_xx1_m32_capbd = @m.x1.xdut.xx1_m32.msky130_fd_pr__pfet_01v8[capbd]
echo OPV XX1_M32 capbd $&s1_xx1_m32_capbd
let s1_xx1_m32_capbs = @m.x1.xdut.xx1_m32.msky130_fd_pr__pfet_01v8[capbs]
echo OPV XX1_M32 capbs $&s1_xx1_m32_capbs
let s1_xx1_m32_cgso = @m.x1.xdut.xx1_m32.msky130_fd_pr__pfet_01v8[cgso]
echo OPV XX1_M32 cgso $&s1_xx1_m32_cgso
let s1_xx1_m32_cgdo = @m.x1.xdut.xx1_m32.msky130_fd_pr__pfet_01v8[cgdo]
echo OPV XX1_M32 cgdo $&s1_xx1_m32_cgdo
let s1_xx1_m32_cgbo = @m.x1.xdut.xx1_m32.msky130_fd_pr__pfet_01v8[cgbo]
echo OPV XX1_M32 cgbo $&s1_xx1_m32_cgbo
let s1_xx1_m32_weff = @m.x1.xdut.xx1_m32.msky130_fd_pr__pfet_01v8[weff]
echo OPV XX1_M32 weff $&s1_xx1_m32_weff
let s1_xx1_m32_leff = @m.x1.xdut.xx1_m32.msky130_fd_pr__pfet_01v8[leff]
echo OPV XX1_M32 leff $&s1_xx1_m32_leff
let s1_xx1_m21_id = @m.x1.xdut.xx1_m21.msky130_fd_pr__pfet_01v8_lvt[id]
echo OPV XX1_M21 id $&s1_xx1_m21_id
let s1_xx1_m21_vgs = @m.x1.xdut.xx1_m21.msky130_fd_pr__pfet_01v8_lvt[vgs]
echo OPV XX1_M21 vgs $&s1_xx1_m21_vgs
let s1_xx1_m21_vds = @m.x1.xdut.xx1_m21.msky130_fd_pr__pfet_01v8_lvt[vds]
echo OPV XX1_M21 vds $&s1_xx1_m21_vds
let s1_xx1_m21_vbs = @m.x1.xdut.xx1_m21.msky130_fd_pr__pfet_01v8_lvt[vbs]
echo OPV XX1_M21 vbs $&s1_xx1_m21_vbs
let s1_xx1_m21_vth = @m.x1.xdut.xx1_m21.msky130_fd_pr__pfet_01v8_lvt[vth]
echo OPV XX1_M21 vth $&s1_xx1_m21_vth
let s1_xx1_m21_vdsat = @m.x1.xdut.xx1_m21.msky130_fd_pr__pfet_01v8_lvt[vdsat]
echo OPV XX1_M21 vdsat $&s1_xx1_m21_vdsat
let s1_xx1_m21_gm = @m.x1.xdut.xx1_m21.msky130_fd_pr__pfet_01v8_lvt[gm]
echo OPV XX1_M21 gm $&s1_xx1_m21_gm
let s1_xx1_m21_gds = @m.x1.xdut.xx1_m21.msky130_fd_pr__pfet_01v8_lvt[gds]
echo OPV XX1_M21 gds $&s1_xx1_m21_gds
let s1_xx1_m21_gmbs = @m.x1.xdut.xx1_m21.msky130_fd_pr__pfet_01v8_lvt[gmbs]
echo OPV XX1_M21 gmbs $&s1_xx1_m21_gmbs
let s1_xx1_m21_cgg = @m.x1.xdut.xx1_m21.msky130_fd_pr__pfet_01v8_lvt[cgg]
echo OPV XX1_M21 cgg $&s1_xx1_m21_cgg
let s1_xx1_m21_cgd = @m.x1.xdut.xx1_m21.msky130_fd_pr__pfet_01v8_lvt[cgd]
echo OPV XX1_M21 cgd $&s1_xx1_m21_cgd
let s1_xx1_m21_cgs = @m.x1.xdut.xx1_m21.msky130_fd_pr__pfet_01v8_lvt[cgs]
echo OPV XX1_M21 cgs $&s1_xx1_m21_cgs
let s1_xx1_m21_cgb = @m.x1.xdut.xx1_m21.msky130_fd_pr__pfet_01v8_lvt[cgb]
echo OPV XX1_M21 cgb $&s1_xx1_m21_cgb
let s1_xx1_m21_cdg = @m.x1.xdut.xx1_m21.msky130_fd_pr__pfet_01v8_lvt[cdg]
echo OPV XX1_M21 cdg $&s1_xx1_m21_cdg
let s1_xx1_m21_cdd = @m.x1.xdut.xx1_m21.msky130_fd_pr__pfet_01v8_lvt[cdd]
echo OPV XX1_M21 cdd $&s1_xx1_m21_cdd
let s1_xx1_m21_cds = @m.x1.xdut.xx1_m21.msky130_fd_pr__pfet_01v8_lvt[cds]
echo OPV XX1_M21 cds $&s1_xx1_m21_cds
let s1_xx1_m21_cdb = @m.x1.xdut.xx1_m21.msky130_fd_pr__pfet_01v8_lvt[cdb]
echo OPV XX1_M21 cdb $&s1_xx1_m21_cdb
let s1_xx1_m21_csg = @m.x1.xdut.xx1_m21.msky130_fd_pr__pfet_01v8_lvt[csg]
echo OPV XX1_M21 csg $&s1_xx1_m21_csg
let s1_xx1_m21_csd = @m.x1.xdut.xx1_m21.msky130_fd_pr__pfet_01v8_lvt[csd]
echo OPV XX1_M21 csd $&s1_xx1_m21_csd
let s1_xx1_m21_css = @m.x1.xdut.xx1_m21.msky130_fd_pr__pfet_01v8_lvt[css]
echo OPV XX1_M21 css $&s1_xx1_m21_css
let s1_xx1_m21_csb = @m.x1.xdut.xx1_m21.msky130_fd_pr__pfet_01v8_lvt[csb]
echo OPV XX1_M21 csb $&s1_xx1_m21_csb
let s1_xx1_m21_cbg = @m.x1.xdut.xx1_m21.msky130_fd_pr__pfet_01v8_lvt[cbg]
echo OPV XX1_M21 cbg $&s1_xx1_m21_cbg
let s1_xx1_m21_cbd = @m.x1.xdut.xx1_m21.msky130_fd_pr__pfet_01v8_lvt[cbd]
echo OPV XX1_M21 cbd $&s1_xx1_m21_cbd
let s1_xx1_m21_cbs = @m.x1.xdut.xx1_m21.msky130_fd_pr__pfet_01v8_lvt[cbs]
echo OPV XX1_M21 cbs $&s1_xx1_m21_cbs
let s1_xx1_m21_cbb = @m.x1.xdut.xx1_m21.msky130_fd_pr__pfet_01v8_lvt[cbb]
echo OPV XX1_M21 cbb $&s1_xx1_m21_cbb
let s1_xx1_m21_capbd = @m.x1.xdut.xx1_m21.msky130_fd_pr__pfet_01v8_lvt[capbd]
echo OPV XX1_M21 capbd $&s1_xx1_m21_capbd
let s1_xx1_m21_capbs = @m.x1.xdut.xx1_m21.msky130_fd_pr__pfet_01v8_lvt[capbs]
echo OPV XX1_M21 capbs $&s1_xx1_m21_capbs
let s1_xx1_m21_cgso = @m.x1.xdut.xx1_m21.msky130_fd_pr__pfet_01v8_lvt[cgso]
echo OPV XX1_M21 cgso $&s1_xx1_m21_cgso
let s1_xx1_m21_cgdo = @m.x1.xdut.xx1_m21.msky130_fd_pr__pfet_01v8_lvt[cgdo]
echo OPV XX1_M21 cgdo $&s1_xx1_m21_cgdo
let s1_xx1_m21_cgbo = @m.x1.xdut.xx1_m21.msky130_fd_pr__pfet_01v8_lvt[cgbo]
echo OPV XX1_M21 cgbo $&s1_xx1_m21_cgbo
let s1_xx1_m21_weff = @m.x1.xdut.xx1_m21.msky130_fd_pr__pfet_01v8_lvt[weff]
echo OPV XX1_M21 weff $&s1_xx1_m21_weff
let s1_xx1_m21_leff = @m.x1.xdut.xx1_m21.msky130_fd_pr__pfet_01v8_lvt[leff]
echo OPV XX1_M21 leff $&s1_xx1_m21_leff
let s1_xx1_m25_id = @m.x1.xdut.xx1_m25.msky130_fd_pr__pfet_01v8_lvt[id]
echo OPV XX1_M25 id $&s1_xx1_m25_id
let s1_xx1_m25_vgs = @m.x1.xdut.xx1_m25.msky130_fd_pr__pfet_01v8_lvt[vgs]
echo OPV XX1_M25 vgs $&s1_xx1_m25_vgs
let s1_xx1_m25_vds = @m.x1.xdut.xx1_m25.msky130_fd_pr__pfet_01v8_lvt[vds]
echo OPV XX1_M25 vds $&s1_xx1_m25_vds
let s1_xx1_m25_vbs = @m.x1.xdut.xx1_m25.msky130_fd_pr__pfet_01v8_lvt[vbs]
echo OPV XX1_M25 vbs $&s1_xx1_m25_vbs
let s1_xx1_m25_vth = @m.x1.xdut.xx1_m25.msky130_fd_pr__pfet_01v8_lvt[vth]
echo OPV XX1_M25 vth $&s1_xx1_m25_vth
let s1_xx1_m25_vdsat = @m.x1.xdut.xx1_m25.msky130_fd_pr__pfet_01v8_lvt[vdsat]
echo OPV XX1_M25 vdsat $&s1_xx1_m25_vdsat
let s1_xx1_m25_gm = @m.x1.xdut.xx1_m25.msky130_fd_pr__pfet_01v8_lvt[gm]
echo OPV XX1_M25 gm $&s1_xx1_m25_gm
let s1_xx1_m25_gds = @m.x1.xdut.xx1_m25.msky130_fd_pr__pfet_01v8_lvt[gds]
echo OPV XX1_M25 gds $&s1_xx1_m25_gds
let s1_xx1_m25_gmbs = @m.x1.xdut.xx1_m25.msky130_fd_pr__pfet_01v8_lvt[gmbs]
echo OPV XX1_M25 gmbs $&s1_xx1_m25_gmbs
let s1_xx1_m25_cgg = @m.x1.xdut.xx1_m25.msky130_fd_pr__pfet_01v8_lvt[cgg]
echo OPV XX1_M25 cgg $&s1_xx1_m25_cgg
let s1_xx1_m25_cgd = @m.x1.xdut.xx1_m25.msky130_fd_pr__pfet_01v8_lvt[cgd]
echo OPV XX1_M25 cgd $&s1_xx1_m25_cgd
let s1_xx1_m25_cgs = @m.x1.xdut.xx1_m25.msky130_fd_pr__pfet_01v8_lvt[cgs]
echo OPV XX1_M25 cgs $&s1_xx1_m25_cgs
let s1_xx1_m25_cgb = @m.x1.xdut.xx1_m25.msky130_fd_pr__pfet_01v8_lvt[cgb]
echo OPV XX1_M25 cgb $&s1_xx1_m25_cgb
let s1_xx1_m25_cdg = @m.x1.xdut.xx1_m25.msky130_fd_pr__pfet_01v8_lvt[cdg]
echo OPV XX1_M25 cdg $&s1_xx1_m25_cdg
let s1_xx1_m25_cdd = @m.x1.xdut.xx1_m25.msky130_fd_pr__pfet_01v8_lvt[cdd]
echo OPV XX1_M25 cdd $&s1_xx1_m25_cdd
let s1_xx1_m25_cds = @m.x1.xdut.xx1_m25.msky130_fd_pr__pfet_01v8_lvt[cds]
echo OPV XX1_M25 cds $&s1_xx1_m25_cds
let s1_xx1_m25_cdb = @m.x1.xdut.xx1_m25.msky130_fd_pr__pfet_01v8_lvt[cdb]
echo OPV XX1_M25 cdb $&s1_xx1_m25_cdb
let s1_xx1_m25_csg = @m.x1.xdut.xx1_m25.msky130_fd_pr__pfet_01v8_lvt[csg]
echo OPV XX1_M25 csg $&s1_xx1_m25_csg
let s1_xx1_m25_csd = @m.x1.xdut.xx1_m25.msky130_fd_pr__pfet_01v8_lvt[csd]
echo OPV XX1_M25 csd $&s1_xx1_m25_csd
let s1_xx1_m25_css = @m.x1.xdut.xx1_m25.msky130_fd_pr__pfet_01v8_lvt[css]
echo OPV XX1_M25 css $&s1_xx1_m25_css
let s1_xx1_m25_csb = @m.x1.xdut.xx1_m25.msky130_fd_pr__pfet_01v8_lvt[csb]
echo OPV XX1_M25 csb $&s1_xx1_m25_csb
let s1_xx1_m25_cbg = @m.x1.xdut.xx1_m25.msky130_fd_pr__pfet_01v8_lvt[cbg]
echo OPV XX1_M25 cbg $&s1_xx1_m25_cbg
let s1_xx1_m25_cbd = @m.x1.xdut.xx1_m25.msky130_fd_pr__pfet_01v8_lvt[cbd]
echo OPV XX1_M25 cbd $&s1_xx1_m25_cbd
let s1_xx1_m25_cbs = @m.x1.xdut.xx1_m25.msky130_fd_pr__pfet_01v8_lvt[cbs]
echo OPV XX1_M25 cbs $&s1_xx1_m25_cbs
let s1_xx1_m25_cbb = @m.x1.xdut.xx1_m25.msky130_fd_pr__pfet_01v8_lvt[cbb]
echo OPV XX1_M25 cbb $&s1_xx1_m25_cbb
let s1_xx1_m25_capbd = @m.x1.xdut.xx1_m25.msky130_fd_pr__pfet_01v8_lvt[capbd]
echo OPV XX1_M25 capbd $&s1_xx1_m25_capbd
let s1_xx1_m25_capbs = @m.x1.xdut.xx1_m25.msky130_fd_pr__pfet_01v8_lvt[capbs]
echo OPV XX1_M25 capbs $&s1_xx1_m25_capbs
let s1_xx1_m25_cgso = @m.x1.xdut.xx1_m25.msky130_fd_pr__pfet_01v8_lvt[cgso]
echo OPV XX1_M25 cgso $&s1_xx1_m25_cgso
let s1_xx1_m25_cgdo = @m.x1.xdut.xx1_m25.msky130_fd_pr__pfet_01v8_lvt[cgdo]
echo OPV XX1_M25 cgdo $&s1_xx1_m25_cgdo
let s1_xx1_m25_cgbo = @m.x1.xdut.xx1_m25.msky130_fd_pr__pfet_01v8_lvt[cgbo]
echo OPV XX1_M25 cgbo $&s1_xx1_m25_cgbo
let s1_xx1_m25_weff = @m.x1.xdut.xx1_m25.msky130_fd_pr__pfet_01v8_lvt[weff]
echo OPV XX1_M25 weff $&s1_xx1_m25_weff
let s1_xx1_m25_leff = @m.x1.xdut.xx1_m25.msky130_fd_pr__pfet_01v8_lvt[leff]
echo OPV XX1_M25 leff $&s1_xx1_m25_leff
let s1_xx1_m31_id = @m.x1.xdut.xx1_m31.msky130_fd_pr__pfet_01v8_lvt[id]
echo OPV XX1_M31 id $&s1_xx1_m31_id
let s1_xx1_m31_vgs = @m.x1.xdut.xx1_m31.msky130_fd_pr__pfet_01v8_lvt[vgs]
echo OPV XX1_M31 vgs $&s1_xx1_m31_vgs
let s1_xx1_m31_vds = @m.x1.xdut.xx1_m31.msky130_fd_pr__pfet_01v8_lvt[vds]
echo OPV XX1_M31 vds $&s1_xx1_m31_vds
let s1_xx1_m31_vbs = @m.x1.xdut.xx1_m31.msky130_fd_pr__pfet_01v8_lvt[vbs]
echo OPV XX1_M31 vbs $&s1_xx1_m31_vbs
let s1_xx1_m31_vth = @m.x1.xdut.xx1_m31.msky130_fd_pr__pfet_01v8_lvt[vth]
echo OPV XX1_M31 vth $&s1_xx1_m31_vth
let s1_xx1_m31_vdsat = @m.x1.xdut.xx1_m31.msky130_fd_pr__pfet_01v8_lvt[vdsat]
echo OPV XX1_M31 vdsat $&s1_xx1_m31_vdsat
let s1_xx1_m31_gm = @m.x1.xdut.xx1_m31.msky130_fd_pr__pfet_01v8_lvt[gm]
echo OPV XX1_M31 gm $&s1_xx1_m31_gm
let s1_xx1_m31_gds = @m.x1.xdut.xx1_m31.msky130_fd_pr__pfet_01v8_lvt[gds]
echo OPV XX1_M31 gds $&s1_xx1_m31_gds
let s1_xx1_m31_gmbs = @m.x1.xdut.xx1_m31.msky130_fd_pr__pfet_01v8_lvt[gmbs]
echo OPV XX1_M31 gmbs $&s1_xx1_m31_gmbs
let s1_xx1_m31_cgg = @m.x1.xdut.xx1_m31.msky130_fd_pr__pfet_01v8_lvt[cgg]
echo OPV XX1_M31 cgg $&s1_xx1_m31_cgg
let s1_xx1_m31_cgd = @m.x1.xdut.xx1_m31.msky130_fd_pr__pfet_01v8_lvt[cgd]
echo OPV XX1_M31 cgd $&s1_xx1_m31_cgd
let s1_xx1_m31_cgs = @m.x1.xdut.xx1_m31.msky130_fd_pr__pfet_01v8_lvt[cgs]
echo OPV XX1_M31 cgs $&s1_xx1_m31_cgs
let s1_xx1_m31_cgb = @m.x1.xdut.xx1_m31.msky130_fd_pr__pfet_01v8_lvt[cgb]
echo OPV XX1_M31 cgb $&s1_xx1_m31_cgb
let s1_xx1_m31_cdg = @m.x1.xdut.xx1_m31.msky130_fd_pr__pfet_01v8_lvt[cdg]
echo OPV XX1_M31 cdg $&s1_xx1_m31_cdg
let s1_xx1_m31_cdd = @m.x1.xdut.xx1_m31.msky130_fd_pr__pfet_01v8_lvt[cdd]
echo OPV XX1_M31 cdd $&s1_xx1_m31_cdd
let s1_xx1_m31_cds = @m.x1.xdut.xx1_m31.msky130_fd_pr__pfet_01v8_lvt[cds]
echo OPV XX1_M31 cds $&s1_xx1_m31_cds
let s1_xx1_m31_cdb = @m.x1.xdut.xx1_m31.msky130_fd_pr__pfet_01v8_lvt[cdb]
echo OPV XX1_M31 cdb $&s1_xx1_m31_cdb
let s1_xx1_m31_csg = @m.x1.xdut.xx1_m31.msky130_fd_pr__pfet_01v8_lvt[csg]
echo OPV XX1_M31 csg $&s1_xx1_m31_csg
let s1_xx1_m31_csd = @m.x1.xdut.xx1_m31.msky130_fd_pr__pfet_01v8_lvt[csd]
echo OPV XX1_M31 csd $&s1_xx1_m31_csd
let s1_xx1_m31_css = @m.x1.xdut.xx1_m31.msky130_fd_pr__pfet_01v8_lvt[css]
echo OPV XX1_M31 css $&s1_xx1_m31_css
let s1_xx1_m31_csb = @m.x1.xdut.xx1_m31.msky130_fd_pr__pfet_01v8_lvt[csb]
echo OPV XX1_M31 csb $&s1_xx1_m31_csb
let s1_xx1_m31_cbg = @m.x1.xdut.xx1_m31.msky130_fd_pr__pfet_01v8_lvt[cbg]
echo OPV XX1_M31 cbg $&s1_xx1_m31_cbg
let s1_xx1_m31_cbd = @m.x1.xdut.xx1_m31.msky130_fd_pr__pfet_01v8_lvt[cbd]
echo OPV XX1_M31 cbd $&s1_xx1_m31_cbd
let s1_xx1_m31_cbs = @m.x1.xdut.xx1_m31.msky130_fd_pr__pfet_01v8_lvt[cbs]
echo OPV XX1_M31 cbs $&s1_xx1_m31_cbs
let s1_xx1_m31_cbb = @m.x1.xdut.xx1_m31.msky130_fd_pr__pfet_01v8_lvt[cbb]
echo OPV XX1_M31 cbb $&s1_xx1_m31_cbb
let s1_xx1_m31_capbd = @m.x1.xdut.xx1_m31.msky130_fd_pr__pfet_01v8_lvt[capbd]
echo OPV XX1_M31 capbd $&s1_xx1_m31_capbd
let s1_xx1_m31_capbs = @m.x1.xdut.xx1_m31.msky130_fd_pr__pfet_01v8_lvt[capbs]
echo OPV XX1_M31 capbs $&s1_xx1_m31_capbs
let s1_xx1_m31_cgso = @m.x1.xdut.xx1_m31.msky130_fd_pr__pfet_01v8_lvt[cgso]
echo OPV XX1_M31 cgso $&s1_xx1_m31_cgso
let s1_xx1_m31_cgdo = @m.x1.xdut.xx1_m31.msky130_fd_pr__pfet_01v8_lvt[cgdo]
echo OPV XX1_M31 cgdo $&s1_xx1_m31_cgdo
let s1_xx1_m31_cgbo = @m.x1.xdut.xx1_m31.msky130_fd_pr__pfet_01v8_lvt[cgbo]
echo OPV XX1_M31 cgbo $&s1_xx1_m31_cgbo
let s1_xx1_m31_weff = @m.x1.xdut.xx1_m31.msky130_fd_pr__pfet_01v8_lvt[weff]
echo OPV XX1_M31 weff $&s1_xx1_m31_weff
let s1_xx1_m31_leff = @m.x1.xdut.xx1_m31.msky130_fd_pr__pfet_01v8_lvt[leff]
echo OPV XX1_M31 leff $&s1_xx1_m31_leff
let s1_xx1_m1_id = @m.x1.xdut.xx1_m1.msky130_fd_pr__nfet_01v8_lvt[id]
echo OPV XX1_M1 id $&s1_xx1_m1_id
let s1_xx1_m1_vgs = @m.x1.xdut.xx1_m1.msky130_fd_pr__nfet_01v8_lvt[vgs]
echo OPV XX1_M1 vgs $&s1_xx1_m1_vgs
let s1_xx1_m1_vds = @m.x1.xdut.xx1_m1.msky130_fd_pr__nfet_01v8_lvt[vds]
echo OPV XX1_M1 vds $&s1_xx1_m1_vds
let s1_xx1_m1_vbs = @m.x1.xdut.xx1_m1.msky130_fd_pr__nfet_01v8_lvt[vbs]
echo OPV XX1_M1 vbs $&s1_xx1_m1_vbs
let s1_xx1_m1_vth = @m.x1.xdut.xx1_m1.msky130_fd_pr__nfet_01v8_lvt[vth]
echo OPV XX1_M1 vth $&s1_xx1_m1_vth
let s1_xx1_m1_vdsat = @m.x1.xdut.xx1_m1.msky130_fd_pr__nfet_01v8_lvt[vdsat]
echo OPV XX1_M1 vdsat $&s1_xx1_m1_vdsat
let s1_xx1_m1_gm = @m.x1.xdut.xx1_m1.msky130_fd_pr__nfet_01v8_lvt[gm]
echo OPV XX1_M1 gm $&s1_xx1_m1_gm
let s1_xx1_m1_gds = @m.x1.xdut.xx1_m1.msky130_fd_pr__nfet_01v8_lvt[gds]
echo OPV XX1_M1 gds $&s1_xx1_m1_gds
let s1_xx1_m1_gmbs = @m.x1.xdut.xx1_m1.msky130_fd_pr__nfet_01v8_lvt[gmbs]
echo OPV XX1_M1 gmbs $&s1_xx1_m1_gmbs
let s1_xx1_m1_cgg = @m.x1.xdut.xx1_m1.msky130_fd_pr__nfet_01v8_lvt[cgg]
echo OPV XX1_M1 cgg $&s1_xx1_m1_cgg
let s1_xx1_m1_cgd = @m.x1.xdut.xx1_m1.msky130_fd_pr__nfet_01v8_lvt[cgd]
echo OPV XX1_M1 cgd $&s1_xx1_m1_cgd
let s1_xx1_m1_cgs = @m.x1.xdut.xx1_m1.msky130_fd_pr__nfet_01v8_lvt[cgs]
echo OPV XX1_M1 cgs $&s1_xx1_m1_cgs
let s1_xx1_m1_cgb = @m.x1.xdut.xx1_m1.msky130_fd_pr__nfet_01v8_lvt[cgb]
echo OPV XX1_M1 cgb $&s1_xx1_m1_cgb
let s1_xx1_m1_cdg = @m.x1.xdut.xx1_m1.msky130_fd_pr__nfet_01v8_lvt[cdg]
echo OPV XX1_M1 cdg $&s1_xx1_m1_cdg
let s1_xx1_m1_cdd = @m.x1.xdut.xx1_m1.msky130_fd_pr__nfet_01v8_lvt[cdd]
echo OPV XX1_M1 cdd $&s1_xx1_m1_cdd
let s1_xx1_m1_cds = @m.x1.xdut.xx1_m1.msky130_fd_pr__nfet_01v8_lvt[cds]
echo OPV XX1_M1 cds $&s1_xx1_m1_cds
let s1_xx1_m1_cdb = @m.x1.xdut.xx1_m1.msky130_fd_pr__nfet_01v8_lvt[cdb]
echo OPV XX1_M1 cdb $&s1_xx1_m1_cdb
let s1_xx1_m1_csg = @m.x1.xdut.xx1_m1.msky130_fd_pr__nfet_01v8_lvt[csg]
echo OPV XX1_M1 csg $&s1_xx1_m1_csg
let s1_xx1_m1_csd = @m.x1.xdut.xx1_m1.msky130_fd_pr__nfet_01v8_lvt[csd]
echo OPV XX1_M1 csd $&s1_xx1_m1_csd
let s1_xx1_m1_css = @m.x1.xdut.xx1_m1.msky130_fd_pr__nfet_01v8_lvt[css]
echo OPV XX1_M1 css $&s1_xx1_m1_css
let s1_xx1_m1_csb = @m.x1.xdut.xx1_m1.msky130_fd_pr__nfet_01v8_lvt[csb]
echo OPV XX1_M1 csb $&s1_xx1_m1_csb
let s1_xx1_m1_cbg = @m.x1.xdut.xx1_m1.msky130_fd_pr__nfet_01v8_lvt[cbg]
echo OPV XX1_M1 cbg $&s1_xx1_m1_cbg
let s1_xx1_m1_cbd = @m.x1.xdut.xx1_m1.msky130_fd_pr__nfet_01v8_lvt[cbd]
echo OPV XX1_M1 cbd $&s1_xx1_m1_cbd
let s1_xx1_m1_cbs = @m.x1.xdut.xx1_m1.msky130_fd_pr__nfet_01v8_lvt[cbs]
echo OPV XX1_M1 cbs $&s1_xx1_m1_cbs
let s1_xx1_m1_cbb = @m.x1.xdut.xx1_m1.msky130_fd_pr__nfet_01v8_lvt[cbb]
echo OPV XX1_M1 cbb $&s1_xx1_m1_cbb
let s1_xx1_m1_capbd = @m.x1.xdut.xx1_m1.msky130_fd_pr__nfet_01v8_lvt[capbd]
echo OPV XX1_M1 capbd $&s1_xx1_m1_capbd
let s1_xx1_m1_capbs = @m.x1.xdut.xx1_m1.msky130_fd_pr__nfet_01v8_lvt[capbs]
echo OPV XX1_M1 capbs $&s1_xx1_m1_capbs
let s1_xx1_m1_cgso = @m.x1.xdut.xx1_m1.msky130_fd_pr__nfet_01v8_lvt[cgso]
echo OPV XX1_M1 cgso $&s1_xx1_m1_cgso
let s1_xx1_m1_cgdo = @m.x1.xdut.xx1_m1.msky130_fd_pr__nfet_01v8_lvt[cgdo]
echo OPV XX1_M1 cgdo $&s1_xx1_m1_cgdo
let s1_xx1_m1_cgbo = @m.x1.xdut.xx1_m1.msky130_fd_pr__nfet_01v8_lvt[cgbo]
echo OPV XX1_M1 cgbo $&s1_xx1_m1_cgbo
let s1_xx1_m1_weff = @m.x1.xdut.xx1_m1.msky130_fd_pr__nfet_01v8_lvt[weff]
echo OPV XX1_M1 weff $&s1_xx1_m1_weff
let s1_xx1_m1_leff = @m.x1.xdut.xx1_m1.msky130_fd_pr__nfet_01v8_lvt[leff]
echo OPV XX1_M1 leff $&s1_xx1_m1_leff
let s1_xx1_m2_id = @m.x1.xdut.xx1_m2.msky130_fd_pr__nfet_01v8[id]
echo OPV XX1_M2 id $&s1_xx1_m2_id
let s1_xx1_m2_vgs = @m.x1.xdut.xx1_m2.msky130_fd_pr__nfet_01v8[vgs]
echo OPV XX1_M2 vgs $&s1_xx1_m2_vgs
let s1_xx1_m2_vds = @m.x1.xdut.xx1_m2.msky130_fd_pr__nfet_01v8[vds]
echo OPV XX1_M2 vds $&s1_xx1_m2_vds
let s1_xx1_m2_vbs = @m.x1.xdut.xx1_m2.msky130_fd_pr__nfet_01v8[vbs]
echo OPV XX1_M2 vbs $&s1_xx1_m2_vbs
let s1_xx1_m2_vth = @m.x1.xdut.xx1_m2.msky130_fd_pr__nfet_01v8[vth]
echo OPV XX1_M2 vth $&s1_xx1_m2_vth
let s1_xx1_m2_vdsat = @m.x1.xdut.xx1_m2.msky130_fd_pr__nfet_01v8[vdsat]
echo OPV XX1_M2 vdsat $&s1_xx1_m2_vdsat
let s1_xx1_m2_gm = @m.x1.xdut.xx1_m2.msky130_fd_pr__nfet_01v8[gm]
echo OPV XX1_M2 gm $&s1_xx1_m2_gm
let s1_xx1_m2_gds = @m.x1.xdut.xx1_m2.msky130_fd_pr__nfet_01v8[gds]
echo OPV XX1_M2 gds $&s1_xx1_m2_gds
let s1_xx1_m2_gmbs = @m.x1.xdut.xx1_m2.msky130_fd_pr__nfet_01v8[gmbs]
echo OPV XX1_M2 gmbs $&s1_xx1_m2_gmbs
let s1_xx1_m2_cgg = @m.x1.xdut.xx1_m2.msky130_fd_pr__nfet_01v8[cgg]
echo OPV XX1_M2 cgg $&s1_xx1_m2_cgg
let s1_xx1_m2_cgd = @m.x1.xdut.xx1_m2.msky130_fd_pr__nfet_01v8[cgd]
echo OPV XX1_M2 cgd $&s1_xx1_m2_cgd
let s1_xx1_m2_cgs = @m.x1.xdut.xx1_m2.msky130_fd_pr__nfet_01v8[cgs]
echo OPV XX1_M2 cgs $&s1_xx1_m2_cgs
let s1_xx1_m2_cgb = @m.x1.xdut.xx1_m2.msky130_fd_pr__nfet_01v8[cgb]
echo OPV XX1_M2 cgb $&s1_xx1_m2_cgb
let s1_xx1_m2_cdg = @m.x1.xdut.xx1_m2.msky130_fd_pr__nfet_01v8[cdg]
echo OPV XX1_M2 cdg $&s1_xx1_m2_cdg
let s1_xx1_m2_cdd = @m.x1.xdut.xx1_m2.msky130_fd_pr__nfet_01v8[cdd]
echo OPV XX1_M2 cdd $&s1_xx1_m2_cdd
let s1_xx1_m2_cds = @m.x1.xdut.xx1_m2.msky130_fd_pr__nfet_01v8[cds]
echo OPV XX1_M2 cds $&s1_xx1_m2_cds
let s1_xx1_m2_cdb = @m.x1.xdut.xx1_m2.msky130_fd_pr__nfet_01v8[cdb]
echo OPV XX1_M2 cdb $&s1_xx1_m2_cdb
let s1_xx1_m2_csg = @m.x1.xdut.xx1_m2.msky130_fd_pr__nfet_01v8[csg]
echo OPV XX1_M2 csg $&s1_xx1_m2_csg
let s1_xx1_m2_csd = @m.x1.xdut.xx1_m2.msky130_fd_pr__nfet_01v8[csd]
echo OPV XX1_M2 csd $&s1_xx1_m2_csd
let s1_xx1_m2_css = @m.x1.xdut.xx1_m2.msky130_fd_pr__nfet_01v8[css]
echo OPV XX1_M2 css $&s1_xx1_m2_css
let s1_xx1_m2_csb = @m.x1.xdut.xx1_m2.msky130_fd_pr__nfet_01v8[csb]
echo OPV XX1_M2 csb $&s1_xx1_m2_csb
let s1_xx1_m2_cbg = @m.x1.xdut.xx1_m2.msky130_fd_pr__nfet_01v8[cbg]
echo OPV XX1_M2 cbg $&s1_xx1_m2_cbg
let s1_xx1_m2_cbd = @m.x1.xdut.xx1_m2.msky130_fd_pr__nfet_01v8[cbd]
echo OPV XX1_M2 cbd $&s1_xx1_m2_cbd
let s1_xx1_m2_cbs = @m.x1.xdut.xx1_m2.msky130_fd_pr__nfet_01v8[cbs]
echo OPV XX1_M2 cbs $&s1_xx1_m2_cbs
let s1_xx1_m2_cbb = @m.x1.xdut.xx1_m2.msky130_fd_pr__nfet_01v8[cbb]
echo OPV XX1_M2 cbb $&s1_xx1_m2_cbb
let s1_xx1_m2_capbd = @m.x1.xdut.xx1_m2.msky130_fd_pr__nfet_01v8[capbd]
echo OPV XX1_M2 capbd $&s1_xx1_m2_capbd
let s1_xx1_m2_capbs = @m.x1.xdut.xx1_m2.msky130_fd_pr__nfet_01v8[capbs]
echo OPV XX1_M2 capbs $&s1_xx1_m2_capbs
let s1_xx1_m2_cgso = @m.x1.xdut.xx1_m2.msky130_fd_pr__nfet_01v8[cgso]
echo OPV XX1_M2 cgso $&s1_xx1_m2_cgso
let s1_xx1_m2_cgdo = @m.x1.xdut.xx1_m2.msky130_fd_pr__nfet_01v8[cgdo]
echo OPV XX1_M2 cgdo $&s1_xx1_m2_cgdo
let s1_xx1_m2_cgbo = @m.x1.xdut.xx1_m2.msky130_fd_pr__nfet_01v8[cgbo]
echo OPV XX1_M2 cgbo $&s1_xx1_m2_cgbo
let s1_xx1_m2_weff = @m.x1.xdut.xx1_m2.msky130_fd_pr__nfet_01v8[weff]
echo OPV XX1_M2 weff $&s1_xx1_m2_weff
let s1_xx1_m2_leff = @m.x1.xdut.xx1_m2.msky130_fd_pr__nfet_01v8[leff]
echo OPV XX1_M2 leff $&s1_xx1_m2_leff
let s1_xx1_m3_id = @m.x1.xdut.xx1_m3.msky130_fd_pr__nfet_01v8[id]
echo OPV XX1_M3 id $&s1_xx1_m3_id
let s1_xx1_m3_vgs = @m.x1.xdut.xx1_m3.msky130_fd_pr__nfet_01v8[vgs]
echo OPV XX1_M3 vgs $&s1_xx1_m3_vgs
let s1_xx1_m3_vds = @m.x1.xdut.xx1_m3.msky130_fd_pr__nfet_01v8[vds]
echo OPV XX1_M3 vds $&s1_xx1_m3_vds
let s1_xx1_m3_vbs = @m.x1.xdut.xx1_m3.msky130_fd_pr__nfet_01v8[vbs]
echo OPV XX1_M3 vbs $&s1_xx1_m3_vbs
let s1_xx1_m3_vth = @m.x1.xdut.xx1_m3.msky130_fd_pr__nfet_01v8[vth]
echo OPV XX1_M3 vth $&s1_xx1_m3_vth
let s1_xx1_m3_vdsat = @m.x1.xdut.xx1_m3.msky130_fd_pr__nfet_01v8[vdsat]
echo OPV XX1_M3 vdsat $&s1_xx1_m3_vdsat
let s1_xx1_m3_gm = @m.x1.xdut.xx1_m3.msky130_fd_pr__nfet_01v8[gm]
echo OPV XX1_M3 gm $&s1_xx1_m3_gm
let s1_xx1_m3_gds = @m.x1.xdut.xx1_m3.msky130_fd_pr__nfet_01v8[gds]
echo OPV XX1_M3 gds $&s1_xx1_m3_gds
let s1_xx1_m3_gmbs = @m.x1.xdut.xx1_m3.msky130_fd_pr__nfet_01v8[gmbs]
echo OPV XX1_M3 gmbs $&s1_xx1_m3_gmbs
let s1_xx1_m3_cgg = @m.x1.xdut.xx1_m3.msky130_fd_pr__nfet_01v8[cgg]
echo OPV XX1_M3 cgg $&s1_xx1_m3_cgg
let s1_xx1_m3_cgd = @m.x1.xdut.xx1_m3.msky130_fd_pr__nfet_01v8[cgd]
echo OPV XX1_M3 cgd $&s1_xx1_m3_cgd
let s1_xx1_m3_cgs = @m.x1.xdut.xx1_m3.msky130_fd_pr__nfet_01v8[cgs]
echo OPV XX1_M3 cgs $&s1_xx1_m3_cgs
let s1_xx1_m3_cgb = @m.x1.xdut.xx1_m3.msky130_fd_pr__nfet_01v8[cgb]
echo OPV XX1_M3 cgb $&s1_xx1_m3_cgb
let s1_xx1_m3_cdg = @m.x1.xdut.xx1_m3.msky130_fd_pr__nfet_01v8[cdg]
echo OPV XX1_M3 cdg $&s1_xx1_m3_cdg
let s1_xx1_m3_cdd = @m.x1.xdut.xx1_m3.msky130_fd_pr__nfet_01v8[cdd]
echo OPV XX1_M3 cdd $&s1_xx1_m3_cdd
let s1_xx1_m3_cds = @m.x1.xdut.xx1_m3.msky130_fd_pr__nfet_01v8[cds]
echo OPV XX1_M3 cds $&s1_xx1_m3_cds
let s1_xx1_m3_cdb = @m.x1.xdut.xx1_m3.msky130_fd_pr__nfet_01v8[cdb]
echo OPV XX1_M3 cdb $&s1_xx1_m3_cdb
let s1_xx1_m3_csg = @m.x1.xdut.xx1_m3.msky130_fd_pr__nfet_01v8[csg]
echo OPV XX1_M3 csg $&s1_xx1_m3_csg
let s1_xx1_m3_csd = @m.x1.xdut.xx1_m3.msky130_fd_pr__nfet_01v8[csd]
echo OPV XX1_M3 csd $&s1_xx1_m3_csd
let s1_xx1_m3_css = @m.x1.xdut.xx1_m3.msky130_fd_pr__nfet_01v8[css]
echo OPV XX1_M3 css $&s1_xx1_m3_css
let s1_xx1_m3_csb = @m.x1.xdut.xx1_m3.msky130_fd_pr__nfet_01v8[csb]
echo OPV XX1_M3 csb $&s1_xx1_m3_csb
let s1_xx1_m3_cbg = @m.x1.xdut.xx1_m3.msky130_fd_pr__nfet_01v8[cbg]
echo OPV XX1_M3 cbg $&s1_xx1_m3_cbg
let s1_xx1_m3_cbd = @m.x1.xdut.xx1_m3.msky130_fd_pr__nfet_01v8[cbd]
echo OPV XX1_M3 cbd $&s1_xx1_m3_cbd
let s1_xx1_m3_cbs = @m.x1.xdut.xx1_m3.msky130_fd_pr__nfet_01v8[cbs]
echo OPV XX1_M3 cbs $&s1_xx1_m3_cbs
let s1_xx1_m3_cbb = @m.x1.xdut.xx1_m3.msky130_fd_pr__nfet_01v8[cbb]
echo OPV XX1_M3 cbb $&s1_xx1_m3_cbb
let s1_xx1_m3_capbd = @m.x1.xdut.xx1_m3.msky130_fd_pr__nfet_01v8[capbd]
echo OPV XX1_M3 capbd $&s1_xx1_m3_capbd
let s1_xx1_m3_capbs = @m.x1.xdut.xx1_m3.msky130_fd_pr__nfet_01v8[capbs]
echo OPV XX1_M3 capbs $&s1_xx1_m3_capbs
let s1_xx1_m3_cgso = @m.x1.xdut.xx1_m3.msky130_fd_pr__nfet_01v8[cgso]
echo OPV XX1_M3 cgso $&s1_xx1_m3_cgso
let s1_xx1_m3_cgdo = @m.x1.xdut.xx1_m3.msky130_fd_pr__nfet_01v8[cgdo]
echo OPV XX1_M3 cgdo $&s1_xx1_m3_cgdo
let s1_xx1_m3_cgbo = @m.x1.xdut.xx1_m3.msky130_fd_pr__nfet_01v8[cgbo]
echo OPV XX1_M3 cgbo $&s1_xx1_m3_cgbo
let s1_xx1_m3_weff = @m.x1.xdut.xx1_m3.msky130_fd_pr__nfet_01v8[weff]
echo OPV XX1_M3 weff $&s1_xx1_m3_weff
let s1_xx1_m3_leff = @m.x1.xdut.xx1_m3.msky130_fd_pr__nfet_01v8[leff]
echo OPV XX1_M3 leff $&s1_xx1_m3_leff
let s1_xx1_m4_id = @m.x1.xdut.xx1_m4.msky130_fd_pr__nfet_01v8[id]
echo OPV XX1_M4 id $&s1_xx1_m4_id
let s1_xx1_m4_vgs = @m.x1.xdut.xx1_m4.msky130_fd_pr__nfet_01v8[vgs]
echo OPV XX1_M4 vgs $&s1_xx1_m4_vgs
let s1_xx1_m4_vds = @m.x1.xdut.xx1_m4.msky130_fd_pr__nfet_01v8[vds]
echo OPV XX1_M4 vds $&s1_xx1_m4_vds
let s1_xx1_m4_vbs = @m.x1.xdut.xx1_m4.msky130_fd_pr__nfet_01v8[vbs]
echo OPV XX1_M4 vbs $&s1_xx1_m4_vbs
let s1_xx1_m4_vth = @m.x1.xdut.xx1_m4.msky130_fd_pr__nfet_01v8[vth]
echo OPV XX1_M4 vth $&s1_xx1_m4_vth
let s1_xx1_m4_vdsat = @m.x1.xdut.xx1_m4.msky130_fd_pr__nfet_01v8[vdsat]
echo OPV XX1_M4 vdsat $&s1_xx1_m4_vdsat
let s1_xx1_m4_gm = @m.x1.xdut.xx1_m4.msky130_fd_pr__nfet_01v8[gm]
echo OPV XX1_M4 gm $&s1_xx1_m4_gm
let s1_xx1_m4_gds = @m.x1.xdut.xx1_m4.msky130_fd_pr__nfet_01v8[gds]
echo OPV XX1_M4 gds $&s1_xx1_m4_gds
let s1_xx1_m4_gmbs = @m.x1.xdut.xx1_m4.msky130_fd_pr__nfet_01v8[gmbs]
echo OPV XX1_M4 gmbs $&s1_xx1_m4_gmbs
let s1_xx1_m4_cgg = @m.x1.xdut.xx1_m4.msky130_fd_pr__nfet_01v8[cgg]
echo OPV XX1_M4 cgg $&s1_xx1_m4_cgg
let s1_xx1_m4_cgd = @m.x1.xdut.xx1_m4.msky130_fd_pr__nfet_01v8[cgd]
echo OPV XX1_M4 cgd $&s1_xx1_m4_cgd
let s1_xx1_m4_cgs = @m.x1.xdut.xx1_m4.msky130_fd_pr__nfet_01v8[cgs]
echo OPV XX1_M4 cgs $&s1_xx1_m4_cgs
let s1_xx1_m4_cgb = @m.x1.xdut.xx1_m4.msky130_fd_pr__nfet_01v8[cgb]
echo OPV XX1_M4 cgb $&s1_xx1_m4_cgb
let s1_xx1_m4_cdg = @m.x1.xdut.xx1_m4.msky130_fd_pr__nfet_01v8[cdg]
echo OPV XX1_M4 cdg $&s1_xx1_m4_cdg
let s1_xx1_m4_cdd = @m.x1.xdut.xx1_m4.msky130_fd_pr__nfet_01v8[cdd]
echo OPV XX1_M4 cdd $&s1_xx1_m4_cdd
let s1_xx1_m4_cds = @m.x1.xdut.xx1_m4.msky130_fd_pr__nfet_01v8[cds]
echo OPV XX1_M4 cds $&s1_xx1_m4_cds
let s1_xx1_m4_cdb = @m.x1.xdut.xx1_m4.msky130_fd_pr__nfet_01v8[cdb]
echo OPV XX1_M4 cdb $&s1_xx1_m4_cdb
let s1_xx1_m4_csg = @m.x1.xdut.xx1_m4.msky130_fd_pr__nfet_01v8[csg]
echo OPV XX1_M4 csg $&s1_xx1_m4_csg
let s1_xx1_m4_csd = @m.x1.xdut.xx1_m4.msky130_fd_pr__nfet_01v8[csd]
echo OPV XX1_M4 csd $&s1_xx1_m4_csd
let s1_xx1_m4_css = @m.x1.xdut.xx1_m4.msky130_fd_pr__nfet_01v8[css]
echo OPV XX1_M4 css $&s1_xx1_m4_css
let s1_xx1_m4_csb = @m.x1.xdut.xx1_m4.msky130_fd_pr__nfet_01v8[csb]
echo OPV XX1_M4 csb $&s1_xx1_m4_csb
let s1_xx1_m4_cbg = @m.x1.xdut.xx1_m4.msky130_fd_pr__nfet_01v8[cbg]
echo OPV XX1_M4 cbg $&s1_xx1_m4_cbg
let s1_xx1_m4_cbd = @m.x1.xdut.xx1_m4.msky130_fd_pr__nfet_01v8[cbd]
echo OPV XX1_M4 cbd $&s1_xx1_m4_cbd
let s1_xx1_m4_cbs = @m.x1.xdut.xx1_m4.msky130_fd_pr__nfet_01v8[cbs]
echo OPV XX1_M4 cbs $&s1_xx1_m4_cbs
let s1_xx1_m4_cbb = @m.x1.xdut.xx1_m4.msky130_fd_pr__nfet_01v8[cbb]
echo OPV XX1_M4 cbb $&s1_xx1_m4_cbb
let s1_xx1_m4_capbd = @m.x1.xdut.xx1_m4.msky130_fd_pr__nfet_01v8[capbd]
echo OPV XX1_M4 capbd $&s1_xx1_m4_capbd
let s1_xx1_m4_capbs = @m.x1.xdut.xx1_m4.msky130_fd_pr__nfet_01v8[capbs]
echo OPV XX1_M4 capbs $&s1_xx1_m4_capbs
let s1_xx1_m4_cgso = @m.x1.xdut.xx1_m4.msky130_fd_pr__nfet_01v8[cgso]
echo OPV XX1_M4 cgso $&s1_xx1_m4_cgso
let s1_xx1_m4_cgdo = @m.x1.xdut.xx1_m4.msky130_fd_pr__nfet_01v8[cgdo]
echo OPV XX1_M4 cgdo $&s1_xx1_m4_cgdo
let s1_xx1_m4_cgbo = @m.x1.xdut.xx1_m4.msky130_fd_pr__nfet_01v8[cgbo]
echo OPV XX1_M4 cgbo $&s1_xx1_m4_cgbo
let s1_xx1_m4_weff = @m.x1.xdut.xx1_m4.msky130_fd_pr__nfet_01v8[weff]
echo OPV XX1_M4 weff $&s1_xx1_m4_weff
let s1_xx1_m4_leff = @m.x1.xdut.xx1_m4.msky130_fd_pr__nfet_01v8[leff]
echo OPV XX1_M4 leff $&s1_xx1_m4_leff
let s1_xx1_m5_id = @m.x1.xdut.xx1_m5.msky130_fd_pr__nfet_01v8[id]
echo OPV XX1_M5 id $&s1_xx1_m5_id
let s1_xx1_m5_vgs = @m.x1.xdut.xx1_m5.msky130_fd_pr__nfet_01v8[vgs]
echo OPV XX1_M5 vgs $&s1_xx1_m5_vgs
let s1_xx1_m5_vds = @m.x1.xdut.xx1_m5.msky130_fd_pr__nfet_01v8[vds]
echo OPV XX1_M5 vds $&s1_xx1_m5_vds
let s1_xx1_m5_vbs = @m.x1.xdut.xx1_m5.msky130_fd_pr__nfet_01v8[vbs]
echo OPV XX1_M5 vbs $&s1_xx1_m5_vbs
let s1_xx1_m5_vth = @m.x1.xdut.xx1_m5.msky130_fd_pr__nfet_01v8[vth]
echo OPV XX1_M5 vth $&s1_xx1_m5_vth
let s1_xx1_m5_vdsat = @m.x1.xdut.xx1_m5.msky130_fd_pr__nfet_01v8[vdsat]
echo OPV XX1_M5 vdsat $&s1_xx1_m5_vdsat
let s1_xx1_m5_gm = @m.x1.xdut.xx1_m5.msky130_fd_pr__nfet_01v8[gm]
echo OPV XX1_M5 gm $&s1_xx1_m5_gm
let s1_xx1_m5_gds = @m.x1.xdut.xx1_m5.msky130_fd_pr__nfet_01v8[gds]
echo OPV XX1_M5 gds $&s1_xx1_m5_gds
let s1_xx1_m5_gmbs = @m.x1.xdut.xx1_m5.msky130_fd_pr__nfet_01v8[gmbs]
echo OPV XX1_M5 gmbs $&s1_xx1_m5_gmbs
let s1_xx1_m5_cgg = @m.x1.xdut.xx1_m5.msky130_fd_pr__nfet_01v8[cgg]
echo OPV XX1_M5 cgg $&s1_xx1_m5_cgg
let s1_xx1_m5_cgd = @m.x1.xdut.xx1_m5.msky130_fd_pr__nfet_01v8[cgd]
echo OPV XX1_M5 cgd $&s1_xx1_m5_cgd
let s1_xx1_m5_cgs = @m.x1.xdut.xx1_m5.msky130_fd_pr__nfet_01v8[cgs]
echo OPV XX1_M5 cgs $&s1_xx1_m5_cgs
let s1_xx1_m5_cgb = @m.x1.xdut.xx1_m5.msky130_fd_pr__nfet_01v8[cgb]
echo OPV XX1_M5 cgb $&s1_xx1_m5_cgb
let s1_xx1_m5_cdg = @m.x1.xdut.xx1_m5.msky130_fd_pr__nfet_01v8[cdg]
echo OPV XX1_M5 cdg $&s1_xx1_m5_cdg
let s1_xx1_m5_cdd = @m.x1.xdut.xx1_m5.msky130_fd_pr__nfet_01v8[cdd]
echo OPV XX1_M5 cdd $&s1_xx1_m5_cdd
let s1_xx1_m5_cds = @m.x1.xdut.xx1_m5.msky130_fd_pr__nfet_01v8[cds]
echo OPV XX1_M5 cds $&s1_xx1_m5_cds
let s1_xx1_m5_cdb = @m.x1.xdut.xx1_m5.msky130_fd_pr__nfet_01v8[cdb]
echo OPV XX1_M5 cdb $&s1_xx1_m5_cdb
let s1_xx1_m5_csg = @m.x1.xdut.xx1_m5.msky130_fd_pr__nfet_01v8[csg]
echo OPV XX1_M5 csg $&s1_xx1_m5_csg
let s1_xx1_m5_csd = @m.x1.xdut.xx1_m5.msky130_fd_pr__nfet_01v8[csd]
echo OPV XX1_M5 csd $&s1_xx1_m5_csd
let s1_xx1_m5_css = @m.x1.xdut.xx1_m5.msky130_fd_pr__nfet_01v8[css]
echo OPV XX1_M5 css $&s1_xx1_m5_css
let s1_xx1_m5_csb = @m.x1.xdut.xx1_m5.msky130_fd_pr__nfet_01v8[csb]
echo OPV XX1_M5 csb $&s1_xx1_m5_csb
let s1_xx1_m5_cbg = @m.x1.xdut.xx1_m5.msky130_fd_pr__nfet_01v8[cbg]
echo OPV XX1_M5 cbg $&s1_xx1_m5_cbg
let s1_xx1_m5_cbd = @m.x1.xdut.xx1_m5.msky130_fd_pr__nfet_01v8[cbd]
echo OPV XX1_M5 cbd $&s1_xx1_m5_cbd
let s1_xx1_m5_cbs = @m.x1.xdut.xx1_m5.msky130_fd_pr__nfet_01v8[cbs]
echo OPV XX1_M5 cbs $&s1_xx1_m5_cbs
let s1_xx1_m5_cbb = @m.x1.xdut.xx1_m5.msky130_fd_pr__nfet_01v8[cbb]
echo OPV XX1_M5 cbb $&s1_xx1_m5_cbb
let s1_xx1_m5_capbd = @m.x1.xdut.xx1_m5.msky130_fd_pr__nfet_01v8[capbd]
echo OPV XX1_M5 capbd $&s1_xx1_m5_capbd
let s1_xx1_m5_capbs = @m.x1.xdut.xx1_m5.msky130_fd_pr__nfet_01v8[capbs]
echo OPV XX1_M5 capbs $&s1_xx1_m5_capbs
let s1_xx1_m5_cgso = @m.x1.xdut.xx1_m5.msky130_fd_pr__nfet_01v8[cgso]
echo OPV XX1_M5 cgso $&s1_xx1_m5_cgso
let s1_xx1_m5_cgdo = @m.x1.xdut.xx1_m5.msky130_fd_pr__nfet_01v8[cgdo]
echo OPV XX1_M5 cgdo $&s1_xx1_m5_cgdo
let s1_xx1_m5_cgbo = @m.x1.xdut.xx1_m5.msky130_fd_pr__nfet_01v8[cgbo]
echo OPV XX1_M5 cgbo $&s1_xx1_m5_cgbo
let s1_xx1_m5_weff = @m.x1.xdut.xx1_m5.msky130_fd_pr__nfet_01v8[weff]
echo OPV XX1_M5 weff $&s1_xx1_m5_weff
let s1_xx1_m5_leff = @m.x1.xdut.xx1_m5.msky130_fd_pr__nfet_01v8[leff]
echo OPV XX1_M5 leff $&s1_xx1_m5_leff
let s1_xx1_m6_id = @m.x1.xdut.xx1_m6.msky130_fd_pr__nfet_01v8[id]
echo OPV XX1_M6 id $&s1_xx1_m6_id
let s1_xx1_m6_vgs = @m.x1.xdut.xx1_m6.msky130_fd_pr__nfet_01v8[vgs]
echo OPV XX1_M6 vgs $&s1_xx1_m6_vgs
let s1_xx1_m6_vds = @m.x1.xdut.xx1_m6.msky130_fd_pr__nfet_01v8[vds]
echo OPV XX1_M6 vds $&s1_xx1_m6_vds
let s1_xx1_m6_vbs = @m.x1.xdut.xx1_m6.msky130_fd_pr__nfet_01v8[vbs]
echo OPV XX1_M6 vbs $&s1_xx1_m6_vbs
let s1_xx1_m6_vth = @m.x1.xdut.xx1_m6.msky130_fd_pr__nfet_01v8[vth]
echo OPV XX1_M6 vth $&s1_xx1_m6_vth
let s1_xx1_m6_vdsat = @m.x1.xdut.xx1_m6.msky130_fd_pr__nfet_01v8[vdsat]
echo OPV XX1_M6 vdsat $&s1_xx1_m6_vdsat
let s1_xx1_m6_gm = @m.x1.xdut.xx1_m6.msky130_fd_pr__nfet_01v8[gm]
echo OPV XX1_M6 gm $&s1_xx1_m6_gm
let s1_xx1_m6_gds = @m.x1.xdut.xx1_m6.msky130_fd_pr__nfet_01v8[gds]
echo OPV XX1_M6 gds $&s1_xx1_m6_gds
let s1_xx1_m6_gmbs = @m.x1.xdut.xx1_m6.msky130_fd_pr__nfet_01v8[gmbs]
echo OPV XX1_M6 gmbs $&s1_xx1_m6_gmbs
let s1_xx1_m6_cgg = @m.x1.xdut.xx1_m6.msky130_fd_pr__nfet_01v8[cgg]
echo OPV XX1_M6 cgg $&s1_xx1_m6_cgg
let s1_xx1_m6_cgd = @m.x1.xdut.xx1_m6.msky130_fd_pr__nfet_01v8[cgd]
echo OPV XX1_M6 cgd $&s1_xx1_m6_cgd
let s1_xx1_m6_cgs = @m.x1.xdut.xx1_m6.msky130_fd_pr__nfet_01v8[cgs]
echo OPV XX1_M6 cgs $&s1_xx1_m6_cgs
let s1_xx1_m6_cgb = @m.x1.xdut.xx1_m6.msky130_fd_pr__nfet_01v8[cgb]
echo OPV XX1_M6 cgb $&s1_xx1_m6_cgb
let s1_xx1_m6_cdg = @m.x1.xdut.xx1_m6.msky130_fd_pr__nfet_01v8[cdg]
echo OPV XX1_M6 cdg $&s1_xx1_m6_cdg
let s1_xx1_m6_cdd = @m.x1.xdut.xx1_m6.msky130_fd_pr__nfet_01v8[cdd]
echo OPV XX1_M6 cdd $&s1_xx1_m6_cdd
let s1_xx1_m6_cds = @m.x1.xdut.xx1_m6.msky130_fd_pr__nfet_01v8[cds]
echo OPV XX1_M6 cds $&s1_xx1_m6_cds
let s1_xx1_m6_cdb = @m.x1.xdut.xx1_m6.msky130_fd_pr__nfet_01v8[cdb]
echo OPV XX1_M6 cdb $&s1_xx1_m6_cdb
let s1_xx1_m6_csg = @m.x1.xdut.xx1_m6.msky130_fd_pr__nfet_01v8[csg]
echo OPV XX1_M6 csg $&s1_xx1_m6_csg
let s1_xx1_m6_csd = @m.x1.xdut.xx1_m6.msky130_fd_pr__nfet_01v8[csd]
echo OPV XX1_M6 csd $&s1_xx1_m6_csd
let s1_xx1_m6_css = @m.x1.xdut.xx1_m6.msky130_fd_pr__nfet_01v8[css]
echo OPV XX1_M6 css $&s1_xx1_m6_css
let s1_xx1_m6_csb = @m.x1.xdut.xx1_m6.msky130_fd_pr__nfet_01v8[csb]
echo OPV XX1_M6 csb $&s1_xx1_m6_csb
let s1_xx1_m6_cbg = @m.x1.xdut.xx1_m6.msky130_fd_pr__nfet_01v8[cbg]
echo OPV XX1_M6 cbg $&s1_xx1_m6_cbg
let s1_xx1_m6_cbd = @m.x1.xdut.xx1_m6.msky130_fd_pr__nfet_01v8[cbd]
echo OPV XX1_M6 cbd $&s1_xx1_m6_cbd
let s1_xx1_m6_cbs = @m.x1.xdut.xx1_m6.msky130_fd_pr__nfet_01v8[cbs]
echo OPV XX1_M6 cbs $&s1_xx1_m6_cbs
let s1_xx1_m6_cbb = @m.x1.xdut.xx1_m6.msky130_fd_pr__nfet_01v8[cbb]
echo OPV XX1_M6 cbb $&s1_xx1_m6_cbb
let s1_xx1_m6_capbd = @m.x1.xdut.xx1_m6.msky130_fd_pr__nfet_01v8[capbd]
echo OPV XX1_M6 capbd $&s1_xx1_m6_capbd
let s1_xx1_m6_capbs = @m.x1.xdut.xx1_m6.msky130_fd_pr__nfet_01v8[capbs]
echo OPV XX1_M6 capbs $&s1_xx1_m6_capbs
let s1_xx1_m6_cgso = @m.x1.xdut.xx1_m6.msky130_fd_pr__nfet_01v8[cgso]
echo OPV XX1_M6 cgso $&s1_xx1_m6_cgso
let s1_xx1_m6_cgdo = @m.x1.xdut.xx1_m6.msky130_fd_pr__nfet_01v8[cgdo]
echo OPV XX1_M6 cgdo $&s1_xx1_m6_cgdo
let s1_xx1_m6_cgbo = @m.x1.xdut.xx1_m6.msky130_fd_pr__nfet_01v8[cgbo]
echo OPV XX1_M6 cgbo $&s1_xx1_m6_cgbo
let s1_xx1_m6_weff = @m.x1.xdut.xx1_m6.msky130_fd_pr__nfet_01v8[weff]
echo OPV XX1_M6 weff $&s1_xx1_m6_weff
let s1_xx1_m6_leff = @m.x1.xdut.xx1_m6.msky130_fd_pr__nfet_01v8[leff]
echo OPV XX1_M6 leff $&s1_xx1_m6_leff
let s1_xx1_m7_id = @m.x1.xdut.xx1_m7.msky130_fd_pr__nfet_01v8[id]
echo OPV XX1_M7 id $&s1_xx1_m7_id
let s1_xx1_m7_vgs = @m.x1.xdut.xx1_m7.msky130_fd_pr__nfet_01v8[vgs]
echo OPV XX1_M7 vgs $&s1_xx1_m7_vgs
let s1_xx1_m7_vds = @m.x1.xdut.xx1_m7.msky130_fd_pr__nfet_01v8[vds]
echo OPV XX1_M7 vds $&s1_xx1_m7_vds
let s1_xx1_m7_vbs = @m.x1.xdut.xx1_m7.msky130_fd_pr__nfet_01v8[vbs]
echo OPV XX1_M7 vbs $&s1_xx1_m7_vbs
let s1_xx1_m7_vth = @m.x1.xdut.xx1_m7.msky130_fd_pr__nfet_01v8[vth]
echo OPV XX1_M7 vth $&s1_xx1_m7_vth
let s1_xx1_m7_vdsat = @m.x1.xdut.xx1_m7.msky130_fd_pr__nfet_01v8[vdsat]
echo OPV XX1_M7 vdsat $&s1_xx1_m7_vdsat
let s1_xx1_m7_gm = @m.x1.xdut.xx1_m7.msky130_fd_pr__nfet_01v8[gm]
echo OPV XX1_M7 gm $&s1_xx1_m7_gm
let s1_xx1_m7_gds = @m.x1.xdut.xx1_m7.msky130_fd_pr__nfet_01v8[gds]
echo OPV XX1_M7 gds $&s1_xx1_m7_gds
let s1_xx1_m7_gmbs = @m.x1.xdut.xx1_m7.msky130_fd_pr__nfet_01v8[gmbs]
echo OPV XX1_M7 gmbs $&s1_xx1_m7_gmbs
let s1_xx1_m7_cgg = @m.x1.xdut.xx1_m7.msky130_fd_pr__nfet_01v8[cgg]
echo OPV XX1_M7 cgg $&s1_xx1_m7_cgg
let s1_xx1_m7_cgd = @m.x1.xdut.xx1_m7.msky130_fd_pr__nfet_01v8[cgd]
echo OPV XX1_M7 cgd $&s1_xx1_m7_cgd
let s1_xx1_m7_cgs = @m.x1.xdut.xx1_m7.msky130_fd_pr__nfet_01v8[cgs]
echo OPV XX1_M7 cgs $&s1_xx1_m7_cgs
let s1_xx1_m7_cgb = @m.x1.xdut.xx1_m7.msky130_fd_pr__nfet_01v8[cgb]
echo OPV XX1_M7 cgb $&s1_xx1_m7_cgb
let s1_xx1_m7_cdg = @m.x1.xdut.xx1_m7.msky130_fd_pr__nfet_01v8[cdg]
echo OPV XX1_M7 cdg $&s1_xx1_m7_cdg
let s1_xx1_m7_cdd = @m.x1.xdut.xx1_m7.msky130_fd_pr__nfet_01v8[cdd]
echo OPV XX1_M7 cdd $&s1_xx1_m7_cdd
let s1_xx1_m7_cds = @m.x1.xdut.xx1_m7.msky130_fd_pr__nfet_01v8[cds]
echo OPV XX1_M7 cds $&s1_xx1_m7_cds
let s1_xx1_m7_cdb = @m.x1.xdut.xx1_m7.msky130_fd_pr__nfet_01v8[cdb]
echo OPV XX1_M7 cdb $&s1_xx1_m7_cdb
let s1_xx1_m7_csg = @m.x1.xdut.xx1_m7.msky130_fd_pr__nfet_01v8[csg]
echo OPV XX1_M7 csg $&s1_xx1_m7_csg
let s1_xx1_m7_csd = @m.x1.xdut.xx1_m7.msky130_fd_pr__nfet_01v8[csd]
echo OPV XX1_M7 csd $&s1_xx1_m7_csd
let s1_xx1_m7_css = @m.x1.xdut.xx1_m7.msky130_fd_pr__nfet_01v8[css]
echo OPV XX1_M7 css $&s1_xx1_m7_css
let s1_xx1_m7_csb = @m.x1.xdut.xx1_m7.msky130_fd_pr__nfet_01v8[csb]
echo OPV XX1_M7 csb $&s1_xx1_m7_csb
let s1_xx1_m7_cbg = @m.x1.xdut.xx1_m7.msky130_fd_pr__nfet_01v8[cbg]
echo OPV XX1_M7 cbg $&s1_xx1_m7_cbg
let s1_xx1_m7_cbd = @m.x1.xdut.xx1_m7.msky130_fd_pr__nfet_01v8[cbd]
echo OPV XX1_M7 cbd $&s1_xx1_m7_cbd
let s1_xx1_m7_cbs = @m.x1.xdut.xx1_m7.msky130_fd_pr__nfet_01v8[cbs]
echo OPV XX1_M7 cbs $&s1_xx1_m7_cbs
let s1_xx1_m7_cbb = @m.x1.xdut.xx1_m7.msky130_fd_pr__nfet_01v8[cbb]
echo OPV XX1_M7 cbb $&s1_xx1_m7_cbb
let s1_xx1_m7_capbd = @m.x1.xdut.xx1_m7.msky130_fd_pr__nfet_01v8[capbd]
echo OPV XX1_M7 capbd $&s1_xx1_m7_capbd
let s1_xx1_m7_capbs = @m.x1.xdut.xx1_m7.msky130_fd_pr__nfet_01v8[capbs]
echo OPV XX1_M7 capbs $&s1_xx1_m7_capbs
let s1_xx1_m7_cgso = @m.x1.xdut.xx1_m7.msky130_fd_pr__nfet_01v8[cgso]
echo OPV XX1_M7 cgso $&s1_xx1_m7_cgso
let s1_xx1_m7_cgdo = @m.x1.xdut.xx1_m7.msky130_fd_pr__nfet_01v8[cgdo]
echo OPV XX1_M7 cgdo $&s1_xx1_m7_cgdo
let s1_xx1_m7_cgbo = @m.x1.xdut.xx1_m7.msky130_fd_pr__nfet_01v8[cgbo]
echo OPV XX1_M7 cgbo $&s1_xx1_m7_cgbo
let s1_xx1_m7_weff = @m.x1.xdut.xx1_m7.msky130_fd_pr__nfet_01v8[weff]
echo OPV XX1_M7 weff $&s1_xx1_m7_weff
let s1_xx1_m7_leff = @m.x1.xdut.xx1_m7.msky130_fd_pr__nfet_01v8[leff]
echo OPV XX1_M7 leff $&s1_xx1_m7_leff
let s1_xx1_m33_id = @m.x1.xdut.xx1_m33.msky130_fd_pr__nfet_01v8[id]
echo OPV XX1_M33 id $&s1_xx1_m33_id
let s1_xx1_m33_vgs = @m.x1.xdut.xx1_m33.msky130_fd_pr__nfet_01v8[vgs]
echo OPV XX1_M33 vgs $&s1_xx1_m33_vgs
let s1_xx1_m33_vds = @m.x1.xdut.xx1_m33.msky130_fd_pr__nfet_01v8[vds]
echo OPV XX1_M33 vds $&s1_xx1_m33_vds
let s1_xx1_m33_vbs = @m.x1.xdut.xx1_m33.msky130_fd_pr__nfet_01v8[vbs]
echo OPV XX1_M33 vbs $&s1_xx1_m33_vbs
let s1_xx1_m33_vth = @m.x1.xdut.xx1_m33.msky130_fd_pr__nfet_01v8[vth]
echo OPV XX1_M33 vth $&s1_xx1_m33_vth
let s1_xx1_m33_vdsat = @m.x1.xdut.xx1_m33.msky130_fd_pr__nfet_01v8[vdsat]
echo OPV XX1_M33 vdsat $&s1_xx1_m33_vdsat
let s1_xx1_m33_gm = @m.x1.xdut.xx1_m33.msky130_fd_pr__nfet_01v8[gm]
echo OPV XX1_M33 gm $&s1_xx1_m33_gm
let s1_xx1_m33_gds = @m.x1.xdut.xx1_m33.msky130_fd_pr__nfet_01v8[gds]
echo OPV XX1_M33 gds $&s1_xx1_m33_gds
let s1_xx1_m33_gmbs = @m.x1.xdut.xx1_m33.msky130_fd_pr__nfet_01v8[gmbs]
echo OPV XX1_M33 gmbs $&s1_xx1_m33_gmbs
let s1_xx1_m33_cgg = @m.x1.xdut.xx1_m33.msky130_fd_pr__nfet_01v8[cgg]
echo OPV XX1_M33 cgg $&s1_xx1_m33_cgg
let s1_xx1_m33_cgd = @m.x1.xdut.xx1_m33.msky130_fd_pr__nfet_01v8[cgd]
echo OPV XX1_M33 cgd $&s1_xx1_m33_cgd
let s1_xx1_m33_cgs = @m.x1.xdut.xx1_m33.msky130_fd_pr__nfet_01v8[cgs]
echo OPV XX1_M33 cgs $&s1_xx1_m33_cgs
let s1_xx1_m33_cgb = @m.x1.xdut.xx1_m33.msky130_fd_pr__nfet_01v8[cgb]
echo OPV XX1_M33 cgb $&s1_xx1_m33_cgb
let s1_xx1_m33_cdg = @m.x1.xdut.xx1_m33.msky130_fd_pr__nfet_01v8[cdg]
echo OPV XX1_M33 cdg $&s1_xx1_m33_cdg
let s1_xx1_m33_cdd = @m.x1.xdut.xx1_m33.msky130_fd_pr__nfet_01v8[cdd]
echo OPV XX1_M33 cdd $&s1_xx1_m33_cdd
let s1_xx1_m33_cds = @m.x1.xdut.xx1_m33.msky130_fd_pr__nfet_01v8[cds]
echo OPV XX1_M33 cds $&s1_xx1_m33_cds
let s1_xx1_m33_cdb = @m.x1.xdut.xx1_m33.msky130_fd_pr__nfet_01v8[cdb]
echo OPV XX1_M33 cdb $&s1_xx1_m33_cdb
let s1_xx1_m33_csg = @m.x1.xdut.xx1_m33.msky130_fd_pr__nfet_01v8[csg]
echo OPV XX1_M33 csg $&s1_xx1_m33_csg
let s1_xx1_m33_csd = @m.x1.xdut.xx1_m33.msky130_fd_pr__nfet_01v8[csd]
echo OPV XX1_M33 csd $&s1_xx1_m33_csd
let s1_xx1_m33_css = @m.x1.xdut.xx1_m33.msky130_fd_pr__nfet_01v8[css]
echo OPV XX1_M33 css $&s1_xx1_m33_css
let s1_xx1_m33_csb = @m.x1.xdut.xx1_m33.msky130_fd_pr__nfet_01v8[csb]
echo OPV XX1_M33 csb $&s1_xx1_m33_csb
let s1_xx1_m33_cbg = @m.x1.xdut.xx1_m33.msky130_fd_pr__nfet_01v8[cbg]
echo OPV XX1_M33 cbg $&s1_xx1_m33_cbg
let s1_xx1_m33_cbd = @m.x1.xdut.xx1_m33.msky130_fd_pr__nfet_01v8[cbd]
echo OPV XX1_M33 cbd $&s1_xx1_m33_cbd
let s1_xx1_m33_cbs = @m.x1.xdut.xx1_m33.msky130_fd_pr__nfet_01v8[cbs]
echo OPV XX1_M33 cbs $&s1_xx1_m33_cbs
let s1_xx1_m33_cbb = @m.x1.xdut.xx1_m33.msky130_fd_pr__nfet_01v8[cbb]
echo OPV XX1_M33 cbb $&s1_xx1_m33_cbb
let s1_xx1_m33_capbd = @m.x1.xdut.xx1_m33.msky130_fd_pr__nfet_01v8[capbd]
echo OPV XX1_M33 capbd $&s1_xx1_m33_capbd
let s1_xx1_m33_capbs = @m.x1.xdut.xx1_m33.msky130_fd_pr__nfet_01v8[capbs]
echo OPV XX1_M33 capbs $&s1_xx1_m33_capbs
let s1_xx1_m33_cgso = @m.x1.xdut.xx1_m33.msky130_fd_pr__nfet_01v8[cgso]
echo OPV XX1_M33 cgso $&s1_xx1_m33_cgso
let s1_xx1_m33_cgdo = @m.x1.xdut.xx1_m33.msky130_fd_pr__nfet_01v8[cgdo]
echo OPV XX1_M33 cgdo $&s1_xx1_m33_cgdo
let s1_xx1_m33_cgbo = @m.x1.xdut.xx1_m33.msky130_fd_pr__nfet_01v8[cgbo]
echo OPV XX1_M33 cgbo $&s1_xx1_m33_cgbo
let s1_xx1_m33_weff = @m.x1.xdut.xx1_m33.msky130_fd_pr__nfet_01v8[weff]
echo OPV XX1_M33 weff $&s1_xx1_m33_weff
let s1_xx1_m33_leff = @m.x1.xdut.xx1_m33.msky130_fd_pr__nfet_01v8[leff]
echo OPV XX1_M33 leff $&s1_xx1_m33_leff
let s1_xx1_m49_id = @m.x1.xdut.xx1_m49.msky130_fd_pr__nfet_01v8[id]
echo OPV XX1_M49 id $&s1_xx1_m49_id
let s1_xx1_m49_vgs = @m.x1.xdut.xx1_m49.msky130_fd_pr__nfet_01v8[vgs]
echo OPV XX1_M49 vgs $&s1_xx1_m49_vgs
let s1_xx1_m49_vds = @m.x1.xdut.xx1_m49.msky130_fd_pr__nfet_01v8[vds]
echo OPV XX1_M49 vds $&s1_xx1_m49_vds
let s1_xx1_m49_vbs = @m.x1.xdut.xx1_m49.msky130_fd_pr__nfet_01v8[vbs]
echo OPV XX1_M49 vbs $&s1_xx1_m49_vbs
let s1_xx1_m49_vth = @m.x1.xdut.xx1_m49.msky130_fd_pr__nfet_01v8[vth]
echo OPV XX1_M49 vth $&s1_xx1_m49_vth
let s1_xx1_m49_vdsat = @m.x1.xdut.xx1_m49.msky130_fd_pr__nfet_01v8[vdsat]
echo OPV XX1_M49 vdsat $&s1_xx1_m49_vdsat
let s1_xx1_m49_gm = @m.x1.xdut.xx1_m49.msky130_fd_pr__nfet_01v8[gm]
echo OPV XX1_M49 gm $&s1_xx1_m49_gm
let s1_xx1_m49_gds = @m.x1.xdut.xx1_m49.msky130_fd_pr__nfet_01v8[gds]
echo OPV XX1_M49 gds $&s1_xx1_m49_gds
let s1_xx1_m49_gmbs = @m.x1.xdut.xx1_m49.msky130_fd_pr__nfet_01v8[gmbs]
echo OPV XX1_M49 gmbs $&s1_xx1_m49_gmbs
let s1_xx1_m49_cgg = @m.x1.xdut.xx1_m49.msky130_fd_pr__nfet_01v8[cgg]
echo OPV XX1_M49 cgg $&s1_xx1_m49_cgg
let s1_xx1_m49_cgd = @m.x1.xdut.xx1_m49.msky130_fd_pr__nfet_01v8[cgd]
echo OPV XX1_M49 cgd $&s1_xx1_m49_cgd
let s1_xx1_m49_cgs = @m.x1.xdut.xx1_m49.msky130_fd_pr__nfet_01v8[cgs]
echo OPV XX1_M49 cgs $&s1_xx1_m49_cgs
let s1_xx1_m49_cgb = @m.x1.xdut.xx1_m49.msky130_fd_pr__nfet_01v8[cgb]
echo OPV XX1_M49 cgb $&s1_xx1_m49_cgb
let s1_xx1_m49_cdg = @m.x1.xdut.xx1_m49.msky130_fd_pr__nfet_01v8[cdg]
echo OPV XX1_M49 cdg $&s1_xx1_m49_cdg
let s1_xx1_m49_cdd = @m.x1.xdut.xx1_m49.msky130_fd_pr__nfet_01v8[cdd]
echo OPV XX1_M49 cdd $&s1_xx1_m49_cdd
let s1_xx1_m49_cds = @m.x1.xdut.xx1_m49.msky130_fd_pr__nfet_01v8[cds]
echo OPV XX1_M49 cds $&s1_xx1_m49_cds
let s1_xx1_m49_cdb = @m.x1.xdut.xx1_m49.msky130_fd_pr__nfet_01v8[cdb]
echo OPV XX1_M49 cdb $&s1_xx1_m49_cdb
let s1_xx1_m49_csg = @m.x1.xdut.xx1_m49.msky130_fd_pr__nfet_01v8[csg]
echo OPV XX1_M49 csg $&s1_xx1_m49_csg
let s1_xx1_m49_csd = @m.x1.xdut.xx1_m49.msky130_fd_pr__nfet_01v8[csd]
echo OPV XX1_M49 csd $&s1_xx1_m49_csd
let s1_xx1_m49_css = @m.x1.xdut.xx1_m49.msky130_fd_pr__nfet_01v8[css]
echo OPV XX1_M49 css $&s1_xx1_m49_css
let s1_xx1_m49_csb = @m.x1.xdut.xx1_m49.msky130_fd_pr__nfet_01v8[csb]
echo OPV XX1_M49 csb $&s1_xx1_m49_csb
let s1_xx1_m49_cbg = @m.x1.xdut.xx1_m49.msky130_fd_pr__nfet_01v8[cbg]
echo OPV XX1_M49 cbg $&s1_xx1_m49_cbg
let s1_xx1_m49_cbd = @m.x1.xdut.xx1_m49.msky130_fd_pr__nfet_01v8[cbd]
echo OPV XX1_M49 cbd $&s1_xx1_m49_cbd
let s1_xx1_m49_cbs = @m.x1.xdut.xx1_m49.msky130_fd_pr__nfet_01v8[cbs]
echo OPV XX1_M49 cbs $&s1_xx1_m49_cbs
let s1_xx1_m49_cbb = @m.x1.xdut.xx1_m49.msky130_fd_pr__nfet_01v8[cbb]
echo OPV XX1_M49 cbb $&s1_xx1_m49_cbb
let s1_xx1_m49_capbd = @m.x1.xdut.xx1_m49.msky130_fd_pr__nfet_01v8[capbd]
echo OPV XX1_M49 capbd $&s1_xx1_m49_capbd
let s1_xx1_m49_capbs = @m.x1.xdut.xx1_m49.msky130_fd_pr__nfet_01v8[capbs]
echo OPV XX1_M49 capbs $&s1_xx1_m49_capbs
let s1_xx1_m49_cgso = @m.x1.xdut.xx1_m49.msky130_fd_pr__nfet_01v8[cgso]
echo OPV XX1_M49 cgso $&s1_xx1_m49_cgso
let s1_xx1_m49_cgdo = @m.x1.xdut.xx1_m49.msky130_fd_pr__nfet_01v8[cgdo]
echo OPV XX1_M49 cgdo $&s1_xx1_m49_cgdo
let s1_xx1_m49_cgbo = @m.x1.xdut.xx1_m49.msky130_fd_pr__nfet_01v8[cgbo]
echo OPV XX1_M49 cgbo $&s1_xx1_m49_cgbo
let s1_xx1_m49_weff = @m.x1.xdut.xx1_m49.msky130_fd_pr__nfet_01v8[weff]
echo OPV XX1_M49 weff $&s1_xx1_m49_weff
let s1_xx1_m49_leff = @m.x1.xdut.xx1_m49.msky130_fd_pr__nfet_01v8[leff]
echo OPV XX1_M49 leff $&s1_xx1_m49_leff
let s1_xx1_m50_id = @m.x1.xdut.xx1_m50.msky130_fd_pr__nfet_01v8[id]
echo OPV XX1_M50 id $&s1_xx1_m50_id
let s1_xx1_m50_vgs = @m.x1.xdut.xx1_m50.msky130_fd_pr__nfet_01v8[vgs]
echo OPV XX1_M50 vgs $&s1_xx1_m50_vgs
let s1_xx1_m50_vds = @m.x1.xdut.xx1_m50.msky130_fd_pr__nfet_01v8[vds]
echo OPV XX1_M50 vds $&s1_xx1_m50_vds
let s1_xx1_m50_vbs = @m.x1.xdut.xx1_m50.msky130_fd_pr__nfet_01v8[vbs]
echo OPV XX1_M50 vbs $&s1_xx1_m50_vbs
let s1_xx1_m50_vth = @m.x1.xdut.xx1_m50.msky130_fd_pr__nfet_01v8[vth]
echo OPV XX1_M50 vth $&s1_xx1_m50_vth
let s1_xx1_m50_vdsat = @m.x1.xdut.xx1_m50.msky130_fd_pr__nfet_01v8[vdsat]
echo OPV XX1_M50 vdsat $&s1_xx1_m50_vdsat
let s1_xx1_m50_gm = @m.x1.xdut.xx1_m50.msky130_fd_pr__nfet_01v8[gm]
echo OPV XX1_M50 gm $&s1_xx1_m50_gm
let s1_xx1_m50_gds = @m.x1.xdut.xx1_m50.msky130_fd_pr__nfet_01v8[gds]
echo OPV XX1_M50 gds $&s1_xx1_m50_gds
let s1_xx1_m50_gmbs = @m.x1.xdut.xx1_m50.msky130_fd_pr__nfet_01v8[gmbs]
echo OPV XX1_M50 gmbs $&s1_xx1_m50_gmbs
let s1_xx1_m50_cgg = @m.x1.xdut.xx1_m50.msky130_fd_pr__nfet_01v8[cgg]
echo OPV XX1_M50 cgg $&s1_xx1_m50_cgg
let s1_xx1_m50_cgd = @m.x1.xdut.xx1_m50.msky130_fd_pr__nfet_01v8[cgd]
echo OPV XX1_M50 cgd $&s1_xx1_m50_cgd
let s1_xx1_m50_cgs = @m.x1.xdut.xx1_m50.msky130_fd_pr__nfet_01v8[cgs]
echo OPV XX1_M50 cgs $&s1_xx1_m50_cgs
let s1_xx1_m50_cgb = @m.x1.xdut.xx1_m50.msky130_fd_pr__nfet_01v8[cgb]
echo OPV XX1_M50 cgb $&s1_xx1_m50_cgb
let s1_xx1_m50_cdg = @m.x1.xdut.xx1_m50.msky130_fd_pr__nfet_01v8[cdg]
echo OPV XX1_M50 cdg $&s1_xx1_m50_cdg
let s1_xx1_m50_cdd = @m.x1.xdut.xx1_m50.msky130_fd_pr__nfet_01v8[cdd]
echo OPV XX1_M50 cdd $&s1_xx1_m50_cdd
let s1_xx1_m50_cds = @m.x1.xdut.xx1_m50.msky130_fd_pr__nfet_01v8[cds]
echo OPV XX1_M50 cds $&s1_xx1_m50_cds
let s1_xx1_m50_cdb = @m.x1.xdut.xx1_m50.msky130_fd_pr__nfet_01v8[cdb]
echo OPV XX1_M50 cdb $&s1_xx1_m50_cdb
let s1_xx1_m50_csg = @m.x1.xdut.xx1_m50.msky130_fd_pr__nfet_01v8[csg]
echo OPV XX1_M50 csg $&s1_xx1_m50_csg
let s1_xx1_m50_csd = @m.x1.xdut.xx1_m50.msky130_fd_pr__nfet_01v8[csd]
echo OPV XX1_M50 csd $&s1_xx1_m50_csd
let s1_xx1_m50_css = @m.x1.xdut.xx1_m50.msky130_fd_pr__nfet_01v8[css]
echo OPV XX1_M50 css $&s1_xx1_m50_css
let s1_xx1_m50_csb = @m.x1.xdut.xx1_m50.msky130_fd_pr__nfet_01v8[csb]
echo OPV XX1_M50 csb $&s1_xx1_m50_csb
let s1_xx1_m50_cbg = @m.x1.xdut.xx1_m50.msky130_fd_pr__nfet_01v8[cbg]
echo OPV XX1_M50 cbg $&s1_xx1_m50_cbg
let s1_xx1_m50_cbd = @m.x1.xdut.xx1_m50.msky130_fd_pr__nfet_01v8[cbd]
echo OPV XX1_M50 cbd $&s1_xx1_m50_cbd
let s1_xx1_m50_cbs = @m.x1.xdut.xx1_m50.msky130_fd_pr__nfet_01v8[cbs]
echo OPV XX1_M50 cbs $&s1_xx1_m50_cbs
let s1_xx1_m50_cbb = @m.x1.xdut.xx1_m50.msky130_fd_pr__nfet_01v8[cbb]
echo OPV XX1_M50 cbb $&s1_xx1_m50_cbb
let s1_xx1_m50_capbd = @m.x1.xdut.xx1_m50.msky130_fd_pr__nfet_01v8[capbd]
echo OPV XX1_M50 capbd $&s1_xx1_m50_capbd
let s1_xx1_m50_capbs = @m.x1.xdut.xx1_m50.msky130_fd_pr__nfet_01v8[capbs]
echo OPV XX1_M50 capbs $&s1_xx1_m50_capbs
let s1_xx1_m50_cgso = @m.x1.xdut.xx1_m50.msky130_fd_pr__nfet_01v8[cgso]
echo OPV XX1_M50 cgso $&s1_xx1_m50_cgso
let s1_xx1_m50_cgdo = @m.x1.xdut.xx1_m50.msky130_fd_pr__nfet_01v8[cgdo]
echo OPV XX1_M50 cgdo $&s1_xx1_m50_cgdo
let s1_xx1_m50_cgbo = @m.x1.xdut.xx1_m50.msky130_fd_pr__nfet_01v8[cgbo]
echo OPV XX1_M50 cgbo $&s1_xx1_m50_cgbo
let s1_xx1_m50_weff = @m.x1.xdut.xx1_m50.msky130_fd_pr__nfet_01v8[weff]
echo OPV XX1_M50 weff $&s1_xx1_m50_weff
let s1_xx1_m50_leff = @m.x1.xdut.xx1_m50.msky130_fd_pr__nfet_01v8[leff]
echo OPV XX1_M50 leff $&s1_xx1_m50_leff
let s1_xx1_m63_id = @m.x1.xdut.xx1_m63.msky130_fd_pr__nfet_01v8[id]
echo OPV XX1_M63 id $&s1_xx1_m63_id
let s1_xx1_m63_vgs = @m.x1.xdut.xx1_m63.msky130_fd_pr__nfet_01v8[vgs]
echo OPV XX1_M63 vgs $&s1_xx1_m63_vgs
let s1_xx1_m63_vds = @m.x1.xdut.xx1_m63.msky130_fd_pr__nfet_01v8[vds]
echo OPV XX1_M63 vds $&s1_xx1_m63_vds
let s1_xx1_m63_vbs = @m.x1.xdut.xx1_m63.msky130_fd_pr__nfet_01v8[vbs]
echo OPV XX1_M63 vbs $&s1_xx1_m63_vbs
let s1_xx1_m63_vth = @m.x1.xdut.xx1_m63.msky130_fd_pr__nfet_01v8[vth]
echo OPV XX1_M63 vth $&s1_xx1_m63_vth
let s1_xx1_m63_vdsat = @m.x1.xdut.xx1_m63.msky130_fd_pr__nfet_01v8[vdsat]
echo OPV XX1_M63 vdsat $&s1_xx1_m63_vdsat
let s1_xx1_m63_gm = @m.x1.xdut.xx1_m63.msky130_fd_pr__nfet_01v8[gm]
echo OPV XX1_M63 gm $&s1_xx1_m63_gm
let s1_xx1_m63_gds = @m.x1.xdut.xx1_m63.msky130_fd_pr__nfet_01v8[gds]
echo OPV XX1_M63 gds $&s1_xx1_m63_gds
let s1_xx1_m63_gmbs = @m.x1.xdut.xx1_m63.msky130_fd_pr__nfet_01v8[gmbs]
echo OPV XX1_M63 gmbs $&s1_xx1_m63_gmbs
let s1_xx1_m63_cgg = @m.x1.xdut.xx1_m63.msky130_fd_pr__nfet_01v8[cgg]
echo OPV XX1_M63 cgg $&s1_xx1_m63_cgg
let s1_xx1_m63_cgd = @m.x1.xdut.xx1_m63.msky130_fd_pr__nfet_01v8[cgd]
echo OPV XX1_M63 cgd $&s1_xx1_m63_cgd
let s1_xx1_m63_cgs = @m.x1.xdut.xx1_m63.msky130_fd_pr__nfet_01v8[cgs]
echo OPV XX1_M63 cgs $&s1_xx1_m63_cgs
let s1_xx1_m63_cgb = @m.x1.xdut.xx1_m63.msky130_fd_pr__nfet_01v8[cgb]
echo OPV XX1_M63 cgb $&s1_xx1_m63_cgb
let s1_xx1_m63_cdg = @m.x1.xdut.xx1_m63.msky130_fd_pr__nfet_01v8[cdg]
echo OPV XX1_M63 cdg $&s1_xx1_m63_cdg
let s1_xx1_m63_cdd = @m.x1.xdut.xx1_m63.msky130_fd_pr__nfet_01v8[cdd]
echo OPV XX1_M63 cdd $&s1_xx1_m63_cdd
let s1_xx1_m63_cds = @m.x1.xdut.xx1_m63.msky130_fd_pr__nfet_01v8[cds]
echo OPV XX1_M63 cds $&s1_xx1_m63_cds
let s1_xx1_m63_cdb = @m.x1.xdut.xx1_m63.msky130_fd_pr__nfet_01v8[cdb]
echo OPV XX1_M63 cdb $&s1_xx1_m63_cdb
let s1_xx1_m63_csg = @m.x1.xdut.xx1_m63.msky130_fd_pr__nfet_01v8[csg]
echo OPV XX1_M63 csg $&s1_xx1_m63_csg
let s1_xx1_m63_csd = @m.x1.xdut.xx1_m63.msky130_fd_pr__nfet_01v8[csd]
echo OPV XX1_M63 csd $&s1_xx1_m63_csd
let s1_xx1_m63_css = @m.x1.xdut.xx1_m63.msky130_fd_pr__nfet_01v8[css]
echo OPV XX1_M63 css $&s1_xx1_m63_css
let s1_xx1_m63_csb = @m.x1.xdut.xx1_m63.msky130_fd_pr__nfet_01v8[csb]
echo OPV XX1_M63 csb $&s1_xx1_m63_csb
let s1_xx1_m63_cbg = @m.x1.xdut.xx1_m63.msky130_fd_pr__nfet_01v8[cbg]
echo OPV XX1_M63 cbg $&s1_xx1_m63_cbg
let s1_xx1_m63_cbd = @m.x1.xdut.xx1_m63.msky130_fd_pr__nfet_01v8[cbd]
echo OPV XX1_M63 cbd $&s1_xx1_m63_cbd
let s1_xx1_m63_cbs = @m.x1.xdut.xx1_m63.msky130_fd_pr__nfet_01v8[cbs]
echo OPV XX1_M63 cbs $&s1_xx1_m63_cbs
let s1_xx1_m63_cbb = @m.x1.xdut.xx1_m63.msky130_fd_pr__nfet_01v8[cbb]
echo OPV XX1_M63 cbb $&s1_xx1_m63_cbb
let s1_xx1_m63_capbd = @m.x1.xdut.xx1_m63.msky130_fd_pr__nfet_01v8[capbd]
echo OPV XX1_M63 capbd $&s1_xx1_m63_capbd
let s1_xx1_m63_capbs = @m.x1.xdut.xx1_m63.msky130_fd_pr__nfet_01v8[capbs]
echo OPV XX1_M63 capbs $&s1_xx1_m63_capbs
let s1_xx1_m63_cgso = @m.x1.xdut.xx1_m63.msky130_fd_pr__nfet_01v8[cgso]
echo OPV XX1_M63 cgso $&s1_xx1_m63_cgso
let s1_xx1_m63_cgdo = @m.x1.xdut.xx1_m63.msky130_fd_pr__nfet_01v8[cgdo]
echo OPV XX1_M63 cgdo $&s1_xx1_m63_cgdo
let s1_xx1_m63_cgbo = @m.x1.xdut.xx1_m63.msky130_fd_pr__nfet_01v8[cgbo]
echo OPV XX1_M63 cgbo $&s1_xx1_m63_cgbo
let s1_xx1_m63_weff = @m.x1.xdut.xx1_m63.msky130_fd_pr__nfet_01v8[weff]
echo OPV XX1_M63 weff $&s1_xx1_m63_weff
let s1_xx1_m63_leff = @m.x1.xdut.xx1_m63.msky130_fd_pr__nfet_01v8[leff]
echo OPV XX1_M63 leff $&s1_xx1_m63_leff
let s1_xx1_m68_id = @m.x1.xdut.xx1_m68.msky130_fd_pr__nfet_01v8[id]
echo OPV XX1_M68 id $&s1_xx1_m68_id
let s1_xx1_m68_vgs = @m.x1.xdut.xx1_m68.msky130_fd_pr__nfet_01v8[vgs]
echo OPV XX1_M68 vgs $&s1_xx1_m68_vgs
let s1_xx1_m68_vds = @m.x1.xdut.xx1_m68.msky130_fd_pr__nfet_01v8[vds]
echo OPV XX1_M68 vds $&s1_xx1_m68_vds
let s1_xx1_m68_vbs = @m.x1.xdut.xx1_m68.msky130_fd_pr__nfet_01v8[vbs]
echo OPV XX1_M68 vbs $&s1_xx1_m68_vbs
let s1_xx1_m68_vth = @m.x1.xdut.xx1_m68.msky130_fd_pr__nfet_01v8[vth]
echo OPV XX1_M68 vth $&s1_xx1_m68_vth
let s1_xx1_m68_vdsat = @m.x1.xdut.xx1_m68.msky130_fd_pr__nfet_01v8[vdsat]
echo OPV XX1_M68 vdsat $&s1_xx1_m68_vdsat
let s1_xx1_m68_gm = @m.x1.xdut.xx1_m68.msky130_fd_pr__nfet_01v8[gm]
echo OPV XX1_M68 gm $&s1_xx1_m68_gm
let s1_xx1_m68_gds = @m.x1.xdut.xx1_m68.msky130_fd_pr__nfet_01v8[gds]
echo OPV XX1_M68 gds $&s1_xx1_m68_gds
let s1_xx1_m68_gmbs = @m.x1.xdut.xx1_m68.msky130_fd_pr__nfet_01v8[gmbs]
echo OPV XX1_M68 gmbs $&s1_xx1_m68_gmbs
let s1_xx1_m68_cgg = @m.x1.xdut.xx1_m68.msky130_fd_pr__nfet_01v8[cgg]
echo OPV XX1_M68 cgg $&s1_xx1_m68_cgg
let s1_xx1_m68_cgd = @m.x1.xdut.xx1_m68.msky130_fd_pr__nfet_01v8[cgd]
echo OPV XX1_M68 cgd $&s1_xx1_m68_cgd
let s1_xx1_m68_cgs = @m.x1.xdut.xx1_m68.msky130_fd_pr__nfet_01v8[cgs]
echo OPV XX1_M68 cgs $&s1_xx1_m68_cgs
let s1_xx1_m68_cgb = @m.x1.xdut.xx1_m68.msky130_fd_pr__nfet_01v8[cgb]
echo OPV XX1_M68 cgb $&s1_xx1_m68_cgb
let s1_xx1_m68_cdg = @m.x1.xdut.xx1_m68.msky130_fd_pr__nfet_01v8[cdg]
echo OPV XX1_M68 cdg $&s1_xx1_m68_cdg
let s1_xx1_m68_cdd = @m.x1.xdut.xx1_m68.msky130_fd_pr__nfet_01v8[cdd]
echo OPV XX1_M68 cdd $&s1_xx1_m68_cdd
let s1_xx1_m68_cds = @m.x1.xdut.xx1_m68.msky130_fd_pr__nfet_01v8[cds]
echo OPV XX1_M68 cds $&s1_xx1_m68_cds
let s1_xx1_m68_cdb = @m.x1.xdut.xx1_m68.msky130_fd_pr__nfet_01v8[cdb]
echo OPV XX1_M68 cdb $&s1_xx1_m68_cdb
let s1_xx1_m68_csg = @m.x1.xdut.xx1_m68.msky130_fd_pr__nfet_01v8[csg]
echo OPV XX1_M68 csg $&s1_xx1_m68_csg
let s1_xx1_m68_csd = @m.x1.xdut.xx1_m68.msky130_fd_pr__nfet_01v8[csd]
echo OPV XX1_M68 csd $&s1_xx1_m68_csd
let s1_xx1_m68_css = @m.x1.xdut.xx1_m68.msky130_fd_pr__nfet_01v8[css]
echo OPV XX1_M68 css $&s1_xx1_m68_css
let s1_xx1_m68_csb = @m.x1.xdut.xx1_m68.msky130_fd_pr__nfet_01v8[csb]
echo OPV XX1_M68 csb $&s1_xx1_m68_csb
let s1_xx1_m68_cbg = @m.x1.xdut.xx1_m68.msky130_fd_pr__nfet_01v8[cbg]
echo OPV XX1_M68 cbg $&s1_xx1_m68_cbg
let s1_xx1_m68_cbd = @m.x1.xdut.xx1_m68.msky130_fd_pr__nfet_01v8[cbd]
echo OPV XX1_M68 cbd $&s1_xx1_m68_cbd
let s1_xx1_m68_cbs = @m.x1.xdut.xx1_m68.msky130_fd_pr__nfet_01v8[cbs]
echo OPV XX1_M68 cbs $&s1_xx1_m68_cbs
let s1_xx1_m68_cbb = @m.x1.xdut.xx1_m68.msky130_fd_pr__nfet_01v8[cbb]
echo OPV XX1_M68 cbb $&s1_xx1_m68_cbb
let s1_xx1_m68_capbd = @m.x1.xdut.xx1_m68.msky130_fd_pr__nfet_01v8[capbd]
echo OPV XX1_M68 capbd $&s1_xx1_m68_capbd
let s1_xx1_m68_capbs = @m.x1.xdut.xx1_m68.msky130_fd_pr__nfet_01v8[capbs]
echo OPV XX1_M68 capbs $&s1_xx1_m68_capbs
let s1_xx1_m68_cgso = @m.x1.xdut.xx1_m68.msky130_fd_pr__nfet_01v8[cgso]
echo OPV XX1_M68 cgso $&s1_xx1_m68_cgso
let s1_xx1_m68_cgdo = @m.x1.xdut.xx1_m68.msky130_fd_pr__nfet_01v8[cgdo]
echo OPV XX1_M68 cgdo $&s1_xx1_m68_cgdo
let s1_xx1_m68_cgbo = @m.x1.xdut.xx1_m68.msky130_fd_pr__nfet_01v8[cgbo]
echo OPV XX1_M68 cgbo $&s1_xx1_m68_cgbo
let s1_xx1_m68_weff = @m.x1.xdut.xx1_m68.msky130_fd_pr__nfet_01v8[weff]
echo OPV XX1_M68 weff $&s1_xx1_m68_weff
let s1_xx1_m68_leff = @m.x1.xdut.xx1_m68.msky130_fd_pr__nfet_01v8[leff]
echo OPV XX1_M68 leff $&s1_xx1_m68_leff
let s1_xx1_m69_id = @m.x1.xdut.xx1_m69.msky130_fd_pr__nfet_01v8[id]
echo OPV XX1_M69 id $&s1_xx1_m69_id
let s1_xx1_m69_vgs = @m.x1.xdut.xx1_m69.msky130_fd_pr__nfet_01v8[vgs]
echo OPV XX1_M69 vgs $&s1_xx1_m69_vgs
let s1_xx1_m69_vds = @m.x1.xdut.xx1_m69.msky130_fd_pr__nfet_01v8[vds]
echo OPV XX1_M69 vds $&s1_xx1_m69_vds
let s1_xx1_m69_vbs = @m.x1.xdut.xx1_m69.msky130_fd_pr__nfet_01v8[vbs]
echo OPV XX1_M69 vbs $&s1_xx1_m69_vbs
let s1_xx1_m69_vth = @m.x1.xdut.xx1_m69.msky130_fd_pr__nfet_01v8[vth]
echo OPV XX1_M69 vth $&s1_xx1_m69_vth
let s1_xx1_m69_vdsat = @m.x1.xdut.xx1_m69.msky130_fd_pr__nfet_01v8[vdsat]
echo OPV XX1_M69 vdsat $&s1_xx1_m69_vdsat
let s1_xx1_m69_gm = @m.x1.xdut.xx1_m69.msky130_fd_pr__nfet_01v8[gm]
echo OPV XX1_M69 gm $&s1_xx1_m69_gm
let s1_xx1_m69_gds = @m.x1.xdut.xx1_m69.msky130_fd_pr__nfet_01v8[gds]
echo OPV XX1_M69 gds $&s1_xx1_m69_gds
let s1_xx1_m69_gmbs = @m.x1.xdut.xx1_m69.msky130_fd_pr__nfet_01v8[gmbs]
echo OPV XX1_M69 gmbs $&s1_xx1_m69_gmbs
let s1_xx1_m69_cgg = @m.x1.xdut.xx1_m69.msky130_fd_pr__nfet_01v8[cgg]
echo OPV XX1_M69 cgg $&s1_xx1_m69_cgg
let s1_xx1_m69_cgd = @m.x1.xdut.xx1_m69.msky130_fd_pr__nfet_01v8[cgd]
echo OPV XX1_M69 cgd $&s1_xx1_m69_cgd
let s1_xx1_m69_cgs = @m.x1.xdut.xx1_m69.msky130_fd_pr__nfet_01v8[cgs]
echo OPV XX1_M69 cgs $&s1_xx1_m69_cgs
let s1_xx1_m69_cgb = @m.x1.xdut.xx1_m69.msky130_fd_pr__nfet_01v8[cgb]
echo OPV XX1_M69 cgb $&s1_xx1_m69_cgb
let s1_xx1_m69_cdg = @m.x1.xdut.xx1_m69.msky130_fd_pr__nfet_01v8[cdg]
echo OPV XX1_M69 cdg $&s1_xx1_m69_cdg
let s1_xx1_m69_cdd = @m.x1.xdut.xx1_m69.msky130_fd_pr__nfet_01v8[cdd]
echo OPV XX1_M69 cdd $&s1_xx1_m69_cdd
let s1_xx1_m69_cds = @m.x1.xdut.xx1_m69.msky130_fd_pr__nfet_01v8[cds]
echo OPV XX1_M69 cds $&s1_xx1_m69_cds
let s1_xx1_m69_cdb = @m.x1.xdut.xx1_m69.msky130_fd_pr__nfet_01v8[cdb]
echo OPV XX1_M69 cdb $&s1_xx1_m69_cdb
let s1_xx1_m69_csg = @m.x1.xdut.xx1_m69.msky130_fd_pr__nfet_01v8[csg]
echo OPV XX1_M69 csg $&s1_xx1_m69_csg
let s1_xx1_m69_csd = @m.x1.xdut.xx1_m69.msky130_fd_pr__nfet_01v8[csd]
echo OPV XX1_M69 csd $&s1_xx1_m69_csd
let s1_xx1_m69_css = @m.x1.xdut.xx1_m69.msky130_fd_pr__nfet_01v8[css]
echo OPV XX1_M69 css $&s1_xx1_m69_css
let s1_xx1_m69_csb = @m.x1.xdut.xx1_m69.msky130_fd_pr__nfet_01v8[csb]
echo OPV XX1_M69 csb $&s1_xx1_m69_csb
let s1_xx1_m69_cbg = @m.x1.xdut.xx1_m69.msky130_fd_pr__nfet_01v8[cbg]
echo OPV XX1_M69 cbg $&s1_xx1_m69_cbg
let s1_xx1_m69_cbd = @m.x1.xdut.xx1_m69.msky130_fd_pr__nfet_01v8[cbd]
echo OPV XX1_M69 cbd $&s1_xx1_m69_cbd
let s1_xx1_m69_cbs = @m.x1.xdut.xx1_m69.msky130_fd_pr__nfet_01v8[cbs]
echo OPV XX1_M69 cbs $&s1_xx1_m69_cbs
let s1_xx1_m69_cbb = @m.x1.xdut.xx1_m69.msky130_fd_pr__nfet_01v8[cbb]
echo OPV XX1_M69 cbb $&s1_xx1_m69_cbb
let s1_xx1_m69_capbd = @m.x1.xdut.xx1_m69.msky130_fd_pr__nfet_01v8[capbd]
echo OPV XX1_M69 capbd $&s1_xx1_m69_capbd
let s1_xx1_m69_capbs = @m.x1.xdut.xx1_m69.msky130_fd_pr__nfet_01v8[capbs]
echo OPV XX1_M69 capbs $&s1_xx1_m69_capbs
let s1_xx1_m69_cgso = @m.x1.xdut.xx1_m69.msky130_fd_pr__nfet_01v8[cgso]
echo OPV XX1_M69 cgso $&s1_xx1_m69_cgso
let s1_xx1_m69_cgdo = @m.x1.xdut.xx1_m69.msky130_fd_pr__nfet_01v8[cgdo]
echo OPV XX1_M69 cgdo $&s1_xx1_m69_cgdo
let s1_xx1_m69_cgbo = @m.x1.xdut.xx1_m69.msky130_fd_pr__nfet_01v8[cgbo]
echo OPV XX1_M69 cgbo $&s1_xx1_m69_cgbo
let s1_xx1_m69_weff = @m.x1.xdut.xx1_m69.msky130_fd_pr__nfet_01v8[weff]
echo OPV XX1_M69 weff $&s1_xx1_m69_weff
let s1_xx1_m69_leff = @m.x1.xdut.xx1_m69.msky130_fd_pr__nfet_01v8[leff]
echo OPV XX1_M69 leff $&s1_xx1_m69_leff
let s1_xx1_m70_id = @m.x1.xdut.xx1_m70.msky130_fd_pr__nfet_01v8[id]
echo OPV XX1_M70 id $&s1_xx1_m70_id
let s1_xx1_m70_vgs = @m.x1.xdut.xx1_m70.msky130_fd_pr__nfet_01v8[vgs]
echo OPV XX1_M70 vgs $&s1_xx1_m70_vgs
let s1_xx1_m70_vds = @m.x1.xdut.xx1_m70.msky130_fd_pr__nfet_01v8[vds]
echo OPV XX1_M70 vds $&s1_xx1_m70_vds
let s1_xx1_m70_vbs = @m.x1.xdut.xx1_m70.msky130_fd_pr__nfet_01v8[vbs]
echo OPV XX1_M70 vbs $&s1_xx1_m70_vbs
let s1_xx1_m70_vth = @m.x1.xdut.xx1_m70.msky130_fd_pr__nfet_01v8[vth]
echo OPV XX1_M70 vth $&s1_xx1_m70_vth
let s1_xx1_m70_vdsat = @m.x1.xdut.xx1_m70.msky130_fd_pr__nfet_01v8[vdsat]
echo OPV XX1_M70 vdsat $&s1_xx1_m70_vdsat
let s1_xx1_m70_gm = @m.x1.xdut.xx1_m70.msky130_fd_pr__nfet_01v8[gm]
echo OPV XX1_M70 gm $&s1_xx1_m70_gm
let s1_xx1_m70_gds = @m.x1.xdut.xx1_m70.msky130_fd_pr__nfet_01v8[gds]
echo OPV XX1_M70 gds $&s1_xx1_m70_gds
let s1_xx1_m70_gmbs = @m.x1.xdut.xx1_m70.msky130_fd_pr__nfet_01v8[gmbs]
echo OPV XX1_M70 gmbs $&s1_xx1_m70_gmbs
let s1_xx1_m70_cgg = @m.x1.xdut.xx1_m70.msky130_fd_pr__nfet_01v8[cgg]
echo OPV XX1_M70 cgg $&s1_xx1_m70_cgg
let s1_xx1_m70_cgd = @m.x1.xdut.xx1_m70.msky130_fd_pr__nfet_01v8[cgd]
echo OPV XX1_M70 cgd $&s1_xx1_m70_cgd
let s1_xx1_m70_cgs = @m.x1.xdut.xx1_m70.msky130_fd_pr__nfet_01v8[cgs]
echo OPV XX1_M70 cgs $&s1_xx1_m70_cgs
let s1_xx1_m70_cgb = @m.x1.xdut.xx1_m70.msky130_fd_pr__nfet_01v8[cgb]
echo OPV XX1_M70 cgb $&s1_xx1_m70_cgb
let s1_xx1_m70_cdg = @m.x1.xdut.xx1_m70.msky130_fd_pr__nfet_01v8[cdg]
echo OPV XX1_M70 cdg $&s1_xx1_m70_cdg
let s1_xx1_m70_cdd = @m.x1.xdut.xx1_m70.msky130_fd_pr__nfet_01v8[cdd]
echo OPV XX1_M70 cdd $&s1_xx1_m70_cdd
let s1_xx1_m70_cds = @m.x1.xdut.xx1_m70.msky130_fd_pr__nfet_01v8[cds]
echo OPV XX1_M70 cds $&s1_xx1_m70_cds
let s1_xx1_m70_cdb = @m.x1.xdut.xx1_m70.msky130_fd_pr__nfet_01v8[cdb]
echo OPV XX1_M70 cdb $&s1_xx1_m70_cdb
let s1_xx1_m70_csg = @m.x1.xdut.xx1_m70.msky130_fd_pr__nfet_01v8[csg]
echo OPV XX1_M70 csg $&s1_xx1_m70_csg
let s1_xx1_m70_csd = @m.x1.xdut.xx1_m70.msky130_fd_pr__nfet_01v8[csd]
echo OPV XX1_M70 csd $&s1_xx1_m70_csd
let s1_xx1_m70_css = @m.x1.xdut.xx1_m70.msky130_fd_pr__nfet_01v8[css]
echo OPV XX1_M70 css $&s1_xx1_m70_css
let s1_xx1_m70_csb = @m.x1.xdut.xx1_m70.msky130_fd_pr__nfet_01v8[csb]
echo OPV XX1_M70 csb $&s1_xx1_m70_csb
let s1_xx1_m70_cbg = @m.x1.xdut.xx1_m70.msky130_fd_pr__nfet_01v8[cbg]
echo OPV XX1_M70 cbg $&s1_xx1_m70_cbg
let s1_xx1_m70_cbd = @m.x1.xdut.xx1_m70.msky130_fd_pr__nfet_01v8[cbd]
echo OPV XX1_M70 cbd $&s1_xx1_m70_cbd
let s1_xx1_m70_cbs = @m.x1.xdut.xx1_m70.msky130_fd_pr__nfet_01v8[cbs]
echo OPV XX1_M70 cbs $&s1_xx1_m70_cbs
let s1_xx1_m70_cbb = @m.x1.xdut.xx1_m70.msky130_fd_pr__nfet_01v8[cbb]
echo OPV XX1_M70 cbb $&s1_xx1_m70_cbb
let s1_xx1_m70_capbd = @m.x1.xdut.xx1_m70.msky130_fd_pr__nfet_01v8[capbd]
echo OPV XX1_M70 capbd $&s1_xx1_m70_capbd
let s1_xx1_m70_capbs = @m.x1.xdut.xx1_m70.msky130_fd_pr__nfet_01v8[capbs]
echo OPV XX1_M70 capbs $&s1_xx1_m70_capbs
let s1_xx1_m70_cgso = @m.x1.xdut.xx1_m70.msky130_fd_pr__nfet_01v8[cgso]
echo OPV XX1_M70 cgso $&s1_xx1_m70_cgso
let s1_xx1_m70_cgdo = @m.x1.xdut.xx1_m70.msky130_fd_pr__nfet_01v8[cgdo]
echo OPV XX1_M70 cgdo $&s1_xx1_m70_cgdo
let s1_xx1_m70_cgbo = @m.x1.xdut.xx1_m70.msky130_fd_pr__nfet_01v8[cgbo]
echo OPV XX1_M70 cgbo $&s1_xx1_m70_cgbo
let s1_xx1_m70_weff = @m.x1.xdut.xx1_m70.msky130_fd_pr__nfet_01v8[weff]
echo OPV XX1_M70 weff $&s1_xx1_m70_weff
let s1_xx1_m70_leff = @m.x1.xdut.xx1_m70.msky130_fd_pr__nfet_01v8[leff]
echo OPV XX1_M70 leff $&s1_xx1_m70_leff
let s1_xx1_m71_id = @m.x1.xdut.xx1_m71.msky130_fd_pr__nfet_01v8[id]
echo OPV XX1_M71 id $&s1_xx1_m71_id
let s1_xx1_m71_vgs = @m.x1.xdut.xx1_m71.msky130_fd_pr__nfet_01v8[vgs]
echo OPV XX1_M71 vgs $&s1_xx1_m71_vgs
let s1_xx1_m71_vds = @m.x1.xdut.xx1_m71.msky130_fd_pr__nfet_01v8[vds]
echo OPV XX1_M71 vds $&s1_xx1_m71_vds
let s1_xx1_m71_vbs = @m.x1.xdut.xx1_m71.msky130_fd_pr__nfet_01v8[vbs]
echo OPV XX1_M71 vbs $&s1_xx1_m71_vbs
let s1_xx1_m71_vth = @m.x1.xdut.xx1_m71.msky130_fd_pr__nfet_01v8[vth]
echo OPV XX1_M71 vth $&s1_xx1_m71_vth
let s1_xx1_m71_vdsat = @m.x1.xdut.xx1_m71.msky130_fd_pr__nfet_01v8[vdsat]
echo OPV XX1_M71 vdsat $&s1_xx1_m71_vdsat
let s1_xx1_m71_gm = @m.x1.xdut.xx1_m71.msky130_fd_pr__nfet_01v8[gm]
echo OPV XX1_M71 gm $&s1_xx1_m71_gm
let s1_xx1_m71_gds = @m.x1.xdut.xx1_m71.msky130_fd_pr__nfet_01v8[gds]
echo OPV XX1_M71 gds $&s1_xx1_m71_gds
let s1_xx1_m71_gmbs = @m.x1.xdut.xx1_m71.msky130_fd_pr__nfet_01v8[gmbs]
echo OPV XX1_M71 gmbs $&s1_xx1_m71_gmbs
let s1_xx1_m71_cgg = @m.x1.xdut.xx1_m71.msky130_fd_pr__nfet_01v8[cgg]
echo OPV XX1_M71 cgg $&s1_xx1_m71_cgg
let s1_xx1_m71_cgd = @m.x1.xdut.xx1_m71.msky130_fd_pr__nfet_01v8[cgd]
echo OPV XX1_M71 cgd $&s1_xx1_m71_cgd
let s1_xx1_m71_cgs = @m.x1.xdut.xx1_m71.msky130_fd_pr__nfet_01v8[cgs]
echo OPV XX1_M71 cgs $&s1_xx1_m71_cgs
let s1_xx1_m71_cgb = @m.x1.xdut.xx1_m71.msky130_fd_pr__nfet_01v8[cgb]
echo OPV XX1_M71 cgb $&s1_xx1_m71_cgb
let s1_xx1_m71_cdg = @m.x1.xdut.xx1_m71.msky130_fd_pr__nfet_01v8[cdg]
echo OPV XX1_M71 cdg $&s1_xx1_m71_cdg
let s1_xx1_m71_cdd = @m.x1.xdut.xx1_m71.msky130_fd_pr__nfet_01v8[cdd]
echo OPV XX1_M71 cdd $&s1_xx1_m71_cdd
let s1_xx1_m71_cds = @m.x1.xdut.xx1_m71.msky130_fd_pr__nfet_01v8[cds]
echo OPV XX1_M71 cds $&s1_xx1_m71_cds
let s1_xx1_m71_cdb = @m.x1.xdut.xx1_m71.msky130_fd_pr__nfet_01v8[cdb]
echo OPV XX1_M71 cdb $&s1_xx1_m71_cdb
let s1_xx1_m71_csg = @m.x1.xdut.xx1_m71.msky130_fd_pr__nfet_01v8[csg]
echo OPV XX1_M71 csg $&s1_xx1_m71_csg
let s1_xx1_m71_csd = @m.x1.xdut.xx1_m71.msky130_fd_pr__nfet_01v8[csd]
echo OPV XX1_M71 csd $&s1_xx1_m71_csd
let s1_xx1_m71_css = @m.x1.xdut.xx1_m71.msky130_fd_pr__nfet_01v8[css]
echo OPV XX1_M71 css $&s1_xx1_m71_css
let s1_xx1_m71_csb = @m.x1.xdut.xx1_m71.msky130_fd_pr__nfet_01v8[csb]
echo OPV XX1_M71 csb $&s1_xx1_m71_csb
let s1_xx1_m71_cbg = @m.x1.xdut.xx1_m71.msky130_fd_pr__nfet_01v8[cbg]
echo OPV XX1_M71 cbg $&s1_xx1_m71_cbg
let s1_xx1_m71_cbd = @m.x1.xdut.xx1_m71.msky130_fd_pr__nfet_01v8[cbd]
echo OPV XX1_M71 cbd $&s1_xx1_m71_cbd
let s1_xx1_m71_cbs = @m.x1.xdut.xx1_m71.msky130_fd_pr__nfet_01v8[cbs]
echo OPV XX1_M71 cbs $&s1_xx1_m71_cbs
let s1_xx1_m71_cbb = @m.x1.xdut.xx1_m71.msky130_fd_pr__nfet_01v8[cbb]
echo OPV XX1_M71 cbb $&s1_xx1_m71_cbb
let s1_xx1_m71_capbd = @m.x1.xdut.xx1_m71.msky130_fd_pr__nfet_01v8[capbd]
echo OPV XX1_M71 capbd $&s1_xx1_m71_capbd
let s1_xx1_m71_capbs = @m.x1.xdut.xx1_m71.msky130_fd_pr__nfet_01v8[capbs]
echo OPV XX1_M71 capbs $&s1_xx1_m71_capbs
let s1_xx1_m71_cgso = @m.x1.xdut.xx1_m71.msky130_fd_pr__nfet_01v8[cgso]
echo OPV XX1_M71 cgso $&s1_xx1_m71_cgso
let s1_xx1_m71_cgdo = @m.x1.xdut.xx1_m71.msky130_fd_pr__nfet_01v8[cgdo]
echo OPV XX1_M71 cgdo $&s1_xx1_m71_cgdo
let s1_xx1_m71_cgbo = @m.x1.xdut.xx1_m71.msky130_fd_pr__nfet_01v8[cgbo]
echo OPV XX1_M71 cgbo $&s1_xx1_m71_cgbo
let s1_xx1_m71_weff = @m.x1.xdut.xx1_m71.msky130_fd_pr__nfet_01v8[weff]
echo OPV XX1_M71 weff $&s1_xx1_m71_weff
let s1_xx1_m71_leff = @m.x1.xdut.xx1_m71.msky130_fd_pr__nfet_01v8[leff]
echo OPV XX1_M71 leff $&s1_xx1_m71_leff
let s1_xx1_m72_id = @m.x1.xdut.xx1_m72.msky130_fd_pr__nfet_01v8[id]
echo OPV XX1_M72 id $&s1_xx1_m72_id
let s1_xx1_m72_vgs = @m.x1.xdut.xx1_m72.msky130_fd_pr__nfet_01v8[vgs]
echo OPV XX1_M72 vgs $&s1_xx1_m72_vgs
let s1_xx1_m72_vds = @m.x1.xdut.xx1_m72.msky130_fd_pr__nfet_01v8[vds]
echo OPV XX1_M72 vds $&s1_xx1_m72_vds
let s1_xx1_m72_vbs = @m.x1.xdut.xx1_m72.msky130_fd_pr__nfet_01v8[vbs]
echo OPV XX1_M72 vbs $&s1_xx1_m72_vbs
let s1_xx1_m72_vth = @m.x1.xdut.xx1_m72.msky130_fd_pr__nfet_01v8[vth]
echo OPV XX1_M72 vth $&s1_xx1_m72_vth
let s1_xx1_m72_vdsat = @m.x1.xdut.xx1_m72.msky130_fd_pr__nfet_01v8[vdsat]
echo OPV XX1_M72 vdsat $&s1_xx1_m72_vdsat
let s1_xx1_m72_gm = @m.x1.xdut.xx1_m72.msky130_fd_pr__nfet_01v8[gm]
echo OPV XX1_M72 gm $&s1_xx1_m72_gm
let s1_xx1_m72_gds = @m.x1.xdut.xx1_m72.msky130_fd_pr__nfet_01v8[gds]
echo OPV XX1_M72 gds $&s1_xx1_m72_gds
let s1_xx1_m72_gmbs = @m.x1.xdut.xx1_m72.msky130_fd_pr__nfet_01v8[gmbs]
echo OPV XX1_M72 gmbs $&s1_xx1_m72_gmbs
let s1_xx1_m72_cgg = @m.x1.xdut.xx1_m72.msky130_fd_pr__nfet_01v8[cgg]
echo OPV XX1_M72 cgg $&s1_xx1_m72_cgg
let s1_xx1_m72_cgd = @m.x1.xdut.xx1_m72.msky130_fd_pr__nfet_01v8[cgd]
echo OPV XX1_M72 cgd $&s1_xx1_m72_cgd
let s1_xx1_m72_cgs = @m.x1.xdut.xx1_m72.msky130_fd_pr__nfet_01v8[cgs]
echo OPV XX1_M72 cgs $&s1_xx1_m72_cgs
let s1_xx1_m72_cgb = @m.x1.xdut.xx1_m72.msky130_fd_pr__nfet_01v8[cgb]
echo OPV XX1_M72 cgb $&s1_xx1_m72_cgb
let s1_xx1_m72_cdg = @m.x1.xdut.xx1_m72.msky130_fd_pr__nfet_01v8[cdg]
echo OPV XX1_M72 cdg $&s1_xx1_m72_cdg
let s1_xx1_m72_cdd = @m.x1.xdut.xx1_m72.msky130_fd_pr__nfet_01v8[cdd]
echo OPV XX1_M72 cdd $&s1_xx1_m72_cdd
let s1_xx1_m72_cds = @m.x1.xdut.xx1_m72.msky130_fd_pr__nfet_01v8[cds]
echo OPV XX1_M72 cds $&s1_xx1_m72_cds
let s1_xx1_m72_cdb = @m.x1.xdut.xx1_m72.msky130_fd_pr__nfet_01v8[cdb]
echo OPV XX1_M72 cdb $&s1_xx1_m72_cdb
let s1_xx1_m72_csg = @m.x1.xdut.xx1_m72.msky130_fd_pr__nfet_01v8[csg]
echo OPV XX1_M72 csg $&s1_xx1_m72_csg
let s1_xx1_m72_csd = @m.x1.xdut.xx1_m72.msky130_fd_pr__nfet_01v8[csd]
echo OPV XX1_M72 csd $&s1_xx1_m72_csd
let s1_xx1_m72_css = @m.x1.xdut.xx1_m72.msky130_fd_pr__nfet_01v8[css]
echo OPV XX1_M72 css $&s1_xx1_m72_css
let s1_xx1_m72_csb = @m.x1.xdut.xx1_m72.msky130_fd_pr__nfet_01v8[csb]
echo OPV XX1_M72 csb $&s1_xx1_m72_csb
let s1_xx1_m72_cbg = @m.x1.xdut.xx1_m72.msky130_fd_pr__nfet_01v8[cbg]
echo OPV XX1_M72 cbg $&s1_xx1_m72_cbg
let s1_xx1_m72_cbd = @m.x1.xdut.xx1_m72.msky130_fd_pr__nfet_01v8[cbd]
echo OPV XX1_M72 cbd $&s1_xx1_m72_cbd
let s1_xx1_m72_cbs = @m.x1.xdut.xx1_m72.msky130_fd_pr__nfet_01v8[cbs]
echo OPV XX1_M72 cbs $&s1_xx1_m72_cbs
let s1_xx1_m72_cbb = @m.x1.xdut.xx1_m72.msky130_fd_pr__nfet_01v8[cbb]
echo OPV XX1_M72 cbb $&s1_xx1_m72_cbb
let s1_xx1_m72_capbd = @m.x1.xdut.xx1_m72.msky130_fd_pr__nfet_01v8[capbd]
echo OPV XX1_M72 capbd $&s1_xx1_m72_capbd
let s1_xx1_m72_capbs = @m.x1.xdut.xx1_m72.msky130_fd_pr__nfet_01v8[capbs]
echo OPV XX1_M72 capbs $&s1_xx1_m72_capbs
let s1_xx1_m72_cgso = @m.x1.xdut.xx1_m72.msky130_fd_pr__nfet_01v8[cgso]
echo OPV XX1_M72 cgso $&s1_xx1_m72_cgso
let s1_xx1_m72_cgdo = @m.x1.xdut.xx1_m72.msky130_fd_pr__nfet_01v8[cgdo]
echo OPV XX1_M72 cgdo $&s1_xx1_m72_cgdo
let s1_xx1_m72_cgbo = @m.x1.xdut.xx1_m72.msky130_fd_pr__nfet_01v8[cgbo]
echo OPV XX1_M72 cgbo $&s1_xx1_m72_cgbo
let s1_xx1_m72_weff = @m.x1.xdut.xx1_m72.msky130_fd_pr__nfet_01v8[weff]
echo OPV XX1_M72 weff $&s1_xx1_m72_weff
let s1_xx1_m72_leff = @m.x1.xdut.xx1_m72.msky130_fd_pr__nfet_01v8[leff]
echo OPV XX1_M72 leff $&s1_xx1_m72_leff
let s1_xx1_m73_id = @m.x1.xdut.xx1_m73.msky130_fd_pr__nfet_01v8[id]
echo OPV XX1_M73 id $&s1_xx1_m73_id
let s1_xx1_m73_vgs = @m.x1.xdut.xx1_m73.msky130_fd_pr__nfet_01v8[vgs]
echo OPV XX1_M73 vgs $&s1_xx1_m73_vgs
let s1_xx1_m73_vds = @m.x1.xdut.xx1_m73.msky130_fd_pr__nfet_01v8[vds]
echo OPV XX1_M73 vds $&s1_xx1_m73_vds
let s1_xx1_m73_vbs = @m.x1.xdut.xx1_m73.msky130_fd_pr__nfet_01v8[vbs]
echo OPV XX1_M73 vbs $&s1_xx1_m73_vbs
let s1_xx1_m73_vth = @m.x1.xdut.xx1_m73.msky130_fd_pr__nfet_01v8[vth]
echo OPV XX1_M73 vth $&s1_xx1_m73_vth
let s1_xx1_m73_vdsat = @m.x1.xdut.xx1_m73.msky130_fd_pr__nfet_01v8[vdsat]
echo OPV XX1_M73 vdsat $&s1_xx1_m73_vdsat
let s1_xx1_m73_gm = @m.x1.xdut.xx1_m73.msky130_fd_pr__nfet_01v8[gm]
echo OPV XX1_M73 gm $&s1_xx1_m73_gm
let s1_xx1_m73_gds = @m.x1.xdut.xx1_m73.msky130_fd_pr__nfet_01v8[gds]
echo OPV XX1_M73 gds $&s1_xx1_m73_gds
let s1_xx1_m73_gmbs = @m.x1.xdut.xx1_m73.msky130_fd_pr__nfet_01v8[gmbs]
echo OPV XX1_M73 gmbs $&s1_xx1_m73_gmbs
let s1_xx1_m73_cgg = @m.x1.xdut.xx1_m73.msky130_fd_pr__nfet_01v8[cgg]
echo OPV XX1_M73 cgg $&s1_xx1_m73_cgg
let s1_xx1_m73_cgd = @m.x1.xdut.xx1_m73.msky130_fd_pr__nfet_01v8[cgd]
echo OPV XX1_M73 cgd $&s1_xx1_m73_cgd
let s1_xx1_m73_cgs = @m.x1.xdut.xx1_m73.msky130_fd_pr__nfet_01v8[cgs]
echo OPV XX1_M73 cgs $&s1_xx1_m73_cgs
let s1_xx1_m73_cgb = @m.x1.xdut.xx1_m73.msky130_fd_pr__nfet_01v8[cgb]
echo OPV XX1_M73 cgb $&s1_xx1_m73_cgb
let s1_xx1_m73_cdg = @m.x1.xdut.xx1_m73.msky130_fd_pr__nfet_01v8[cdg]
echo OPV XX1_M73 cdg $&s1_xx1_m73_cdg
let s1_xx1_m73_cdd = @m.x1.xdut.xx1_m73.msky130_fd_pr__nfet_01v8[cdd]
echo OPV XX1_M73 cdd $&s1_xx1_m73_cdd
let s1_xx1_m73_cds = @m.x1.xdut.xx1_m73.msky130_fd_pr__nfet_01v8[cds]
echo OPV XX1_M73 cds $&s1_xx1_m73_cds
let s1_xx1_m73_cdb = @m.x1.xdut.xx1_m73.msky130_fd_pr__nfet_01v8[cdb]
echo OPV XX1_M73 cdb $&s1_xx1_m73_cdb
let s1_xx1_m73_csg = @m.x1.xdut.xx1_m73.msky130_fd_pr__nfet_01v8[csg]
echo OPV XX1_M73 csg $&s1_xx1_m73_csg
let s1_xx1_m73_csd = @m.x1.xdut.xx1_m73.msky130_fd_pr__nfet_01v8[csd]
echo OPV XX1_M73 csd $&s1_xx1_m73_csd
let s1_xx1_m73_css = @m.x1.xdut.xx1_m73.msky130_fd_pr__nfet_01v8[css]
echo OPV XX1_M73 css $&s1_xx1_m73_css
let s1_xx1_m73_csb = @m.x1.xdut.xx1_m73.msky130_fd_pr__nfet_01v8[csb]
echo OPV XX1_M73 csb $&s1_xx1_m73_csb
let s1_xx1_m73_cbg = @m.x1.xdut.xx1_m73.msky130_fd_pr__nfet_01v8[cbg]
echo OPV XX1_M73 cbg $&s1_xx1_m73_cbg
let s1_xx1_m73_cbd = @m.x1.xdut.xx1_m73.msky130_fd_pr__nfet_01v8[cbd]
echo OPV XX1_M73 cbd $&s1_xx1_m73_cbd
let s1_xx1_m73_cbs = @m.x1.xdut.xx1_m73.msky130_fd_pr__nfet_01v8[cbs]
echo OPV XX1_M73 cbs $&s1_xx1_m73_cbs
let s1_xx1_m73_cbb = @m.x1.xdut.xx1_m73.msky130_fd_pr__nfet_01v8[cbb]
echo OPV XX1_M73 cbb $&s1_xx1_m73_cbb
let s1_xx1_m73_capbd = @m.x1.xdut.xx1_m73.msky130_fd_pr__nfet_01v8[capbd]
echo OPV XX1_M73 capbd $&s1_xx1_m73_capbd
let s1_xx1_m73_capbs = @m.x1.xdut.xx1_m73.msky130_fd_pr__nfet_01v8[capbs]
echo OPV XX1_M73 capbs $&s1_xx1_m73_capbs
let s1_xx1_m73_cgso = @m.x1.xdut.xx1_m73.msky130_fd_pr__nfet_01v8[cgso]
echo OPV XX1_M73 cgso $&s1_xx1_m73_cgso
let s1_xx1_m73_cgdo = @m.x1.xdut.xx1_m73.msky130_fd_pr__nfet_01v8[cgdo]
echo OPV XX1_M73 cgdo $&s1_xx1_m73_cgdo
let s1_xx1_m73_cgbo = @m.x1.xdut.xx1_m73.msky130_fd_pr__nfet_01v8[cgbo]
echo OPV XX1_M73 cgbo $&s1_xx1_m73_cgbo
let s1_xx1_m73_weff = @m.x1.xdut.xx1_m73.msky130_fd_pr__nfet_01v8[weff]
echo OPV XX1_M73 weff $&s1_xx1_m73_weff
let s1_xx1_m73_leff = @m.x1.xdut.xx1_m73.msky130_fd_pr__nfet_01v8[leff]
echo OPV XX1_M73 leff $&s1_xx1_m73_leff
let s1_xx1_m74_id = @m.x1.xdut.xx1_m74.msky130_fd_pr__nfet_01v8[id]
echo OPV XX1_M74 id $&s1_xx1_m74_id
let s1_xx1_m74_vgs = @m.x1.xdut.xx1_m74.msky130_fd_pr__nfet_01v8[vgs]
echo OPV XX1_M74 vgs $&s1_xx1_m74_vgs
let s1_xx1_m74_vds = @m.x1.xdut.xx1_m74.msky130_fd_pr__nfet_01v8[vds]
echo OPV XX1_M74 vds $&s1_xx1_m74_vds
let s1_xx1_m74_vbs = @m.x1.xdut.xx1_m74.msky130_fd_pr__nfet_01v8[vbs]
echo OPV XX1_M74 vbs $&s1_xx1_m74_vbs
let s1_xx1_m74_vth = @m.x1.xdut.xx1_m74.msky130_fd_pr__nfet_01v8[vth]
echo OPV XX1_M74 vth $&s1_xx1_m74_vth
let s1_xx1_m74_vdsat = @m.x1.xdut.xx1_m74.msky130_fd_pr__nfet_01v8[vdsat]
echo OPV XX1_M74 vdsat $&s1_xx1_m74_vdsat
let s1_xx1_m74_gm = @m.x1.xdut.xx1_m74.msky130_fd_pr__nfet_01v8[gm]
echo OPV XX1_M74 gm $&s1_xx1_m74_gm
let s1_xx1_m74_gds = @m.x1.xdut.xx1_m74.msky130_fd_pr__nfet_01v8[gds]
echo OPV XX1_M74 gds $&s1_xx1_m74_gds
let s1_xx1_m74_gmbs = @m.x1.xdut.xx1_m74.msky130_fd_pr__nfet_01v8[gmbs]
echo OPV XX1_M74 gmbs $&s1_xx1_m74_gmbs
let s1_xx1_m74_cgg = @m.x1.xdut.xx1_m74.msky130_fd_pr__nfet_01v8[cgg]
echo OPV XX1_M74 cgg $&s1_xx1_m74_cgg
let s1_xx1_m74_cgd = @m.x1.xdut.xx1_m74.msky130_fd_pr__nfet_01v8[cgd]
echo OPV XX1_M74 cgd $&s1_xx1_m74_cgd
let s1_xx1_m74_cgs = @m.x1.xdut.xx1_m74.msky130_fd_pr__nfet_01v8[cgs]
echo OPV XX1_M74 cgs $&s1_xx1_m74_cgs
let s1_xx1_m74_cgb = @m.x1.xdut.xx1_m74.msky130_fd_pr__nfet_01v8[cgb]
echo OPV XX1_M74 cgb $&s1_xx1_m74_cgb
let s1_xx1_m74_cdg = @m.x1.xdut.xx1_m74.msky130_fd_pr__nfet_01v8[cdg]
echo OPV XX1_M74 cdg $&s1_xx1_m74_cdg
let s1_xx1_m74_cdd = @m.x1.xdut.xx1_m74.msky130_fd_pr__nfet_01v8[cdd]
echo OPV XX1_M74 cdd $&s1_xx1_m74_cdd
let s1_xx1_m74_cds = @m.x1.xdut.xx1_m74.msky130_fd_pr__nfet_01v8[cds]
echo OPV XX1_M74 cds $&s1_xx1_m74_cds
let s1_xx1_m74_cdb = @m.x1.xdut.xx1_m74.msky130_fd_pr__nfet_01v8[cdb]
echo OPV XX1_M74 cdb $&s1_xx1_m74_cdb
let s1_xx1_m74_csg = @m.x1.xdut.xx1_m74.msky130_fd_pr__nfet_01v8[csg]
echo OPV XX1_M74 csg $&s1_xx1_m74_csg
let s1_xx1_m74_csd = @m.x1.xdut.xx1_m74.msky130_fd_pr__nfet_01v8[csd]
echo OPV XX1_M74 csd $&s1_xx1_m74_csd
let s1_xx1_m74_css = @m.x1.xdut.xx1_m74.msky130_fd_pr__nfet_01v8[css]
echo OPV XX1_M74 css $&s1_xx1_m74_css
let s1_xx1_m74_csb = @m.x1.xdut.xx1_m74.msky130_fd_pr__nfet_01v8[csb]
echo OPV XX1_M74 csb $&s1_xx1_m74_csb
let s1_xx1_m74_cbg = @m.x1.xdut.xx1_m74.msky130_fd_pr__nfet_01v8[cbg]
echo OPV XX1_M74 cbg $&s1_xx1_m74_cbg
let s1_xx1_m74_cbd = @m.x1.xdut.xx1_m74.msky130_fd_pr__nfet_01v8[cbd]
echo OPV XX1_M74 cbd $&s1_xx1_m74_cbd
let s1_xx1_m74_cbs = @m.x1.xdut.xx1_m74.msky130_fd_pr__nfet_01v8[cbs]
echo OPV XX1_M74 cbs $&s1_xx1_m74_cbs
let s1_xx1_m74_cbb = @m.x1.xdut.xx1_m74.msky130_fd_pr__nfet_01v8[cbb]
echo OPV XX1_M74 cbb $&s1_xx1_m74_cbb
let s1_xx1_m74_capbd = @m.x1.xdut.xx1_m74.msky130_fd_pr__nfet_01v8[capbd]
echo OPV XX1_M74 capbd $&s1_xx1_m74_capbd
let s1_xx1_m74_capbs = @m.x1.xdut.xx1_m74.msky130_fd_pr__nfet_01v8[capbs]
echo OPV XX1_M74 capbs $&s1_xx1_m74_capbs
let s1_xx1_m74_cgso = @m.x1.xdut.xx1_m74.msky130_fd_pr__nfet_01v8[cgso]
echo OPV XX1_M74 cgso $&s1_xx1_m74_cgso
let s1_xx1_m74_cgdo = @m.x1.xdut.xx1_m74.msky130_fd_pr__nfet_01v8[cgdo]
echo OPV XX1_M74 cgdo $&s1_xx1_m74_cgdo
let s1_xx1_m74_cgbo = @m.x1.xdut.xx1_m74.msky130_fd_pr__nfet_01v8[cgbo]
echo OPV XX1_M74 cgbo $&s1_xx1_m74_cgbo
let s1_xx1_m74_weff = @m.x1.xdut.xx1_m74.msky130_fd_pr__nfet_01v8[weff]
echo OPV XX1_M74 weff $&s1_xx1_m74_weff
let s1_xx1_m74_leff = @m.x1.xdut.xx1_m74.msky130_fd_pr__nfet_01v8[leff]
echo OPV XX1_M74 leff $&s1_xx1_m74_leff
let s1_xx1_m75_id = @m.x1.xdut.xx1_m75.msky130_fd_pr__nfet_01v8[id]
echo OPV XX1_M75 id $&s1_xx1_m75_id
let s1_xx1_m75_vgs = @m.x1.xdut.xx1_m75.msky130_fd_pr__nfet_01v8[vgs]
echo OPV XX1_M75 vgs $&s1_xx1_m75_vgs
let s1_xx1_m75_vds = @m.x1.xdut.xx1_m75.msky130_fd_pr__nfet_01v8[vds]
echo OPV XX1_M75 vds $&s1_xx1_m75_vds
let s1_xx1_m75_vbs = @m.x1.xdut.xx1_m75.msky130_fd_pr__nfet_01v8[vbs]
echo OPV XX1_M75 vbs $&s1_xx1_m75_vbs
let s1_xx1_m75_vth = @m.x1.xdut.xx1_m75.msky130_fd_pr__nfet_01v8[vth]
echo OPV XX1_M75 vth $&s1_xx1_m75_vth
let s1_xx1_m75_vdsat = @m.x1.xdut.xx1_m75.msky130_fd_pr__nfet_01v8[vdsat]
echo OPV XX1_M75 vdsat $&s1_xx1_m75_vdsat
let s1_xx1_m75_gm = @m.x1.xdut.xx1_m75.msky130_fd_pr__nfet_01v8[gm]
echo OPV XX1_M75 gm $&s1_xx1_m75_gm
let s1_xx1_m75_gds = @m.x1.xdut.xx1_m75.msky130_fd_pr__nfet_01v8[gds]
echo OPV XX1_M75 gds $&s1_xx1_m75_gds
let s1_xx1_m75_gmbs = @m.x1.xdut.xx1_m75.msky130_fd_pr__nfet_01v8[gmbs]
echo OPV XX1_M75 gmbs $&s1_xx1_m75_gmbs
let s1_xx1_m75_cgg = @m.x1.xdut.xx1_m75.msky130_fd_pr__nfet_01v8[cgg]
echo OPV XX1_M75 cgg $&s1_xx1_m75_cgg
let s1_xx1_m75_cgd = @m.x1.xdut.xx1_m75.msky130_fd_pr__nfet_01v8[cgd]
echo OPV XX1_M75 cgd $&s1_xx1_m75_cgd
let s1_xx1_m75_cgs = @m.x1.xdut.xx1_m75.msky130_fd_pr__nfet_01v8[cgs]
echo OPV XX1_M75 cgs $&s1_xx1_m75_cgs
let s1_xx1_m75_cgb = @m.x1.xdut.xx1_m75.msky130_fd_pr__nfet_01v8[cgb]
echo OPV XX1_M75 cgb $&s1_xx1_m75_cgb
let s1_xx1_m75_cdg = @m.x1.xdut.xx1_m75.msky130_fd_pr__nfet_01v8[cdg]
echo OPV XX1_M75 cdg $&s1_xx1_m75_cdg
let s1_xx1_m75_cdd = @m.x1.xdut.xx1_m75.msky130_fd_pr__nfet_01v8[cdd]
echo OPV XX1_M75 cdd $&s1_xx1_m75_cdd
let s1_xx1_m75_cds = @m.x1.xdut.xx1_m75.msky130_fd_pr__nfet_01v8[cds]
echo OPV XX1_M75 cds $&s1_xx1_m75_cds
let s1_xx1_m75_cdb = @m.x1.xdut.xx1_m75.msky130_fd_pr__nfet_01v8[cdb]
echo OPV XX1_M75 cdb $&s1_xx1_m75_cdb
let s1_xx1_m75_csg = @m.x1.xdut.xx1_m75.msky130_fd_pr__nfet_01v8[csg]
echo OPV XX1_M75 csg $&s1_xx1_m75_csg
let s1_xx1_m75_csd = @m.x1.xdut.xx1_m75.msky130_fd_pr__nfet_01v8[csd]
echo OPV XX1_M75 csd $&s1_xx1_m75_csd
let s1_xx1_m75_css = @m.x1.xdut.xx1_m75.msky130_fd_pr__nfet_01v8[css]
echo OPV XX1_M75 css $&s1_xx1_m75_css
let s1_xx1_m75_csb = @m.x1.xdut.xx1_m75.msky130_fd_pr__nfet_01v8[csb]
echo OPV XX1_M75 csb $&s1_xx1_m75_csb
let s1_xx1_m75_cbg = @m.x1.xdut.xx1_m75.msky130_fd_pr__nfet_01v8[cbg]
echo OPV XX1_M75 cbg $&s1_xx1_m75_cbg
let s1_xx1_m75_cbd = @m.x1.xdut.xx1_m75.msky130_fd_pr__nfet_01v8[cbd]
echo OPV XX1_M75 cbd $&s1_xx1_m75_cbd
let s1_xx1_m75_cbs = @m.x1.xdut.xx1_m75.msky130_fd_pr__nfet_01v8[cbs]
echo OPV XX1_M75 cbs $&s1_xx1_m75_cbs
let s1_xx1_m75_cbb = @m.x1.xdut.xx1_m75.msky130_fd_pr__nfet_01v8[cbb]
echo OPV XX1_M75 cbb $&s1_xx1_m75_cbb
let s1_xx1_m75_capbd = @m.x1.xdut.xx1_m75.msky130_fd_pr__nfet_01v8[capbd]
echo OPV XX1_M75 capbd $&s1_xx1_m75_capbd
let s1_xx1_m75_capbs = @m.x1.xdut.xx1_m75.msky130_fd_pr__nfet_01v8[capbs]
echo OPV XX1_M75 capbs $&s1_xx1_m75_capbs
let s1_xx1_m75_cgso = @m.x1.xdut.xx1_m75.msky130_fd_pr__nfet_01v8[cgso]
echo OPV XX1_M75 cgso $&s1_xx1_m75_cgso
let s1_xx1_m75_cgdo = @m.x1.xdut.xx1_m75.msky130_fd_pr__nfet_01v8[cgdo]
echo OPV XX1_M75 cgdo $&s1_xx1_m75_cgdo
let s1_xx1_m75_cgbo = @m.x1.xdut.xx1_m75.msky130_fd_pr__nfet_01v8[cgbo]
echo OPV XX1_M75 cgbo $&s1_xx1_m75_cgbo
let s1_xx1_m75_weff = @m.x1.xdut.xx1_m75.msky130_fd_pr__nfet_01v8[weff]
echo OPV XX1_M75 weff $&s1_xx1_m75_weff
let s1_xx1_m75_leff = @m.x1.xdut.xx1_m75.msky130_fd_pr__nfet_01v8[leff]
echo OPV XX1_M75 leff $&s1_xx1_m75_leff
let s1_xx1_m76_id = @m.x1.xdut.xx1_m76.msky130_fd_pr__nfet_01v8[id]
echo OPV XX1_M76 id $&s1_xx1_m76_id
let s1_xx1_m76_vgs = @m.x1.xdut.xx1_m76.msky130_fd_pr__nfet_01v8[vgs]
echo OPV XX1_M76 vgs $&s1_xx1_m76_vgs
let s1_xx1_m76_vds = @m.x1.xdut.xx1_m76.msky130_fd_pr__nfet_01v8[vds]
echo OPV XX1_M76 vds $&s1_xx1_m76_vds
let s1_xx1_m76_vbs = @m.x1.xdut.xx1_m76.msky130_fd_pr__nfet_01v8[vbs]
echo OPV XX1_M76 vbs $&s1_xx1_m76_vbs
let s1_xx1_m76_vth = @m.x1.xdut.xx1_m76.msky130_fd_pr__nfet_01v8[vth]
echo OPV XX1_M76 vth $&s1_xx1_m76_vth
let s1_xx1_m76_vdsat = @m.x1.xdut.xx1_m76.msky130_fd_pr__nfet_01v8[vdsat]
echo OPV XX1_M76 vdsat $&s1_xx1_m76_vdsat
let s1_xx1_m76_gm = @m.x1.xdut.xx1_m76.msky130_fd_pr__nfet_01v8[gm]
echo OPV XX1_M76 gm $&s1_xx1_m76_gm
let s1_xx1_m76_gds = @m.x1.xdut.xx1_m76.msky130_fd_pr__nfet_01v8[gds]
echo OPV XX1_M76 gds $&s1_xx1_m76_gds
let s1_xx1_m76_gmbs = @m.x1.xdut.xx1_m76.msky130_fd_pr__nfet_01v8[gmbs]
echo OPV XX1_M76 gmbs $&s1_xx1_m76_gmbs
let s1_xx1_m76_cgg = @m.x1.xdut.xx1_m76.msky130_fd_pr__nfet_01v8[cgg]
echo OPV XX1_M76 cgg $&s1_xx1_m76_cgg
let s1_xx1_m76_cgd = @m.x1.xdut.xx1_m76.msky130_fd_pr__nfet_01v8[cgd]
echo OPV XX1_M76 cgd $&s1_xx1_m76_cgd
let s1_xx1_m76_cgs = @m.x1.xdut.xx1_m76.msky130_fd_pr__nfet_01v8[cgs]
echo OPV XX1_M76 cgs $&s1_xx1_m76_cgs
let s1_xx1_m76_cgb = @m.x1.xdut.xx1_m76.msky130_fd_pr__nfet_01v8[cgb]
echo OPV XX1_M76 cgb $&s1_xx1_m76_cgb
let s1_xx1_m76_cdg = @m.x1.xdut.xx1_m76.msky130_fd_pr__nfet_01v8[cdg]
echo OPV XX1_M76 cdg $&s1_xx1_m76_cdg
let s1_xx1_m76_cdd = @m.x1.xdut.xx1_m76.msky130_fd_pr__nfet_01v8[cdd]
echo OPV XX1_M76 cdd $&s1_xx1_m76_cdd
let s1_xx1_m76_cds = @m.x1.xdut.xx1_m76.msky130_fd_pr__nfet_01v8[cds]
echo OPV XX1_M76 cds $&s1_xx1_m76_cds
let s1_xx1_m76_cdb = @m.x1.xdut.xx1_m76.msky130_fd_pr__nfet_01v8[cdb]
echo OPV XX1_M76 cdb $&s1_xx1_m76_cdb
let s1_xx1_m76_csg = @m.x1.xdut.xx1_m76.msky130_fd_pr__nfet_01v8[csg]
echo OPV XX1_M76 csg $&s1_xx1_m76_csg
let s1_xx1_m76_csd = @m.x1.xdut.xx1_m76.msky130_fd_pr__nfet_01v8[csd]
echo OPV XX1_M76 csd $&s1_xx1_m76_csd
let s1_xx1_m76_css = @m.x1.xdut.xx1_m76.msky130_fd_pr__nfet_01v8[css]
echo OPV XX1_M76 css $&s1_xx1_m76_css
let s1_xx1_m76_csb = @m.x1.xdut.xx1_m76.msky130_fd_pr__nfet_01v8[csb]
echo OPV XX1_M76 csb $&s1_xx1_m76_csb
let s1_xx1_m76_cbg = @m.x1.xdut.xx1_m76.msky130_fd_pr__nfet_01v8[cbg]
echo OPV XX1_M76 cbg $&s1_xx1_m76_cbg
let s1_xx1_m76_cbd = @m.x1.xdut.xx1_m76.msky130_fd_pr__nfet_01v8[cbd]
echo OPV XX1_M76 cbd $&s1_xx1_m76_cbd
let s1_xx1_m76_cbs = @m.x1.xdut.xx1_m76.msky130_fd_pr__nfet_01v8[cbs]
echo OPV XX1_M76 cbs $&s1_xx1_m76_cbs
let s1_xx1_m76_cbb = @m.x1.xdut.xx1_m76.msky130_fd_pr__nfet_01v8[cbb]
echo OPV XX1_M76 cbb $&s1_xx1_m76_cbb
let s1_xx1_m76_capbd = @m.x1.xdut.xx1_m76.msky130_fd_pr__nfet_01v8[capbd]
echo OPV XX1_M76 capbd $&s1_xx1_m76_capbd
let s1_xx1_m76_capbs = @m.x1.xdut.xx1_m76.msky130_fd_pr__nfet_01v8[capbs]
echo OPV XX1_M76 capbs $&s1_xx1_m76_capbs
let s1_xx1_m76_cgso = @m.x1.xdut.xx1_m76.msky130_fd_pr__nfet_01v8[cgso]
echo OPV XX1_M76 cgso $&s1_xx1_m76_cgso
let s1_xx1_m76_cgdo = @m.x1.xdut.xx1_m76.msky130_fd_pr__nfet_01v8[cgdo]
echo OPV XX1_M76 cgdo $&s1_xx1_m76_cgdo
let s1_xx1_m76_cgbo = @m.x1.xdut.xx1_m76.msky130_fd_pr__nfet_01v8[cgbo]
echo OPV XX1_M76 cgbo $&s1_xx1_m76_cgbo
let s1_xx1_m76_weff = @m.x1.xdut.xx1_m76.msky130_fd_pr__nfet_01v8[weff]
echo OPV XX1_M76 weff $&s1_xx1_m76_weff
let s1_xx1_m76_leff = @m.x1.xdut.xx1_m76.msky130_fd_pr__nfet_01v8[leff]
echo OPV XX1_M76 leff $&s1_xx1_m76_leff
let s1_xx1_m77_id = @m.x1.xdut.xx1_m77.msky130_fd_pr__nfet_01v8[id]
echo OPV XX1_M77 id $&s1_xx1_m77_id
let s1_xx1_m77_vgs = @m.x1.xdut.xx1_m77.msky130_fd_pr__nfet_01v8[vgs]
echo OPV XX1_M77 vgs $&s1_xx1_m77_vgs
let s1_xx1_m77_vds = @m.x1.xdut.xx1_m77.msky130_fd_pr__nfet_01v8[vds]
echo OPV XX1_M77 vds $&s1_xx1_m77_vds
let s1_xx1_m77_vbs = @m.x1.xdut.xx1_m77.msky130_fd_pr__nfet_01v8[vbs]
echo OPV XX1_M77 vbs $&s1_xx1_m77_vbs
let s1_xx1_m77_vth = @m.x1.xdut.xx1_m77.msky130_fd_pr__nfet_01v8[vth]
echo OPV XX1_M77 vth $&s1_xx1_m77_vth
let s1_xx1_m77_vdsat = @m.x1.xdut.xx1_m77.msky130_fd_pr__nfet_01v8[vdsat]
echo OPV XX1_M77 vdsat $&s1_xx1_m77_vdsat
let s1_xx1_m77_gm = @m.x1.xdut.xx1_m77.msky130_fd_pr__nfet_01v8[gm]
echo OPV XX1_M77 gm $&s1_xx1_m77_gm
let s1_xx1_m77_gds = @m.x1.xdut.xx1_m77.msky130_fd_pr__nfet_01v8[gds]
echo OPV XX1_M77 gds $&s1_xx1_m77_gds
let s1_xx1_m77_gmbs = @m.x1.xdut.xx1_m77.msky130_fd_pr__nfet_01v8[gmbs]
echo OPV XX1_M77 gmbs $&s1_xx1_m77_gmbs
let s1_xx1_m77_cgg = @m.x1.xdut.xx1_m77.msky130_fd_pr__nfet_01v8[cgg]
echo OPV XX1_M77 cgg $&s1_xx1_m77_cgg
let s1_xx1_m77_cgd = @m.x1.xdut.xx1_m77.msky130_fd_pr__nfet_01v8[cgd]
echo OPV XX1_M77 cgd $&s1_xx1_m77_cgd
let s1_xx1_m77_cgs = @m.x1.xdut.xx1_m77.msky130_fd_pr__nfet_01v8[cgs]
echo OPV XX1_M77 cgs $&s1_xx1_m77_cgs
let s1_xx1_m77_cgb = @m.x1.xdut.xx1_m77.msky130_fd_pr__nfet_01v8[cgb]
echo OPV XX1_M77 cgb $&s1_xx1_m77_cgb
let s1_xx1_m77_cdg = @m.x1.xdut.xx1_m77.msky130_fd_pr__nfet_01v8[cdg]
echo OPV XX1_M77 cdg $&s1_xx1_m77_cdg
let s1_xx1_m77_cdd = @m.x1.xdut.xx1_m77.msky130_fd_pr__nfet_01v8[cdd]
echo OPV XX1_M77 cdd $&s1_xx1_m77_cdd
let s1_xx1_m77_cds = @m.x1.xdut.xx1_m77.msky130_fd_pr__nfet_01v8[cds]
echo OPV XX1_M77 cds $&s1_xx1_m77_cds
let s1_xx1_m77_cdb = @m.x1.xdut.xx1_m77.msky130_fd_pr__nfet_01v8[cdb]
echo OPV XX1_M77 cdb $&s1_xx1_m77_cdb
let s1_xx1_m77_csg = @m.x1.xdut.xx1_m77.msky130_fd_pr__nfet_01v8[csg]
echo OPV XX1_M77 csg $&s1_xx1_m77_csg
let s1_xx1_m77_csd = @m.x1.xdut.xx1_m77.msky130_fd_pr__nfet_01v8[csd]
echo OPV XX1_M77 csd $&s1_xx1_m77_csd
let s1_xx1_m77_css = @m.x1.xdut.xx1_m77.msky130_fd_pr__nfet_01v8[css]
echo OPV XX1_M77 css $&s1_xx1_m77_css
let s1_xx1_m77_csb = @m.x1.xdut.xx1_m77.msky130_fd_pr__nfet_01v8[csb]
echo OPV XX1_M77 csb $&s1_xx1_m77_csb
let s1_xx1_m77_cbg = @m.x1.xdut.xx1_m77.msky130_fd_pr__nfet_01v8[cbg]
echo OPV XX1_M77 cbg $&s1_xx1_m77_cbg
let s1_xx1_m77_cbd = @m.x1.xdut.xx1_m77.msky130_fd_pr__nfet_01v8[cbd]
echo OPV XX1_M77 cbd $&s1_xx1_m77_cbd
let s1_xx1_m77_cbs = @m.x1.xdut.xx1_m77.msky130_fd_pr__nfet_01v8[cbs]
echo OPV XX1_M77 cbs $&s1_xx1_m77_cbs
let s1_xx1_m77_cbb = @m.x1.xdut.xx1_m77.msky130_fd_pr__nfet_01v8[cbb]
echo OPV XX1_M77 cbb $&s1_xx1_m77_cbb
let s1_xx1_m77_capbd = @m.x1.xdut.xx1_m77.msky130_fd_pr__nfet_01v8[capbd]
echo OPV XX1_M77 capbd $&s1_xx1_m77_capbd
let s1_xx1_m77_capbs = @m.x1.xdut.xx1_m77.msky130_fd_pr__nfet_01v8[capbs]
echo OPV XX1_M77 capbs $&s1_xx1_m77_capbs
let s1_xx1_m77_cgso = @m.x1.xdut.xx1_m77.msky130_fd_pr__nfet_01v8[cgso]
echo OPV XX1_M77 cgso $&s1_xx1_m77_cgso
let s1_xx1_m77_cgdo = @m.x1.xdut.xx1_m77.msky130_fd_pr__nfet_01v8[cgdo]
echo OPV XX1_M77 cgdo $&s1_xx1_m77_cgdo
let s1_xx1_m77_cgbo = @m.x1.xdut.xx1_m77.msky130_fd_pr__nfet_01v8[cgbo]
echo OPV XX1_M77 cgbo $&s1_xx1_m77_cgbo
let s1_xx1_m77_weff = @m.x1.xdut.xx1_m77.msky130_fd_pr__nfet_01v8[weff]
echo OPV XX1_M77 weff $&s1_xx1_m77_weff
let s1_xx1_m77_leff = @m.x1.xdut.xx1_m77.msky130_fd_pr__nfet_01v8[leff]
echo OPV XX1_M77 leff $&s1_xx1_m77_leff
let s1_xx1_m78_id = @m.x1.xdut.xx1_m78.msky130_fd_pr__nfet_01v8[id]
echo OPV XX1_M78 id $&s1_xx1_m78_id
let s1_xx1_m78_vgs = @m.x1.xdut.xx1_m78.msky130_fd_pr__nfet_01v8[vgs]
echo OPV XX1_M78 vgs $&s1_xx1_m78_vgs
let s1_xx1_m78_vds = @m.x1.xdut.xx1_m78.msky130_fd_pr__nfet_01v8[vds]
echo OPV XX1_M78 vds $&s1_xx1_m78_vds
let s1_xx1_m78_vbs = @m.x1.xdut.xx1_m78.msky130_fd_pr__nfet_01v8[vbs]
echo OPV XX1_M78 vbs $&s1_xx1_m78_vbs
let s1_xx1_m78_vth = @m.x1.xdut.xx1_m78.msky130_fd_pr__nfet_01v8[vth]
echo OPV XX1_M78 vth $&s1_xx1_m78_vth
let s1_xx1_m78_vdsat = @m.x1.xdut.xx1_m78.msky130_fd_pr__nfet_01v8[vdsat]
echo OPV XX1_M78 vdsat $&s1_xx1_m78_vdsat
let s1_xx1_m78_gm = @m.x1.xdut.xx1_m78.msky130_fd_pr__nfet_01v8[gm]
echo OPV XX1_M78 gm $&s1_xx1_m78_gm
let s1_xx1_m78_gds = @m.x1.xdut.xx1_m78.msky130_fd_pr__nfet_01v8[gds]
echo OPV XX1_M78 gds $&s1_xx1_m78_gds
let s1_xx1_m78_gmbs = @m.x1.xdut.xx1_m78.msky130_fd_pr__nfet_01v8[gmbs]
echo OPV XX1_M78 gmbs $&s1_xx1_m78_gmbs
let s1_xx1_m78_cgg = @m.x1.xdut.xx1_m78.msky130_fd_pr__nfet_01v8[cgg]
echo OPV XX1_M78 cgg $&s1_xx1_m78_cgg
let s1_xx1_m78_cgd = @m.x1.xdut.xx1_m78.msky130_fd_pr__nfet_01v8[cgd]
echo OPV XX1_M78 cgd $&s1_xx1_m78_cgd
let s1_xx1_m78_cgs = @m.x1.xdut.xx1_m78.msky130_fd_pr__nfet_01v8[cgs]
echo OPV XX1_M78 cgs $&s1_xx1_m78_cgs
let s1_xx1_m78_cgb = @m.x1.xdut.xx1_m78.msky130_fd_pr__nfet_01v8[cgb]
echo OPV XX1_M78 cgb $&s1_xx1_m78_cgb
let s1_xx1_m78_cdg = @m.x1.xdut.xx1_m78.msky130_fd_pr__nfet_01v8[cdg]
echo OPV XX1_M78 cdg $&s1_xx1_m78_cdg
let s1_xx1_m78_cdd = @m.x1.xdut.xx1_m78.msky130_fd_pr__nfet_01v8[cdd]
echo OPV XX1_M78 cdd $&s1_xx1_m78_cdd
let s1_xx1_m78_cds = @m.x1.xdut.xx1_m78.msky130_fd_pr__nfet_01v8[cds]
echo OPV XX1_M78 cds $&s1_xx1_m78_cds
let s1_xx1_m78_cdb = @m.x1.xdut.xx1_m78.msky130_fd_pr__nfet_01v8[cdb]
echo OPV XX1_M78 cdb $&s1_xx1_m78_cdb
let s1_xx1_m78_csg = @m.x1.xdut.xx1_m78.msky130_fd_pr__nfet_01v8[csg]
echo OPV XX1_M78 csg $&s1_xx1_m78_csg
let s1_xx1_m78_csd = @m.x1.xdut.xx1_m78.msky130_fd_pr__nfet_01v8[csd]
echo OPV XX1_M78 csd $&s1_xx1_m78_csd
let s1_xx1_m78_css = @m.x1.xdut.xx1_m78.msky130_fd_pr__nfet_01v8[css]
echo OPV XX1_M78 css $&s1_xx1_m78_css
let s1_xx1_m78_csb = @m.x1.xdut.xx1_m78.msky130_fd_pr__nfet_01v8[csb]
echo OPV XX1_M78 csb $&s1_xx1_m78_csb
let s1_xx1_m78_cbg = @m.x1.xdut.xx1_m78.msky130_fd_pr__nfet_01v8[cbg]
echo OPV XX1_M78 cbg $&s1_xx1_m78_cbg
let s1_xx1_m78_cbd = @m.x1.xdut.xx1_m78.msky130_fd_pr__nfet_01v8[cbd]
echo OPV XX1_M78 cbd $&s1_xx1_m78_cbd
let s1_xx1_m78_cbs = @m.x1.xdut.xx1_m78.msky130_fd_pr__nfet_01v8[cbs]
echo OPV XX1_M78 cbs $&s1_xx1_m78_cbs
let s1_xx1_m78_cbb = @m.x1.xdut.xx1_m78.msky130_fd_pr__nfet_01v8[cbb]
echo OPV XX1_M78 cbb $&s1_xx1_m78_cbb
let s1_xx1_m78_capbd = @m.x1.xdut.xx1_m78.msky130_fd_pr__nfet_01v8[capbd]
echo OPV XX1_M78 capbd $&s1_xx1_m78_capbd
let s1_xx1_m78_capbs = @m.x1.xdut.xx1_m78.msky130_fd_pr__nfet_01v8[capbs]
echo OPV XX1_M78 capbs $&s1_xx1_m78_capbs
let s1_xx1_m78_cgso = @m.x1.xdut.xx1_m78.msky130_fd_pr__nfet_01v8[cgso]
echo OPV XX1_M78 cgso $&s1_xx1_m78_cgso
let s1_xx1_m78_cgdo = @m.x1.xdut.xx1_m78.msky130_fd_pr__nfet_01v8[cgdo]
echo OPV XX1_M78 cgdo $&s1_xx1_m78_cgdo
let s1_xx1_m78_cgbo = @m.x1.xdut.xx1_m78.msky130_fd_pr__nfet_01v8[cgbo]
echo OPV XX1_M78 cgbo $&s1_xx1_m78_cgbo
let s1_xx1_m78_weff = @m.x1.xdut.xx1_m78.msky130_fd_pr__nfet_01v8[weff]
echo OPV XX1_M78 weff $&s1_xx1_m78_weff
let s1_xx1_m78_leff = @m.x1.xdut.xx1_m78.msky130_fd_pr__nfet_01v8[leff]
echo OPV XX1_M78 leff $&s1_xx1_m78_leff
let s1_xx1_m79_id = @m.x1.xdut.xx1_m79.msky130_fd_pr__nfet_01v8[id]
echo OPV XX1_M79 id $&s1_xx1_m79_id
let s1_xx1_m79_vgs = @m.x1.xdut.xx1_m79.msky130_fd_pr__nfet_01v8[vgs]
echo OPV XX1_M79 vgs $&s1_xx1_m79_vgs
let s1_xx1_m79_vds = @m.x1.xdut.xx1_m79.msky130_fd_pr__nfet_01v8[vds]
echo OPV XX1_M79 vds $&s1_xx1_m79_vds
let s1_xx1_m79_vbs = @m.x1.xdut.xx1_m79.msky130_fd_pr__nfet_01v8[vbs]
echo OPV XX1_M79 vbs $&s1_xx1_m79_vbs
let s1_xx1_m79_vth = @m.x1.xdut.xx1_m79.msky130_fd_pr__nfet_01v8[vth]
echo OPV XX1_M79 vth $&s1_xx1_m79_vth
let s1_xx1_m79_vdsat = @m.x1.xdut.xx1_m79.msky130_fd_pr__nfet_01v8[vdsat]
echo OPV XX1_M79 vdsat $&s1_xx1_m79_vdsat
let s1_xx1_m79_gm = @m.x1.xdut.xx1_m79.msky130_fd_pr__nfet_01v8[gm]
echo OPV XX1_M79 gm $&s1_xx1_m79_gm
let s1_xx1_m79_gds = @m.x1.xdut.xx1_m79.msky130_fd_pr__nfet_01v8[gds]
echo OPV XX1_M79 gds $&s1_xx1_m79_gds
let s1_xx1_m79_gmbs = @m.x1.xdut.xx1_m79.msky130_fd_pr__nfet_01v8[gmbs]
echo OPV XX1_M79 gmbs $&s1_xx1_m79_gmbs
let s1_xx1_m79_cgg = @m.x1.xdut.xx1_m79.msky130_fd_pr__nfet_01v8[cgg]
echo OPV XX1_M79 cgg $&s1_xx1_m79_cgg
let s1_xx1_m79_cgd = @m.x1.xdut.xx1_m79.msky130_fd_pr__nfet_01v8[cgd]
echo OPV XX1_M79 cgd $&s1_xx1_m79_cgd
let s1_xx1_m79_cgs = @m.x1.xdut.xx1_m79.msky130_fd_pr__nfet_01v8[cgs]
echo OPV XX1_M79 cgs $&s1_xx1_m79_cgs
let s1_xx1_m79_cgb = @m.x1.xdut.xx1_m79.msky130_fd_pr__nfet_01v8[cgb]
echo OPV XX1_M79 cgb $&s1_xx1_m79_cgb
let s1_xx1_m79_cdg = @m.x1.xdut.xx1_m79.msky130_fd_pr__nfet_01v8[cdg]
echo OPV XX1_M79 cdg $&s1_xx1_m79_cdg
let s1_xx1_m79_cdd = @m.x1.xdut.xx1_m79.msky130_fd_pr__nfet_01v8[cdd]
echo OPV XX1_M79 cdd $&s1_xx1_m79_cdd
let s1_xx1_m79_cds = @m.x1.xdut.xx1_m79.msky130_fd_pr__nfet_01v8[cds]
echo OPV XX1_M79 cds $&s1_xx1_m79_cds
let s1_xx1_m79_cdb = @m.x1.xdut.xx1_m79.msky130_fd_pr__nfet_01v8[cdb]
echo OPV XX1_M79 cdb $&s1_xx1_m79_cdb
let s1_xx1_m79_csg = @m.x1.xdut.xx1_m79.msky130_fd_pr__nfet_01v8[csg]
echo OPV XX1_M79 csg $&s1_xx1_m79_csg
let s1_xx1_m79_csd = @m.x1.xdut.xx1_m79.msky130_fd_pr__nfet_01v8[csd]
echo OPV XX1_M79 csd $&s1_xx1_m79_csd
let s1_xx1_m79_css = @m.x1.xdut.xx1_m79.msky130_fd_pr__nfet_01v8[css]
echo OPV XX1_M79 css $&s1_xx1_m79_css
let s1_xx1_m79_csb = @m.x1.xdut.xx1_m79.msky130_fd_pr__nfet_01v8[csb]
echo OPV XX1_M79 csb $&s1_xx1_m79_csb
let s1_xx1_m79_cbg = @m.x1.xdut.xx1_m79.msky130_fd_pr__nfet_01v8[cbg]
echo OPV XX1_M79 cbg $&s1_xx1_m79_cbg
let s1_xx1_m79_cbd = @m.x1.xdut.xx1_m79.msky130_fd_pr__nfet_01v8[cbd]
echo OPV XX1_M79 cbd $&s1_xx1_m79_cbd
let s1_xx1_m79_cbs = @m.x1.xdut.xx1_m79.msky130_fd_pr__nfet_01v8[cbs]
echo OPV XX1_M79 cbs $&s1_xx1_m79_cbs
let s1_xx1_m79_cbb = @m.x1.xdut.xx1_m79.msky130_fd_pr__nfet_01v8[cbb]
echo OPV XX1_M79 cbb $&s1_xx1_m79_cbb
let s1_xx1_m79_capbd = @m.x1.xdut.xx1_m79.msky130_fd_pr__nfet_01v8[capbd]
echo OPV XX1_M79 capbd $&s1_xx1_m79_capbd
let s1_xx1_m79_capbs = @m.x1.xdut.xx1_m79.msky130_fd_pr__nfet_01v8[capbs]
echo OPV XX1_M79 capbs $&s1_xx1_m79_capbs
let s1_xx1_m79_cgso = @m.x1.xdut.xx1_m79.msky130_fd_pr__nfet_01v8[cgso]
echo OPV XX1_M79 cgso $&s1_xx1_m79_cgso
let s1_xx1_m79_cgdo = @m.x1.xdut.xx1_m79.msky130_fd_pr__nfet_01v8[cgdo]
echo OPV XX1_M79 cgdo $&s1_xx1_m79_cgdo
let s1_xx1_m79_cgbo = @m.x1.xdut.xx1_m79.msky130_fd_pr__nfet_01v8[cgbo]
echo OPV XX1_M79 cgbo $&s1_xx1_m79_cgbo
let s1_xx1_m79_weff = @m.x1.xdut.xx1_m79.msky130_fd_pr__nfet_01v8[weff]
echo OPV XX1_M79 weff $&s1_xx1_m79_weff
let s1_xx1_m79_leff = @m.x1.xdut.xx1_m79.msky130_fd_pr__nfet_01v8[leff]
echo OPV XX1_M79 leff $&s1_xx1_m79_leff
let s1_xx1_m64_id = @m.x1.xdut.xx1_m64.msky130_fd_pr__nfet_01v8[id]
echo OPV XX1_M64 id $&s1_xx1_m64_id
let s1_xx1_m64_vgs = @m.x1.xdut.xx1_m64.msky130_fd_pr__nfet_01v8[vgs]
echo OPV XX1_M64 vgs $&s1_xx1_m64_vgs
let s1_xx1_m64_vds = @m.x1.xdut.xx1_m64.msky130_fd_pr__nfet_01v8[vds]
echo OPV XX1_M64 vds $&s1_xx1_m64_vds
let s1_xx1_m64_vbs = @m.x1.xdut.xx1_m64.msky130_fd_pr__nfet_01v8[vbs]
echo OPV XX1_M64 vbs $&s1_xx1_m64_vbs
let s1_xx1_m64_vth = @m.x1.xdut.xx1_m64.msky130_fd_pr__nfet_01v8[vth]
echo OPV XX1_M64 vth $&s1_xx1_m64_vth
let s1_xx1_m64_vdsat = @m.x1.xdut.xx1_m64.msky130_fd_pr__nfet_01v8[vdsat]
echo OPV XX1_M64 vdsat $&s1_xx1_m64_vdsat
let s1_xx1_m64_gm = @m.x1.xdut.xx1_m64.msky130_fd_pr__nfet_01v8[gm]
echo OPV XX1_M64 gm $&s1_xx1_m64_gm
let s1_xx1_m64_gds = @m.x1.xdut.xx1_m64.msky130_fd_pr__nfet_01v8[gds]
echo OPV XX1_M64 gds $&s1_xx1_m64_gds
let s1_xx1_m64_gmbs = @m.x1.xdut.xx1_m64.msky130_fd_pr__nfet_01v8[gmbs]
echo OPV XX1_M64 gmbs $&s1_xx1_m64_gmbs
let s1_xx1_m64_cgg = @m.x1.xdut.xx1_m64.msky130_fd_pr__nfet_01v8[cgg]
echo OPV XX1_M64 cgg $&s1_xx1_m64_cgg
let s1_xx1_m64_cgd = @m.x1.xdut.xx1_m64.msky130_fd_pr__nfet_01v8[cgd]
echo OPV XX1_M64 cgd $&s1_xx1_m64_cgd
let s1_xx1_m64_cgs = @m.x1.xdut.xx1_m64.msky130_fd_pr__nfet_01v8[cgs]
echo OPV XX1_M64 cgs $&s1_xx1_m64_cgs
let s1_xx1_m64_cgb = @m.x1.xdut.xx1_m64.msky130_fd_pr__nfet_01v8[cgb]
echo OPV XX1_M64 cgb $&s1_xx1_m64_cgb
let s1_xx1_m64_cdg = @m.x1.xdut.xx1_m64.msky130_fd_pr__nfet_01v8[cdg]
echo OPV XX1_M64 cdg $&s1_xx1_m64_cdg
let s1_xx1_m64_cdd = @m.x1.xdut.xx1_m64.msky130_fd_pr__nfet_01v8[cdd]
echo OPV XX1_M64 cdd $&s1_xx1_m64_cdd
let s1_xx1_m64_cds = @m.x1.xdut.xx1_m64.msky130_fd_pr__nfet_01v8[cds]
echo OPV XX1_M64 cds $&s1_xx1_m64_cds
let s1_xx1_m64_cdb = @m.x1.xdut.xx1_m64.msky130_fd_pr__nfet_01v8[cdb]
echo OPV XX1_M64 cdb $&s1_xx1_m64_cdb
let s1_xx1_m64_csg = @m.x1.xdut.xx1_m64.msky130_fd_pr__nfet_01v8[csg]
echo OPV XX1_M64 csg $&s1_xx1_m64_csg
let s1_xx1_m64_csd = @m.x1.xdut.xx1_m64.msky130_fd_pr__nfet_01v8[csd]
echo OPV XX1_M64 csd $&s1_xx1_m64_csd
let s1_xx1_m64_css = @m.x1.xdut.xx1_m64.msky130_fd_pr__nfet_01v8[css]
echo OPV XX1_M64 css $&s1_xx1_m64_css
let s1_xx1_m64_csb = @m.x1.xdut.xx1_m64.msky130_fd_pr__nfet_01v8[csb]
echo OPV XX1_M64 csb $&s1_xx1_m64_csb
let s1_xx1_m64_cbg = @m.x1.xdut.xx1_m64.msky130_fd_pr__nfet_01v8[cbg]
echo OPV XX1_M64 cbg $&s1_xx1_m64_cbg
let s1_xx1_m64_cbd = @m.x1.xdut.xx1_m64.msky130_fd_pr__nfet_01v8[cbd]
echo OPV XX1_M64 cbd $&s1_xx1_m64_cbd
let s1_xx1_m64_cbs = @m.x1.xdut.xx1_m64.msky130_fd_pr__nfet_01v8[cbs]
echo OPV XX1_M64 cbs $&s1_xx1_m64_cbs
let s1_xx1_m64_cbb = @m.x1.xdut.xx1_m64.msky130_fd_pr__nfet_01v8[cbb]
echo OPV XX1_M64 cbb $&s1_xx1_m64_cbb
let s1_xx1_m64_capbd = @m.x1.xdut.xx1_m64.msky130_fd_pr__nfet_01v8[capbd]
echo OPV XX1_M64 capbd $&s1_xx1_m64_capbd
let s1_xx1_m64_capbs = @m.x1.xdut.xx1_m64.msky130_fd_pr__nfet_01v8[capbs]
echo OPV XX1_M64 capbs $&s1_xx1_m64_capbs
let s1_xx1_m64_cgso = @m.x1.xdut.xx1_m64.msky130_fd_pr__nfet_01v8[cgso]
echo OPV XX1_M64 cgso $&s1_xx1_m64_cgso
let s1_xx1_m64_cgdo = @m.x1.xdut.xx1_m64.msky130_fd_pr__nfet_01v8[cgdo]
echo OPV XX1_M64 cgdo $&s1_xx1_m64_cgdo
let s1_xx1_m64_cgbo = @m.x1.xdut.xx1_m64.msky130_fd_pr__nfet_01v8[cgbo]
echo OPV XX1_M64 cgbo $&s1_xx1_m64_cgbo
let s1_xx1_m64_weff = @m.x1.xdut.xx1_m64.msky130_fd_pr__nfet_01v8[weff]
echo OPV XX1_M64 weff $&s1_xx1_m64_weff
let s1_xx1_m64_leff = @m.x1.xdut.xx1_m64.msky130_fd_pr__nfet_01v8[leff]
echo OPV XX1_M64 leff $&s1_xx1_m64_leff
let s1_xx1_m65_id = @m.x1.xdut.xx1_m65.msky130_fd_pr__nfet_01v8[id]
echo OPV XX1_M65 id $&s1_xx1_m65_id
let s1_xx1_m65_vgs = @m.x1.xdut.xx1_m65.msky130_fd_pr__nfet_01v8[vgs]
echo OPV XX1_M65 vgs $&s1_xx1_m65_vgs
let s1_xx1_m65_vds = @m.x1.xdut.xx1_m65.msky130_fd_pr__nfet_01v8[vds]
echo OPV XX1_M65 vds $&s1_xx1_m65_vds
let s1_xx1_m65_vbs = @m.x1.xdut.xx1_m65.msky130_fd_pr__nfet_01v8[vbs]
echo OPV XX1_M65 vbs $&s1_xx1_m65_vbs
let s1_xx1_m65_vth = @m.x1.xdut.xx1_m65.msky130_fd_pr__nfet_01v8[vth]
echo OPV XX1_M65 vth $&s1_xx1_m65_vth
let s1_xx1_m65_vdsat = @m.x1.xdut.xx1_m65.msky130_fd_pr__nfet_01v8[vdsat]
echo OPV XX1_M65 vdsat $&s1_xx1_m65_vdsat
let s1_xx1_m65_gm = @m.x1.xdut.xx1_m65.msky130_fd_pr__nfet_01v8[gm]
echo OPV XX1_M65 gm $&s1_xx1_m65_gm
let s1_xx1_m65_gds = @m.x1.xdut.xx1_m65.msky130_fd_pr__nfet_01v8[gds]
echo OPV XX1_M65 gds $&s1_xx1_m65_gds
let s1_xx1_m65_gmbs = @m.x1.xdut.xx1_m65.msky130_fd_pr__nfet_01v8[gmbs]
echo OPV XX1_M65 gmbs $&s1_xx1_m65_gmbs
let s1_xx1_m65_cgg = @m.x1.xdut.xx1_m65.msky130_fd_pr__nfet_01v8[cgg]
echo OPV XX1_M65 cgg $&s1_xx1_m65_cgg
let s1_xx1_m65_cgd = @m.x1.xdut.xx1_m65.msky130_fd_pr__nfet_01v8[cgd]
echo OPV XX1_M65 cgd $&s1_xx1_m65_cgd
let s1_xx1_m65_cgs = @m.x1.xdut.xx1_m65.msky130_fd_pr__nfet_01v8[cgs]
echo OPV XX1_M65 cgs $&s1_xx1_m65_cgs
let s1_xx1_m65_cgb = @m.x1.xdut.xx1_m65.msky130_fd_pr__nfet_01v8[cgb]
echo OPV XX1_M65 cgb $&s1_xx1_m65_cgb
let s1_xx1_m65_cdg = @m.x1.xdut.xx1_m65.msky130_fd_pr__nfet_01v8[cdg]
echo OPV XX1_M65 cdg $&s1_xx1_m65_cdg
let s1_xx1_m65_cdd = @m.x1.xdut.xx1_m65.msky130_fd_pr__nfet_01v8[cdd]
echo OPV XX1_M65 cdd $&s1_xx1_m65_cdd
let s1_xx1_m65_cds = @m.x1.xdut.xx1_m65.msky130_fd_pr__nfet_01v8[cds]
echo OPV XX1_M65 cds $&s1_xx1_m65_cds
let s1_xx1_m65_cdb = @m.x1.xdut.xx1_m65.msky130_fd_pr__nfet_01v8[cdb]
echo OPV XX1_M65 cdb $&s1_xx1_m65_cdb
let s1_xx1_m65_csg = @m.x1.xdut.xx1_m65.msky130_fd_pr__nfet_01v8[csg]
echo OPV XX1_M65 csg $&s1_xx1_m65_csg
let s1_xx1_m65_csd = @m.x1.xdut.xx1_m65.msky130_fd_pr__nfet_01v8[csd]
echo OPV XX1_M65 csd $&s1_xx1_m65_csd
let s1_xx1_m65_css = @m.x1.xdut.xx1_m65.msky130_fd_pr__nfet_01v8[css]
echo OPV XX1_M65 css $&s1_xx1_m65_css
let s1_xx1_m65_csb = @m.x1.xdut.xx1_m65.msky130_fd_pr__nfet_01v8[csb]
echo OPV XX1_M65 csb $&s1_xx1_m65_csb
let s1_xx1_m65_cbg = @m.x1.xdut.xx1_m65.msky130_fd_pr__nfet_01v8[cbg]
echo OPV XX1_M65 cbg $&s1_xx1_m65_cbg
let s1_xx1_m65_cbd = @m.x1.xdut.xx1_m65.msky130_fd_pr__nfet_01v8[cbd]
echo OPV XX1_M65 cbd $&s1_xx1_m65_cbd
let s1_xx1_m65_cbs = @m.x1.xdut.xx1_m65.msky130_fd_pr__nfet_01v8[cbs]
echo OPV XX1_M65 cbs $&s1_xx1_m65_cbs
let s1_xx1_m65_cbb = @m.x1.xdut.xx1_m65.msky130_fd_pr__nfet_01v8[cbb]
echo OPV XX1_M65 cbb $&s1_xx1_m65_cbb
let s1_xx1_m65_capbd = @m.x1.xdut.xx1_m65.msky130_fd_pr__nfet_01v8[capbd]
echo OPV XX1_M65 capbd $&s1_xx1_m65_capbd
let s1_xx1_m65_capbs = @m.x1.xdut.xx1_m65.msky130_fd_pr__nfet_01v8[capbs]
echo OPV XX1_M65 capbs $&s1_xx1_m65_capbs
let s1_xx1_m65_cgso = @m.x1.xdut.xx1_m65.msky130_fd_pr__nfet_01v8[cgso]
echo OPV XX1_M65 cgso $&s1_xx1_m65_cgso
let s1_xx1_m65_cgdo = @m.x1.xdut.xx1_m65.msky130_fd_pr__nfet_01v8[cgdo]
echo OPV XX1_M65 cgdo $&s1_xx1_m65_cgdo
let s1_xx1_m65_cgbo = @m.x1.xdut.xx1_m65.msky130_fd_pr__nfet_01v8[cgbo]
echo OPV XX1_M65 cgbo $&s1_xx1_m65_cgbo
let s1_xx1_m65_weff = @m.x1.xdut.xx1_m65.msky130_fd_pr__nfet_01v8[weff]
echo OPV XX1_M65 weff $&s1_xx1_m65_weff
let s1_xx1_m65_leff = @m.x1.xdut.xx1_m65.msky130_fd_pr__nfet_01v8[leff]
echo OPV XX1_M65 leff $&s1_xx1_m65_leff
let s1_xx1_m66_id = @m.x1.xdut.xx1_m66.msky130_fd_pr__nfet_01v8[id]
echo OPV XX1_M66 id $&s1_xx1_m66_id
let s1_xx1_m66_vgs = @m.x1.xdut.xx1_m66.msky130_fd_pr__nfet_01v8[vgs]
echo OPV XX1_M66 vgs $&s1_xx1_m66_vgs
let s1_xx1_m66_vds = @m.x1.xdut.xx1_m66.msky130_fd_pr__nfet_01v8[vds]
echo OPV XX1_M66 vds $&s1_xx1_m66_vds
let s1_xx1_m66_vbs = @m.x1.xdut.xx1_m66.msky130_fd_pr__nfet_01v8[vbs]
echo OPV XX1_M66 vbs $&s1_xx1_m66_vbs
let s1_xx1_m66_vth = @m.x1.xdut.xx1_m66.msky130_fd_pr__nfet_01v8[vth]
echo OPV XX1_M66 vth $&s1_xx1_m66_vth
let s1_xx1_m66_vdsat = @m.x1.xdut.xx1_m66.msky130_fd_pr__nfet_01v8[vdsat]
echo OPV XX1_M66 vdsat $&s1_xx1_m66_vdsat
let s1_xx1_m66_gm = @m.x1.xdut.xx1_m66.msky130_fd_pr__nfet_01v8[gm]
echo OPV XX1_M66 gm $&s1_xx1_m66_gm
let s1_xx1_m66_gds = @m.x1.xdut.xx1_m66.msky130_fd_pr__nfet_01v8[gds]
echo OPV XX1_M66 gds $&s1_xx1_m66_gds
let s1_xx1_m66_gmbs = @m.x1.xdut.xx1_m66.msky130_fd_pr__nfet_01v8[gmbs]
echo OPV XX1_M66 gmbs $&s1_xx1_m66_gmbs
let s1_xx1_m66_cgg = @m.x1.xdut.xx1_m66.msky130_fd_pr__nfet_01v8[cgg]
echo OPV XX1_M66 cgg $&s1_xx1_m66_cgg
let s1_xx1_m66_cgd = @m.x1.xdut.xx1_m66.msky130_fd_pr__nfet_01v8[cgd]
echo OPV XX1_M66 cgd $&s1_xx1_m66_cgd
let s1_xx1_m66_cgs = @m.x1.xdut.xx1_m66.msky130_fd_pr__nfet_01v8[cgs]
echo OPV XX1_M66 cgs $&s1_xx1_m66_cgs
let s1_xx1_m66_cgb = @m.x1.xdut.xx1_m66.msky130_fd_pr__nfet_01v8[cgb]
echo OPV XX1_M66 cgb $&s1_xx1_m66_cgb
let s1_xx1_m66_cdg = @m.x1.xdut.xx1_m66.msky130_fd_pr__nfet_01v8[cdg]
echo OPV XX1_M66 cdg $&s1_xx1_m66_cdg
let s1_xx1_m66_cdd = @m.x1.xdut.xx1_m66.msky130_fd_pr__nfet_01v8[cdd]
echo OPV XX1_M66 cdd $&s1_xx1_m66_cdd
let s1_xx1_m66_cds = @m.x1.xdut.xx1_m66.msky130_fd_pr__nfet_01v8[cds]
echo OPV XX1_M66 cds $&s1_xx1_m66_cds
let s1_xx1_m66_cdb = @m.x1.xdut.xx1_m66.msky130_fd_pr__nfet_01v8[cdb]
echo OPV XX1_M66 cdb $&s1_xx1_m66_cdb
let s1_xx1_m66_csg = @m.x1.xdut.xx1_m66.msky130_fd_pr__nfet_01v8[csg]
echo OPV XX1_M66 csg $&s1_xx1_m66_csg
let s1_xx1_m66_csd = @m.x1.xdut.xx1_m66.msky130_fd_pr__nfet_01v8[csd]
echo OPV XX1_M66 csd $&s1_xx1_m66_csd
let s1_xx1_m66_css = @m.x1.xdut.xx1_m66.msky130_fd_pr__nfet_01v8[css]
echo OPV XX1_M66 css $&s1_xx1_m66_css
let s1_xx1_m66_csb = @m.x1.xdut.xx1_m66.msky130_fd_pr__nfet_01v8[csb]
echo OPV XX1_M66 csb $&s1_xx1_m66_csb
let s1_xx1_m66_cbg = @m.x1.xdut.xx1_m66.msky130_fd_pr__nfet_01v8[cbg]
echo OPV XX1_M66 cbg $&s1_xx1_m66_cbg
let s1_xx1_m66_cbd = @m.x1.xdut.xx1_m66.msky130_fd_pr__nfet_01v8[cbd]
echo OPV XX1_M66 cbd $&s1_xx1_m66_cbd
let s1_xx1_m66_cbs = @m.x1.xdut.xx1_m66.msky130_fd_pr__nfet_01v8[cbs]
echo OPV XX1_M66 cbs $&s1_xx1_m66_cbs
let s1_xx1_m66_cbb = @m.x1.xdut.xx1_m66.msky130_fd_pr__nfet_01v8[cbb]
echo OPV XX1_M66 cbb $&s1_xx1_m66_cbb
let s1_xx1_m66_capbd = @m.x1.xdut.xx1_m66.msky130_fd_pr__nfet_01v8[capbd]
echo OPV XX1_M66 capbd $&s1_xx1_m66_capbd
let s1_xx1_m66_capbs = @m.x1.xdut.xx1_m66.msky130_fd_pr__nfet_01v8[capbs]
echo OPV XX1_M66 capbs $&s1_xx1_m66_capbs
let s1_xx1_m66_cgso = @m.x1.xdut.xx1_m66.msky130_fd_pr__nfet_01v8[cgso]
echo OPV XX1_M66 cgso $&s1_xx1_m66_cgso
let s1_xx1_m66_cgdo = @m.x1.xdut.xx1_m66.msky130_fd_pr__nfet_01v8[cgdo]
echo OPV XX1_M66 cgdo $&s1_xx1_m66_cgdo
let s1_xx1_m66_cgbo = @m.x1.xdut.xx1_m66.msky130_fd_pr__nfet_01v8[cgbo]
echo OPV XX1_M66 cgbo $&s1_xx1_m66_cgbo
let s1_xx1_m66_weff = @m.x1.xdut.xx1_m66.msky130_fd_pr__nfet_01v8[weff]
echo OPV XX1_M66 weff $&s1_xx1_m66_weff
let s1_xx1_m66_leff = @m.x1.xdut.xx1_m66.msky130_fd_pr__nfet_01v8[leff]
echo OPV XX1_M66 leff $&s1_xx1_m66_leff
let s1_xx1_m67_id = @m.x1.xdut.xx1_m67.msky130_fd_pr__nfet_01v8[id]
echo OPV XX1_M67 id $&s1_xx1_m67_id
let s1_xx1_m67_vgs = @m.x1.xdut.xx1_m67.msky130_fd_pr__nfet_01v8[vgs]
echo OPV XX1_M67 vgs $&s1_xx1_m67_vgs
let s1_xx1_m67_vds = @m.x1.xdut.xx1_m67.msky130_fd_pr__nfet_01v8[vds]
echo OPV XX1_M67 vds $&s1_xx1_m67_vds
let s1_xx1_m67_vbs = @m.x1.xdut.xx1_m67.msky130_fd_pr__nfet_01v8[vbs]
echo OPV XX1_M67 vbs $&s1_xx1_m67_vbs
let s1_xx1_m67_vth = @m.x1.xdut.xx1_m67.msky130_fd_pr__nfet_01v8[vth]
echo OPV XX1_M67 vth $&s1_xx1_m67_vth
let s1_xx1_m67_vdsat = @m.x1.xdut.xx1_m67.msky130_fd_pr__nfet_01v8[vdsat]
echo OPV XX1_M67 vdsat $&s1_xx1_m67_vdsat
let s1_xx1_m67_gm = @m.x1.xdut.xx1_m67.msky130_fd_pr__nfet_01v8[gm]
echo OPV XX1_M67 gm $&s1_xx1_m67_gm
let s1_xx1_m67_gds = @m.x1.xdut.xx1_m67.msky130_fd_pr__nfet_01v8[gds]
echo OPV XX1_M67 gds $&s1_xx1_m67_gds
let s1_xx1_m67_gmbs = @m.x1.xdut.xx1_m67.msky130_fd_pr__nfet_01v8[gmbs]
echo OPV XX1_M67 gmbs $&s1_xx1_m67_gmbs
let s1_xx1_m67_cgg = @m.x1.xdut.xx1_m67.msky130_fd_pr__nfet_01v8[cgg]
echo OPV XX1_M67 cgg $&s1_xx1_m67_cgg
let s1_xx1_m67_cgd = @m.x1.xdut.xx1_m67.msky130_fd_pr__nfet_01v8[cgd]
echo OPV XX1_M67 cgd $&s1_xx1_m67_cgd
let s1_xx1_m67_cgs = @m.x1.xdut.xx1_m67.msky130_fd_pr__nfet_01v8[cgs]
echo OPV XX1_M67 cgs $&s1_xx1_m67_cgs
let s1_xx1_m67_cgb = @m.x1.xdut.xx1_m67.msky130_fd_pr__nfet_01v8[cgb]
echo OPV XX1_M67 cgb $&s1_xx1_m67_cgb
let s1_xx1_m67_cdg = @m.x1.xdut.xx1_m67.msky130_fd_pr__nfet_01v8[cdg]
echo OPV XX1_M67 cdg $&s1_xx1_m67_cdg
let s1_xx1_m67_cdd = @m.x1.xdut.xx1_m67.msky130_fd_pr__nfet_01v8[cdd]
echo OPV XX1_M67 cdd $&s1_xx1_m67_cdd
let s1_xx1_m67_cds = @m.x1.xdut.xx1_m67.msky130_fd_pr__nfet_01v8[cds]
echo OPV XX1_M67 cds $&s1_xx1_m67_cds
let s1_xx1_m67_cdb = @m.x1.xdut.xx1_m67.msky130_fd_pr__nfet_01v8[cdb]
echo OPV XX1_M67 cdb $&s1_xx1_m67_cdb
let s1_xx1_m67_csg = @m.x1.xdut.xx1_m67.msky130_fd_pr__nfet_01v8[csg]
echo OPV XX1_M67 csg $&s1_xx1_m67_csg
let s1_xx1_m67_csd = @m.x1.xdut.xx1_m67.msky130_fd_pr__nfet_01v8[csd]
echo OPV XX1_M67 csd $&s1_xx1_m67_csd
let s1_xx1_m67_css = @m.x1.xdut.xx1_m67.msky130_fd_pr__nfet_01v8[css]
echo OPV XX1_M67 css $&s1_xx1_m67_css
let s1_xx1_m67_csb = @m.x1.xdut.xx1_m67.msky130_fd_pr__nfet_01v8[csb]
echo OPV XX1_M67 csb $&s1_xx1_m67_csb
let s1_xx1_m67_cbg = @m.x1.xdut.xx1_m67.msky130_fd_pr__nfet_01v8[cbg]
echo OPV XX1_M67 cbg $&s1_xx1_m67_cbg
let s1_xx1_m67_cbd = @m.x1.xdut.xx1_m67.msky130_fd_pr__nfet_01v8[cbd]
echo OPV XX1_M67 cbd $&s1_xx1_m67_cbd
let s1_xx1_m67_cbs = @m.x1.xdut.xx1_m67.msky130_fd_pr__nfet_01v8[cbs]
echo OPV XX1_M67 cbs $&s1_xx1_m67_cbs
let s1_xx1_m67_cbb = @m.x1.xdut.xx1_m67.msky130_fd_pr__nfet_01v8[cbb]
echo OPV XX1_M67 cbb $&s1_xx1_m67_cbb
let s1_xx1_m67_capbd = @m.x1.xdut.xx1_m67.msky130_fd_pr__nfet_01v8[capbd]
echo OPV XX1_M67 capbd $&s1_xx1_m67_capbd
let s1_xx1_m67_capbs = @m.x1.xdut.xx1_m67.msky130_fd_pr__nfet_01v8[capbs]
echo OPV XX1_M67 capbs $&s1_xx1_m67_capbs
let s1_xx1_m67_cgso = @m.x1.xdut.xx1_m67.msky130_fd_pr__nfet_01v8[cgso]
echo OPV XX1_M67 cgso $&s1_xx1_m67_cgso
let s1_xx1_m67_cgdo = @m.x1.xdut.xx1_m67.msky130_fd_pr__nfet_01v8[cgdo]
echo OPV XX1_M67 cgdo $&s1_xx1_m67_cgdo
let s1_xx1_m67_cgbo = @m.x1.xdut.xx1_m67.msky130_fd_pr__nfet_01v8[cgbo]
echo OPV XX1_M67 cgbo $&s1_xx1_m67_cgbo
let s1_xx1_m67_weff = @m.x1.xdut.xx1_m67.msky130_fd_pr__nfet_01v8[weff]
echo OPV XX1_M67 weff $&s1_xx1_m67_weff
let s1_xx1_m67_leff = @m.x1.xdut.xx1_m67.msky130_fd_pr__nfet_01v8[leff]
echo OPV XX1_M67 leff $&s1_xx1_m67_leff
let s1_xx1_m57_id = @m.x1.xdut.xx1_m57.msky130_fd_pr__pfet_01v8[id]
echo OPV XX1_M57 id $&s1_xx1_m57_id
let s1_xx1_m57_vgs = @m.x1.xdut.xx1_m57.msky130_fd_pr__pfet_01v8[vgs]
echo OPV XX1_M57 vgs $&s1_xx1_m57_vgs
let s1_xx1_m57_vds = @m.x1.xdut.xx1_m57.msky130_fd_pr__pfet_01v8[vds]
echo OPV XX1_M57 vds $&s1_xx1_m57_vds
let s1_xx1_m57_vbs = @m.x1.xdut.xx1_m57.msky130_fd_pr__pfet_01v8[vbs]
echo OPV XX1_M57 vbs $&s1_xx1_m57_vbs
let s1_xx1_m57_vth = @m.x1.xdut.xx1_m57.msky130_fd_pr__pfet_01v8[vth]
echo OPV XX1_M57 vth $&s1_xx1_m57_vth
let s1_xx1_m57_vdsat = @m.x1.xdut.xx1_m57.msky130_fd_pr__pfet_01v8[vdsat]
echo OPV XX1_M57 vdsat $&s1_xx1_m57_vdsat
let s1_xx1_m57_gm = @m.x1.xdut.xx1_m57.msky130_fd_pr__pfet_01v8[gm]
echo OPV XX1_M57 gm $&s1_xx1_m57_gm
let s1_xx1_m57_gds = @m.x1.xdut.xx1_m57.msky130_fd_pr__pfet_01v8[gds]
echo OPV XX1_M57 gds $&s1_xx1_m57_gds
let s1_xx1_m57_gmbs = @m.x1.xdut.xx1_m57.msky130_fd_pr__pfet_01v8[gmbs]
echo OPV XX1_M57 gmbs $&s1_xx1_m57_gmbs
let s1_xx1_m57_cgg = @m.x1.xdut.xx1_m57.msky130_fd_pr__pfet_01v8[cgg]
echo OPV XX1_M57 cgg $&s1_xx1_m57_cgg
let s1_xx1_m57_cgd = @m.x1.xdut.xx1_m57.msky130_fd_pr__pfet_01v8[cgd]
echo OPV XX1_M57 cgd $&s1_xx1_m57_cgd
let s1_xx1_m57_cgs = @m.x1.xdut.xx1_m57.msky130_fd_pr__pfet_01v8[cgs]
echo OPV XX1_M57 cgs $&s1_xx1_m57_cgs
let s1_xx1_m57_cgb = @m.x1.xdut.xx1_m57.msky130_fd_pr__pfet_01v8[cgb]
echo OPV XX1_M57 cgb $&s1_xx1_m57_cgb
let s1_xx1_m57_cdg = @m.x1.xdut.xx1_m57.msky130_fd_pr__pfet_01v8[cdg]
echo OPV XX1_M57 cdg $&s1_xx1_m57_cdg
let s1_xx1_m57_cdd = @m.x1.xdut.xx1_m57.msky130_fd_pr__pfet_01v8[cdd]
echo OPV XX1_M57 cdd $&s1_xx1_m57_cdd
let s1_xx1_m57_cds = @m.x1.xdut.xx1_m57.msky130_fd_pr__pfet_01v8[cds]
echo OPV XX1_M57 cds $&s1_xx1_m57_cds
let s1_xx1_m57_cdb = @m.x1.xdut.xx1_m57.msky130_fd_pr__pfet_01v8[cdb]
echo OPV XX1_M57 cdb $&s1_xx1_m57_cdb
let s1_xx1_m57_csg = @m.x1.xdut.xx1_m57.msky130_fd_pr__pfet_01v8[csg]
echo OPV XX1_M57 csg $&s1_xx1_m57_csg
let s1_xx1_m57_csd = @m.x1.xdut.xx1_m57.msky130_fd_pr__pfet_01v8[csd]
echo OPV XX1_M57 csd $&s1_xx1_m57_csd
let s1_xx1_m57_css = @m.x1.xdut.xx1_m57.msky130_fd_pr__pfet_01v8[css]
echo OPV XX1_M57 css $&s1_xx1_m57_css
let s1_xx1_m57_csb = @m.x1.xdut.xx1_m57.msky130_fd_pr__pfet_01v8[csb]
echo OPV XX1_M57 csb $&s1_xx1_m57_csb
let s1_xx1_m57_cbg = @m.x1.xdut.xx1_m57.msky130_fd_pr__pfet_01v8[cbg]
echo OPV XX1_M57 cbg $&s1_xx1_m57_cbg
let s1_xx1_m57_cbd = @m.x1.xdut.xx1_m57.msky130_fd_pr__pfet_01v8[cbd]
echo OPV XX1_M57 cbd $&s1_xx1_m57_cbd
let s1_xx1_m57_cbs = @m.x1.xdut.xx1_m57.msky130_fd_pr__pfet_01v8[cbs]
echo OPV XX1_M57 cbs $&s1_xx1_m57_cbs
let s1_xx1_m57_cbb = @m.x1.xdut.xx1_m57.msky130_fd_pr__pfet_01v8[cbb]
echo OPV XX1_M57 cbb $&s1_xx1_m57_cbb
let s1_xx1_m57_capbd = @m.x1.xdut.xx1_m57.msky130_fd_pr__pfet_01v8[capbd]
echo OPV XX1_M57 capbd $&s1_xx1_m57_capbd
let s1_xx1_m57_capbs = @m.x1.xdut.xx1_m57.msky130_fd_pr__pfet_01v8[capbs]
echo OPV XX1_M57 capbs $&s1_xx1_m57_capbs
let s1_xx1_m57_cgso = @m.x1.xdut.xx1_m57.msky130_fd_pr__pfet_01v8[cgso]
echo OPV XX1_M57 cgso $&s1_xx1_m57_cgso
let s1_xx1_m57_cgdo = @m.x1.xdut.xx1_m57.msky130_fd_pr__pfet_01v8[cgdo]
echo OPV XX1_M57 cgdo $&s1_xx1_m57_cgdo
let s1_xx1_m57_cgbo = @m.x1.xdut.xx1_m57.msky130_fd_pr__pfet_01v8[cgbo]
echo OPV XX1_M57 cgbo $&s1_xx1_m57_cgbo
let s1_xx1_m57_weff = @m.x1.xdut.xx1_m57.msky130_fd_pr__pfet_01v8[weff]
echo OPV XX1_M57 weff $&s1_xx1_m57_weff
let s1_xx1_m57_leff = @m.x1.xdut.xx1_m57.msky130_fd_pr__pfet_01v8[leff]
echo OPV XX1_M57 leff $&s1_xx1_m57_leff
let s1_xx1_m58_id = @m.x1.xdut.xx1_m58.msky130_fd_pr__pfet_01v8[id]
echo OPV XX1_M58 id $&s1_xx1_m58_id
let s1_xx1_m58_vgs = @m.x1.xdut.xx1_m58.msky130_fd_pr__pfet_01v8[vgs]
echo OPV XX1_M58 vgs $&s1_xx1_m58_vgs
let s1_xx1_m58_vds = @m.x1.xdut.xx1_m58.msky130_fd_pr__pfet_01v8[vds]
echo OPV XX1_M58 vds $&s1_xx1_m58_vds
let s1_xx1_m58_vbs = @m.x1.xdut.xx1_m58.msky130_fd_pr__pfet_01v8[vbs]
echo OPV XX1_M58 vbs $&s1_xx1_m58_vbs
let s1_xx1_m58_vth = @m.x1.xdut.xx1_m58.msky130_fd_pr__pfet_01v8[vth]
echo OPV XX1_M58 vth $&s1_xx1_m58_vth
let s1_xx1_m58_vdsat = @m.x1.xdut.xx1_m58.msky130_fd_pr__pfet_01v8[vdsat]
echo OPV XX1_M58 vdsat $&s1_xx1_m58_vdsat
let s1_xx1_m58_gm = @m.x1.xdut.xx1_m58.msky130_fd_pr__pfet_01v8[gm]
echo OPV XX1_M58 gm $&s1_xx1_m58_gm
let s1_xx1_m58_gds = @m.x1.xdut.xx1_m58.msky130_fd_pr__pfet_01v8[gds]
echo OPV XX1_M58 gds $&s1_xx1_m58_gds
let s1_xx1_m58_gmbs = @m.x1.xdut.xx1_m58.msky130_fd_pr__pfet_01v8[gmbs]
echo OPV XX1_M58 gmbs $&s1_xx1_m58_gmbs
let s1_xx1_m58_cgg = @m.x1.xdut.xx1_m58.msky130_fd_pr__pfet_01v8[cgg]
echo OPV XX1_M58 cgg $&s1_xx1_m58_cgg
let s1_xx1_m58_cgd = @m.x1.xdut.xx1_m58.msky130_fd_pr__pfet_01v8[cgd]
echo OPV XX1_M58 cgd $&s1_xx1_m58_cgd
let s1_xx1_m58_cgs = @m.x1.xdut.xx1_m58.msky130_fd_pr__pfet_01v8[cgs]
echo OPV XX1_M58 cgs $&s1_xx1_m58_cgs
let s1_xx1_m58_cgb = @m.x1.xdut.xx1_m58.msky130_fd_pr__pfet_01v8[cgb]
echo OPV XX1_M58 cgb $&s1_xx1_m58_cgb
let s1_xx1_m58_cdg = @m.x1.xdut.xx1_m58.msky130_fd_pr__pfet_01v8[cdg]
echo OPV XX1_M58 cdg $&s1_xx1_m58_cdg
let s1_xx1_m58_cdd = @m.x1.xdut.xx1_m58.msky130_fd_pr__pfet_01v8[cdd]
echo OPV XX1_M58 cdd $&s1_xx1_m58_cdd
let s1_xx1_m58_cds = @m.x1.xdut.xx1_m58.msky130_fd_pr__pfet_01v8[cds]
echo OPV XX1_M58 cds $&s1_xx1_m58_cds
let s1_xx1_m58_cdb = @m.x1.xdut.xx1_m58.msky130_fd_pr__pfet_01v8[cdb]
echo OPV XX1_M58 cdb $&s1_xx1_m58_cdb
let s1_xx1_m58_csg = @m.x1.xdut.xx1_m58.msky130_fd_pr__pfet_01v8[csg]
echo OPV XX1_M58 csg $&s1_xx1_m58_csg
let s1_xx1_m58_csd = @m.x1.xdut.xx1_m58.msky130_fd_pr__pfet_01v8[csd]
echo OPV XX1_M58 csd $&s1_xx1_m58_csd
let s1_xx1_m58_css = @m.x1.xdut.xx1_m58.msky130_fd_pr__pfet_01v8[css]
echo OPV XX1_M58 css $&s1_xx1_m58_css
let s1_xx1_m58_csb = @m.x1.xdut.xx1_m58.msky130_fd_pr__pfet_01v8[csb]
echo OPV XX1_M58 csb $&s1_xx1_m58_csb
let s1_xx1_m58_cbg = @m.x1.xdut.xx1_m58.msky130_fd_pr__pfet_01v8[cbg]
echo OPV XX1_M58 cbg $&s1_xx1_m58_cbg
let s1_xx1_m58_cbd = @m.x1.xdut.xx1_m58.msky130_fd_pr__pfet_01v8[cbd]
echo OPV XX1_M58 cbd $&s1_xx1_m58_cbd
let s1_xx1_m58_cbs = @m.x1.xdut.xx1_m58.msky130_fd_pr__pfet_01v8[cbs]
echo OPV XX1_M58 cbs $&s1_xx1_m58_cbs
let s1_xx1_m58_cbb = @m.x1.xdut.xx1_m58.msky130_fd_pr__pfet_01v8[cbb]
echo OPV XX1_M58 cbb $&s1_xx1_m58_cbb
let s1_xx1_m58_capbd = @m.x1.xdut.xx1_m58.msky130_fd_pr__pfet_01v8[capbd]
echo OPV XX1_M58 capbd $&s1_xx1_m58_capbd
let s1_xx1_m58_capbs = @m.x1.xdut.xx1_m58.msky130_fd_pr__pfet_01v8[capbs]
echo OPV XX1_M58 capbs $&s1_xx1_m58_capbs
let s1_xx1_m58_cgso = @m.x1.xdut.xx1_m58.msky130_fd_pr__pfet_01v8[cgso]
echo OPV XX1_M58 cgso $&s1_xx1_m58_cgso
let s1_xx1_m58_cgdo = @m.x1.xdut.xx1_m58.msky130_fd_pr__pfet_01v8[cgdo]
echo OPV XX1_M58 cgdo $&s1_xx1_m58_cgdo
let s1_xx1_m58_cgbo = @m.x1.xdut.xx1_m58.msky130_fd_pr__pfet_01v8[cgbo]
echo OPV XX1_M58 cgbo $&s1_xx1_m58_cgbo
let s1_xx1_m58_weff = @m.x1.xdut.xx1_m58.msky130_fd_pr__pfet_01v8[weff]
echo OPV XX1_M58 weff $&s1_xx1_m58_weff
let s1_xx1_m58_leff = @m.x1.xdut.xx1_m58.msky130_fd_pr__pfet_01v8[leff]
echo OPV XX1_M58 leff $&s1_xx1_m58_leff
let s1_xx1_m59_id = @m.x1.xdut.xx1_m59.msky130_fd_pr__pfet_01v8[id]
echo OPV XX1_M59 id $&s1_xx1_m59_id
let s1_xx1_m59_vgs = @m.x1.xdut.xx1_m59.msky130_fd_pr__pfet_01v8[vgs]
echo OPV XX1_M59 vgs $&s1_xx1_m59_vgs
let s1_xx1_m59_vds = @m.x1.xdut.xx1_m59.msky130_fd_pr__pfet_01v8[vds]
echo OPV XX1_M59 vds $&s1_xx1_m59_vds
let s1_xx1_m59_vbs = @m.x1.xdut.xx1_m59.msky130_fd_pr__pfet_01v8[vbs]
echo OPV XX1_M59 vbs $&s1_xx1_m59_vbs
let s1_xx1_m59_vth = @m.x1.xdut.xx1_m59.msky130_fd_pr__pfet_01v8[vth]
echo OPV XX1_M59 vth $&s1_xx1_m59_vth
let s1_xx1_m59_vdsat = @m.x1.xdut.xx1_m59.msky130_fd_pr__pfet_01v8[vdsat]
echo OPV XX1_M59 vdsat $&s1_xx1_m59_vdsat
let s1_xx1_m59_gm = @m.x1.xdut.xx1_m59.msky130_fd_pr__pfet_01v8[gm]
echo OPV XX1_M59 gm $&s1_xx1_m59_gm
let s1_xx1_m59_gds = @m.x1.xdut.xx1_m59.msky130_fd_pr__pfet_01v8[gds]
echo OPV XX1_M59 gds $&s1_xx1_m59_gds
let s1_xx1_m59_gmbs = @m.x1.xdut.xx1_m59.msky130_fd_pr__pfet_01v8[gmbs]
echo OPV XX1_M59 gmbs $&s1_xx1_m59_gmbs
let s1_xx1_m59_cgg = @m.x1.xdut.xx1_m59.msky130_fd_pr__pfet_01v8[cgg]
echo OPV XX1_M59 cgg $&s1_xx1_m59_cgg
let s1_xx1_m59_cgd = @m.x1.xdut.xx1_m59.msky130_fd_pr__pfet_01v8[cgd]
echo OPV XX1_M59 cgd $&s1_xx1_m59_cgd
let s1_xx1_m59_cgs = @m.x1.xdut.xx1_m59.msky130_fd_pr__pfet_01v8[cgs]
echo OPV XX1_M59 cgs $&s1_xx1_m59_cgs
let s1_xx1_m59_cgb = @m.x1.xdut.xx1_m59.msky130_fd_pr__pfet_01v8[cgb]
echo OPV XX1_M59 cgb $&s1_xx1_m59_cgb
let s1_xx1_m59_cdg = @m.x1.xdut.xx1_m59.msky130_fd_pr__pfet_01v8[cdg]
echo OPV XX1_M59 cdg $&s1_xx1_m59_cdg
let s1_xx1_m59_cdd = @m.x1.xdut.xx1_m59.msky130_fd_pr__pfet_01v8[cdd]
echo OPV XX1_M59 cdd $&s1_xx1_m59_cdd
let s1_xx1_m59_cds = @m.x1.xdut.xx1_m59.msky130_fd_pr__pfet_01v8[cds]
echo OPV XX1_M59 cds $&s1_xx1_m59_cds
let s1_xx1_m59_cdb = @m.x1.xdut.xx1_m59.msky130_fd_pr__pfet_01v8[cdb]
echo OPV XX1_M59 cdb $&s1_xx1_m59_cdb
let s1_xx1_m59_csg = @m.x1.xdut.xx1_m59.msky130_fd_pr__pfet_01v8[csg]
echo OPV XX1_M59 csg $&s1_xx1_m59_csg
let s1_xx1_m59_csd = @m.x1.xdut.xx1_m59.msky130_fd_pr__pfet_01v8[csd]
echo OPV XX1_M59 csd $&s1_xx1_m59_csd
let s1_xx1_m59_css = @m.x1.xdut.xx1_m59.msky130_fd_pr__pfet_01v8[css]
echo OPV XX1_M59 css $&s1_xx1_m59_css
let s1_xx1_m59_csb = @m.x1.xdut.xx1_m59.msky130_fd_pr__pfet_01v8[csb]
echo OPV XX1_M59 csb $&s1_xx1_m59_csb
let s1_xx1_m59_cbg = @m.x1.xdut.xx1_m59.msky130_fd_pr__pfet_01v8[cbg]
echo OPV XX1_M59 cbg $&s1_xx1_m59_cbg
let s1_xx1_m59_cbd = @m.x1.xdut.xx1_m59.msky130_fd_pr__pfet_01v8[cbd]
echo OPV XX1_M59 cbd $&s1_xx1_m59_cbd
let s1_xx1_m59_cbs = @m.x1.xdut.xx1_m59.msky130_fd_pr__pfet_01v8[cbs]
echo OPV XX1_M59 cbs $&s1_xx1_m59_cbs
let s1_xx1_m59_cbb = @m.x1.xdut.xx1_m59.msky130_fd_pr__pfet_01v8[cbb]
echo OPV XX1_M59 cbb $&s1_xx1_m59_cbb
let s1_xx1_m59_capbd = @m.x1.xdut.xx1_m59.msky130_fd_pr__pfet_01v8[capbd]
echo OPV XX1_M59 capbd $&s1_xx1_m59_capbd
let s1_xx1_m59_capbs = @m.x1.xdut.xx1_m59.msky130_fd_pr__pfet_01v8[capbs]
echo OPV XX1_M59 capbs $&s1_xx1_m59_capbs
let s1_xx1_m59_cgso = @m.x1.xdut.xx1_m59.msky130_fd_pr__pfet_01v8[cgso]
echo OPV XX1_M59 cgso $&s1_xx1_m59_cgso
let s1_xx1_m59_cgdo = @m.x1.xdut.xx1_m59.msky130_fd_pr__pfet_01v8[cgdo]
echo OPV XX1_M59 cgdo $&s1_xx1_m59_cgdo
let s1_xx1_m59_cgbo = @m.x1.xdut.xx1_m59.msky130_fd_pr__pfet_01v8[cgbo]
echo OPV XX1_M59 cgbo $&s1_xx1_m59_cgbo
let s1_xx1_m59_weff = @m.x1.xdut.xx1_m59.msky130_fd_pr__pfet_01v8[weff]
echo OPV XX1_M59 weff $&s1_xx1_m59_weff
let s1_xx1_m59_leff = @m.x1.xdut.xx1_m59.msky130_fd_pr__pfet_01v8[leff]
echo OPV XX1_M59 leff $&s1_xx1_m59_leff
let s1_xx1_m60_id = @m.x1.xdut.xx1_m60.msky130_fd_pr__pfet_01v8[id]
echo OPV XX1_M60 id $&s1_xx1_m60_id
let s1_xx1_m60_vgs = @m.x1.xdut.xx1_m60.msky130_fd_pr__pfet_01v8[vgs]
echo OPV XX1_M60 vgs $&s1_xx1_m60_vgs
let s1_xx1_m60_vds = @m.x1.xdut.xx1_m60.msky130_fd_pr__pfet_01v8[vds]
echo OPV XX1_M60 vds $&s1_xx1_m60_vds
let s1_xx1_m60_vbs = @m.x1.xdut.xx1_m60.msky130_fd_pr__pfet_01v8[vbs]
echo OPV XX1_M60 vbs $&s1_xx1_m60_vbs
let s1_xx1_m60_vth = @m.x1.xdut.xx1_m60.msky130_fd_pr__pfet_01v8[vth]
echo OPV XX1_M60 vth $&s1_xx1_m60_vth
let s1_xx1_m60_vdsat = @m.x1.xdut.xx1_m60.msky130_fd_pr__pfet_01v8[vdsat]
echo OPV XX1_M60 vdsat $&s1_xx1_m60_vdsat
let s1_xx1_m60_gm = @m.x1.xdut.xx1_m60.msky130_fd_pr__pfet_01v8[gm]
echo OPV XX1_M60 gm $&s1_xx1_m60_gm
let s1_xx1_m60_gds = @m.x1.xdut.xx1_m60.msky130_fd_pr__pfet_01v8[gds]
echo OPV XX1_M60 gds $&s1_xx1_m60_gds
let s1_xx1_m60_gmbs = @m.x1.xdut.xx1_m60.msky130_fd_pr__pfet_01v8[gmbs]
echo OPV XX1_M60 gmbs $&s1_xx1_m60_gmbs
let s1_xx1_m60_cgg = @m.x1.xdut.xx1_m60.msky130_fd_pr__pfet_01v8[cgg]
echo OPV XX1_M60 cgg $&s1_xx1_m60_cgg
let s1_xx1_m60_cgd = @m.x1.xdut.xx1_m60.msky130_fd_pr__pfet_01v8[cgd]
echo OPV XX1_M60 cgd $&s1_xx1_m60_cgd
let s1_xx1_m60_cgs = @m.x1.xdut.xx1_m60.msky130_fd_pr__pfet_01v8[cgs]
echo OPV XX1_M60 cgs $&s1_xx1_m60_cgs
let s1_xx1_m60_cgb = @m.x1.xdut.xx1_m60.msky130_fd_pr__pfet_01v8[cgb]
echo OPV XX1_M60 cgb $&s1_xx1_m60_cgb
let s1_xx1_m60_cdg = @m.x1.xdut.xx1_m60.msky130_fd_pr__pfet_01v8[cdg]
echo OPV XX1_M60 cdg $&s1_xx1_m60_cdg
let s1_xx1_m60_cdd = @m.x1.xdut.xx1_m60.msky130_fd_pr__pfet_01v8[cdd]
echo OPV XX1_M60 cdd $&s1_xx1_m60_cdd
let s1_xx1_m60_cds = @m.x1.xdut.xx1_m60.msky130_fd_pr__pfet_01v8[cds]
echo OPV XX1_M60 cds $&s1_xx1_m60_cds
let s1_xx1_m60_cdb = @m.x1.xdut.xx1_m60.msky130_fd_pr__pfet_01v8[cdb]
echo OPV XX1_M60 cdb $&s1_xx1_m60_cdb
let s1_xx1_m60_csg = @m.x1.xdut.xx1_m60.msky130_fd_pr__pfet_01v8[csg]
echo OPV XX1_M60 csg $&s1_xx1_m60_csg
let s1_xx1_m60_csd = @m.x1.xdut.xx1_m60.msky130_fd_pr__pfet_01v8[csd]
echo OPV XX1_M60 csd $&s1_xx1_m60_csd
let s1_xx1_m60_css = @m.x1.xdut.xx1_m60.msky130_fd_pr__pfet_01v8[css]
echo OPV XX1_M60 css $&s1_xx1_m60_css
let s1_xx1_m60_csb = @m.x1.xdut.xx1_m60.msky130_fd_pr__pfet_01v8[csb]
echo OPV XX1_M60 csb $&s1_xx1_m60_csb
let s1_xx1_m60_cbg = @m.x1.xdut.xx1_m60.msky130_fd_pr__pfet_01v8[cbg]
echo OPV XX1_M60 cbg $&s1_xx1_m60_cbg
let s1_xx1_m60_cbd = @m.x1.xdut.xx1_m60.msky130_fd_pr__pfet_01v8[cbd]
echo OPV XX1_M60 cbd $&s1_xx1_m60_cbd
let s1_xx1_m60_cbs = @m.x1.xdut.xx1_m60.msky130_fd_pr__pfet_01v8[cbs]
echo OPV XX1_M60 cbs $&s1_xx1_m60_cbs
let s1_xx1_m60_cbb = @m.x1.xdut.xx1_m60.msky130_fd_pr__pfet_01v8[cbb]
echo OPV XX1_M60 cbb $&s1_xx1_m60_cbb
let s1_xx1_m60_capbd = @m.x1.xdut.xx1_m60.msky130_fd_pr__pfet_01v8[capbd]
echo OPV XX1_M60 capbd $&s1_xx1_m60_capbd
let s1_xx1_m60_capbs = @m.x1.xdut.xx1_m60.msky130_fd_pr__pfet_01v8[capbs]
echo OPV XX1_M60 capbs $&s1_xx1_m60_capbs
let s1_xx1_m60_cgso = @m.x1.xdut.xx1_m60.msky130_fd_pr__pfet_01v8[cgso]
echo OPV XX1_M60 cgso $&s1_xx1_m60_cgso
let s1_xx1_m60_cgdo = @m.x1.xdut.xx1_m60.msky130_fd_pr__pfet_01v8[cgdo]
echo OPV XX1_M60 cgdo $&s1_xx1_m60_cgdo
let s1_xx1_m60_cgbo = @m.x1.xdut.xx1_m60.msky130_fd_pr__pfet_01v8[cgbo]
echo OPV XX1_M60 cgbo $&s1_xx1_m60_cgbo
let s1_xx1_m60_weff = @m.x1.xdut.xx1_m60.msky130_fd_pr__pfet_01v8[weff]
echo OPV XX1_M60 weff $&s1_xx1_m60_weff
let s1_xx1_m60_leff = @m.x1.xdut.xx1_m60.msky130_fd_pr__pfet_01v8[leff]
echo OPV XX1_M60 leff $&s1_xx1_m60_leff
let s1_xx1_m42_id = @m.x1.xdut.xx1_m42.msky130_fd_pr__nfet_01v8[id]
echo OPV XX1_M42 id $&s1_xx1_m42_id
let s1_xx1_m42_vgs = @m.x1.xdut.xx1_m42.msky130_fd_pr__nfet_01v8[vgs]
echo OPV XX1_M42 vgs $&s1_xx1_m42_vgs
let s1_xx1_m42_vds = @m.x1.xdut.xx1_m42.msky130_fd_pr__nfet_01v8[vds]
echo OPV XX1_M42 vds $&s1_xx1_m42_vds
let s1_xx1_m42_vbs = @m.x1.xdut.xx1_m42.msky130_fd_pr__nfet_01v8[vbs]
echo OPV XX1_M42 vbs $&s1_xx1_m42_vbs
let s1_xx1_m42_vth = @m.x1.xdut.xx1_m42.msky130_fd_pr__nfet_01v8[vth]
echo OPV XX1_M42 vth $&s1_xx1_m42_vth
let s1_xx1_m42_vdsat = @m.x1.xdut.xx1_m42.msky130_fd_pr__nfet_01v8[vdsat]
echo OPV XX1_M42 vdsat $&s1_xx1_m42_vdsat
let s1_xx1_m42_gm = @m.x1.xdut.xx1_m42.msky130_fd_pr__nfet_01v8[gm]
echo OPV XX1_M42 gm $&s1_xx1_m42_gm
let s1_xx1_m42_gds = @m.x1.xdut.xx1_m42.msky130_fd_pr__nfet_01v8[gds]
echo OPV XX1_M42 gds $&s1_xx1_m42_gds
let s1_xx1_m42_gmbs = @m.x1.xdut.xx1_m42.msky130_fd_pr__nfet_01v8[gmbs]
echo OPV XX1_M42 gmbs $&s1_xx1_m42_gmbs
let s1_xx1_m42_cgg = @m.x1.xdut.xx1_m42.msky130_fd_pr__nfet_01v8[cgg]
echo OPV XX1_M42 cgg $&s1_xx1_m42_cgg
let s1_xx1_m42_cgd = @m.x1.xdut.xx1_m42.msky130_fd_pr__nfet_01v8[cgd]
echo OPV XX1_M42 cgd $&s1_xx1_m42_cgd
let s1_xx1_m42_cgs = @m.x1.xdut.xx1_m42.msky130_fd_pr__nfet_01v8[cgs]
echo OPV XX1_M42 cgs $&s1_xx1_m42_cgs
let s1_xx1_m42_cgb = @m.x1.xdut.xx1_m42.msky130_fd_pr__nfet_01v8[cgb]
echo OPV XX1_M42 cgb $&s1_xx1_m42_cgb
let s1_xx1_m42_cdg = @m.x1.xdut.xx1_m42.msky130_fd_pr__nfet_01v8[cdg]
echo OPV XX1_M42 cdg $&s1_xx1_m42_cdg
let s1_xx1_m42_cdd = @m.x1.xdut.xx1_m42.msky130_fd_pr__nfet_01v8[cdd]
echo OPV XX1_M42 cdd $&s1_xx1_m42_cdd
let s1_xx1_m42_cds = @m.x1.xdut.xx1_m42.msky130_fd_pr__nfet_01v8[cds]
echo OPV XX1_M42 cds $&s1_xx1_m42_cds
let s1_xx1_m42_cdb = @m.x1.xdut.xx1_m42.msky130_fd_pr__nfet_01v8[cdb]
echo OPV XX1_M42 cdb $&s1_xx1_m42_cdb
let s1_xx1_m42_csg = @m.x1.xdut.xx1_m42.msky130_fd_pr__nfet_01v8[csg]
echo OPV XX1_M42 csg $&s1_xx1_m42_csg
let s1_xx1_m42_csd = @m.x1.xdut.xx1_m42.msky130_fd_pr__nfet_01v8[csd]
echo OPV XX1_M42 csd $&s1_xx1_m42_csd
let s1_xx1_m42_css = @m.x1.xdut.xx1_m42.msky130_fd_pr__nfet_01v8[css]
echo OPV XX1_M42 css $&s1_xx1_m42_css
let s1_xx1_m42_csb = @m.x1.xdut.xx1_m42.msky130_fd_pr__nfet_01v8[csb]
echo OPV XX1_M42 csb $&s1_xx1_m42_csb
let s1_xx1_m42_cbg = @m.x1.xdut.xx1_m42.msky130_fd_pr__nfet_01v8[cbg]
echo OPV XX1_M42 cbg $&s1_xx1_m42_cbg
let s1_xx1_m42_cbd = @m.x1.xdut.xx1_m42.msky130_fd_pr__nfet_01v8[cbd]
echo OPV XX1_M42 cbd $&s1_xx1_m42_cbd
let s1_xx1_m42_cbs = @m.x1.xdut.xx1_m42.msky130_fd_pr__nfet_01v8[cbs]
echo OPV XX1_M42 cbs $&s1_xx1_m42_cbs
let s1_xx1_m42_cbb = @m.x1.xdut.xx1_m42.msky130_fd_pr__nfet_01v8[cbb]
echo OPV XX1_M42 cbb $&s1_xx1_m42_cbb
let s1_xx1_m42_capbd = @m.x1.xdut.xx1_m42.msky130_fd_pr__nfet_01v8[capbd]
echo OPV XX1_M42 capbd $&s1_xx1_m42_capbd
let s1_xx1_m42_capbs = @m.x1.xdut.xx1_m42.msky130_fd_pr__nfet_01v8[capbs]
echo OPV XX1_M42 capbs $&s1_xx1_m42_capbs
let s1_xx1_m42_cgso = @m.x1.xdut.xx1_m42.msky130_fd_pr__nfet_01v8[cgso]
echo OPV XX1_M42 cgso $&s1_xx1_m42_cgso
let s1_xx1_m42_cgdo = @m.x1.xdut.xx1_m42.msky130_fd_pr__nfet_01v8[cgdo]
echo OPV XX1_M42 cgdo $&s1_xx1_m42_cgdo
let s1_xx1_m42_cgbo = @m.x1.xdut.xx1_m42.msky130_fd_pr__nfet_01v8[cgbo]
echo OPV XX1_M42 cgbo $&s1_xx1_m42_cgbo
let s1_xx1_m42_weff = @m.x1.xdut.xx1_m42.msky130_fd_pr__nfet_01v8[weff]
echo OPV XX1_M42 weff $&s1_xx1_m42_weff
let s1_xx1_m42_leff = @m.x1.xdut.xx1_m42.msky130_fd_pr__nfet_01v8[leff]
echo OPV XX1_M42 leff $&s1_xx1_m42_leff
let s1_xx1_m44_id = @m.x1.xdut.xx1_m44.msky130_fd_pr__nfet_01v8[id]
echo OPV XX1_M44 id $&s1_xx1_m44_id
let s1_xx1_m44_vgs = @m.x1.xdut.xx1_m44.msky130_fd_pr__nfet_01v8[vgs]
echo OPV XX1_M44 vgs $&s1_xx1_m44_vgs
let s1_xx1_m44_vds = @m.x1.xdut.xx1_m44.msky130_fd_pr__nfet_01v8[vds]
echo OPV XX1_M44 vds $&s1_xx1_m44_vds
let s1_xx1_m44_vbs = @m.x1.xdut.xx1_m44.msky130_fd_pr__nfet_01v8[vbs]
echo OPV XX1_M44 vbs $&s1_xx1_m44_vbs
let s1_xx1_m44_vth = @m.x1.xdut.xx1_m44.msky130_fd_pr__nfet_01v8[vth]
echo OPV XX1_M44 vth $&s1_xx1_m44_vth
let s1_xx1_m44_vdsat = @m.x1.xdut.xx1_m44.msky130_fd_pr__nfet_01v8[vdsat]
echo OPV XX1_M44 vdsat $&s1_xx1_m44_vdsat
let s1_xx1_m44_gm = @m.x1.xdut.xx1_m44.msky130_fd_pr__nfet_01v8[gm]
echo OPV XX1_M44 gm $&s1_xx1_m44_gm
let s1_xx1_m44_gds = @m.x1.xdut.xx1_m44.msky130_fd_pr__nfet_01v8[gds]
echo OPV XX1_M44 gds $&s1_xx1_m44_gds
let s1_xx1_m44_gmbs = @m.x1.xdut.xx1_m44.msky130_fd_pr__nfet_01v8[gmbs]
echo OPV XX1_M44 gmbs $&s1_xx1_m44_gmbs
let s1_xx1_m44_cgg = @m.x1.xdut.xx1_m44.msky130_fd_pr__nfet_01v8[cgg]
echo OPV XX1_M44 cgg $&s1_xx1_m44_cgg
let s1_xx1_m44_cgd = @m.x1.xdut.xx1_m44.msky130_fd_pr__nfet_01v8[cgd]
echo OPV XX1_M44 cgd $&s1_xx1_m44_cgd
let s1_xx1_m44_cgs = @m.x1.xdut.xx1_m44.msky130_fd_pr__nfet_01v8[cgs]
echo OPV XX1_M44 cgs $&s1_xx1_m44_cgs
let s1_xx1_m44_cgb = @m.x1.xdut.xx1_m44.msky130_fd_pr__nfet_01v8[cgb]
echo OPV XX1_M44 cgb $&s1_xx1_m44_cgb
let s1_xx1_m44_cdg = @m.x1.xdut.xx1_m44.msky130_fd_pr__nfet_01v8[cdg]
echo OPV XX1_M44 cdg $&s1_xx1_m44_cdg
let s1_xx1_m44_cdd = @m.x1.xdut.xx1_m44.msky130_fd_pr__nfet_01v8[cdd]
echo OPV XX1_M44 cdd $&s1_xx1_m44_cdd
let s1_xx1_m44_cds = @m.x1.xdut.xx1_m44.msky130_fd_pr__nfet_01v8[cds]
echo OPV XX1_M44 cds $&s1_xx1_m44_cds
let s1_xx1_m44_cdb = @m.x1.xdut.xx1_m44.msky130_fd_pr__nfet_01v8[cdb]
echo OPV XX1_M44 cdb $&s1_xx1_m44_cdb
let s1_xx1_m44_csg = @m.x1.xdut.xx1_m44.msky130_fd_pr__nfet_01v8[csg]
echo OPV XX1_M44 csg $&s1_xx1_m44_csg
let s1_xx1_m44_csd = @m.x1.xdut.xx1_m44.msky130_fd_pr__nfet_01v8[csd]
echo OPV XX1_M44 csd $&s1_xx1_m44_csd
let s1_xx1_m44_css = @m.x1.xdut.xx1_m44.msky130_fd_pr__nfet_01v8[css]
echo OPV XX1_M44 css $&s1_xx1_m44_css
let s1_xx1_m44_csb = @m.x1.xdut.xx1_m44.msky130_fd_pr__nfet_01v8[csb]
echo OPV XX1_M44 csb $&s1_xx1_m44_csb
let s1_xx1_m44_cbg = @m.x1.xdut.xx1_m44.msky130_fd_pr__nfet_01v8[cbg]
echo OPV XX1_M44 cbg $&s1_xx1_m44_cbg
let s1_xx1_m44_cbd = @m.x1.xdut.xx1_m44.msky130_fd_pr__nfet_01v8[cbd]
echo OPV XX1_M44 cbd $&s1_xx1_m44_cbd
let s1_xx1_m44_cbs = @m.x1.xdut.xx1_m44.msky130_fd_pr__nfet_01v8[cbs]
echo OPV XX1_M44 cbs $&s1_xx1_m44_cbs
let s1_xx1_m44_cbb = @m.x1.xdut.xx1_m44.msky130_fd_pr__nfet_01v8[cbb]
echo OPV XX1_M44 cbb $&s1_xx1_m44_cbb
let s1_xx1_m44_capbd = @m.x1.xdut.xx1_m44.msky130_fd_pr__nfet_01v8[capbd]
echo OPV XX1_M44 capbd $&s1_xx1_m44_capbd
let s1_xx1_m44_capbs = @m.x1.xdut.xx1_m44.msky130_fd_pr__nfet_01v8[capbs]
echo OPV XX1_M44 capbs $&s1_xx1_m44_capbs
let s1_xx1_m44_cgso = @m.x1.xdut.xx1_m44.msky130_fd_pr__nfet_01v8[cgso]
echo OPV XX1_M44 cgso $&s1_xx1_m44_cgso
let s1_xx1_m44_cgdo = @m.x1.xdut.xx1_m44.msky130_fd_pr__nfet_01v8[cgdo]
echo OPV XX1_M44 cgdo $&s1_xx1_m44_cgdo
let s1_xx1_m44_cgbo = @m.x1.xdut.xx1_m44.msky130_fd_pr__nfet_01v8[cgbo]
echo OPV XX1_M44 cgbo $&s1_xx1_m44_cgbo
let s1_xx1_m44_weff = @m.x1.xdut.xx1_m44.msky130_fd_pr__nfet_01v8[weff]
echo OPV XX1_M44 weff $&s1_xx1_m44_weff
let s1_xx1_m44_leff = @m.x1.xdut.xx1_m44.msky130_fd_pr__nfet_01v8[leff]
echo OPV XX1_M44 leff $&s1_xx1_m44_leff
let s1_xx1_m34_id = @m.x1.xdut.xx1_m34.msky130_fd_pr__nfet_01v8[id]
echo OPV XX1_M34 id $&s1_xx1_m34_id
let s1_xx1_m34_vgs = @m.x1.xdut.xx1_m34.msky130_fd_pr__nfet_01v8[vgs]
echo OPV XX1_M34 vgs $&s1_xx1_m34_vgs
let s1_xx1_m34_vds = @m.x1.xdut.xx1_m34.msky130_fd_pr__nfet_01v8[vds]
echo OPV XX1_M34 vds $&s1_xx1_m34_vds
let s1_xx1_m34_vbs = @m.x1.xdut.xx1_m34.msky130_fd_pr__nfet_01v8[vbs]
echo OPV XX1_M34 vbs $&s1_xx1_m34_vbs
let s1_xx1_m34_vth = @m.x1.xdut.xx1_m34.msky130_fd_pr__nfet_01v8[vth]
echo OPV XX1_M34 vth $&s1_xx1_m34_vth
let s1_xx1_m34_vdsat = @m.x1.xdut.xx1_m34.msky130_fd_pr__nfet_01v8[vdsat]
echo OPV XX1_M34 vdsat $&s1_xx1_m34_vdsat
let s1_xx1_m34_gm = @m.x1.xdut.xx1_m34.msky130_fd_pr__nfet_01v8[gm]
echo OPV XX1_M34 gm $&s1_xx1_m34_gm
let s1_xx1_m34_gds = @m.x1.xdut.xx1_m34.msky130_fd_pr__nfet_01v8[gds]
echo OPV XX1_M34 gds $&s1_xx1_m34_gds
let s1_xx1_m34_gmbs = @m.x1.xdut.xx1_m34.msky130_fd_pr__nfet_01v8[gmbs]
echo OPV XX1_M34 gmbs $&s1_xx1_m34_gmbs
let s1_xx1_m34_cgg = @m.x1.xdut.xx1_m34.msky130_fd_pr__nfet_01v8[cgg]
echo OPV XX1_M34 cgg $&s1_xx1_m34_cgg
let s1_xx1_m34_cgd = @m.x1.xdut.xx1_m34.msky130_fd_pr__nfet_01v8[cgd]
echo OPV XX1_M34 cgd $&s1_xx1_m34_cgd
let s1_xx1_m34_cgs = @m.x1.xdut.xx1_m34.msky130_fd_pr__nfet_01v8[cgs]
echo OPV XX1_M34 cgs $&s1_xx1_m34_cgs
let s1_xx1_m34_cgb = @m.x1.xdut.xx1_m34.msky130_fd_pr__nfet_01v8[cgb]
echo OPV XX1_M34 cgb $&s1_xx1_m34_cgb
let s1_xx1_m34_cdg = @m.x1.xdut.xx1_m34.msky130_fd_pr__nfet_01v8[cdg]
echo OPV XX1_M34 cdg $&s1_xx1_m34_cdg
let s1_xx1_m34_cdd = @m.x1.xdut.xx1_m34.msky130_fd_pr__nfet_01v8[cdd]
echo OPV XX1_M34 cdd $&s1_xx1_m34_cdd
let s1_xx1_m34_cds = @m.x1.xdut.xx1_m34.msky130_fd_pr__nfet_01v8[cds]
echo OPV XX1_M34 cds $&s1_xx1_m34_cds
let s1_xx1_m34_cdb = @m.x1.xdut.xx1_m34.msky130_fd_pr__nfet_01v8[cdb]
echo OPV XX1_M34 cdb $&s1_xx1_m34_cdb
let s1_xx1_m34_csg = @m.x1.xdut.xx1_m34.msky130_fd_pr__nfet_01v8[csg]
echo OPV XX1_M34 csg $&s1_xx1_m34_csg
let s1_xx1_m34_csd = @m.x1.xdut.xx1_m34.msky130_fd_pr__nfet_01v8[csd]
echo OPV XX1_M34 csd $&s1_xx1_m34_csd
let s1_xx1_m34_css = @m.x1.xdut.xx1_m34.msky130_fd_pr__nfet_01v8[css]
echo OPV XX1_M34 css $&s1_xx1_m34_css
let s1_xx1_m34_csb = @m.x1.xdut.xx1_m34.msky130_fd_pr__nfet_01v8[csb]
echo OPV XX1_M34 csb $&s1_xx1_m34_csb
let s1_xx1_m34_cbg = @m.x1.xdut.xx1_m34.msky130_fd_pr__nfet_01v8[cbg]
echo OPV XX1_M34 cbg $&s1_xx1_m34_cbg
let s1_xx1_m34_cbd = @m.x1.xdut.xx1_m34.msky130_fd_pr__nfet_01v8[cbd]
echo OPV XX1_M34 cbd $&s1_xx1_m34_cbd
let s1_xx1_m34_cbs = @m.x1.xdut.xx1_m34.msky130_fd_pr__nfet_01v8[cbs]
echo OPV XX1_M34 cbs $&s1_xx1_m34_cbs
let s1_xx1_m34_cbb = @m.x1.xdut.xx1_m34.msky130_fd_pr__nfet_01v8[cbb]
echo OPV XX1_M34 cbb $&s1_xx1_m34_cbb
let s1_xx1_m34_capbd = @m.x1.xdut.xx1_m34.msky130_fd_pr__nfet_01v8[capbd]
echo OPV XX1_M34 capbd $&s1_xx1_m34_capbd
let s1_xx1_m34_capbs = @m.x1.xdut.xx1_m34.msky130_fd_pr__nfet_01v8[capbs]
echo OPV XX1_M34 capbs $&s1_xx1_m34_capbs
let s1_xx1_m34_cgso = @m.x1.xdut.xx1_m34.msky130_fd_pr__nfet_01v8[cgso]
echo OPV XX1_M34 cgso $&s1_xx1_m34_cgso
let s1_xx1_m34_cgdo = @m.x1.xdut.xx1_m34.msky130_fd_pr__nfet_01v8[cgdo]
echo OPV XX1_M34 cgdo $&s1_xx1_m34_cgdo
let s1_xx1_m34_cgbo = @m.x1.xdut.xx1_m34.msky130_fd_pr__nfet_01v8[cgbo]
echo OPV XX1_M34 cgbo $&s1_xx1_m34_cgbo
let s1_xx1_m34_weff = @m.x1.xdut.xx1_m34.msky130_fd_pr__nfet_01v8[weff]
echo OPV XX1_M34 weff $&s1_xx1_m34_weff
let s1_xx1_m34_leff = @m.x1.xdut.xx1_m34.msky130_fd_pr__nfet_01v8[leff]
echo OPV XX1_M34 leff $&s1_xx1_m34_leff
let s1_xx1_m35_id = @m.x1.xdut.xx1_m35.msky130_fd_pr__nfet_01v8[id]
echo OPV XX1_M35 id $&s1_xx1_m35_id
let s1_xx1_m35_vgs = @m.x1.xdut.xx1_m35.msky130_fd_pr__nfet_01v8[vgs]
echo OPV XX1_M35 vgs $&s1_xx1_m35_vgs
let s1_xx1_m35_vds = @m.x1.xdut.xx1_m35.msky130_fd_pr__nfet_01v8[vds]
echo OPV XX1_M35 vds $&s1_xx1_m35_vds
let s1_xx1_m35_vbs = @m.x1.xdut.xx1_m35.msky130_fd_pr__nfet_01v8[vbs]
echo OPV XX1_M35 vbs $&s1_xx1_m35_vbs
let s1_xx1_m35_vth = @m.x1.xdut.xx1_m35.msky130_fd_pr__nfet_01v8[vth]
echo OPV XX1_M35 vth $&s1_xx1_m35_vth
let s1_xx1_m35_vdsat = @m.x1.xdut.xx1_m35.msky130_fd_pr__nfet_01v8[vdsat]
echo OPV XX1_M35 vdsat $&s1_xx1_m35_vdsat
let s1_xx1_m35_gm = @m.x1.xdut.xx1_m35.msky130_fd_pr__nfet_01v8[gm]
echo OPV XX1_M35 gm $&s1_xx1_m35_gm
let s1_xx1_m35_gds = @m.x1.xdut.xx1_m35.msky130_fd_pr__nfet_01v8[gds]
echo OPV XX1_M35 gds $&s1_xx1_m35_gds
let s1_xx1_m35_gmbs = @m.x1.xdut.xx1_m35.msky130_fd_pr__nfet_01v8[gmbs]
echo OPV XX1_M35 gmbs $&s1_xx1_m35_gmbs
let s1_xx1_m35_cgg = @m.x1.xdut.xx1_m35.msky130_fd_pr__nfet_01v8[cgg]
echo OPV XX1_M35 cgg $&s1_xx1_m35_cgg
let s1_xx1_m35_cgd = @m.x1.xdut.xx1_m35.msky130_fd_pr__nfet_01v8[cgd]
echo OPV XX1_M35 cgd $&s1_xx1_m35_cgd
let s1_xx1_m35_cgs = @m.x1.xdut.xx1_m35.msky130_fd_pr__nfet_01v8[cgs]
echo OPV XX1_M35 cgs $&s1_xx1_m35_cgs
let s1_xx1_m35_cgb = @m.x1.xdut.xx1_m35.msky130_fd_pr__nfet_01v8[cgb]
echo OPV XX1_M35 cgb $&s1_xx1_m35_cgb
let s1_xx1_m35_cdg = @m.x1.xdut.xx1_m35.msky130_fd_pr__nfet_01v8[cdg]
echo OPV XX1_M35 cdg $&s1_xx1_m35_cdg
let s1_xx1_m35_cdd = @m.x1.xdut.xx1_m35.msky130_fd_pr__nfet_01v8[cdd]
echo OPV XX1_M35 cdd $&s1_xx1_m35_cdd
let s1_xx1_m35_cds = @m.x1.xdut.xx1_m35.msky130_fd_pr__nfet_01v8[cds]
echo OPV XX1_M35 cds $&s1_xx1_m35_cds
let s1_xx1_m35_cdb = @m.x1.xdut.xx1_m35.msky130_fd_pr__nfet_01v8[cdb]
echo OPV XX1_M35 cdb $&s1_xx1_m35_cdb
let s1_xx1_m35_csg = @m.x1.xdut.xx1_m35.msky130_fd_pr__nfet_01v8[csg]
echo OPV XX1_M35 csg $&s1_xx1_m35_csg
let s1_xx1_m35_csd = @m.x1.xdut.xx1_m35.msky130_fd_pr__nfet_01v8[csd]
echo OPV XX1_M35 csd $&s1_xx1_m35_csd
let s1_xx1_m35_css = @m.x1.xdut.xx1_m35.msky130_fd_pr__nfet_01v8[css]
echo OPV XX1_M35 css $&s1_xx1_m35_css
let s1_xx1_m35_csb = @m.x1.xdut.xx1_m35.msky130_fd_pr__nfet_01v8[csb]
echo OPV XX1_M35 csb $&s1_xx1_m35_csb
let s1_xx1_m35_cbg = @m.x1.xdut.xx1_m35.msky130_fd_pr__nfet_01v8[cbg]
echo OPV XX1_M35 cbg $&s1_xx1_m35_cbg
let s1_xx1_m35_cbd = @m.x1.xdut.xx1_m35.msky130_fd_pr__nfet_01v8[cbd]
echo OPV XX1_M35 cbd $&s1_xx1_m35_cbd
let s1_xx1_m35_cbs = @m.x1.xdut.xx1_m35.msky130_fd_pr__nfet_01v8[cbs]
echo OPV XX1_M35 cbs $&s1_xx1_m35_cbs
let s1_xx1_m35_cbb = @m.x1.xdut.xx1_m35.msky130_fd_pr__nfet_01v8[cbb]
echo OPV XX1_M35 cbb $&s1_xx1_m35_cbb
let s1_xx1_m35_capbd = @m.x1.xdut.xx1_m35.msky130_fd_pr__nfet_01v8[capbd]
echo OPV XX1_M35 capbd $&s1_xx1_m35_capbd
let s1_xx1_m35_capbs = @m.x1.xdut.xx1_m35.msky130_fd_pr__nfet_01v8[capbs]
echo OPV XX1_M35 capbs $&s1_xx1_m35_capbs
let s1_xx1_m35_cgso = @m.x1.xdut.xx1_m35.msky130_fd_pr__nfet_01v8[cgso]
echo OPV XX1_M35 cgso $&s1_xx1_m35_cgso
let s1_xx1_m35_cgdo = @m.x1.xdut.xx1_m35.msky130_fd_pr__nfet_01v8[cgdo]
echo OPV XX1_M35 cgdo $&s1_xx1_m35_cgdo
let s1_xx1_m35_cgbo = @m.x1.xdut.xx1_m35.msky130_fd_pr__nfet_01v8[cgbo]
echo OPV XX1_M35 cgbo $&s1_xx1_m35_cgbo
let s1_xx1_m35_weff = @m.x1.xdut.xx1_m35.msky130_fd_pr__nfet_01v8[weff]
echo OPV XX1_M35 weff $&s1_xx1_m35_weff
let s1_xx1_m35_leff = @m.x1.xdut.xx1_m35.msky130_fd_pr__nfet_01v8[leff]
echo OPV XX1_M35 leff $&s1_xx1_m35_leff
let s1_xx1_m36_id = @m.x1.xdut.xx1_m36.msky130_fd_pr__nfet_01v8[id]
echo OPV XX1_M36 id $&s1_xx1_m36_id
let s1_xx1_m36_vgs = @m.x1.xdut.xx1_m36.msky130_fd_pr__nfet_01v8[vgs]
echo OPV XX1_M36 vgs $&s1_xx1_m36_vgs
let s1_xx1_m36_vds = @m.x1.xdut.xx1_m36.msky130_fd_pr__nfet_01v8[vds]
echo OPV XX1_M36 vds $&s1_xx1_m36_vds
let s1_xx1_m36_vbs = @m.x1.xdut.xx1_m36.msky130_fd_pr__nfet_01v8[vbs]
echo OPV XX1_M36 vbs $&s1_xx1_m36_vbs
let s1_xx1_m36_vth = @m.x1.xdut.xx1_m36.msky130_fd_pr__nfet_01v8[vth]
echo OPV XX1_M36 vth $&s1_xx1_m36_vth
let s1_xx1_m36_vdsat = @m.x1.xdut.xx1_m36.msky130_fd_pr__nfet_01v8[vdsat]
echo OPV XX1_M36 vdsat $&s1_xx1_m36_vdsat
let s1_xx1_m36_gm = @m.x1.xdut.xx1_m36.msky130_fd_pr__nfet_01v8[gm]
echo OPV XX1_M36 gm $&s1_xx1_m36_gm
let s1_xx1_m36_gds = @m.x1.xdut.xx1_m36.msky130_fd_pr__nfet_01v8[gds]
echo OPV XX1_M36 gds $&s1_xx1_m36_gds
let s1_xx1_m36_gmbs = @m.x1.xdut.xx1_m36.msky130_fd_pr__nfet_01v8[gmbs]
echo OPV XX1_M36 gmbs $&s1_xx1_m36_gmbs
let s1_xx1_m36_cgg = @m.x1.xdut.xx1_m36.msky130_fd_pr__nfet_01v8[cgg]
echo OPV XX1_M36 cgg $&s1_xx1_m36_cgg
let s1_xx1_m36_cgd = @m.x1.xdut.xx1_m36.msky130_fd_pr__nfet_01v8[cgd]
echo OPV XX1_M36 cgd $&s1_xx1_m36_cgd
let s1_xx1_m36_cgs = @m.x1.xdut.xx1_m36.msky130_fd_pr__nfet_01v8[cgs]
echo OPV XX1_M36 cgs $&s1_xx1_m36_cgs
let s1_xx1_m36_cgb = @m.x1.xdut.xx1_m36.msky130_fd_pr__nfet_01v8[cgb]
echo OPV XX1_M36 cgb $&s1_xx1_m36_cgb
let s1_xx1_m36_cdg = @m.x1.xdut.xx1_m36.msky130_fd_pr__nfet_01v8[cdg]
echo OPV XX1_M36 cdg $&s1_xx1_m36_cdg
let s1_xx1_m36_cdd = @m.x1.xdut.xx1_m36.msky130_fd_pr__nfet_01v8[cdd]
echo OPV XX1_M36 cdd $&s1_xx1_m36_cdd
let s1_xx1_m36_cds = @m.x1.xdut.xx1_m36.msky130_fd_pr__nfet_01v8[cds]
echo OPV XX1_M36 cds $&s1_xx1_m36_cds
let s1_xx1_m36_cdb = @m.x1.xdut.xx1_m36.msky130_fd_pr__nfet_01v8[cdb]
echo OPV XX1_M36 cdb $&s1_xx1_m36_cdb
let s1_xx1_m36_csg = @m.x1.xdut.xx1_m36.msky130_fd_pr__nfet_01v8[csg]
echo OPV XX1_M36 csg $&s1_xx1_m36_csg
let s1_xx1_m36_csd = @m.x1.xdut.xx1_m36.msky130_fd_pr__nfet_01v8[csd]
echo OPV XX1_M36 csd $&s1_xx1_m36_csd
let s1_xx1_m36_css = @m.x1.xdut.xx1_m36.msky130_fd_pr__nfet_01v8[css]
echo OPV XX1_M36 css $&s1_xx1_m36_css
let s1_xx1_m36_csb = @m.x1.xdut.xx1_m36.msky130_fd_pr__nfet_01v8[csb]
echo OPV XX1_M36 csb $&s1_xx1_m36_csb
let s1_xx1_m36_cbg = @m.x1.xdut.xx1_m36.msky130_fd_pr__nfet_01v8[cbg]
echo OPV XX1_M36 cbg $&s1_xx1_m36_cbg
let s1_xx1_m36_cbd = @m.x1.xdut.xx1_m36.msky130_fd_pr__nfet_01v8[cbd]
echo OPV XX1_M36 cbd $&s1_xx1_m36_cbd
let s1_xx1_m36_cbs = @m.x1.xdut.xx1_m36.msky130_fd_pr__nfet_01v8[cbs]
echo OPV XX1_M36 cbs $&s1_xx1_m36_cbs
let s1_xx1_m36_cbb = @m.x1.xdut.xx1_m36.msky130_fd_pr__nfet_01v8[cbb]
echo OPV XX1_M36 cbb $&s1_xx1_m36_cbb
let s1_xx1_m36_capbd = @m.x1.xdut.xx1_m36.msky130_fd_pr__nfet_01v8[capbd]
echo OPV XX1_M36 capbd $&s1_xx1_m36_capbd
let s1_xx1_m36_capbs = @m.x1.xdut.xx1_m36.msky130_fd_pr__nfet_01v8[capbs]
echo OPV XX1_M36 capbs $&s1_xx1_m36_capbs
let s1_xx1_m36_cgso = @m.x1.xdut.xx1_m36.msky130_fd_pr__nfet_01v8[cgso]
echo OPV XX1_M36 cgso $&s1_xx1_m36_cgso
let s1_xx1_m36_cgdo = @m.x1.xdut.xx1_m36.msky130_fd_pr__nfet_01v8[cgdo]
echo OPV XX1_M36 cgdo $&s1_xx1_m36_cgdo
let s1_xx1_m36_cgbo = @m.x1.xdut.xx1_m36.msky130_fd_pr__nfet_01v8[cgbo]
echo OPV XX1_M36 cgbo $&s1_xx1_m36_cgbo
let s1_xx1_m36_weff = @m.x1.xdut.xx1_m36.msky130_fd_pr__nfet_01v8[weff]
echo OPV XX1_M36 weff $&s1_xx1_m36_weff
let s1_xx1_m36_leff = @m.x1.xdut.xx1_m36.msky130_fd_pr__nfet_01v8[leff]
echo OPV XX1_M36 leff $&s1_xx1_m36_leff
let s1_xx1_m37_id = @m.x1.xdut.xx1_m37.msky130_fd_pr__nfet_01v8[id]
echo OPV XX1_M37 id $&s1_xx1_m37_id
let s1_xx1_m37_vgs = @m.x1.xdut.xx1_m37.msky130_fd_pr__nfet_01v8[vgs]
echo OPV XX1_M37 vgs $&s1_xx1_m37_vgs
let s1_xx1_m37_vds = @m.x1.xdut.xx1_m37.msky130_fd_pr__nfet_01v8[vds]
echo OPV XX1_M37 vds $&s1_xx1_m37_vds
let s1_xx1_m37_vbs = @m.x1.xdut.xx1_m37.msky130_fd_pr__nfet_01v8[vbs]
echo OPV XX1_M37 vbs $&s1_xx1_m37_vbs
let s1_xx1_m37_vth = @m.x1.xdut.xx1_m37.msky130_fd_pr__nfet_01v8[vth]
echo OPV XX1_M37 vth $&s1_xx1_m37_vth
let s1_xx1_m37_vdsat = @m.x1.xdut.xx1_m37.msky130_fd_pr__nfet_01v8[vdsat]
echo OPV XX1_M37 vdsat $&s1_xx1_m37_vdsat
let s1_xx1_m37_gm = @m.x1.xdut.xx1_m37.msky130_fd_pr__nfet_01v8[gm]
echo OPV XX1_M37 gm $&s1_xx1_m37_gm
let s1_xx1_m37_gds = @m.x1.xdut.xx1_m37.msky130_fd_pr__nfet_01v8[gds]
echo OPV XX1_M37 gds $&s1_xx1_m37_gds
let s1_xx1_m37_gmbs = @m.x1.xdut.xx1_m37.msky130_fd_pr__nfet_01v8[gmbs]
echo OPV XX1_M37 gmbs $&s1_xx1_m37_gmbs
let s1_xx1_m37_cgg = @m.x1.xdut.xx1_m37.msky130_fd_pr__nfet_01v8[cgg]
echo OPV XX1_M37 cgg $&s1_xx1_m37_cgg
let s1_xx1_m37_cgd = @m.x1.xdut.xx1_m37.msky130_fd_pr__nfet_01v8[cgd]
echo OPV XX1_M37 cgd $&s1_xx1_m37_cgd
let s1_xx1_m37_cgs = @m.x1.xdut.xx1_m37.msky130_fd_pr__nfet_01v8[cgs]
echo OPV XX1_M37 cgs $&s1_xx1_m37_cgs
let s1_xx1_m37_cgb = @m.x1.xdut.xx1_m37.msky130_fd_pr__nfet_01v8[cgb]
echo OPV XX1_M37 cgb $&s1_xx1_m37_cgb
let s1_xx1_m37_cdg = @m.x1.xdut.xx1_m37.msky130_fd_pr__nfet_01v8[cdg]
echo OPV XX1_M37 cdg $&s1_xx1_m37_cdg
let s1_xx1_m37_cdd = @m.x1.xdut.xx1_m37.msky130_fd_pr__nfet_01v8[cdd]
echo OPV XX1_M37 cdd $&s1_xx1_m37_cdd
let s1_xx1_m37_cds = @m.x1.xdut.xx1_m37.msky130_fd_pr__nfet_01v8[cds]
echo OPV XX1_M37 cds $&s1_xx1_m37_cds
let s1_xx1_m37_cdb = @m.x1.xdut.xx1_m37.msky130_fd_pr__nfet_01v8[cdb]
echo OPV XX1_M37 cdb $&s1_xx1_m37_cdb
let s1_xx1_m37_csg = @m.x1.xdut.xx1_m37.msky130_fd_pr__nfet_01v8[csg]
echo OPV XX1_M37 csg $&s1_xx1_m37_csg
let s1_xx1_m37_csd = @m.x1.xdut.xx1_m37.msky130_fd_pr__nfet_01v8[csd]
echo OPV XX1_M37 csd $&s1_xx1_m37_csd
let s1_xx1_m37_css = @m.x1.xdut.xx1_m37.msky130_fd_pr__nfet_01v8[css]
echo OPV XX1_M37 css $&s1_xx1_m37_css
let s1_xx1_m37_csb = @m.x1.xdut.xx1_m37.msky130_fd_pr__nfet_01v8[csb]
echo OPV XX1_M37 csb $&s1_xx1_m37_csb
let s1_xx1_m37_cbg = @m.x1.xdut.xx1_m37.msky130_fd_pr__nfet_01v8[cbg]
echo OPV XX1_M37 cbg $&s1_xx1_m37_cbg
let s1_xx1_m37_cbd = @m.x1.xdut.xx1_m37.msky130_fd_pr__nfet_01v8[cbd]
echo OPV XX1_M37 cbd $&s1_xx1_m37_cbd
let s1_xx1_m37_cbs = @m.x1.xdut.xx1_m37.msky130_fd_pr__nfet_01v8[cbs]
echo OPV XX1_M37 cbs $&s1_xx1_m37_cbs
let s1_xx1_m37_cbb = @m.x1.xdut.xx1_m37.msky130_fd_pr__nfet_01v8[cbb]
echo OPV XX1_M37 cbb $&s1_xx1_m37_cbb
let s1_xx1_m37_capbd = @m.x1.xdut.xx1_m37.msky130_fd_pr__nfet_01v8[capbd]
echo OPV XX1_M37 capbd $&s1_xx1_m37_capbd
let s1_xx1_m37_capbs = @m.x1.xdut.xx1_m37.msky130_fd_pr__nfet_01v8[capbs]
echo OPV XX1_M37 capbs $&s1_xx1_m37_capbs
let s1_xx1_m37_cgso = @m.x1.xdut.xx1_m37.msky130_fd_pr__nfet_01v8[cgso]
echo OPV XX1_M37 cgso $&s1_xx1_m37_cgso
let s1_xx1_m37_cgdo = @m.x1.xdut.xx1_m37.msky130_fd_pr__nfet_01v8[cgdo]
echo OPV XX1_M37 cgdo $&s1_xx1_m37_cgdo
let s1_xx1_m37_cgbo = @m.x1.xdut.xx1_m37.msky130_fd_pr__nfet_01v8[cgbo]
echo OPV XX1_M37 cgbo $&s1_xx1_m37_cgbo
let s1_xx1_m37_weff = @m.x1.xdut.xx1_m37.msky130_fd_pr__nfet_01v8[weff]
echo OPV XX1_M37 weff $&s1_xx1_m37_weff
let s1_xx1_m37_leff = @m.x1.xdut.xx1_m37.msky130_fd_pr__nfet_01v8[leff]
echo OPV XX1_M37 leff $&s1_xx1_m37_leff
let s1_xx1_m54_id = @m.x1.xdut.xx1_m54.msky130_fd_pr__pfet_01v8[id]
echo OPV XX1_M54 id $&s1_xx1_m54_id
let s1_xx1_m54_vgs = @m.x1.xdut.xx1_m54.msky130_fd_pr__pfet_01v8[vgs]
echo OPV XX1_M54 vgs $&s1_xx1_m54_vgs
let s1_xx1_m54_vds = @m.x1.xdut.xx1_m54.msky130_fd_pr__pfet_01v8[vds]
echo OPV XX1_M54 vds $&s1_xx1_m54_vds
let s1_xx1_m54_vbs = @m.x1.xdut.xx1_m54.msky130_fd_pr__pfet_01v8[vbs]
echo OPV XX1_M54 vbs $&s1_xx1_m54_vbs
let s1_xx1_m54_vth = @m.x1.xdut.xx1_m54.msky130_fd_pr__pfet_01v8[vth]
echo OPV XX1_M54 vth $&s1_xx1_m54_vth
let s1_xx1_m54_vdsat = @m.x1.xdut.xx1_m54.msky130_fd_pr__pfet_01v8[vdsat]
echo OPV XX1_M54 vdsat $&s1_xx1_m54_vdsat
let s1_xx1_m54_gm = @m.x1.xdut.xx1_m54.msky130_fd_pr__pfet_01v8[gm]
echo OPV XX1_M54 gm $&s1_xx1_m54_gm
let s1_xx1_m54_gds = @m.x1.xdut.xx1_m54.msky130_fd_pr__pfet_01v8[gds]
echo OPV XX1_M54 gds $&s1_xx1_m54_gds
let s1_xx1_m54_gmbs = @m.x1.xdut.xx1_m54.msky130_fd_pr__pfet_01v8[gmbs]
echo OPV XX1_M54 gmbs $&s1_xx1_m54_gmbs
let s1_xx1_m54_cgg = @m.x1.xdut.xx1_m54.msky130_fd_pr__pfet_01v8[cgg]
echo OPV XX1_M54 cgg $&s1_xx1_m54_cgg
let s1_xx1_m54_cgd = @m.x1.xdut.xx1_m54.msky130_fd_pr__pfet_01v8[cgd]
echo OPV XX1_M54 cgd $&s1_xx1_m54_cgd
let s1_xx1_m54_cgs = @m.x1.xdut.xx1_m54.msky130_fd_pr__pfet_01v8[cgs]
echo OPV XX1_M54 cgs $&s1_xx1_m54_cgs
let s1_xx1_m54_cgb = @m.x1.xdut.xx1_m54.msky130_fd_pr__pfet_01v8[cgb]
echo OPV XX1_M54 cgb $&s1_xx1_m54_cgb
let s1_xx1_m54_cdg = @m.x1.xdut.xx1_m54.msky130_fd_pr__pfet_01v8[cdg]
echo OPV XX1_M54 cdg $&s1_xx1_m54_cdg
let s1_xx1_m54_cdd = @m.x1.xdut.xx1_m54.msky130_fd_pr__pfet_01v8[cdd]
echo OPV XX1_M54 cdd $&s1_xx1_m54_cdd
let s1_xx1_m54_cds = @m.x1.xdut.xx1_m54.msky130_fd_pr__pfet_01v8[cds]
echo OPV XX1_M54 cds $&s1_xx1_m54_cds
let s1_xx1_m54_cdb = @m.x1.xdut.xx1_m54.msky130_fd_pr__pfet_01v8[cdb]
echo OPV XX1_M54 cdb $&s1_xx1_m54_cdb
let s1_xx1_m54_csg = @m.x1.xdut.xx1_m54.msky130_fd_pr__pfet_01v8[csg]
echo OPV XX1_M54 csg $&s1_xx1_m54_csg
let s1_xx1_m54_csd = @m.x1.xdut.xx1_m54.msky130_fd_pr__pfet_01v8[csd]
echo OPV XX1_M54 csd $&s1_xx1_m54_csd
let s1_xx1_m54_css = @m.x1.xdut.xx1_m54.msky130_fd_pr__pfet_01v8[css]
echo OPV XX1_M54 css $&s1_xx1_m54_css
let s1_xx1_m54_csb = @m.x1.xdut.xx1_m54.msky130_fd_pr__pfet_01v8[csb]
echo OPV XX1_M54 csb $&s1_xx1_m54_csb
let s1_xx1_m54_cbg = @m.x1.xdut.xx1_m54.msky130_fd_pr__pfet_01v8[cbg]
echo OPV XX1_M54 cbg $&s1_xx1_m54_cbg
let s1_xx1_m54_cbd = @m.x1.xdut.xx1_m54.msky130_fd_pr__pfet_01v8[cbd]
echo OPV XX1_M54 cbd $&s1_xx1_m54_cbd
let s1_xx1_m54_cbs = @m.x1.xdut.xx1_m54.msky130_fd_pr__pfet_01v8[cbs]
echo OPV XX1_M54 cbs $&s1_xx1_m54_cbs
let s1_xx1_m54_cbb = @m.x1.xdut.xx1_m54.msky130_fd_pr__pfet_01v8[cbb]
echo OPV XX1_M54 cbb $&s1_xx1_m54_cbb
let s1_xx1_m54_capbd = @m.x1.xdut.xx1_m54.msky130_fd_pr__pfet_01v8[capbd]
echo OPV XX1_M54 capbd $&s1_xx1_m54_capbd
let s1_xx1_m54_capbs = @m.x1.xdut.xx1_m54.msky130_fd_pr__pfet_01v8[capbs]
echo OPV XX1_M54 capbs $&s1_xx1_m54_capbs
let s1_xx1_m54_cgso = @m.x1.xdut.xx1_m54.msky130_fd_pr__pfet_01v8[cgso]
echo OPV XX1_M54 cgso $&s1_xx1_m54_cgso
let s1_xx1_m54_cgdo = @m.x1.xdut.xx1_m54.msky130_fd_pr__pfet_01v8[cgdo]
echo OPV XX1_M54 cgdo $&s1_xx1_m54_cgdo
let s1_xx1_m54_cgbo = @m.x1.xdut.xx1_m54.msky130_fd_pr__pfet_01v8[cgbo]
echo OPV XX1_M54 cgbo $&s1_xx1_m54_cgbo
let s1_xx1_m54_weff = @m.x1.xdut.xx1_m54.msky130_fd_pr__pfet_01v8[weff]
echo OPV XX1_M54 weff $&s1_xx1_m54_weff
let s1_xx1_m54_leff = @m.x1.xdut.xx1_m54.msky130_fd_pr__pfet_01v8[leff]
echo OPV XX1_M54 leff $&s1_xx1_m54_leff
let s1_xx1_m29_id = @m.x1.xdut.xx1_m29.msky130_fd_pr__nfet_01v8[id]
echo OPV XX1_M29 id $&s1_xx1_m29_id
let s1_xx1_m29_vgs = @m.x1.xdut.xx1_m29.msky130_fd_pr__nfet_01v8[vgs]
echo OPV XX1_M29 vgs $&s1_xx1_m29_vgs
let s1_xx1_m29_vds = @m.x1.xdut.xx1_m29.msky130_fd_pr__nfet_01v8[vds]
echo OPV XX1_M29 vds $&s1_xx1_m29_vds
let s1_xx1_m29_vbs = @m.x1.xdut.xx1_m29.msky130_fd_pr__nfet_01v8[vbs]
echo OPV XX1_M29 vbs $&s1_xx1_m29_vbs
let s1_xx1_m29_vth = @m.x1.xdut.xx1_m29.msky130_fd_pr__nfet_01v8[vth]
echo OPV XX1_M29 vth $&s1_xx1_m29_vth
let s1_xx1_m29_vdsat = @m.x1.xdut.xx1_m29.msky130_fd_pr__nfet_01v8[vdsat]
echo OPV XX1_M29 vdsat $&s1_xx1_m29_vdsat
let s1_xx1_m29_gm = @m.x1.xdut.xx1_m29.msky130_fd_pr__nfet_01v8[gm]
echo OPV XX1_M29 gm $&s1_xx1_m29_gm
let s1_xx1_m29_gds = @m.x1.xdut.xx1_m29.msky130_fd_pr__nfet_01v8[gds]
echo OPV XX1_M29 gds $&s1_xx1_m29_gds
let s1_xx1_m29_gmbs = @m.x1.xdut.xx1_m29.msky130_fd_pr__nfet_01v8[gmbs]
echo OPV XX1_M29 gmbs $&s1_xx1_m29_gmbs
let s1_xx1_m29_cgg = @m.x1.xdut.xx1_m29.msky130_fd_pr__nfet_01v8[cgg]
echo OPV XX1_M29 cgg $&s1_xx1_m29_cgg
let s1_xx1_m29_cgd = @m.x1.xdut.xx1_m29.msky130_fd_pr__nfet_01v8[cgd]
echo OPV XX1_M29 cgd $&s1_xx1_m29_cgd
let s1_xx1_m29_cgs = @m.x1.xdut.xx1_m29.msky130_fd_pr__nfet_01v8[cgs]
echo OPV XX1_M29 cgs $&s1_xx1_m29_cgs
let s1_xx1_m29_cgb = @m.x1.xdut.xx1_m29.msky130_fd_pr__nfet_01v8[cgb]
echo OPV XX1_M29 cgb $&s1_xx1_m29_cgb
let s1_xx1_m29_cdg = @m.x1.xdut.xx1_m29.msky130_fd_pr__nfet_01v8[cdg]
echo OPV XX1_M29 cdg $&s1_xx1_m29_cdg
let s1_xx1_m29_cdd = @m.x1.xdut.xx1_m29.msky130_fd_pr__nfet_01v8[cdd]
echo OPV XX1_M29 cdd $&s1_xx1_m29_cdd
let s1_xx1_m29_cds = @m.x1.xdut.xx1_m29.msky130_fd_pr__nfet_01v8[cds]
echo OPV XX1_M29 cds $&s1_xx1_m29_cds
let s1_xx1_m29_cdb = @m.x1.xdut.xx1_m29.msky130_fd_pr__nfet_01v8[cdb]
echo OPV XX1_M29 cdb $&s1_xx1_m29_cdb
let s1_xx1_m29_csg = @m.x1.xdut.xx1_m29.msky130_fd_pr__nfet_01v8[csg]
echo OPV XX1_M29 csg $&s1_xx1_m29_csg
let s1_xx1_m29_csd = @m.x1.xdut.xx1_m29.msky130_fd_pr__nfet_01v8[csd]
echo OPV XX1_M29 csd $&s1_xx1_m29_csd
let s1_xx1_m29_css = @m.x1.xdut.xx1_m29.msky130_fd_pr__nfet_01v8[css]
echo OPV XX1_M29 css $&s1_xx1_m29_css
let s1_xx1_m29_csb = @m.x1.xdut.xx1_m29.msky130_fd_pr__nfet_01v8[csb]
echo OPV XX1_M29 csb $&s1_xx1_m29_csb
let s1_xx1_m29_cbg = @m.x1.xdut.xx1_m29.msky130_fd_pr__nfet_01v8[cbg]
echo OPV XX1_M29 cbg $&s1_xx1_m29_cbg
let s1_xx1_m29_cbd = @m.x1.xdut.xx1_m29.msky130_fd_pr__nfet_01v8[cbd]
echo OPV XX1_M29 cbd $&s1_xx1_m29_cbd
let s1_xx1_m29_cbs = @m.x1.xdut.xx1_m29.msky130_fd_pr__nfet_01v8[cbs]
echo OPV XX1_M29 cbs $&s1_xx1_m29_cbs
let s1_xx1_m29_cbb = @m.x1.xdut.xx1_m29.msky130_fd_pr__nfet_01v8[cbb]
echo OPV XX1_M29 cbb $&s1_xx1_m29_cbb
let s1_xx1_m29_capbd = @m.x1.xdut.xx1_m29.msky130_fd_pr__nfet_01v8[capbd]
echo OPV XX1_M29 capbd $&s1_xx1_m29_capbd
let s1_xx1_m29_capbs = @m.x1.xdut.xx1_m29.msky130_fd_pr__nfet_01v8[capbs]
echo OPV XX1_M29 capbs $&s1_xx1_m29_capbs
let s1_xx1_m29_cgso = @m.x1.xdut.xx1_m29.msky130_fd_pr__nfet_01v8[cgso]
echo OPV XX1_M29 cgso $&s1_xx1_m29_cgso
let s1_xx1_m29_cgdo = @m.x1.xdut.xx1_m29.msky130_fd_pr__nfet_01v8[cgdo]
echo OPV XX1_M29 cgdo $&s1_xx1_m29_cgdo
let s1_xx1_m29_cgbo = @m.x1.xdut.xx1_m29.msky130_fd_pr__nfet_01v8[cgbo]
echo OPV XX1_M29 cgbo $&s1_xx1_m29_cgbo
let s1_xx1_m29_weff = @m.x1.xdut.xx1_m29.msky130_fd_pr__nfet_01v8[weff]
echo OPV XX1_M29 weff $&s1_xx1_m29_weff
let s1_xx1_m29_leff = @m.x1.xdut.xx1_m29.msky130_fd_pr__nfet_01v8[leff]
echo OPV XX1_M29 leff $&s1_xx1_m29_leff
let s1_xx1_m8_id = @m.x1.xdut.xx1_m8.msky130_fd_pr__nfet_01v8[id]
echo OPV XX1_M8 id $&s1_xx1_m8_id
let s1_xx1_m8_vgs = @m.x1.xdut.xx1_m8.msky130_fd_pr__nfet_01v8[vgs]
echo OPV XX1_M8 vgs $&s1_xx1_m8_vgs
let s1_xx1_m8_vds = @m.x1.xdut.xx1_m8.msky130_fd_pr__nfet_01v8[vds]
echo OPV XX1_M8 vds $&s1_xx1_m8_vds
let s1_xx1_m8_vbs = @m.x1.xdut.xx1_m8.msky130_fd_pr__nfet_01v8[vbs]
echo OPV XX1_M8 vbs $&s1_xx1_m8_vbs
let s1_xx1_m8_vth = @m.x1.xdut.xx1_m8.msky130_fd_pr__nfet_01v8[vth]
echo OPV XX1_M8 vth $&s1_xx1_m8_vth
let s1_xx1_m8_vdsat = @m.x1.xdut.xx1_m8.msky130_fd_pr__nfet_01v8[vdsat]
echo OPV XX1_M8 vdsat $&s1_xx1_m8_vdsat
let s1_xx1_m8_gm = @m.x1.xdut.xx1_m8.msky130_fd_pr__nfet_01v8[gm]
echo OPV XX1_M8 gm $&s1_xx1_m8_gm
let s1_xx1_m8_gds = @m.x1.xdut.xx1_m8.msky130_fd_pr__nfet_01v8[gds]
echo OPV XX1_M8 gds $&s1_xx1_m8_gds
let s1_xx1_m8_gmbs = @m.x1.xdut.xx1_m8.msky130_fd_pr__nfet_01v8[gmbs]
echo OPV XX1_M8 gmbs $&s1_xx1_m8_gmbs
let s1_xx1_m8_cgg = @m.x1.xdut.xx1_m8.msky130_fd_pr__nfet_01v8[cgg]
echo OPV XX1_M8 cgg $&s1_xx1_m8_cgg
let s1_xx1_m8_cgd = @m.x1.xdut.xx1_m8.msky130_fd_pr__nfet_01v8[cgd]
echo OPV XX1_M8 cgd $&s1_xx1_m8_cgd
let s1_xx1_m8_cgs = @m.x1.xdut.xx1_m8.msky130_fd_pr__nfet_01v8[cgs]
echo OPV XX1_M8 cgs $&s1_xx1_m8_cgs
let s1_xx1_m8_cgb = @m.x1.xdut.xx1_m8.msky130_fd_pr__nfet_01v8[cgb]
echo OPV XX1_M8 cgb $&s1_xx1_m8_cgb
let s1_xx1_m8_cdg = @m.x1.xdut.xx1_m8.msky130_fd_pr__nfet_01v8[cdg]
echo OPV XX1_M8 cdg $&s1_xx1_m8_cdg
let s1_xx1_m8_cdd = @m.x1.xdut.xx1_m8.msky130_fd_pr__nfet_01v8[cdd]
echo OPV XX1_M8 cdd $&s1_xx1_m8_cdd
let s1_xx1_m8_cds = @m.x1.xdut.xx1_m8.msky130_fd_pr__nfet_01v8[cds]
echo OPV XX1_M8 cds $&s1_xx1_m8_cds
let s1_xx1_m8_cdb = @m.x1.xdut.xx1_m8.msky130_fd_pr__nfet_01v8[cdb]
echo OPV XX1_M8 cdb $&s1_xx1_m8_cdb
let s1_xx1_m8_csg = @m.x1.xdut.xx1_m8.msky130_fd_pr__nfet_01v8[csg]
echo OPV XX1_M8 csg $&s1_xx1_m8_csg
let s1_xx1_m8_csd = @m.x1.xdut.xx1_m8.msky130_fd_pr__nfet_01v8[csd]
echo OPV XX1_M8 csd $&s1_xx1_m8_csd
let s1_xx1_m8_css = @m.x1.xdut.xx1_m8.msky130_fd_pr__nfet_01v8[css]
echo OPV XX1_M8 css $&s1_xx1_m8_css
let s1_xx1_m8_csb = @m.x1.xdut.xx1_m8.msky130_fd_pr__nfet_01v8[csb]
echo OPV XX1_M8 csb $&s1_xx1_m8_csb
let s1_xx1_m8_cbg = @m.x1.xdut.xx1_m8.msky130_fd_pr__nfet_01v8[cbg]
echo OPV XX1_M8 cbg $&s1_xx1_m8_cbg
let s1_xx1_m8_cbd = @m.x1.xdut.xx1_m8.msky130_fd_pr__nfet_01v8[cbd]
echo OPV XX1_M8 cbd $&s1_xx1_m8_cbd
let s1_xx1_m8_cbs = @m.x1.xdut.xx1_m8.msky130_fd_pr__nfet_01v8[cbs]
echo OPV XX1_M8 cbs $&s1_xx1_m8_cbs
let s1_xx1_m8_cbb = @m.x1.xdut.xx1_m8.msky130_fd_pr__nfet_01v8[cbb]
echo OPV XX1_M8 cbb $&s1_xx1_m8_cbb
let s1_xx1_m8_capbd = @m.x1.xdut.xx1_m8.msky130_fd_pr__nfet_01v8[capbd]
echo OPV XX1_M8 capbd $&s1_xx1_m8_capbd
let s1_xx1_m8_capbs = @m.x1.xdut.xx1_m8.msky130_fd_pr__nfet_01v8[capbs]
echo OPV XX1_M8 capbs $&s1_xx1_m8_capbs
let s1_xx1_m8_cgso = @m.x1.xdut.xx1_m8.msky130_fd_pr__nfet_01v8[cgso]
echo OPV XX1_M8 cgso $&s1_xx1_m8_cgso
let s1_xx1_m8_cgdo = @m.x1.xdut.xx1_m8.msky130_fd_pr__nfet_01v8[cgdo]
echo OPV XX1_M8 cgdo $&s1_xx1_m8_cgdo
let s1_xx1_m8_cgbo = @m.x1.xdut.xx1_m8.msky130_fd_pr__nfet_01v8[cgbo]
echo OPV XX1_M8 cgbo $&s1_xx1_m8_cgbo
let s1_xx1_m8_weff = @m.x1.xdut.xx1_m8.msky130_fd_pr__nfet_01v8[weff]
echo OPV XX1_M8 weff $&s1_xx1_m8_weff
let s1_xx1_m8_leff = @m.x1.xdut.xx1_m8.msky130_fd_pr__nfet_01v8[leff]
echo OPV XX1_M8 leff $&s1_xx1_m8_leff
let s1_xx1_m10_id = @m.x1.xdut.xx1_m10.msky130_fd_pr__nfet_01v8_lvt[id]
echo OPV XX1_M10 id $&s1_xx1_m10_id
let s1_xx1_m10_vgs = @m.x1.xdut.xx1_m10.msky130_fd_pr__nfet_01v8_lvt[vgs]
echo OPV XX1_M10 vgs $&s1_xx1_m10_vgs
let s1_xx1_m10_vds = @m.x1.xdut.xx1_m10.msky130_fd_pr__nfet_01v8_lvt[vds]
echo OPV XX1_M10 vds $&s1_xx1_m10_vds
let s1_xx1_m10_vbs = @m.x1.xdut.xx1_m10.msky130_fd_pr__nfet_01v8_lvt[vbs]
echo OPV XX1_M10 vbs $&s1_xx1_m10_vbs
let s1_xx1_m10_vth = @m.x1.xdut.xx1_m10.msky130_fd_pr__nfet_01v8_lvt[vth]
echo OPV XX1_M10 vth $&s1_xx1_m10_vth
let s1_xx1_m10_vdsat = @m.x1.xdut.xx1_m10.msky130_fd_pr__nfet_01v8_lvt[vdsat]
echo OPV XX1_M10 vdsat $&s1_xx1_m10_vdsat
let s1_xx1_m10_gm = @m.x1.xdut.xx1_m10.msky130_fd_pr__nfet_01v8_lvt[gm]
echo OPV XX1_M10 gm $&s1_xx1_m10_gm
let s1_xx1_m10_gds = @m.x1.xdut.xx1_m10.msky130_fd_pr__nfet_01v8_lvt[gds]
echo OPV XX1_M10 gds $&s1_xx1_m10_gds
let s1_xx1_m10_gmbs = @m.x1.xdut.xx1_m10.msky130_fd_pr__nfet_01v8_lvt[gmbs]
echo OPV XX1_M10 gmbs $&s1_xx1_m10_gmbs
let s1_xx1_m10_cgg = @m.x1.xdut.xx1_m10.msky130_fd_pr__nfet_01v8_lvt[cgg]
echo OPV XX1_M10 cgg $&s1_xx1_m10_cgg
let s1_xx1_m10_cgd = @m.x1.xdut.xx1_m10.msky130_fd_pr__nfet_01v8_lvt[cgd]
echo OPV XX1_M10 cgd $&s1_xx1_m10_cgd
let s1_xx1_m10_cgs = @m.x1.xdut.xx1_m10.msky130_fd_pr__nfet_01v8_lvt[cgs]
echo OPV XX1_M10 cgs $&s1_xx1_m10_cgs
let s1_xx1_m10_cgb = @m.x1.xdut.xx1_m10.msky130_fd_pr__nfet_01v8_lvt[cgb]
echo OPV XX1_M10 cgb $&s1_xx1_m10_cgb
let s1_xx1_m10_cdg = @m.x1.xdut.xx1_m10.msky130_fd_pr__nfet_01v8_lvt[cdg]
echo OPV XX1_M10 cdg $&s1_xx1_m10_cdg
let s1_xx1_m10_cdd = @m.x1.xdut.xx1_m10.msky130_fd_pr__nfet_01v8_lvt[cdd]
echo OPV XX1_M10 cdd $&s1_xx1_m10_cdd
let s1_xx1_m10_cds = @m.x1.xdut.xx1_m10.msky130_fd_pr__nfet_01v8_lvt[cds]
echo OPV XX1_M10 cds $&s1_xx1_m10_cds
let s1_xx1_m10_cdb = @m.x1.xdut.xx1_m10.msky130_fd_pr__nfet_01v8_lvt[cdb]
echo OPV XX1_M10 cdb $&s1_xx1_m10_cdb
let s1_xx1_m10_csg = @m.x1.xdut.xx1_m10.msky130_fd_pr__nfet_01v8_lvt[csg]
echo OPV XX1_M10 csg $&s1_xx1_m10_csg
let s1_xx1_m10_csd = @m.x1.xdut.xx1_m10.msky130_fd_pr__nfet_01v8_lvt[csd]
echo OPV XX1_M10 csd $&s1_xx1_m10_csd
let s1_xx1_m10_css = @m.x1.xdut.xx1_m10.msky130_fd_pr__nfet_01v8_lvt[css]
echo OPV XX1_M10 css $&s1_xx1_m10_css
let s1_xx1_m10_csb = @m.x1.xdut.xx1_m10.msky130_fd_pr__nfet_01v8_lvt[csb]
echo OPV XX1_M10 csb $&s1_xx1_m10_csb
let s1_xx1_m10_cbg = @m.x1.xdut.xx1_m10.msky130_fd_pr__nfet_01v8_lvt[cbg]
echo OPV XX1_M10 cbg $&s1_xx1_m10_cbg
let s1_xx1_m10_cbd = @m.x1.xdut.xx1_m10.msky130_fd_pr__nfet_01v8_lvt[cbd]
echo OPV XX1_M10 cbd $&s1_xx1_m10_cbd
let s1_xx1_m10_cbs = @m.x1.xdut.xx1_m10.msky130_fd_pr__nfet_01v8_lvt[cbs]
echo OPV XX1_M10 cbs $&s1_xx1_m10_cbs
let s1_xx1_m10_cbb = @m.x1.xdut.xx1_m10.msky130_fd_pr__nfet_01v8_lvt[cbb]
echo OPV XX1_M10 cbb $&s1_xx1_m10_cbb
let s1_xx1_m10_capbd = @m.x1.xdut.xx1_m10.msky130_fd_pr__nfet_01v8_lvt[capbd]
echo OPV XX1_M10 capbd $&s1_xx1_m10_capbd
let s1_xx1_m10_capbs = @m.x1.xdut.xx1_m10.msky130_fd_pr__nfet_01v8_lvt[capbs]
echo OPV XX1_M10 capbs $&s1_xx1_m10_capbs
let s1_xx1_m10_cgso = @m.x1.xdut.xx1_m10.msky130_fd_pr__nfet_01v8_lvt[cgso]
echo OPV XX1_M10 cgso $&s1_xx1_m10_cgso
let s1_xx1_m10_cgdo = @m.x1.xdut.xx1_m10.msky130_fd_pr__nfet_01v8_lvt[cgdo]
echo OPV XX1_M10 cgdo $&s1_xx1_m10_cgdo
let s1_xx1_m10_cgbo = @m.x1.xdut.xx1_m10.msky130_fd_pr__nfet_01v8_lvt[cgbo]
echo OPV XX1_M10 cgbo $&s1_xx1_m10_cgbo
let s1_xx1_m10_weff = @m.x1.xdut.xx1_m10.msky130_fd_pr__nfet_01v8_lvt[weff]
echo OPV XX1_M10 weff $&s1_xx1_m10_weff
let s1_xx1_m10_leff = @m.x1.xdut.xx1_m10.msky130_fd_pr__nfet_01v8_lvt[leff]
echo OPV XX1_M10 leff $&s1_xx1_m10_leff
let s1_xx1_m27_id = @m.x1.xdut.xx1_m27.msky130_fd_pr__nfet_01v8_lvt[id]
echo OPV XX1_M27 id $&s1_xx1_m27_id
let s1_xx1_m27_vgs = @m.x1.xdut.xx1_m27.msky130_fd_pr__nfet_01v8_lvt[vgs]
echo OPV XX1_M27 vgs $&s1_xx1_m27_vgs
let s1_xx1_m27_vds = @m.x1.xdut.xx1_m27.msky130_fd_pr__nfet_01v8_lvt[vds]
echo OPV XX1_M27 vds $&s1_xx1_m27_vds
let s1_xx1_m27_vbs = @m.x1.xdut.xx1_m27.msky130_fd_pr__nfet_01v8_lvt[vbs]
echo OPV XX1_M27 vbs $&s1_xx1_m27_vbs
let s1_xx1_m27_vth = @m.x1.xdut.xx1_m27.msky130_fd_pr__nfet_01v8_lvt[vth]
echo OPV XX1_M27 vth $&s1_xx1_m27_vth
let s1_xx1_m27_vdsat = @m.x1.xdut.xx1_m27.msky130_fd_pr__nfet_01v8_lvt[vdsat]
echo OPV XX1_M27 vdsat $&s1_xx1_m27_vdsat
let s1_xx1_m27_gm = @m.x1.xdut.xx1_m27.msky130_fd_pr__nfet_01v8_lvt[gm]
echo OPV XX1_M27 gm $&s1_xx1_m27_gm
let s1_xx1_m27_gds = @m.x1.xdut.xx1_m27.msky130_fd_pr__nfet_01v8_lvt[gds]
echo OPV XX1_M27 gds $&s1_xx1_m27_gds
let s1_xx1_m27_gmbs = @m.x1.xdut.xx1_m27.msky130_fd_pr__nfet_01v8_lvt[gmbs]
echo OPV XX1_M27 gmbs $&s1_xx1_m27_gmbs
let s1_xx1_m27_cgg = @m.x1.xdut.xx1_m27.msky130_fd_pr__nfet_01v8_lvt[cgg]
echo OPV XX1_M27 cgg $&s1_xx1_m27_cgg
let s1_xx1_m27_cgd = @m.x1.xdut.xx1_m27.msky130_fd_pr__nfet_01v8_lvt[cgd]
echo OPV XX1_M27 cgd $&s1_xx1_m27_cgd
let s1_xx1_m27_cgs = @m.x1.xdut.xx1_m27.msky130_fd_pr__nfet_01v8_lvt[cgs]
echo OPV XX1_M27 cgs $&s1_xx1_m27_cgs
let s1_xx1_m27_cgb = @m.x1.xdut.xx1_m27.msky130_fd_pr__nfet_01v8_lvt[cgb]
echo OPV XX1_M27 cgb $&s1_xx1_m27_cgb
let s1_xx1_m27_cdg = @m.x1.xdut.xx1_m27.msky130_fd_pr__nfet_01v8_lvt[cdg]
echo OPV XX1_M27 cdg $&s1_xx1_m27_cdg
let s1_xx1_m27_cdd = @m.x1.xdut.xx1_m27.msky130_fd_pr__nfet_01v8_lvt[cdd]
echo OPV XX1_M27 cdd $&s1_xx1_m27_cdd
let s1_xx1_m27_cds = @m.x1.xdut.xx1_m27.msky130_fd_pr__nfet_01v8_lvt[cds]
echo OPV XX1_M27 cds $&s1_xx1_m27_cds
let s1_xx1_m27_cdb = @m.x1.xdut.xx1_m27.msky130_fd_pr__nfet_01v8_lvt[cdb]
echo OPV XX1_M27 cdb $&s1_xx1_m27_cdb
let s1_xx1_m27_csg = @m.x1.xdut.xx1_m27.msky130_fd_pr__nfet_01v8_lvt[csg]
echo OPV XX1_M27 csg $&s1_xx1_m27_csg
let s1_xx1_m27_csd = @m.x1.xdut.xx1_m27.msky130_fd_pr__nfet_01v8_lvt[csd]
echo OPV XX1_M27 csd $&s1_xx1_m27_csd
let s1_xx1_m27_css = @m.x1.xdut.xx1_m27.msky130_fd_pr__nfet_01v8_lvt[css]
echo OPV XX1_M27 css $&s1_xx1_m27_css
let s1_xx1_m27_csb = @m.x1.xdut.xx1_m27.msky130_fd_pr__nfet_01v8_lvt[csb]
echo OPV XX1_M27 csb $&s1_xx1_m27_csb
let s1_xx1_m27_cbg = @m.x1.xdut.xx1_m27.msky130_fd_pr__nfet_01v8_lvt[cbg]
echo OPV XX1_M27 cbg $&s1_xx1_m27_cbg
let s1_xx1_m27_cbd = @m.x1.xdut.xx1_m27.msky130_fd_pr__nfet_01v8_lvt[cbd]
echo OPV XX1_M27 cbd $&s1_xx1_m27_cbd
let s1_xx1_m27_cbs = @m.x1.xdut.xx1_m27.msky130_fd_pr__nfet_01v8_lvt[cbs]
echo OPV XX1_M27 cbs $&s1_xx1_m27_cbs
let s1_xx1_m27_cbb = @m.x1.xdut.xx1_m27.msky130_fd_pr__nfet_01v8_lvt[cbb]
echo OPV XX1_M27 cbb $&s1_xx1_m27_cbb
let s1_xx1_m27_capbd = @m.x1.xdut.xx1_m27.msky130_fd_pr__nfet_01v8_lvt[capbd]
echo OPV XX1_M27 capbd $&s1_xx1_m27_capbd
let s1_xx1_m27_capbs = @m.x1.xdut.xx1_m27.msky130_fd_pr__nfet_01v8_lvt[capbs]
echo OPV XX1_M27 capbs $&s1_xx1_m27_capbs
let s1_xx1_m27_cgso = @m.x1.xdut.xx1_m27.msky130_fd_pr__nfet_01v8_lvt[cgso]
echo OPV XX1_M27 cgso $&s1_xx1_m27_cgso
let s1_xx1_m27_cgdo = @m.x1.xdut.xx1_m27.msky130_fd_pr__nfet_01v8_lvt[cgdo]
echo OPV XX1_M27 cgdo $&s1_xx1_m27_cgdo
let s1_xx1_m27_cgbo = @m.x1.xdut.xx1_m27.msky130_fd_pr__nfet_01v8_lvt[cgbo]
echo OPV XX1_M27 cgbo $&s1_xx1_m27_cgbo
let s1_xx1_m27_weff = @m.x1.xdut.xx1_m27.msky130_fd_pr__nfet_01v8_lvt[weff]
echo OPV XX1_M27 weff $&s1_xx1_m27_weff
let s1_xx1_m27_leff = @m.x1.xdut.xx1_m27.msky130_fd_pr__nfet_01v8_lvt[leff]
echo OPV XX1_M27 leff $&s1_xx1_m27_leff
let s1_xx1_m46_id = @m.x1.xdut.xx1_m46.msky130_fd_pr__pfet_01v8_lvt[id]
echo OPV XX1_M46 id $&s1_xx1_m46_id
let s1_xx1_m46_vgs = @m.x1.xdut.xx1_m46.msky130_fd_pr__pfet_01v8_lvt[vgs]
echo OPV XX1_M46 vgs $&s1_xx1_m46_vgs
let s1_xx1_m46_vds = @m.x1.xdut.xx1_m46.msky130_fd_pr__pfet_01v8_lvt[vds]
echo OPV XX1_M46 vds $&s1_xx1_m46_vds
let s1_xx1_m46_vbs = @m.x1.xdut.xx1_m46.msky130_fd_pr__pfet_01v8_lvt[vbs]
echo OPV XX1_M46 vbs $&s1_xx1_m46_vbs
let s1_xx1_m46_vth = @m.x1.xdut.xx1_m46.msky130_fd_pr__pfet_01v8_lvt[vth]
echo OPV XX1_M46 vth $&s1_xx1_m46_vth
let s1_xx1_m46_vdsat = @m.x1.xdut.xx1_m46.msky130_fd_pr__pfet_01v8_lvt[vdsat]
echo OPV XX1_M46 vdsat $&s1_xx1_m46_vdsat
let s1_xx1_m46_gm = @m.x1.xdut.xx1_m46.msky130_fd_pr__pfet_01v8_lvt[gm]
echo OPV XX1_M46 gm $&s1_xx1_m46_gm
let s1_xx1_m46_gds = @m.x1.xdut.xx1_m46.msky130_fd_pr__pfet_01v8_lvt[gds]
echo OPV XX1_M46 gds $&s1_xx1_m46_gds
let s1_xx1_m46_gmbs = @m.x1.xdut.xx1_m46.msky130_fd_pr__pfet_01v8_lvt[gmbs]
echo OPV XX1_M46 gmbs $&s1_xx1_m46_gmbs
let s1_xx1_m46_cgg = @m.x1.xdut.xx1_m46.msky130_fd_pr__pfet_01v8_lvt[cgg]
echo OPV XX1_M46 cgg $&s1_xx1_m46_cgg
let s1_xx1_m46_cgd = @m.x1.xdut.xx1_m46.msky130_fd_pr__pfet_01v8_lvt[cgd]
echo OPV XX1_M46 cgd $&s1_xx1_m46_cgd
let s1_xx1_m46_cgs = @m.x1.xdut.xx1_m46.msky130_fd_pr__pfet_01v8_lvt[cgs]
echo OPV XX1_M46 cgs $&s1_xx1_m46_cgs
let s1_xx1_m46_cgb = @m.x1.xdut.xx1_m46.msky130_fd_pr__pfet_01v8_lvt[cgb]
echo OPV XX1_M46 cgb $&s1_xx1_m46_cgb
let s1_xx1_m46_cdg = @m.x1.xdut.xx1_m46.msky130_fd_pr__pfet_01v8_lvt[cdg]
echo OPV XX1_M46 cdg $&s1_xx1_m46_cdg
let s1_xx1_m46_cdd = @m.x1.xdut.xx1_m46.msky130_fd_pr__pfet_01v8_lvt[cdd]
echo OPV XX1_M46 cdd $&s1_xx1_m46_cdd
let s1_xx1_m46_cds = @m.x1.xdut.xx1_m46.msky130_fd_pr__pfet_01v8_lvt[cds]
echo OPV XX1_M46 cds $&s1_xx1_m46_cds
let s1_xx1_m46_cdb = @m.x1.xdut.xx1_m46.msky130_fd_pr__pfet_01v8_lvt[cdb]
echo OPV XX1_M46 cdb $&s1_xx1_m46_cdb
let s1_xx1_m46_csg = @m.x1.xdut.xx1_m46.msky130_fd_pr__pfet_01v8_lvt[csg]
echo OPV XX1_M46 csg $&s1_xx1_m46_csg
let s1_xx1_m46_csd = @m.x1.xdut.xx1_m46.msky130_fd_pr__pfet_01v8_lvt[csd]
echo OPV XX1_M46 csd $&s1_xx1_m46_csd
let s1_xx1_m46_css = @m.x1.xdut.xx1_m46.msky130_fd_pr__pfet_01v8_lvt[css]
echo OPV XX1_M46 css $&s1_xx1_m46_css
let s1_xx1_m46_csb = @m.x1.xdut.xx1_m46.msky130_fd_pr__pfet_01v8_lvt[csb]
echo OPV XX1_M46 csb $&s1_xx1_m46_csb
let s1_xx1_m46_cbg = @m.x1.xdut.xx1_m46.msky130_fd_pr__pfet_01v8_lvt[cbg]
echo OPV XX1_M46 cbg $&s1_xx1_m46_cbg
let s1_xx1_m46_cbd = @m.x1.xdut.xx1_m46.msky130_fd_pr__pfet_01v8_lvt[cbd]
echo OPV XX1_M46 cbd $&s1_xx1_m46_cbd
let s1_xx1_m46_cbs = @m.x1.xdut.xx1_m46.msky130_fd_pr__pfet_01v8_lvt[cbs]
echo OPV XX1_M46 cbs $&s1_xx1_m46_cbs
let s1_xx1_m46_cbb = @m.x1.xdut.xx1_m46.msky130_fd_pr__pfet_01v8_lvt[cbb]
echo OPV XX1_M46 cbb $&s1_xx1_m46_cbb
let s1_xx1_m46_capbd = @m.x1.xdut.xx1_m46.msky130_fd_pr__pfet_01v8_lvt[capbd]
echo OPV XX1_M46 capbd $&s1_xx1_m46_capbd
let s1_xx1_m46_capbs = @m.x1.xdut.xx1_m46.msky130_fd_pr__pfet_01v8_lvt[capbs]
echo OPV XX1_M46 capbs $&s1_xx1_m46_capbs
let s1_xx1_m46_cgso = @m.x1.xdut.xx1_m46.msky130_fd_pr__pfet_01v8_lvt[cgso]
echo OPV XX1_M46 cgso $&s1_xx1_m46_cgso
let s1_xx1_m46_cgdo = @m.x1.xdut.xx1_m46.msky130_fd_pr__pfet_01v8_lvt[cgdo]
echo OPV XX1_M46 cgdo $&s1_xx1_m46_cgdo
let s1_xx1_m46_cgbo = @m.x1.xdut.xx1_m46.msky130_fd_pr__pfet_01v8_lvt[cgbo]
echo OPV XX1_M46 cgbo $&s1_xx1_m46_cgbo
let s1_xx1_m46_weff = @m.x1.xdut.xx1_m46.msky130_fd_pr__pfet_01v8_lvt[weff]
echo OPV XX1_M46 weff $&s1_xx1_m46_weff
let s1_xx1_m46_leff = @m.x1.xdut.xx1_m46.msky130_fd_pr__pfet_01v8_lvt[leff]
echo OPV XX1_M46 leff $&s1_xx1_m46_leff
let s1_xx1_m47_id = @m.x1.xdut.xx1_m47.msky130_fd_pr__pfet_01v8_lvt[id]
echo OPV XX1_M47 id $&s1_xx1_m47_id
let s1_xx1_m47_vgs = @m.x1.xdut.xx1_m47.msky130_fd_pr__pfet_01v8_lvt[vgs]
echo OPV XX1_M47 vgs $&s1_xx1_m47_vgs
let s1_xx1_m47_vds = @m.x1.xdut.xx1_m47.msky130_fd_pr__pfet_01v8_lvt[vds]
echo OPV XX1_M47 vds $&s1_xx1_m47_vds
let s1_xx1_m47_vbs = @m.x1.xdut.xx1_m47.msky130_fd_pr__pfet_01v8_lvt[vbs]
echo OPV XX1_M47 vbs $&s1_xx1_m47_vbs
let s1_xx1_m47_vth = @m.x1.xdut.xx1_m47.msky130_fd_pr__pfet_01v8_lvt[vth]
echo OPV XX1_M47 vth $&s1_xx1_m47_vth
let s1_xx1_m47_vdsat = @m.x1.xdut.xx1_m47.msky130_fd_pr__pfet_01v8_lvt[vdsat]
echo OPV XX1_M47 vdsat $&s1_xx1_m47_vdsat
let s1_xx1_m47_gm = @m.x1.xdut.xx1_m47.msky130_fd_pr__pfet_01v8_lvt[gm]
echo OPV XX1_M47 gm $&s1_xx1_m47_gm
let s1_xx1_m47_gds = @m.x1.xdut.xx1_m47.msky130_fd_pr__pfet_01v8_lvt[gds]
echo OPV XX1_M47 gds $&s1_xx1_m47_gds
let s1_xx1_m47_gmbs = @m.x1.xdut.xx1_m47.msky130_fd_pr__pfet_01v8_lvt[gmbs]
echo OPV XX1_M47 gmbs $&s1_xx1_m47_gmbs
let s1_xx1_m47_cgg = @m.x1.xdut.xx1_m47.msky130_fd_pr__pfet_01v8_lvt[cgg]
echo OPV XX1_M47 cgg $&s1_xx1_m47_cgg
let s1_xx1_m47_cgd = @m.x1.xdut.xx1_m47.msky130_fd_pr__pfet_01v8_lvt[cgd]
echo OPV XX1_M47 cgd $&s1_xx1_m47_cgd
let s1_xx1_m47_cgs = @m.x1.xdut.xx1_m47.msky130_fd_pr__pfet_01v8_lvt[cgs]
echo OPV XX1_M47 cgs $&s1_xx1_m47_cgs
let s1_xx1_m47_cgb = @m.x1.xdut.xx1_m47.msky130_fd_pr__pfet_01v8_lvt[cgb]
echo OPV XX1_M47 cgb $&s1_xx1_m47_cgb
let s1_xx1_m47_cdg = @m.x1.xdut.xx1_m47.msky130_fd_pr__pfet_01v8_lvt[cdg]
echo OPV XX1_M47 cdg $&s1_xx1_m47_cdg
let s1_xx1_m47_cdd = @m.x1.xdut.xx1_m47.msky130_fd_pr__pfet_01v8_lvt[cdd]
echo OPV XX1_M47 cdd $&s1_xx1_m47_cdd
let s1_xx1_m47_cds = @m.x1.xdut.xx1_m47.msky130_fd_pr__pfet_01v8_lvt[cds]
echo OPV XX1_M47 cds $&s1_xx1_m47_cds
let s1_xx1_m47_cdb = @m.x1.xdut.xx1_m47.msky130_fd_pr__pfet_01v8_lvt[cdb]
echo OPV XX1_M47 cdb $&s1_xx1_m47_cdb
let s1_xx1_m47_csg = @m.x1.xdut.xx1_m47.msky130_fd_pr__pfet_01v8_lvt[csg]
echo OPV XX1_M47 csg $&s1_xx1_m47_csg
let s1_xx1_m47_csd = @m.x1.xdut.xx1_m47.msky130_fd_pr__pfet_01v8_lvt[csd]
echo OPV XX1_M47 csd $&s1_xx1_m47_csd
let s1_xx1_m47_css = @m.x1.xdut.xx1_m47.msky130_fd_pr__pfet_01v8_lvt[css]
echo OPV XX1_M47 css $&s1_xx1_m47_css
let s1_xx1_m47_csb = @m.x1.xdut.xx1_m47.msky130_fd_pr__pfet_01v8_lvt[csb]
echo OPV XX1_M47 csb $&s1_xx1_m47_csb
let s1_xx1_m47_cbg = @m.x1.xdut.xx1_m47.msky130_fd_pr__pfet_01v8_lvt[cbg]
echo OPV XX1_M47 cbg $&s1_xx1_m47_cbg
let s1_xx1_m47_cbd = @m.x1.xdut.xx1_m47.msky130_fd_pr__pfet_01v8_lvt[cbd]
echo OPV XX1_M47 cbd $&s1_xx1_m47_cbd
let s1_xx1_m47_cbs = @m.x1.xdut.xx1_m47.msky130_fd_pr__pfet_01v8_lvt[cbs]
echo OPV XX1_M47 cbs $&s1_xx1_m47_cbs
let s1_xx1_m47_cbb = @m.x1.xdut.xx1_m47.msky130_fd_pr__pfet_01v8_lvt[cbb]
echo OPV XX1_M47 cbb $&s1_xx1_m47_cbb
let s1_xx1_m47_capbd = @m.x1.xdut.xx1_m47.msky130_fd_pr__pfet_01v8_lvt[capbd]
echo OPV XX1_M47 capbd $&s1_xx1_m47_capbd
let s1_xx1_m47_capbs = @m.x1.xdut.xx1_m47.msky130_fd_pr__pfet_01v8_lvt[capbs]
echo OPV XX1_M47 capbs $&s1_xx1_m47_capbs
let s1_xx1_m47_cgso = @m.x1.xdut.xx1_m47.msky130_fd_pr__pfet_01v8_lvt[cgso]
echo OPV XX1_M47 cgso $&s1_xx1_m47_cgso
let s1_xx1_m47_cgdo = @m.x1.xdut.xx1_m47.msky130_fd_pr__pfet_01v8_lvt[cgdo]
echo OPV XX1_M47 cgdo $&s1_xx1_m47_cgdo
let s1_xx1_m47_cgbo = @m.x1.xdut.xx1_m47.msky130_fd_pr__pfet_01v8_lvt[cgbo]
echo OPV XX1_M47 cgbo $&s1_xx1_m47_cgbo
let s1_xx1_m47_weff = @m.x1.xdut.xx1_m47.msky130_fd_pr__pfet_01v8_lvt[weff]
echo OPV XX1_M47 weff $&s1_xx1_m47_weff
let s1_xx1_m47_leff = @m.x1.xdut.xx1_m47.msky130_fd_pr__pfet_01v8_lvt[leff]
echo OPV XX1_M47 leff $&s1_xx1_m47_leff
let s1_xx1_m48_id = @m.x1.xdut.xx1_m48.msky130_fd_pr__pfet_01v8_lvt[id]
echo OPV XX1_M48 id $&s1_xx1_m48_id
let s1_xx1_m48_vgs = @m.x1.xdut.xx1_m48.msky130_fd_pr__pfet_01v8_lvt[vgs]
echo OPV XX1_M48 vgs $&s1_xx1_m48_vgs
let s1_xx1_m48_vds = @m.x1.xdut.xx1_m48.msky130_fd_pr__pfet_01v8_lvt[vds]
echo OPV XX1_M48 vds $&s1_xx1_m48_vds
let s1_xx1_m48_vbs = @m.x1.xdut.xx1_m48.msky130_fd_pr__pfet_01v8_lvt[vbs]
echo OPV XX1_M48 vbs $&s1_xx1_m48_vbs
let s1_xx1_m48_vth = @m.x1.xdut.xx1_m48.msky130_fd_pr__pfet_01v8_lvt[vth]
echo OPV XX1_M48 vth $&s1_xx1_m48_vth
let s1_xx1_m48_vdsat = @m.x1.xdut.xx1_m48.msky130_fd_pr__pfet_01v8_lvt[vdsat]
echo OPV XX1_M48 vdsat $&s1_xx1_m48_vdsat
let s1_xx1_m48_gm = @m.x1.xdut.xx1_m48.msky130_fd_pr__pfet_01v8_lvt[gm]
echo OPV XX1_M48 gm $&s1_xx1_m48_gm
let s1_xx1_m48_gds = @m.x1.xdut.xx1_m48.msky130_fd_pr__pfet_01v8_lvt[gds]
echo OPV XX1_M48 gds $&s1_xx1_m48_gds
let s1_xx1_m48_gmbs = @m.x1.xdut.xx1_m48.msky130_fd_pr__pfet_01v8_lvt[gmbs]
echo OPV XX1_M48 gmbs $&s1_xx1_m48_gmbs
let s1_xx1_m48_cgg = @m.x1.xdut.xx1_m48.msky130_fd_pr__pfet_01v8_lvt[cgg]
echo OPV XX1_M48 cgg $&s1_xx1_m48_cgg
let s1_xx1_m48_cgd = @m.x1.xdut.xx1_m48.msky130_fd_pr__pfet_01v8_lvt[cgd]
echo OPV XX1_M48 cgd $&s1_xx1_m48_cgd
let s1_xx1_m48_cgs = @m.x1.xdut.xx1_m48.msky130_fd_pr__pfet_01v8_lvt[cgs]
echo OPV XX1_M48 cgs $&s1_xx1_m48_cgs
let s1_xx1_m48_cgb = @m.x1.xdut.xx1_m48.msky130_fd_pr__pfet_01v8_lvt[cgb]
echo OPV XX1_M48 cgb $&s1_xx1_m48_cgb
let s1_xx1_m48_cdg = @m.x1.xdut.xx1_m48.msky130_fd_pr__pfet_01v8_lvt[cdg]
echo OPV XX1_M48 cdg $&s1_xx1_m48_cdg
let s1_xx1_m48_cdd = @m.x1.xdut.xx1_m48.msky130_fd_pr__pfet_01v8_lvt[cdd]
echo OPV XX1_M48 cdd $&s1_xx1_m48_cdd
let s1_xx1_m48_cds = @m.x1.xdut.xx1_m48.msky130_fd_pr__pfet_01v8_lvt[cds]
echo OPV XX1_M48 cds $&s1_xx1_m48_cds
let s1_xx1_m48_cdb = @m.x1.xdut.xx1_m48.msky130_fd_pr__pfet_01v8_lvt[cdb]
echo OPV XX1_M48 cdb $&s1_xx1_m48_cdb
let s1_xx1_m48_csg = @m.x1.xdut.xx1_m48.msky130_fd_pr__pfet_01v8_lvt[csg]
echo OPV XX1_M48 csg $&s1_xx1_m48_csg
let s1_xx1_m48_csd = @m.x1.xdut.xx1_m48.msky130_fd_pr__pfet_01v8_lvt[csd]
echo OPV XX1_M48 csd $&s1_xx1_m48_csd
let s1_xx1_m48_css = @m.x1.xdut.xx1_m48.msky130_fd_pr__pfet_01v8_lvt[css]
echo OPV XX1_M48 css $&s1_xx1_m48_css
let s1_xx1_m48_csb = @m.x1.xdut.xx1_m48.msky130_fd_pr__pfet_01v8_lvt[csb]
echo OPV XX1_M48 csb $&s1_xx1_m48_csb
let s1_xx1_m48_cbg = @m.x1.xdut.xx1_m48.msky130_fd_pr__pfet_01v8_lvt[cbg]
echo OPV XX1_M48 cbg $&s1_xx1_m48_cbg
let s1_xx1_m48_cbd = @m.x1.xdut.xx1_m48.msky130_fd_pr__pfet_01v8_lvt[cbd]
echo OPV XX1_M48 cbd $&s1_xx1_m48_cbd
let s1_xx1_m48_cbs = @m.x1.xdut.xx1_m48.msky130_fd_pr__pfet_01v8_lvt[cbs]
echo OPV XX1_M48 cbs $&s1_xx1_m48_cbs
let s1_xx1_m48_cbb = @m.x1.xdut.xx1_m48.msky130_fd_pr__pfet_01v8_lvt[cbb]
echo OPV XX1_M48 cbb $&s1_xx1_m48_cbb
let s1_xx1_m48_capbd = @m.x1.xdut.xx1_m48.msky130_fd_pr__pfet_01v8_lvt[capbd]
echo OPV XX1_M48 capbd $&s1_xx1_m48_capbd
let s1_xx1_m48_capbs = @m.x1.xdut.xx1_m48.msky130_fd_pr__pfet_01v8_lvt[capbs]
echo OPV XX1_M48 capbs $&s1_xx1_m48_capbs
let s1_xx1_m48_cgso = @m.x1.xdut.xx1_m48.msky130_fd_pr__pfet_01v8_lvt[cgso]
echo OPV XX1_M48 cgso $&s1_xx1_m48_cgso
let s1_xx1_m48_cgdo = @m.x1.xdut.xx1_m48.msky130_fd_pr__pfet_01v8_lvt[cgdo]
echo OPV XX1_M48 cgdo $&s1_xx1_m48_cgdo
let s1_xx1_m48_cgbo = @m.x1.xdut.xx1_m48.msky130_fd_pr__pfet_01v8_lvt[cgbo]
echo OPV XX1_M48 cgbo $&s1_xx1_m48_cgbo
let s1_xx1_m48_weff = @m.x1.xdut.xx1_m48.msky130_fd_pr__pfet_01v8_lvt[weff]
echo OPV XX1_M48 weff $&s1_xx1_m48_weff
let s1_xx1_m48_leff = @m.x1.xdut.xx1_m48.msky130_fd_pr__pfet_01v8_lvt[leff]
echo OPV XX1_M48 leff $&s1_xx1_m48_leff
let s1_xx1_m51_id = @m.x1.xdut.xx1_m51.msky130_fd_pr__pfet_01v8[id]
echo OPV XX1_M51 id $&s1_xx1_m51_id
let s1_xx1_m51_vgs = @m.x1.xdut.xx1_m51.msky130_fd_pr__pfet_01v8[vgs]
echo OPV XX1_M51 vgs $&s1_xx1_m51_vgs
let s1_xx1_m51_vds = @m.x1.xdut.xx1_m51.msky130_fd_pr__pfet_01v8[vds]
echo OPV XX1_M51 vds $&s1_xx1_m51_vds
let s1_xx1_m51_vbs = @m.x1.xdut.xx1_m51.msky130_fd_pr__pfet_01v8[vbs]
echo OPV XX1_M51 vbs $&s1_xx1_m51_vbs
let s1_xx1_m51_vth = @m.x1.xdut.xx1_m51.msky130_fd_pr__pfet_01v8[vth]
echo OPV XX1_M51 vth $&s1_xx1_m51_vth
let s1_xx1_m51_vdsat = @m.x1.xdut.xx1_m51.msky130_fd_pr__pfet_01v8[vdsat]
echo OPV XX1_M51 vdsat $&s1_xx1_m51_vdsat
let s1_xx1_m51_gm = @m.x1.xdut.xx1_m51.msky130_fd_pr__pfet_01v8[gm]
echo OPV XX1_M51 gm $&s1_xx1_m51_gm
let s1_xx1_m51_gds = @m.x1.xdut.xx1_m51.msky130_fd_pr__pfet_01v8[gds]
echo OPV XX1_M51 gds $&s1_xx1_m51_gds
let s1_xx1_m51_gmbs = @m.x1.xdut.xx1_m51.msky130_fd_pr__pfet_01v8[gmbs]
echo OPV XX1_M51 gmbs $&s1_xx1_m51_gmbs
let s1_xx1_m51_cgg = @m.x1.xdut.xx1_m51.msky130_fd_pr__pfet_01v8[cgg]
echo OPV XX1_M51 cgg $&s1_xx1_m51_cgg
let s1_xx1_m51_cgd = @m.x1.xdut.xx1_m51.msky130_fd_pr__pfet_01v8[cgd]
echo OPV XX1_M51 cgd $&s1_xx1_m51_cgd
let s1_xx1_m51_cgs = @m.x1.xdut.xx1_m51.msky130_fd_pr__pfet_01v8[cgs]
echo OPV XX1_M51 cgs $&s1_xx1_m51_cgs
let s1_xx1_m51_cgb = @m.x1.xdut.xx1_m51.msky130_fd_pr__pfet_01v8[cgb]
echo OPV XX1_M51 cgb $&s1_xx1_m51_cgb
let s1_xx1_m51_cdg = @m.x1.xdut.xx1_m51.msky130_fd_pr__pfet_01v8[cdg]
echo OPV XX1_M51 cdg $&s1_xx1_m51_cdg
let s1_xx1_m51_cdd = @m.x1.xdut.xx1_m51.msky130_fd_pr__pfet_01v8[cdd]
echo OPV XX1_M51 cdd $&s1_xx1_m51_cdd
let s1_xx1_m51_cds = @m.x1.xdut.xx1_m51.msky130_fd_pr__pfet_01v8[cds]
echo OPV XX1_M51 cds $&s1_xx1_m51_cds
let s1_xx1_m51_cdb = @m.x1.xdut.xx1_m51.msky130_fd_pr__pfet_01v8[cdb]
echo OPV XX1_M51 cdb $&s1_xx1_m51_cdb
let s1_xx1_m51_csg = @m.x1.xdut.xx1_m51.msky130_fd_pr__pfet_01v8[csg]
echo OPV XX1_M51 csg $&s1_xx1_m51_csg
let s1_xx1_m51_csd = @m.x1.xdut.xx1_m51.msky130_fd_pr__pfet_01v8[csd]
echo OPV XX1_M51 csd $&s1_xx1_m51_csd
let s1_xx1_m51_css = @m.x1.xdut.xx1_m51.msky130_fd_pr__pfet_01v8[css]
echo OPV XX1_M51 css $&s1_xx1_m51_css
let s1_xx1_m51_csb = @m.x1.xdut.xx1_m51.msky130_fd_pr__pfet_01v8[csb]
echo OPV XX1_M51 csb $&s1_xx1_m51_csb
let s1_xx1_m51_cbg = @m.x1.xdut.xx1_m51.msky130_fd_pr__pfet_01v8[cbg]
echo OPV XX1_M51 cbg $&s1_xx1_m51_cbg
let s1_xx1_m51_cbd = @m.x1.xdut.xx1_m51.msky130_fd_pr__pfet_01v8[cbd]
echo OPV XX1_M51 cbd $&s1_xx1_m51_cbd
let s1_xx1_m51_cbs = @m.x1.xdut.xx1_m51.msky130_fd_pr__pfet_01v8[cbs]
echo OPV XX1_M51 cbs $&s1_xx1_m51_cbs
let s1_xx1_m51_cbb = @m.x1.xdut.xx1_m51.msky130_fd_pr__pfet_01v8[cbb]
echo OPV XX1_M51 cbb $&s1_xx1_m51_cbb
let s1_xx1_m51_capbd = @m.x1.xdut.xx1_m51.msky130_fd_pr__pfet_01v8[capbd]
echo OPV XX1_M51 capbd $&s1_xx1_m51_capbd
let s1_xx1_m51_capbs = @m.x1.xdut.xx1_m51.msky130_fd_pr__pfet_01v8[capbs]
echo OPV XX1_M51 capbs $&s1_xx1_m51_capbs
let s1_xx1_m51_cgso = @m.x1.xdut.xx1_m51.msky130_fd_pr__pfet_01v8[cgso]
echo OPV XX1_M51 cgso $&s1_xx1_m51_cgso
let s1_xx1_m51_cgdo = @m.x1.xdut.xx1_m51.msky130_fd_pr__pfet_01v8[cgdo]
echo OPV XX1_M51 cgdo $&s1_xx1_m51_cgdo
let s1_xx1_m51_cgbo = @m.x1.xdut.xx1_m51.msky130_fd_pr__pfet_01v8[cgbo]
echo OPV XX1_M51 cgbo $&s1_xx1_m51_cgbo
let s1_xx1_m51_weff = @m.x1.xdut.xx1_m51.msky130_fd_pr__pfet_01v8[weff]
echo OPV XX1_M51 weff $&s1_xx1_m51_weff
let s1_xx1_m51_leff = @m.x1.xdut.xx1_m51.msky130_fd_pr__pfet_01v8[leff]
echo OPV XX1_M51 leff $&s1_xx1_m51_leff
let s1_xx2_m1_id = @m.x1.xdut.xx2_m1.msky130_fd_pr__nfet_01v8_lvt[id]
echo OPV XX2_M1 id $&s1_xx2_m1_id
let s1_xx2_m1_vgs = @m.x1.xdut.xx2_m1.msky130_fd_pr__nfet_01v8_lvt[vgs]
echo OPV XX2_M1 vgs $&s1_xx2_m1_vgs
let s1_xx2_m1_vds = @m.x1.xdut.xx2_m1.msky130_fd_pr__nfet_01v8_lvt[vds]
echo OPV XX2_M1 vds $&s1_xx2_m1_vds
let s1_xx2_m1_vbs = @m.x1.xdut.xx2_m1.msky130_fd_pr__nfet_01v8_lvt[vbs]
echo OPV XX2_M1 vbs $&s1_xx2_m1_vbs
let s1_xx2_m1_vth = @m.x1.xdut.xx2_m1.msky130_fd_pr__nfet_01v8_lvt[vth]
echo OPV XX2_M1 vth $&s1_xx2_m1_vth
let s1_xx2_m1_vdsat = @m.x1.xdut.xx2_m1.msky130_fd_pr__nfet_01v8_lvt[vdsat]
echo OPV XX2_M1 vdsat $&s1_xx2_m1_vdsat
let s1_xx2_m1_gm = @m.x1.xdut.xx2_m1.msky130_fd_pr__nfet_01v8_lvt[gm]
echo OPV XX2_M1 gm $&s1_xx2_m1_gm
let s1_xx2_m1_gds = @m.x1.xdut.xx2_m1.msky130_fd_pr__nfet_01v8_lvt[gds]
echo OPV XX2_M1 gds $&s1_xx2_m1_gds
let s1_xx2_m1_gmbs = @m.x1.xdut.xx2_m1.msky130_fd_pr__nfet_01v8_lvt[gmbs]
echo OPV XX2_M1 gmbs $&s1_xx2_m1_gmbs
let s1_xx2_m1_cgg = @m.x1.xdut.xx2_m1.msky130_fd_pr__nfet_01v8_lvt[cgg]
echo OPV XX2_M1 cgg $&s1_xx2_m1_cgg
let s1_xx2_m1_cgd = @m.x1.xdut.xx2_m1.msky130_fd_pr__nfet_01v8_lvt[cgd]
echo OPV XX2_M1 cgd $&s1_xx2_m1_cgd
let s1_xx2_m1_cgs = @m.x1.xdut.xx2_m1.msky130_fd_pr__nfet_01v8_lvt[cgs]
echo OPV XX2_M1 cgs $&s1_xx2_m1_cgs
let s1_xx2_m1_cgb = @m.x1.xdut.xx2_m1.msky130_fd_pr__nfet_01v8_lvt[cgb]
echo OPV XX2_M1 cgb $&s1_xx2_m1_cgb
let s1_xx2_m1_cdg = @m.x1.xdut.xx2_m1.msky130_fd_pr__nfet_01v8_lvt[cdg]
echo OPV XX2_M1 cdg $&s1_xx2_m1_cdg
let s1_xx2_m1_cdd = @m.x1.xdut.xx2_m1.msky130_fd_pr__nfet_01v8_lvt[cdd]
echo OPV XX2_M1 cdd $&s1_xx2_m1_cdd
let s1_xx2_m1_cds = @m.x1.xdut.xx2_m1.msky130_fd_pr__nfet_01v8_lvt[cds]
echo OPV XX2_M1 cds $&s1_xx2_m1_cds
let s1_xx2_m1_cdb = @m.x1.xdut.xx2_m1.msky130_fd_pr__nfet_01v8_lvt[cdb]
echo OPV XX2_M1 cdb $&s1_xx2_m1_cdb
let s1_xx2_m1_csg = @m.x1.xdut.xx2_m1.msky130_fd_pr__nfet_01v8_lvt[csg]
echo OPV XX2_M1 csg $&s1_xx2_m1_csg
let s1_xx2_m1_csd = @m.x1.xdut.xx2_m1.msky130_fd_pr__nfet_01v8_lvt[csd]
echo OPV XX2_M1 csd $&s1_xx2_m1_csd
let s1_xx2_m1_css = @m.x1.xdut.xx2_m1.msky130_fd_pr__nfet_01v8_lvt[css]
echo OPV XX2_M1 css $&s1_xx2_m1_css
let s1_xx2_m1_csb = @m.x1.xdut.xx2_m1.msky130_fd_pr__nfet_01v8_lvt[csb]
echo OPV XX2_M1 csb $&s1_xx2_m1_csb
let s1_xx2_m1_cbg = @m.x1.xdut.xx2_m1.msky130_fd_pr__nfet_01v8_lvt[cbg]
echo OPV XX2_M1 cbg $&s1_xx2_m1_cbg
let s1_xx2_m1_cbd = @m.x1.xdut.xx2_m1.msky130_fd_pr__nfet_01v8_lvt[cbd]
echo OPV XX2_M1 cbd $&s1_xx2_m1_cbd
let s1_xx2_m1_cbs = @m.x1.xdut.xx2_m1.msky130_fd_pr__nfet_01v8_lvt[cbs]
echo OPV XX2_M1 cbs $&s1_xx2_m1_cbs
let s1_xx2_m1_cbb = @m.x1.xdut.xx2_m1.msky130_fd_pr__nfet_01v8_lvt[cbb]
echo OPV XX2_M1 cbb $&s1_xx2_m1_cbb
let s1_xx2_m1_capbd = @m.x1.xdut.xx2_m1.msky130_fd_pr__nfet_01v8_lvt[capbd]
echo OPV XX2_M1 capbd $&s1_xx2_m1_capbd
let s1_xx2_m1_capbs = @m.x1.xdut.xx2_m1.msky130_fd_pr__nfet_01v8_lvt[capbs]
echo OPV XX2_M1 capbs $&s1_xx2_m1_capbs
let s1_xx2_m1_cgso = @m.x1.xdut.xx2_m1.msky130_fd_pr__nfet_01v8_lvt[cgso]
echo OPV XX2_M1 cgso $&s1_xx2_m1_cgso
let s1_xx2_m1_cgdo = @m.x1.xdut.xx2_m1.msky130_fd_pr__nfet_01v8_lvt[cgdo]
echo OPV XX2_M1 cgdo $&s1_xx2_m1_cgdo
let s1_xx2_m1_cgbo = @m.x1.xdut.xx2_m1.msky130_fd_pr__nfet_01v8_lvt[cgbo]
echo OPV XX2_M1 cgbo $&s1_xx2_m1_cgbo
let s1_xx2_m1_weff = @m.x1.xdut.xx2_m1.msky130_fd_pr__nfet_01v8_lvt[weff]
echo OPV XX2_M1 weff $&s1_xx2_m1_weff
let s1_xx2_m1_leff = @m.x1.xdut.xx2_m1.msky130_fd_pr__nfet_01v8_lvt[leff]
echo OPV XX2_M1 leff $&s1_xx2_m1_leff
let s1_xx2_m2_id = @m.x1.xdut.xx2_m2.msky130_fd_pr__nfet_01v8_lvt[id]
echo OPV XX2_M2 id $&s1_xx2_m2_id
let s1_xx2_m2_vgs = @m.x1.xdut.xx2_m2.msky130_fd_pr__nfet_01v8_lvt[vgs]
echo OPV XX2_M2 vgs $&s1_xx2_m2_vgs
let s1_xx2_m2_vds = @m.x1.xdut.xx2_m2.msky130_fd_pr__nfet_01v8_lvt[vds]
echo OPV XX2_M2 vds $&s1_xx2_m2_vds
let s1_xx2_m2_vbs = @m.x1.xdut.xx2_m2.msky130_fd_pr__nfet_01v8_lvt[vbs]
echo OPV XX2_M2 vbs $&s1_xx2_m2_vbs
let s1_xx2_m2_vth = @m.x1.xdut.xx2_m2.msky130_fd_pr__nfet_01v8_lvt[vth]
echo OPV XX2_M2 vth $&s1_xx2_m2_vth
let s1_xx2_m2_vdsat = @m.x1.xdut.xx2_m2.msky130_fd_pr__nfet_01v8_lvt[vdsat]
echo OPV XX2_M2 vdsat $&s1_xx2_m2_vdsat
let s1_xx2_m2_gm = @m.x1.xdut.xx2_m2.msky130_fd_pr__nfet_01v8_lvt[gm]
echo OPV XX2_M2 gm $&s1_xx2_m2_gm
let s1_xx2_m2_gds = @m.x1.xdut.xx2_m2.msky130_fd_pr__nfet_01v8_lvt[gds]
echo OPV XX2_M2 gds $&s1_xx2_m2_gds
let s1_xx2_m2_gmbs = @m.x1.xdut.xx2_m2.msky130_fd_pr__nfet_01v8_lvt[gmbs]
echo OPV XX2_M2 gmbs $&s1_xx2_m2_gmbs
let s1_xx2_m2_cgg = @m.x1.xdut.xx2_m2.msky130_fd_pr__nfet_01v8_lvt[cgg]
echo OPV XX2_M2 cgg $&s1_xx2_m2_cgg
let s1_xx2_m2_cgd = @m.x1.xdut.xx2_m2.msky130_fd_pr__nfet_01v8_lvt[cgd]
echo OPV XX2_M2 cgd $&s1_xx2_m2_cgd
let s1_xx2_m2_cgs = @m.x1.xdut.xx2_m2.msky130_fd_pr__nfet_01v8_lvt[cgs]
echo OPV XX2_M2 cgs $&s1_xx2_m2_cgs
let s1_xx2_m2_cgb = @m.x1.xdut.xx2_m2.msky130_fd_pr__nfet_01v8_lvt[cgb]
echo OPV XX2_M2 cgb $&s1_xx2_m2_cgb
let s1_xx2_m2_cdg = @m.x1.xdut.xx2_m2.msky130_fd_pr__nfet_01v8_lvt[cdg]
echo OPV XX2_M2 cdg $&s1_xx2_m2_cdg
let s1_xx2_m2_cdd = @m.x1.xdut.xx2_m2.msky130_fd_pr__nfet_01v8_lvt[cdd]
echo OPV XX2_M2 cdd $&s1_xx2_m2_cdd
let s1_xx2_m2_cds = @m.x1.xdut.xx2_m2.msky130_fd_pr__nfet_01v8_lvt[cds]
echo OPV XX2_M2 cds $&s1_xx2_m2_cds
let s1_xx2_m2_cdb = @m.x1.xdut.xx2_m2.msky130_fd_pr__nfet_01v8_lvt[cdb]
echo OPV XX2_M2 cdb $&s1_xx2_m2_cdb
let s1_xx2_m2_csg = @m.x1.xdut.xx2_m2.msky130_fd_pr__nfet_01v8_lvt[csg]
echo OPV XX2_M2 csg $&s1_xx2_m2_csg
let s1_xx2_m2_csd = @m.x1.xdut.xx2_m2.msky130_fd_pr__nfet_01v8_lvt[csd]
echo OPV XX2_M2 csd $&s1_xx2_m2_csd
let s1_xx2_m2_css = @m.x1.xdut.xx2_m2.msky130_fd_pr__nfet_01v8_lvt[css]
echo OPV XX2_M2 css $&s1_xx2_m2_css
let s1_xx2_m2_csb = @m.x1.xdut.xx2_m2.msky130_fd_pr__nfet_01v8_lvt[csb]
echo OPV XX2_M2 csb $&s1_xx2_m2_csb
let s1_xx2_m2_cbg = @m.x1.xdut.xx2_m2.msky130_fd_pr__nfet_01v8_lvt[cbg]
echo OPV XX2_M2 cbg $&s1_xx2_m2_cbg
let s1_xx2_m2_cbd = @m.x1.xdut.xx2_m2.msky130_fd_pr__nfet_01v8_lvt[cbd]
echo OPV XX2_M2 cbd $&s1_xx2_m2_cbd
let s1_xx2_m2_cbs = @m.x1.xdut.xx2_m2.msky130_fd_pr__nfet_01v8_lvt[cbs]
echo OPV XX2_M2 cbs $&s1_xx2_m2_cbs
let s1_xx2_m2_cbb = @m.x1.xdut.xx2_m2.msky130_fd_pr__nfet_01v8_lvt[cbb]
echo OPV XX2_M2 cbb $&s1_xx2_m2_cbb
let s1_xx2_m2_capbd = @m.x1.xdut.xx2_m2.msky130_fd_pr__nfet_01v8_lvt[capbd]
echo OPV XX2_M2 capbd $&s1_xx2_m2_capbd
let s1_xx2_m2_capbs = @m.x1.xdut.xx2_m2.msky130_fd_pr__nfet_01v8_lvt[capbs]
echo OPV XX2_M2 capbs $&s1_xx2_m2_capbs
let s1_xx2_m2_cgso = @m.x1.xdut.xx2_m2.msky130_fd_pr__nfet_01v8_lvt[cgso]
echo OPV XX2_M2 cgso $&s1_xx2_m2_cgso
let s1_xx2_m2_cgdo = @m.x1.xdut.xx2_m2.msky130_fd_pr__nfet_01v8_lvt[cgdo]
echo OPV XX2_M2 cgdo $&s1_xx2_m2_cgdo
let s1_xx2_m2_cgbo = @m.x1.xdut.xx2_m2.msky130_fd_pr__nfet_01v8_lvt[cgbo]
echo OPV XX2_M2 cgbo $&s1_xx2_m2_cgbo
let s1_xx2_m2_weff = @m.x1.xdut.xx2_m2.msky130_fd_pr__nfet_01v8_lvt[weff]
echo OPV XX2_M2 weff $&s1_xx2_m2_weff
let s1_xx2_m2_leff = @m.x1.xdut.xx2_m2.msky130_fd_pr__nfet_01v8_lvt[leff]
echo OPV XX2_M2 leff $&s1_xx2_m2_leff
let s1_xx2_m6_id = @m.x1.xdut.xx2_m6.msky130_fd_pr__nfet_01v8[id]
echo OPV XX2_M6 id $&s1_xx2_m6_id
let s1_xx2_m6_vgs = @m.x1.xdut.xx2_m6.msky130_fd_pr__nfet_01v8[vgs]
echo OPV XX2_M6 vgs $&s1_xx2_m6_vgs
let s1_xx2_m6_vds = @m.x1.xdut.xx2_m6.msky130_fd_pr__nfet_01v8[vds]
echo OPV XX2_M6 vds $&s1_xx2_m6_vds
let s1_xx2_m6_vbs = @m.x1.xdut.xx2_m6.msky130_fd_pr__nfet_01v8[vbs]
echo OPV XX2_M6 vbs $&s1_xx2_m6_vbs
let s1_xx2_m6_vth = @m.x1.xdut.xx2_m6.msky130_fd_pr__nfet_01v8[vth]
echo OPV XX2_M6 vth $&s1_xx2_m6_vth
let s1_xx2_m6_vdsat = @m.x1.xdut.xx2_m6.msky130_fd_pr__nfet_01v8[vdsat]
echo OPV XX2_M6 vdsat $&s1_xx2_m6_vdsat
let s1_xx2_m6_gm = @m.x1.xdut.xx2_m6.msky130_fd_pr__nfet_01v8[gm]
echo OPV XX2_M6 gm $&s1_xx2_m6_gm
let s1_xx2_m6_gds = @m.x1.xdut.xx2_m6.msky130_fd_pr__nfet_01v8[gds]
echo OPV XX2_M6 gds $&s1_xx2_m6_gds
let s1_xx2_m6_gmbs = @m.x1.xdut.xx2_m6.msky130_fd_pr__nfet_01v8[gmbs]
echo OPV XX2_M6 gmbs $&s1_xx2_m6_gmbs
let s1_xx2_m6_cgg = @m.x1.xdut.xx2_m6.msky130_fd_pr__nfet_01v8[cgg]
echo OPV XX2_M6 cgg $&s1_xx2_m6_cgg
let s1_xx2_m6_cgd = @m.x1.xdut.xx2_m6.msky130_fd_pr__nfet_01v8[cgd]
echo OPV XX2_M6 cgd $&s1_xx2_m6_cgd
let s1_xx2_m6_cgs = @m.x1.xdut.xx2_m6.msky130_fd_pr__nfet_01v8[cgs]
echo OPV XX2_M6 cgs $&s1_xx2_m6_cgs
let s1_xx2_m6_cgb = @m.x1.xdut.xx2_m6.msky130_fd_pr__nfet_01v8[cgb]
echo OPV XX2_M6 cgb $&s1_xx2_m6_cgb
let s1_xx2_m6_cdg = @m.x1.xdut.xx2_m6.msky130_fd_pr__nfet_01v8[cdg]
echo OPV XX2_M6 cdg $&s1_xx2_m6_cdg
let s1_xx2_m6_cdd = @m.x1.xdut.xx2_m6.msky130_fd_pr__nfet_01v8[cdd]
echo OPV XX2_M6 cdd $&s1_xx2_m6_cdd
let s1_xx2_m6_cds = @m.x1.xdut.xx2_m6.msky130_fd_pr__nfet_01v8[cds]
echo OPV XX2_M6 cds $&s1_xx2_m6_cds
let s1_xx2_m6_cdb = @m.x1.xdut.xx2_m6.msky130_fd_pr__nfet_01v8[cdb]
echo OPV XX2_M6 cdb $&s1_xx2_m6_cdb
let s1_xx2_m6_csg = @m.x1.xdut.xx2_m6.msky130_fd_pr__nfet_01v8[csg]
echo OPV XX2_M6 csg $&s1_xx2_m6_csg
let s1_xx2_m6_csd = @m.x1.xdut.xx2_m6.msky130_fd_pr__nfet_01v8[csd]
echo OPV XX2_M6 csd $&s1_xx2_m6_csd
let s1_xx2_m6_css = @m.x1.xdut.xx2_m6.msky130_fd_pr__nfet_01v8[css]
echo OPV XX2_M6 css $&s1_xx2_m6_css
let s1_xx2_m6_csb = @m.x1.xdut.xx2_m6.msky130_fd_pr__nfet_01v8[csb]
echo OPV XX2_M6 csb $&s1_xx2_m6_csb
let s1_xx2_m6_cbg = @m.x1.xdut.xx2_m6.msky130_fd_pr__nfet_01v8[cbg]
echo OPV XX2_M6 cbg $&s1_xx2_m6_cbg
let s1_xx2_m6_cbd = @m.x1.xdut.xx2_m6.msky130_fd_pr__nfet_01v8[cbd]
echo OPV XX2_M6 cbd $&s1_xx2_m6_cbd
let s1_xx2_m6_cbs = @m.x1.xdut.xx2_m6.msky130_fd_pr__nfet_01v8[cbs]
echo OPV XX2_M6 cbs $&s1_xx2_m6_cbs
let s1_xx2_m6_cbb = @m.x1.xdut.xx2_m6.msky130_fd_pr__nfet_01v8[cbb]
echo OPV XX2_M6 cbb $&s1_xx2_m6_cbb
let s1_xx2_m6_capbd = @m.x1.xdut.xx2_m6.msky130_fd_pr__nfet_01v8[capbd]
echo OPV XX2_M6 capbd $&s1_xx2_m6_capbd
let s1_xx2_m6_capbs = @m.x1.xdut.xx2_m6.msky130_fd_pr__nfet_01v8[capbs]
echo OPV XX2_M6 capbs $&s1_xx2_m6_capbs
let s1_xx2_m6_cgso = @m.x1.xdut.xx2_m6.msky130_fd_pr__nfet_01v8[cgso]
echo OPV XX2_M6 cgso $&s1_xx2_m6_cgso
let s1_xx2_m6_cgdo = @m.x1.xdut.xx2_m6.msky130_fd_pr__nfet_01v8[cgdo]
echo OPV XX2_M6 cgdo $&s1_xx2_m6_cgdo
let s1_xx2_m6_cgbo = @m.x1.xdut.xx2_m6.msky130_fd_pr__nfet_01v8[cgbo]
echo OPV XX2_M6 cgbo $&s1_xx2_m6_cgbo
let s1_xx2_m6_weff = @m.x1.xdut.xx2_m6.msky130_fd_pr__nfet_01v8[weff]
echo OPV XX2_M6 weff $&s1_xx2_m6_weff
let s1_xx2_m6_leff = @m.x1.xdut.xx2_m6.msky130_fd_pr__nfet_01v8[leff]
echo OPV XX2_M6 leff $&s1_xx2_m6_leff
let s1_xx2_m5_id = @m.x1.xdut.xx2_m5.msky130_fd_pr__nfet_01v8[id]
echo OPV XX2_M5 id $&s1_xx2_m5_id
let s1_xx2_m5_vgs = @m.x1.xdut.xx2_m5.msky130_fd_pr__nfet_01v8[vgs]
echo OPV XX2_M5 vgs $&s1_xx2_m5_vgs
let s1_xx2_m5_vds = @m.x1.xdut.xx2_m5.msky130_fd_pr__nfet_01v8[vds]
echo OPV XX2_M5 vds $&s1_xx2_m5_vds
let s1_xx2_m5_vbs = @m.x1.xdut.xx2_m5.msky130_fd_pr__nfet_01v8[vbs]
echo OPV XX2_M5 vbs $&s1_xx2_m5_vbs
let s1_xx2_m5_vth = @m.x1.xdut.xx2_m5.msky130_fd_pr__nfet_01v8[vth]
echo OPV XX2_M5 vth $&s1_xx2_m5_vth
let s1_xx2_m5_vdsat = @m.x1.xdut.xx2_m5.msky130_fd_pr__nfet_01v8[vdsat]
echo OPV XX2_M5 vdsat $&s1_xx2_m5_vdsat
let s1_xx2_m5_gm = @m.x1.xdut.xx2_m5.msky130_fd_pr__nfet_01v8[gm]
echo OPV XX2_M5 gm $&s1_xx2_m5_gm
let s1_xx2_m5_gds = @m.x1.xdut.xx2_m5.msky130_fd_pr__nfet_01v8[gds]
echo OPV XX2_M5 gds $&s1_xx2_m5_gds
let s1_xx2_m5_gmbs = @m.x1.xdut.xx2_m5.msky130_fd_pr__nfet_01v8[gmbs]
echo OPV XX2_M5 gmbs $&s1_xx2_m5_gmbs
let s1_xx2_m5_cgg = @m.x1.xdut.xx2_m5.msky130_fd_pr__nfet_01v8[cgg]
echo OPV XX2_M5 cgg $&s1_xx2_m5_cgg
let s1_xx2_m5_cgd = @m.x1.xdut.xx2_m5.msky130_fd_pr__nfet_01v8[cgd]
echo OPV XX2_M5 cgd $&s1_xx2_m5_cgd
let s1_xx2_m5_cgs = @m.x1.xdut.xx2_m5.msky130_fd_pr__nfet_01v8[cgs]
echo OPV XX2_M5 cgs $&s1_xx2_m5_cgs
let s1_xx2_m5_cgb = @m.x1.xdut.xx2_m5.msky130_fd_pr__nfet_01v8[cgb]
echo OPV XX2_M5 cgb $&s1_xx2_m5_cgb
let s1_xx2_m5_cdg = @m.x1.xdut.xx2_m5.msky130_fd_pr__nfet_01v8[cdg]
echo OPV XX2_M5 cdg $&s1_xx2_m5_cdg
let s1_xx2_m5_cdd = @m.x1.xdut.xx2_m5.msky130_fd_pr__nfet_01v8[cdd]
echo OPV XX2_M5 cdd $&s1_xx2_m5_cdd
let s1_xx2_m5_cds = @m.x1.xdut.xx2_m5.msky130_fd_pr__nfet_01v8[cds]
echo OPV XX2_M5 cds $&s1_xx2_m5_cds
let s1_xx2_m5_cdb = @m.x1.xdut.xx2_m5.msky130_fd_pr__nfet_01v8[cdb]
echo OPV XX2_M5 cdb $&s1_xx2_m5_cdb
let s1_xx2_m5_csg = @m.x1.xdut.xx2_m5.msky130_fd_pr__nfet_01v8[csg]
echo OPV XX2_M5 csg $&s1_xx2_m5_csg
let s1_xx2_m5_csd = @m.x1.xdut.xx2_m5.msky130_fd_pr__nfet_01v8[csd]
echo OPV XX2_M5 csd $&s1_xx2_m5_csd
let s1_xx2_m5_css = @m.x1.xdut.xx2_m5.msky130_fd_pr__nfet_01v8[css]
echo OPV XX2_M5 css $&s1_xx2_m5_css
let s1_xx2_m5_csb = @m.x1.xdut.xx2_m5.msky130_fd_pr__nfet_01v8[csb]
echo OPV XX2_M5 csb $&s1_xx2_m5_csb
let s1_xx2_m5_cbg = @m.x1.xdut.xx2_m5.msky130_fd_pr__nfet_01v8[cbg]
echo OPV XX2_M5 cbg $&s1_xx2_m5_cbg
let s1_xx2_m5_cbd = @m.x1.xdut.xx2_m5.msky130_fd_pr__nfet_01v8[cbd]
echo OPV XX2_M5 cbd $&s1_xx2_m5_cbd
let s1_xx2_m5_cbs = @m.x1.xdut.xx2_m5.msky130_fd_pr__nfet_01v8[cbs]
echo OPV XX2_M5 cbs $&s1_xx2_m5_cbs
let s1_xx2_m5_cbb = @m.x1.xdut.xx2_m5.msky130_fd_pr__nfet_01v8[cbb]
echo OPV XX2_M5 cbb $&s1_xx2_m5_cbb
let s1_xx2_m5_capbd = @m.x1.xdut.xx2_m5.msky130_fd_pr__nfet_01v8[capbd]
echo OPV XX2_M5 capbd $&s1_xx2_m5_capbd
let s1_xx2_m5_capbs = @m.x1.xdut.xx2_m5.msky130_fd_pr__nfet_01v8[capbs]
echo OPV XX2_M5 capbs $&s1_xx2_m5_capbs
let s1_xx2_m5_cgso = @m.x1.xdut.xx2_m5.msky130_fd_pr__nfet_01v8[cgso]
echo OPV XX2_M5 cgso $&s1_xx2_m5_cgso
let s1_xx2_m5_cgdo = @m.x1.xdut.xx2_m5.msky130_fd_pr__nfet_01v8[cgdo]
echo OPV XX2_M5 cgdo $&s1_xx2_m5_cgdo
let s1_xx2_m5_cgbo = @m.x1.xdut.xx2_m5.msky130_fd_pr__nfet_01v8[cgbo]
echo OPV XX2_M5 cgbo $&s1_xx2_m5_cgbo
let s1_xx2_m5_weff = @m.x1.xdut.xx2_m5.msky130_fd_pr__nfet_01v8[weff]
echo OPV XX2_M5 weff $&s1_xx2_m5_weff
let s1_xx2_m5_leff = @m.x1.xdut.xx2_m5.msky130_fd_pr__nfet_01v8[leff]
echo OPV XX2_M5 leff $&s1_xx2_m5_leff
let s1_xx2_m11_id = @m.x1.xdut.xx2_m11.msky130_fd_pr__pfet_01v8_lvt[id]
echo OPV XX2_M11 id $&s1_xx2_m11_id
let s1_xx2_m11_vgs = @m.x1.xdut.xx2_m11.msky130_fd_pr__pfet_01v8_lvt[vgs]
echo OPV XX2_M11 vgs $&s1_xx2_m11_vgs
let s1_xx2_m11_vds = @m.x1.xdut.xx2_m11.msky130_fd_pr__pfet_01v8_lvt[vds]
echo OPV XX2_M11 vds $&s1_xx2_m11_vds
let s1_xx2_m11_vbs = @m.x1.xdut.xx2_m11.msky130_fd_pr__pfet_01v8_lvt[vbs]
echo OPV XX2_M11 vbs $&s1_xx2_m11_vbs
let s1_xx2_m11_vth = @m.x1.xdut.xx2_m11.msky130_fd_pr__pfet_01v8_lvt[vth]
echo OPV XX2_M11 vth $&s1_xx2_m11_vth
let s1_xx2_m11_vdsat = @m.x1.xdut.xx2_m11.msky130_fd_pr__pfet_01v8_lvt[vdsat]
echo OPV XX2_M11 vdsat $&s1_xx2_m11_vdsat
let s1_xx2_m11_gm = @m.x1.xdut.xx2_m11.msky130_fd_pr__pfet_01v8_lvt[gm]
echo OPV XX2_M11 gm $&s1_xx2_m11_gm
let s1_xx2_m11_gds = @m.x1.xdut.xx2_m11.msky130_fd_pr__pfet_01v8_lvt[gds]
echo OPV XX2_M11 gds $&s1_xx2_m11_gds
let s1_xx2_m11_gmbs = @m.x1.xdut.xx2_m11.msky130_fd_pr__pfet_01v8_lvt[gmbs]
echo OPV XX2_M11 gmbs $&s1_xx2_m11_gmbs
let s1_xx2_m11_cgg = @m.x1.xdut.xx2_m11.msky130_fd_pr__pfet_01v8_lvt[cgg]
echo OPV XX2_M11 cgg $&s1_xx2_m11_cgg
let s1_xx2_m11_cgd = @m.x1.xdut.xx2_m11.msky130_fd_pr__pfet_01v8_lvt[cgd]
echo OPV XX2_M11 cgd $&s1_xx2_m11_cgd
let s1_xx2_m11_cgs = @m.x1.xdut.xx2_m11.msky130_fd_pr__pfet_01v8_lvt[cgs]
echo OPV XX2_M11 cgs $&s1_xx2_m11_cgs
let s1_xx2_m11_cgb = @m.x1.xdut.xx2_m11.msky130_fd_pr__pfet_01v8_lvt[cgb]
echo OPV XX2_M11 cgb $&s1_xx2_m11_cgb
let s1_xx2_m11_cdg = @m.x1.xdut.xx2_m11.msky130_fd_pr__pfet_01v8_lvt[cdg]
echo OPV XX2_M11 cdg $&s1_xx2_m11_cdg
let s1_xx2_m11_cdd = @m.x1.xdut.xx2_m11.msky130_fd_pr__pfet_01v8_lvt[cdd]
echo OPV XX2_M11 cdd $&s1_xx2_m11_cdd
let s1_xx2_m11_cds = @m.x1.xdut.xx2_m11.msky130_fd_pr__pfet_01v8_lvt[cds]
echo OPV XX2_M11 cds $&s1_xx2_m11_cds
let s1_xx2_m11_cdb = @m.x1.xdut.xx2_m11.msky130_fd_pr__pfet_01v8_lvt[cdb]
echo OPV XX2_M11 cdb $&s1_xx2_m11_cdb
let s1_xx2_m11_csg = @m.x1.xdut.xx2_m11.msky130_fd_pr__pfet_01v8_lvt[csg]
echo OPV XX2_M11 csg $&s1_xx2_m11_csg
let s1_xx2_m11_csd = @m.x1.xdut.xx2_m11.msky130_fd_pr__pfet_01v8_lvt[csd]
echo OPV XX2_M11 csd $&s1_xx2_m11_csd
let s1_xx2_m11_css = @m.x1.xdut.xx2_m11.msky130_fd_pr__pfet_01v8_lvt[css]
echo OPV XX2_M11 css $&s1_xx2_m11_css
let s1_xx2_m11_csb = @m.x1.xdut.xx2_m11.msky130_fd_pr__pfet_01v8_lvt[csb]
echo OPV XX2_M11 csb $&s1_xx2_m11_csb
let s1_xx2_m11_cbg = @m.x1.xdut.xx2_m11.msky130_fd_pr__pfet_01v8_lvt[cbg]
echo OPV XX2_M11 cbg $&s1_xx2_m11_cbg
let s1_xx2_m11_cbd = @m.x1.xdut.xx2_m11.msky130_fd_pr__pfet_01v8_lvt[cbd]
echo OPV XX2_M11 cbd $&s1_xx2_m11_cbd
let s1_xx2_m11_cbs = @m.x1.xdut.xx2_m11.msky130_fd_pr__pfet_01v8_lvt[cbs]
echo OPV XX2_M11 cbs $&s1_xx2_m11_cbs
let s1_xx2_m11_cbb = @m.x1.xdut.xx2_m11.msky130_fd_pr__pfet_01v8_lvt[cbb]
echo OPV XX2_M11 cbb $&s1_xx2_m11_cbb
let s1_xx2_m11_capbd = @m.x1.xdut.xx2_m11.msky130_fd_pr__pfet_01v8_lvt[capbd]
echo OPV XX2_M11 capbd $&s1_xx2_m11_capbd
let s1_xx2_m11_capbs = @m.x1.xdut.xx2_m11.msky130_fd_pr__pfet_01v8_lvt[capbs]
echo OPV XX2_M11 capbs $&s1_xx2_m11_capbs
let s1_xx2_m11_cgso = @m.x1.xdut.xx2_m11.msky130_fd_pr__pfet_01v8_lvt[cgso]
echo OPV XX2_M11 cgso $&s1_xx2_m11_cgso
let s1_xx2_m11_cgdo = @m.x1.xdut.xx2_m11.msky130_fd_pr__pfet_01v8_lvt[cgdo]
echo OPV XX2_M11 cgdo $&s1_xx2_m11_cgdo
let s1_xx2_m11_cgbo = @m.x1.xdut.xx2_m11.msky130_fd_pr__pfet_01v8_lvt[cgbo]
echo OPV XX2_M11 cgbo $&s1_xx2_m11_cgbo
let s1_xx2_m11_weff = @m.x1.xdut.xx2_m11.msky130_fd_pr__pfet_01v8_lvt[weff]
echo OPV XX2_M11 weff $&s1_xx2_m11_weff
let s1_xx2_m11_leff = @m.x1.xdut.xx2_m11.msky130_fd_pr__pfet_01v8_lvt[leff]
echo OPV XX2_M11 leff $&s1_xx2_m11_leff
let s1_xx2_m12_id = @m.x1.xdut.xx2_m12.msky130_fd_pr__pfet_01v8_lvt[id]
echo OPV XX2_M12 id $&s1_xx2_m12_id
let s1_xx2_m12_vgs = @m.x1.xdut.xx2_m12.msky130_fd_pr__pfet_01v8_lvt[vgs]
echo OPV XX2_M12 vgs $&s1_xx2_m12_vgs
let s1_xx2_m12_vds = @m.x1.xdut.xx2_m12.msky130_fd_pr__pfet_01v8_lvt[vds]
echo OPV XX2_M12 vds $&s1_xx2_m12_vds
let s1_xx2_m12_vbs = @m.x1.xdut.xx2_m12.msky130_fd_pr__pfet_01v8_lvt[vbs]
echo OPV XX2_M12 vbs $&s1_xx2_m12_vbs
let s1_xx2_m12_vth = @m.x1.xdut.xx2_m12.msky130_fd_pr__pfet_01v8_lvt[vth]
echo OPV XX2_M12 vth $&s1_xx2_m12_vth
let s1_xx2_m12_vdsat = @m.x1.xdut.xx2_m12.msky130_fd_pr__pfet_01v8_lvt[vdsat]
echo OPV XX2_M12 vdsat $&s1_xx2_m12_vdsat
let s1_xx2_m12_gm = @m.x1.xdut.xx2_m12.msky130_fd_pr__pfet_01v8_lvt[gm]
echo OPV XX2_M12 gm $&s1_xx2_m12_gm
let s1_xx2_m12_gds = @m.x1.xdut.xx2_m12.msky130_fd_pr__pfet_01v8_lvt[gds]
echo OPV XX2_M12 gds $&s1_xx2_m12_gds
let s1_xx2_m12_gmbs = @m.x1.xdut.xx2_m12.msky130_fd_pr__pfet_01v8_lvt[gmbs]
echo OPV XX2_M12 gmbs $&s1_xx2_m12_gmbs
let s1_xx2_m12_cgg = @m.x1.xdut.xx2_m12.msky130_fd_pr__pfet_01v8_lvt[cgg]
echo OPV XX2_M12 cgg $&s1_xx2_m12_cgg
let s1_xx2_m12_cgd = @m.x1.xdut.xx2_m12.msky130_fd_pr__pfet_01v8_lvt[cgd]
echo OPV XX2_M12 cgd $&s1_xx2_m12_cgd
let s1_xx2_m12_cgs = @m.x1.xdut.xx2_m12.msky130_fd_pr__pfet_01v8_lvt[cgs]
echo OPV XX2_M12 cgs $&s1_xx2_m12_cgs
let s1_xx2_m12_cgb = @m.x1.xdut.xx2_m12.msky130_fd_pr__pfet_01v8_lvt[cgb]
echo OPV XX2_M12 cgb $&s1_xx2_m12_cgb
let s1_xx2_m12_cdg = @m.x1.xdut.xx2_m12.msky130_fd_pr__pfet_01v8_lvt[cdg]
echo OPV XX2_M12 cdg $&s1_xx2_m12_cdg
let s1_xx2_m12_cdd = @m.x1.xdut.xx2_m12.msky130_fd_pr__pfet_01v8_lvt[cdd]
echo OPV XX2_M12 cdd $&s1_xx2_m12_cdd
let s1_xx2_m12_cds = @m.x1.xdut.xx2_m12.msky130_fd_pr__pfet_01v8_lvt[cds]
echo OPV XX2_M12 cds $&s1_xx2_m12_cds
let s1_xx2_m12_cdb = @m.x1.xdut.xx2_m12.msky130_fd_pr__pfet_01v8_lvt[cdb]
echo OPV XX2_M12 cdb $&s1_xx2_m12_cdb
let s1_xx2_m12_csg = @m.x1.xdut.xx2_m12.msky130_fd_pr__pfet_01v8_lvt[csg]
echo OPV XX2_M12 csg $&s1_xx2_m12_csg
let s1_xx2_m12_csd = @m.x1.xdut.xx2_m12.msky130_fd_pr__pfet_01v8_lvt[csd]
echo OPV XX2_M12 csd $&s1_xx2_m12_csd
let s1_xx2_m12_css = @m.x1.xdut.xx2_m12.msky130_fd_pr__pfet_01v8_lvt[css]
echo OPV XX2_M12 css $&s1_xx2_m12_css
let s1_xx2_m12_csb = @m.x1.xdut.xx2_m12.msky130_fd_pr__pfet_01v8_lvt[csb]
echo OPV XX2_M12 csb $&s1_xx2_m12_csb
let s1_xx2_m12_cbg = @m.x1.xdut.xx2_m12.msky130_fd_pr__pfet_01v8_lvt[cbg]
echo OPV XX2_M12 cbg $&s1_xx2_m12_cbg
let s1_xx2_m12_cbd = @m.x1.xdut.xx2_m12.msky130_fd_pr__pfet_01v8_lvt[cbd]
echo OPV XX2_M12 cbd $&s1_xx2_m12_cbd
let s1_xx2_m12_cbs = @m.x1.xdut.xx2_m12.msky130_fd_pr__pfet_01v8_lvt[cbs]
echo OPV XX2_M12 cbs $&s1_xx2_m12_cbs
let s1_xx2_m12_cbb = @m.x1.xdut.xx2_m12.msky130_fd_pr__pfet_01v8_lvt[cbb]
echo OPV XX2_M12 cbb $&s1_xx2_m12_cbb
let s1_xx2_m12_capbd = @m.x1.xdut.xx2_m12.msky130_fd_pr__pfet_01v8_lvt[capbd]
echo OPV XX2_M12 capbd $&s1_xx2_m12_capbd
let s1_xx2_m12_capbs = @m.x1.xdut.xx2_m12.msky130_fd_pr__pfet_01v8_lvt[capbs]
echo OPV XX2_M12 capbs $&s1_xx2_m12_capbs
let s1_xx2_m12_cgso = @m.x1.xdut.xx2_m12.msky130_fd_pr__pfet_01v8_lvt[cgso]
echo OPV XX2_M12 cgso $&s1_xx2_m12_cgso
let s1_xx2_m12_cgdo = @m.x1.xdut.xx2_m12.msky130_fd_pr__pfet_01v8_lvt[cgdo]
echo OPV XX2_M12 cgdo $&s1_xx2_m12_cgdo
let s1_xx2_m12_cgbo = @m.x1.xdut.xx2_m12.msky130_fd_pr__pfet_01v8_lvt[cgbo]
echo OPV XX2_M12 cgbo $&s1_xx2_m12_cgbo
let s1_xx2_m12_weff = @m.x1.xdut.xx2_m12.msky130_fd_pr__pfet_01v8_lvt[weff]
echo OPV XX2_M12 weff $&s1_xx2_m12_weff
let s1_xx2_m12_leff = @m.x1.xdut.xx2_m12.msky130_fd_pr__pfet_01v8_lvt[leff]
echo OPV XX2_M12 leff $&s1_xx2_m12_leff
let s1_xx2_m1a_id = @m.x1.xdut.xx2_m1a.msky130_fd_pr__pfet_01v8[id]
echo OPV XX2_M1A id $&s1_xx2_m1a_id
let s1_xx2_m1a_vgs = @m.x1.xdut.xx2_m1a.msky130_fd_pr__pfet_01v8[vgs]
echo OPV XX2_M1A vgs $&s1_xx2_m1a_vgs
let s1_xx2_m1a_vds = @m.x1.xdut.xx2_m1a.msky130_fd_pr__pfet_01v8[vds]
echo OPV XX2_M1A vds $&s1_xx2_m1a_vds
let s1_xx2_m1a_vbs = @m.x1.xdut.xx2_m1a.msky130_fd_pr__pfet_01v8[vbs]
echo OPV XX2_M1A vbs $&s1_xx2_m1a_vbs
let s1_xx2_m1a_vth = @m.x1.xdut.xx2_m1a.msky130_fd_pr__pfet_01v8[vth]
echo OPV XX2_M1A vth $&s1_xx2_m1a_vth
let s1_xx2_m1a_vdsat = @m.x1.xdut.xx2_m1a.msky130_fd_pr__pfet_01v8[vdsat]
echo OPV XX2_M1A vdsat $&s1_xx2_m1a_vdsat
let s1_xx2_m1a_gm = @m.x1.xdut.xx2_m1a.msky130_fd_pr__pfet_01v8[gm]
echo OPV XX2_M1A gm $&s1_xx2_m1a_gm
let s1_xx2_m1a_gds = @m.x1.xdut.xx2_m1a.msky130_fd_pr__pfet_01v8[gds]
echo OPV XX2_M1A gds $&s1_xx2_m1a_gds
let s1_xx2_m1a_gmbs = @m.x1.xdut.xx2_m1a.msky130_fd_pr__pfet_01v8[gmbs]
echo OPV XX2_M1A gmbs $&s1_xx2_m1a_gmbs
let s1_xx2_m1a_cgg = @m.x1.xdut.xx2_m1a.msky130_fd_pr__pfet_01v8[cgg]
echo OPV XX2_M1A cgg $&s1_xx2_m1a_cgg
let s1_xx2_m1a_cgd = @m.x1.xdut.xx2_m1a.msky130_fd_pr__pfet_01v8[cgd]
echo OPV XX2_M1A cgd $&s1_xx2_m1a_cgd
let s1_xx2_m1a_cgs = @m.x1.xdut.xx2_m1a.msky130_fd_pr__pfet_01v8[cgs]
echo OPV XX2_M1A cgs $&s1_xx2_m1a_cgs
let s1_xx2_m1a_cgb = @m.x1.xdut.xx2_m1a.msky130_fd_pr__pfet_01v8[cgb]
echo OPV XX2_M1A cgb $&s1_xx2_m1a_cgb
let s1_xx2_m1a_cdg = @m.x1.xdut.xx2_m1a.msky130_fd_pr__pfet_01v8[cdg]
echo OPV XX2_M1A cdg $&s1_xx2_m1a_cdg
let s1_xx2_m1a_cdd = @m.x1.xdut.xx2_m1a.msky130_fd_pr__pfet_01v8[cdd]
echo OPV XX2_M1A cdd $&s1_xx2_m1a_cdd
let s1_xx2_m1a_cds = @m.x1.xdut.xx2_m1a.msky130_fd_pr__pfet_01v8[cds]
echo OPV XX2_M1A cds $&s1_xx2_m1a_cds
let s1_xx2_m1a_cdb = @m.x1.xdut.xx2_m1a.msky130_fd_pr__pfet_01v8[cdb]
echo OPV XX2_M1A cdb $&s1_xx2_m1a_cdb
let s1_xx2_m1a_csg = @m.x1.xdut.xx2_m1a.msky130_fd_pr__pfet_01v8[csg]
echo OPV XX2_M1A csg $&s1_xx2_m1a_csg
let s1_xx2_m1a_csd = @m.x1.xdut.xx2_m1a.msky130_fd_pr__pfet_01v8[csd]
echo OPV XX2_M1A csd $&s1_xx2_m1a_csd
let s1_xx2_m1a_css = @m.x1.xdut.xx2_m1a.msky130_fd_pr__pfet_01v8[css]
echo OPV XX2_M1A css $&s1_xx2_m1a_css
let s1_xx2_m1a_csb = @m.x1.xdut.xx2_m1a.msky130_fd_pr__pfet_01v8[csb]
echo OPV XX2_M1A csb $&s1_xx2_m1a_csb
let s1_xx2_m1a_cbg = @m.x1.xdut.xx2_m1a.msky130_fd_pr__pfet_01v8[cbg]
echo OPV XX2_M1A cbg $&s1_xx2_m1a_cbg
let s1_xx2_m1a_cbd = @m.x1.xdut.xx2_m1a.msky130_fd_pr__pfet_01v8[cbd]
echo OPV XX2_M1A cbd $&s1_xx2_m1a_cbd
let s1_xx2_m1a_cbs = @m.x1.xdut.xx2_m1a.msky130_fd_pr__pfet_01v8[cbs]
echo OPV XX2_M1A cbs $&s1_xx2_m1a_cbs
let s1_xx2_m1a_cbb = @m.x1.xdut.xx2_m1a.msky130_fd_pr__pfet_01v8[cbb]
echo OPV XX2_M1A cbb $&s1_xx2_m1a_cbb
let s1_xx2_m1a_capbd = @m.x1.xdut.xx2_m1a.msky130_fd_pr__pfet_01v8[capbd]
echo OPV XX2_M1A capbd $&s1_xx2_m1a_capbd
let s1_xx2_m1a_capbs = @m.x1.xdut.xx2_m1a.msky130_fd_pr__pfet_01v8[capbs]
echo OPV XX2_M1A capbs $&s1_xx2_m1a_capbs
let s1_xx2_m1a_cgso = @m.x1.xdut.xx2_m1a.msky130_fd_pr__pfet_01v8[cgso]
echo OPV XX2_M1A cgso $&s1_xx2_m1a_cgso
let s1_xx2_m1a_cgdo = @m.x1.xdut.xx2_m1a.msky130_fd_pr__pfet_01v8[cgdo]
echo OPV XX2_M1A cgdo $&s1_xx2_m1a_cgdo
let s1_xx2_m1a_cgbo = @m.x1.xdut.xx2_m1a.msky130_fd_pr__pfet_01v8[cgbo]
echo OPV XX2_M1A cgbo $&s1_xx2_m1a_cgbo
let s1_xx2_m1a_weff = @m.x1.xdut.xx2_m1a.msky130_fd_pr__pfet_01v8[weff]
echo OPV XX2_M1A weff $&s1_xx2_m1a_weff
let s1_xx2_m1a_leff = @m.x1.xdut.xx2_m1a.msky130_fd_pr__pfet_01v8[leff]
echo OPV XX2_M1A leff $&s1_xx2_m1a_leff
let s1_xx2_m8_id = @m.x1.xdut.xx2_m8.msky130_fd_pr__pfet_01v8[id]
echo OPV XX2_M8 id $&s1_xx2_m8_id
let s1_xx2_m8_vgs = @m.x1.xdut.xx2_m8.msky130_fd_pr__pfet_01v8[vgs]
echo OPV XX2_M8 vgs $&s1_xx2_m8_vgs
let s1_xx2_m8_vds = @m.x1.xdut.xx2_m8.msky130_fd_pr__pfet_01v8[vds]
echo OPV XX2_M8 vds $&s1_xx2_m8_vds
let s1_xx2_m8_vbs = @m.x1.xdut.xx2_m8.msky130_fd_pr__pfet_01v8[vbs]
echo OPV XX2_M8 vbs $&s1_xx2_m8_vbs
let s1_xx2_m8_vth = @m.x1.xdut.xx2_m8.msky130_fd_pr__pfet_01v8[vth]
echo OPV XX2_M8 vth $&s1_xx2_m8_vth
let s1_xx2_m8_vdsat = @m.x1.xdut.xx2_m8.msky130_fd_pr__pfet_01v8[vdsat]
echo OPV XX2_M8 vdsat $&s1_xx2_m8_vdsat
let s1_xx2_m8_gm = @m.x1.xdut.xx2_m8.msky130_fd_pr__pfet_01v8[gm]
echo OPV XX2_M8 gm $&s1_xx2_m8_gm
let s1_xx2_m8_gds = @m.x1.xdut.xx2_m8.msky130_fd_pr__pfet_01v8[gds]
echo OPV XX2_M8 gds $&s1_xx2_m8_gds
let s1_xx2_m8_gmbs = @m.x1.xdut.xx2_m8.msky130_fd_pr__pfet_01v8[gmbs]
echo OPV XX2_M8 gmbs $&s1_xx2_m8_gmbs
let s1_xx2_m8_cgg = @m.x1.xdut.xx2_m8.msky130_fd_pr__pfet_01v8[cgg]
echo OPV XX2_M8 cgg $&s1_xx2_m8_cgg
let s1_xx2_m8_cgd = @m.x1.xdut.xx2_m8.msky130_fd_pr__pfet_01v8[cgd]
echo OPV XX2_M8 cgd $&s1_xx2_m8_cgd
let s1_xx2_m8_cgs = @m.x1.xdut.xx2_m8.msky130_fd_pr__pfet_01v8[cgs]
echo OPV XX2_M8 cgs $&s1_xx2_m8_cgs
let s1_xx2_m8_cgb = @m.x1.xdut.xx2_m8.msky130_fd_pr__pfet_01v8[cgb]
echo OPV XX2_M8 cgb $&s1_xx2_m8_cgb
let s1_xx2_m8_cdg = @m.x1.xdut.xx2_m8.msky130_fd_pr__pfet_01v8[cdg]
echo OPV XX2_M8 cdg $&s1_xx2_m8_cdg
let s1_xx2_m8_cdd = @m.x1.xdut.xx2_m8.msky130_fd_pr__pfet_01v8[cdd]
echo OPV XX2_M8 cdd $&s1_xx2_m8_cdd
let s1_xx2_m8_cds = @m.x1.xdut.xx2_m8.msky130_fd_pr__pfet_01v8[cds]
echo OPV XX2_M8 cds $&s1_xx2_m8_cds
let s1_xx2_m8_cdb = @m.x1.xdut.xx2_m8.msky130_fd_pr__pfet_01v8[cdb]
echo OPV XX2_M8 cdb $&s1_xx2_m8_cdb
let s1_xx2_m8_csg = @m.x1.xdut.xx2_m8.msky130_fd_pr__pfet_01v8[csg]
echo OPV XX2_M8 csg $&s1_xx2_m8_csg
let s1_xx2_m8_csd = @m.x1.xdut.xx2_m8.msky130_fd_pr__pfet_01v8[csd]
echo OPV XX2_M8 csd $&s1_xx2_m8_csd
let s1_xx2_m8_css = @m.x1.xdut.xx2_m8.msky130_fd_pr__pfet_01v8[css]
echo OPV XX2_M8 css $&s1_xx2_m8_css
let s1_xx2_m8_csb = @m.x1.xdut.xx2_m8.msky130_fd_pr__pfet_01v8[csb]
echo OPV XX2_M8 csb $&s1_xx2_m8_csb
let s1_xx2_m8_cbg = @m.x1.xdut.xx2_m8.msky130_fd_pr__pfet_01v8[cbg]
echo OPV XX2_M8 cbg $&s1_xx2_m8_cbg
let s1_xx2_m8_cbd = @m.x1.xdut.xx2_m8.msky130_fd_pr__pfet_01v8[cbd]
echo OPV XX2_M8 cbd $&s1_xx2_m8_cbd
let s1_xx2_m8_cbs = @m.x1.xdut.xx2_m8.msky130_fd_pr__pfet_01v8[cbs]
echo OPV XX2_M8 cbs $&s1_xx2_m8_cbs
let s1_xx2_m8_cbb = @m.x1.xdut.xx2_m8.msky130_fd_pr__pfet_01v8[cbb]
echo OPV XX2_M8 cbb $&s1_xx2_m8_cbb
let s1_xx2_m8_capbd = @m.x1.xdut.xx2_m8.msky130_fd_pr__pfet_01v8[capbd]
echo OPV XX2_M8 capbd $&s1_xx2_m8_capbd
let s1_xx2_m8_capbs = @m.x1.xdut.xx2_m8.msky130_fd_pr__pfet_01v8[capbs]
echo OPV XX2_M8 capbs $&s1_xx2_m8_capbs
let s1_xx2_m8_cgso = @m.x1.xdut.xx2_m8.msky130_fd_pr__pfet_01v8[cgso]
echo OPV XX2_M8 cgso $&s1_xx2_m8_cgso
let s1_xx2_m8_cgdo = @m.x1.xdut.xx2_m8.msky130_fd_pr__pfet_01v8[cgdo]
echo OPV XX2_M8 cgdo $&s1_xx2_m8_cgdo
let s1_xx2_m8_cgbo = @m.x1.xdut.xx2_m8.msky130_fd_pr__pfet_01v8[cgbo]
echo OPV XX2_M8 cgbo $&s1_xx2_m8_cgbo
let s1_xx2_m8_weff = @m.x1.xdut.xx2_m8.msky130_fd_pr__pfet_01v8[weff]
echo OPV XX2_M8 weff $&s1_xx2_m8_weff
let s1_xx2_m8_leff = @m.x1.xdut.xx2_m8.msky130_fd_pr__pfet_01v8[leff]
echo OPV XX2_M8 leff $&s1_xx2_m8_leff
let s1_xx2_m3a_id = @m.x1.xdut.xx2_m3a.msky130_fd_pr__nfet_01v8[id]
echo OPV XX2_M3A id $&s1_xx2_m3a_id
let s1_xx2_m3a_vgs = @m.x1.xdut.xx2_m3a.msky130_fd_pr__nfet_01v8[vgs]
echo OPV XX2_M3A vgs $&s1_xx2_m3a_vgs
let s1_xx2_m3a_vds = @m.x1.xdut.xx2_m3a.msky130_fd_pr__nfet_01v8[vds]
echo OPV XX2_M3A vds $&s1_xx2_m3a_vds
let s1_xx2_m3a_vbs = @m.x1.xdut.xx2_m3a.msky130_fd_pr__nfet_01v8[vbs]
echo OPV XX2_M3A vbs $&s1_xx2_m3a_vbs
let s1_xx2_m3a_vth = @m.x1.xdut.xx2_m3a.msky130_fd_pr__nfet_01v8[vth]
echo OPV XX2_M3A vth $&s1_xx2_m3a_vth
let s1_xx2_m3a_vdsat = @m.x1.xdut.xx2_m3a.msky130_fd_pr__nfet_01v8[vdsat]
echo OPV XX2_M3A vdsat $&s1_xx2_m3a_vdsat
let s1_xx2_m3a_gm = @m.x1.xdut.xx2_m3a.msky130_fd_pr__nfet_01v8[gm]
echo OPV XX2_M3A gm $&s1_xx2_m3a_gm
let s1_xx2_m3a_gds = @m.x1.xdut.xx2_m3a.msky130_fd_pr__nfet_01v8[gds]
echo OPV XX2_M3A gds $&s1_xx2_m3a_gds
let s1_xx2_m3a_gmbs = @m.x1.xdut.xx2_m3a.msky130_fd_pr__nfet_01v8[gmbs]
echo OPV XX2_M3A gmbs $&s1_xx2_m3a_gmbs
let s1_xx2_m3a_cgg = @m.x1.xdut.xx2_m3a.msky130_fd_pr__nfet_01v8[cgg]
echo OPV XX2_M3A cgg $&s1_xx2_m3a_cgg
let s1_xx2_m3a_cgd = @m.x1.xdut.xx2_m3a.msky130_fd_pr__nfet_01v8[cgd]
echo OPV XX2_M3A cgd $&s1_xx2_m3a_cgd
let s1_xx2_m3a_cgs = @m.x1.xdut.xx2_m3a.msky130_fd_pr__nfet_01v8[cgs]
echo OPV XX2_M3A cgs $&s1_xx2_m3a_cgs
let s1_xx2_m3a_cgb = @m.x1.xdut.xx2_m3a.msky130_fd_pr__nfet_01v8[cgb]
echo OPV XX2_M3A cgb $&s1_xx2_m3a_cgb
let s1_xx2_m3a_cdg = @m.x1.xdut.xx2_m3a.msky130_fd_pr__nfet_01v8[cdg]
echo OPV XX2_M3A cdg $&s1_xx2_m3a_cdg
let s1_xx2_m3a_cdd = @m.x1.xdut.xx2_m3a.msky130_fd_pr__nfet_01v8[cdd]
echo OPV XX2_M3A cdd $&s1_xx2_m3a_cdd
let s1_xx2_m3a_cds = @m.x1.xdut.xx2_m3a.msky130_fd_pr__nfet_01v8[cds]
echo OPV XX2_M3A cds $&s1_xx2_m3a_cds
let s1_xx2_m3a_cdb = @m.x1.xdut.xx2_m3a.msky130_fd_pr__nfet_01v8[cdb]
echo OPV XX2_M3A cdb $&s1_xx2_m3a_cdb
let s1_xx2_m3a_csg = @m.x1.xdut.xx2_m3a.msky130_fd_pr__nfet_01v8[csg]
echo OPV XX2_M3A csg $&s1_xx2_m3a_csg
let s1_xx2_m3a_csd = @m.x1.xdut.xx2_m3a.msky130_fd_pr__nfet_01v8[csd]
echo OPV XX2_M3A csd $&s1_xx2_m3a_csd
let s1_xx2_m3a_css = @m.x1.xdut.xx2_m3a.msky130_fd_pr__nfet_01v8[css]
echo OPV XX2_M3A css $&s1_xx2_m3a_css
let s1_xx2_m3a_csb = @m.x1.xdut.xx2_m3a.msky130_fd_pr__nfet_01v8[csb]
echo OPV XX2_M3A csb $&s1_xx2_m3a_csb
let s1_xx2_m3a_cbg = @m.x1.xdut.xx2_m3a.msky130_fd_pr__nfet_01v8[cbg]
echo OPV XX2_M3A cbg $&s1_xx2_m3a_cbg
let s1_xx2_m3a_cbd = @m.x1.xdut.xx2_m3a.msky130_fd_pr__nfet_01v8[cbd]
echo OPV XX2_M3A cbd $&s1_xx2_m3a_cbd
let s1_xx2_m3a_cbs = @m.x1.xdut.xx2_m3a.msky130_fd_pr__nfet_01v8[cbs]
echo OPV XX2_M3A cbs $&s1_xx2_m3a_cbs
let s1_xx2_m3a_cbb = @m.x1.xdut.xx2_m3a.msky130_fd_pr__nfet_01v8[cbb]
echo OPV XX2_M3A cbb $&s1_xx2_m3a_cbb
let s1_xx2_m3a_capbd = @m.x1.xdut.xx2_m3a.msky130_fd_pr__nfet_01v8[capbd]
echo OPV XX2_M3A capbd $&s1_xx2_m3a_capbd
let s1_xx2_m3a_capbs = @m.x1.xdut.xx2_m3a.msky130_fd_pr__nfet_01v8[capbs]
echo OPV XX2_M3A capbs $&s1_xx2_m3a_capbs
let s1_xx2_m3a_cgso = @m.x1.xdut.xx2_m3a.msky130_fd_pr__nfet_01v8[cgso]
echo OPV XX2_M3A cgso $&s1_xx2_m3a_cgso
let s1_xx2_m3a_cgdo = @m.x1.xdut.xx2_m3a.msky130_fd_pr__nfet_01v8[cgdo]
echo OPV XX2_M3A cgdo $&s1_xx2_m3a_cgdo
let s1_xx2_m3a_cgbo = @m.x1.xdut.xx2_m3a.msky130_fd_pr__nfet_01v8[cgbo]
echo OPV XX2_M3A cgbo $&s1_xx2_m3a_cgbo
let s1_xx2_m3a_weff = @m.x1.xdut.xx2_m3a.msky130_fd_pr__nfet_01v8[weff]
echo OPV XX2_M3A weff $&s1_xx2_m3a_weff
let s1_xx2_m3a_leff = @m.x1.xdut.xx2_m3a.msky130_fd_pr__nfet_01v8[leff]
echo OPV XX2_M3A leff $&s1_xx2_m3a_leff
let s1_xx2_m7_id = @m.x1.xdut.xx2_m7.msky130_fd_pr__nfet_01v8[id]
echo OPV XX2_M7 id $&s1_xx2_m7_id
let s1_xx2_m7_vgs = @m.x1.xdut.xx2_m7.msky130_fd_pr__nfet_01v8[vgs]
echo OPV XX2_M7 vgs $&s1_xx2_m7_vgs
let s1_xx2_m7_vds = @m.x1.xdut.xx2_m7.msky130_fd_pr__nfet_01v8[vds]
echo OPV XX2_M7 vds $&s1_xx2_m7_vds
let s1_xx2_m7_vbs = @m.x1.xdut.xx2_m7.msky130_fd_pr__nfet_01v8[vbs]
echo OPV XX2_M7 vbs $&s1_xx2_m7_vbs
let s1_xx2_m7_vth = @m.x1.xdut.xx2_m7.msky130_fd_pr__nfet_01v8[vth]
echo OPV XX2_M7 vth $&s1_xx2_m7_vth
let s1_xx2_m7_vdsat = @m.x1.xdut.xx2_m7.msky130_fd_pr__nfet_01v8[vdsat]
echo OPV XX2_M7 vdsat $&s1_xx2_m7_vdsat
let s1_xx2_m7_gm = @m.x1.xdut.xx2_m7.msky130_fd_pr__nfet_01v8[gm]
echo OPV XX2_M7 gm $&s1_xx2_m7_gm
let s1_xx2_m7_gds = @m.x1.xdut.xx2_m7.msky130_fd_pr__nfet_01v8[gds]
echo OPV XX2_M7 gds $&s1_xx2_m7_gds
let s1_xx2_m7_gmbs = @m.x1.xdut.xx2_m7.msky130_fd_pr__nfet_01v8[gmbs]
echo OPV XX2_M7 gmbs $&s1_xx2_m7_gmbs
let s1_xx2_m7_cgg = @m.x1.xdut.xx2_m7.msky130_fd_pr__nfet_01v8[cgg]
echo OPV XX2_M7 cgg $&s1_xx2_m7_cgg
let s1_xx2_m7_cgd = @m.x1.xdut.xx2_m7.msky130_fd_pr__nfet_01v8[cgd]
echo OPV XX2_M7 cgd $&s1_xx2_m7_cgd
let s1_xx2_m7_cgs = @m.x1.xdut.xx2_m7.msky130_fd_pr__nfet_01v8[cgs]
echo OPV XX2_M7 cgs $&s1_xx2_m7_cgs
let s1_xx2_m7_cgb = @m.x1.xdut.xx2_m7.msky130_fd_pr__nfet_01v8[cgb]
echo OPV XX2_M7 cgb $&s1_xx2_m7_cgb
let s1_xx2_m7_cdg = @m.x1.xdut.xx2_m7.msky130_fd_pr__nfet_01v8[cdg]
echo OPV XX2_M7 cdg $&s1_xx2_m7_cdg
let s1_xx2_m7_cdd = @m.x1.xdut.xx2_m7.msky130_fd_pr__nfet_01v8[cdd]
echo OPV XX2_M7 cdd $&s1_xx2_m7_cdd
let s1_xx2_m7_cds = @m.x1.xdut.xx2_m7.msky130_fd_pr__nfet_01v8[cds]
echo OPV XX2_M7 cds $&s1_xx2_m7_cds
let s1_xx2_m7_cdb = @m.x1.xdut.xx2_m7.msky130_fd_pr__nfet_01v8[cdb]
echo OPV XX2_M7 cdb $&s1_xx2_m7_cdb
let s1_xx2_m7_csg = @m.x1.xdut.xx2_m7.msky130_fd_pr__nfet_01v8[csg]
echo OPV XX2_M7 csg $&s1_xx2_m7_csg
let s1_xx2_m7_csd = @m.x1.xdut.xx2_m7.msky130_fd_pr__nfet_01v8[csd]
echo OPV XX2_M7 csd $&s1_xx2_m7_csd
let s1_xx2_m7_css = @m.x1.xdut.xx2_m7.msky130_fd_pr__nfet_01v8[css]
echo OPV XX2_M7 css $&s1_xx2_m7_css
let s1_xx2_m7_csb = @m.x1.xdut.xx2_m7.msky130_fd_pr__nfet_01v8[csb]
echo OPV XX2_M7 csb $&s1_xx2_m7_csb
let s1_xx2_m7_cbg = @m.x1.xdut.xx2_m7.msky130_fd_pr__nfet_01v8[cbg]
echo OPV XX2_M7 cbg $&s1_xx2_m7_cbg
let s1_xx2_m7_cbd = @m.x1.xdut.xx2_m7.msky130_fd_pr__nfet_01v8[cbd]
echo OPV XX2_M7 cbd $&s1_xx2_m7_cbd
let s1_xx2_m7_cbs = @m.x1.xdut.xx2_m7.msky130_fd_pr__nfet_01v8[cbs]
echo OPV XX2_M7 cbs $&s1_xx2_m7_cbs
let s1_xx2_m7_cbb = @m.x1.xdut.xx2_m7.msky130_fd_pr__nfet_01v8[cbb]
echo OPV XX2_M7 cbb $&s1_xx2_m7_cbb
let s1_xx2_m7_capbd = @m.x1.xdut.xx2_m7.msky130_fd_pr__nfet_01v8[capbd]
echo OPV XX2_M7 capbd $&s1_xx2_m7_capbd
let s1_xx2_m7_capbs = @m.x1.xdut.xx2_m7.msky130_fd_pr__nfet_01v8[capbs]
echo OPV XX2_M7 capbs $&s1_xx2_m7_capbs
let s1_xx2_m7_cgso = @m.x1.xdut.xx2_m7.msky130_fd_pr__nfet_01v8[cgso]
echo OPV XX2_M7 cgso $&s1_xx2_m7_cgso
let s1_xx2_m7_cgdo = @m.x1.xdut.xx2_m7.msky130_fd_pr__nfet_01v8[cgdo]
echo OPV XX2_M7 cgdo $&s1_xx2_m7_cgdo
let s1_xx2_m7_cgbo = @m.x1.xdut.xx2_m7.msky130_fd_pr__nfet_01v8[cgbo]
echo OPV XX2_M7 cgbo $&s1_xx2_m7_cgbo
let s1_xx2_m7_weff = @m.x1.xdut.xx2_m7.msky130_fd_pr__nfet_01v8[weff]
echo OPV XX2_M7 weff $&s1_xx2_m7_weff
let s1_xx2_m7_leff = @m.x1.xdut.xx2_m7.msky130_fd_pr__nfet_01v8[leff]
echo OPV XX2_M7 leff $&s1_xx2_m7_leff
let s1_xx2_m3_id = @m.x1.xdut.xx2_m3.msky130_fd_pr__nfet_01v8[id]
echo OPV XX2_M3 id $&s1_xx2_m3_id
let s1_xx2_m3_vgs = @m.x1.xdut.xx2_m3.msky130_fd_pr__nfet_01v8[vgs]
echo OPV XX2_M3 vgs $&s1_xx2_m3_vgs
let s1_xx2_m3_vds = @m.x1.xdut.xx2_m3.msky130_fd_pr__nfet_01v8[vds]
echo OPV XX2_M3 vds $&s1_xx2_m3_vds
let s1_xx2_m3_vbs = @m.x1.xdut.xx2_m3.msky130_fd_pr__nfet_01v8[vbs]
echo OPV XX2_M3 vbs $&s1_xx2_m3_vbs
let s1_xx2_m3_vth = @m.x1.xdut.xx2_m3.msky130_fd_pr__nfet_01v8[vth]
echo OPV XX2_M3 vth $&s1_xx2_m3_vth
let s1_xx2_m3_vdsat = @m.x1.xdut.xx2_m3.msky130_fd_pr__nfet_01v8[vdsat]
echo OPV XX2_M3 vdsat $&s1_xx2_m3_vdsat
let s1_xx2_m3_gm = @m.x1.xdut.xx2_m3.msky130_fd_pr__nfet_01v8[gm]
echo OPV XX2_M3 gm $&s1_xx2_m3_gm
let s1_xx2_m3_gds = @m.x1.xdut.xx2_m3.msky130_fd_pr__nfet_01v8[gds]
echo OPV XX2_M3 gds $&s1_xx2_m3_gds
let s1_xx2_m3_gmbs = @m.x1.xdut.xx2_m3.msky130_fd_pr__nfet_01v8[gmbs]
echo OPV XX2_M3 gmbs $&s1_xx2_m3_gmbs
let s1_xx2_m3_cgg = @m.x1.xdut.xx2_m3.msky130_fd_pr__nfet_01v8[cgg]
echo OPV XX2_M3 cgg $&s1_xx2_m3_cgg
let s1_xx2_m3_cgd = @m.x1.xdut.xx2_m3.msky130_fd_pr__nfet_01v8[cgd]
echo OPV XX2_M3 cgd $&s1_xx2_m3_cgd
let s1_xx2_m3_cgs = @m.x1.xdut.xx2_m3.msky130_fd_pr__nfet_01v8[cgs]
echo OPV XX2_M3 cgs $&s1_xx2_m3_cgs
let s1_xx2_m3_cgb = @m.x1.xdut.xx2_m3.msky130_fd_pr__nfet_01v8[cgb]
echo OPV XX2_M3 cgb $&s1_xx2_m3_cgb
let s1_xx2_m3_cdg = @m.x1.xdut.xx2_m3.msky130_fd_pr__nfet_01v8[cdg]
echo OPV XX2_M3 cdg $&s1_xx2_m3_cdg
let s1_xx2_m3_cdd = @m.x1.xdut.xx2_m3.msky130_fd_pr__nfet_01v8[cdd]
echo OPV XX2_M3 cdd $&s1_xx2_m3_cdd
let s1_xx2_m3_cds = @m.x1.xdut.xx2_m3.msky130_fd_pr__nfet_01v8[cds]
echo OPV XX2_M3 cds $&s1_xx2_m3_cds
let s1_xx2_m3_cdb = @m.x1.xdut.xx2_m3.msky130_fd_pr__nfet_01v8[cdb]
echo OPV XX2_M3 cdb $&s1_xx2_m3_cdb
let s1_xx2_m3_csg = @m.x1.xdut.xx2_m3.msky130_fd_pr__nfet_01v8[csg]
echo OPV XX2_M3 csg $&s1_xx2_m3_csg
let s1_xx2_m3_csd = @m.x1.xdut.xx2_m3.msky130_fd_pr__nfet_01v8[csd]
echo OPV XX2_M3 csd $&s1_xx2_m3_csd
let s1_xx2_m3_css = @m.x1.xdut.xx2_m3.msky130_fd_pr__nfet_01v8[css]
echo OPV XX2_M3 css $&s1_xx2_m3_css
let s1_xx2_m3_csb = @m.x1.xdut.xx2_m3.msky130_fd_pr__nfet_01v8[csb]
echo OPV XX2_M3 csb $&s1_xx2_m3_csb
let s1_xx2_m3_cbg = @m.x1.xdut.xx2_m3.msky130_fd_pr__nfet_01v8[cbg]
echo OPV XX2_M3 cbg $&s1_xx2_m3_cbg
let s1_xx2_m3_cbd = @m.x1.xdut.xx2_m3.msky130_fd_pr__nfet_01v8[cbd]
echo OPV XX2_M3 cbd $&s1_xx2_m3_cbd
let s1_xx2_m3_cbs = @m.x1.xdut.xx2_m3.msky130_fd_pr__nfet_01v8[cbs]
echo OPV XX2_M3 cbs $&s1_xx2_m3_cbs
let s1_xx2_m3_cbb = @m.x1.xdut.xx2_m3.msky130_fd_pr__nfet_01v8[cbb]
echo OPV XX2_M3 cbb $&s1_xx2_m3_cbb
let s1_xx2_m3_capbd = @m.x1.xdut.xx2_m3.msky130_fd_pr__nfet_01v8[capbd]
echo OPV XX2_M3 capbd $&s1_xx2_m3_capbd
let s1_xx2_m3_capbs = @m.x1.xdut.xx2_m3.msky130_fd_pr__nfet_01v8[capbs]
echo OPV XX2_M3 capbs $&s1_xx2_m3_capbs
let s1_xx2_m3_cgso = @m.x1.xdut.xx2_m3.msky130_fd_pr__nfet_01v8[cgso]
echo OPV XX2_M3 cgso $&s1_xx2_m3_cgso
let s1_xx2_m3_cgdo = @m.x1.xdut.xx2_m3.msky130_fd_pr__nfet_01v8[cgdo]
echo OPV XX2_M3 cgdo $&s1_xx2_m3_cgdo
let s1_xx2_m3_cgbo = @m.x1.xdut.xx2_m3.msky130_fd_pr__nfet_01v8[cgbo]
echo OPV XX2_M3 cgbo $&s1_xx2_m3_cgbo
let s1_xx2_m3_weff = @m.x1.xdut.xx2_m3.msky130_fd_pr__nfet_01v8[weff]
echo OPV XX2_M3 weff $&s1_xx2_m3_weff
let s1_xx2_m3_leff = @m.x1.xdut.xx2_m3.msky130_fd_pr__nfet_01v8[leff]
echo OPV XX2_M3 leff $&s1_xx2_m3_leff
let s1_xx2_m4_id = @m.x1.xdut.xx2_m4.msky130_fd_pr__nfet_01v8[id]
echo OPV XX2_M4 id $&s1_xx2_m4_id
let s1_xx2_m4_vgs = @m.x1.xdut.xx2_m4.msky130_fd_pr__nfet_01v8[vgs]
echo OPV XX2_M4 vgs $&s1_xx2_m4_vgs
let s1_xx2_m4_vds = @m.x1.xdut.xx2_m4.msky130_fd_pr__nfet_01v8[vds]
echo OPV XX2_M4 vds $&s1_xx2_m4_vds
let s1_xx2_m4_vbs = @m.x1.xdut.xx2_m4.msky130_fd_pr__nfet_01v8[vbs]
echo OPV XX2_M4 vbs $&s1_xx2_m4_vbs
let s1_xx2_m4_vth = @m.x1.xdut.xx2_m4.msky130_fd_pr__nfet_01v8[vth]
echo OPV XX2_M4 vth $&s1_xx2_m4_vth
let s1_xx2_m4_vdsat = @m.x1.xdut.xx2_m4.msky130_fd_pr__nfet_01v8[vdsat]
echo OPV XX2_M4 vdsat $&s1_xx2_m4_vdsat
let s1_xx2_m4_gm = @m.x1.xdut.xx2_m4.msky130_fd_pr__nfet_01v8[gm]
echo OPV XX2_M4 gm $&s1_xx2_m4_gm
let s1_xx2_m4_gds = @m.x1.xdut.xx2_m4.msky130_fd_pr__nfet_01v8[gds]
echo OPV XX2_M4 gds $&s1_xx2_m4_gds
let s1_xx2_m4_gmbs = @m.x1.xdut.xx2_m4.msky130_fd_pr__nfet_01v8[gmbs]
echo OPV XX2_M4 gmbs $&s1_xx2_m4_gmbs
let s1_xx2_m4_cgg = @m.x1.xdut.xx2_m4.msky130_fd_pr__nfet_01v8[cgg]
echo OPV XX2_M4 cgg $&s1_xx2_m4_cgg
let s1_xx2_m4_cgd = @m.x1.xdut.xx2_m4.msky130_fd_pr__nfet_01v8[cgd]
echo OPV XX2_M4 cgd $&s1_xx2_m4_cgd
let s1_xx2_m4_cgs = @m.x1.xdut.xx2_m4.msky130_fd_pr__nfet_01v8[cgs]
echo OPV XX2_M4 cgs $&s1_xx2_m4_cgs
let s1_xx2_m4_cgb = @m.x1.xdut.xx2_m4.msky130_fd_pr__nfet_01v8[cgb]
echo OPV XX2_M4 cgb $&s1_xx2_m4_cgb
let s1_xx2_m4_cdg = @m.x1.xdut.xx2_m4.msky130_fd_pr__nfet_01v8[cdg]
echo OPV XX2_M4 cdg $&s1_xx2_m4_cdg
let s1_xx2_m4_cdd = @m.x1.xdut.xx2_m4.msky130_fd_pr__nfet_01v8[cdd]
echo OPV XX2_M4 cdd $&s1_xx2_m4_cdd
let s1_xx2_m4_cds = @m.x1.xdut.xx2_m4.msky130_fd_pr__nfet_01v8[cds]
echo OPV XX2_M4 cds $&s1_xx2_m4_cds
let s1_xx2_m4_cdb = @m.x1.xdut.xx2_m4.msky130_fd_pr__nfet_01v8[cdb]
echo OPV XX2_M4 cdb $&s1_xx2_m4_cdb
let s1_xx2_m4_csg = @m.x1.xdut.xx2_m4.msky130_fd_pr__nfet_01v8[csg]
echo OPV XX2_M4 csg $&s1_xx2_m4_csg
let s1_xx2_m4_csd = @m.x1.xdut.xx2_m4.msky130_fd_pr__nfet_01v8[csd]
echo OPV XX2_M4 csd $&s1_xx2_m4_csd
let s1_xx2_m4_css = @m.x1.xdut.xx2_m4.msky130_fd_pr__nfet_01v8[css]
echo OPV XX2_M4 css $&s1_xx2_m4_css
let s1_xx2_m4_csb = @m.x1.xdut.xx2_m4.msky130_fd_pr__nfet_01v8[csb]
echo OPV XX2_M4 csb $&s1_xx2_m4_csb
let s1_xx2_m4_cbg = @m.x1.xdut.xx2_m4.msky130_fd_pr__nfet_01v8[cbg]
echo OPV XX2_M4 cbg $&s1_xx2_m4_cbg
let s1_xx2_m4_cbd = @m.x1.xdut.xx2_m4.msky130_fd_pr__nfet_01v8[cbd]
echo OPV XX2_M4 cbd $&s1_xx2_m4_cbd
let s1_xx2_m4_cbs = @m.x1.xdut.xx2_m4.msky130_fd_pr__nfet_01v8[cbs]
echo OPV XX2_M4 cbs $&s1_xx2_m4_cbs
let s1_xx2_m4_cbb = @m.x1.xdut.xx2_m4.msky130_fd_pr__nfet_01v8[cbb]
echo OPV XX2_M4 cbb $&s1_xx2_m4_cbb
let s1_xx2_m4_capbd = @m.x1.xdut.xx2_m4.msky130_fd_pr__nfet_01v8[capbd]
echo OPV XX2_M4 capbd $&s1_xx2_m4_capbd
let s1_xx2_m4_capbs = @m.x1.xdut.xx2_m4.msky130_fd_pr__nfet_01v8[capbs]
echo OPV XX2_M4 capbs $&s1_xx2_m4_capbs
let s1_xx2_m4_cgso = @m.x1.xdut.xx2_m4.msky130_fd_pr__nfet_01v8[cgso]
echo OPV XX2_M4 cgso $&s1_xx2_m4_cgso
let s1_xx2_m4_cgdo = @m.x1.xdut.xx2_m4.msky130_fd_pr__nfet_01v8[cgdo]
echo OPV XX2_M4 cgdo $&s1_xx2_m4_cgdo
let s1_xx2_m4_cgbo = @m.x1.xdut.xx2_m4.msky130_fd_pr__nfet_01v8[cgbo]
echo OPV XX2_M4 cgbo $&s1_xx2_m4_cgbo
let s1_xx2_m4_weff = @m.x1.xdut.xx2_m4.msky130_fd_pr__nfet_01v8[weff]
echo OPV XX2_M4 weff $&s1_xx2_m4_weff
let s1_xx2_m4_leff = @m.x1.xdut.xx2_m4.msky130_fd_pr__nfet_01v8[leff]
echo OPV XX2_M4 leff $&s1_xx2_m4_leff
let s1_xx2_m82_id = @m.x1.xdut.xx2_m82.msky130_fd_pr__pfet_01v8[id]
echo OPV XX2_M82 id $&s1_xx2_m82_id
let s1_xx2_m82_vgs = @m.x1.xdut.xx2_m82.msky130_fd_pr__pfet_01v8[vgs]
echo OPV XX2_M82 vgs $&s1_xx2_m82_vgs
let s1_xx2_m82_vds = @m.x1.xdut.xx2_m82.msky130_fd_pr__pfet_01v8[vds]
echo OPV XX2_M82 vds $&s1_xx2_m82_vds
let s1_xx2_m82_vbs = @m.x1.xdut.xx2_m82.msky130_fd_pr__pfet_01v8[vbs]
echo OPV XX2_M82 vbs $&s1_xx2_m82_vbs
let s1_xx2_m82_vth = @m.x1.xdut.xx2_m82.msky130_fd_pr__pfet_01v8[vth]
echo OPV XX2_M82 vth $&s1_xx2_m82_vth
let s1_xx2_m82_vdsat = @m.x1.xdut.xx2_m82.msky130_fd_pr__pfet_01v8[vdsat]
echo OPV XX2_M82 vdsat $&s1_xx2_m82_vdsat
let s1_xx2_m82_gm = @m.x1.xdut.xx2_m82.msky130_fd_pr__pfet_01v8[gm]
echo OPV XX2_M82 gm $&s1_xx2_m82_gm
let s1_xx2_m82_gds = @m.x1.xdut.xx2_m82.msky130_fd_pr__pfet_01v8[gds]
echo OPV XX2_M82 gds $&s1_xx2_m82_gds
let s1_xx2_m82_gmbs = @m.x1.xdut.xx2_m82.msky130_fd_pr__pfet_01v8[gmbs]
echo OPV XX2_M82 gmbs $&s1_xx2_m82_gmbs
let s1_xx2_m82_cgg = @m.x1.xdut.xx2_m82.msky130_fd_pr__pfet_01v8[cgg]
echo OPV XX2_M82 cgg $&s1_xx2_m82_cgg
let s1_xx2_m82_cgd = @m.x1.xdut.xx2_m82.msky130_fd_pr__pfet_01v8[cgd]
echo OPV XX2_M82 cgd $&s1_xx2_m82_cgd
let s1_xx2_m82_cgs = @m.x1.xdut.xx2_m82.msky130_fd_pr__pfet_01v8[cgs]
echo OPV XX2_M82 cgs $&s1_xx2_m82_cgs
let s1_xx2_m82_cgb = @m.x1.xdut.xx2_m82.msky130_fd_pr__pfet_01v8[cgb]
echo OPV XX2_M82 cgb $&s1_xx2_m82_cgb
let s1_xx2_m82_cdg = @m.x1.xdut.xx2_m82.msky130_fd_pr__pfet_01v8[cdg]
echo OPV XX2_M82 cdg $&s1_xx2_m82_cdg
let s1_xx2_m82_cdd = @m.x1.xdut.xx2_m82.msky130_fd_pr__pfet_01v8[cdd]
echo OPV XX2_M82 cdd $&s1_xx2_m82_cdd
let s1_xx2_m82_cds = @m.x1.xdut.xx2_m82.msky130_fd_pr__pfet_01v8[cds]
echo OPV XX2_M82 cds $&s1_xx2_m82_cds
let s1_xx2_m82_cdb = @m.x1.xdut.xx2_m82.msky130_fd_pr__pfet_01v8[cdb]
echo OPV XX2_M82 cdb $&s1_xx2_m82_cdb
let s1_xx2_m82_csg = @m.x1.xdut.xx2_m82.msky130_fd_pr__pfet_01v8[csg]
echo OPV XX2_M82 csg $&s1_xx2_m82_csg
let s1_xx2_m82_csd = @m.x1.xdut.xx2_m82.msky130_fd_pr__pfet_01v8[csd]
echo OPV XX2_M82 csd $&s1_xx2_m82_csd
let s1_xx2_m82_css = @m.x1.xdut.xx2_m82.msky130_fd_pr__pfet_01v8[css]
echo OPV XX2_M82 css $&s1_xx2_m82_css
let s1_xx2_m82_csb = @m.x1.xdut.xx2_m82.msky130_fd_pr__pfet_01v8[csb]
echo OPV XX2_M82 csb $&s1_xx2_m82_csb
let s1_xx2_m82_cbg = @m.x1.xdut.xx2_m82.msky130_fd_pr__pfet_01v8[cbg]
echo OPV XX2_M82 cbg $&s1_xx2_m82_cbg
let s1_xx2_m82_cbd = @m.x1.xdut.xx2_m82.msky130_fd_pr__pfet_01v8[cbd]
echo OPV XX2_M82 cbd $&s1_xx2_m82_cbd
let s1_xx2_m82_cbs = @m.x1.xdut.xx2_m82.msky130_fd_pr__pfet_01v8[cbs]
echo OPV XX2_M82 cbs $&s1_xx2_m82_cbs
let s1_xx2_m82_cbb = @m.x1.xdut.xx2_m82.msky130_fd_pr__pfet_01v8[cbb]
echo OPV XX2_M82 cbb $&s1_xx2_m82_cbb
let s1_xx2_m82_capbd = @m.x1.xdut.xx2_m82.msky130_fd_pr__pfet_01v8[capbd]
echo OPV XX2_M82 capbd $&s1_xx2_m82_capbd
let s1_xx2_m82_capbs = @m.x1.xdut.xx2_m82.msky130_fd_pr__pfet_01v8[capbs]
echo OPV XX2_M82 capbs $&s1_xx2_m82_capbs
let s1_xx2_m82_cgso = @m.x1.xdut.xx2_m82.msky130_fd_pr__pfet_01v8[cgso]
echo OPV XX2_M82 cgso $&s1_xx2_m82_cgso
let s1_xx2_m82_cgdo = @m.x1.xdut.xx2_m82.msky130_fd_pr__pfet_01v8[cgdo]
echo OPV XX2_M82 cgdo $&s1_xx2_m82_cgdo
let s1_xx2_m82_cgbo = @m.x1.xdut.xx2_m82.msky130_fd_pr__pfet_01v8[cgbo]
echo OPV XX2_M82 cgbo $&s1_xx2_m82_cgbo
let s1_xx2_m82_weff = @m.x1.xdut.xx2_m82.msky130_fd_pr__pfet_01v8[weff]
echo OPV XX2_M82 weff $&s1_xx2_m82_weff
let s1_xx2_m82_leff = @m.x1.xdut.xx2_m82.msky130_fd_pr__pfet_01v8[leff]
echo OPV XX2_M82 leff $&s1_xx2_m82_leff
let s1_xx2_m83_id = @m.x1.xdut.xx2_m83.msky130_fd_pr__pfet_01v8[id]
echo OPV XX2_M83 id $&s1_xx2_m83_id
let s1_xx2_m83_vgs = @m.x1.xdut.xx2_m83.msky130_fd_pr__pfet_01v8[vgs]
echo OPV XX2_M83 vgs $&s1_xx2_m83_vgs
let s1_xx2_m83_vds = @m.x1.xdut.xx2_m83.msky130_fd_pr__pfet_01v8[vds]
echo OPV XX2_M83 vds $&s1_xx2_m83_vds
let s1_xx2_m83_vbs = @m.x1.xdut.xx2_m83.msky130_fd_pr__pfet_01v8[vbs]
echo OPV XX2_M83 vbs $&s1_xx2_m83_vbs
let s1_xx2_m83_vth = @m.x1.xdut.xx2_m83.msky130_fd_pr__pfet_01v8[vth]
echo OPV XX2_M83 vth $&s1_xx2_m83_vth
let s1_xx2_m83_vdsat = @m.x1.xdut.xx2_m83.msky130_fd_pr__pfet_01v8[vdsat]
echo OPV XX2_M83 vdsat $&s1_xx2_m83_vdsat
let s1_xx2_m83_gm = @m.x1.xdut.xx2_m83.msky130_fd_pr__pfet_01v8[gm]
echo OPV XX2_M83 gm $&s1_xx2_m83_gm
let s1_xx2_m83_gds = @m.x1.xdut.xx2_m83.msky130_fd_pr__pfet_01v8[gds]
echo OPV XX2_M83 gds $&s1_xx2_m83_gds
let s1_xx2_m83_gmbs = @m.x1.xdut.xx2_m83.msky130_fd_pr__pfet_01v8[gmbs]
echo OPV XX2_M83 gmbs $&s1_xx2_m83_gmbs
let s1_xx2_m83_cgg = @m.x1.xdut.xx2_m83.msky130_fd_pr__pfet_01v8[cgg]
echo OPV XX2_M83 cgg $&s1_xx2_m83_cgg
let s1_xx2_m83_cgd = @m.x1.xdut.xx2_m83.msky130_fd_pr__pfet_01v8[cgd]
echo OPV XX2_M83 cgd $&s1_xx2_m83_cgd
let s1_xx2_m83_cgs = @m.x1.xdut.xx2_m83.msky130_fd_pr__pfet_01v8[cgs]
echo OPV XX2_M83 cgs $&s1_xx2_m83_cgs
let s1_xx2_m83_cgb = @m.x1.xdut.xx2_m83.msky130_fd_pr__pfet_01v8[cgb]
echo OPV XX2_M83 cgb $&s1_xx2_m83_cgb
let s1_xx2_m83_cdg = @m.x1.xdut.xx2_m83.msky130_fd_pr__pfet_01v8[cdg]
echo OPV XX2_M83 cdg $&s1_xx2_m83_cdg
let s1_xx2_m83_cdd = @m.x1.xdut.xx2_m83.msky130_fd_pr__pfet_01v8[cdd]
echo OPV XX2_M83 cdd $&s1_xx2_m83_cdd
let s1_xx2_m83_cds = @m.x1.xdut.xx2_m83.msky130_fd_pr__pfet_01v8[cds]
echo OPV XX2_M83 cds $&s1_xx2_m83_cds
let s1_xx2_m83_cdb = @m.x1.xdut.xx2_m83.msky130_fd_pr__pfet_01v8[cdb]
echo OPV XX2_M83 cdb $&s1_xx2_m83_cdb
let s1_xx2_m83_csg = @m.x1.xdut.xx2_m83.msky130_fd_pr__pfet_01v8[csg]
echo OPV XX2_M83 csg $&s1_xx2_m83_csg
let s1_xx2_m83_csd = @m.x1.xdut.xx2_m83.msky130_fd_pr__pfet_01v8[csd]
echo OPV XX2_M83 csd $&s1_xx2_m83_csd
let s1_xx2_m83_css = @m.x1.xdut.xx2_m83.msky130_fd_pr__pfet_01v8[css]
echo OPV XX2_M83 css $&s1_xx2_m83_css
let s1_xx2_m83_csb = @m.x1.xdut.xx2_m83.msky130_fd_pr__pfet_01v8[csb]
echo OPV XX2_M83 csb $&s1_xx2_m83_csb
let s1_xx2_m83_cbg = @m.x1.xdut.xx2_m83.msky130_fd_pr__pfet_01v8[cbg]
echo OPV XX2_M83 cbg $&s1_xx2_m83_cbg
let s1_xx2_m83_cbd = @m.x1.xdut.xx2_m83.msky130_fd_pr__pfet_01v8[cbd]
echo OPV XX2_M83 cbd $&s1_xx2_m83_cbd
let s1_xx2_m83_cbs = @m.x1.xdut.xx2_m83.msky130_fd_pr__pfet_01v8[cbs]
echo OPV XX2_M83 cbs $&s1_xx2_m83_cbs
let s1_xx2_m83_cbb = @m.x1.xdut.xx2_m83.msky130_fd_pr__pfet_01v8[cbb]
echo OPV XX2_M83 cbb $&s1_xx2_m83_cbb
let s1_xx2_m83_capbd = @m.x1.xdut.xx2_m83.msky130_fd_pr__pfet_01v8[capbd]
echo OPV XX2_M83 capbd $&s1_xx2_m83_capbd
let s1_xx2_m83_capbs = @m.x1.xdut.xx2_m83.msky130_fd_pr__pfet_01v8[capbs]
echo OPV XX2_M83 capbs $&s1_xx2_m83_capbs
let s1_xx2_m83_cgso = @m.x1.xdut.xx2_m83.msky130_fd_pr__pfet_01v8[cgso]
echo OPV XX2_M83 cgso $&s1_xx2_m83_cgso
let s1_xx2_m83_cgdo = @m.x1.xdut.xx2_m83.msky130_fd_pr__pfet_01v8[cgdo]
echo OPV XX2_M83 cgdo $&s1_xx2_m83_cgdo
let s1_xx2_m83_cgbo = @m.x1.xdut.xx2_m83.msky130_fd_pr__pfet_01v8[cgbo]
echo OPV XX2_M83 cgbo $&s1_xx2_m83_cgbo
let s1_xx2_m83_weff = @m.x1.xdut.xx2_m83.msky130_fd_pr__pfet_01v8[weff]
echo OPV XX2_M83 weff $&s1_xx2_m83_weff
let s1_xx2_m83_leff = @m.x1.xdut.xx2_m83.msky130_fd_pr__pfet_01v8[leff]
echo OPV XX2_M83 leff $&s1_xx2_m83_leff
let s1_xx2_m55_id = @m.x1.xdut.xx2_m55.msky130_fd_pr__pfet_01v8[id]
echo OPV XX2_M55 id $&s1_xx2_m55_id
let s1_xx2_m55_vgs = @m.x1.xdut.xx2_m55.msky130_fd_pr__pfet_01v8[vgs]
echo OPV XX2_M55 vgs $&s1_xx2_m55_vgs
let s1_xx2_m55_vds = @m.x1.xdut.xx2_m55.msky130_fd_pr__pfet_01v8[vds]
echo OPV XX2_M55 vds $&s1_xx2_m55_vds
let s1_xx2_m55_vbs = @m.x1.xdut.xx2_m55.msky130_fd_pr__pfet_01v8[vbs]
echo OPV XX2_M55 vbs $&s1_xx2_m55_vbs
let s1_xx2_m55_vth = @m.x1.xdut.xx2_m55.msky130_fd_pr__pfet_01v8[vth]
echo OPV XX2_M55 vth $&s1_xx2_m55_vth
let s1_xx2_m55_vdsat = @m.x1.xdut.xx2_m55.msky130_fd_pr__pfet_01v8[vdsat]
echo OPV XX2_M55 vdsat $&s1_xx2_m55_vdsat
let s1_xx2_m55_gm = @m.x1.xdut.xx2_m55.msky130_fd_pr__pfet_01v8[gm]
echo OPV XX2_M55 gm $&s1_xx2_m55_gm
let s1_xx2_m55_gds = @m.x1.xdut.xx2_m55.msky130_fd_pr__pfet_01v8[gds]
echo OPV XX2_M55 gds $&s1_xx2_m55_gds
let s1_xx2_m55_gmbs = @m.x1.xdut.xx2_m55.msky130_fd_pr__pfet_01v8[gmbs]
echo OPV XX2_M55 gmbs $&s1_xx2_m55_gmbs
let s1_xx2_m55_cgg = @m.x1.xdut.xx2_m55.msky130_fd_pr__pfet_01v8[cgg]
echo OPV XX2_M55 cgg $&s1_xx2_m55_cgg
let s1_xx2_m55_cgd = @m.x1.xdut.xx2_m55.msky130_fd_pr__pfet_01v8[cgd]
echo OPV XX2_M55 cgd $&s1_xx2_m55_cgd
let s1_xx2_m55_cgs = @m.x1.xdut.xx2_m55.msky130_fd_pr__pfet_01v8[cgs]
echo OPV XX2_M55 cgs $&s1_xx2_m55_cgs
let s1_xx2_m55_cgb = @m.x1.xdut.xx2_m55.msky130_fd_pr__pfet_01v8[cgb]
echo OPV XX2_M55 cgb $&s1_xx2_m55_cgb
let s1_xx2_m55_cdg = @m.x1.xdut.xx2_m55.msky130_fd_pr__pfet_01v8[cdg]
echo OPV XX2_M55 cdg $&s1_xx2_m55_cdg
let s1_xx2_m55_cdd = @m.x1.xdut.xx2_m55.msky130_fd_pr__pfet_01v8[cdd]
echo OPV XX2_M55 cdd $&s1_xx2_m55_cdd
let s1_xx2_m55_cds = @m.x1.xdut.xx2_m55.msky130_fd_pr__pfet_01v8[cds]
echo OPV XX2_M55 cds $&s1_xx2_m55_cds
let s1_xx2_m55_cdb = @m.x1.xdut.xx2_m55.msky130_fd_pr__pfet_01v8[cdb]
echo OPV XX2_M55 cdb $&s1_xx2_m55_cdb
let s1_xx2_m55_csg = @m.x1.xdut.xx2_m55.msky130_fd_pr__pfet_01v8[csg]
echo OPV XX2_M55 csg $&s1_xx2_m55_csg
let s1_xx2_m55_csd = @m.x1.xdut.xx2_m55.msky130_fd_pr__pfet_01v8[csd]
echo OPV XX2_M55 csd $&s1_xx2_m55_csd
let s1_xx2_m55_css = @m.x1.xdut.xx2_m55.msky130_fd_pr__pfet_01v8[css]
echo OPV XX2_M55 css $&s1_xx2_m55_css
let s1_xx2_m55_csb = @m.x1.xdut.xx2_m55.msky130_fd_pr__pfet_01v8[csb]
echo OPV XX2_M55 csb $&s1_xx2_m55_csb
let s1_xx2_m55_cbg = @m.x1.xdut.xx2_m55.msky130_fd_pr__pfet_01v8[cbg]
echo OPV XX2_M55 cbg $&s1_xx2_m55_cbg
let s1_xx2_m55_cbd = @m.x1.xdut.xx2_m55.msky130_fd_pr__pfet_01v8[cbd]
echo OPV XX2_M55 cbd $&s1_xx2_m55_cbd
let s1_xx2_m55_cbs = @m.x1.xdut.xx2_m55.msky130_fd_pr__pfet_01v8[cbs]
echo OPV XX2_M55 cbs $&s1_xx2_m55_cbs
let s1_xx2_m55_cbb = @m.x1.xdut.xx2_m55.msky130_fd_pr__pfet_01v8[cbb]
echo OPV XX2_M55 cbb $&s1_xx2_m55_cbb
let s1_xx2_m55_capbd = @m.x1.xdut.xx2_m55.msky130_fd_pr__pfet_01v8[capbd]
echo OPV XX2_M55 capbd $&s1_xx2_m55_capbd
let s1_xx2_m55_capbs = @m.x1.xdut.xx2_m55.msky130_fd_pr__pfet_01v8[capbs]
echo OPV XX2_M55 capbs $&s1_xx2_m55_capbs
let s1_xx2_m55_cgso = @m.x1.xdut.xx2_m55.msky130_fd_pr__pfet_01v8[cgso]
echo OPV XX2_M55 cgso $&s1_xx2_m55_cgso
let s1_xx2_m55_cgdo = @m.x1.xdut.xx2_m55.msky130_fd_pr__pfet_01v8[cgdo]
echo OPV XX2_M55 cgdo $&s1_xx2_m55_cgdo
let s1_xx2_m55_cgbo = @m.x1.xdut.xx2_m55.msky130_fd_pr__pfet_01v8[cgbo]
echo OPV XX2_M55 cgbo $&s1_xx2_m55_cgbo
let s1_xx2_m55_weff = @m.x1.xdut.xx2_m55.msky130_fd_pr__pfet_01v8[weff]
echo OPV XX2_M55 weff $&s1_xx2_m55_weff
let s1_xx2_m55_leff = @m.x1.xdut.xx2_m55.msky130_fd_pr__pfet_01v8[leff]
echo OPV XX2_M55 leff $&s1_xx2_m55_leff
let s1_xx2_m56_id = @m.x1.xdut.xx2_m56.msky130_fd_pr__pfet_01v8[id]
echo OPV XX2_M56 id $&s1_xx2_m56_id
let s1_xx2_m56_vgs = @m.x1.xdut.xx2_m56.msky130_fd_pr__pfet_01v8[vgs]
echo OPV XX2_M56 vgs $&s1_xx2_m56_vgs
let s1_xx2_m56_vds = @m.x1.xdut.xx2_m56.msky130_fd_pr__pfet_01v8[vds]
echo OPV XX2_M56 vds $&s1_xx2_m56_vds
let s1_xx2_m56_vbs = @m.x1.xdut.xx2_m56.msky130_fd_pr__pfet_01v8[vbs]
echo OPV XX2_M56 vbs $&s1_xx2_m56_vbs
let s1_xx2_m56_vth = @m.x1.xdut.xx2_m56.msky130_fd_pr__pfet_01v8[vth]
echo OPV XX2_M56 vth $&s1_xx2_m56_vth
let s1_xx2_m56_vdsat = @m.x1.xdut.xx2_m56.msky130_fd_pr__pfet_01v8[vdsat]
echo OPV XX2_M56 vdsat $&s1_xx2_m56_vdsat
let s1_xx2_m56_gm = @m.x1.xdut.xx2_m56.msky130_fd_pr__pfet_01v8[gm]
echo OPV XX2_M56 gm $&s1_xx2_m56_gm
let s1_xx2_m56_gds = @m.x1.xdut.xx2_m56.msky130_fd_pr__pfet_01v8[gds]
echo OPV XX2_M56 gds $&s1_xx2_m56_gds
let s1_xx2_m56_gmbs = @m.x1.xdut.xx2_m56.msky130_fd_pr__pfet_01v8[gmbs]
echo OPV XX2_M56 gmbs $&s1_xx2_m56_gmbs
let s1_xx2_m56_cgg = @m.x1.xdut.xx2_m56.msky130_fd_pr__pfet_01v8[cgg]
echo OPV XX2_M56 cgg $&s1_xx2_m56_cgg
let s1_xx2_m56_cgd = @m.x1.xdut.xx2_m56.msky130_fd_pr__pfet_01v8[cgd]
echo OPV XX2_M56 cgd $&s1_xx2_m56_cgd
let s1_xx2_m56_cgs = @m.x1.xdut.xx2_m56.msky130_fd_pr__pfet_01v8[cgs]
echo OPV XX2_M56 cgs $&s1_xx2_m56_cgs
let s1_xx2_m56_cgb = @m.x1.xdut.xx2_m56.msky130_fd_pr__pfet_01v8[cgb]
echo OPV XX2_M56 cgb $&s1_xx2_m56_cgb
let s1_xx2_m56_cdg = @m.x1.xdut.xx2_m56.msky130_fd_pr__pfet_01v8[cdg]
echo OPV XX2_M56 cdg $&s1_xx2_m56_cdg
let s1_xx2_m56_cdd = @m.x1.xdut.xx2_m56.msky130_fd_pr__pfet_01v8[cdd]
echo OPV XX2_M56 cdd $&s1_xx2_m56_cdd
let s1_xx2_m56_cds = @m.x1.xdut.xx2_m56.msky130_fd_pr__pfet_01v8[cds]
echo OPV XX2_M56 cds $&s1_xx2_m56_cds
let s1_xx2_m56_cdb = @m.x1.xdut.xx2_m56.msky130_fd_pr__pfet_01v8[cdb]
echo OPV XX2_M56 cdb $&s1_xx2_m56_cdb
let s1_xx2_m56_csg = @m.x1.xdut.xx2_m56.msky130_fd_pr__pfet_01v8[csg]
echo OPV XX2_M56 csg $&s1_xx2_m56_csg
let s1_xx2_m56_csd = @m.x1.xdut.xx2_m56.msky130_fd_pr__pfet_01v8[csd]
echo OPV XX2_M56 csd $&s1_xx2_m56_csd
let s1_xx2_m56_css = @m.x1.xdut.xx2_m56.msky130_fd_pr__pfet_01v8[css]
echo OPV XX2_M56 css $&s1_xx2_m56_css
let s1_xx2_m56_csb = @m.x1.xdut.xx2_m56.msky130_fd_pr__pfet_01v8[csb]
echo OPV XX2_M56 csb $&s1_xx2_m56_csb
let s1_xx2_m56_cbg = @m.x1.xdut.xx2_m56.msky130_fd_pr__pfet_01v8[cbg]
echo OPV XX2_M56 cbg $&s1_xx2_m56_cbg
let s1_xx2_m56_cbd = @m.x1.xdut.xx2_m56.msky130_fd_pr__pfet_01v8[cbd]
echo OPV XX2_M56 cbd $&s1_xx2_m56_cbd
let s1_xx2_m56_cbs = @m.x1.xdut.xx2_m56.msky130_fd_pr__pfet_01v8[cbs]
echo OPV XX2_M56 cbs $&s1_xx2_m56_cbs
let s1_xx2_m56_cbb = @m.x1.xdut.xx2_m56.msky130_fd_pr__pfet_01v8[cbb]
echo OPV XX2_M56 cbb $&s1_xx2_m56_cbb
let s1_xx2_m56_capbd = @m.x1.xdut.xx2_m56.msky130_fd_pr__pfet_01v8[capbd]
echo OPV XX2_M56 capbd $&s1_xx2_m56_capbd
let s1_xx2_m56_capbs = @m.x1.xdut.xx2_m56.msky130_fd_pr__pfet_01v8[capbs]
echo OPV XX2_M56 capbs $&s1_xx2_m56_capbs
let s1_xx2_m56_cgso = @m.x1.xdut.xx2_m56.msky130_fd_pr__pfet_01v8[cgso]
echo OPV XX2_M56 cgso $&s1_xx2_m56_cgso
let s1_xx2_m56_cgdo = @m.x1.xdut.xx2_m56.msky130_fd_pr__pfet_01v8[cgdo]
echo OPV XX2_M56 cgdo $&s1_xx2_m56_cgdo
let s1_xx2_m56_cgbo = @m.x1.xdut.xx2_m56.msky130_fd_pr__pfet_01v8[cgbo]
echo OPV XX2_M56 cgbo $&s1_xx2_m56_cgbo
let s1_xx2_m56_weff = @m.x1.xdut.xx2_m56.msky130_fd_pr__pfet_01v8[weff]
echo OPV XX2_M56 weff $&s1_xx2_m56_weff
let s1_xx2_m56_leff = @m.x1.xdut.xx2_m56.msky130_fd_pr__pfet_01v8[leff]
echo OPV XX2_M56 leff $&s1_xx2_m56_leff
let s1_xx2_m61_id = @m.x1.xdut.xx2_m61.msky130_fd_pr__pfet_01v8[id]
echo OPV XX2_M61 id $&s1_xx2_m61_id
let s1_xx2_m61_vgs = @m.x1.xdut.xx2_m61.msky130_fd_pr__pfet_01v8[vgs]
echo OPV XX2_M61 vgs $&s1_xx2_m61_vgs
let s1_xx2_m61_vds = @m.x1.xdut.xx2_m61.msky130_fd_pr__pfet_01v8[vds]
echo OPV XX2_M61 vds $&s1_xx2_m61_vds
let s1_xx2_m61_vbs = @m.x1.xdut.xx2_m61.msky130_fd_pr__pfet_01v8[vbs]
echo OPV XX2_M61 vbs $&s1_xx2_m61_vbs
let s1_xx2_m61_vth = @m.x1.xdut.xx2_m61.msky130_fd_pr__pfet_01v8[vth]
echo OPV XX2_M61 vth $&s1_xx2_m61_vth
let s1_xx2_m61_vdsat = @m.x1.xdut.xx2_m61.msky130_fd_pr__pfet_01v8[vdsat]
echo OPV XX2_M61 vdsat $&s1_xx2_m61_vdsat
let s1_xx2_m61_gm = @m.x1.xdut.xx2_m61.msky130_fd_pr__pfet_01v8[gm]
echo OPV XX2_M61 gm $&s1_xx2_m61_gm
let s1_xx2_m61_gds = @m.x1.xdut.xx2_m61.msky130_fd_pr__pfet_01v8[gds]
echo OPV XX2_M61 gds $&s1_xx2_m61_gds
let s1_xx2_m61_gmbs = @m.x1.xdut.xx2_m61.msky130_fd_pr__pfet_01v8[gmbs]
echo OPV XX2_M61 gmbs $&s1_xx2_m61_gmbs
let s1_xx2_m61_cgg = @m.x1.xdut.xx2_m61.msky130_fd_pr__pfet_01v8[cgg]
echo OPV XX2_M61 cgg $&s1_xx2_m61_cgg
let s1_xx2_m61_cgd = @m.x1.xdut.xx2_m61.msky130_fd_pr__pfet_01v8[cgd]
echo OPV XX2_M61 cgd $&s1_xx2_m61_cgd
let s1_xx2_m61_cgs = @m.x1.xdut.xx2_m61.msky130_fd_pr__pfet_01v8[cgs]
echo OPV XX2_M61 cgs $&s1_xx2_m61_cgs
let s1_xx2_m61_cgb = @m.x1.xdut.xx2_m61.msky130_fd_pr__pfet_01v8[cgb]
echo OPV XX2_M61 cgb $&s1_xx2_m61_cgb
let s1_xx2_m61_cdg = @m.x1.xdut.xx2_m61.msky130_fd_pr__pfet_01v8[cdg]
echo OPV XX2_M61 cdg $&s1_xx2_m61_cdg
let s1_xx2_m61_cdd = @m.x1.xdut.xx2_m61.msky130_fd_pr__pfet_01v8[cdd]
echo OPV XX2_M61 cdd $&s1_xx2_m61_cdd
let s1_xx2_m61_cds = @m.x1.xdut.xx2_m61.msky130_fd_pr__pfet_01v8[cds]
echo OPV XX2_M61 cds $&s1_xx2_m61_cds
let s1_xx2_m61_cdb = @m.x1.xdut.xx2_m61.msky130_fd_pr__pfet_01v8[cdb]
echo OPV XX2_M61 cdb $&s1_xx2_m61_cdb
let s1_xx2_m61_csg = @m.x1.xdut.xx2_m61.msky130_fd_pr__pfet_01v8[csg]
echo OPV XX2_M61 csg $&s1_xx2_m61_csg
let s1_xx2_m61_csd = @m.x1.xdut.xx2_m61.msky130_fd_pr__pfet_01v8[csd]
echo OPV XX2_M61 csd $&s1_xx2_m61_csd
let s1_xx2_m61_css = @m.x1.xdut.xx2_m61.msky130_fd_pr__pfet_01v8[css]
echo OPV XX2_M61 css $&s1_xx2_m61_css
let s1_xx2_m61_csb = @m.x1.xdut.xx2_m61.msky130_fd_pr__pfet_01v8[csb]
echo OPV XX2_M61 csb $&s1_xx2_m61_csb
let s1_xx2_m61_cbg = @m.x1.xdut.xx2_m61.msky130_fd_pr__pfet_01v8[cbg]
echo OPV XX2_M61 cbg $&s1_xx2_m61_cbg
let s1_xx2_m61_cbd = @m.x1.xdut.xx2_m61.msky130_fd_pr__pfet_01v8[cbd]
echo OPV XX2_M61 cbd $&s1_xx2_m61_cbd
let s1_xx2_m61_cbs = @m.x1.xdut.xx2_m61.msky130_fd_pr__pfet_01v8[cbs]
echo OPV XX2_M61 cbs $&s1_xx2_m61_cbs
let s1_xx2_m61_cbb = @m.x1.xdut.xx2_m61.msky130_fd_pr__pfet_01v8[cbb]
echo OPV XX2_M61 cbb $&s1_xx2_m61_cbb
let s1_xx2_m61_capbd = @m.x1.xdut.xx2_m61.msky130_fd_pr__pfet_01v8[capbd]
echo OPV XX2_M61 capbd $&s1_xx2_m61_capbd
let s1_xx2_m61_capbs = @m.x1.xdut.xx2_m61.msky130_fd_pr__pfet_01v8[capbs]
echo OPV XX2_M61 capbs $&s1_xx2_m61_capbs
let s1_xx2_m61_cgso = @m.x1.xdut.xx2_m61.msky130_fd_pr__pfet_01v8[cgso]
echo OPV XX2_M61 cgso $&s1_xx2_m61_cgso
let s1_xx2_m61_cgdo = @m.x1.xdut.xx2_m61.msky130_fd_pr__pfet_01v8[cgdo]
echo OPV XX2_M61 cgdo $&s1_xx2_m61_cgdo
let s1_xx2_m61_cgbo = @m.x1.xdut.xx2_m61.msky130_fd_pr__pfet_01v8[cgbo]
echo OPV XX2_M61 cgbo $&s1_xx2_m61_cgbo
let s1_xx2_m61_weff = @m.x1.xdut.xx2_m61.msky130_fd_pr__pfet_01v8[weff]
echo OPV XX2_M61 weff $&s1_xx2_m61_weff
let s1_xx2_m61_leff = @m.x1.xdut.xx2_m61.msky130_fd_pr__pfet_01v8[leff]
echo OPV XX2_M61 leff $&s1_xx2_m61_leff
let s1_xx2_m62_id = @m.x1.xdut.xx2_m62.msky130_fd_pr__pfet_01v8[id]
echo OPV XX2_M62 id $&s1_xx2_m62_id
let s1_xx2_m62_vgs = @m.x1.xdut.xx2_m62.msky130_fd_pr__pfet_01v8[vgs]
echo OPV XX2_M62 vgs $&s1_xx2_m62_vgs
let s1_xx2_m62_vds = @m.x1.xdut.xx2_m62.msky130_fd_pr__pfet_01v8[vds]
echo OPV XX2_M62 vds $&s1_xx2_m62_vds
let s1_xx2_m62_vbs = @m.x1.xdut.xx2_m62.msky130_fd_pr__pfet_01v8[vbs]
echo OPV XX2_M62 vbs $&s1_xx2_m62_vbs
let s1_xx2_m62_vth = @m.x1.xdut.xx2_m62.msky130_fd_pr__pfet_01v8[vth]
echo OPV XX2_M62 vth $&s1_xx2_m62_vth
let s1_xx2_m62_vdsat = @m.x1.xdut.xx2_m62.msky130_fd_pr__pfet_01v8[vdsat]
echo OPV XX2_M62 vdsat $&s1_xx2_m62_vdsat
let s1_xx2_m62_gm = @m.x1.xdut.xx2_m62.msky130_fd_pr__pfet_01v8[gm]
echo OPV XX2_M62 gm $&s1_xx2_m62_gm
let s1_xx2_m62_gds = @m.x1.xdut.xx2_m62.msky130_fd_pr__pfet_01v8[gds]
echo OPV XX2_M62 gds $&s1_xx2_m62_gds
let s1_xx2_m62_gmbs = @m.x1.xdut.xx2_m62.msky130_fd_pr__pfet_01v8[gmbs]
echo OPV XX2_M62 gmbs $&s1_xx2_m62_gmbs
let s1_xx2_m62_cgg = @m.x1.xdut.xx2_m62.msky130_fd_pr__pfet_01v8[cgg]
echo OPV XX2_M62 cgg $&s1_xx2_m62_cgg
let s1_xx2_m62_cgd = @m.x1.xdut.xx2_m62.msky130_fd_pr__pfet_01v8[cgd]
echo OPV XX2_M62 cgd $&s1_xx2_m62_cgd
let s1_xx2_m62_cgs = @m.x1.xdut.xx2_m62.msky130_fd_pr__pfet_01v8[cgs]
echo OPV XX2_M62 cgs $&s1_xx2_m62_cgs
let s1_xx2_m62_cgb = @m.x1.xdut.xx2_m62.msky130_fd_pr__pfet_01v8[cgb]
echo OPV XX2_M62 cgb $&s1_xx2_m62_cgb
let s1_xx2_m62_cdg = @m.x1.xdut.xx2_m62.msky130_fd_pr__pfet_01v8[cdg]
echo OPV XX2_M62 cdg $&s1_xx2_m62_cdg
let s1_xx2_m62_cdd = @m.x1.xdut.xx2_m62.msky130_fd_pr__pfet_01v8[cdd]
echo OPV XX2_M62 cdd $&s1_xx2_m62_cdd
let s1_xx2_m62_cds = @m.x1.xdut.xx2_m62.msky130_fd_pr__pfet_01v8[cds]
echo OPV XX2_M62 cds $&s1_xx2_m62_cds
let s1_xx2_m62_cdb = @m.x1.xdut.xx2_m62.msky130_fd_pr__pfet_01v8[cdb]
echo OPV XX2_M62 cdb $&s1_xx2_m62_cdb
let s1_xx2_m62_csg = @m.x1.xdut.xx2_m62.msky130_fd_pr__pfet_01v8[csg]
echo OPV XX2_M62 csg $&s1_xx2_m62_csg
let s1_xx2_m62_csd = @m.x1.xdut.xx2_m62.msky130_fd_pr__pfet_01v8[csd]
echo OPV XX2_M62 csd $&s1_xx2_m62_csd
let s1_xx2_m62_css = @m.x1.xdut.xx2_m62.msky130_fd_pr__pfet_01v8[css]
echo OPV XX2_M62 css $&s1_xx2_m62_css
let s1_xx2_m62_csb = @m.x1.xdut.xx2_m62.msky130_fd_pr__pfet_01v8[csb]
echo OPV XX2_M62 csb $&s1_xx2_m62_csb
let s1_xx2_m62_cbg = @m.x1.xdut.xx2_m62.msky130_fd_pr__pfet_01v8[cbg]
echo OPV XX2_M62 cbg $&s1_xx2_m62_cbg
let s1_xx2_m62_cbd = @m.x1.xdut.xx2_m62.msky130_fd_pr__pfet_01v8[cbd]
echo OPV XX2_M62 cbd $&s1_xx2_m62_cbd
let s1_xx2_m62_cbs = @m.x1.xdut.xx2_m62.msky130_fd_pr__pfet_01v8[cbs]
echo OPV XX2_M62 cbs $&s1_xx2_m62_cbs
let s1_xx2_m62_cbb = @m.x1.xdut.xx2_m62.msky130_fd_pr__pfet_01v8[cbb]
echo OPV XX2_M62 cbb $&s1_xx2_m62_cbb
let s1_xx2_m62_capbd = @m.x1.xdut.xx2_m62.msky130_fd_pr__pfet_01v8[capbd]
echo OPV XX2_M62 capbd $&s1_xx2_m62_capbd
let s1_xx2_m62_capbs = @m.x1.xdut.xx2_m62.msky130_fd_pr__pfet_01v8[capbs]
echo OPV XX2_M62 capbs $&s1_xx2_m62_capbs
let s1_xx2_m62_cgso = @m.x1.xdut.xx2_m62.msky130_fd_pr__pfet_01v8[cgso]
echo OPV XX2_M62 cgso $&s1_xx2_m62_cgso
let s1_xx2_m62_cgdo = @m.x1.xdut.xx2_m62.msky130_fd_pr__pfet_01v8[cgdo]
echo OPV XX2_M62 cgdo $&s1_xx2_m62_cgdo
let s1_xx2_m62_cgbo = @m.x1.xdut.xx2_m62.msky130_fd_pr__pfet_01v8[cgbo]
echo OPV XX2_M62 cgbo $&s1_xx2_m62_cgbo
let s1_xx2_m62_weff = @m.x1.xdut.xx2_m62.msky130_fd_pr__pfet_01v8[weff]
echo OPV XX2_M62 weff $&s1_xx2_m62_weff
let s1_xx2_m62_leff = @m.x1.xdut.xx2_m62.msky130_fd_pr__pfet_01v8[leff]
echo OPV XX2_M62 leff $&s1_xx2_m62_leff
let s1_xx2_m40_id = @m.x1.xdut.xx2_m40.msky130_fd_pr__nfet_01v8[id]
echo OPV XX2_M40 id $&s1_xx2_m40_id
let s1_xx2_m40_vgs = @m.x1.xdut.xx2_m40.msky130_fd_pr__nfet_01v8[vgs]
echo OPV XX2_M40 vgs $&s1_xx2_m40_vgs
let s1_xx2_m40_vds = @m.x1.xdut.xx2_m40.msky130_fd_pr__nfet_01v8[vds]
echo OPV XX2_M40 vds $&s1_xx2_m40_vds
let s1_xx2_m40_vbs = @m.x1.xdut.xx2_m40.msky130_fd_pr__nfet_01v8[vbs]
echo OPV XX2_M40 vbs $&s1_xx2_m40_vbs
let s1_xx2_m40_vth = @m.x1.xdut.xx2_m40.msky130_fd_pr__nfet_01v8[vth]
echo OPV XX2_M40 vth $&s1_xx2_m40_vth
let s1_xx2_m40_vdsat = @m.x1.xdut.xx2_m40.msky130_fd_pr__nfet_01v8[vdsat]
echo OPV XX2_M40 vdsat $&s1_xx2_m40_vdsat
let s1_xx2_m40_gm = @m.x1.xdut.xx2_m40.msky130_fd_pr__nfet_01v8[gm]
echo OPV XX2_M40 gm $&s1_xx2_m40_gm
let s1_xx2_m40_gds = @m.x1.xdut.xx2_m40.msky130_fd_pr__nfet_01v8[gds]
echo OPV XX2_M40 gds $&s1_xx2_m40_gds
let s1_xx2_m40_gmbs = @m.x1.xdut.xx2_m40.msky130_fd_pr__nfet_01v8[gmbs]
echo OPV XX2_M40 gmbs $&s1_xx2_m40_gmbs
let s1_xx2_m40_cgg = @m.x1.xdut.xx2_m40.msky130_fd_pr__nfet_01v8[cgg]
echo OPV XX2_M40 cgg $&s1_xx2_m40_cgg
let s1_xx2_m40_cgd = @m.x1.xdut.xx2_m40.msky130_fd_pr__nfet_01v8[cgd]
echo OPV XX2_M40 cgd $&s1_xx2_m40_cgd
let s1_xx2_m40_cgs = @m.x1.xdut.xx2_m40.msky130_fd_pr__nfet_01v8[cgs]
echo OPV XX2_M40 cgs $&s1_xx2_m40_cgs
let s1_xx2_m40_cgb = @m.x1.xdut.xx2_m40.msky130_fd_pr__nfet_01v8[cgb]
echo OPV XX2_M40 cgb $&s1_xx2_m40_cgb
let s1_xx2_m40_cdg = @m.x1.xdut.xx2_m40.msky130_fd_pr__nfet_01v8[cdg]
echo OPV XX2_M40 cdg $&s1_xx2_m40_cdg
let s1_xx2_m40_cdd = @m.x1.xdut.xx2_m40.msky130_fd_pr__nfet_01v8[cdd]
echo OPV XX2_M40 cdd $&s1_xx2_m40_cdd
let s1_xx2_m40_cds = @m.x1.xdut.xx2_m40.msky130_fd_pr__nfet_01v8[cds]
echo OPV XX2_M40 cds $&s1_xx2_m40_cds
let s1_xx2_m40_cdb = @m.x1.xdut.xx2_m40.msky130_fd_pr__nfet_01v8[cdb]
echo OPV XX2_M40 cdb $&s1_xx2_m40_cdb
let s1_xx2_m40_csg = @m.x1.xdut.xx2_m40.msky130_fd_pr__nfet_01v8[csg]
echo OPV XX2_M40 csg $&s1_xx2_m40_csg
let s1_xx2_m40_csd = @m.x1.xdut.xx2_m40.msky130_fd_pr__nfet_01v8[csd]
echo OPV XX2_M40 csd $&s1_xx2_m40_csd
let s1_xx2_m40_css = @m.x1.xdut.xx2_m40.msky130_fd_pr__nfet_01v8[css]
echo OPV XX2_M40 css $&s1_xx2_m40_css
let s1_xx2_m40_csb = @m.x1.xdut.xx2_m40.msky130_fd_pr__nfet_01v8[csb]
echo OPV XX2_M40 csb $&s1_xx2_m40_csb
let s1_xx2_m40_cbg = @m.x1.xdut.xx2_m40.msky130_fd_pr__nfet_01v8[cbg]
echo OPV XX2_M40 cbg $&s1_xx2_m40_cbg
let s1_xx2_m40_cbd = @m.x1.xdut.xx2_m40.msky130_fd_pr__nfet_01v8[cbd]
echo OPV XX2_M40 cbd $&s1_xx2_m40_cbd
let s1_xx2_m40_cbs = @m.x1.xdut.xx2_m40.msky130_fd_pr__nfet_01v8[cbs]
echo OPV XX2_M40 cbs $&s1_xx2_m40_cbs
let s1_xx2_m40_cbb = @m.x1.xdut.xx2_m40.msky130_fd_pr__nfet_01v8[cbb]
echo OPV XX2_M40 cbb $&s1_xx2_m40_cbb
let s1_xx2_m40_capbd = @m.x1.xdut.xx2_m40.msky130_fd_pr__nfet_01v8[capbd]
echo OPV XX2_M40 capbd $&s1_xx2_m40_capbd
let s1_xx2_m40_capbs = @m.x1.xdut.xx2_m40.msky130_fd_pr__nfet_01v8[capbs]
echo OPV XX2_M40 capbs $&s1_xx2_m40_capbs
let s1_xx2_m40_cgso = @m.x1.xdut.xx2_m40.msky130_fd_pr__nfet_01v8[cgso]
echo OPV XX2_M40 cgso $&s1_xx2_m40_cgso
let s1_xx2_m40_cgdo = @m.x1.xdut.xx2_m40.msky130_fd_pr__nfet_01v8[cgdo]
echo OPV XX2_M40 cgdo $&s1_xx2_m40_cgdo
let s1_xx2_m40_cgbo = @m.x1.xdut.xx2_m40.msky130_fd_pr__nfet_01v8[cgbo]
echo OPV XX2_M40 cgbo $&s1_xx2_m40_cgbo
let s1_xx2_m40_weff = @m.x1.xdut.xx2_m40.msky130_fd_pr__nfet_01v8[weff]
echo OPV XX2_M40 weff $&s1_xx2_m40_weff
let s1_xx2_m40_leff = @m.x1.xdut.xx2_m40.msky130_fd_pr__nfet_01v8[leff]
echo OPV XX2_M40 leff $&s1_xx2_m40_leff
let s1_xx2_m41_id = @m.x1.xdut.xx2_m41.msky130_fd_pr__nfet_01v8[id]
echo OPV XX2_M41 id $&s1_xx2_m41_id
let s1_xx2_m41_vgs = @m.x1.xdut.xx2_m41.msky130_fd_pr__nfet_01v8[vgs]
echo OPV XX2_M41 vgs $&s1_xx2_m41_vgs
let s1_xx2_m41_vds = @m.x1.xdut.xx2_m41.msky130_fd_pr__nfet_01v8[vds]
echo OPV XX2_M41 vds $&s1_xx2_m41_vds
let s1_xx2_m41_vbs = @m.x1.xdut.xx2_m41.msky130_fd_pr__nfet_01v8[vbs]
echo OPV XX2_M41 vbs $&s1_xx2_m41_vbs
let s1_xx2_m41_vth = @m.x1.xdut.xx2_m41.msky130_fd_pr__nfet_01v8[vth]
echo OPV XX2_M41 vth $&s1_xx2_m41_vth
let s1_xx2_m41_vdsat = @m.x1.xdut.xx2_m41.msky130_fd_pr__nfet_01v8[vdsat]
echo OPV XX2_M41 vdsat $&s1_xx2_m41_vdsat
let s1_xx2_m41_gm = @m.x1.xdut.xx2_m41.msky130_fd_pr__nfet_01v8[gm]
echo OPV XX2_M41 gm $&s1_xx2_m41_gm
let s1_xx2_m41_gds = @m.x1.xdut.xx2_m41.msky130_fd_pr__nfet_01v8[gds]
echo OPV XX2_M41 gds $&s1_xx2_m41_gds
let s1_xx2_m41_gmbs = @m.x1.xdut.xx2_m41.msky130_fd_pr__nfet_01v8[gmbs]
echo OPV XX2_M41 gmbs $&s1_xx2_m41_gmbs
let s1_xx2_m41_cgg = @m.x1.xdut.xx2_m41.msky130_fd_pr__nfet_01v8[cgg]
echo OPV XX2_M41 cgg $&s1_xx2_m41_cgg
let s1_xx2_m41_cgd = @m.x1.xdut.xx2_m41.msky130_fd_pr__nfet_01v8[cgd]
echo OPV XX2_M41 cgd $&s1_xx2_m41_cgd
let s1_xx2_m41_cgs = @m.x1.xdut.xx2_m41.msky130_fd_pr__nfet_01v8[cgs]
echo OPV XX2_M41 cgs $&s1_xx2_m41_cgs
let s1_xx2_m41_cgb = @m.x1.xdut.xx2_m41.msky130_fd_pr__nfet_01v8[cgb]
echo OPV XX2_M41 cgb $&s1_xx2_m41_cgb
let s1_xx2_m41_cdg = @m.x1.xdut.xx2_m41.msky130_fd_pr__nfet_01v8[cdg]
echo OPV XX2_M41 cdg $&s1_xx2_m41_cdg
let s1_xx2_m41_cdd = @m.x1.xdut.xx2_m41.msky130_fd_pr__nfet_01v8[cdd]
echo OPV XX2_M41 cdd $&s1_xx2_m41_cdd
let s1_xx2_m41_cds = @m.x1.xdut.xx2_m41.msky130_fd_pr__nfet_01v8[cds]
echo OPV XX2_M41 cds $&s1_xx2_m41_cds
let s1_xx2_m41_cdb = @m.x1.xdut.xx2_m41.msky130_fd_pr__nfet_01v8[cdb]
echo OPV XX2_M41 cdb $&s1_xx2_m41_cdb
let s1_xx2_m41_csg = @m.x1.xdut.xx2_m41.msky130_fd_pr__nfet_01v8[csg]
echo OPV XX2_M41 csg $&s1_xx2_m41_csg
let s1_xx2_m41_csd = @m.x1.xdut.xx2_m41.msky130_fd_pr__nfet_01v8[csd]
echo OPV XX2_M41 csd $&s1_xx2_m41_csd
let s1_xx2_m41_css = @m.x1.xdut.xx2_m41.msky130_fd_pr__nfet_01v8[css]
echo OPV XX2_M41 css $&s1_xx2_m41_css
let s1_xx2_m41_csb = @m.x1.xdut.xx2_m41.msky130_fd_pr__nfet_01v8[csb]
echo OPV XX2_M41 csb $&s1_xx2_m41_csb
let s1_xx2_m41_cbg = @m.x1.xdut.xx2_m41.msky130_fd_pr__nfet_01v8[cbg]
echo OPV XX2_M41 cbg $&s1_xx2_m41_cbg
let s1_xx2_m41_cbd = @m.x1.xdut.xx2_m41.msky130_fd_pr__nfet_01v8[cbd]
echo OPV XX2_M41 cbd $&s1_xx2_m41_cbd
let s1_xx2_m41_cbs = @m.x1.xdut.xx2_m41.msky130_fd_pr__nfet_01v8[cbs]
echo OPV XX2_M41 cbs $&s1_xx2_m41_cbs
let s1_xx2_m41_cbb = @m.x1.xdut.xx2_m41.msky130_fd_pr__nfet_01v8[cbb]
echo OPV XX2_M41 cbb $&s1_xx2_m41_cbb
let s1_xx2_m41_capbd = @m.x1.xdut.xx2_m41.msky130_fd_pr__nfet_01v8[capbd]
echo OPV XX2_M41 capbd $&s1_xx2_m41_capbd
let s1_xx2_m41_capbs = @m.x1.xdut.xx2_m41.msky130_fd_pr__nfet_01v8[capbs]
echo OPV XX2_M41 capbs $&s1_xx2_m41_capbs
let s1_xx2_m41_cgso = @m.x1.xdut.xx2_m41.msky130_fd_pr__nfet_01v8[cgso]
echo OPV XX2_M41 cgso $&s1_xx2_m41_cgso
let s1_xx2_m41_cgdo = @m.x1.xdut.xx2_m41.msky130_fd_pr__nfet_01v8[cgdo]
echo OPV XX2_M41 cgdo $&s1_xx2_m41_cgdo
let s1_xx2_m41_cgbo = @m.x1.xdut.xx2_m41.msky130_fd_pr__nfet_01v8[cgbo]
echo OPV XX2_M41 cgbo $&s1_xx2_m41_cgbo
let s1_xx2_m41_weff = @m.x1.xdut.xx2_m41.msky130_fd_pr__nfet_01v8[weff]
echo OPV XX2_M41 weff $&s1_xx2_m41_weff
let s1_xx2_m41_leff = @m.x1.xdut.xx2_m41.msky130_fd_pr__nfet_01v8[leff]
echo OPV XX2_M41 leff $&s1_xx2_m41_leff
let s1_xx2_m38_id = @m.x1.xdut.xx2_m38.msky130_fd_pr__nfet_01v8[id]
echo OPV XX2_M38 id $&s1_xx2_m38_id
let s1_xx2_m38_vgs = @m.x1.xdut.xx2_m38.msky130_fd_pr__nfet_01v8[vgs]
echo OPV XX2_M38 vgs $&s1_xx2_m38_vgs
let s1_xx2_m38_vds = @m.x1.xdut.xx2_m38.msky130_fd_pr__nfet_01v8[vds]
echo OPV XX2_M38 vds $&s1_xx2_m38_vds
let s1_xx2_m38_vbs = @m.x1.xdut.xx2_m38.msky130_fd_pr__nfet_01v8[vbs]
echo OPV XX2_M38 vbs $&s1_xx2_m38_vbs
let s1_xx2_m38_vth = @m.x1.xdut.xx2_m38.msky130_fd_pr__nfet_01v8[vth]
echo OPV XX2_M38 vth $&s1_xx2_m38_vth
let s1_xx2_m38_vdsat = @m.x1.xdut.xx2_m38.msky130_fd_pr__nfet_01v8[vdsat]
echo OPV XX2_M38 vdsat $&s1_xx2_m38_vdsat
let s1_xx2_m38_gm = @m.x1.xdut.xx2_m38.msky130_fd_pr__nfet_01v8[gm]
echo OPV XX2_M38 gm $&s1_xx2_m38_gm
let s1_xx2_m38_gds = @m.x1.xdut.xx2_m38.msky130_fd_pr__nfet_01v8[gds]
echo OPV XX2_M38 gds $&s1_xx2_m38_gds
let s1_xx2_m38_gmbs = @m.x1.xdut.xx2_m38.msky130_fd_pr__nfet_01v8[gmbs]
echo OPV XX2_M38 gmbs $&s1_xx2_m38_gmbs
let s1_xx2_m38_cgg = @m.x1.xdut.xx2_m38.msky130_fd_pr__nfet_01v8[cgg]
echo OPV XX2_M38 cgg $&s1_xx2_m38_cgg
let s1_xx2_m38_cgd = @m.x1.xdut.xx2_m38.msky130_fd_pr__nfet_01v8[cgd]
echo OPV XX2_M38 cgd $&s1_xx2_m38_cgd
let s1_xx2_m38_cgs = @m.x1.xdut.xx2_m38.msky130_fd_pr__nfet_01v8[cgs]
echo OPV XX2_M38 cgs $&s1_xx2_m38_cgs
let s1_xx2_m38_cgb = @m.x1.xdut.xx2_m38.msky130_fd_pr__nfet_01v8[cgb]
echo OPV XX2_M38 cgb $&s1_xx2_m38_cgb
let s1_xx2_m38_cdg = @m.x1.xdut.xx2_m38.msky130_fd_pr__nfet_01v8[cdg]
echo OPV XX2_M38 cdg $&s1_xx2_m38_cdg
let s1_xx2_m38_cdd = @m.x1.xdut.xx2_m38.msky130_fd_pr__nfet_01v8[cdd]
echo OPV XX2_M38 cdd $&s1_xx2_m38_cdd
let s1_xx2_m38_cds = @m.x1.xdut.xx2_m38.msky130_fd_pr__nfet_01v8[cds]
echo OPV XX2_M38 cds $&s1_xx2_m38_cds
let s1_xx2_m38_cdb = @m.x1.xdut.xx2_m38.msky130_fd_pr__nfet_01v8[cdb]
echo OPV XX2_M38 cdb $&s1_xx2_m38_cdb
let s1_xx2_m38_csg = @m.x1.xdut.xx2_m38.msky130_fd_pr__nfet_01v8[csg]
echo OPV XX2_M38 csg $&s1_xx2_m38_csg
let s1_xx2_m38_csd = @m.x1.xdut.xx2_m38.msky130_fd_pr__nfet_01v8[csd]
echo OPV XX2_M38 csd $&s1_xx2_m38_csd
let s1_xx2_m38_css = @m.x1.xdut.xx2_m38.msky130_fd_pr__nfet_01v8[css]
echo OPV XX2_M38 css $&s1_xx2_m38_css
let s1_xx2_m38_csb = @m.x1.xdut.xx2_m38.msky130_fd_pr__nfet_01v8[csb]
echo OPV XX2_M38 csb $&s1_xx2_m38_csb
let s1_xx2_m38_cbg = @m.x1.xdut.xx2_m38.msky130_fd_pr__nfet_01v8[cbg]
echo OPV XX2_M38 cbg $&s1_xx2_m38_cbg
let s1_xx2_m38_cbd = @m.x1.xdut.xx2_m38.msky130_fd_pr__nfet_01v8[cbd]
echo OPV XX2_M38 cbd $&s1_xx2_m38_cbd
let s1_xx2_m38_cbs = @m.x1.xdut.xx2_m38.msky130_fd_pr__nfet_01v8[cbs]
echo OPV XX2_M38 cbs $&s1_xx2_m38_cbs
let s1_xx2_m38_cbb = @m.x1.xdut.xx2_m38.msky130_fd_pr__nfet_01v8[cbb]
echo OPV XX2_M38 cbb $&s1_xx2_m38_cbb
let s1_xx2_m38_capbd = @m.x1.xdut.xx2_m38.msky130_fd_pr__nfet_01v8[capbd]
echo OPV XX2_M38 capbd $&s1_xx2_m38_capbd
let s1_xx2_m38_capbs = @m.x1.xdut.xx2_m38.msky130_fd_pr__nfet_01v8[capbs]
echo OPV XX2_M38 capbs $&s1_xx2_m38_capbs
let s1_xx2_m38_cgso = @m.x1.xdut.xx2_m38.msky130_fd_pr__nfet_01v8[cgso]
echo OPV XX2_M38 cgso $&s1_xx2_m38_cgso
let s1_xx2_m38_cgdo = @m.x1.xdut.xx2_m38.msky130_fd_pr__nfet_01v8[cgdo]
echo OPV XX2_M38 cgdo $&s1_xx2_m38_cgdo
let s1_xx2_m38_cgbo = @m.x1.xdut.xx2_m38.msky130_fd_pr__nfet_01v8[cgbo]
echo OPV XX2_M38 cgbo $&s1_xx2_m38_cgbo
let s1_xx2_m38_weff = @m.x1.xdut.xx2_m38.msky130_fd_pr__nfet_01v8[weff]
echo OPV XX2_M38 weff $&s1_xx2_m38_weff
let s1_xx2_m38_leff = @m.x1.xdut.xx2_m38.msky130_fd_pr__nfet_01v8[leff]
echo OPV XX2_M38 leff $&s1_xx2_m38_leff
let s1_xx2_m39_id = @m.x1.xdut.xx2_m39.msky130_fd_pr__nfet_01v8[id]
echo OPV XX2_M39 id $&s1_xx2_m39_id
let s1_xx2_m39_vgs = @m.x1.xdut.xx2_m39.msky130_fd_pr__nfet_01v8[vgs]
echo OPV XX2_M39 vgs $&s1_xx2_m39_vgs
let s1_xx2_m39_vds = @m.x1.xdut.xx2_m39.msky130_fd_pr__nfet_01v8[vds]
echo OPV XX2_M39 vds $&s1_xx2_m39_vds
let s1_xx2_m39_vbs = @m.x1.xdut.xx2_m39.msky130_fd_pr__nfet_01v8[vbs]
echo OPV XX2_M39 vbs $&s1_xx2_m39_vbs
let s1_xx2_m39_vth = @m.x1.xdut.xx2_m39.msky130_fd_pr__nfet_01v8[vth]
echo OPV XX2_M39 vth $&s1_xx2_m39_vth
let s1_xx2_m39_vdsat = @m.x1.xdut.xx2_m39.msky130_fd_pr__nfet_01v8[vdsat]
echo OPV XX2_M39 vdsat $&s1_xx2_m39_vdsat
let s1_xx2_m39_gm = @m.x1.xdut.xx2_m39.msky130_fd_pr__nfet_01v8[gm]
echo OPV XX2_M39 gm $&s1_xx2_m39_gm
let s1_xx2_m39_gds = @m.x1.xdut.xx2_m39.msky130_fd_pr__nfet_01v8[gds]
echo OPV XX2_M39 gds $&s1_xx2_m39_gds
let s1_xx2_m39_gmbs = @m.x1.xdut.xx2_m39.msky130_fd_pr__nfet_01v8[gmbs]
echo OPV XX2_M39 gmbs $&s1_xx2_m39_gmbs
let s1_xx2_m39_cgg = @m.x1.xdut.xx2_m39.msky130_fd_pr__nfet_01v8[cgg]
echo OPV XX2_M39 cgg $&s1_xx2_m39_cgg
let s1_xx2_m39_cgd = @m.x1.xdut.xx2_m39.msky130_fd_pr__nfet_01v8[cgd]
echo OPV XX2_M39 cgd $&s1_xx2_m39_cgd
let s1_xx2_m39_cgs = @m.x1.xdut.xx2_m39.msky130_fd_pr__nfet_01v8[cgs]
echo OPV XX2_M39 cgs $&s1_xx2_m39_cgs
let s1_xx2_m39_cgb = @m.x1.xdut.xx2_m39.msky130_fd_pr__nfet_01v8[cgb]
echo OPV XX2_M39 cgb $&s1_xx2_m39_cgb
let s1_xx2_m39_cdg = @m.x1.xdut.xx2_m39.msky130_fd_pr__nfet_01v8[cdg]
echo OPV XX2_M39 cdg $&s1_xx2_m39_cdg
let s1_xx2_m39_cdd = @m.x1.xdut.xx2_m39.msky130_fd_pr__nfet_01v8[cdd]
echo OPV XX2_M39 cdd $&s1_xx2_m39_cdd
let s1_xx2_m39_cds = @m.x1.xdut.xx2_m39.msky130_fd_pr__nfet_01v8[cds]
echo OPV XX2_M39 cds $&s1_xx2_m39_cds
let s1_xx2_m39_cdb = @m.x1.xdut.xx2_m39.msky130_fd_pr__nfet_01v8[cdb]
echo OPV XX2_M39 cdb $&s1_xx2_m39_cdb
let s1_xx2_m39_csg = @m.x1.xdut.xx2_m39.msky130_fd_pr__nfet_01v8[csg]
echo OPV XX2_M39 csg $&s1_xx2_m39_csg
let s1_xx2_m39_csd = @m.x1.xdut.xx2_m39.msky130_fd_pr__nfet_01v8[csd]
echo OPV XX2_M39 csd $&s1_xx2_m39_csd
let s1_xx2_m39_css = @m.x1.xdut.xx2_m39.msky130_fd_pr__nfet_01v8[css]
echo OPV XX2_M39 css $&s1_xx2_m39_css
let s1_xx2_m39_csb = @m.x1.xdut.xx2_m39.msky130_fd_pr__nfet_01v8[csb]
echo OPV XX2_M39 csb $&s1_xx2_m39_csb
let s1_xx2_m39_cbg = @m.x1.xdut.xx2_m39.msky130_fd_pr__nfet_01v8[cbg]
echo OPV XX2_M39 cbg $&s1_xx2_m39_cbg
let s1_xx2_m39_cbd = @m.x1.xdut.xx2_m39.msky130_fd_pr__nfet_01v8[cbd]
echo OPV XX2_M39 cbd $&s1_xx2_m39_cbd
let s1_xx2_m39_cbs = @m.x1.xdut.xx2_m39.msky130_fd_pr__nfet_01v8[cbs]
echo OPV XX2_M39 cbs $&s1_xx2_m39_cbs
let s1_xx2_m39_cbb = @m.x1.xdut.xx2_m39.msky130_fd_pr__nfet_01v8[cbb]
echo OPV XX2_M39 cbb $&s1_xx2_m39_cbb
let s1_xx2_m39_capbd = @m.x1.xdut.xx2_m39.msky130_fd_pr__nfet_01v8[capbd]
echo OPV XX2_M39 capbd $&s1_xx2_m39_capbd
let s1_xx2_m39_capbs = @m.x1.xdut.xx2_m39.msky130_fd_pr__nfet_01v8[capbs]
echo OPV XX2_M39 capbs $&s1_xx2_m39_capbs
let s1_xx2_m39_cgso = @m.x1.xdut.xx2_m39.msky130_fd_pr__nfet_01v8[cgso]
echo OPV XX2_M39 cgso $&s1_xx2_m39_cgso
let s1_xx2_m39_cgdo = @m.x1.xdut.xx2_m39.msky130_fd_pr__nfet_01v8[cgdo]
echo OPV XX2_M39 cgdo $&s1_xx2_m39_cgdo
let s1_xx2_m39_cgbo = @m.x1.xdut.xx2_m39.msky130_fd_pr__nfet_01v8[cgbo]
echo OPV XX2_M39 cgbo $&s1_xx2_m39_cgbo
let s1_xx2_m39_weff = @m.x1.xdut.xx2_m39.msky130_fd_pr__nfet_01v8[weff]
echo OPV XX2_M39 weff $&s1_xx2_m39_weff
let s1_xx2_m39_leff = @m.x1.xdut.xx2_m39.msky130_fd_pr__nfet_01v8[leff]
echo OPV XX2_M39 leff $&s1_xx2_m39_leff
let s1_xx2_m30_id = @m.x1.xdut.xx2_m30.msky130_fd_pr__nfet_01v8[id]
echo OPV XX2_M30 id $&s1_xx2_m30_id
let s1_xx2_m30_vgs = @m.x1.xdut.xx2_m30.msky130_fd_pr__nfet_01v8[vgs]
echo OPV XX2_M30 vgs $&s1_xx2_m30_vgs
let s1_xx2_m30_vds = @m.x1.xdut.xx2_m30.msky130_fd_pr__nfet_01v8[vds]
echo OPV XX2_M30 vds $&s1_xx2_m30_vds
let s1_xx2_m30_vbs = @m.x1.xdut.xx2_m30.msky130_fd_pr__nfet_01v8[vbs]
echo OPV XX2_M30 vbs $&s1_xx2_m30_vbs
let s1_xx2_m30_vth = @m.x1.xdut.xx2_m30.msky130_fd_pr__nfet_01v8[vth]
echo OPV XX2_M30 vth $&s1_xx2_m30_vth
let s1_xx2_m30_vdsat = @m.x1.xdut.xx2_m30.msky130_fd_pr__nfet_01v8[vdsat]
echo OPV XX2_M30 vdsat $&s1_xx2_m30_vdsat
let s1_xx2_m30_gm = @m.x1.xdut.xx2_m30.msky130_fd_pr__nfet_01v8[gm]
echo OPV XX2_M30 gm $&s1_xx2_m30_gm
let s1_xx2_m30_gds = @m.x1.xdut.xx2_m30.msky130_fd_pr__nfet_01v8[gds]
echo OPV XX2_M30 gds $&s1_xx2_m30_gds
let s1_xx2_m30_gmbs = @m.x1.xdut.xx2_m30.msky130_fd_pr__nfet_01v8[gmbs]
echo OPV XX2_M30 gmbs $&s1_xx2_m30_gmbs
let s1_xx2_m30_cgg = @m.x1.xdut.xx2_m30.msky130_fd_pr__nfet_01v8[cgg]
echo OPV XX2_M30 cgg $&s1_xx2_m30_cgg
let s1_xx2_m30_cgd = @m.x1.xdut.xx2_m30.msky130_fd_pr__nfet_01v8[cgd]
echo OPV XX2_M30 cgd $&s1_xx2_m30_cgd
let s1_xx2_m30_cgs = @m.x1.xdut.xx2_m30.msky130_fd_pr__nfet_01v8[cgs]
echo OPV XX2_M30 cgs $&s1_xx2_m30_cgs
let s1_xx2_m30_cgb = @m.x1.xdut.xx2_m30.msky130_fd_pr__nfet_01v8[cgb]
echo OPV XX2_M30 cgb $&s1_xx2_m30_cgb
let s1_xx2_m30_cdg = @m.x1.xdut.xx2_m30.msky130_fd_pr__nfet_01v8[cdg]
echo OPV XX2_M30 cdg $&s1_xx2_m30_cdg
let s1_xx2_m30_cdd = @m.x1.xdut.xx2_m30.msky130_fd_pr__nfet_01v8[cdd]
echo OPV XX2_M30 cdd $&s1_xx2_m30_cdd
let s1_xx2_m30_cds = @m.x1.xdut.xx2_m30.msky130_fd_pr__nfet_01v8[cds]
echo OPV XX2_M30 cds $&s1_xx2_m30_cds
let s1_xx2_m30_cdb = @m.x1.xdut.xx2_m30.msky130_fd_pr__nfet_01v8[cdb]
echo OPV XX2_M30 cdb $&s1_xx2_m30_cdb
let s1_xx2_m30_csg = @m.x1.xdut.xx2_m30.msky130_fd_pr__nfet_01v8[csg]
echo OPV XX2_M30 csg $&s1_xx2_m30_csg
let s1_xx2_m30_csd = @m.x1.xdut.xx2_m30.msky130_fd_pr__nfet_01v8[csd]
echo OPV XX2_M30 csd $&s1_xx2_m30_csd
let s1_xx2_m30_css = @m.x1.xdut.xx2_m30.msky130_fd_pr__nfet_01v8[css]
echo OPV XX2_M30 css $&s1_xx2_m30_css
let s1_xx2_m30_csb = @m.x1.xdut.xx2_m30.msky130_fd_pr__nfet_01v8[csb]
echo OPV XX2_M30 csb $&s1_xx2_m30_csb
let s1_xx2_m30_cbg = @m.x1.xdut.xx2_m30.msky130_fd_pr__nfet_01v8[cbg]
echo OPV XX2_M30 cbg $&s1_xx2_m30_cbg
let s1_xx2_m30_cbd = @m.x1.xdut.xx2_m30.msky130_fd_pr__nfet_01v8[cbd]
echo OPV XX2_M30 cbd $&s1_xx2_m30_cbd
let s1_xx2_m30_cbs = @m.x1.xdut.xx2_m30.msky130_fd_pr__nfet_01v8[cbs]
echo OPV XX2_M30 cbs $&s1_xx2_m30_cbs
let s1_xx2_m30_cbb = @m.x1.xdut.xx2_m30.msky130_fd_pr__nfet_01v8[cbb]
echo OPV XX2_M30 cbb $&s1_xx2_m30_cbb
let s1_xx2_m30_capbd = @m.x1.xdut.xx2_m30.msky130_fd_pr__nfet_01v8[capbd]
echo OPV XX2_M30 capbd $&s1_xx2_m30_capbd
let s1_xx2_m30_capbs = @m.x1.xdut.xx2_m30.msky130_fd_pr__nfet_01v8[capbs]
echo OPV XX2_M30 capbs $&s1_xx2_m30_capbs
let s1_xx2_m30_cgso = @m.x1.xdut.xx2_m30.msky130_fd_pr__nfet_01v8[cgso]
echo OPV XX2_M30 cgso $&s1_xx2_m30_cgso
let s1_xx2_m30_cgdo = @m.x1.xdut.xx2_m30.msky130_fd_pr__nfet_01v8[cgdo]
echo OPV XX2_M30 cgdo $&s1_xx2_m30_cgdo
let s1_xx2_m30_cgbo = @m.x1.xdut.xx2_m30.msky130_fd_pr__nfet_01v8[cgbo]
echo OPV XX2_M30 cgbo $&s1_xx2_m30_cgbo
let s1_xx2_m30_weff = @m.x1.xdut.xx2_m30.msky130_fd_pr__nfet_01v8[weff]
echo OPV XX2_M30 weff $&s1_xx2_m30_weff
let s1_xx2_m30_leff = @m.x1.xdut.xx2_m30.msky130_fd_pr__nfet_01v8[leff]
echo OPV XX2_M30 leff $&s1_xx2_m30_leff
let s1_xx2_m23_id = @m.x1.xdut.xx2_m23.msky130_fd_pr__nfet_01v8_lvt[id]
echo OPV XX2_M23 id $&s1_xx2_m23_id
let s1_xx2_m23_vgs = @m.x1.xdut.xx2_m23.msky130_fd_pr__nfet_01v8_lvt[vgs]
echo OPV XX2_M23 vgs $&s1_xx2_m23_vgs
let s1_xx2_m23_vds = @m.x1.xdut.xx2_m23.msky130_fd_pr__nfet_01v8_lvt[vds]
echo OPV XX2_M23 vds $&s1_xx2_m23_vds
let s1_xx2_m23_vbs = @m.x1.xdut.xx2_m23.msky130_fd_pr__nfet_01v8_lvt[vbs]
echo OPV XX2_M23 vbs $&s1_xx2_m23_vbs
let s1_xx2_m23_vth = @m.x1.xdut.xx2_m23.msky130_fd_pr__nfet_01v8_lvt[vth]
echo OPV XX2_M23 vth $&s1_xx2_m23_vth
let s1_xx2_m23_vdsat = @m.x1.xdut.xx2_m23.msky130_fd_pr__nfet_01v8_lvt[vdsat]
echo OPV XX2_M23 vdsat $&s1_xx2_m23_vdsat
let s1_xx2_m23_gm = @m.x1.xdut.xx2_m23.msky130_fd_pr__nfet_01v8_lvt[gm]
echo OPV XX2_M23 gm $&s1_xx2_m23_gm
let s1_xx2_m23_gds = @m.x1.xdut.xx2_m23.msky130_fd_pr__nfet_01v8_lvt[gds]
echo OPV XX2_M23 gds $&s1_xx2_m23_gds
let s1_xx2_m23_gmbs = @m.x1.xdut.xx2_m23.msky130_fd_pr__nfet_01v8_lvt[gmbs]
echo OPV XX2_M23 gmbs $&s1_xx2_m23_gmbs
let s1_xx2_m23_cgg = @m.x1.xdut.xx2_m23.msky130_fd_pr__nfet_01v8_lvt[cgg]
echo OPV XX2_M23 cgg $&s1_xx2_m23_cgg
let s1_xx2_m23_cgd = @m.x1.xdut.xx2_m23.msky130_fd_pr__nfet_01v8_lvt[cgd]
echo OPV XX2_M23 cgd $&s1_xx2_m23_cgd
let s1_xx2_m23_cgs = @m.x1.xdut.xx2_m23.msky130_fd_pr__nfet_01v8_lvt[cgs]
echo OPV XX2_M23 cgs $&s1_xx2_m23_cgs
let s1_xx2_m23_cgb = @m.x1.xdut.xx2_m23.msky130_fd_pr__nfet_01v8_lvt[cgb]
echo OPV XX2_M23 cgb $&s1_xx2_m23_cgb
let s1_xx2_m23_cdg = @m.x1.xdut.xx2_m23.msky130_fd_pr__nfet_01v8_lvt[cdg]
echo OPV XX2_M23 cdg $&s1_xx2_m23_cdg
let s1_xx2_m23_cdd = @m.x1.xdut.xx2_m23.msky130_fd_pr__nfet_01v8_lvt[cdd]
echo OPV XX2_M23 cdd $&s1_xx2_m23_cdd
let s1_xx2_m23_cds = @m.x1.xdut.xx2_m23.msky130_fd_pr__nfet_01v8_lvt[cds]
echo OPV XX2_M23 cds $&s1_xx2_m23_cds
let s1_xx2_m23_cdb = @m.x1.xdut.xx2_m23.msky130_fd_pr__nfet_01v8_lvt[cdb]
echo OPV XX2_M23 cdb $&s1_xx2_m23_cdb
let s1_xx2_m23_csg = @m.x1.xdut.xx2_m23.msky130_fd_pr__nfet_01v8_lvt[csg]
echo OPV XX2_M23 csg $&s1_xx2_m23_csg
let s1_xx2_m23_csd = @m.x1.xdut.xx2_m23.msky130_fd_pr__nfet_01v8_lvt[csd]
echo OPV XX2_M23 csd $&s1_xx2_m23_csd
let s1_xx2_m23_css = @m.x1.xdut.xx2_m23.msky130_fd_pr__nfet_01v8_lvt[css]
echo OPV XX2_M23 css $&s1_xx2_m23_css
let s1_xx2_m23_csb = @m.x1.xdut.xx2_m23.msky130_fd_pr__nfet_01v8_lvt[csb]
echo OPV XX2_M23 csb $&s1_xx2_m23_csb
let s1_xx2_m23_cbg = @m.x1.xdut.xx2_m23.msky130_fd_pr__nfet_01v8_lvt[cbg]
echo OPV XX2_M23 cbg $&s1_xx2_m23_cbg
let s1_xx2_m23_cbd = @m.x1.xdut.xx2_m23.msky130_fd_pr__nfet_01v8_lvt[cbd]
echo OPV XX2_M23 cbd $&s1_xx2_m23_cbd
let s1_xx2_m23_cbs = @m.x1.xdut.xx2_m23.msky130_fd_pr__nfet_01v8_lvt[cbs]
echo OPV XX2_M23 cbs $&s1_xx2_m23_cbs
let s1_xx2_m23_cbb = @m.x1.xdut.xx2_m23.msky130_fd_pr__nfet_01v8_lvt[cbb]
echo OPV XX2_M23 cbb $&s1_xx2_m23_cbb
let s1_xx2_m23_capbd = @m.x1.xdut.xx2_m23.msky130_fd_pr__nfet_01v8_lvt[capbd]
echo OPV XX2_M23 capbd $&s1_xx2_m23_capbd
let s1_xx2_m23_capbs = @m.x1.xdut.xx2_m23.msky130_fd_pr__nfet_01v8_lvt[capbs]
echo OPV XX2_M23 capbs $&s1_xx2_m23_capbs
let s1_xx2_m23_cgso = @m.x1.xdut.xx2_m23.msky130_fd_pr__nfet_01v8_lvt[cgso]
echo OPV XX2_M23 cgso $&s1_xx2_m23_cgso
let s1_xx2_m23_cgdo = @m.x1.xdut.xx2_m23.msky130_fd_pr__nfet_01v8_lvt[cgdo]
echo OPV XX2_M23 cgdo $&s1_xx2_m23_cgdo
let s1_xx2_m23_cgbo = @m.x1.xdut.xx2_m23.msky130_fd_pr__nfet_01v8_lvt[cgbo]
echo OPV XX2_M23 cgbo $&s1_xx2_m23_cgbo
let s1_xx2_m23_weff = @m.x1.xdut.xx2_m23.msky130_fd_pr__nfet_01v8_lvt[weff]
echo OPV XX2_M23 weff $&s1_xx2_m23_weff
let s1_xx2_m23_leff = @m.x1.xdut.xx2_m23.msky130_fd_pr__nfet_01v8_lvt[leff]
echo OPV XX2_M23 leff $&s1_xx2_m23_leff
let s1_xx2_m24_id = @m.x1.xdut.xx2_m24.msky130_fd_pr__nfet_01v8_lvt[id]
echo OPV XX2_M24 id $&s1_xx2_m24_id
let s1_xx2_m24_vgs = @m.x1.xdut.xx2_m24.msky130_fd_pr__nfet_01v8_lvt[vgs]
echo OPV XX2_M24 vgs $&s1_xx2_m24_vgs
let s1_xx2_m24_vds = @m.x1.xdut.xx2_m24.msky130_fd_pr__nfet_01v8_lvt[vds]
echo OPV XX2_M24 vds $&s1_xx2_m24_vds
let s1_xx2_m24_vbs = @m.x1.xdut.xx2_m24.msky130_fd_pr__nfet_01v8_lvt[vbs]
echo OPV XX2_M24 vbs $&s1_xx2_m24_vbs
let s1_xx2_m24_vth = @m.x1.xdut.xx2_m24.msky130_fd_pr__nfet_01v8_lvt[vth]
echo OPV XX2_M24 vth $&s1_xx2_m24_vth
let s1_xx2_m24_vdsat = @m.x1.xdut.xx2_m24.msky130_fd_pr__nfet_01v8_lvt[vdsat]
echo OPV XX2_M24 vdsat $&s1_xx2_m24_vdsat
let s1_xx2_m24_gm = @m.x1.xdut.xx2_m24.msky130_fd_pr__nfet_01v8_lvt[gm]
echo OPV XX2_M24 gm $&s1_xx2_m24_gm
let s1_xx2_m24_gds = @m.x1.xdut.xx2_m24.msky130_fd_pr__nfet_01v8_lvt[gds]
echo OPV XX2_M24 gds $&s1_xx2_m24_gds
let s1_xx2_m24_gmbs = @m.x1.xdut.xx2_m24.msky130_fd_pr__nfet_01v8_lvt[gmbs]
echo OPV XX2_M24 gmbs $&s1_xx2_m24_gmbs
let s1_xx2_m24_cgg = @m.x1.xdut.xx2_m24.msky130_fd_pr__nfet_01v8_lvt[cgg]
echo OPV XX2_M24 cgg $&s1_xx2_m24_cgg
let s1_xx2_m24_cgd = @m.x1.xdut.xx2_m24.msky130_fd_pr__nfet_01v8_lvt[cgd]
echo OPV XX2_M24 cgd $&s1_xx2_m24_cgd
let s1_xx2_m24_cgs = @m.x1.xdut.xx2_m24.msky130_fd_pr__nfet_01v8_lvt[cgs]
echo OPV XX2_M24 cgs $&s1_xx2_m24_cgs
let s1_xx2_m24_cgb = @m.x1.xdut.xx2_m24.msky130_fd_pr__nfet_01v8_lvt[cgb]
echo OPV XX2_M24 cgb $&s1_xx2_m24_cgb
let s1_xx2_m24_cdg = @m.x1.xdut.xx2_m24.msky130_fd_pr__nfet_01v8_lvt[cdg]
echo OPV XX2_M24 cdg $&s1_xx2_m24_cdg
let s1_xx2_m24_cdd = @m.x1.xdut.xx2_m24.msky130_fd_pr__nfet_01v8_lvt[cdd]
echo OPV XX2_M24 cdd $&s1_xx2_m24_cdd
let s1_xx2_m24_cds = @m.x1.xdut.xx2_m24.msky130_fd_pr__nfet_01v8_lvt[cds]
echo OPV XX2_M24 cds $&s1_xx2_m24_cds
let s1_xx2_m24_cdb = @m.x1.xdut.xx2_m24.msky130_fd_pr__nfet_01v8_lvt[cdb]
echo OPV XX2_M24 cdb $&s1_xx2_m24_cdb
let s1_xx2_m24_csg = @m.x1.xdut.xx2_m24.msky130_fd_pr__nfet_01v8_lvt[csg]
echo OPV XX2_M24 csg $&s1_xx2_m24_csg
let s1_xx2_m24_csd = @m.x1.xdut.xx2_m24.msky130_fd_pr__nfet_01v8_lvt[csd]
echo OPV XX2_M24 csd $&s1_xx2_m24_csd
let s1_xx2_m24_css = @m.x1.xdut.xx2_m24.msky130_fd_pr__nfet_01v8_lvt[css]
echo OPV XX2_M24 css $&s1_xx2_m24_css
let s1_xx2_m24_csb = @m.x1.xdut.xx2_m24.msky130_fd_pr__nfet_01v8_lvt[csb]
echo OPV XX2_M24 csb $&s1_xx2_m24_csb
let s1_xx2_m24_cbg = @m.x1.xdut.xx2_m24.msky130_fd_pr__nfet_01v8_lvt[cbg]
echo OPV XX2_M24 cbg $&s1_xx2_m24_cbg
let s1_xx2_m24_cbd = @m.x1.xdut.xx2_m24.msky130_fd_pr__nfet_01v8_lvt[cbd]
echo OPV XX2_M24 cbd $&s1_xx2_m24_cbd
let s1_xx2_m24_cbs = @m.x1.xdut.xx2_m24.msky130_fd_pr__nfet_01v8_lvt[cbs]
echo OPV XX2_M24 cbs $&s1_xx2_m24_cbs
let s1_xx2_m24_cbb = @m.x1.xdut.xx2_m24.msky130_fd_pr__nfet_01v8_lvt[cbb]
echo OPV XX2_M24 cbb $&s1_xx2_m24_cbb
let s1_xx2_m24_capbd = @m.x1.xdut.xx2_m24.msky130_fd_pr__nfet_01v8_lvt[capbd]
echo OPV XX2_M24 capbd $&s1_xx2_m24_capbd
let s1_xx2_m24_capbs = @m.x1.xdut.xx2_m24.msky130_fd_pr__nfet_01v8_lvt[capbs]
echo OPV XX2_M24 capbs $&s1_xx2_m24_capbs
let s1_xx2_m24_cgso = @m.x1.xdut.xx2_m24.msky130_fd_pr__nfet_01v8_lvt[cgso]
echo OPV XX2_M24 cgso $&s1_xx2_m24_cgso
let s1_xx2_m24_cgdo = @m.x1.xdut.xx2_m24.msky130_fd_pr__nfet_01v8_lvt[cgdo]
echo OPV XX2_M24 cgdo $&s1_xx2_m24_cgdo
let s1_xx2_m24_cgbo = @m.x1.xdut.xx2_m24.msky130_fd_pr__nfet_01v8_lvt[cgbo]
echo OPV XX2_M24 cgbo $&s1_xx2_m24_cgbo
let s1_xx2_m24_weff = @m.x1.xdut.xx2_m24.msky130_fd_pr__nfet_01v8_lvt[weff]
echo OPV XX2_M24 weff $&s1_xx2_m24_weff
let s1_xx2_m24_leff = @m.x1.xdut.xx2_m24.msky130_fd_pr__nfet_01v8_lvt[leff]
echo OPV XX2_M24 leff $&s1_xx2_m24_leff
let s1_xx2_m80_id = @m.x1.xdut.xx2_m80.msky130_fd_pr__nfet_01v8[id]
echo OPV XX2_M80 id $&s1_xx2_m80_id
let s1_xx2_m80_vgs = @m.x1.xdut.xx2_m80.msky130_fd_pr__nfet_01v8[vgs]
echo OPV XX2_M80 vgs $&s1_xx2_m80_vgs
let s1_xx2_m80_vds = @m.x1.xdut.xx2_m80.msky130_fd_pr__nfet_01v8[vds]
echo OPV XX2_M80 vds $&s1_xx2_m80_vds
let s1_xx2_m80_vbs = @m.x1.xdut.xx2_m80.msky130_fd_pr__nfet_01v8[vbs]
echo OPV XX2_M80 vbs $&s1_xx2_m80_vbs
let s1_xx2_m80_vth = @m.x1.xdut.xx2_m80.msky130_fd_pr__nfet_01v8[vth]
echo OPV XX2_M80 vth $&s1_xx2_m80_vth
let s1_xx2_m80_vdsat = @m.x1.xdut.xx2_m80.msky130_fd_pr__nfet_01v8[vdsat]
echo OPV XX2_M80 vdsat $&s1_xx2_m80_vdsat
let s1_xx2_m80_gm = @m.x1.xdut.xx2_m80.msky130_fd_pr__nfet_01v8[gm]
echo OPV XX2_M80 gm $&s1_xx2_m80_gm
let s1_xx2_m80_gds = @m.x1.xdut.xx2_m80.msky130_fd_pr__nfet_01v8[gds]
echo OPV XX2_M80 gds $&s1_xx2_m80_gds
let s1_xx2_m80_gmbs = @m.x1.xdut.xx2_m80.msky130_fd_pr__nfet_01v8[gmbs]
echo OPV XX2_M80 gmbs $&s1_xx2_m80_gmbs
let s1_xx2_m80_cgg = @m.x1.xdut.xx2_m80.msky130_fd_pr__nfet_01v8[cgg]
echo OPV XX2_M80 cgg $&s1_xx2_m80_cgg
let s1_xx2_m80_cgd = @m.x1.xdut.xx2_m80.msky130_fd_pr__nfet_01v8[cgd]
echo OPV XX2_M80 cgd $&s1_xx2_m80_cgd
let s1_xx2_m80_cgs = @m.x1.xdut.xx2_m80.msky130_fd_pr__nfet_01v8[cgs]
echo OPV XX2_M80 cgs $&s1_xx2_m80_cgs
let s1_xx2_m80_cgb = @m.x1.xdut.xx2_m80.msky130_fd_pr__nfet_01v8[cgb]
echo OPV XX2_M80 cgb $&s1_xx2_m80_cgb
let s1_xx2_m80_cdg = @m.x1.xdut.xx2_m80.msky130_fd_pr__nfet_01v8[cdg]
echo OPV XX2_M80 cdg $&s1_xx2_m80_cdg
let s1_xx2_m80_cdd = @m.x1.xdut.xx2_m80.msky130_fd_pr__nfet_01v8[cdd]
echo OPV XX2_M80 cdd $&s1_xx2_m80_cdd
let s1_xx2_m80_cds = @m.x1.xdut.xx2_m80.msky130_fd_pr__nfet_01v8[cds]
echo OPV XX2_M80 cds $&s1_xx2_m80_cds
let s1_xx2_m80_cdb = @m.x1.xdut.xx2_m80.msky130_fd_pr__nfet_01v8[cdb]
echo OPV XX2_M80 cdb $&s1_xx2_m80_cdb
let s1_xx2_m80_csg = @m.x1.xdut.xx2_m80.msky130_fd_pr__nfet_01v8[csg]
echo OPV XX2_M80 csg $&s1_xx2_m80_csg
let s1_xx2_m80_csd = @m.x1.xdut.xx2_m80.msky130_fd_pr__nfet_01v8[csd]
echo OPV XX2_M80 csd $&s1_xx2_m80_csd
let s1_xx2_m80_css = @m.x1.xdut.xx2_m80.msky130_fd_pr__nfet_01v8[css]
echo OPV XX2_M80 css $&s1_xx2_m80_css
let s1_xx2_m80_csb = @m.x1.xdut.xx2_m80.msky130_fd_pr__nfet_01v8[csb]
echo OPV XX2_M80 csb $&s1_xx2_m80_csb
let s1_xx2_m80_cbg = @m.x1.xdut.xx2_m80.msky130_fd_pr__nfet_01v8[cbg]
echo OPV XX2_M80 cbg $&s1_xx2_m80_cbg
let s1_xx2_m80_cbd = @m.x1.xdut.xx2_m80.msky130_fd_pr__nfet_01v8[cbd]
echo OPV XX2_M80 cbd $&s1_xx2_m80_cbd
let s1_xx2_m80_cbs = @m.x1.xdut.xx2_m80.msky130_fd_pr__nfet_01v8[cbs]
echo OPV XX2_M80 cbs $&s1_xx2_m80_cbs
let s1_xx2_m80_cbb = @m.x1.xdut.xx2_m80.msky130_fd_pr__nfet_01v8[cbb]
echo OPV XX2_M80 cbb $&s1_xx2_m80_cbb
let s1_xx2_m80_capbd = @m.x1.xdut.xx2_m80.msky130_fd_pr__nfet_01v8[capbd]
echo OPV XX2_M80 capbd $&s1_xx2_m80_capbd
let s1_xx2_m80_capbs = @m.x1.xdut.xx2_m80.msky130_fd_pr__nfet_01v8[capbs]
echo OPV XX2_M80 capbs $&s1_xx2_m80_capbs
let s1_xx2_m80_cgso = @m.x1.xdut.xx2_m80.msky130_fd_pr__nfet_01v8[cgso]
echo OPV XX2_M80 cgso $&s1_xx2_m80_cgso
let s1_xx2_m80_cgdo = @m.x1.xdut.xx2_m80.msky130_fd_pr__nfet_01v8[cgdo]
echo OPV XX2_M80 cgdo $&s1_xx2_m80_cgdo
let s1_xx2_m80_cgbo = @m.x1.xdut.xx2_m80.msky130_fd_pr__nfet_01v8[cgbo]
echo OPV XX2_M80 cgbo $&s1_xx2_m80_cgbo
let s1_xx2_m80_weff = @m.x1.xdut.xx2_m80.msky130_fd_pr__nfet_01v8[weff]
echo OPV XX2_M80 weff $&s1_xx2_m80_weff
let s1_xx2_m80_leff = @m.x1.xdut.xx2_m80.msky130_fd_pr__nfet_01v8[leff]
echo OPV XX2_M80 leff $&s1_xx2_m80_leff
let s1_xx2_m81_id = @m.x1.xdut.xx2_m81.msky130_fd_pr__nfet_01v8[id]
echo OPV XX2_M81 id $&s1_xx2_m81_id
let s1_xx2_m81_vgs = @m.x1.xdut.xx2_m81.msky130_fd_pr__nfet_01v8[vgs]
echo OPV XX2_M81 vgs $&s1_xx2_m81_vgs
let s1_xx2_m81_vds = @m.x1.xdut.xx2_m81.msky130_fd_pr__nfet_01v8[vds]
echo OPV XX2_M81 vds $&s1_xx2_m81_vds
let s1_xx2_m81_vbs = @m.x1.xdut.xx2_m81.msky130_fd_pr__nfet_01v8[vbs]
echo OPV XX2_M81 vbs $&s1_xx2_m81_vbs
let s1_xx2_m81_vth = @m.x1.xdut.xx2_m81.msky130_fd_pr__nfet_01v8[vth]
echo OPV XX2_M81 vth $&s1_xx2_m81_vth
let s1_xx2_m81_vdsat = @m.x1.xdut.xx2_m81.msky130_fd_pr__nfet_01v8[vdsat]
echo OPV XX2_M81 vdsat $&s1_xx2_m81_vdsat
let s1_xx2_m81_gm = @m.x1.xdut.xx2_m81.msky130_fd_pr__nfet_01v8[gm]
echo OPV XX2_M81 gm $&s1_xx2_m81_gm
let s1_xx2_m81_gds = @m.x1.xdut.xx2_m81.msky130_fd_pr__nfet_01v8[gds]
echo OPV XX2_M81 gds $&s1_xx2_m81_gds
let s1_xx2_m81_gmbs = @m.x1.xdut.xx2_m81.msky130_fd_pr__nfet_01v8[gmbs]
echo OPV XX2_M81 gmbs $&s1_xx2_m81_gmbs
let s1_xx2_m81_cgg = @m.x1.xdut.xx2_m81.msky130_fd_pr__nfet_01v8[cgg]
echo OPV XX2_M81 cgg $&s1_xx2_m81_cgg
let s1_xx2_m81_cgd = @m.x1.xdut.xx2_m81.msky130_fd_pr__nfet_01v8[cgd]
echo OPV XX2_M81 cgd $&s1_xx2_m81_cgd
let s1_xx2_m81_cgs = @m.x1.xdut.xx2_m81.msky130_fd_pr__nfet_01v8[cgs]
echo OPV XX2_M81 cgs $&s1_xx2_m81_cgs
let s1_xx2_m81_cgb = @m.x1.xdut.xx2_m81.msky130_fd_pr__nfet_01v8[cgb]
echo OPV XX2_M81 cgb $&s1_xx2_m81_cgb
let s1_xx2_m81_cdg = @m.x1.xdut.xx2_m81.msky130_fd_pr__nfet_01v8[cdg]
echo OPV XX2_M81 cdg $&s1_xx2_m81_cdg
let s1_xx2_m81_cdd = @m.x1.xdut.xx2_m81.msky130_fd_pr__nfet_01v8[cdd]
echo OPV XX2_M81 cdd $&s1_xx2_m81_cdd
let s1_xx2_m81_cds = @m.x1.xdut.xx2_m81.msky130_fd_pr__nfet_01v8[cds]
echo OPV XX2_M81 cds $&s1_xx2_m81_cds
let s1_xx2_m81_cdb = @m.x1.xdut.xx2_m81.msky130_fd_pr__nfet_01v8[cdb]
echo OPV XX2_M81 cdb $&s1_xx2_m81_cdb
let s1_xx2_m81_csg = @m.x1.xdut.xx2_m81.msky130_fd_pr__nfet_01v8[csg]
echo OPV XX2_M81 csg $&s1_xx2_m81_csg
let s1_xx2_m81_csd = @m.x1.xdut.xx2_m81.msky130_fd_pr__nfet_01v8[csd]
echo OPV XX2_M81 csd $&s1_xx2_m81_csd
let s1_xx2_m81_css = @m.x1.xdut.xx2_m81.msky130_fd_pr__nfet_01v8[css]
echo OPV XX2_M81 css $&s1_xx2_m81_css
let s1_xx2_m81_csb = @m.x1.xdut.xx2_m81.msky130_fd_pr__nfet_01v8[csb]
echo OPV XX2_M81 csb $&s1_xx2_m81_csb
let s1_xx2_m81_cbg = @m.x1.xdut.xx2_m81.msky130_fd_pr__nfet_01v8[cbg]
echo OPV XX2_M81 cbg $&s1_xx2_m81_cbg
let s1_xx2_m81_cbd = @m.x1.xdut.xx2_m81.msky130_fd_pr__nfet_01v8[cbd]
echo OPV XX2_M81 cbd $&s1_xx2_m81_cbd
let s1_xx2_m81_cbs = @m.x1.xdut.xx2_m81.msky130_fd_pr__nfet_01v8[cbs]
echo OPV XX2_M81 cbs $&s1_xx2_m81_cbs
let s1_xx2_m81_cbb = @m.x1.xdut.xx2_m81.msky130_fd_pr__nfet_01v8[cbb]
echo OPV XX2_M81 cbb $&s1_xx2_m81_cbb
let s1_xx2_m81_capbd = @m.x1.xdut.xx2_m81.msky130_fd_pr__nfet_01v8[capbd]
echo OPV XX2_M81 capbd $&s1_xx2_m81_capbd
let s1_xx2_m81_capbs = @m.x1.xdut.xx2_m81.msky130_fd_pr__nfet_01v8[capbs]
echo OPV XX2_M81 capbs $&s1_xx2_m81_capbs
let s1_xx2_m81_cgso = @m.x1.xdut.xx2_m81.msky130_fd_pr__nfet_01v8[cgso]
echo OPV XX2_M81 cgso $&s1_xx2_m81_cgso
let s1_xx2_m81_cgdo = @m.x1.xdut.xx2_m81.msky130_fd_pr__nfet_01v8[cgdo]
echo OPV XX2_M81 cgdo $&s1_xx2_m81_cgdo
let s1_xx2_m81_cgbo = @m.x1.xdut.xx2_m81.msky130_fd_pr__nfet_01v8[cgbo]
echo OPV XX2_M81 cgbo $&s1_xx2_m81_cgbo
let s1_xx2_m81_weff = @m.x1.xdut.xx2_m81.msky130_fd_pr__nfet_01v8[weff]
echo OPV XX2_M81 weff $&s1_xx2_m81_weff
let s1_xx2_m81_leff = @m.x1.xdut.xx2_m81.msky130_fd_pr__nfet_01v8[leff]
echo OPV XX2_M81 leff $&s1_xx2_m81_leff
let s1_xx2_m28_id = @m.x1.xdut.xx2_m28.msky130_fd_pr__nfet_01v8[id]
echo OPV XX2_M28 id $&s1_xx2_m28_id
let s1_xx2_m28_vgs = @m.x1.xdut.xx2_m28.msky130_fd_pr__nfet_01v8[vgs]
echo OPV XX2_M28 vgs $&s1_xx2_m28_vgs
let s1_xx2_m28_vds = @m.x1.xdut.xx2_m28.msky130_fd_pr__nfet_01v8[vds]
echo OPV XX2_M28 vds $&s1_xx2_m28_vds
let s1_xx2_m28_vbs = @m.x1.xdut.xx2_m28.msky130_fd_pr__nfet_01v8[vbs]
echo OPV XX2_M28 vbs $&s1_xx2_m28_vbs
let s1_xx2_m28_vth = @m.x1.xdut.xx2_m28.msky130_fd_pr__nfet_01v8[vth]
echo OPV XX2_M28 vth $&s1_xx2_m28_vth
let s1_xx2_m28_vdsat = @m.x1.xdut.xx2_m28.msky130_fd_pr__nfet_01v8[vdsat]
echo OPV XX2_M28 vdsat $&s1_xx2_m28_vdsat
let s1_xx2_m28_gm = @m.x1.xdut.xx2_m28.msky130_fd_pr__nfet_01v8[gm]
echo OPV XX2_M28 gm $&s1_xx2_m28_gm
let s1_xx2_m28_gds = @m.x1.xdut.xx2_m28.msky130_fd_pr__nfet_01v8[gds]
echo OPV XX2_M28 gds $&s1_xx2_m28_gds
let s1_xx2_m28_gmbs = @m.x1.xdut.xx2_m28.msky130_fd_pr__nfet_01v8[gmbs]
echo OPV XX2_M28 gmbs $&s1_xx2_m28_gmbs
let s1_xx2_m28_cgg = @m.x1.xdut.xx2_m28.msky130_fd_pr__nfet_01v8[cgg]
echo OPV XX2_M28 cgg $&s1_xx2_m28_cgg
let s1_xx2_m28_cgd = @m.x1.xdut.xx2_m28.msky130_fd_pr__nfet_01v8[cgd]
echo OPV XX2_M28 cgd $&s1_xx2_m28_cgd
let s1_xx2_m28_cgs = @m.x1.xdut.xx2_m28.msky130_fd_pr__nfet_01v8[cgs]
echo OPV XX2_M28 cgs $&s1_xx2_m28_cgs
let s1_xx2_m28_cgb = @m.x1.xdut.xx2_m28.msky130_fd_pr__nfet_01v8[cgb]
echo OPV XX2_M28 cgb $&s1_xx2_m28_cgb
let s1_xx2_m28_cdg = @m.x1.xdut.xx2_m28.msky130_fd_pr__nfet_01v8[cdg]
echo OPV XX2_M28 cdg $&s1_xx2_m28_cdg
let s1_xx2_m28_cdd = @m.x1.xdut.xx2_m28.msky130_fd_pr__nfet_01v8[cdd]
echo OPV XX2_M28 cdd $&s1_xx2_m28_cdd
let s1_xx2_m28_cds = @m.x1.xdut.xx2_m28.msky130_fd_pr__nfet_01v8[cds]
echo OPV XX2_M28 cds $&s1_xx2_m28_cds
let s1_xx2_m28_cdb = @m.x1.xdut.xx2_m28.msky130_fd_pr__nfet_01v8[cdb]
echo OPV XX2_M28 cdb $&s1_xx2_m28_cdb
let s1_xx2_m28_csg = @m.x1.xdut.xx2_m28.msky130_fd_pr__nfet_01v8[csg]
echo OPV XX2_M28 csg $&s1_xx2_m28_csg
let s1_xx2_m28_csd = @m.x1.xdut.xx2_m28.msky130_fd_pr__nfet_01v8[csd]
echo OPV XX2_M28 csd $&s1_xx2_m28_csd
let s1_xx2_m28_css = @m.x1.xdut.xx2_m28.msky130_fd_pr__nfet_01v8[css]
echo OPV XX2_M28 css $&s1_xx2_m28_css
let s1_xx2_m28_csb = @m.x1.xdut.xx2_m28.msky130_fd_pr__nfet_01v8[csb]
echo OPV XX2_M28 csb $&s1_xx2_m28_csb
let s1_xx2_m28_cbg = @m.x1.xdut.xx2_m28.msky130_fd_pr__nfet_01v8[cbg]
echo OPV XX2_M28 cbg $&s1_xx2_m28_cbg
let s1_xx2_m28_cbd = @m.x1.xdut.xx2_m28.msky130_fd_pr__nfet_01v8[cbd]
echo OPV XX2_M28 cbd $&s1_xx2_m28_cbd
let s1_xx2_m28_cbs = @m.x1.xdut.xx2_m28.msky130_fd_pr__nfet_01v8[cbs]
echo OPV XX2_M28 cbs $&s1_xx2_m28_cbs
let s1_xx2_m28_cbb = @m.x1.xdut.xx2_m28.msky130_fd_pr__nfet_01v8[cbb]
echo OPV XX2_M28 cbb $&s1_xx2_m28_cbb
let s1_xx2_m28_capbd = @m.x1.xdut.xx2_m28.msky130_fd_pr__nfet_01v8[capbd]
echo OPV XX2_M28 capbd $&s1_xx2_m28_capbd
let s1_xx2_m28_capbs = @m.x1.xdut.xx2_m28.msky130_fd_pr__nfet_01v8[capbs]
echo OPV XX2_M28 capbs $&s1_xx2_m28_capbs
let s1_xx2_m28_cgso = @m.x1.xdut.xx2_m28.msky130_fd_pr__nfet_01v8[cgso]
echo OPV XX2_M28 cgso $&s1_xx2_m28_cgso
let s1_xx2_m28_cgdo = @m.x1.xdut.xx2_m28.msky130_fd_pr__nfet_01v8[cgdo]
echo OPV XX2_M28 cgdo $&s1_xx2_m28_cgdo
let s1_xx2_m28_cgbo = @m.x1.xdut.xx2_m28.msky130_fd_pr__nfet_01v8[cgbo]
echo OPV XX2_M28 cgbo $&s1_xx2_m28_cgbo
let s1_xx2_m28_weff = @m.x1.xdut.xx2_m28.msky130_fd_pr__nfet_01v8[weff]
echo OPV XX2_M28 weff $&s1_xx2_m28_weff
let s1_xx2_m28_leff = @m.x1.xdut.xx2_m28.msky130_fd_pr__nfet_01v8[leff]
echo OPV XX2_M28 leff $&s1_xx2_m28_leff
let s1_xm43_id = @m.x1.xdut.xm43.msky130_fd_pr__pfet_01v8_lvt[id]
echo OPV XM43 id $&s1_xm43_id
let s1_xm43_vgs = @m.x1.xdut.xm43.msky130_fd_pr__pfet_01v8_lvt[vgs]
echo OPV XM43 vgs $&s1_xm43_vgs
let s1_xm43_vds = @m.x1.xdut.xm43.msky130_fd_pr__pfet_01v8_lvt[vds]
echo OPV XM43 vds $&s1_xm43_vds
let s1_xm43_vbs = @m.x1.xdut.xm43.msky130_fd_pr__pfet_01v8_lvt[vbs]
echo OPV XM43 vbs $&s1_xm43_vbs
let s1_xm43_vth = @m.x1.xdut.xm43.msky130_fd_pr__pfet_01v8_lvt[vth]
echo OPV XM43 vth $&s1_xm43_vth
let s1_xm43_vdsat = @m.x1.xdut.xm43.msky130_fd_pr__pfet_01v8_lvt[vdsat]
echo OPV XM43 vdsat $&s1_xm43_vdsat
let s1_xm43_gm = @m.x1.xdut.xm43.msky130_fd_pr__pfet_01v8_lvt[gm]
echo OPV XM43 gm $&s1_xm43_gm
let s1_xm43_gds = @m.x1.xdut.xm43.msky130_fd_pr__pfet_01v8_lvt[gds]
echo OPV XM43 gds $&s1_xm43_gds
let s1_xm43_gmbs = @m.x1.xdut.xm43.msky130_fd_pr__pfet_01v8_lvt[gmbs]
echo OPV XM43 gmbs $&s1_xm43_gmbs
let s1_xm43_cgg = @m.x1.xdut.xm43.msky130_fd_pr__pfet_01v8_lvt[cgg]
echo OPV XM43 cgg $&s1_xm43_cgg
let s1_xm43_cgd = @m.x1.xdut.xm43.msky130_fd_pr__pfet_01v8_lvt[cgd]
echo OPV XM43 cgd $&s1_xm43_cgd
let s1_xm43_cgs = @m.x1.xdut.xm43.msky130_fd_pr__pfet_01v8_lvt[cgs]
echo OPV XM43 cgs $&s1_xm43_cgs
let s1_xm43_cgb = @m.x1.xdut.xm43.msky130_fd_pr__pfet_01v8_lvt[cgb]
echo OPV XM43 cgb $&s1_xm43_cgb
let s1_xm43_cdg = @m.x1.xdut.xm43.msky130_fd_pr__pfet_01v8_lvt[cdg]
echo OPV XM43 cdg $&s1_xm43_cdg
let s1_xm43_cdd = @m.x1.xdut.xm43.msky130_fd_pr__pfet_01v8_lvt[cdd]
echo OPV XM43 cdd $&s1_xm43_cdd
let s1_xm43_cds = @m.x1.xdut.xm43.msky130_fd_pr__pfet_01v8_lvt[cds]
echo OPV XM43 cds $&s1_xm43_cds
let s1_xm43_cdb = @m.x1.xdut.xm43.msky130_fd_pr__pfet_01v8_lvt[cdb]
echo OPV XM43 cdb $&s1_xm43_cdb
let s1_xm43_csg = @m.x1.xdut.xm43.msky130_fd_pr__pfet_01v8_lvt[csg]
echo OPV XM43 csg $&s1_xm43_csg
let s1_xm43_csd = @m.x1.xdut.xm43.msky130_fd_pr__pfet_01v8_lvt[csd]
echo OPV XM43 csd $&s1_xm43_csd
let s1_xm43_css = @m.x1.xdut.xm43.msky130_fd_pr__pfet_01v8_lvt[css]
echo OPV XM43 css $&s1_xm43_css
let s1_xm43_csb = @m.x1.xdut.xm43.msky130_fd_pr__pfet_01v8_lvt[csb]
echo OPV XM43 csb $&s1_xm43_csb
let s1_xm43_cbg = @m.x1.xdut.xm43.msky130_fd_pr__pfet_01v8_lvt[cbg]
echo OPV XM43 cbg $&s1_xm43_cbg
let s1_xm43_cbd = @m.x1.xdut.xm43.msky130_fd_pr__pfet_01v8_lvt[cbd]
echo OPV XM43 cbd $&s1_xm43_cbd
let s1_xm43_cbs = @m.x1.xdut.xm43.msky130_fd_pr__pfet_01v8_lvt[cbs]
echo OPV XM43 cbs $&s1_xm43_cbs
let s1_xm43_cbb = @m.x1.xdut.xm43.msky130_fd_pr__pfet_01v8_lvt[cbb]
echo OPV XM43 cbb $&s1_xm43_cbb
let s1_xm43_capbd = @m.x1.xdut.xm43.msky130_fd_pr__pfet_01v8_lvt[capbd]
echo OPV XM43 capbd $&s1_xm43_capbd
let s1_xm43_capbs = @m.x1.xdut.xm43.msky130_fd_pr__pfet_01v8_lvt[capbs]
echo OPV XM43 capbs $&s1_xm43_capbs
let s1_xm43_cgso = @m.x1.xdut.xm43.msky130_fd_pr__pfet_01v8_lvt[cgso]
echo OPV XM43 cgso $&s1_xm43_cgso
let s1_xm43_cgdo = @m.x1.xdut.xm43.msky130_fd_pr__pfet_01v8_lvt[cgdo]
echo OPV XM43 cgdo $&s1_xm43_cgdo
let s1_xm43_cgbo = @m.x1.xdut.xm43.msky130_fd_pr__pfet_01v8_lvt[cgbo]
echo OPV XM43 cgbo $&s1_xm43_cgbo
let s1_xm43_weff = @m.x1.xdut.xm43.msky130_fd_pr__pfet_01v8_lvt[weff]
echo OPV XM43 weff $&s1_xm43_weff
let s1_xm43_leff = @m.x1.xdut.xm43.msky130_fd_pr__pfet_01v8_lvt[leff]
echo OPV XM43 leff $&s1_xm43_leff
let s1_xm45_id = @m.x1.xdut.xm45.msky130_fd_pr__pfet_01v8[id]
echo OPV XM45 id $&s1_xm45_id
let s1_xm45_vgs = @m.x1.xdut.xm45.msky130_fd_pr__pfet_01v8[vgs]
echo OPV XM45 vgs $&s1_xm45_vgs
let s1_xm45_vds = @m.x1.xdut.xm45.msky130_fd_pr__pfet_01v8[vds]
echo OPV XM45 vds $&s1_xm45_vds
let s1_xm45_vbs = @m.x1.xdut.xm45.msky130_fd_pr__pfet_01v8[vbs]
echo OPV XM45 vbs $&s1_xm45_vbs
let s1_xm45_vth = @m.x1.xdut.xm45.msky130_fd_pr__pfet_01v8[vth]
echo OPV XM45 vth $&s1_xm45_vth
let s1_xm45_vdsat = @m.x1.xdut.xm45.msky130_fd_pr__pfet_01v8[vdsat]
echo OPV XM45 vdsat $&s1_xm45_vdsat
let s1_xm45_gm = @m.x1.xdut.xm45.msky130_fd_pr__pfet_01v8[gm]
echo OPV XM45 gm $&s1_xm45_gm
let s1_xm45_gds = @m.x1.xdut.xm45.msky130_fd_pr__pfet_01v8[gds]
echo OPV XM45 gds $&s1_xm45_gds
let s1_xm45_gmbs = @m.x1.xdut.xm45.msky130_fd_pr__pfet_01v8[gmbs]
echo OPV XM45 gmbs $&s1_xm45_gmbs
let s1_xm45_cgg = @m.x1.xdut.xm45.msky130_fd_pr__pfet_01v8[cgg]
echo OPV XM45 cgg $&s1_xm45_cgg
let s1_xm45_cgd = @m.x1.xdut.xm45.msky130_fd_pr__pfet_01v8[cgd]
echo OPV XM45 cgd $&s1_xm45_cgd
let s1_xm45_cgs = @m.x1.xdut.xm45.msky130_fd_pr__pfet_01v8[cgs]
echo OPV XM45 cgs $&s1_xm45_cgs
let s1_xm45_cgb = @m.x1.xdut.xm45.msky130_fd_pr__pfet_01v8[cgb]
echo OPV XM45 cgb $&s1_xm45_cgb
let s1_xm45_cdg = @m.x1.xdut.xm45.msky130_fd_pr__pfet_01v8[cdg]
echo OPV XM45 cdg $&s1_xm45_cdg
let s1_xm45_cdd = @m.x1.xdut.xm45.msky130_fd_pr__pfet_01v8[cdd]
echo OPV XM45 cdd $&s1_xm45_cdd
let s1_xm45_cds = @m.x1.xdut.xm45.msky130_fd_pr__pfet_01v8[cds]
echo OPV XM45 cds $&s1_xm45_cds
let s1_xm45_cdb = @m.x1.xdut.xm45.msky130_fd_pr__pfet_01v8[cdb]
echo OPV XM45 cdb $&s1_xm45_cdb
let s1_xm45_csg = @m.x1.xdut.xm45.msky130_fd_pr__pfet_01v8[csg]
echo OPV XM45 csg $&s1_xm45_csg
let s1_xm45_csd = @m.x1.xdut.xm45.msky130_fd_pr__pfet_01v8[csd]
echo OPV XM45 csd $&s1_xm45_csd
let s1_xm45_css = @m.x1.xdut.xm45.msky130_fd_pr__pfet_01v8[css]
echo OPV XM45 css $&s1_xm45_css
let s1_xm45_csb = @m.x1.xdut.xm45.msky130_fd_pr__pfet_01v8[csb]
echo OPV XM45 csb $&s1_xm45_csb
let s1_xm45_cbg = @m.x1.xdut.xm45.msky130_fd_pr__pfet_01v8[cbg]
echo OPV XM45 cbg $&s1_xm45_cbg
let s1_xm45_cbd = @m.x1.xdut.xm45.msky130_fd_pr__pfet_01v8[cbd]
echo OPV XM45 cbd $&s1_xm45_cbd
let s1_xm45_cbs = @m.x1.xdut.xm45.msky130_fd_pr__pfet_01v8[cbs]
echo OPV XM45 cbs $&s1_xm45_cbs
let s1_xm45_cbb = @m.x1.xdut.xm45.msky130_fd_pr__pfet_01v8[cbb]
echo OPV XM45 cbb $&s1_xm45_cbb
let s1_xm45_capbd = @m.x1.xdut.xm45.msky130_fd_pr__pfet_01v8[capbd]
echo OPV XM45 capbd $&s1_xm45_capbd
let s1_xm45_capbs = @m.x1.xdut.xm45.msky130_fd_pr__pfet_01v8[capbs]
echo OPV XM45 capbs $&s1_xm45_capbs
let s1_xm45_cgso = @m.x1.xdut.xm45.msky130_fd_pr__pfet_01v8[cgso]
echo OPV XM45 cgso $&s1_xm45_cgso
let s1_xm45_cgdo = @m.x1.xdut.xm45.msky130_fd_pr__pfet_01v8[cgdo]
echo OPV XM45 cgdo $&s1_xm45_cgdo
let s1_xm45_cgbo = @m.x1.xdut.xm45.msky130_fd_pr__pfet_01v8[cgbo]
echo OPV XM45 cgbo $&s1_xm45_cgbo
let s1_xm45_weff = @m.x1.xdut.xm45.msky130_fd_pr__pfet_01v8[weff]
echo OPV XM45 weff $&s1_xm45_weff
let s1_xm45_leff = @m.x1.xdut.xm45.msky130_fd_pr__pfet_01v8[leff]
echo OPV XM45 leff $&s1_xm45_leff
let s1_xm9_id = @m.x1.xdut.xm9.msky130_fd_pr__nfet_01v8[id]
echo OPV XM9 id $&s1_xm9_id
let s1_xm9_vgs = @m.x1.xdut.xm9.msky130_fd_pr__nfet_01v8[vgs]
echo OPV XM9 vgs $&s1_xm9_vgs
let s1_xm9_vds = @m.x1.xdut.xm9.msky130_fd_pr__nfet_01v8[vds]
echo OPV XM9 vds $&s1_xm9_vds
let s1_xm9_vbs = @m.x1.xdut.xm9.msky130_fd_pr__nfet_01v8[vbs]
echo OPV XM9 vbs $&s1_xm9_vbs
let s1_xm9_vth = @m.x1.xdut.xm9.msky130_fd_pr__nfet_01v8[vth]
echo OPV XM9 vth $&s1_xm9_vth
let s1_xm9_vdsat = @m.x1.xdut.xm9.msky130_fd_pr__nfet_01v8[vdsat]
echo OPV XM9 vdsat $&s1_xm9_vdsat
let s1_xm9_gm = @m.x1.xdut.xm9.msky130_fd_pr__nfet_01v8[gm]
echo OPV XM9 gm $&s1_xm9_gm
let s1_xm9_gds = @m.x1.xdut.xm9.msky130_fd_pr__nfet_01v8[gds]
echo OPV XM9 gds $&s1_xm9_gds
let s1_xm9_gmbs = @m.x1.xdut.xm9.msky130_fd_pr__nfet_01v8[gmbs]
echo OPV XM9 gmbs $&s1_xm9_gmbs
let s1_xm9_cgg = @m.x1.xdut.xm9.msky130_fd_pr__nfet_01v8[cgg]
echo OPV XM9 cgg $&s1_xm9_cgg
let s1_xm9_cgd = @m.x1.xdut.xm9.msky130_fd_pr__nfet_01v8[cgd]
echo OPV XM9 cgd $&s1_xm9_cgd
let s1_xm9_cgs = @m.x1.xdut.xm9.msky130_fd_pr__nfet_01v8[cgs]
echo OPV XM9 cgs $&s1_xm9_cgs
let s1_xm9_cgb = @m.x1.xdut.xm9.msky130_fd_pr__nfet_01v8[cgb]
echo OPV XM9 cgb $&s1_xm9_cgb
let s1_xm9_cdg = @m.x1.xdut.xm9.msky130_fd_pr__nfet_01v8[cdg]
echo OPV XM9 cdg $&s1_xm9_cdg
let s1_xm9_cdd = @m.x1.xdut.xm9.msky130_fd_pr__nfet_01v8[cdd]
echo OPV XM9 cdd $&s1_xm9_cdd
let s1_xm9_cds = @m.x1.xdut.xm9.msky130_fd_pr__nfet_01v8[cds]
echo OPV XM9 cds $&s1_xm9_cds
let s1_xm9_cdb = @m.x1.xdut.xm9.msky130_fd_pr__nfet_01v8[cdb]
echo OPV XM9 cdb $&s1_xm9_cdb
let s1_xm9_csg = @m.x1.xdut.xm9.msky130_fd_pr__nfet_01v8[csg]
echo OPV XM9 csg $&s1_xm9_csg
let s1_xm9_csd = @m.x1.xdut.xm9.msky130_fd_pr__nfet_01v8[csd]
echo OPV XM9 csd $&s1_xm9_csd
let s1_xm9_css = @m.x1.xdut.xm9.msky130_fd_pr__nfet_01v8[css]
echo OPV XM9 css $&s1_xm9_css
let s1_xm9_csb = @m.x1.xdut.xm9.msky130_fd_pr__nfet_01v8[csb]
echo OPV XM9 csb $&s1_xm9_csb
let s1_xm9_cbg = @m.x1.xdut.xm9.msky130_fd_pr__nfet_01v8[cbg]
echo OPV XM9 cbg $&s1_xm9_cbg
let s1_xm9_cbd = @m.x1.xdut.xm9.msky130_fd_pr__nfet_01v8[cbd]
echo OPV XM9 cbd $&s1_xm9_cbd
let s1_xm9_cbs = @m.x1.xdut.xm9.msky130_fd_pr__nfet_01v8[cbs]
echo OPV XM9 cbs $&s1_xm9_cbs
let s1_xm9_cbb = @m.x1.xdut.xm9.msky130_fd_pr__nfet_01v8[cbb]
echo OPV XM9 cbb $&s1_xm9_cbb
let s1_xm9_capbd = @m.x1.xdut.xm9.msky130_fd_pr__nfet_01v8[capbd]
echo OPV XM9 capbd $&s1_xm9_capbd
let s1_xm9_capbs = @m.x1.xdut.xm9.msky130_fd_pr__nfet_01v8[capbs]
echo OPV XM9 capbs $&s1_xm9_capbs
let s1_xm9_cgso = @m.x1.xdut.xm9.msky130_fd_pr__nfet_01v8[cgso]
echo OPV XM9 cgso $&s1_xm9_cgso
let s1_xm9_cgdo = @m.x1.xdut.xm9.msky130_fd_pr__nfet_01v8[cgdo]
echo OPV XM9 cgdo $&s1_xm9_cgdo
let s1_xm9_cgbo = @m.x1.xdut.xm9.msky130_fd_pr__nfet_01v8[cgbo]
echo OPV XM9 cgbo $&s1_xm9_cgbo
let s1_xm9_weff = @m.x1.xdut.xm9.msky130_fd_pr__nfet_01v8[weff]
echo OPV XM9 weff $&s1_xm9_weff
let s1_xm9_leff = @m.x1.xdut.xm9.msky130_fd_pr__nfet_01v8[leff]
echo OPV XM9 leff $&s1_xm9_leff
let s1i = i(vsup)
echo OPI isup $&s1i
let s1o = v(OUTP) - v(OUTN)
let s1cm = (v(OUTP) + v(OUTN)) / 2
echo OPI voutcm $&s1cm
echo OPI vout $&s1o
quit 0
.endc
**.ends

.subckt dut_amp INP INN OUTN VDD VSS OUTP
XDUT INP INN OUTP OUTN VDD VSS cmc_w cm_w bias_a_w iadc_ota
* ideal CMFB: the steady-state law of the upstream switched-capacitor CMFB (ASSUMPTION)
Bcmfb cmc_w VSS V = v(bias_a_w) + (v(OUTP) + v(OUTN))/2 - v(cm_w)
.ends

.subckt iadc_ota ip in op on VDD VSS cmc cm bias_a
Cbud_s2_0 bias_a VSS 1.87189f
Cbud_s2_1 bias_b VSS 1.52156f
Cbud_s2_2 bias_c VSS 1.02598f
Cbud_s2_3 bias_d VSS 1.2741f
Cbud_s2_4 cm VSS 257.284f
Cbud_s2_5 i_bias VSS 280.725f
Cbud_s2_6 on VSS 0.384671f
Cbud_s2_7 op VSS 0.384671f
Cbud_s2_8 x1_m21d VSS 0.146112f
Cbud_s2_9 x1_m25d VSS 0.169252f
Cbud_s2_10 x1_m2d VSS 0.834217f
Cbud_s2_11 x1_m31d VSS 0.119346f
Cbud_s2_12 x1_m5d VSS 187.821f
Cbud_s2_13 x1_net1 VSS 0.013103f
Cbud_s2_14 x1_net10 VSS 0.0130157f
Cbud_s2_15 x1_net11 VSS 7.70745f
Cbud_s2_16 x1_net12 VSS 0.181332f
Cbud_s2_17 x1_net13 VSS 0.0130157f
Cbud_s2_18 x1_net14 VSS 7.70976f
Cbud_s2_19 x1_net15 VSS 0.181332f
Cbud_s2_20 x1_net2 VSS 7.70976f
Cbud_s2_21 x1_net3 VSS 0.181332f
Cbud_s2_22 x1_net4 VSS 0.013103f
Cbud_s2_23 x1_net5 VSS 0.0131735f
Cbud_s2_24 x1_net6 VSS 8.31742f
Cbud_s2_25 x1_net7 VSS 0.013103f
Cbud_s2_26 x1_net8 VSS 0.0130465f
Cbud_s2_27 x1_net9 VSS 8.31742f
Cbud_s2_28 x2_foldn VSS 0.310813f
Cbud_s2_29 x2_foldp VSS 0.310813f
Cbud_s2_30 x2_m3d VSS 0.445965f
Cbud_s2_31 x2_m4d VSS 0.431969f
Cbud_s2_32 x2_tail VSS 738.605f
Cbud_s2_33 bias_a bias_b 0.0669285f
Cbud_s2_34 bias_a bias_c 0.0530988f
Cbud_s2_35 bias_a bias_d 0.0820457f
Cbud_s2_36 bias_a cm 0.0285369f
Cbud_s2_37 bias_a i_bias 0.0198572f
Cbud_s2_38 bias_a on 0.0323608f
Cbud_s2_39 bias_a op 0.0323608f
Cbud_s2_40 bias_a x1_m21d 0.0105999f
Cbud_s2_41 bias_a x1_m25d 0.012282f
Cbud_s2_42 bias_a x1_m2d 0.0452199f
Cbud_s2_43 bias_a x1_m31d 0.00855443f
Cbud_s2_44 bias_a x1_m5d 33.1724f
Cbud_s2_45 bias_a x1_net1 0.00136837f
Cbud_s2_46 bias_a x1_net10 0.00136837f
Cbud_s2_47 bias_a x1_net11 0.00136838f
Cbud_s2_48 bias_a x1_net12 0.00136838f
Cbud_s2_49 bias_a x1_net13 0.00136837f
Cbud_s2_50 bias_a x1_net14 0.00136838f
Cbud_s2_51 bias_a x1_net15 0.00136838f
Cbud_s2_52 bias_a x1_net2 0.00136838f
Cbud_s2_53 bias_a x1_net3 0.00136838f
Cbud_s2_54 bias_a x1_net4 0.00136837f
Cbud_s2_55 bias_a x1_net5 0.00136838f
Cbud_s2_56 bias_a x1_net6 0.00136838f
Cbud_s2_57 bias_a x1_net7 0.00136837f
Cbud_s2_58 bias_a x1_net8 0.00136838f
Cbud_s2_59 bias_a x1_net9 0.00136838f
Cbud_s2_60 bias_a x2_foldn 0.0228281f
Cbud_s2_61 bias_a x2_foldp 0.0228281f
Cbud_s2_62 bias_a x2_m3d 0.0683082f
Cbud_s2_63 bias_a x2_m4d 0.0676322f
Cbud_s2_64 bias_a x2_tail 0.158962f
Cbud_s2_65 bias_a ip 0.00226553f
Cbud_s2_66 bias_a in 0.00195525f
Cbud_s2_67 bias_b bias_c 0.169367f
Cbud_s2_68 bias_b bias_d 0.0597454f
Cbud_s2_69 bias_b cm 17.1082f
Cbud_s2_70 bias_b i_bias 11.9046f
Cbud_s2_71 bias_b on 0.0323608f
Cbud_s2_72 bias_b op 0.0323608f
Cbud_s2_73 bias_b x1_m21d 0.0226837f
Cbud_s2_74 bias_b x1_m25d 0.0189329f
Cbud_s2_75 bias_b x1_m2d 0.0430031f
Cbud_s2_76 bias_b x1_m31d 8.56958f
Cbud_s2_77 bias_b x1_m5d 11.9046f
Cbud_s2_78 bias_b x1_net1 0.00158159f
Cbud_s2_79 bias_b x1_net10 0.00137589f
Cbud_s2_80 bias_b x1_net11 0.00162641f
Cbud_s2_81 bias_b x1_net12 0.00138759f
Cbud_s2_82 bias_b x1_net13 0.00158159f
Cbud_s2_83 bias_b x1_net14 0.00137938f
Cbud_s2_84 bias_b x1_net15 0.00138759f
Cbud_s2_85 bias_b x1_net2 0.00137938f
Cbud_s2_86 bias_b x1_net3 0.00138759f
Cbud_s2_87 bias_b x1_net4 0.00158159f
Cbud_s2_88 bias_b x1_net5 0.00143674f
Cbud_s2_89 bias_b x1_net6 0.00172958f
Cbud_s2_90 bias_b x1_net7 0.00158159f
Cbud_s2_91 bias_b x1_net8 0.00137938f
Cbud_s2_92 bias_b x1_net9 0.00172958f
Cbud_s2_93 bias_b x2_foldn 0.0457874f
Cbud_s2_94 bias_b x2_foldp 0.0457874f
Cbud_s2_95 bias_b x2_m3d 0.028404f
Cbud_s2_96 bias_b x2_m4d 0.027728f
Cbud_s2_97 bias_b x2_tail 40.1245f
Cbud_s2_98 bias_b ip 0.00226553f
Cbud_s2_99 bias_b in 0.00195525f
Cbud_s2_100 bias_c bias_d 0.0597454f
Cbud_s2_101 bias_c cm 0.034312f
Cbud_s2_102 bias_c i_bias 0.0370876f
Cbud_s2_103 bias_c on 0.0445388f
Cbud_s2_104 bias_c op 0.0445388f
Cbud_s2_105 bias_c x1_m21d 0.0163995f
Cbud_s2_106 bias_c x1_m25d 0.0189329f
Cbud_s2_107 bias_c x1_m2d 0.0496538f
Cbud_s2_108 bias_c x1_m31d 0.0143528f
Cbud_s2_109 bias_c x1_m5d 11.9046f
Cbud_s2_110 bias_c x1_net1 0.00138806f
Cbud_s2_111 bias_c x1_net10 0.00138806f
Cbud_s2_112 bias_c x1_net11 0.00139417f
Cbud_s2_113 bias_c x1_net12 0.00138788f
Cbud_s2_114 bias_c x1_net13 0.00138806f
Cbud_s2_115 bias_c x1_net14 0.00140076f
Cbud_s2_116 bias_c x1_net15 0.00138788f
Cbud_s2_117 bias_c x1_net2 0.00140076f
Cbud_s2_118 bias_c x1_net3 0.00138788f
Cbud_s2_119 bias_c x1_net4 0.0013832f
Cbud_s2_120 bias_c x1_net5 0.00140076f
Cbud_s2_121 bias_c x1_net6 0.00138771f
Cbud_s2_122 bias_c x1_net7 0.0013832f
Cbud_s2_123 bias_c x1_net8 0.00139417f
Cbud_s2_124 bias_c x1_net9 0.00138771f
Cbud_s2_125 bias_c x2_foldn 0.0333381f
Cbud_s2_126 bias_c x2_foldp 0.0333381f
Cbud_s2_127 bias_c x2_m3d 0.028404f
Cbud_s2_128 bias_c x2_m4d 0.027728f
Cbud_s2_129 bias_c x2_tail 31.8427f
Cbud_s2_130 bias_c ip 0.00226553f
Cbud_s2_131 bias_c in 0.00195525f
Cbud_s2_132 bias_d cm 0.0330654f
Cbud_s2_133 bias_d i_bias 0.0230083f
Cbud_s2_134 bias_d on 0.072265f
Cbud_s2_135 bias_d op 0.072265f
Cbud_s2_136 bias_d x1_m21d 0.0122819f
Cbud_s2_137 bias_d x1_m25d 0.012282f
Cbud_s2_138 bias_d x1_m2d 0.159347f
Cbud_s2_139 bias_d x1_m31d 0.00991189f
Cbud_s2_140 bias_d x1_m5d 0.0429604f
Cbud_s2_141 bias_d x1_net1 0.00158549f
Cbud_s2_142 bias_d x1_net10 0.00158549f
Cbud_s2_143 bias_d x1_net11 0.00158549f
Cbud_s2_144 bias_d x1_net12 0.00158549f
Cbud_s2_145 bias_d x1_net13 0.00158549f
Cbud_s2_146 bias_d x1_net14 0.00158549f
Cbud_s2_147 bias_d x1_net15 0.00158549f
Cbud_s2_148 bias_d x1_net2 0.00158549f
Cbud_s2_149 bias_d x1_net3 0.00158549f
Cbud_s2_150 bias_d x1_net4 0.00158549f
Cbud_s2_151 bias_d x1_net5 0.00158549f
Cbud_s2_152 bias_d x1_net6 0.00158549f
Cbud_s2_153 bias_d x1_net7 0.00158549f
Cbud_s2_154 bias_d x1_net8 0.00158549f
Cbud_s2_155 bias_d x1_net9 0.00158549f
Cbud_s2_156 bias_d x2_foldn 0.0228281f
Cbud_s2_157 bias_d x2_foldp 0.0228281f
Cbud_s2_158 bias_d x2_m3d 0.0683082f
Cbud_s2_159 bias_d x2_m4d 0.0676322f
Cbud_s2_160 bias_d x2_tail 0.0597454f
Cbud_s2_161 bias_d ip 0.00226553f
Cbud_s2_162 bias_d in 0.00195525f
Cbud_s2_163 cm i_bias 0.0198768f
Cbud_s2_164 cm on 0.0323608f
Cbud_s2_165 cm op 0.0323608f
Cbud_s2_166 cm x1_m21d 0.0115278f
Cbud_s2_167 cm x1_m25d 0.0122822f
Cbud_s2_168 cm x1_m2d 0.0330655f
Cbud_s2_169 cm x1_m31d 0.0146458f
Cbud_s2_170 cm x1_m5d 11.9081f
Cbud_s2_171 cm x1_net1 2.57561f
Cbud_s2_172 cm x1_net10 0.140053f
Cbud_s2_173 cm x1_net11 0.157216f
Cbud_s2_174 cm x1_net12 1.96735f
Cbud_s2_175 cm x1_net13 0.140053f
Cbud_s2_176 cm x1_net14 0.0698765f
Cbud_s2_177 cm x1_net15 1.96735f
Cbud_s2_178 cm x1_net2 0.0698765f
Cbud_s2_179 cm x1_net3 1.96735f
Cbud_s2_180 cm x1_net4 0.0693947f
Cbud_s2_181 cm x1_net5 1.96794f
Cbud_s2_182 cm x1_net6 1.96735f
Cbud_s2_183 cm x1_net7 0.0693947f
Cbud_s2_184 cm x1_net8 0.157216f
Cbud_s2_185 cm x1_net9 1.96735f
Cbud_s2_186 cm x2_foldn 0.0228281f
Cbud_s2_187 cm x2_foldp 0.0228281f
Cbud_s2_188 cm x2_m3d 0.028404f
Cbud_s2_189 cm x2_m4d 0.027728f
Cbud_s2_190 cm x2_tail 0.0332831f
Cbud_s2_191 cm ip 0.00226553f
Cbud_s2_192 cm in 0.00195525f
Cbud_s2_193 i_bias on 0.0230082f
Cbud_s2_194 i_bias op 0.0230082f
Cbud_s2_195 i_bias x1_m21d 0.0106226f
Cbud_s2_196 i_bias x1_m25d 0.0122822f
Cbud_s2_197 i_bias x1_m2d 0.0230084f
Cbud_s2_198 i_bias x1_m31d 0.00859366f
Cbud_s2_199 i_bias x1_m5d 11.9046f
Cbud_s2_200 i_bias x1_net1 0.00428087f
Cbud_s2_201 i_bias x1_net10 0.00428087f
Cbud_s2_202 i_bias x1_net11 0.00497466f
Cbud_s2_203 i_bias x1_net12 0.0058933f
Cbud_s2_204 i_bias x1_net13 0.00428087f
Cbud_s2_205 i_bias x1_net14 0.00473095f
Cbud_s2_206 i_bias x1_net15 0.0058933f
Cbud_s2_207 i_bias x1_net2 0.00473095f
Cbud_s2_208 i_bias x1_net3 0.0058933f
Cbud_s2_209 i_bias x1_net4 0.00428087f
Cbud_s2_210 i_bias x1_net5 0.0048556f
Cbud_s2_211 i_bias x1_net6 0.00589357f
Cbud_s2_212 i_bias x1_net7 0.00428088f
Cbud_s2_213 i_bias x1_net8 0.00497466f
Cbud_s2_214 i_bias x1_net9 0.00589384f
Cbud_s2_215 i_bias x2_foldn 0.0198571f
Cbud_s2_216 i_bias x2_foldp 0.0198571f
Cbud_s2_217 i_bias x2_m3d 0.0230082f
Cbud_s2_218 i_bias x2_m4d 0.0230082f
Cbud_s2_219 i_bias x2_tail 0.0198624f
Cbud_s2_220 i_bias ip 0.00195525f
Cbud_s2_221 i_bias in 0.00226553f
Cbud_s2_222 on op 0.0323608f
Cbud_s2_223 on x1_m21d 0.0122819f
Cbud_s2_224 on x1_m25d 0.0122819f
Cbud_s2_225 on x1_m2d 0.0323608f
Cbud_s2_226 on x1_m31d 0.00991187f
Cbud_s2_227 on x1_m5d 0.0230082f
Cbud_s2_228 on x1_net1 0.00158546f
Cbud_s2_229 on x1_net10 0.00158546f
Cbud_s2_230 on x1_net11 0.00158546f
Cbud_s2_231 on x1_net12 0.00158546f
Cbud_s2_232 on x1_net13 0.00158546f
Cbud_s2_233 on x1_net14 0.00158546f
Cbud_s2_234 on x1_net15 0.00158546f
Cbud_s2_235 on x1_net2 0.00158546f
Cbud_s2_236 on x1_net3 0.00158546f
Cbud_s2_237 on x1_net4 0.00158546f
Cbud_s2_238 on x1_net5 0.00158546f
Cbud_s2_239 on x1_net6 0.00158546f
Cbud_s2_240 on x1_net7 0.00158546f
Cbud_s2_241 on x1_net8 0.00158546f
Cbud_s2_242 on x1_net9 0.00158546f
Cbud_s2_243 on x2_foldn 0.0228281f
Cbud_s2_244 on x2_foldp 0.039337f
Cbud_s2_245 on x2_m3d 0.0609925f
Cbud_s2_246 on x2_m4d 0.027728f
Cbud_s2_247 on x2_tail 0.0323608f
Cbud_s2_248 on ip 0.00195525f
Cbud_s2_249 on in 0.00226553f
Cbud_s2_250 op x1_m21d 0.0122819f
Cbud_s2_251 op x1_m25d 0.0122819f
Cbud_s2_252 op x1_m2d 0.0323608f
Cbud_s2_253 op x1_m31d 0.00991187f
Cbud_s2_254 op x1_m5d 0.0230082f
Cbud_s2_255 op x1_net1 0.00158546f
Cbud_s2_256 op x1_net10 0.00158546f
Cbud_s2_257 op x1_net11 0.00158546f
Cbud_s2_258 op x1_net12 0.00158546f
Cbud_s2_259 op x1_net13 0.00158546f
Cbud_s2_260 op x1_net14 0.00158546f
Cbud_s2_261 op x1_net15 0.00158546f
Cbud_s2_262 op x1_net2 0.00158546f
Cbud_s2_263 op x1_net3 0.00158546f
Cbud_s2_264 op x1_net4 0.00158546f
Cbud_s2_265 op x1_net5 0.00158546f
Cbud_s2_266 op x1_net6 0.00158546f
Cbud_s2_267 op x1_net7 0.00158546f
Cbud_s2_268 op x1_net8 0.00158546f
Cbud_s2_269 op x1_net9 0.00158546f
Cbud_s2_270 op x2_foldn 0.039337f
Cbud_s2_271 op x2_foldp 0.0228281f
Cbud_s2_272 op x2_m3d 0.028404f
Cbud_s2_273 op x2_m4d 0.060409f
Cbud_s2_274 op x2_tail 0.0323608f
Cbud_s2_275 op ip 0.00226553f
Cbud_s2_276 op in 0.00195525f
Cbud_s2_277 x1_m21d x1_m25d 0.0122822f
Cbud_s2_278 x1_m21d x1_m2d 0.012282f
Cbud_s2_279 x1_m21d x1_m31d 0.145422f
Cbud_s2_280 x1_m21d x1_m5d 6.35475f
Cbud_s2_281 x1_m21d x1_net1 0.00548775f
Cbud_s2_282 x1_m21d x1_net10 0.00561701f
Cbud_s2_283 x1_m21d x1_net11 0.00190807f
Cbud_s2_284 x1_m21d x1_net12 0.00197157f
Cbud_s2_285 x1_m21d x1_net13 0.00548775f
Cbud_s2_286 x1_m21d x1_net14 0.00174873f
Cbud_s2_287 x1_m21d x1_net15 0.00197157f
Cbud_s2_288 x1_m21d x1_net2 0.00174873f
Cbud_s2_289 x1_m21d x1_net3 0.00197157f
Cbud_s2_290 x1_m21d x1_net4 0.00561701f
Cbud_s2_291 x1_m21d x1_net5 0.00174873f
Cbud_s2_292 x1_m21d x1_net6 0.00197157f
Cbud_s2_293 x1_m21d x1_net7 0.00548774f
Cbud_s2_294 x1_m21d x1_net8 0.00174399f
Cbud_s2_295 x1_m21d x1_net9 0.00197157f
Cbud_s2_296 x1_m21d x2_foldn 0.0105998f
Cbud_s2_297 x1_m21d x2_foldp 0.0105998f
Cbud_s2_298 x1_m21d x2_m3d 0.0122819f
Cbud_s2_299 x1_m21d x2_m4d 0.0122819f
Cbud_s2_300 x1_m21d x2_tail 6.3566f
Cbud_s2_301 x1_m21d ip 0.00226553f
Cbud_s2_302 x1_m21d in 0.00195525f
Cbud_s2_303 x1_m25d x1_m2d 0.0193281f
Cbud_s2_304 x1_m25d x1_m31d 0.00991214f
Cbud_s2_305 x1_m25d x1_m5d 0.0106001f
Cbud_s2_306 x1_m25d x1_net1 0.00158576f
Cbud_s2_307 x1_m25d x1_net10 0.00158576f
Cbud_s2_308 x1_m25d x1_net11 0.00158576f
Cbud_s2_309 x1_m25d x1_net12 0.00158576f
Cbud_s2_310 x1_m25d x1_net13 0.00158576f
Cbud_s2_311 x1_m25d x1_net14 0.00158576f
Cbud_s2_312 x1_m25d x1_net15 0.00158576f
Cbud_s2_313 x1_m25d x1_net2 0.00158576f
Cbud_s2_314 x1_m25d x1_net3 0.00158576f
Cbud_s2_315 x1_m25d x1_net4 0.00158576f
Cbud_s2_316 x1_m25d x1_net5 0.00158576f
Cbud_s2_317 x1_m25d x1_net6 0.00158576f
Cbud_s2_318 x1_m25d x1_net7 0.00158576f
Cbud_s2_319 x1_m25d x1_net8 0.00158576f
Cbud_s2_320 x1_m25d x1_net9 0.00158576f
Cbud_s2_321 x1_m25d x2_foldn 0.0105998f
Cbud_s2_322 x1_m25d x2_foldp 0.0105998f
Cbud_s2_323 x1_m25d x2_m3d 0.0122819f
Cbud_s2_324 x1_m25d x2_m4d 0.0122819f
Cbud_s2_325 x1_m25d x2_tail 0.0122822f
Cbud_s2_326 x1_m25d ip 0.00226553f
Cbud_s2_327 x1_m25d in 0.00195525f
Cbud_s2_328 x1_m2d x1_m31d 0.00991199f
Cbud_s2_329 x1_m2d x1_m5d 0.0230103f
Cbud_s2_330 x1_m2d x1_net1 0.00158559f
Cbud_s2_331 x1_m2d x1_net10 0.00158559f
Cbud_s2_332 x1_m2d x1_net11 0.00158559f
Cbud_s2_333 x1_m2d x1_net12 0.00158559f
Cbud_s2_334 x1_m2d x1_net13 0.00158559f
Cbud_s2_335 x1_m2d x1_net14 0.00158559f
Cbud_s2_336 x1_m2d x1_net15 0.00158559f
Cbud_s2_337 x1_m2d x1_net2 0.00158559f
Cbud_s2_338 x1_m2d x1_net3 0.00158559f
Cbud_s2_339 x1_m2d x1_net4 0.00158559f
Cbud_s2_340 x1_m2d x1_net5 0.00158559f
Cbud_s2_341 x1_m2d x1_net6 0.00158559f
Cbud_s2_342 x1_m2d x1_net7 0.00158559f
Cbud_s2_343 x1_m2d x1_net8 0.00158559f
Cbud_s2_344 x1_m2d x1_net9 0.00158559f
Cbud_s2_345 x1_m2d x2_foldn 0.0228281f
Cbud_s2_346 x1_m2d x2_foldp 0.0228281f
Cbud_s2_347 x1_m2d x2_m3d 0.028404f
Cbud_s2_348 x1_m2d x2_m4d 0.027728f
Cbud_s2_349 x1_m2d x2_tail 0.0430031f
Cbud_s2_350 x1_m2d ip 0.00226553f
Cbud_s2_351 x1_m2d in 0.00195525f
Cbud_s2_352 x1_m31d x1_m5d 5.12847f
Cbud_s2_353 x1_m31d x1_net1 0.00609298f
Cbud_s2_354 x1_m31d x1_net10 0.00609298f
Cbud_s2_355 x1_m31d x1_net11 0.006783f
Cbud_s2_356 x1_m31d x1_net12 0.00829841f
Cbud_s2_357 x1_m31d x1_net13 0.00633146f
Cbud_s2_358 x1_m31d x1_net14 0.00708993f
Cbud_s2_359 x1_m31d x1_net15 0.00829841f
Cbud_s2_360 x1_m31d x1_net2 0.00708993f
Cbud_s2_361 x1_m31d x1_net3 0.00829841f
Cbud_s2_362 x1_m31d x1_net4 0.00620453f
Cbud_s2_363 x1_m31d x1_net5 0.00708993f
Cbud_s2_364 x1_m31d x1_net6 0.00743782f
Cbud_s2_365 x1_m31d x1_net7 0.00633146f
Cbud_s2_366 x1_m31d x1_net8 0.00708993f
Cbud_s2_367 x1_m31d x1_net9 0.00743782f
Cbud_s2_368 x1_m31d x2_foldn 0.00855437f
Cbud_s2_369 x1_m31d x2_foldp 0.00855437f
Cbud_s2_370 x1_m31d x2_m3d 0.00991187f
Cbud_s2_371 x1_m31d x2_m4d 0.00991187f
Cbud_s2_372 x1_m31d x2_tail 0.00860755f
Cbud_s2_373 x1_m31d ip 0.00195525f
Cbud_s2_374 x1_m31d in 1.17254f
Cbud_s2_375 x1_m5d x1_net1 0.82057f
Cbud_s2_376 x1_m5d x1_net10 0.82057f
Cbud_s2_377 x1_m5d x1_net11 0.82057f
Cbud_s2_378 x1_m5d x1_net12 0.82057f
Cbud_s2_379 x1_m5d x1_net13 0.82057f
Cbud_s2_380 x1_m5d x1_net14 0.82057f
Cbud_s2_381 x1_m5d x1_net15 0.82057f
Cbud_s2_382 x1_m5d x1_net2 0.82057f
Cbud_s2_383 x1_m5d x1_net3 0.82057f
Cbud_s2_384 x1_m5d x1_net4 0.82057f
Cbud_s2_385 x1_m5d x1_net5 0.82057f
Cbud_s2_386 x1_m5d x1_net6 0.82057f
Cbud_s2_387 x1_m5d x1_net7 0.82057f
Cbud_s2_388 x1_m5d x1_net8 0.82057f
Cbud_s2_389 x1_m5d x1_net9 0.82057f
Cbud_s2_390 x1_m5d x2_foldn 0.0198571f
Cbud_s2_391 x1_m5d x2_foldp 0.0198571f
Cbud_s2_392 x1_m5d x2_m3d 0.0230082f
Cbud_s2_393 x1_m5d x2_m4d 0.0230082f
Cbud_s2_394 x1_m5d x2_tail 11.9081f
Cbud_s2_395 x1_m5d ip 0.00226553f
Cbud_s2_396 x1_m5d in 0.00195525f
Cbud_s2_397 x1_net1 x1_net10 0.00651122f
Cbud_s2_398 x1_net1 x1_net11 0.82057f
Cbud_s2_399 x1_net1 x1_net12 0.82057f
Cbud_s2_400 x1_net1 x1_net13 0.00651122f
Cbud_s2_401 x1_net1 x1_net14 0.82057f
Cbud_s2_402 x1_net1 x1_net15 0.82057f
Cbud_s2_403 x1_net1 x1_net2 1.42823f
Cbud_s2_404 x1_net1 x1_net3 0.00651122f
Cbud_s2_405 x1_net1 x1_net4 0.00651122f
Cbud_s2_406 x1_net1 x1_net5 0.82057f
Cbud_s2_407 x1_net1 x1_net6 0.823374f
Cbud_s2_408 x1_net1 x1_net7 0.00637152f
Cbud_s2_409 x1_net1 x1_net8 0.82057f
Cbud_s2_410 x1_net1 x1_net9 0.823374f
Cbud_s2_411 x1_net1 x2_foldn 0.00136832f
Cbud_s2_412 x1_net1 x2_foldp 0.00136832f
Cbud_s2_413 x1_net1 x2_m3d 0.00158546f
Cbud_s2_414 x1_net1 x2_m4d 0.00158546f
Cbud_s2_415 x1_net1 x2_tail 0.0148796f
Cbud_s2_416 x1_net1 ip 0.00158547f
Cbud_s2_417 x1_net1 in 0.00136832f
Cbud_s2_418 x1_net10 x1_net11 1.42823f
Cbud_s2_419 x1_net10 x1_net12 0.00633146f
Cbud_s2_420 x1_net10 x1_net13 0.82057f
Cbud_s2_421 x1_net10 x1_net14 0.82057f
Cbud_s2_422 x1_net10 x1_net15 0.823374f
Cbud_s2_423 x1_net10 x1_net2 0.82057f
Cbud_s2_424 x1_net10 x1_net3 0.823374f
Cbud_s2_425 x1_net10 x1_net4 0.00651122f
Cbud_s2_426 x1_net10 x1_net5 0.82057f
Cbud_s2_427 x1_net10 x1_net6 0.82057f
Cbud_s2_428 x1_net10 x1_net7 0.00637152f
Cbud_s2_429 x1_net10 x1_net8 0.82057f
Cbud_s2_430 x1_net10 x1_net9 0.82057f
Cbud_s2_431 x1_net10 x2_foldn 0.00136832f
Cbud_s2_432 x1_net10 x2_foldp 0.00136832f
Cbud_s2_433 x1_net10 x2_m3d 0.00158546f
Cbud_s2_434 x1_net10 x2_m4d 0.00158546f
Cbud_s2_435 x1_net10 x2_tail 0.0148796f
Cbud_s2_436 x1_net10 ip 0.00158547f
Cbud_s2_437 x1_net10 in 0.00136832f
Cbud_s2_438 x1_net11 x1_net12 1.42823f
Cbud_s2_439 x1_net11 x1_net13 0.82057f
Cbud_s2_440 x1_net11 x1_net14 0.82057f
Cbud_s2_441 x1_net11 x1_net15 0.82057f
Cbud_s2_442 x1_net11 x1_net2 0.82057f
Cbud_s2_443 x1_net11 x1_net3 0.82057f
Cbud_s2_444 x1_net11 x1_net4 0.82057f
Cbud_s2_445 x1_net11 x1_net5 0.82057f
Cbud_s2_446 x1_net11 x1_net6 0.82057f
Cbud_s2_447 x1_net11 x1_net7 0.82057f
Cbud_s2_448 x1_net11 x1_net8 0.82057f
Cbud_s2_449 x1_net11 x1_net9 0.82057f
Cbud_s2_450 x1_net11 x2_foldn 0.00136832f
Cbud_s2_451 x1_net11 x2_foldp 0.00136832f
Cbud_s2_452 x1_net11 x2_m3d 0.00158546f
Cbud_s2_453 x1_net11 x2_m4d 0.00158546f
Cbud_s2_454 x1_net11 x2_tail 0.0148796f
Cbud_s2_455 x1_net11 ip 0.00158547f
Cbud_s2_456 x1_net11 in 0.00136833f
Cbud_s2_457 x1_net12 x1_net13 0.823374f
Cbud_s2_458 x1_net12 x1_net14 0.82057f
Cbud_s2_459 x1_net12 x1_net2 0.82057f
Cbud_s2_460 x1_net12 x1_net4 0.00637152f
Cbud_s2_461 x1_net12 x1_net5 0.823374f
Cbud_s2_462 x1_net12 x1_net6 0.82057f
Cbud_s2_463 x1_net12 x1_net7 0.823374f
Cbud_s2_464 x1_net12 x1_net8 0.823374f
Cbud_s2_465 x1_net12 x1_net9 0.82057f
Cbud_s2_466 x1_net12 x2_foldn 0.00136832f
Cbud_s2_467 x1_net12 x2_foldp 0.00136832f
Cbud_s2_468 x1_net12 x2_m3d 0.00158546f
Cbud_s2_469 x1_net12 x2_m4d 0.00158546f
Cbud_s2_470 x1_net12 x2_tail 0.82057f
Cbud_s2_471 x1_net12 ip 0.00158547f
Cbud_s2_472 x1_net12 in 0.00136833f
Cbud_s2_473 x1_net13 x1_net14 0.00813622f
Cbud_s2_474 x1_net13 x1_net15 0.00633146f
Cbud_s2_475 x1_net13 x1_net2 0.82057f
Cbud_s2_476 x1_net13 x1_net3 0.823374f
Cbud_s2_477 x1_net13 x1_net4 0.00651122f
Cbud_s2_478 x1_net13 x1_net5 0.82057f
Cbud_s2_479 x1_net13 x1_net6 0.82057f
Cbud_s2_480 x1_net13 x1_net7 0.82057f
Cbud_s2_481 x1_net13 x1_net8 0.82057f
Cbud_s2_482 x1_net13 x1_net9 0.82057f
Cbud_s2_483 x1_net13 x2_foldn 0.00136832f
Cbud_s2_484 x1_net13 x2_foldp 0.00136832f
Cbud_s2_485 x1_net13 x2_m3d 0.00158546f
Cbud_s2_486 x1_net13 x2_m4d 0.00158546f
Cbud_s2_487 x1_net13 x2_tail 0.0148796f
Cbud_s2_488 x1_net13 ip 0.00158547f
Cbud_s2_489 x1_net13 in 0.00136832f
Cbud_s2_490 x1_net14 x1_net15 0.00864078f
Cbud_s2_491 x1_net14 x1_net3 0.82057f
Cbud_s2_492 x1_net14 x1_net4 0.82057f
Cbud_s2_493 x1_net14 x1_net5 0.82057f
Cbud_s2_494 x1_net14 x1_net6 0.820324f
Cbud_s2_495 x1_net14 x1_net7 0.82057f
Cbud_s2_496 x1_net14 x1_net8 0.82057f
Cbud_s2_497 x1_net14 x1_net9 0.820324f
Cbud_s2_498 x1_net14 x2_foldn 0.00136832f
Cbud_s2_499 x1_net14 x2_foldp 0.00136832f
Cbud_s2_500 x1_net14 x2_m3d 0.00158546f
Cbud_s2_501 x1_net14 x2_m4d 0.00158546f
Cbud_s2_502 x1_net14 x2_tail 0.0148796f
Cbud_s2_503 x1_net14 ip 0.00158547f
Cbud_s2_504 x1_net14 in 0.00136833f
Cbud_s2_505 x1_net15 x1_net2 0.82057f
Cbud_s2_506 x1_net15 x1_net4 0.00637152f
Cbud_s2_507 x1_net15 x1_net5 0.823374f
Cbud_s2_508 x1_net15 x1_net6 0.82057f
Cbud_s2_509 x1_net15 x1_net7 0.823374f
Cbud_s2_510 x1_net15 x1_net8 0.823374f
Cbud_s2_511 x1_net15 x1_net9 0.82057f
Cbud_s2_512 x1_net15 x2_foldn 0.00136832f
Cbud_s2_513 x1_net15 x2_foldp 0.00136832f
Cbud_s2_514 x1_net15 x2_m3d 0.00158546f
Cbud_s2_515 x1_net15 x2_m4d 0.00158546f
Cbud_s2_516 x1_net15 x2_tail 0.82057f
Cbud_s2_517 x1_net15 ip 0.00158547f
Cbud_s2_518 x1_net15 in 0.00136833f
Cbud_s2_519 x1_net2 x1_net3 0.00864078f
Cbud_s2_520 x1_net2 x1_net4 0.82057f
Cbud_s2_521 x1_net2 x1_net5 0.82057f
Cbud_s2_522 x1_net2 x1_net6 0.820324f
Cbud_s2_523 x1_net2 x1_net7 0.82057f
Cbud_s2_524 x1_net2 x1_net8 0.82057f
Cbud_s2_525 x1_net2 x1_net9 0.820324f
Cbud_s2_526 x1_net2 x2_foldn 0.00136832f
Cbud_s2_527 x1_net2 x2_foldp 0.00136832f
Cbud_s2_528 x1_net2 x2_m3d 0.00158546f
Cbud_s2_529 x1_net2 x2_m4d 0.00158546f
Cbud_s2_530 x1_net2 x2_tail 0.0148796f
Cbud_s2_531 x1_net2 ip 0.00158547f
Cbud_s2_532 x1_net2 in 0.00136833f
Cbud_s2_533 x1_net3 x1_net4 0.00637152f
Cbud_s2_534 x1_net3 x1_net5 0.823374f
Cbud_s2_535 x1_net3 x1_net6 0.82057f
Cbud_s2_536 x1_net3 x1_net7 0.823374f
Cbud_s2_537 x1_net3 x1_net8 0.823374f
Cbud_s2_538 x1_net3 x1_net9 0.82057f
Cbud_s2_539 x1_net3 x2_foldn 0.00136832f
Cbud_s2_540 x1_net3 x2_foldp 0.00136832f
Cbud_s2_541 x1_net3 x2_m3d 0.00158546f
Cbud_s2_542 x1_net3 x2_m4d 0.00158546f
Cbud_s2_543 x1_net3 x2_tail 0.82057f
Cbud_s2_544 x1_net3 ip 0.00158547f
Cbud_s2_545 x1_net3 in 0.00136833f
Cbud_s2_546 x1_net4 x1_net5 0.00767651f
Cbud_s2_547 x1_net4 x1_net6 0.00637152f
Cbud_s2_548 x1_net4 x1_net7 0.82057f
Cbud_s2_549 x1_net4 x1_net8 0.82057f
Cbud_s2_550 x1_net4 x1_net9 0.82057f
Cbud_s2_551 x1_net4 x2_foldn 0.00136832f
Cbud_s2_552 x1_net4 x2_foldp 0.00136832f
Cbud_s2_553 x1_net4 x2_m3d 0.00158546f
Cbud_s2_554 x1_net4 x2_m4d 0.00158546f
Cbud_s2_555 x1_net4 x2_tail 0.0148796f
Cbud_s2_556 x1_net4 ip 0.00158547f
Cbud_s2_557 x1_net4 in 0.00136832f
Cbud_s2_558 x1_net5 x1_net6 0.00813622f
Cbud_s2_559 x1_net5 x1_net7 0.82057f
Cbud_s2_560 x1_net5 x1_net8 0.006783f
Cbud_s2_561 x1_net5 x1_net9 0.006783f
Cbud_s2_562 x1_net5 x2_foldn 0.00136832f
Cbud_s2_563 x1_net5 x2_foldp 0.00136832f
Cbud_s2_564 x1_net5 x2_m3d 0.00158546f
Cbud_s2_565 x1_net5 x2_m4d 0.00158546f
Cbud_s2_566 x1_net5 x2_tail 0.0148796f
Cbud_s2_567 x1_net5 ip 0.00158547f
Cbud_s2_568 x1_net5 in 0.00136833f
Cbud_s2_569 x1_net6 x1_net7 0.823374f
Cbud_s2_570 x1_net6 x1_net8 0.00651122f
Cbud_s2_571 x1_net6 x2_foldn 0.00136832f
Cbud_s2_572 x1_net6 x2_foldp 0.00136832f
Cbud_s2_573 x1_net6 x2_m3d 0.00158546f
Cbud_s2_574 x1_net6 x2_m4d 0.00158546f
Cbud_s2_575 x1_net6 x2_tail 0.82057f
Cbud_s2_576 x1_net6 ip 0.00158547f
Cbud_s2_577 x1_net6 in 0.00136833f
Cbud_s2_578 x1_net7 x1_net8 0.00813622f
Cbud_s2_579 x1_net7 x1_net9 0.00637152f
Cbud_s2_580 x1_net7 x2_foldn 0.00136832f
Cbud_s2_581 x1_net7 x2_foldp 0.00136832f
Cbud_s2_582 x1_net7 x2_m3d 0.00158546f
Cbud_s2_583 x1_net7 x2_m4d 0.00158546f
Cbud_s2_584 x1_net7 x2_tail 0.0148796f
Cbud_s2_585 x1_net7 ip 0.00158547f
Cbud_s2_586 x1_net7 in 0.00136832f
Cbud_s2_587 x1_net8 x1_net9 0.00864078f
Cbud_s2_588 x1_net8 x2_foldn 0.00136832f
Cbud_s2_589 x1_net8 x2_foldp 0.00136832f
Cbud_s2_590 x1_net8 x2_m3d 0.00158546f
Cbud_s2_591 x1_net8 x2_m4d 0.00158546f
Cbud_s2_592 x1_net8 x2_tail 0.0148796f
Cbud_s2_593 x1_net8 ip 0.00158547f
Cbud_s2_594 x1_net8 in 0.00136833f
Cbud_s2_595 x1_net9 x2_foldn 0.00136832f
Cbud_s2_596 x1_net9 x2_foldp 0.00136832f
Cbud_s2_597 x1_net9 x2_m3d 0.00158546f
Cbud_s2_598 x1_net9 x2_m4d 0.00158546f
Cbud_s2_599 x1_net9 x2_tail 0.82057f
Cbud_s2_600 x1_net9 ip 0.00158547f
Cbud_s2_601 x1_net9 in 0.00136833f
Cbud_s2_602 x2_foldn x2_foldp 0.0228281f
Cbud_s2_603 x2_foldn x2_m3d 0.0228281f
Cbud_s2_604 x2_foldn x2_m4d 0.0228281f
Cbud_s2_605 x2_foldn x2_tail 0.0280416f
Cbud_s2_606 x2_foldn ip 0.00195525f
Cbud_s2_607 x2_foldn in 0.00401573f
Cbud_s2_608 x2_foldp x2_m3d 0.0228281f
Cbud_s2_609 x2_foldp x2_m4d 0.0228281f
Cbud_s2_610 x2_foldp x2_tail 0.0280416f
Cbud_s2_611 x2_foldp ip 0.00401573f
Cbud_s2_612 x2_foldp in 0.00195525f
Cbud_s2_613 x2_m3d x2_m4d 0.027728f
Cbud_s2_614 x2_m3d x2_tail 0.028404f
Cbud_s2_615 x2_m3d ip 0.00195525f
Cbud_s2_616 x2_m3d in 1.1722f
Cbud_s2_617 x2_m4d x2_tail 0.027728f
Cbud_s2_618 x2_m4d ip 1.1722f
Cbud_s2_619 x2_m4d in 0.00195525f
Cbud_s2_620 x2_tail ip 0.00401573f
Cbud_s2_621 x2_tail in 0.00465299f
XX1_M22 s1r_XX1_M22_d s1r_XX1_M22_g s1r_XX1_M22_s VDD sky130_fd_pr__pfet_01v8 L=0.6 W=1.4 NF=1 AD=0.406 AS=0.406 PD=3.38 PS=3.38 NRD=0.207143 NRS=0.207143 SA=0 SB=0 SD=0 MULT=6 M=6
Rpar_s1_XX1_M22_s s1r_XX1_M22_s x1_m21d 0.553403
Rpar_s1_XX1_M22_g s1r_XX1_M22_g bias_c 0.391903
Rpar_s1_XX1_M22_d s1r_XX1_M22_d bias_b 0.553403
XX1_M26 s1r_XX1_M26_d s1r_XX1_M26_g s1r_XX1_M26_s VDD sky130_fd_pr__pfet_01v8 L=0.6 W=1.4 NF=1 AD=0.406 AS=0.406 PD=3.38 PS=3.38 NRD=0.207143 NRS=0.207143 SA=0 SB=0 SD=0 MULT=6 M=6
Rpar_s1_XX1_M26_s s1r_XX1_M26_s x1_m25d 0.553403
Rpar_s1_XX1_M26_g s1r_XX1_M26_g bias_c 0.452629
Rpar_s1_XX1_M26_d s1r_XX1_M26_d x1_m2d 0.553403
XX1_M32 s1r_XX1_M32_d s1r_XX1_M32_g s1r_XX1_M32_s VDD sky130_fd_pr__pfet_01v8 L=0.6 W=1.4 NF=1 AD=0.406 AS=0.406 PD=3.38 PS=3.38 NRD=0.207143 NRS=0.207143 SA=0 SB=0 SD=0 MULT=6 M=6
Rpar_s1_XX1_M32_s s1r_XX1_M32_s x1_m31d 0.641223
Rpar_s1_XX1_M32_g s1r_XX1_M32_g bias_c 234.219
Rpar_s1_XX1_M32_d s1r_XX1_M32_d cm 3.86649
XX1_M21 s1r_XX1_M21_d s1r_XX1_M21_g s1r_XX1_M21_s VDD sky130_fd_pr__pfet_01v8_lvt L=0.6 W=1.4 NF=1 AD=0.406 AS=0.406 PD=3.38 PS=3.38 NRD=0.207143 NRS=0.207143 SA=0 SB=0 SD=0 MULT=6 M=6
Rpar_s1_XX1_M21_s s1r_XX1_M21_s VDD 0.553403
Rpar_s1_XX1_M21_g s1r_XX1_M21_g bias_b 234.219
Rpar_s1_XX1_M21_d s1r_XX1_M21_d x1_m21d 0.553403
XX1_M25 s1r_XX1_M25_d s1r_XX1_M25_g s1r_XX1_M25_s VDD sky130_fd_pr__pfet_01v8_lvt L=0.6 W=1.4 NF=1 AD=0.406 AS=0.406 PD=3.38 PS=3.38 NRD=0.207143 NRS=0.207143 SA=0 SB=0 SD=0 MULT=6 M=6
Rpar_s1_XX1_M25_s s1r_XX1_M25_s VDD 0.553403
Rpar_s1_XX1_M25_g s1r_XX1_M25_g bias_b 0.453112
Rpar_s1_XX1_M25_d s1r_XX1_M25_d x1_m25d 0.553403
XX1_M31 s1r_XX1_M31_d s1r_XX1_M31_g s1r_XX1_M31_s VDD sky130_fd_pr__pfet_01v8_lvt L=0.6 W=1.4 NF=1 AD=0.406 AS=0.406 PD=3.38 PS=3.38 NRD=0.207143 NRS=0.207143 SA=0 SB=0 SD=0 MULT=6 M=6
Rpar_s1_XX1_M31_s s1r_XX1_M31_s VDD 0.553403
Rpar_s1_XX1_M31_g s1r_XX1_M31_g bias_b 234.219
Rpar_s1_XX1_M31_d s1r_XX1_M31_d x1_m31d 0.641223
XX1_M1 s1r_XX1_M1_d s1r_XX1_M1_g s1r_XX1_M1_s VSS sky130_fd_pr__nfet_01v8_lvt L=0.6 W=1.4 NF=1 AD=0.406 AS=0.406 PD=3.38 PS=3.38 NRD=0.207143 NRS=0.207143 SA=0 SB=0 SD=0 MULT=56 M=56
Rpar_s1_XX1_M1_s s1r_XX1_M1_s bias_c 1.07356
Rpar_s1_XX1_M1_g s1r_XX1_M1_g bias_b 1.26112
Rpar_s1_XX1_M1_d s1r_XX1_M1_d bias_b 1.07356
XX1_M2 s1r_XX1_M2_d s1r_XX1_M2_g s1r_XX1_M2_s VSS sky130_fd_pr__nfet_01v8 L=0.6 W=1.4 NF=1 AD=0.406 AS=0.406 PD=3.38 PS=3.38 NRD=0.207143 NRS=0.207143 SA=0 SB=0 SD=0 MULT=50 M=50
Rpar_s1_XX1_M2_s s1r_XX1_M2_s bias_d 0.96449
Rpar_s1_XX1_M2_g s1r_XX1_M2_g x1_m2d 0.978178
Rpar_s1_XX1_M2_d s1r_XX1_M2_d x1_m2d 1.11759
XX1_M3 s1r_XX1_M3_d s1r_XX1_M3_g s1r_XX1_M3_s VSS sky130_fd_pr__nfet_01v8 L=0.6 W=1.4 NF=1 AD=0.406 AS=0.406 PD=3.38 PS=3.38 NRD=0.207143 NRS=0.207143 SA=0 SB=0 SD=0 MULT=2 M=2
Rpar_s1_XX1_M3_s s1r_XX1_M3_s bias_a 0.467406
Rpar_s1_XX1_M3_g s1r_XX1_M3_g x1_m2d 0.809609
Rpar_s1_XX1_M3_d s1r_XX1_M3_d bias_d 0.467406
XX1_M4 s1r_XX1_M4_d s1r_XX1_M4_g s1r_XX1_M4_s VSS sky130_fd_pr__nfet_01v8 L=0.6 W=1.4 NF=1 AD=0.406 AS=0.406 PD=3.38 PS=3.38 NRD=0.207143 NRS=0.207143 SA=0 SB=0 SD=0 MULT=18 M=18
Rpar_s1_XX1_M4_s s1r_XX1_M4_s x1_m5d 0.466195
Rpar_s1_XX1_M4_g s1r_XX1_M4_g bias_d 0.510263
Rpar_s1_XX1_M4_d s1r_XX1_M4_d bias_a 0.402347
XX1_M5 s1r_XX1_M5_d s1r_XX1_M5_g s1r_XX1_M5_s VSS sky130_fd_pr__nfet_01v8 L=0.6 W=1.4 NF=1 AD=0.406 AS=0.406 PD=3.38 PS=3.38 NRD=0.207143 NRS=0.207143 SA=0 SB=0 SD=0 MULT=18 M=18
Rpar_s1_XX1_M5_s s1r_XX1_M5_s VSS 0.402347
Rpar_s1_XX1_M5_g s1r_XX1_M5_g bias_a 264.007
Rpar_s1_XX1_M5_d s1r_XX1_M5_d x1_m5d 0.466195
XX1_M6 s1r_XX1_M6_d s1r_XX1_M6_g s1r_XX1_M6_s VSS sky130_fd_pr__nfet_01v8 L=0.6 W=1.4 NF=1 AD=0.406 AS=0.406 PD=3.38 PS=3.38 NRD=0.207143 NRS=0.207143 SA=0 SB=0 SD=0 MULT=18 M=18
Rpar_s1_XX1_M6_s s1r_XX1_M6_s VSS 0.402347
Rpar_s1_XX1_M6_g s1r_XX1_M6_g i_bias 264.084
Rpar_s1_XX1_M6_d s1r_XX1_M6_d bias_c 0.466195
XX1_M7 s1r_XX1_M7_d s1r_XX1_M7_g s1r_XX1_M7_s VSS sky130_fd_pr__nfet_01v8 L=0.6 W=1.4 NF=1 AD=0.406 AS=0.406 PD=3.38 PS=3.38 NRD=0.207143 NRS=0.207143 SA=0 SB=0 SD=0 MULT=18 M=18
Rpar_s1_XX1_M7_s s1r_XX1_M7_s VSS 0.402347
Rpar_s1_XX1_M7_g s1r_XX1_M7_g i_bias 264.084
Rpar_s1_XX1_M7_d s1r_XX1_M7_d i_bias 0.466195
XX1_M33 s1r_XX1_M33_d s1r_XX1_M33_g s1r_XX1_M33_s VSS sky130_fd_pr__nfet_01v8 L=0.6 W=1.4 NF=1 AD=0.406 AS=0.406 PD=3.38 PS=3.38 NRD=0.207143 NRS=0.207143 SA=0 SB=0 SD=0 MULT=1 M=1
Rpar_s1_XX1_M33_s s1r_XX1_M33_s x1_net1 171.892
Rpar_s1_XX1_M33_g s1r_XX1_M33_g cm 922.894
Rpar_s1_XX1_M33_d s1r_XX1_M33_d cm 512.47
XX1_M49 s1r_XX1_M49_d s1r_XX1_M49_g s1r_XX1_M49_s VSS sky130_fd_pr__nfet_01v8 L=0.6 W=1.4 NF=1 AD=0.406 AS=0.406 PD=3.38 PS=3.38 NRD=0.207143 NRS=0.207143 SA=0 SB=0 SD=0 MULT=1 M=1
Rpar_s1_XX1_M49_s s1r_XX1_M49_s x1_net2 167.971
Rpar_s1_XX1_M49_g s1r_XX1_M49_g cm 1.53964
Rpar_s1_XX1_M49_d s1r_XX1_M49_d x1_net1 171.892
XX1_M50 s1r_XX1_M50_d s1r_XX1_M50_g s1r_XX1_M50_s VSS sky130_fd_pr__nfet_01v8 L=0.6 W=1.4 NF=1 AD=0.406 AS=0.406 PD=3.38 PS=3.38 NRD=0.207143 NRS=0.207143 SA=0 SB=0 SD=0 MULT=1 M=1
Rpar_s1_XX1_M50_s s1r_XX1_M50_s x1_net3 168.374
Rpar_s1_XX1_M50_g s1r_XX1_M50_g cm 922.894
Rpar_s1_XX1_M50_d s1r_XX1_M50_d x1_net2 167.971
XX1_M63 s1r_XX1_M63_d s1r_XX1_M63_g s1r_XX1_M63_s VSS sky130_fd_pr__nfet_01v8 L=0.6 W=1.4 NF=1 AD=0.406 AS=0.406 PD=3.38 PS=3.38 NRD=0.207143 NRS=0.207143 SA=0 SB=0 SD=0 MULT=1 M=1
Rpar_s1_XX1_M63_s s1r_XX1_M63_s VSS 0.859161
Rpar_s1_XX1_M63_g s1r_XX1_M63_g cm 1.56413
Rpar_s1_XX1_M63_d s1r_XX1_M63_d x1_net3 0.867061
XX1_M68 s1r_XX1_M68_d s1r_XX1_M68_g s1r_XX1_M68_s VSS sky130_fd_pr__nfet_01v8 L=0.6 W=1.4 NF=1 AD=0.406 AS=0.406 PD=3.38 PS=3.38 NRD=0.207143 NRS=0.207143 SA=0 SB=0 SD=0 MULT=1 M=1
Rpar_s1_XX1_M68_s s1r_XX1_M68_s x1_net4 68.9365
Rpar_s1_XX1_M68_g s1r_XX1_M68_g cm 922.894
Rpar_s1_XX1_M68_d s1r_XX1_M68_d cm 512.47
XX1_M69 s1r_XX1_M69_d s1r_XX1_M69_g s1r_XX1_M69_s VSS sky130_fd_pr__nfet_01v8 L=0.6 W=1.4 NF=1 AD=0.406 AS=0.406 PD=3.38 PS=3.38 NRD=0.207143 NRS=0.207143 SA=0 SB=0 SD=0 MULT=1 M=1
Rpar_s1_XX1_M69_s s1r_XX1_M69_s x1_net5 167.971
Rpar_s1_XX1_M69_g s1r_XX1_M69_g cm 922.894
Rpar_s1_XX1_M69_d s1r_XX1_M69_d x1_net4 171.892
XX1_M70 s1r_XX1_M70_d s1r_XX1_M70_g s1r_XX1_M70_s VSS sky130_fd_pr__nfet_01v8 L=0.6 W=1.4 NF=1 AD=0.406 AS=0.406 PD=3.38 PS=3.38 NRD=0.207143 NRS=0.207143 SA=0 SB=0 SD=0 MULT=1 M=1
Rpar_s1_XX1_M70_s s1r_XX1_M70_s x1_net6 168.374
Rpar_s1_XX1_M70_g s1r_XX1_M70_g cm 922.894
Rpar_s1_XX1_M70_d s1r_XX1_M70_d x1_net5 167.971
XX1_M71 s1r_XX1_M71_d s1r_XX1_M71_g s1r_XX1_M71_s VSS sky130_fd_pr__nfet_01v8 L=0.6 W=1.4 NF=1 AD=0.406 AS=0.406 PD=3.38 PS=3.38 NRD=0.207143 NRS=0.207143 SA=0 SB=0 SD=0 MULT=1 M=1
Rpar_s1_XX1_M71_s s1r_XX1_M71_s VSS 0.859161
Rpar_s1_XX1_M71_g s1r_XX1_M71_g cm 1.56413
Rpar_s1_XX1_M71_d s1r_XX1_M71_d x1_net6 0.867061
XX1_M72 s1r_XX1_M72_d s1r_XX1_M72_g s1r_XX1_M72_s VSS sky130_fd_pr__nfet_01v8 L=0.6 W=1.4 NF=1 AD=0.406 AS=0.406 PD=3.38 PS=3.38 NRD=0.207143 NRS=0.207143 SA=0 SB=0 SD=0 MULT=1 M=1
Rpar_s1_XX1_M72_s s1r_XX1_M72_s x1_net7 171.892
Rpar_s1_XX1_M72_g s1r_XX1_M72_g cm 922.894
Rpar_s1_XX1_M72_d s1r_XX1_M72_d cm 512.47
XX1_M73 s1r_XX1_M73_d s1r_XX1_M73_g s1r_XX1_M73_s VSS sky130_fd_pr__nfet_01v8 L=0.6 W=1.4 NF=1 AD=0.406 AS=0.406 PD=3.38 PS=3.38 NRD=0.207143 NRS=0.207143 SA=0 SB=0 SD=0 MULT=1 M=1
Rpar_s1_XX1_M73_s s1r_XX1_M73_s x1_net8 167.971
Rpar_s1_XX1_M73_g s1r_XX1_M73_g cm 922.894
Rpar_s1_XX1_M73_d s1r_XX1_M73_d x1_net7 171.892
XX1_M74 s1r_XX1_M74_d s1r_XX1_M74_g s1r_XX1_M74_s VSS sky130_fd_pr__nfet_01v8 L=0.6 W=1.4 NF=1 AD=0.406 AS=0.406 PD=3.38 PS=3.38 NRD=0.207143 NRS=0.207143 SA=0 SB=0 SD=0 MULT=1 M=1
Rpar_s1_XX1_M74_s s1r_XX1_M74_s x1_net9 0.867061
Rpar_s1_XX1_M74_g s1r_XX1_M74_g cm 1.53959
Rpar_s1_XX1_M74_d s1r_XX1_M74_d x1_net8 167.971
XX1_M75 s1r_XX1_M75_d s1r_XX1_M75_g s1r_XX1_M75_s VSS sky130_fd_pr__nfet_01v8 L=0.6 W=1.4 NF=1 AD=0.406 AS=0.406 PD=3.38 PS=3.38 NRD=0.207143 NRS=0.207143 SA=0 SB=0 SD=0 MULT=1 M=1
Rpar_s1_XX1_M75_s s1r_XX1_M75_s VSS 0.859161
Rpar_s1_XX1_M75_g s1r_XX1_M75_g cm 922.894
Rpar_s1_XX1_M75_d s1r_XX1_M75_d x1_net9 168.374
XX1_M76 s1r_XX1_M76_d s1r_XX1_M76_g s1r_XX1_M76_s VSS sky130_fd_pr__nfet_01v8 L=0.6 W=1.4 NF=1 AD=0.406 AS=0.406 PD=3.38 PS=3.38 NRD=0.207143 NRS=0.207143 SA=0 SB=0 SD=0 MULT=1 M=1
Rpar_s1_XX1_M76_s s1r_XX1_M76_s x1_net10 171.892
Rpar_s1_XX1_M76_g s1r_XX1_M76_g cm 922.894
Rpar_s1_XX1_M76_d s1r_XX1_M76_d cm 512.47
XX1_M77 s1r_XX1_M77_d s1r_XX1_M77_g s1r_XX1_M77_s VSS sky130_fd_pr__nfet_01v8 L=0.6 W=1.4 NF=1 AD=0.406 AS=0.406 PD=3.38 PS=3.38 NRD=0.207143 NRS=0.207143 SA=0 SB=0 SD=0 MULT=1 M=1
Rpar_s1_XX1_M77_s s1r_XX1_M77_s x1_net11 167.971
Rpar_s1_XX1_M77_g s1r_XX1_M77_g cm 922.894
Rpar_s1_XX1_M77_d s1r_XX1_M77_d x1_net10 0.867074
XX1_M78 s1r_XX1_M78_d cm s1r_XX1_M78_s VSS sky130_fd_pr__nfet_01v8 L=0.6 W=1.4 NF=1 AD=0.406 AS=0.406 PD=3.38 PS=3.38 NRD=0.207143 NRS=0.207143 SA=0 SB=0 SD=0 MULT=1 M=1
Rpar_s1_XX1_M78_s s1r_XX1_M78_s x1_net12 168.374
Rpar_s1_XX1_M78_d s1r_XX1_M78_d x1_net11 167.971
XX1_M79 s1r_XX1_M79_d s1r_XX1_M79_g s1r_XX1_M79_s VSS sky130_fd_pr__nfet_01v8 L=0.6 W=1.4 NF=1 AD=0.406 AS=0.406 PD=3.38 PS=3.38 NRD=0.207143 NRS=0.207143 SA=0 SB=0 SD=0 MULT=1 M=1
Rpar_s1_XX1_M79_s s1r_XX1_M79_s VSS 0.859161
Rpar_s1_XX1_M79_g s1r_XX1_M79_g cm 1.56413
Rpar_s1_XX1_M79_d s1r_XX1_M79_d x1_net12 168.374
XX1_M64 s1r_XX1_M64_d s1r_XX1_M64_g s1r_XX1_M64_s VSS sky130_fd_pr__nfet_01v8 L=0.6 W=1.4 NF=1 AD=0.406 AS=0.406 PD=3.38 PS=3.38 NRD=0.207143 NRS=0.207143 SA=0 SB=0 SD=0 MULT=1 M=1
Rpar_s1_XX1_M64_s s1r_XX1_M64_s x1_net13 68.9365
Rpar_s1_XX1_M64_g s1r_XX1_M64_g cm 922.894
Rpar_s1_XX1_M64_d s1r_XX1_M64_d cm 512.47
XX1_M65 s1r_XX1_M65_d s1r_XX1_M65_g s1r_XX1_M65_s VSS sky130_fd_pr__nfet_01v8 L=0.6 W=1.4 NF=1 AD=0.406 AS=0.406 PD=3.38 PS=3.38 NRD=0.207143 NRS=0.207143 SA=0 SB=0 SD=0 MULT=1 M=1
Rpar_s1_XX1_M65_s s1r_XX1_M65_s x1_net14 167.971
Rpar_s1_XX1_M65_g s1r_XX1_M65_g cm 1.53963
Rpar_s1_XX1_M65_d s1r_XX1_M65_d x1_net13 171.892
XX1_M66 s1r_XX1_M66_d s1r_XX1_M66_g s1r_XX1_M66_s VSS sky130_fd_pr__nfet_01v8 L=0.6 W=1.4 NF=1 AD=0.406 AS=0.406 PD=3.38 PS=3.38 NRD=0.207143 NRS=0.207143 SA=0 SB=0 SD=0 MULT=1 M=1
Rpar_s1_XX1_M66_s s1r_XX1_M66_s x1_net15 168.374
Rpar_s1_XX1_M66_g s1r_XX1_M66_g cm 922.894
Rpar_s1_XX1_M66_d s1r_XX1_M66_d x1_net14 167.971
XX1_M67 s1r_XX1_M67_d s1r_XX1_M67_g s1r_XX1_M67_s VSS sky130_fd_pr__nfet_01v8 L=0.6 W=1.4 NF=1 AD=0.406 AS=0.406 PD=3.38 PS=3.38 NRD=0.207143 NRS=0.207143 SA=0 SB=0 SD=0 MULT=1 M=1
Rpar_s1_XX1_M67_s s1r_XX1_M67_s VSS 0.859161
Rpar_s1_XX1_M67_g s1r_XX1_M67_g cm 1.56413
Rpar_s1_XX1_M67_d s1r_XX1_M67_d x1_net15 0.867061
XX1_M57 bias_b VDD VDD VDD sky130_fd_pr__pfet_01v8 L=0.6 W=1.4 NF=1 AD=0.406 AS=0.406 PD=3.38 PS=3.38 NRD=0.207143 NRS=0.207143 SA=0 SB=0 SD=0 MULT=2 M=2
XX1_M58 x1_m2d VDD VDD VDD sky130_fd_pr__pfet_01v8 L=0.6 W=1.4 NF=1 AD=0.406 AS=0.406 PD=3.38 PS=3.38 NRD=0.207143 NRS=0.207143 SA=0 SB=0 SD=0 MULT=2 M=2
XX1_M59 cm VDD VDD VDD sky130_fd_pr__pfet_01v8 L=0.6 W=1.4 NF=1 AD=0.406 AS=0.406 PD=3.38 PS=3.38 NRD=0.207143 NRS=0.207143 SA=0 SB=0 SD=0 MULT=2 M=2
XX1_M60 x1_m31d VDD VDD VDD sky130_fd_pr__pfet_01v8 L=0.6 W=1.4 NF=1 AD=0.406 AS=0.406 PD=3.38 PS=3.38 NRD=0.207143 NRS=0.207143 SA=0 SB=0 SD=0 MULT=2 M=2
XX1_M42 x1_m5d VSS VSS VSS sky130_fd_pr__nfet_01v8 L=0.6 W=1.4 NF=1 AD=0.406 AS=0.406 PD=3.38 PS=3.38 NRD=0.207143 NRS=0.207143 SA=0 SB=0 SD=0 MULT=6 M=6
XX1_M44 bias_c bias_c bias_c VSS sky130_fd_pr__nfet_01v8 L=0.6 W=1.4 NF=1 AD=0.406 AS=0.406 PD=3.38 PS=3.38 NRD=0.207143 NRS=0.207143 SA=0 SB=0 SD=0 MULT=2 M=2
XX1_M34 bias_d bias_d bias_d VSS sky130_fd_pr__nfet_01v8 L=0.6 W=1.4 NF=1 AD=0.406 AS=0.406 PD=3.38 PS=3.38 NRD=0.207143 NRS=0.207143 SA=0 SB=0 SD=0 MULT=8 M=8
XX1_M35 x1_m2d x1_m2d x1_m2d VSS sky130_fd_pr__nfet_01v8 L=0.6 W=1.4 NF=1 AD=0.406 AS=0.406 PD=3.38 PS=3.38 NRD=0.207143 NRS=0.207143 SA=0 SB=0 SD=0 MULT=2 M=2
XX1_M36 bias_a bias_a bias_a VSS sky130_fd_pr__nfet_01v8 L=0.6 W=1.4 NF=1 AD=0.406 AS=0.406 PD=3.38 PS=3.38 NRD=0.207143 NRS=0.207143 SA=0 SB=0 SD=0 MULT=4 M=4
XX1_M37 cm cm cm VSS sky130_fd_pr__nfet_01v8 L=0.6 W=1.4 NF=1 AD=0.406 AS=0.406 PD=3.38 PS=3.38 NRD=0.207143 NRS=0.207143 SA=0 SB=0 SD=0 MULT=8 M=8
XX1_M54 x1_m25d x1_m25d x1_m25d VDD sky130_fd_pr__pfet_01v8 L=0.6 W=1.4 NF=1 AD=0.406 AS=0.406 PD=3.38 PS=3.38 NRD=0.207143 NRS=0.207143 SA=0 SB=0 SD=0 MULT=2 M=2
XX1_M29 x1_m5d x1_m5d x1_m5d VSS sky130_fd_pr__nfet_01v8 L=0.6 W=1.4 NF=1 AD=0.406 AS=0.406 PD=3.38 PS=3.38 NRD=0.207143 NRS=0.207143 SA=0 SB=0 SD=0 MULT=6 M=6
XX1_M8 i_bias i_bias i_bias VSS sky130_fd_pr__nfet_01v8 L=0.6 W=1.4 NF=1 AD=0.406 AS=0.406 PD=3.38 PS=3.38 NRD=0.207143 NRS=0.207143 SA=0 SB=0 SD=0 MULT=2 M=2
XX1_M10 bias_c bias_c bias_c VSS sky130_fd_pr__nfet_01v8_lvt L=0.6 W=1.4 NF=1 AD=0.406 AS=0.406 PD=3.38 PS=3.38 NRD=0.207143 NRS=0.207143 SA=0 SB=0 SD=0 MULT=8 M=8
XX1_M27 bias_b bias_b bias_b VSS sky130_fd_pr__nfet_01v8_lvt L=0.6 W=1.4 NF=1 AD=0.406 AS=0.406 PD=3.38 PS=3.38 NRD=0.207143 NRS=0.207143 SA=0 SB=0 SD=0 MULT=8 M=8
XX1_M46 x1_m21d x1_m21d x1_m21d VDD sky130_fd_pr__pfet_01v8_lvt L=0.6 W=1.4 NF=1 AD=0.406 AS=0.406 PD=3.38 PS=3.38 NRD=0.207143 NRS=0.207143 SA=0 SB=0 SD=0 MULT=2 M=2
XX1_M47 x1_m25d x1_m25d x1_m25d VDD sky130_fd_pr__pfet_01v8_lvt L=0.6 W=1.4 NF=1 AD=0.406 AS=0.406 PD=3.38 PS=3.38 NRD=0.207143 NRS=0.207143 SA=0 SB=0 SD=0 MULT=2 M=2
XX1_M48 x1_m31d x1_m31d x1_m31d VDD sky130_fd_pr__pfet_01v8_lvt L=0.6 W=1.4 NF=1 AD=0.406 AS=0.406 PD=3.38 PS=3.38 NRD=0.207143 NRS=0.207143 SA=0 SB=0 SD=0 MULT=2 M=2
XX1_M51 x1_m21d x1_m21d x1_m21d VDD sky130_fd_pr__pfet_01v8 L=0.6 W=1.4 NF=1 AD=0.406 AS=0.406 PD=3.38 PS=3.38 NRD=0.207143 NRS=0.207143 SA=0 SB=0 SD=0 MULT=2 M=2
XX2_M1 s1r_XX2_M1_d s1r_XX2_M1_g s1r_XX2_M1_s VSS sky130_fd_pr__nfet_01v8_lvt L=0.2 W=1.2 NF=1 AD=0.348 AS=0.348 PD=2.98 PS=2.98 NRD=0.241667 NRS=0.241667 SA=0 SB=0 SD=0 MULT=6 M=6
Rpar_s1_XX2_M1_s s1r_XX2_M1_s x2_tail 0.456322
Rpar_s1_XX2_M1_g s1r_XX2_M1_g ip 0.413845
Rpar_s1_XX2_M1_d s1r_XX2_M1_d x2_foldp 0.456322
XX2_M2 s1r_XX2_M2_d s1r_XX2_M2_g s1r_XX2_M2_s VSS sky130_fd_pr__nfet_01v8_lvt L=0.2 W=1.2 NF=1 AD=0.348 AS=0.348 PD=2.98 PS=2.98 NRD=0.241667 NRS=0.241667 SA=0 SB=0 SD=0 MULT=6 M=6
Rpar_s1_XX2_M2_s s1r_XX2_M2_s x2_tail 0.456322
Rpar_s1_XX2_M2_g s1r_XX2_M2_g in 0.413845
Rpar_s1_XX2_M2_d s1r_XX2_M2_d x2_foldn 0.456322
XX2_M6 s1r_XX2_M6_d s1r_XX2_M6_g s1r_XX2_M6_s VSS sky130_fd_pr__nfet_01v8 L=0.6 W=1.4 NF=1 AD=0.406 AS=0.406 PD=3.38 PS=3.38 NRD=0.207143 NRS=0.207143 SA=0 SB=0 SD=0 MULT=96 M=96
Rpar_s1_XX2_M6_s s1r_XX2_M6_s VSS 1.80626
Rpar_s1_XX2_M6_g s1r_XX2_M6_g cmc 1087.47
Rpar_s1_XX2_M6_d s1r_XX2_M6_d x2_tail 2.0929
XX2_M5 s1r_XX2_M5_d s1r_XX2_M5_g s1r_XX2_M5_s VSS sky130_fd_pr__nfet_01v8 L=0.6 W=1.4 NF=1 AD=0.406 AS=0.406 PD=3.38 PS=3.38 NRD=0.207143 NRS=0.207143 SA=0 SB=0 SD=0 MULT=96 M=96
Rpar_s1_XX2_M5_s s1r_XX2_M5_s VSS 2.0929
Rpar_s1_XX2_M5_g s1r_XX2_M5_g bias_a 2.10117
Rpar_s1_XX2_M5_d s1r_XX2_M5_d x2_tail 1.80626
XX2_M11 s1r_XX2_M11_d s1r_XX2_M11_g s1r_XX2_M11_s VDD sky130_fd_pr__pfet_01v8_lvt L=0.6 W=1.4 NF=1 AD=0.406 AS=0.406 PD=3.38 PS=3.38 NRD=0.207143 NRS=0.207143 SA=0 SB=0 SD=0 MULT=24 M=24
Rpar_s1_XX2_M11_s s1r_XX2_M11_s VDD 0.588767
Rpar_s1_XX2_M11_g s1r_XX2_M11_g bias_b 0.548058
Rpar_s1_XX2_M11_d s1r_XX2_M11_d x2_foldp 0.682199
XX2_M12 s1r_XX2_M12_d s1r_XX2_M12_g s1r_XX2_M12_s VDD sky130_fd_pr__pfet_01v8_lvt L=0.6 W=1.4 NF=1 AD=0.406 AS=0.406 PD=3.38 PS=3.38 NRD=0.207143 NRS=0.207143 SA=0 SB=0 SD=0 MULT=24 M=24
Rpar_s1_XX2_M12_s s1r_XX2_M12_s VDD 0.588767
Rpar_s1_XX2_M12_g s1r_XX2_M12_g bias_b 0.548058
Rpar_s1_XX2_M12_d s1r_XX2_M12_d x2_foldn 0.682199
XX2_M1A s1r_XX2_M1A_d s1r_XX2_M1A_g s1r_XX2_M1A_s VDD sky130_fd_pr__pfet_01v8 L=0.6 W=1.4 NF=1 AD=0.406 AS=0.406 PD=3.38 PS=3.38 NRD=0.207143 NRS=0.207143 SA=0 SB=0 SD=0 MULT=20 M=20
Rpar_s1_XX2_M1A_s s1r_XX2_M1A_s x2_foldp 0.760522
Rpar_s1_XX2_M1A_g s1r_XX2_M1A_g bias_c 0.483979
Rpar_s1_XX2_M1A_d s1r_XX2_M1A_d on 0.656364
XX2_M8 s1r_XX2_M8_d s1r_XX2_M8_g s1r_XX2_M8_s VDD sky130_fd_pr__pfet_01v8 L=0.6 W=1.4 NF=1 AD=0.406 AS=0.406 PD=3.38 PS=3.38 NRD=0.207143 NRS=0.207143 SA=0 SB=0 SD=0 MULT=20 M=20
Rpar_s1_XX2_M8_s s1r_XX2_M8_s x2_foldn 0.760522
Rpar_s1_XX2_M8_g s1r_XX2_M8_g bias_c 0.483979
Rpar_s1_XX2_M8_d s1r_XX2_M8_d op 0.656364
XX2_M3A s1r_XX2_M3A_d s1r_XX2_M3A_g s1r_XX2_M3A_s VSS sky130_fd_pr__nfet_01v8 L=0.6 W=1.4 NF=1 AD=0.406 AS=0.406 PD=3.38 PS=3.38 NRD=0.207143 NRS=0.207143 SA=0 SB=0 SD=0 MULT=36 M=36
Rpar_s1_XX2_M3A_s s1r_XX2_M3A_s x2_m3d 0.712243
Rpar_s1_XX2_M3A_g s1r_XX2_M3A_g bias_d 0.731254
Rpar_s1_XX2_M3A_d s1r_XX2_M3A_d on 0.825269
XX2_M7 s1r_XX2_M7_d s1r_XX2_M7_g s1r_XX2_M7_s VSS sky130_fd_pr__nfet_01v8 L=0.6 W=1.4 NF=1 AD=0.406 AS=0.406 PD=3.38 PS=3.38 NRD=0.207143 NRS=0.207143 SA=0 SB=0 SD=0 MULT=36 M=36
Rpar_s1_XX2_M7_s s1r_XX2_M7_s x2_m4d 0.712243
Rpar_s1_XX2_M7_g s1r_XX2_M7_g bias_d 0.731254
Rpar_s1_XX2_M7_d s1r_XX2_M7_d op 0.825269
XX2_M3 s1r_XX2_M3_d s1r_XX2_M3_g s1r_XX2_M3_s VSS sky130_fd_pr__nfet_01v8 L=0.6 W=1.4 NF=1 AD=0.406 AS=0.406 PD=3.38 PS=3.38 NRD=0.207143 NRS=0.207143 SA=0 SB=0 SD=0 MULT=36 M=36
Rpar_s1_XX2_M3_s s1r_XX2_M3_s VSS 0.712243
Rpar_s1_XX2_M3_g s1r_XX2_M3_g bias_a 0.847296
Rpar_s1_XX2_M3_d s1r_XX2_M3_d x2_m3d 0.712243
XX2_M4 s1r_XX2_M4_d s1r_XX2_M4_g s1r_XX2_M4_s VSS sky130_fd_pr__nfet_01v8 L=0.6 W=1.4 NF=1 AD=0.406 AS=0.406 PD=3.38 PS=3.38 NRD=0.207143 NRS=0.207143 SA=0 SB=0 SD=0 MULT=36 M=36
Rpar_s1_XX2_M4_s s1r_XX2_M4_s VSS 0.712243
Rpar_s1_XX2_M4_g s1r_XX2_M4_g bias_a 0.847296
Rpar_s1_XX2_M4_d s1r_XX2_M4_d x2_m4d 0.712243
XX2_M82 x2_foldn x2_foldn x2_foldn VDD sky130_fd_pr__pfet_01v8 L=0.6 W=1.4 NF=1 AD=0.406 AS=0.406 PD=3.38 PS=3.38 NRD=0.207143 NRS=0.207143 SA=0 SB=0 SD=0 MULT=2 M=2
XX2_M83 x2_foldp x2_foldp x2_foldp VDD sky130_fd_pr__pfet_01v8 L=0.6 W=1.4 NF=1 AD=0.406 AS=0.406 PD=3.38 PS=3.38 NRD=0.207143 NRS=0.207143 SA=0 SB=0 SD=0 MULT=2 M=2
XX2_M55 x2_foldn VDD VDD VDD sky130_fd_pr__pfet_01v8 L=0.6 W=1.4 NF=1 AD=0.406 AS=0.406 PD=3.38 PS=3.38 NRD=0.207143 NRS=0.207143 SA=0 SB=0 SD=0 MULT=2 M=2
XX2_M56 op VDD VDD VDD sky130_fd_pr__pfet_01v8 L=0.6 W=1.4 NF=1 AD=0.406 AS=0.406 PD=3.38 PS=3.38 NRD=0.207143 NRS=0.207143 SA=0 SB=0 SD=0 MULT=4 M=4
XX2_M61 x2_foldp VDD VDD VDD sky130_fd_pr__pfet_01v8 L=0.6 W=1.4 NF=1 AD=0.406 AS=0.406 PD=3.38 PS=3.38 NRD=0.207143 NRS=0.207143 SA=0 SB=0 SD=0 MULT=2 M=2
XX2_M62 on VDD VDD VDD sky130_fd_pr__pfet_01v8 L=0.6 W=1.4 NF=1 AD=0.406 AS=0.406 PD=3.38 PS=3.38 NRD=0.207143 NRS=0.207143 SA=0 SB=0 SD=0 MULT=4 M=4
XX2_M40 x2_m4d VSS VSS VSS sky130_fd_pr__nfet_01v8 L=0.6 W=1.4 NF=1 AD=0.406 AS=0.406 PD=3.38 PS=3.38 NRD=0.207143 NRS=0.207143 SA=0 SB=0 SD=0 MULT=6 M=6
XX2_M41 x2_m3d VSS VSS VSS sky130_fd_pr__nfet_01v8 L=0.6 W=1.4 NF=1 AD=0.406 AS=0.406 PD=3.38 PS=3.38 NRD=0.207143 NRS=0.207143 SA=0 SB=0 SD=0 MULT=8 M=8
XX2_M38 op op op VSS sky130_fd_pr__nfet_01v8 L=0.6 W=1.4 NF=1 AD=0.406 AS=0.406 PD=3.38 PS=3.38 NRD=0.207143 NRS=0.207143 SA=0 SB=0 SD=0 MULT=2 M=2
XX2_M39 on on on VSS sky130_fd_pr__nfet_01v8 L=0.6 W=1.4 NF=1 AD=0.406 AS=0.406 PD=3.38 PS=3.38 NRD=0.207143 NRS=0.207143 SA=0 SB=0 SD=0 MULT=2 M=2
XX2_M30 x2_tail VSS VSS VSS sky130_fd_pr__nfet_01v8 L=0.6 W=1.4 NF=1 AD=0.406 AS=0.406 PD=3.38 PS=3.38 NRD=0.207143 NRS=0.207143 SA=0 SB=0 SD=0 MULT=2 M=2
XX2_M23 x2_foldp x2_foldp x2_foldp VSS sky130_fd_pr__nfet_01v8_lvt L=0.2 W=1.2 NF=1 AD=0.348 AS=0.348 PD=2.98 PS=2.98 NRD=0.241667 NRS=0.241667 SA=0 SB=0 SD=0 MULT=2 M=2
XX2_M24 x2_foldn x2_foldn x2_foldn VSS sky130_fd_pr__nfet_01v8_lvt L=0.2 W=1.2 NF=1 AD=0.348 AS=0.348 PD=2.98 PS=2.98 NRD=0.241667 NRS=0.241667 SA=0 SB=0 SD=0 MULT=2 M=2
XX2_M80 op VSS VSS VSS sky130_fd_pr__nfet_01v8 L=0.6 W=1.4 NF=1 AD=0.406 AS=0.406 PD=3.38 PS=3.38 NRD=0.207143 NRS=0.207143 SA=0 SB=0 SD=0 MULT=2 M=2
XX2_M81 on VSS VSS VSS sky130_fd_pr__nfet_01v8 L=0.6 W=1.4 NF=1 AD=0.406 AS=0.406 PD=3.38 PS=3.38 NRD=0.207143 NRS=0.207143 SA=0 SB=0 SD=0 MULT=2 M=2
XX2_M28 x2_tail x2_tail x2_tail VSS sky130_fd_pr__nfet_01v8 L=0.6 W=1.4 NF=1 AD=0.406 AS=0.406 PD=3.38 PS=3.38 NRD=0.207143 NRS=0.207143 SA=0 SB=0 SD=0 MULT=6 M=6
XM43 VDD VDD VDD VDD sky130_fd_pr__pfet_01v8_lvt L=0.6 W=1.4 NF=1 AD=0.406 AS=0.406 PD=3.38 PS=3.38 NRD=0.207143 NRS=0.207143 SA=0 SB=0 SD=0 MULT=8 M=8
XM45 VDD VDD VDD VDD sky130_fd_pr__pfet_01v8 L=0.6 W=1.4 NF=1 AD=0.406 AS=0.406 PD=3.38 PS=3.38 NRD=0.207143 NRS=0.207143 SA=0 SB=0 SD=0 MULT=6 M=6
XM9 VSS VSS VSS VSS sky130_fd_pr__nfet_01v8 L=0.6 W=1.4 NF=1 AD=0.406 AS=0.406 PD=3.38 PS=3.38 NRD=0.207143 NRS=0.207143 SA=0 SB=0 SD=0 MULT=23 M=23
Ibias_ext VDD i_bias 3e-05
XC3 op cmc sky130_fd_pr__cap_mim_m3_1 W=4.8 L=4.8 MF=4 M=4
XC4 on cmc sky130_fd_pr__cap_mim_m3_1 W=4.8 L=4.8 MF=4 M=4
.ends iadc_ota
.end
