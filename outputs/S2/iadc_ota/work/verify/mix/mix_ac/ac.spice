* iadc_ota on dido_amp_AC
.lib $PDK_ROOT/sky130A/libs.tech/combined/sky130.lib.spice tt
.param VDD_V=1.8 VCM_V=0.9 CL_F=0.3p
.temp 27

**.subckt dido_amp_AC
x1 INP INN OUTN VDD 0 OUTP dut_amp
Vsup VDD 0 'VDD_V'
* AC drive through 1 F couplers; DC set by unity feedback through 1 GH chokes (OUTP->INN, OUTN->INP)
Vacp ACP 0 dc 0 ac 0.5
Vacn ACN 0 dc 0 ac -0.5
Cinp ACP INP 1
Cinn ACN INN 1
Lfbp OUTP INN 1G
Lfbn OUTN INP 1G
Cloadp OUTP 0 'CL_F'
Cloadn OUTN 0 'CL_F'
.control
  save all
  ac dec 40 1 1G
  let hsig = v(OUTP) - v(OUTN)
  let hdb = db(hsig)
  let gph_deg = 180/pi * cph(hsig)
  meas ac gain_db find hdb at=1
  meas ac gbw_hz  when hdb=0
  meas ac ph_dc   find gph_deg at=1
  meas ac ph_ugb  find gph_deg when hdb=0
  let gbw_mhz = gbw_hz / 1e6
  let pm_deg  = 180 + (ph_ugb - ph_dc)
  echo MEAS gain_db $&gain_db
  echo MEAS gbw_mhz $&gbw_mhz
  echo MEAS pm_deg $&pm_deg
  write
  quit 0
.endc
**.ends

.subckt dut_amp INP INN OUTN VDD VSS OUTP
XDUT INP INN OUTP OUTN VDD VSS cmc_w cm_w bias_a_w iadc_ota
* ideal CMFB: the steady-state law of the upstream switched-capacitor CMFB (ASSUMPTION)
Bcmfb cmc_w VSS V = v(bias_a_w) + (v(OUTP) + v(OUTN))/2 - v(cm_w)
.ends

.subckt iadc_ota ip in op on VDD VSS cmc cm bias_a
Cbud_s2_0 bias_a VSS 1.87189f
Cbud_s2_1 bias_b VSS 1.52156f
Cbud_s2_2 bias_c VSS 1.02598f
Cbud_s2_3 bias_d VSS 1.2741f
Cbud_s2_4 cm VSS 257.284f
Cbud_s2_5 i_bias VSS 280.725f
Cbud_s2_6 on VSS 0.384671f
Cbud_s2_7 op VSS 0.384671f
Cbud_s2_8 x1_m21d VSS 0.146112f
Cbud_s2_9 x1_m25d VSS 0.169252f
Cbud_s2_10 x1_m2d VSS 0.834217f
Cbud_s2_11 x1_m31d VSS 0.119346f
Cbud_s2_12 x1_m5d VSS 187.821f
Cbud_s2_13 x1_net1 VSS 0.013103f
Cbud_s2_14 x1_net10 VSS 0.0130157f
Cbud_s2_15 x1_net11 VSS 7.70745f
Cbud_s2_16 x1_net12 VSS 0.181332f
Cbud_s2_17 x1_net13 VSS 0.0130157f
Cbud_s2_18 x1_net14 VSS 7.70976f
Cbud_s2_19 x1_net15 VSS 0.181332f
Cbud_s2_20 x1_net2 VSS 7.70976f
Cbud_s2_21 x1_net3 VSS 0.181332f
Cbud_s2_22 x1_net4 VSS 0.013103f
Cbud_s2_23 x1_net5 VSS 0.0131735f
Cbud_s2_24 x1_net6 VSS 8.31742f
Cbud_s2_25 x1_net7 VSS 0.013103f
Cbud_s2_26 x1_net8 VSS 0.0130465f
Cbud_s2_27 x1_net9 VSS 8.31742f
Cbud_s2_28 x2_foldn VSS 0.310813f
Cbud_s2_29 x2_foldp VSS 0.310813f
Cbud_s2_30 x2_m3d VSS 0.445965f
Cbud_s2_31 x2_m4d VSS 0.431969f
Cbud_s2_32 x2_tail VSS 738.605f
Cbud_s2_33 bias_a bias_b 0.0669285f
Cbud_s2_34 bias_a bias_c 0.0530988f
Cbud_s2_35 bias_a bias_d 0.0820457f
Cbud_s2_36 bias_a cm 0.0285369f
Cbud_s2_37 bias_a i_bias 0.0198572f
Cbud_s2_38 bias_a on 0.0323608f
Cbud_s2_39 bias_a op 0.0323608f
Cbud_s2_40 bias_a x1_m21d 0.0105999f
Cbud_s2_41 bias_a x1_m25d 0.012282f
Cbud_s2_42 bias_a x1_m2d 0.0452199f
Cbud_s2_43 bias_a x1_m31d 0.00855443f
Cbud_s2_44 bias_a x1_m5d 33.1724f
Cbud_s2_45 bias_a x1_net1 0.00136837f
Cbud_s2_46 bias_a x1_net10 0.00136837f
Cbud_s2_47 bias_a x1_net11 0.00136838f
Cbud_s2_48 bias_a x1_net12 0.00136838f
Cbud_s2_49 bias_a x1_net13 0.00136837f
Cbud_s2_50 bias_a x1_net14 0.00136838f
Cbud_s2_51 bias_a x1_net15 0.00136838f
Cbud_s2_52 bias_a x1_net2 0.00136838f
Cbud_s2_53 bias_a x1_net3 0.00136838f
Cbud_s2_54 bias_a x1_net4 0.00136837f
Cbud_s2_55 bias_a x1_net5 0.00136838f
Cbud_s2_56 bias_a x1_net6 0.00136838f
Cbud_s2_57 bias_a x1_net7 0.00136837f
Cbud_s2_58 bias_a x1_net8 0.00136838f
Cbud_s2_59 bias_a x1_net9 0.00136838f
Cbud_s2_60 bias_a x2_foldn 0.0228281f
Cbud_s2_61 bias_a x2_foldp 0.0228281f
Cbud_s2_62 bias_a x2_m3d 0.0683082f
Cbud_s2_63 bias_a x2_m4d 0.0676322f
Cbud_s2_64 bias_a x2_tail 0.158962f
Cbud_s2_65 bias_a ip 0.00226553f
Cbud_s2_66 bias_a in 0.00195525f
Cbud_s2_67 bias_b bias_c 0.169367f
Cbud_s2_68 bias_b bias_d 0.0597454f
Cbud_s2_69 bias_b cm 17.1082f
Cbud_s2_70 bias_b i_bias 11.9046f
Cbud_s2_71 bias_b on 0.0323608f
Cbud_s2_72 bias_b op 0.0323608f
Cbud_s2_73 bias_b x1_m21d 0.0226837f
Cbud_s2_74 bias_b x1_m25d 0.0189329f
Cbud_s2_75 bias_b x1_m2d 0.0430031f
Cbud_s2_76 bias_b x1_m31d 8.56958f
Cbud_s2_77 bias_b x1_m5d 11.9046f
Cbud_s2_78 bias_b x1_net1 0.00158159f
Cbud_s2_79 bias_b x1_net10 0.00137589f
Cbud_s2_80 bias_b x1_net11 0.00162641f
Cbud_s2_81 bias_b x1_net12 0.00138759f
Cbud_s2_82 bias_b x1_net13 0.00158159f
Cbud_s2_83 bias_b x1_net14 0.00137938f
Cbud_s2_84 bias_b x1_net15 0.00138759f
Cbud_s2_85 bias_b x1_net2 0.00137938f
Cbud_s2_86 bias_b x1_net3 0.00138759f
Cbud_s2_87 bias_b x1_net4 0.00158159f
Cbud_s2_88 bias_b x1_net5 0.00143674f
Cbud_s2_89 bias_b x1_net6 0.00172958f
Cbud_s2_90 bias_b x1_net7 0.00158159f
Cbud_s2_91 bias_b x1_net8 0.00137938f
Cbud_s2_92 bias_b x1_net9 0.00172958f
Cbud_s2_93 bias_b x2_foldn 0.0457874f
Cbud_s2_94 bias_b x2_foldp 0.0457874f
Cbud_s2_95 bias_b x2_m3d 0.028404f
Cbud_s2_96 bias_b x2_m4d 0.027728f
Cbud_s2_97 bias_b x2_tail 40.1245f
Cbud_s2_98 bias_b ip 0.00226553f
Cbud_s2_99 bias_b in 0.00195525f
Cbud_s2_100 bias_c bias_d 0.0597454f
Cbud_s2_101 bias_c cm 0.034312f
Cbud_s2_102 bias_c i_bias 0.0370876f
Cbud_s2_103 bias_c on 0.0445388f
Cbud_s2_104 bias_c op 0.0445388f
Cbud_s2_105 bias_c x1_m21d 0.0163995f
Cbud_s2_106 bias_c x1_m25d 0.0189329f
Cbud_s2_107 bias_c x1_m2d 0.0496538f
Cbud_s2_108 bias_c x1_m31d 0.0143528f
Cbud_s2_109 bias_c x1_m5d 11.9046f
Cbud_s2_110 bias_c x1_net1 0.00138806f
Cbud_s2_111 bias_c x1_net10 0.00138806f
Cbud_s2_112 bias_c x1_net11 0.00139417f
Cbud_s2_113 bias_c x1_net12 0.00138788f
Cbud_s2_114 bias_c x1_net13 0.00138806f
Cbud_s2_115 bias_c x1_net14 0.00140076f
Cbud_s2_116 bias_c x1_net15 0.00138788f
Cbud_s2_117 bias_c x1_net2 0.00140076f
Cbud_s2_118 bias_c x1_net3 0.00138788f
Cbud_s2_119 bias_c x1_net4 0.0013832f
Cbud_s2_120 bias_c x1_net5 0.00140076f
Cbud_s2_121 bias_c x1_net6 0.00138771f
Cbud_s2_122 bias_c x1_net7 0.0013832f
Cbud_s2_123 bias_c x1_net8 0.00139417f
Cbud_s2_124 bias_c x1_net9 0.00138771f
Cbud_s2_125 bias_c x2_foldn 0.0333381f
Cbud_s2_126 bias_c x2_foldp 0.0333381f
Cbud_s2_127 bias_c x2_m3d 0.028404f
Cbud_s2_128 bias_c x2_m4d 0.027728f
Cbud_s2_129 bias_c x2_tail 31.8427f
Cbud_s2_130 bias_c ip 0.00226553f
Cbud_s2_131 bias_c in 0.00195525f
Cbud_s2_132 bias_d cm 0.0330654f
Cbud_s2_133 bias_d i_bias 0.0230083f
Cbud_s2_134 bias_d on 0.072265f
Cbud_s2_135 bias_d op 0.072265f
Cbud_s2_136 bias_d x1_m21d 0.0122819f
Cbud_s2_137 bias_d x1_m25d 0.012282f
Cbud_s2_138 bias_d x1_m2d 0.159347f
Cbud_s2_139 bias_d x1_m31d 0.00991189f
Cbud_s2_140 bias_d x1_m5d 0.0429604f
Cbud_s2_141 bias_d x1_net1 0.00158549f
Cbud_s2_142 bias_d x1_net10 0.00158549f
Cbud_s2_143 bias_d x1_net11 0.00158549f
Cbud_s2_144 bias_d x1_net12 0.00158549f
Cbud_s2_145 bias_d x1_net13 0.00158549f
Cbud_s2_146 bias_d x1_net14 0.00158549f
Cbud_s2_147 bias_d x1_net15 0.00158549f
Cbud_s2_148 bias_d x1_net2 0.00158549f
Cbud_s2_149 bias_d x1_net3 0.00158549f
Cbud_s2_150 bias_d x1_net4 0.00158549f
Cbud_s2_151 bias_d x1_net5 0.00158549f
Cbud_s2_152 bias_d x1_net6 0.00158549f
Cbud_s2_153 bias_d x1_net7 0.00158549f
Cbud_s2_154 bias_d x1_net8 0.00158549f
Cbud_s2_155 bias_d x1_net9 0.00158549f
Cbud_s2_156 bias_d x2_foldn 0.0228281f
Cbud_s2_157 bias_d x2_foldp 0.0228281f
Cbud_s2_158 bias_d x2_m3d 0.0683082f
Cbud_s2_159 bias_d x2_m4d 0.0676322f
Cbud_s2_160 bias_d x2_tail 0.0597454f
Cbud_s2_161 bias_d ip 0.00226553f
Cbud_s2_162 bias_d in 0.00195525f
Cbud_s2_163 cm i_bias 0.0198768f
Cbud_s2_164 cm on 0.0323608f
Cbud_s2_165 cm op 0.0323608f
Cbud_s2_166 cm x1_m21d 0.0115278f
Cbud_s2_167 cm x1_m25d 0.0122822f
Cbud_s2_168 cm x1_m2d 0.0330655f
Cbud_s2_169 cm x1_m31d 0.0146458f
Cbud_s2_170 cm x1_m5d 11.9081f
Cbud_s2_171 cm x1_net1 2.57561f
Cbud_s2_172 cm x1_net10 0.140053f
Cbud_s2_173 cm x1_net11 0.157216f
Cbud_s2_174 cm x1_net12 1.96735f
Cbud_s2_175 cm x1_net13 0.140053f
Cbud_s2_176 cm x1_net14 0.0698765f
Cbud_s2_177 cm x1_net15 1.96735f
Cbud_s2_178 cm x1_net2 0.0698765f
Cbud_s2_179 cm x1_net3 1.96735f
Cbud_s2_180 cm x1_net4 0.0693947f
Cbud_s2_181 cm x1_net5 1.96794f
Cbud_s2_182 cm x1_net6 1.96735f
Cbud_s2_183 cm x1_net7 0.0693947f
Cbud_s2_184 cm x1_net8 0.157216f
Cbud_s2_185 cm x1_net9 1.96735f
Cbud_s2_186 cm x2_foldn 0.0228281f
Cbud_s2_187 cm x2_foldp 0.0228281f
Cbud_s2_188 cm x2_m3d 0.028404f
Cbud_s2_189 cm x2_m4d 0.027728f
Cbud_s2_190 cm x2_tail 0.0332831f
Cbud_s2_191 cm ip 0.00226553f
Cbud_s2_192 cm in 0.00195525f
Cbud_s2_193 i_bias on 0.0230082f
Cbud_s2_194 i_bias op 0.0230082f
Cbud_s2_195 i_bias x1_m21d 0.0106226f
Cbud_s2_196 i_bias x1_m25d 0.0122822f
Cbud_s2_197 i_bias x1_m2d 0.0230084f
Cbud_s2_198 i_bias x1_m31d 0.00859366f
Cbud_s2_199 i_bias x1_m5d 11.9046f
Cbud_s2_200 i_bias x1_net1 0.00428087f
Cbud_s2_201 i_bias x1_net10 0.00428087f
Cbud_s2_202 i_bias x1_net11 0.00497466f
Cbud_s2_203 i_bias x1_net12 0.0058933f
Cbud_s2_204 i_bias x1_net13 0.00428087f
Cbud_s2_205 i_bias x1_net14 0.00473095f
Cbud_s2_206 i_bias x1_net15 0.0058933f
Cbud_s2_207 i_bias x1_net2 0.00473095f
Cbud_s2_208 i_bias x1_net3 0.0058933f
Cbud_s2_209 i_bias x1_net4 0.00428087f
Cbud_s2_210 i_bias x1_net5 0.0048556f
Cbud_s2_211 i_bias x1_net6 0.00589357f
Cbud_s2_212 i_bias x1_net7 0.00428088f
Cbud_s2_213 i_bias x1_net8 0.00497466f
Cbud_s2_214 i_bias x1_net9 0.00589384f
Cbud_s2_215 i_bias x2_foldn 0.0198571f
Cbud_s2_216 i_bias x2_foldp 0.0198571f
Cbud_s2_217 i_bias x2_m3d 0.0230082f
Cbud_s2_218 i_bias x2_m4d 0.0230082f
Cbud_s2_219 i_bias x2_tail 0.0198624f
Cbud_s2_220 i_bias ip 0.00195525f
Cbud_s2_221 i_bias in 0.00226553f
Cbud_s2_222 on op 0.0323608f
Cbud_s2_223 on x1_m21d 0.0122819f
Cbud_s2_224 on x1_m25d 0.0122819f
Cbud_s2_225 on x1_m2d 0.0323608f
Cbud_s2_226 on x1_m31d 0.00991187f
Cbud_s2_227 on x1_m5d 0.0230082f
Cbud_s2_228 on x1_net1 0.00158546f
Cbud_s2_229 on x1_net10 0.00158546f
Cbud_s2_230 on x1_net11 0.00158546f
Cbud_s2_231 on x1_net12 0.00158546f
Cbud_s2_232 on x1_net13 0.00158546f
Cbud_s2_233 on x1_net14 0.00158546f
Cbud_s2_234 on x1_net15 0.00158546f
Cbud_s2_235 on x1_net2 0.00158546f
Cbud_s2_236 on x1_net3 0.00158546f
Cbud_s2_237 on x1_net4 0.00158546f
Cbud_s2_238 on x1_net5 0.00158546f
Cbud_s2_239 on x1_net6 0.00158546f
Cbud_s2_240 on x1_net7 0.00158546f
Cbud_s2_241 on x1_net8 0.00158546f
Cbud_s2_242 on x1_net9 0.00158546f
Cbud_s2_243 on x2_foldn 0.0228281f
Cbud_s2_244 on x2_foldp 0.039337f
Cbud_s2_245 on x2_m3d 0.0609925f
Cbud_s2_246 on x2_m4d 0.027728f
Cbud_s2_247 on x2_tail 0.0323608f
Cbud_s2_248 on ip 0.00195525f
Cbud_s2_249 on in 0.00226553f
Cbud_s2_250 op x1_m21d 0.0122819f
Cbud_s2_251 op x1_m25d 0.0122819f
Cbud_s2_252 op x1_m2d 0.0323608f
Cbud_s2_253 op x1_m31d 0.00991187f
Cbud_s2_254 op x1_m5d 0.0230082f
Cbud_s2_255 op x1_net1 0.00158546f
Cbud_s2_256 op x1_net10 0.00158546f
Cbud_s2_257 op x1_net11 0.00158546f
Cbud_s2_258 op x1_net12 0.00158546f
Cbud_s2_259 op x1_net13 0.00158546f
Cbud_s2_260 op x1_net14 0.00158546f
Cbud_s2_261 op x1_net15 0.00158546f
Cbud_s2_262 op x1_net2 0.00158546f
Cbud_s2_263 op x1_net3 0.00158546f
Cbud_s2_264 op x1_net4 0.00158546f
Cbud_s2_265 op x1_net5 0.00158546f
Cbud_s2_266 op x1_net6 0.00158546f
Cbud_s2_267 op x1_net7 0.00158546f
Cbud_s2_268 op x1_net8 0.00158546f
Cbud_s2_269 op x1_net9 0.00158546f
Cbud_s2_270 op x2_foldn 0.039337f
Cbud_s2_271 op x2_foldp 0.0228281f
Cbud_s2_272 op x2_m3d 0.028404f
Cbud_s2_273 op x2_m4d 0.060409f
Cbud_s2_274 op x2_tail 0.0323608f
Cbud_s2_275 op ip 0.00226553f
Cbud_s2_276 op in 0.00195525f
Cbud_s2_277 x1_m21d x1_m25d 0.0122822f
Cbud_s2_278 x1_m21d x1_m2d 0.012282f
Cbud_s2_279 x1_m21d x1_m31d 0.145422f
Cbud_s2_280 x1_m21d x1_m5d 6.35475f
Cbud_s2_281 x1_m21d x1_net1 0.00548775f
Cbud_s2_282 x1_m21d x1_net10 0.00561701f
Cbud_s2_283 x1_m21d x1_net11 0.00190807f
Cbud_s2_284 x1_m21d x1_net12 0.00197157f
Cbud_s2_285 x1_m21d x1_net13 0.00548775f
Cbud_s2_286 x1_m21d x1_net14 0.00174873f
Cbud_s2_287 x1_m21d x1_net15 0.00197157f
Cbud_s2_288 x1_m21d x1_net2 0.00174873f
Cbud_s2_289 x1_m21d x1_net3 0.00197157f
Cbud_s2_290 x1_m21d x1_net4 0.00561701f
Cbud_s2_291 x1_m21d x1_net5 0.00174873f
Cbud_s2_292 x1_m21d x1_net6 0.00197157f
Cbud_s2_293 x1_m21d x1_net7 0.00548774f
Cbud_s2_294 x1_m21d x1_net8 0.00174399f
Cbud_s2_295 x1_m21d x1_net9 0.00197157f
Cbud_s2_296 x1_m21d x2_foldn 0.0105998f
Cbud_s2_297 x1_m21d x2_foldp 0.0105998f
Cbud_s2_298 x1_m21d x2_m3d 0.0122819f
Cbud_s2_299 x1_m21d x2_m4d 0.0122819f
Cbud_s2_300 x1_m21d x2_tail 6.3566f
Cbud_s2_301 x1_m21d ip 0.00226553f
Cbud_s2_302 x1_m21d in 0.00195525f
Cbud_s2_303 x1_m25d x1_m2d 0.0193281f
Cbud_s2_304 x1_m25d x1_m31d 0.00991214f
Cbud_s2_305 x1_m25d x1_m5d 0.0106001f
Cbud_s2_306 x1_m25d x1_net1 0.00158576f
Cbud_s2_307 x1_m25d x1_net10 0.00158576f
Cbud_s2_308 x1_m25d x1_net11 0.00158576f
Cbud_s2_309 x1_m25d x1_net12 0.00158576f
Cbud_s2_310 x1_m25d x1_net13 0.00158576f
Cbud_s2_311 x1_m25d x1_net14 0.00158576f
Cbud_s2_312 x1_m25d x1_net15 0.00158576f
Cbud_s2_313 x1_m25d x1_net2 0.00158576f
Cbud_s2_314 x1_m25d x1_net3 0.00158576f
Cbud_s2_315 x1_m25d x1_net4 0.00158576f
Cbud_s2_316 x1_m25d x1_net5 0.00158576f
Cbud_s2_317 x1_m25d x1_net6 0.00158576f
Cbud_s2_318 x1_m25d x1_net7 0.00158576f
Cbud_s2_319 x1_m25d x1_net8 0.00158576f
Cbud_s2_320 x1_m25d x1_net9 0.00158576f
Cbud_s2_321 x1_m25d x2_foldn 0.0105998f
Cbud_s2_322 x1_m25d x2_foldp 0.0105998f
Cbud_s2_323 x1_m25d x2_m3d 0.0122819f
Cbud_s2_324 x1_m25d x2_m4d 0.0122819f
Cbud_s2_325 x1_m25d x2_tail 0.0122822f
Cbud_s2_326 x1_m25d ip 0.00226553f
Cbud_s2_327 x1_m25d in 0.00195525f
Cbud_s2_328 x1_m2d x1_m31d 0.00991199f
Cbud_s2_329 x1_m2d x1_m5d 0.0230103f
Cbud_s2_330 x1_m2d x1_net1 0.00158559f
Cbud_s2_331 x1_m2d x1_net10 0.00158559f
Cbud_s2_332 x1_m2d x1_net11 0.00158559f
Cbud_s2_333 x1_m2d x1_net12 0.00158559f
Cbud_s2_334 x1_m2d x1_net13 0.00158559f
Cbud_s2_335 x1_m2d x1_net14 0.00158559f
Cbud_s2_336 x1_m2d x1_net15 0.00158559f
Cbud_s2_337 x1_m2d x1_net2 0.00158559f
Cbud_s2_338 x1_m2d x1_net3 0.00158559f
Cbud_s2_339 x1_m2d x1_net4 0.00158559f
Cbud_s2_340 x1_m2d x1_net5 0.00158559f
Cbud_s2_341 x1_m2d x1_net6 0.00158559f
Cbud_s2_342 x1_m2d x1_net7 0.00158559f
Cbud_s2_343 x1_m2d x1_net8 0.00158559f
Cbud_s2_344 x1_m2d x1_net9 0.00158559f
Cbud_s2_345 x1_m2d x2_foldn 0.0228281f
Cbud_s2_346 x1_m2d x2_foldp 0.0228281f
Cbud_s2_347 x1_m2d x2_m3d 0.028404f
Cbud_s2_348 x1_m2d x2_m4d 0.027728f
Cbud_s2_349 x1_m2d x2_tail 0.0430031f
Cbud_s2_350 x1_m2d ip 0.00226553f
Cbud_s2_351 x1_m2d in 0.00195525f
Cbud_s2_352 x1_m31d x1_m5d 5.12847f
Cbud_s2_353 x1_m31d x1_net1 0.00609298f
Cbud_s2_354 x1_m31d x1_net10 0.00609298f
Cbud_s2_355 x1_m31d x1_net11 0.006783f
Cbud_s2_356 x1_m31d x1_net12 0.00829841f
Cbud_s2_357 x1_m31d x1_net13 0.00633146f
Cbud_s2_358 x1_m31d x1_net14 0.00708993f
Cbud_s2_359 x1_m31d x1_net15 0.00829841f
Cbud_s2_360 x1_m31d x1_net2 0.00708993f
Cbud_s2_361 x1_m31d x1_net3 0.00829841f
Cbud_s2_362 x1_m31d x1_net4 0.00620453f
Cbud_s2_363 x1_m31d x1_net5 0.00708993f
Cbud_s2_364 x1_m31d x1_net6 0.00743782f
Cbud_s2_365 x1_m31d x1_net7 0.00633146f
Cbud_s2_366 x1_m31d x1_net8 0.00708993f
Cbud_s2_367 x1_m31d x1_net9 0.00743782f
Cbud_s2_368 x1_m31d x2_foldn 0.00855437f
Cbud_s2_369 x1_m31d x2_foldp 0.00855437f
Cbud_s2_370 x1_m31d x2_m3d 0.00991187f
Cbud_s2_371 x1_m31d x2_m4d 0.00991187f
Cbud_s2_372 x1_m31d x2_tail 0.00860755f
Cbud_s2_373 x1_m31d ip 0.00195525f
Cbud_s2_374 x1_m31d in 1.17254f
Cbud_s2_375 x1_m5d x1_net1 0.82057f
Cbud_s2_376 x1_m5d x1_net10 0.82057f
Cbud_s2_377 x1_m5d x1_net11 0.82057f
Cbud_s2_378 x1_m5d x1_net12 0.82057f
Cbud_s2_379 x1_m5d x1_net13 0.82057f
Cbud_s2_380 x1_m5d x1_net14 0.82057f
Cbud_s2_381 x1_m5d x1_net15 0.82057f
Cbud_s2_382 x1_m5d x1_net2 0.82057f
Cbud_s2_383 x1_m5d x1_net3 0.82057f
Cbud_s2_384 x1_m5d x1_net4 0.82057f
Cbud_s2_385 x1_m5d x1_net5 0.82057f
Cbud_s2_386 x1_m5d x1_net6 0.82057f
Cbud_s2_387 x1_m5d x1_net7 0.82057f
Cbud_s2_388 x1_m5d x1_net8 0.82057f
Cbud_s2_389 x1_m5d x1_net9 0.82057f
Cbud_s2_390 x1_m5d x2_foldn 0.0198571f
Cbud_s2_391 x1_m5d x2_foldp 0.0198571f
Cbud_s2_392 x1_m5d x2_m3d 0.0230082f
Cbud_s2_393 x1_m5d x2_m4d 0.0230082f
Cbud_s2_394 x1_m5d x2_tail 11.9081f
Cbud_s2_395 x1_m5d ip 0.00226553f
Cbud_s2_396 x1_m5d in 0.00195525f
Cbud_s2_397 x1_net1 x1_net10 0.00651122f
Cbud_s2_398 x1_net1 x1_net11 0.82057f
Cbud_s2_399 x1_net1 x1_net12 0.82057f
Cbud_s2_400 x1_net1 x1_net13 0.00651122f
Cbud_s2_401 x1_net1 x1_net14 0.82057f
Cbud_s2_402 x1_net1 x1_net15 0.82057f
Cbud_s2_403 x1_net1 x1_net2 1.42823f
Cbud_s2_404 x1_net1 x1_net3 0.00651122f
Cbud_s2_405 x1_net1 x1_net4 0.00651122f
Cbud_s2_406 x1_net1 x1_net5 0.82057f
Cbud_s2_407 x1_net1 x1_net6 0.823374f
Cbud_s2_408 x1_net1 x1_net7 0.00637152f
Cbud_s2_409 x1_net1 x1_net8 0.82057f
Cbud_s2_410 x1_net1 x1_net9 0.823374f
Cbud_s2_411 x1_net1 x2_foldn 0.00136832f
Cbud_s2_412 x1_net1 x2_foldp 0.00136832f
Cbud_s2_413 x1_net1 x2_m3d 0.00158546f
Cbud_s2_414 x1_net1 x2_m4d 0.00158546f
Cbud_s2_415 x1_net1 x2_tail 0.0148796f
Cbud_s2_416 x1_net1 ip 0.00158547f
Cbud_s2_417 x1_net1 in 0.00136832f
Cbud_s2_418 x1_net10 x1_net11 1.42823f
Cbud_s2_419 x1_net10 x1_net12 0.00633146f
Cbud_s2_420 x1_net10 x1_net13 0.82057f
Cbud_s2_421 x1_net10 x1_net14 0.82057f
Cbud_s2_422 x1_net10 x1_net15 0.823374f
Cbud_s2_423 x1_net10 x1_net2 0.82057f
Cbud_s2_424 x1_net10 x1_net3 0.823374f
Cbud_s2_425 x1_net10 x1_net4 0.00651122f
Cbud_s2_426 x1_net10 x1_net5 0.82057f
Cbud_s2_427 x1_net10 x1_net6 0.82057f
Cbud_s2_428 x1_net10 x1_net7 0.00637152f
Cbud_s2_429 x1_net10 x1_net8 0.82057f
Cbud_s2_430 x1_net10 x1_net9 0.82057f
Cbud_s2_431 x1_net10 x2_foldn 0.00136832f
Cbud_s2_432 x1_net10 x2_foldp 0.00136832f
Cbud_s2_433 x1_net10 x2_m3d 0.00158546f
Cbud_s2_434 x1_net10 x2_m4d 0.00158546f
Cbud_s2_435 x1_net10 x2_tail 0.0148796f
Cbud_s2_436 x1_net10 ip 0.00158547f
Cbud_s2_437 x1_net10 in 0.00136832f
Cbud_s2_438 x1_net11 x1_net12 1.42823f
Cbud_s2_439 x1_net11 x1_net13 0.82057f
Cbud_s2_440 x1_net11 x1_net14 0.82057f
Cbud_s2_441 x1_net11 x1_net15 0.82057f
Cbud_s2_442 x1_net11 x1_net2 0.82057f
Cbud_s2_443 x1_net11 x1_net3 0.82057f
Cbud_s2_444 x1_net11 x1_net4 0.82057f
Cbud_s2_445 x1_net11 x1_net5 0.82057f
Cbud_s2_446 x1_net11 x1_net6 0.82057f
Cbud_s2_447 x1_net11 x1_net7 0.82057f
Cbud_s2_448 x1_net11 x1_net8 0.82057f
Cbud_s2_449 x1_net11 x1_net9 0.82057f
Cbud_s2_450 x1_net11 x2_foldn 0.00136832f
Cbud_s2_451 x1_net11 x2_foldp 0.00136832f
Cbud_s2_452 x1_net11 x2_m3d 0.00158546f
Cbud_s2_453 x1_net11 x2_m4d 0.00158546f
Cbud_s2_454 x1_net11 x2_tail 0.0148796f
Cbud_s2_455 x1_net11 ip 0.00158547f
Cbud_s2_456 x1_net11 in 0.00136833f
Cbud_s2_457 x1_net12 x1_net13 0.823374f
Cbud_s2_458 x1_net12 x1_net14 0.82057f
Cbud_s2_459 x1_net12 x1_net2 0.82057f
Cbud_s2_460 x1_net12 x1_net4 0.00637152f
Cbud_s2_461 x1_net12 x1_net5 0.823374f
Cbud_s2_462 x1_net12 x1_net6 0.82057f
Cbud_s2_463 x1_net12 x1_net7 0.823374f
Cbud_s2_464 x1_net12 x1_net8 0.823374f
Cbud_s2_465 x1_net12 x1_net9 0.82057f
Cbud_s2_466 x1_net12 x2_foldn 0.00136832f
Cbud_s2_467 x1_net12 x2_foldp 0.00136832f
Cbud_s2_468 x1_net12 x2_m3d 0.00158546f
Cbud_s2_469 x1_net12 x2_m4d 0.00158546f
Cbud_s2_470 x1_net12 x2_tail 0.82057f
Cbud_s2_471 x1_net12 ip 0.00158547f
Cbud_s2_472 x1_net12 in 0.00136833f
Cbud_s2_473 x1_net13 x1_net14 0.00813622f
Cbud_s2_474 x1_net13 x1_net15 0.00633146f
Cbud_s2_475 x1_net13 x1_net2 0.82057f
Cbud_s2_476 x1_net13 x1_net3 0.823374f
Cbud_s2_477 x1_net13 x1_net4 0.00651122f
Cbud_s2_478 x1_net13 x1_net5 0.82057f
Cbud_s2_479 x1_net13 x1_net6 0.82057f
Cbud_s2_480 x1_net13 x1_net7 0.82057f
Cbud_s2_481 x1_net13 x1_net8 0.82057f
Cbud_s2_482 x1_net13 x1_net9 0.82057f
Cbud_s2_483 x1_net13 x2_foldn 0.00136832f
Cbud_s2_484 x1_net13 x2_foldp 0.00136832f
Cbud_s2_485 x1_net13 x2_m3d 0.00158546f
Cbud_s2_486 x1_net13 x2_m4d 0.00158546f
Cbud_s2_487 x1_net13 x2_tail 0.0148796f
Cbud_s2_488 x1_net13 ip 0.00158547f
Cbud_s2_489 x1_net13 in 0.00136832f
Cbud_s2_490 x1_net14 x1_net15 0.00864078f
Cbud_s2_491 x1_net14 x1_net3 0.82057f
Cbud_s2_492 x1_net14 x1_net4 0.82057f
Cbud_s2_493 x1_net14 x1_net5 0.82057f
Cbud_s2_494 x1_net14 x1_net6 0.820324f
Cbud_s2_495 x1_net14 x1_net7 0.82057f
Cbud_s2_496 x1_net14 x1_net8 0.82057f
Cbud_s2_497 x1_net14 x1_net9 0.820324f
Cbud_s2_498 x1_net14 x2_foldn 0.00136832f
Cbud_s2_499 x1_net14 x2_foldp 0.00136832f
Cbud_s2_500 x1_net14 x2_m3d 0.00158546f
Cbud_s2_501 x1_net14 x2_m4d 0.00158546f
Cbud_s2_502 x1_net14 x2_tail 0.0148796f
Cbud_s2_503 x1_net14 ip 0.00158547f
Cbud_s2_504 x1_net14 in 0.00136833f
Cbud_s2_505 x1_net15 x1_net2 0.82057f
Cbud_s2_506 x1_net15 x1_net4 0.00637152f
Cbud_s2_507 x1_net15 x1_net5 0.823374f
Cbud_s2_508 x1_net15 x1_net6 0.82057f
Cbud_s2_509 x1_net15 x1_net7 0.823374f
Cbud_s2_510 x1_net15 x1_net8 0.823374f
Cbud_s2_511 x1_net15 x1_net9 0.82057f
Cbud_s2_512 x1_net15 x2_foldn 0.00136832f
Cbud_s2_513 x1_net15 x2_foldp 0.00136832f
Cbud_s2_514 x1_net15 x2_m3d 0.00158546f
Cbud_s2_515 x1_net15 x2_m4d 0.00158546f
Cbud_s2_516 x1_net15 x2_tail 0.82057f
Cbud_s2_517 x1_net15 ip 0.00158547f
Cbud_s2_518 x1_net15 in 0.00136833f
Cbud_s2_519 x1_net2 x1_net3 0.00864078f
Cbud_s2_520 x1_net2 x1_net4 0.82057f
Cbud_s2_521 x1_net2 x1_net5 0.82057f
Cbud_s2_522 x1_net2 x1_net6 0.820324f
Cbud_s2_523 x1_net2 x1_net7 0.82057f
Cbud_s2_524 x1_net2 x1_net8 0.82057f
Cbud_s2_525 x1_net2 x1_net9 0.820324f
Cbud_s2_526 x1_net2 x2_foldn 0.00136832f
Cbud_s2_527 x1_net2 x2_foldp 0.00136832f
Cbud_s2_528 x1_net2 x2_m3d 0.00158546f
Cbud_s2_529 x1_net2 x2_m4d 0.00158546f
Cbud_s2_530 x1_net2 x2_tail 0.0148796f
Cbud_s2_531 x1_net2 ip 0.00158547f
Cbud_s2_532 x1_net2 in 0.00136833f
Cbud_s2_533 x1_net3 x1_net4 0.00637152f
Cbud_s2_534 x1_net3 x1_net5 0.823374f
Cbud_s2_535 x1_net3 x1_net6 0.82057f
Cbud_s2_536 x1_net3 x1_net7 0.823374f
Cbud_s2_537 x1_net3 x1_net8 0.823374f
Cbud_s2_538 x1_net3 x1_net9 0.82057f
Cbud_s2_539 x1_net3 x2_foldn 0.00136832f
Cbud_s2_540 x1_net3 x2_foldp 0.00136832f
Cbud_s2_541 x1_net3 x2_m3d 0.00158546f
Cbud_s2_542 x1_net3 x2_m4d 0.00158546f
Cbud_s2_543 x1_net3 x2_tail 0.82057f
Cbud_s2_544 x1_net3 ip 0.00158547f
Cbud_s2_545 x1_net3 in 0.00136833f
Cbud_s2_546 x1_net4 x1_net5 0.00767651f
Cbud_s2_547 x1_net4 x1_net6 0.00637152f
Cbud_s2_548 x1_net4 x1_net7 0.82057f
Cbud_s2_549 x1_net4 x1_net8 0.82057f
Cbud_s2_550 x1_net4 x1_net9 0.82057f
Cbud_s2_551 x1_net4 x2_foldn 0.00136832f
Cbud_s2_552 x1_net4 x2_foldp 0.00136832f
Cbud_s2_553 x1_net4 x2_m3d 0.00158546f
Cbud_s2_554 x1_net4 x2_m4d 0.00158546f
Cbud_s2_555 x1_net4 x2_tail 0.0148796f
Cbud_s2_556 x1_net4 ip 0.00158547f
Cbud_s2_557 x1_net4 in 0.00136832f
Cbud_s2_558 x1_net5 x1_net6 0.00813622f
Cbud_s2_559 x1_net5 x1_net7 0.82057f
Cbud_s2_560 x1_net5 x1_net8 0.006783f
Cbud_s2_561 x1_net5 x1_net9 0.006783f
Cbud_s2_562 x1_net5 x2_foldn 0.00136832f
Cbud_s2_563 x1_net5 x2_foldp 0.00136832f
Cbud_s2_564 x1_net5 x2_m3d 0.00158546f
Cbud_s2_565 x1_net5 x2_m4d 0.00158546f
Cbud_s2_566 x1_net5 x2_tail 0.0148796f
Cbud_s2_567 x1_net5 ip 0.00158547f
Cbud_s2_568 x1_net5 in 0.00136833f
Cbud_s2_569 x1_net6 x1_net7 0.823374f
Cbud_s2_570 x1_net6 x1_net8 0.00651122f
Cbud_s2_571 x1_net6 x2_foldn 0.00136832f
Cbud_s2_572 x1_net6 x2_foldp 0.00136832f
Cbud_s2_573 x1_net6 x2_m3d 0.00158546f
Cbud_s2_574 x1_net6 x2_m4d 0.00158546f
Cbud_s2_575 x1_net6 x2_tail 0.82057f
Cbud_s2_576 x1_net6 ip 0.00158547f
Cbud_s2_577 x1_net6 in 0.00136833f
Cbud_s2_578 x1_net7 x1_net8 0.00813622f
Cbud_s2_579 x1_net7 x1_net9 0.00637152f
Cbud_s2_580 x1_net7 x2_foldn 0.00136832f
Cbud_s2_581 x1_net7 x2_foldp 0.00136832f
Cbud_s2_582 x1_net7 x2_m3d 0.00158546f
Cbud_s2_583 x1_net7 x2_m4d 0.00158546f
Cbud_s2_584 x1_net7 x2_tail 0.0148796f
Cbud_s2_585 x1_net7 ip 0.00158547f
Cbud_s2_586 x1_net7 in 0.00136832f
Cbud_s2_587 x1_net8 x1_net9 0.00864078f
Cbud_s2_588 x1_net8 x2_foldn 0.00136832f
Cbud_s2_589 x1_net8 x2_foldp 0.00136832f
Cbud_s2_590 x1_net8 x2_m3d 0.00158546f
Cbud_s2_591 x1_net8 x2_m4d 0.00158546f
Cbud_s2_592 x1_net8 x2_tail 0.0148796f
Cbud_s2_593 x1_net8 ip 0.00158547f
Cbud_s2_594 x1_net8 in 0.00136833f
Cbud_s2_595 x1_net9 x2_foldn 0.00136832f
Cbud_s2_596 x1_net9 x2_foldp 0.00136832f
Cbud_s2_597 x1_net9 x2_m3d 0.00158546f
Cbud_s2_598 x1_net9 x2_m4d 0.00158546f
Cbud_s2_599 x1_net9 x2_tail 0.82057f
Cbud_s2_600 x1_net9 ip 0.00158547f
Cbud_s2_601 x1_net9 in 0.00136833f
Cbud_s2_602 x2_foldn x2_foldp 0.0228281f
Cbud_s2_603 x2_foldn x2_m3d 0.0228281f
Cbud_s2_604 x2_foldn x2_m4d 0.0228281f
Cbud_s2_605 x2_foldn x2_tail 0.0280416f
Cbud_s2_606 x2_foldn ip 0.00195525f
Cbud_s2_607 x2_foldn in 0.00401573f
Cbud_s2_608 x2_foldp x2_m3d 0.0228281f
Cbud_s2_609 x2_foldp x2_m4d 0.0228281f
Cbud_s2_610 x2_foldp x2_tail 0.0280416f
Cbud_s2_611 x2_foldp ip 0.00401573f
Cbud_s2_612 x2_foldp in 0.00195525f
Cbud_s2_613 x2_m3d x2_m4d 0.027728f
Cbud_s2_614 x2_m3d x2_tail 0.028404f
Cbud_s2_615 x2_m3d ip 0.00195525f
Cbud_s2_616 x2_m3d in 1.1722f
Cbud_s2_617 x2_m4d x2_tail 0.027728f
Cbud_s2_618 x2_m4d ip 1.1722f
Cbud_s2_619 x2_m4d in 0.00195525f
Cbud_s2_620 x2_tail ip 0.00401573f
Cbud_s2_621 x2_tail in 0.00465299f
XX1_M22 s1r_XX1_M22_d s1r_XX1_M22_g s1r_XX1_M22_s VDD sky130_fd_pr__pfet_01v8 L=0.6 W=1.4 NF=1 AD=0.406 AS=0.406 PD=3.38 PS=3.38 NRD=0.207143 NRS=0.207143 SA=0 SB=0 SD=0 MULT=6 M=6
Rpar_s1_XX1_M22_s s1r_XX1_M22_s x1_m21d 0.553403
Rpar_s1_XX1_M22_g s1r_XX1_M22_g bias_c 0.391903
Rpar_s1_XX1_M22_d s1r_XX1_M22_d bias_b 0.553403
XX1_M26 s1r_XX1_M26_d s1r_XX1_M26_g s1r_XX1_M26_s VDD sky130_fd_pr__pfet_01v8 L=0.6 W=1.4 NF=1 AD=0.406 AS=0.406 PD=3.38 PS=3.38 NRD=0.207143 NRS=0.207143 SA=0 SB=0 SD=0 MULT=6 M=6
Rpar_s1_XX1_M26_s s1r_XX1_M26_s x1_m25d 0.553403
Rpar_s1_XX1_M26_g s1r_XX1_M26_g bias_c 0.452629
Rpar_s1_XX1_M26_d s1r_XX1_M26_d x1_m2d 0.553403
XX1_M32 s1r_XX1_M32_d s1r_XX1_M32_g s1r_XX1_M32_s VDD sky130_fd_pr__pfet_01v8 L=0.6 W=1.4 NF=1 AD=0.406 AS=0.406 PD=3.38 PS=3.38 NRD=0.207143 NRS=0.207143 SA=0 SB=0 SD=0 MULT=6 M=6
Rpar_s1_XX1_M32_s s1r_XX1_M32_s x1_m31d 0.641223
Rpar_s1_XX1_M32_g s1r_XX1_M32_g bias_c 234.219
Rpar_s1_XX1_M32_d s1r_XX1_M32_d cm 3.86649
XX1_M21 s1r_XX1_M21_d s1r_XX1_M21_g s1r_XX1_M21_s VDD sky130_fd_pr__pfet_01v8_lvt L=0.6 W=1.4 NF=1 AD=0.406 AS=0.406 PD=3.38 PS=3.38 NRD=0.207143 NRS=0.207143 SA=0 SB=0 SD=0 MULT=6 M=6
Rpar_s1_XX1_M21_s s1r_XX1_M21_s VDD 0.553403
Rpar_s1_XX1_M21_g s1r_XX1_M21_g bias_b 234.219
Rpar_s1_XX1_M21_d s1r_XX1_M21_d x1_m21d 0.553403
XX1_M25 s1r_XX1_M25_d s1r_XX1_M25_g s1r_XX1_M25_s VDD sky130_fd_pr__pfet_01v8_lvt L=0.6 W=1.4 NF=1 AD=0.406 AS=0.406 PD=3.38 PS=3.38 NRD=0.207143 NRS=0.207143 SA=0 SB=0 SD=0 MULT=6 M=6
Rpar_s1_XX1_M25_s s1r_XX1_M25_s VDD 0.553403
Rpar_s1_XX1_M25_g s1r_XX1_M25_g bias_b 0.453112
Rpar_s1_XX1_M25_d s1r_XX1_M25_d x1_m25d 0.553403
XX1_M31 s1r_XX1_M31_d s1r_XX1_M31_g s1r_XX1_M31_s VDD sky130_fd_pr__pfet_01v8_lvt L=0.6 W=1.4 NF=1 AD=0.406 AS=0.406 PD=3.38 PS=3.38 NRD=0.207143 NRS=0.207143 SA=0 SB=0 SD=0 MULT=6 M=6
Rpar_s1_XX1_M31_s s1r_XX1_M31_s VDD 0.553403
Rpar_s1_XX1_M31_g s1r_XX1_M31_g bias_b 234.219
Rpar_s1_XX1_M31_d s1r_XX1_M31_d x1_m31d 0.641223
XX1_M1 s1r_XX1_M1_d s1r_XX1_M1_g s1r_XX1_M1_s VSS sky130_fd_pr__nfet_01v8_lvt L=0.6 W=1.4 NF=1 AD=0.406 AS=0.406 PD=3.38 PS=3.38 NRD=0.207143 NRS=0.207143 SA=0 SB=0 SD=0 MULT=56 M=56
Rpar_s1_XX1_M1_s s1r_XX1_M1_s bias_c 1.07356
Rpar_s1_XX1_M1_g s1r_XX1_M1_g bias_b 1.26112
Rpar_s1_XX1_M1_d s1r_XX1_M1_d bias_b 1.07356
XX1_M2 s1r_XX1_M2_d s1r_XX1_M2_g s1r_XX1_M2_s VSS sky130_fd_pr__nfet_01v8 L=0.6 W=1.4 NF=1 AD=0.406 AS=0.406 PD=3.38 PS=3.38 NRD=0.207143 NRS=0.207143 SA=0 SB=0 SD=0 MULT=50 M=50
Rpar_s1_XX1_M2_s s1r_XX1_M2_s bias_d 0.96449
Rpar_s1_XX1_M2_g s1r_XX1_M2_g x1_m2d 0.978178
Rpar_s1_XX1_M2_d s1r_XX1_M2_d x1_m2d 1.11759
XX1_M3 s1r_XX1_M3_d s1r_XX1_M3_g s1r_XX1_M3_s VSS sky130_fd_pr__nfet_01v8 L=0.6 W=1.4 NF=1 AD=0.406 AS=0.406 PD=3.38 PS=3.38 NRD=0.207143 NRS=0.207143 SA=0 SB=0 SD=0 MULT=2 M=2
Rpar_s1_XX1_M3_s s1r_XX1_M3_s bias_a 0.467406
Rpar_s1_XX1_M3_g s1r_XX1_M3_g x1_m2d 0.809609
Rpar_s1_XX1_M3_d s1r_XX1_M3_d bias_d 0.467406
XX1_M4 s1r_XX1_M4_d s1r_XX1_M4_g s1r_XX1_M4_s VSS sky130_fd_pr__nfet_01v8 L=0.6 W=1.4 NF=1 AD=0.406 AS=0.406 PD=3.38 PS=3.38 NRD=0.207143 NRS=0.207143 SA=0 SB=0 SD=0 MULT=18 M=18
Rpar_s1_XX1_M4_s s1r_XX1_M4_s x1_m5d 0.466195
Rpar_s1_XX1_M4_g s1r_XX1_M4_g bias_d 0.510263
Rpar_s1_XX1_M4_d s1r_XX1_M4_d bias_a 0.402347
XX1_M5 s1r_XX1_M5_d s1r_XX1_M5_g s1r_XX1_M5_s VSS sky130_fd_pr__nfet_01v8 L=0.6 W=1.4 NF=1 AD=0.406 AS=0.406 PD=3.38 PS=3.38 NRD=0.207143 NRS=0.207143 SA=0 SB=0 SD=0 MULT=18 M=18
Rpar_s1_XX1_M5_s s1r_XX1_M5_s VSS 0.402347
Rpar_s1_XX1_M5_g s1r_XX1_M5_g bias_a 264.007
Rpar_s1_XX1_M5_d s1r_XX1_M5_d x1_m5d 0.466195
XX1_M6 s1r_XX1_M6_d s1r_XX1_M6_g s1r_XX1_M6_s VSS sky130_fd_pr__nfet_01v8 L=0.6 W=1.4 NF=1 AD=0.406 AS=0.406 PD=3.38 PS=3.38 NRD=0.207143 NRS=0.207143 SA=0 SB=0 SD=0 MULT=18 M=18
Rpar_s1_XX1_M6_s s1r_XX1_M6_s VSS 0.402347
Rpar_s1_XX1_M6_g s1r_XX1_M6_g i_bias 264.084
Rpar_s1_XX1_M6_d s1r_XX1_M6_d bias_c 0.466195
XX1_M7 s1r_XX1_M7_d s1r_XX1_M7_g s1r_XX1_M7_s VSS sky130_fd_pr__nfet_01v8 L=0.6 W=1.4 NF=1 AD=0.406 AS=0.406 PD=3.38 PS=3.38 NRD=0.207143 NRS=0.207143 SA=0 SB=0 SD=0 MULT=18 M=18
Rpar_s1_XX1_M7_s s1r_XX1_M7_s VSS 0.402347
Rpar_s1_XX1_M7_g s1r_XX1_M7_g i_bias 264.084
Rpar_s1_XX1_M7_d s1r_XX1_M7_d i_bias 0.466195
XX1_M33 s1r_XX1_M33_d s1r_XX1_M33_g s1r_XX1_M33_s VSS sky130_fd_pr__nfet_01v8 L=0.6 W=1.4 NF=1 AD=0.406 AS=0.406 PD=3.38 PS=3.38 NRD=0.207143 NRS=0.207143 SA=0 SB=0 SD=0 MULT=1 M=1
Rpar_s1_XX1_M33_s s1r_XX1_M33_s x1_net1 171.892
Rpar_s1_XX1_M33_g s1r_XX1_M33_g cm 922.894
Rpar_s1_XX1_M33_d s1r_XX1_M33_d cm 512.47
XX1_M49 s1r_XX1_M49_d s1r_XX1_M49_g s1r_XX1_M49_s VSS sky130_fd_pr__nfet_01v8 L=0.6 W=1.4 NF=1 AD=0.406 AS=0.406 PD=3.38 PS=3.38 NRD=0.207143 NRS=0.207143 SA=0 SB=0 SD=0 MULT=1 M=1
Rpar_s1_XX1_M49_s s1r_XX1_M49_s x1_net2 167.971
Rpar_s1_XX1_M49_g s1r_XX1_M49_g cm 1.53964
Rpar_s1_XX1_M49_d s1r_XX1_M49_d x1_net1 171.892
XX1_M50 s1r_XX1_M50_d s1r_XX1_M50_g s1r_XX1_M50_s VSS sky130_fd_pr__nfet_01v8 L=0.6 W=1.4 NF=1 AD=0.406 AS=0.406 PD=3.38 PS=3.38 NRD=0.207143 NRS=0.207143 SA=0 SB=0 SD=0 MULT=1 M=1
Rpar_s1_XX1_M50_s s1r_XX1_M50_s x1_net3 168.374
Rpar_s1_XX1_M50_g s1r_XX1_M50_g cm 922.894
Rpar_s1_XX1_M50_d s1r_XX1_M50_d x1_net2 167.971
XX1_M63 s1r_XX1_M63_d s1r_XX1_M63_g s1r_XX1_M63_s VSS sky130_fd_pr__nfet_01v8 L=0.6 W=1.4 NF=1 AD=0.406 AS=0.406 PD=3.38 PS=3.38 NRD=0.207143 NRS=0.207143 SA=0 SB=0 SD=0 MULT=1 M=1
Rpar_s1_XX1_M63_s s1r_XX1_M63_s VSS 0.859161
Rpar_s1_XX1_M63_g s1r_XX1_M63_g cm 1.56413
Rpar_s1_XX1_M63_d s1r_XX1_M63_d x1_net3 0.867061
XX1_M68 s1r_XX1_M68_d s1r_XX1_M68_g s1r_XX1_M68_s VSS sky130_fd_pr__nfet_01v8 L=0.6 W=1.4 NF=1 AD=0.406 AS=0.406 PD=3.38 PS=3.38 NRD=0.207143 NRS=0.207143 SA=0 SB=0 SD=0 MULT=1 M=1
Rpar_s1_XX1_M68_s s1r_XX1_M68_s x1_net4 68.9365
Rpar_s1_XX1_M68_g s1r_XX1_M68_g cm 922.894
Rpar_s1_XX1_M68_d s1r_XX1_M68_d cm 512.47
XX1_M69 s1r_XX1_M69_d s1r_XX1_M69_g s1r_XX1_M69_s VSS sky130_fd_pr__nfet_01v8 L=0.6 W=1.4 NF=1 AD=0.406 AS=0.406 PD=3.38 PS=3.38 NRD=0.207143 NRS=0.207143 SA=0 SB=0 SD=0 MULT=1 M=1
Rpar_s1_XX1_M69_s s1r_XX1_M69_s x1_net5 167.971
Rpar_s1_XX1_M69_g s1r_XX1_M69_g cm 922.894
Rpar_s1_XX1_M69_d s1r_XX1_M69_d x1_net4 171.892
XX1_M70 s1r_XX1_M70_d s1r_XX1_M70_g s1r_XX1_M70_s VSS sky130_fd_pr__nfet_01v8 L=0.6 W=1.4 NF=1 AD=0.406 AS=0.406 PD=3.38 PS=3.38 NRD=0.207143 NRS=0.207143 SA=0 SB=0 SD=0 MULT=1 M=1
Rpar_s1_XX1_M70_s s1r_XX1_M70_s x1_net6 168.374
Rpar_s1_XX1_M70_g s1r_XX1_M70_g cm 922.894
Rpar_s1_XX1_M70_d s1r_XX1_M70_d x1_net5 167.971
XX1_M71 s1r_XX1_M71_d s1r_XX1_M71_g s1r_XX1_M71_s VSS sky130_fd_pr__nfet_01v8 L=0.6 W=1.4 NF=1 AD=0.406 AS=0.406 PD=3.38 PS=3.38 NRD=0.207143 NRS=0.207143 SA=0 SB=0 SD=0 MULT=1 M=1
Rpar_s1_XX1_M71_s s1r_XX1_M71_s VSS 0.859161
Rpar_s1_XX1_M71_g s1r_XX1_M71_g cm 1.56413
Rpar_s1_XX1_M71_d s1r_XX1_M71_d x1_net6 0.867061
XX1_M72 s1r_XX1_M72_d s1r_XX1_M72_g s1r_XX1_M72_s VSS sky130_fd_pr__nfet_01v8 L=0.6 W=1.4 NF=1 AD=0.406 AS=0.406 PD=3.38 PS=3.38 NRD=0.207143 NRS=0.207143 SA=0 SB=0 SD=0 MULT=1 M=1
Rpar_s1_XX1_M72_s s1r_XX1_M72_s x1_net7 171.892
Rpar_s1_XX1_M72_g s1r_XX1_M72_g cm 922.894
Rpar_s1_XX1_M72_d s1r_XX1_M72_d cm 512.47
XX1_M73 s1r_XX1_M73_d s1r_XX1_M73_g s1r_XX1_M73_s VSS sky130_fd_pr__nfet_01v8 L=0.6 W=1.4 NF=1 AD=0.406 AS=0.406 PD=3.38 PS=3.38 NRD=0.207143 NRS=0.207143 SA=0 SB=0 SD=0 MULT=1 M=1
Rpar_s1_XX1_M73_s s1r_XX1_M73_s x1_net8 167.971
Rpar_s1_XX1_M73_g s1r_XX1_M73_g cm 922.894
Rpar_s1_XX1_M73_d s1r_XX1_M73_d x1_net7 171.892
XX1_M74 s1r_XX1_M74_d s1r_XX1_M74_g s1r_XX1_M74_s VSS sky130_fd_pr__nfet_01v8 L=0.6 W=1.4 NF=1 AD=0.406 AS=0.406 PD=3.38 PS=3.38 NRD=0.207143 NRS=0.207143 SA=0 SB=0 SD=0 MULT=1 M=1
Rpar_s1_XX1_M74_s s1r_XX1_M74_s x1_net9 0.867061
Rpar_s1_XX1_M74_g s1r_XX1_M74_g cm 1.53959
Rpar_s1_XX1_M74_d s1r_XX1_M74_d x1_net8 167.971
XX1_M75 s1r_XX1_M75_d s1r_XX1_M75_g s1r_XX1_M75_s VSS sky130_fd_pr__nfet_01v8 L=0.6 W=1.4 NF=1 AD=0.406 AS=0.406 PD=3.38 PS=3.38 NRD=0.207143 NRS=0.207143 SA=0 SB=0 SD=0 MULT=1 M=1
Rpar_s1_XX1_M75_s s1r_XX1_M75_s VSS 0.859161
Rpar_s1_XX1_M75_g s1r_XX1_M75_g cm 922.894
Rpar_s1_XX1_M75_d s1r_XX1_M75_d x1_net9 168.374
XX1_M76 s1r_XX1_M76_d s1r_XX1_M76_g s1r_XX1_M76_s VSS sky130_fd_pr__nfet_01v8 L=0.6 W=1.4 NF=1 AD=0.406 AS=0.406 PD=3.38 PS=3.38 NRD=0.207143 NRS=0.207143 SA=0 SB=0 SD=0 MULT=1 M=1
Rpar_s1_XX1_M76_s s1r_XX1_M76_s x1_net10 171.892
Rpar_s1_XX1_M76_g s1r_XX1_M76_g cm 922.894
Rpar_s1_XX1_M76_d s1r_XX1_M76_d cm 512.47
XX1_M77 s1r_XX1_M77_d s1r_XX1_M77_g s1r_XX1_M77_s VSS sky130_fd_pr__nfet_01v8 L=0.6 W=1.4 NF=1 AD=0.406 AS=0.406 PD=3.38 PS=3.38 NRD=0.207143 NRS=0.207143 SA=0 SB=0 SD=0 MULT=1 M=1
Rpar_s1_XX1_M77_s s1r_XX1_M77_s x1_net11 167.971
Rpar_s1_XX1_M77_g s1r_XX1_M77_g cm 922.894
Rpar_s1_XX1_M77_d s1r_XX1_M77_d x1_net10 0.867074
XX1_M78 s1r_XX1_M78_d cm s1r_XX1_M78_s VSS sky130_fd_pr__nfet_01v8 L=0.6 W=1.4 NF=1 AD=0.406 AS=0.406 PD=3.38 PS=3.38 NRD=0.207143 NRS=0.207143 SA=0 SB=0 SD=0 MULT=1 M=1
Rpar_s1_XX1_M78_s s1r_XX1_M78_s x1_net12 168.374
Rpar_s1_XX1_M78_d s1r_XX1_M78_d x1_net11 167.971
XX1_M79 s1r_XX1_M79_d s1r_XX1_M79_g s1r_XX1_M79_s VSS sky130_fd_pr__nfet_01v8 L=0.6 W=1.4 NF=1 AD=0.406 AS=0.406 PD=3.38 PS=3.38 NRD=0.207143 NRS=0.207143 SA=0 SB=0 SD=0 MULT=1 M=1
Rpar_s1_XX1_M79_s s1r_XX1_M79_s VSS 0.859161
Rpar_s1_XX1_M79_g s1r_XX1_M79_g cm 1.56413
Rpar_s1_XX1_M79_d s1r_XX1_M79_d x1_net12 168.374
XX1_M64 s1r_XX1_M64_d s1r_XX1_M64_g s1r_XX1_M64_s VSS sky130_fd_pr__nfet_01v8 L=0.6 W=1.4 NF=1 AD=0.406 AS=0.406 PD=3.38 PS=3.38 NRD=0.207143 NRS=0.207143 SA=0 SB=0 SD=0 MULT=1 M=1
Rpar_s1_XX1_M64_s s1r_XX1_M64_s x1_net13 68.9365
Rpar_s1_XX1_M64_g s1r_XX1_M64_g cm 922.894
Rpar_s1_XX1_M64_d s1r_XX1_M64_d cm 512.47
XX1_M65 s1r_XX1_M65_d s1r_XX1_M65_g s1r_XX1_M65_s VSS sky130_fd_pr__nfet_01v8 L=0.6 W=1.4 NF=1 AD=0.406 AS=0.406 PD=3.38 PS=3.38 NRD=0.207143 NRS=0.207143 SA=0 SB=0 SD=0 MULT=1 M=1
Rpar_s1_XX1_M65_s s1r_XX1_M65_s x1_net14 167.971
Rpar_s1_XX1_M65_g s1r_XX1_M65_g cm 1.53963
Rpar_s1_XX1_M65_d s1r_XX1_M65_d x1_net13 171.892
XX1_M66 s1r_XX1_M66_d s1r_XX1_M66_g s1r_XX1_M66_s VSS sky130_fd_pr__nfet_01v8 L=0.6 W=1.4 NF=1 AD=0.406 AS=0.406 PD=3.38 PS=3.38 NRD=0.207143 NRS=0.207143 SA=0 SB=0 SD=0 MULT=1 M=1
Rpar_s1_XX1_M66_s s1r_XX1_M66_s x1_net15 168.374
Rpar_s1_XX1_M66_g s1r_XX1_M66_g cm 922.894
Rpar_s1_XX1_M66_d s1r_XX1_M66_d x1_net14 167.971
XX1_M67 s1r_XX1_M67_d s1r_XX1_M67_g s1r_XX1_M67_s VSS sky130_fd_pr__nfet_01v8 L=0.6 W=1.4 NF=1 AD=0.406 AS=0.406 PD=3.38 PS=3.38 NRD=0.207143 NRS=0.207143 SA=0 SB=0 SD=0 MULT=1 M=1
Rpar_s1_XX1_M67_s s1r_XX1_M67_s VSS 0.859161
Rpar_s1_XX1_M67_g s1r_XX1_M67_g cm 1.56413
Rpar_s1_XX1_M67_d s1r_XX1_M67_d x1_net15 0.867061
XX1_M57 bias_b VDD VDD VDD sky130_fd_pr__pfet_01v8 L=0.6 W=1.4 NF=1 AD=0.406 AS=0.406 PD=3.38 PS=3.38 NRD=0.207143 NRS=0.207143 SA=0 SB=0 SD=0 MULT=2 M=2
XX1_M58 x1_m2d VDD VDD VDD sky130_fd_pr__pfet_01v8 L=0.6 W=1.4 NF=1 AD=0.406 AS=0.406 PD=3.38 PS=3.38 NRD=0.207143 NRS=0.207143 SA=0 SB=0 SD=0 MULT=2 M=2
XX1_M59 cm VDD VDD VDD sky130_fd_pr__pfet_01v8 L=0.6 W=1.4 NF=1 AD=0.406 AS=0.406 PD=3.38 PS=3.38 NRD=0.207143 NRS=0.207143 SA=0 SB=0 SD=0 MULT=2 M=2
XX1_M60 x1_m31d VDD VDD VDD sky130_fd_pr__pfet_01v8 L=0.6 W=1.4 NF=1 AD=0.406 AS=0.406 PD=3.38 PS=3.38 NRD=0.207143 NRS=0.207143 SA=0 SB=0 SD=0 MULT=2 M=2
XX1_M42 x1_m5d VSS VSS VSS sky130_fd_pr__nfet_01v8 L=0.6 W=1.4 NF=1 AD=0.406 AS=0.406 PD=3.38 PS=3.38 NRD=0.207143 NRS=0.207143 SA=0 SB=0 SD=0 MULT=6 M=6
XX1_M44 bias_c bias_c bias_c VSS sky130_fd_pr__nfet_01v8 L=0.6 W=1.4 NF=1 AD=0.406 AS=0.406 PD=3.38 PS=3.38 NRD=0.207143 NRS=0.207143 SA=0 SB=0 SD=0 MULT=2 M=2
XX1_M34 bias_d bias_d bias_d VSS sky130_fd_pr__nfet_01v8 L=0.6 W=1.4 NF=1 AD=0.406 AS=0.406 PD=3.38 PS=3.38 NRD=0.207143 NRS=0.207143 SA=0 SB=0 SD=0 MULT=8 M=8
XX1_M35 x1_m2d x1_m2d x1_m2d VSS sky130_fd_pr__nfet_01v8 L=0.6 W=1.4 NF=1 AD=0.406 AS=0.406 PD=3.38 PS=3.38 NRD=0.207143 NRS=0.207143 SA=0 SB=0 SD=0 MULT=2 M=2
XX1_M36 bias_a bias_a bias_a VSS sky130_fd_pr__nfet_01v8 L=0.6 W=1.4 NF=1 AD=0.406 AS=0.406 PD=3.38 PS=3.38 NRD=0.207143 NRS=0.207143 SA=0 SB=0 SD=0 MULT=4 M=4
XX1_M37 cm cm cm VSS sky130_fd_pr__nfet_01v8 L=0.6 W=1.4 NF=1 AD=0.406 AS=0.406 PD=3.38 PS=3.38 NRD=0.207143 NRS=0.207143 SA=0 SB=0 SD=0 MULT=8 M=8
XX1_M54 x1_m25d x1_m25d x1_m25d VDD sky130_fd_pr__pfet_01v8 L=0.6 W=1.4 NF=1 AD=0.406 AS=0.406 PD=3.38 PS=3.38 NRD=0.207143 NRS=0.207143 SA=0 SB=0 SD=0 MULT=2 M=2
XX1_M29 x1_m5d x1_m5d x1_m5d VSS sky130_fd_pr__nfet_01v8 L=0.6 W=1.4 NF=1 AD=0.406 AS=0.406 PD=3.38 PS=3.38 NRD=0.207143 NRS=0.207143 SA=0 SB=0 SD=0 MULT=6 M=6
XX1_M8 i_bias i_bias i_bias VSS sky130_fd_pr__nfet_01v8 L=0.6 W=1.4 NF=1 AD=0.406 AS=0.406 PD=3.38 PS=3.38 NRD=0.207143 NRS=0.207143 SA=0 SB=0 SD=0 MULT=2 M=2
XX1_M10 bias_c bias_c bias_c VSS sky130_fd_pr__nfet_01v8_lvt L=0.6 W=1.4 NF=1 AD=0.406 AS=0.406 PD=3.38 PS=3.38 NRD=0.207143 NRS=0.207143 SA=0 SB=0 SD=0 MULT=8 M=8
XX1_M27 bias_b bias_b bias_b VSS sky130_fd_pr__nfet_01v8_lvt L=0.6 W=1.4 NF=1 AD=0.406 AS=0.406 PD=3.38 PS=3.38 NRD=0.207143 NRS=0.207143 SA=0 SB=0 SD=0 MULT=8 M=8
XX1_M46 x1_m21d x1_m21d x1_m21d VDD sky130_fd_pr__pfet_01v8_lvt L=0.6 W=1.4 NF=1 AD=0.406 AS=0.406 PD=3.38 PS=3.38 NRD=0.207143 NRS=0.207143 SA=0 SB=0 SD=0 MULT=2 M=2
XX1_M47 x1_m25d x1_m25d x1_m25d VDD sky130_fd_pr__pfet_01v8_lvt L=0.6 W=1.4 NF=1 AD=0.406 AS=0.406 PD=3.38 PS=3.38 NRD=0.207143 NRS=0.207143 SA=0 SB=0 SD=0 MULT=2 M=2
XX1_M48 x1_m31d x1_m31d x1_m31d VDD sky130_fd_pr__pfet_01v8_lvt L=0.6 W=1.4 NF=1 AD=0.406 AS=0.406 PD=3.38 PS=3.38 NRD=0.207143 NRS=0.207143 SA=0 SB=0 SD=0 MULT=2 M=2
XX1_M51 x1_m21d x1_m21d x1_m21d VDD sky130_fd_pr__pfet_01v8 L=0.6 W=1.4 NF=1 AD=0.406 AS=0.406 PD=3.38 PS=3.38 NRD=0.207143 NRS=0.207143 SA=0 SB=0 SD=0 MULT=2 M=2
XX2_M1 s1r_XX2_M1_d s1r_XX2_M1_g s1r_XX2_M1_s VSS sky130_fd_pr__nfet_01v8_lvt L=0.2 W=1.2 NF=1 AD=0.348 AS=0.348 PD=2.98 PS=2.98 NRD=0.241667 NRS=0.241667 SA=0 SB=0 SD=0 MULT=6 M=6
Rpar_s1_XX2_M1_s s1r_XX2_M1_s x2_tail 0.456322
Rpar_s1_XX2_M1_g s1r_XX2_M1_g ip 0.413845
Rpar_s1_XX2_M1_d s1r_XX2_M1_d x2_foldp 0.456322
XX2_M2 s1r_XX2_M2_d s1r_XX2_M2_g s1r_XX2_M2_s VSS sky130_fd_pr__nfet_01v8_lvt L=0.2 W=1.2 NF=1 AD=0.348 AS=0.348 PD=2.98 PS=2.98 NRD=0.241667 NRS=0.241667 SA=0 SB=0 SD=0 MULT=6 M=6
Rpar_s1_XX2_M2_s s1r_XX2_M2_s x2_tail 0.456322
Rpar_s1_XX2_M2_g s1r_XX2_M2_g in 0.413845
Rpar_s1_XX2_M2_d s1r_XX2_M2_d x2_foldn 0.456322
XX2_M6 s1r_XX2_M6_d s1r_XX2_M6_g s1r_XX2_M6_s VSS sky130_fd_pr__nfet_01v8 L=0.6 W=1.4 NF=1 AD=0.406 AS=0.406 PD=3.38 PS=3.38 NRD=0.207143 NRS=0.207143 SA=0 SB=0 SD=0 MULT=96 M=96
Rpar_s1_XX2_M6_s s1r_XX2_M6_s VSS 1.80626
Rpar_s1_XX2_M6_g s1r_XX2_M6_g cmc 1087.47
Rpar_s1_XX2_M6_d s1r_XX2_M6_d x2_tail 2.0929
XX2_M5 s1r_XX2_M5_d s1r_XX2_M5_g s1r_XX2_M5_s VSS sky130_fd_pr__nfet_01v8 L=0.6 W=1.4 NF=1 AD=0.406 AS=0.406 PD=3.38 PS=3.38 NRD=0.207143 NRS=0.207143 SA=0 SB=0 SD=0 MULT=96 M=96
Rpar_s1_XX2_M5_s s1r_XX2_M5_s VSS 2.0929
Rpar_s1_XX2_M5_g s1r_XX2_M5_g bias_a 2.10117
Rpar_s1_XX2_M5_d s1r_XX2_M5_d x2_tail 1.80626
XX2_M11 s1r_XX2_M11_d s1r_XX2_M11_g s1r_XX2_M11_s VDD sky130_fd_pr__pfet_01v8_lvt L=0.6 W=1.4 NF=1 AD=0.406 AS=0.406 PD=3.38 PS=3.38 NRD=0.207143 NRS=0.207143 SA=0 SB=0 SD=0 MULT=24 M=24
Rpar_s1_XX2_M11_s s1r_XX2_M11_s VDD 0.588767
Rpar_s1_XX2_M11_g s1r_XX2_M11_g bias_b 0.548058
Rpar_s1_XX2_M11_d s1r_XX2_M11_d x2_foldp 0.682199
XX2_M12 s1r_XX2_M12_d s1r_XX2_M12_g s1r_XX2_M12_s VDD sky130_fd_pr__pfet_01v8_lvt L=0.6 W=1.4 NF=1 AD=0.406 AS=0.406 PD=3.38 PS=3.38 NRD=0.207143 NRS=0.207143 SA=0 SB=0 SD=0 MULT=24 M=24
Rpar_s1_XX2_M12_s s1r_XX2_M12_s VDD 0.588767
Rpar_s1_XX2_M12_g s1r_XX2_M12_g bias_b 0.548058
Rpar_s1_XX2_M12_d s1r_XX2_M12_d x2_foldn 0.682199
XX2_M1A s1r_XX2_M1A_d s1r_XX2_M1A_g s1r_XX2_M1A_s VDD sky130_fd_pr__pfet_01v8 L=0.6 W=1.4 NF=1 AD=0.406 AS=0.406 PD=3.38 PS=3.38 NRD=0.207143 NRS=0.207143 SA=0 SB=0 SD=0 MULT=20 M=20
Rpar_s1_XX2_M1A_s s1r_XX2_M1A_s x2_foldp 0.760522
Rpar_s1_XX2_M1A_g s1r_XX2_M1A_g bias_c 0.483979
Rpar_s1_XX2_M1A_d s1r_XX2_M1A_d on 0.656364
XX2_M8 s1r_XX2_M8_d s1r_XX2_M8_g s1r_XX2_M8_s VDD sky130_fd_pr__pfet_01v8 L=0.6 W=1.4 NF=1 AD=0.406 AS=0.406 PD=3.38 PS=3.38 NRD=0.207143 NRS=0.207143 SA=0 SB=0 SD=0 MULT=20 M=20
Rpar_s1_XX2_M8_s s1r_XX2_M8_s x2_foldn 0.760522
Rpar_s1_XX2_M8_g s1r_XX2_M8_g bias_c 0.483979
Rpar_s1_XX2_M8_d s1r_XX2_M8_d op 0.656364
XX2_M3A s1r_XX2_M3A_d s1r_XX2_M3A_g s1r_XX2_M3A_s VSS sky130_fd_pr__nfet_01v8 L=0.6 W=1.4 NF=1 AD=0.406 AS=0.406 PD=3.38 PS=3.38 NRD=0.207143 NRS=0.207143 SA=0 SB=0 SD=0 MULT=36 M=36
Rpar_s1_XX2_M3A_s s1r_XX2_M3A_s x2_m3d 0.712243
Rpar_s1_XX2_M3A_g s1r_XX2_M3A_g bias_d 0.731254
Rpar_s1_XX2_M3A_d s1r_XX2_M3A_d on 0.825269
XX2_M7 s1r_XX2_M7_d s1r_XX2_M7_g s1r_XX2_M7_s VSS sky130_fd_pr__nfet_01v8 L=0.6 W=1.4 NF=1 AD=0.406 AS=0.406 PD=3.38 PS=3.38 NRD=0.207143 NRS=0.207143 SA=0 SB=0 SD=0 MULT=36 M=36
Rpar_s1_XX2_M7_s s1r_XX2_M7_s x2_m4d 0.712243
Rpar_s1_XX2_M7_g s1r_XX2_M7_g bias_d 0.731254
Rpar_s1_XX2_M7_d s1r_XX2_M7_d op 0.825269
XX2_M3 s1r_XX2_M3_d s1r_XX2_M3_g s1r_XX2_M3_s VSS sky130_fd_pr__nfet_01v8 L=0.6 W=1.4 NF=1 AD=0.406 AS=0.406 PD=3.38 PS=3.38 NRD=0.207143 NRS=0.207143 SA=0 SB=0 SD=0 MULT=36 M=36
Rpar_s1_XX2_M3_s s1r_XX2_M3_s VSS 0.712243
Rpar_s1_XX2_M3_g s1r_XX2_M3_g bias_a 0.847296
Rpar_s1_XX2_M3_d s1r_XX2_M3_d x2_m3d 0.712243
XX2_M4 s1r_XX2_M4_d s1r_XX2_M4_g s1r_XX2_M4_s VSS sky130_fd_pr__nfet_01v8 L=0.6 W=1.4 NF=1 AD=0.406 AS=0.406 PD=3.38 PS=3.38 NRD=0.207143 NRS=0.207143 SA=0 SB=0 SD=0 MULT=36 M=36
Rpar_s1_XX2_M4_s s1r_XX2_M4_s VSS 0.712243
Rpar_s1_XX2_M4_g s1r_XX2_M4_g bias_a 0.847296
Rpar_s1_XX2_M4_d s1r_XX2_M4_d x2_m4d 0.712243
XX2_M82 x2_foldn x2_foldn x2_foldn VDD sky130_fd_pr__pfet_01v8 L=0.6 W=1.4 NF=1 AD=0.406 AS=0.406 PD=3.38 PS=3.38 NRD=0.207143 NRS=0.207143 SA=0 SB=0 SD=0 MULT=2 M=2
XX2_M83 x2_foldp x2_foldp x2_foldp VDD sky130_fd_pr__pfet_01v8 L=0.6 W=1.4 NF=1 AD=0.406 AS=0.406 PD=3.38 PS=3.38 NRD=0.207143 NRS=0.207143 SA=0 SB=0 SD=0 MULT=2 M=2
XX2_M55 x2_foldn VDD VDD VDD sky130_fd_pr__pfet_01v8 L=0.6 W=1.4 NF=1 AD=0.406 AS=0.406 PD=3.38 PS=3.38 NRD=0.207143 NRS=0.207143 SA=0 SB=0 SD=0 MULT=2 M=2
XX2_M56 op VDD VDD VDD sky130_fd_pr__pfet_01v8 L=0.6 W=1.4 NF=1 AD=0.406 AS=0.406 PD=3.38 PS=3.38 NRD=0.207143 NRS=0.207143 SA=0 SB=0 SD=0 MULT=4 M=4
XX2_M61 x2_foldp VDD VDD VDD sky130_fd_pr__pfet_01v8 L=0.6 W=1.4 NF=1 AD=0.406 AS=0.406 PD=3.38 PS=3.38 NRD=0.207143 NRS=0.207143 SA=0 SB=0 SD=0 MULT=2 M=2
XX2_M62 on VDD VDD VDD sky130_fd_pr__pfet_01v8 L=0.6 W=1.4 NF=1 AD=0.406 AS=0.406 PD=3.38 PS=3.38 NRD=0.207143 NRS=0.207143 SA=0 SB=0 SD=0 MULT=4 M=4
XX2_M40 x2_m4d VSS VSS VSS sky130_fd_pr__nfet_01v8 L=0.6 W=1.4 NF=1 AD=0.406 AS=0.406 PD=3.38 PS=3.38 NRD=0.207143 NRS=0.207143 SA=0 SB=0 SD=0 MULT=6 M=6
XX2_M41 x2_m3d VSS VSS VSS sky130_fd_pr__nfet_01v8 L=0.6 W=1.4 NF=1 AD=0.406 AS=0.406 PD=3.38 PS=3.38 NRD=0.207143 NRS=0.207143 SA=0 SB=0 SD=0 MULT=8 M=8
XX2_M38 op op op VSS sky130_fd_pr__nfet_01v8 L=0.6 W=1.4 NF=1 AD=0.406 AS=0.406 PD=3.38 PS=3.38 NRD=0.207143 NRS=0.207143 SA=0 SB=0 SD=0 MULT=2 M=2
XX2_M39 on on on VSS sky130_fd_pr__nfet_01v8 L=0.6 W=1.4 NF=1 AD=0.406 AS=0.406 PD=3.38 PS=3.38 NRD=0.207143 NRS=0.207143 SA=0 SB=0 SD=0 MULT=2 M=2
XX2_M30 x2_tail VSS VSS VSS sky130_fd_pr__nfet_01v8 L=0.6 W=1.4 NF=1 AD=0.406 AS=0.406 PD=3.38 PS=3.38 NRD=0.207143 NRS=0.207143 SA=0 SB=0 SD=0 MULT=2 M=2
XX2_M23 x2_foldp x2_foldp x2_foldp VSS sky130_fd_pr__nfet_01v8_lvt L=0.2 W=1.2 NF=1 AD=0.348 AS=0.348 PD=2.98 PS=2.98 NRD=0.241667 NRS=0.241667 SA=0 SB=0 SD=0 MULT=2 M=2
XX2_M24 x2_foldn x2_foldn x2_foldn VSS sky130_fd_pr__nfet_01v8_lvt L=0.2 W=1.2 NF=1 AD=0.348 AS=0.348 PD=2.98 PS=2.98 NRD=0.241667 NRS=0.241667 SA=0 SB=0 SD=0 MULT=2 M=2
XX2_M80 op VSS VSS VSS sky130_fd_pr__nfet_01v8 L=0.6 W=1.4 NF=1 AD=0.406 AS=0.406 PD=3.38 PS=3.38 NRD=0.207143 NRS=0.207143 SA=0 SB=0 SD=0 MULT=2 M=2
XX2_M81 on VSS VSS VSS sky130_fd_pr__nfet_01v8 L=0.6 W=1.4 NF=1 AD=0.406 AS=0.406 PD=3.38 PS=3.38 NRD=0.207143 NRS=0.207143 SA=0 SB=0 SD=0 MULT=2 M=2
XX2_M28 x2_tail x2_tail x2_tail VSS sky130_fd_pr__nfet_01v8 L=0.6 W=1.4 NF=1 AD=0.406 AS=0.406 PD=3.38 PS=3.38 NRD=0.207143 NRS=0.207143 SA=0 SB=0 SD=0 MULT=6 M=6
XM43 VDD VDD VDD VDD sky130_fd_pr__pfet_01v8_lvt L=0.6 W=1.4 NF=1 AD=0.406 AS=0.406 PD=3.38 PS=3.38 NRD=0.207143 NRS=0.207143 SA=0 SB=0 SD=0 MULT=8 M=8
XM45 VDD VDD VDD VDD sky130_fd_pr__pfet_01v8 L=0.6 W=1.4 NF=1 AD=0.406 AS=0.406 PD=3.38 PS=3.38 NRD=0.207143 NRS=0.207143 SA=0 SB=0 SD=0 MULT=6 M=6
XM9 VSS VSS VSS VSS sky130_fd_pr__nfet_01v8 L=0.6 W=1.4 NF=1 AD=0.406 AS=0.406 PD=3.38 PS=3.38 NRD=0.207143 NRS=0.207143 SA=0 SB=0 SD=0 MULT=23 M=23
Ibias_ext VDD i_bias 3e-05
XC3 op cmc sky130_fd_pr__cap_mim_m3_1 W=4.8 L=4.8 MF=4 M=4
XC4 on cmc sky130_fd_pr__cap_mim_m3_1 W=4.8 L=4.8 MF=4 M=4
.ends iadc_ota
.end
