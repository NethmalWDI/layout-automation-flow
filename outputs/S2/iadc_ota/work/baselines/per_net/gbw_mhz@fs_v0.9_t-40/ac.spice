* iadc_ota on dido_amp_AC
.lib $PDK_ROOT/sky130A/libs.tech/combined/sky130.lib.spice fs
.param VDD_V=1.62 VCM_V=0.9 CL_F=0.3p
.temp -40

**.subckt dido_amp_AC
x1 INP INN OUTN VDD 0 OUTP dut_amp
Vsup VDD 0 'VDD_V'
* AC drive through 1 F couplers; DC set by unity feedback through 1 GH chokes (OUTP->INN, OUTN->INP)
Vacp ACP 0 dc 0 ac 0.5
Vacn ACN 0 dc 0 ac -0.5
Cinp ACP INP 1
Cinn ACN INN 1
Lfbp OUTP INN 1G
Lfbn OUTN INP 1G
Cloadp OUTP 0 'CL_F'
Cloadn OUTN 0 'CL_F'
.control
  save all
  ac dec 40 1 1G
  let hsig = v(OUTP) - v(OUTN)
  let hdb = db(hsig)
  let gph_deg = 180/pi * cph(hsig)
  meas ac gain_db find hdb at=1
  meas ac gbw_hz  when hdb=0
  meas ac ph_dc   find gph_deg at=1
  meas ac ph_ugb  find gph_deg when hdb=0
  let gbw_mhz = gbw_hz / 1e6
  let pm_deg  = 180 + (ph_ugb - ph_dc)
  echo MEAS gain_db $&gain_db
  echo MEAS gbw_mhz $&gbw_mhz
  echo MEAS pm_deg $&pm_deg
  write
  quit 0
.endc
**.ends

.subckt dut_amp INP INN OUTN VDD VSS OUTP
XDUT INP INN OUTP OUTN VDD VSS cmc_w cm_w bias_a_w iadc_ota
* ideal CMFB: the steady-state law of the upstream switched-capacitor CMFB (ASSUMPTION)
Bcmfb cmc_w VSS V = v(bias_a_w) + (v(OUTP) + v(OUTN))/2 - v(cm_w)
.ends

.subckt iadc_ota ip in op on VDD VSS cmc cm bias_a
Cbud_s2_0 bias_b VSS 915.806f
Cbud_s2_1 bias_c VSS 617.528f
Cbud_s2_2 bias_d VSS 661.851f
Cbud_s2_3 on VSS 3.90644f
Cbud_s2_4 op VSS 3.90537f
Cbud_s2_5 x1_m21d VSS 87.9203f
Cbud_s2_6 x1_m25d VSS 87.9203f
Cbud_s2_7 x1_m2d VSS 433.346f
Cbud_s2_8 x1_m5d VSS 188.512f
Cbud_s2_9 x2_foldn VSS 1.77425f
Cbud_s2_10 x2_foldp VSS 1.77424f
Cbud_s2_11 x2_m3d VSS 231.663f
Cbud_s2_12 x2_m4d VSS 224.392f
Cbud_s2_13 x2_tail VSS 741.326f
Cbud_s2_14 bias_a bias_d 42.6198f
Cbud_s2_15 bias_a on 3.91675f
Cbud_s2_16 bias_a op 3.8951f
Cbud_s2_17 bias_a x1_m25d 6.38002f
Cbud_s2_18 bias_a x1_m2d 23.4901f
Cbud_s2_19 bias_a x1_m5d 33.2946f
Cbud_s2_20 bias_a x2_foldn 1.77796f
Cbud_s2_21 bias_a x2_foldp 1.77049f
Cbud_s2_22 bias_a x2_m3d 35.4836f
Cbud_s2_23 bias_a x2_m4d 35.1325f
Cbud_s2_24 bias_a ip 1.17686f
Cbud_s2_25 bias_b bias_d 31.0356f
Cbud_s2_26 bias_b cm 17.1763f
Cbud_s2_27 bias_b i_bias 11.952f
Cbud_s2_28 bias_b on 3.90599f
Cbud_s2_29 bias_b op 3.90578f
Cbud_s2_30 bias_b x1_m21d 13.4942f
Cbud_s2_31 bias_b x1_m25d 9.83482f
Cbud_s2_32 bias_b x1_m2d 22.3385f
Cbud_s2_33 bias_b x1_m31d 8.60366f
Cbud_s2_34 bias_b x1_m5d 11.952f
Cbud_s2_35 bias_b x1_net1 0.823592f
Cbud_s2_36 bias_b x1_net10 0.823592f
Cbud_s2_37 bias_b x1_net11 0.823592f
Cbud_s2_38 bias_b x1_net12 0.823592f
Cbud_s2_39 bias_b x1_net13 0.823592f
Cbud_s2_40 bias_b x1_net14 0.823592f
Cbud_s2_41 bias_b x1_net15 0.823592f
Cbud_s2_42 bias_b x1_net2 0.823592f
Cbud_s2_43 bias_b x1_net3 0.823592f
Cbud_s2_44 bias_b x1_net4 0.823592f
Cbud_s2_45 bias_b x1_net5 0.823592f
Cbud_s2_46 bias_b x1_net6 0.823592f
Cbud_s2_47 bias_b x1_net7 0.823592f
Cbud_s2_48 bias_b x1_net8 0.823592f
Cbud_s2_49 bias_b x1_net9 0.823592f
Cbud_s2_50 bias_b x2_foldn 1.77469f
Cbud_s2_51 bias_b x2_foldp 1.77368f
Cbud_s2_52 bias_b x2_m3d 14.7548f
Cbud_s2_53 bias_b x2_m4d 14.4037f
Cbud_s2_54 bias_b x2_tail 40.2841f
Cbud_s2_55 bias_b ip 1.17686f
Cbud_s2_56 bias_c bias_d 31.0356f
Cbud_s2_57 bias_c cm 20.6311f
Cbud_s2_58 bias_c i_bias 22.3164f
Cbud_s2_59 bias_c on 3.90597f
Cbud_s2_60 bias_c op 3.90579f
Cbud_s2_61 bias_c x1_m21d 9.83482f
Cbud_s2_62 bias_c x1_m25d 9.83482f
Cbud_s2_63 bias_c x1_m2d 25.7933f
Cbud_s2_64 bias_c x1_m31d 8.60366f
Cbud_s2_65 bias_c x1_m5d 11.952f
Cbud_s2_66 bias_c x1_net1 0.823592f
Cbud_s2_67 bias_c x1_net10 0.823592f
Cbud_s2_68 bias_c x1_net11 0.823592f
Cbud_s2_69 bias_c x1_net12 0.823592f
Cbud_s2_70 bias_c x1_net13 0.823592f
Cbud_s2_71 bias_c x1_net14 0.823592f
Cbud_s2_72 bias_c x1_net15 0.823592f
Cbud_s2_73 bias_c x1_net2 0.823592f
Cbud_s2_74 bias_c x1_net3 0.823592f
Cbud_s2_75 bias_c x1_net4 0.823592f
Cbud_s2_76 bias_c x1_net5 0.823592f
Cbud_s2_77 bias_c x1_net6 0.823592f
Cbud_s2_78 bias_c x1_net7 0.823592f
Cbud_s2_79 bias_c x1_net8 0.823592f
Cbud_s2_80 bias_c x1_net9 0.823592f
Cbud_s2_81 bias_c x2_foldn 1.77488f
Cbud_s2_82 bias_c x2_foldp 1.77356f
Cbud_s2_83 bias_c x2_m3d 14.7548f
Cbud_s2_84 bias_c x2_m4d 14.4037f
Cbud_s2_85 bias_c x2_tail 31.96f
Cbud_s2_86 bias_c ip 1.17686f
Cbud_s2_87 bias_d cm 17.1763f
Cbud_s2_88 bias_d i_bias 11.952f
Cbud_s2_89 bias_d on 3.88452f
Cbud_s2_90 bias_d op 3.92737f
Cbud_s2_91 bias_d x1_m21d 6.38002f
Cbud_s2_92 bias_d x1_m25d 6.38002f
Cbud_s2_93 bias_d x1_m2d 82.7751f
Cbud_s2_94 bias_d x1_m31d 5.14886f
Cbud_s2_95 bias_d x1_m5d 22.3164f
Cbud_s2_96 bias_d x1_net1 0.823592f
Cbud_s2_97 bias_d x1_net10 0.823592f
Cbud_s2_98 bias_d x1_net11 0.823592f
Cbud_s2_99 bias_d x1_net12 0.823592f
Cbud_s2_100 bias_d x1_net13 0.823592f
Cbud_s2_101 bias_d x1_net14 0.823592f
Cbud_s2_102 bias_d x1_net15 0.823592f
Cbud_s2_103 bias_d x1_net2 0.823592f
Cbud_s2_104 bias_d x1_net3 0.823592f
Cbud_s2_105 bias_d x1_net4 0.823592f
Cbud_s2_106 bias_d x1_net5 0.823592f
Cbud_s2_107 bias_d x1_net6 0.823592f
Cbud_s2_108 bias_d x1_net7 0.823592f
Cbud_s2_109 bias_d x1_net8 0.823592f
Cbud_s2_110 bias_d x1_net9 0.823592f
Cbud_s2_111 bias_d x2_foldn 1.77836f
Cbud_s2_112 bias_d x2_foldp 1.77006f
Cbud_s2_113 bias_d x2_m3d 35.4836f
Cbud_s2_114 bias_d x2_m4d 35.1325f
Cbud_s2_115 bias_d x2_tail 31.0356f
Cbud_s2_116 bias_d in 1.17686f
Cbud_s2_117 cm on 3.90642f
Cbud_s2_118 cm op 3.90535f
Cbud_s2_119 cm x1_m21d 6.38002f
Cbud_s2_120 cm x1_m25d 6.38002f
Cbud_s2_121 cm x1_m2d 17.1763f
Cbud_s2_122 cm x1_m5d 11.952f
Cbud_s2_123 cm x2_foldn 1.77418f
Cbud_s2_124 cm x2_foldp 1.77417f
Cbud_s2_125 cm x2_m3d 14.7548f
Cbud_s2_126 cm x2_m4d 14.4037f
Cbud_s2_127 cm x2_tail 17.1763f
Cbud_s2_128 cm ip 1.17686f
Cbud_s2_129 i_bias on 3.90711f
Cbud_s2_130 i_bias op 3.9047f
Cbud_s2_131 i_bias x1_m21d 6.38002f
Cbud_s2_132 i_bias x1_m25d 6.38002f
Cbud_s2_133 i_bias x1_m2d 11.952f
Cbud_s2_134 i_bias x1_m31d 5.14886f
Cbud_s2_135 i_bias x1_m5d 11.952f
Cbud_s2_136 i_bias x2_foldn 1.77387f
Cbud_s2_137 i_bias x2_foldp 1.77465f
Cbud_s2_138 i_bias x2_m3d 11.952f
Cbud_s2_139 i_bias x2_m4d 11.952f
Cbud_s2_140 i_bias in 1.17686f
Cbud_s2_141 on op 0.976467f
Cbud_s2_142 on x1_m21d 3.90617f
Cbud_s2_143 on x1_m25d 3.90183f
Cbud_s2_144 on x1_m2d 3.89884f
Cbud_s2_145 on x1_m31d 3.90655f
Cbud_s2_146 on x1_m5d 3.90813f
Cbud_s2_147 on x1_net1 0.823592f
Cbud_s2_148 on x1_net10 0.823592f
Cbud_s2_149 on x1_net11 0.823592f
Cbud_s2_150 on x1_net12 0.823592f
Cbud_s2_151 on x1_net13 0.823592f
Cbud_s2_152 on x1_net14 0.823592f
Cbud_s2_153 on x1_net15 0.823592f
Cbud_s2_154 on x1_net2 0.823592f
Cbud_s2_155 on x1_net3 0.823592f
Cbud_s2_156 on x1_net4 0.823592f
Cbud_s2_157 on x1_net5 0.823592f
Cbud_s2_158 on x1_net6 0.823592f
Cbud_s2_159 on x1_net7 0.823592f
Cbud_s2_160 on x1_net8 0.823592f
Cbud_s2_161 on x1_net9 0.823592f
Cbud_s2_162 on x2_foldn 0.663011f
Cbud_s2_163 on x2_foldp 4.33668f
Cbud_s2_164 on x2_m3d 7.09536f
Cbud_s2_165 on x2_m4d 2.16497f
Cbud_s2_166 on x2_tail 3.90643f
Cbud_s2_167 on ip 1.17686f
Cbud_s2_168 on in 1.17686f
Cbud_s2_169 op x1_m21d 3.90568f
Cbud_s2_170 op x1_m25d 3.90999f
Cbud_s2_171 op x1_m2d 3.91291f
Cbud_s2_172 op x1_m31d 3.90533f
Cbud_s2_173 op x1_m5d 3.90375f
Cbud_s2_174 op x1_net1 0.823592f
Cbud_s2_175 op x1_net10 0.823592f
Cbud_s2_176 op x1_net11 0.823592f
Cbud_s2_177 op x1_net12 0.823592f
Cbud_s2_178 op x1_net13 0.823592f
Cbud_s2_179 op x1_net14 0.823592f
Cbud_s2_180 op x1_net15 0.823592f
Cbud_s2_181 op x1_net2 0.823592f
Cbud_s2_182 op x1_net3 0.823592f
Cbud_s2_183 op x1_net4 0.823592f
Cbud_s2_184 op x1_net5 0.823592f
Cbud_s2_185 op x1_net6 0.823592f
Cbud_s2_186 op x1_net7 0.823592f
Cbud_s2_187 op x1_net8 0.823592f
Cbud_s2_188 op x1_net9 0.823592f
Cbud_s2_189 op x2_foldn 4.33584f
Cbud_s2_190 op x2_foldp 0.663019f
Cbud_s2_191 op x2_m3d 2.17126f
Cbud_s2_192 op x2_m4d 7.00631f
Cbud_s2_193 op x2_tail 3.90538f
Cbud_s2_194 op ip 1.17686f
Cbud_s2_195 op in 1.17686f
Cbud_s2_196 x1_m21d x1_m25d 6.38002f
Cbud_s2_197 x1_m21d x1_m2d 6.38002f
Cbud_s2_198 x1_m21d x1_m5d 6.38002f
Cbud_s2_199 x1_m21d x1_net1 0.823592f
Cbud_s2_200 x1_m21d x1_net10 0.823592f
Cbud_s2_201 x1_m21d x1_net11 0.823592f
Cbud_s2_202 x1_m21d x1_net12 0.823592f
Cbud_s2_203 x1_m21d x1_net13 0.823592f
Cbud_s2_204 x1_m21d x1_net14 0.823592f
Cbud_s2_205 x1_m21d x1_net15 0.823592f
Cbud_s2_206 x1_m21d x1_net2 0.823592f
Cbud_s2_207 x1_m21d x1_net3 0.823592f
Cbud_s2_208 x1_m21d x1_net4 0.823592f
Cbud_s2_209 x1_m21d x1_net5 0.823592f
Cbud_s2_210 x1_m21d x1_net6 0.823592f
Cbud_s2_211 x1_m21d x1_net7 0.823592f
Cbud_s2_212 x1_m21d x1_net8 0.823592f
Cbud_s2_213 x1_m21d x1_net9 0.823592f
Cbud_s2_214 x1_m21d x2_foldn 1.7746f
Cbud_s2_215 x1_m21d x2_foldp 1.77385f
Cbud_s2_216 x1_m21d x2_m3d 6.38002f
Cbud_s2_217 x1_m21d x2_m4d 6.38002f
Cbud_s2_218 x1_m21d x2_tail 6.38002f
Cbud_s2_219 x1_m21d ip 1.17686f
Cbud_s2_220 x1_m25d x1_m2d 10.0394f
Cbud_s2_221 x1_m25d x1_m31d 5.14886f
Cbud_s2_222 x1_m25d x1_m5d 6.38002f
Cbud_s2_223 x1_m25d x1_net1 0.823592f
Cbud_s2_224 x1_m25d x1_net10 0.823592f
Cbud_s2_225 x1_m25d x1_net11 0.823592f
Cbud_s2_226 x1_m25d x1_net12 0.823592f
Cbud_s2_227 x1_m25d x1_net13 0.823592f
Cbud_s2_228 x1_m25d x1_net14 0.823592f
Cbud_s2_229 x1_m25d x1_net15 0.823592f
Cbud_s2_230 x1_m25d x1_net2 0.823592f
Cbud_s2_231 x1_m25d x1_net3 0.823592f
Cbud_s2_232 x1_m25d x1_net4 0.823592f
Cbud_s2_233 x1_m25d x1_net5 0.823592f
Cbud_s2_234 x1_m25d x1_net6 0.823592f
Cbud_s2_235 x1_m25d x1_net7 0.823592f
Cbud_s2_236 x1_m25d x1_net8 0.823592f
Cbud_s2_237 x1_m25d x1_net9 0.823592f
Cbud_s2_238 x1_m25d x2_foldn 1.77699f
Cbud_s2_239 x1_m25d x2_foldp 1.77146f
Cbud_s2_240 x1_m25d x2_m3d 6.38002f
Cbud_s2_241 x1_m25d x2_m4d 6.38002f
Cbud_s2_242 x1_m25d x2_tail 6.38002f
Cbud_s2_243 x1_m25d in 1.17686f
Cbud_s2_244 x1_m2d x1_m31d 5.14886f
Cbud_s2_245 x1_m2d x1_m5d 11.952f
Cbud_s2_246 x1_m2d x1_net1 0.823592f
Cbud_s2_247 x1_m2d x1_net10 0.823592f
Cbud_s2_248 x1_m2d x1_net11 0.823592f
Cbud_s2_249 x1_m2d x1_net12 0.823592f
Cbud_s2_250 x1_m2d x1_net13 0.823592f
Cbud_s2_251 x1_m2d x1_net14 0.823592f
Cbud_s2_252 x1_m2d x1_net15 0.823592f
Cbud_s2_253 x1_m2d x1_net2 0.823592f
Cbud_s2_254 x1_m2d x1_net3 0.823592f
Cbud_s2_255 x1_m2d x1_net4 0.823592f
Cbud_s2_256 x1_m2d x1_net5 0.823592f
Cbud_s2_257 x1_m2d x1_net6 0.823592f
Cbud_s2_258 x1_m2d x1_net7 0.823592f
Cbud_s2_259 x1_m2d x1_net8 0.823592f
Cbud_s2_260 x1_m2d x1_net9 0.823592f
Cbud_s2_261 x1_m2d x2_foldn 1.77913f
Cbud_s2_262 x1_m2d x2_foldp 1.76927f
Cbud_s2_263 x1_m2d x2_m3d 14.7548f
Cbud_s2_264 x1_m2d x2_m4d 14.4037f
Cbud_s2_265 x1_m2d x2_tail 22.3385f
Cbud_s2_266 x1_m2d ip 1.17686f
Cbud_s2_267 x1_m31d x1_m5d 5.14886f
Cbud_s2_268 x1_m31d x2_foldn 1.77431f
Cbud_s2_269 x1_m31d x2_foldp 1.77424f
Cbud_s2_270 x1_m31d x2_m3d 5.14886f
Cbud_s2_271 x1_m31d x2_m4d 5.14886f
Cbud_s2_272 x1_m31d x2_tail 5.14886f
Cbud_s2_273 x1_m31d ip 1.17686f
Cbud_s2_274 x1_m5d x1_net1 0.823592f
Cbud_s2_275 x1_m5d x1_net10 0.823592f
Cbud_s2_276 x1_m5d x1_net11 0.823592f
Cbud_s2_277 x1_m5d x1_net12 0.823592f
Cbud_s2_278 x1_m5d x1_net13 0.823592f
Cbud_s2_279 x1_m5d x1_net14 0.823592f
Cbud_s2_280 x1_m5d x1_net15 0.823592f
Cbud_s2_281 x1_m5d x1_net2 0.823592f
Cbud_s2_282 x1_m5d x1_net3 0.823592f
Cbud_s2_283 x1_m5d x1_net4 0.823592f
Cbud_s2_284 x1_m5d x1_net5 0.823592f
Cbud_s2_285 x1_m5d x1_net6 0.823592f
Cbud_s2_286 x1_m5d x1_net7 0.823592f
Cbud_s2_287 x1_m5d x1_net8 0.823592f
Cbud_s2_288 x1_m5d x1_net9 0.823592f
Cbud_s2_289 x1_m5d x2_foldn 1.78556f
Cbud_s2_290 x1_m5d x2_foldp 1.76285f
Cbud_s2_291 x1_m5d x2_m3d 11.952f
Cbud_s2_292 x1_m5d x2_m4d 11.952f
Cbud_s2_293 x1_m5d x2_tail 11.952f
Cbud_s2_294 x1_m5d ip 1.17686f
Cbud_s2_295 x1_net1 x2_foldn 0.823592f
Cbud_s2_296 x1_net1 x2_foldp 0.823592f
Cbud_s2_297 x1_net1 x2_m3d 0.823592f
Cbud_s2_298 x1_net1 x2_m4d 0.823592f
Cbud_s2_299 x1_net1 x2_tail 0.823592f
Cbud_s2_300 x1_net1 ip 0.823592f
Cbud_s2_301 x1_net10 x2_foldn 0.823592f
Cbud_s2_302 x1_net10 x2_foldp 0.823592f
Cbud_s2_303 x1_net10 x2_m3d 0.823592f
Cbud_s2_304 x1_net10 x2_m4d 0.823592f
Cbud_s2_305 x1_net10 x2_tail 0.823592f
Cbud_s2_306 x1_net10 ip 0.823592f
Cbud_s2_307 x1_net11 x2_foldn 0.823592f
Cbud_s2_308 x1_net11 x2_foldp 0.823592f
Cbud_s2_309 x1_net11 x2_m3d 0.823592f
Cbud_s2_310 x1_net11 x2_m4d 0.823592f
Cbud_s2_311 x1_net11 x2_tail 0.823592f
Cbud_s2_312 x1_net11 ip 0.823592f
Cbud_s2_313 x1_net12 x2_foldn 0.823592f
Cbud_s2_314 x1_net12 x2_foldp 0.823592f
Cbud_s2_315 x1_net12 x2_m3d 0.823592f
Cbud_s2_316 x1_net12 x2_m4d 0.823592f
Cbud_s2_317 x1_net12 x2_tail 0.823592f
Cbud_s2_318 x1_net12 ip 0.823592f
Cbud_s2_319 x1_net13 x2_foldn 0.823592f
Cbud_s2_320 x1_net13 x2_foldp 0.823592f
Cbud_s2_321 x1_net13 x2_m3d 0.823592f
Cbud_s2_322 x1_net13 x2_m4d 0.823592f
Cbud_s2_323 x1_net13 x2_tail 0.823592f
Cbud_s2_324 x1_net13 ip 0.823592f
Cbud_s2_325 x1_net14 x2_foldn 0.823592f
Cbud_s2_326 x1_net14 x2_foldp 0.823592f
Cbud_s2_327 x1_net14 x2_m3d 0.823592f
Cbud_s2_328 x1_net14 x2_m4d 0.823592f
Cbud_s2_329 x1_net14 x2_tail 0.823592f
Cbud_s2_330 x1_net14 ip 0.823592f
Cbud_s2_331 x1_net15 x2_foldn 0.823592f
Cbud_s2_332 x1_net15 x2_foldp 0.823592f
Cbud_s2_333 x1_net15 x2_m3d 0.823592f
Cbud_s2_334 x1_net15 x2_m4d 0.823592f
Cbud_s2_335 x1_net15 x2_tail 0.823592f
Cbud_s2_336 x1_net15 ip 0.823592f
Cbud_s2_337 x1_net2 x2_foldn 0.823592f
Cbud_s2_338 x1_net2 x2_foldp 0.823592f
Cbud_s2_339 x1_net2 x2_m3d 0.823592f
Cbud_s2_340 x1_net2 x2_m4d 0.823592f
Cbud_s2_341 x1_net2 x2_tail 0.823592f
Cbud_s2_342 x1_net2 ip 0.823592f
Cbud_s2_343 x1_net3 x2_foldn 0.823592f
Cbud_s2_344 x1_net3 x2_foldp 0.823592f
Cbud_s2_345 x1_net3 x2_m3d 0.823592f
Cbud_s2_346 x1_net3 x2_m4d 0.823592f
Cbud_s2_347 x1_net3 x2_tail 0.823592f
Cbud_s2_348 x1_net3 ip 0.823592f
Cbud_s2_349 x1_net4 x2_foldn 0.823592f
Cbud_s2_350 x1_net4 x2_foldp 0.823592f
Cbud_s2_351 x1_net4 x2_m3d 0.823592f
Cbud_s2_352 x1_net4 x2_m4d 0.823592f
Cbud_s2_353 x1_net4 x2_tail 0.823592f
Cbud_s2_354 x1_net4 ip 0.823592f
Cbud_s2_355 x1_net5 x2_foldn 0.823592f
Cbud_s2_356 x1_net5 x2_foldp 0.823592f
Cbud_s2_357 x1_net5 x2_m3d 0.823592f
Cbud_s2_358 x1_net5 x2_m4d 0.823592f
Cbud_s2_359 x1_net5 x2_tail 0.823592f
Cbud_s2_360 x1_net5 ip 0.823592f
Cbud_s2_361 x1_net6 x2_foldn 0.823592f
Cbud_s2_362 x1_net6 x2_foldp 0.823592f
Cbud_s2_363 x1_net6 x2_m3d 0.823592f
Cbud_s2_364 x1_net6 x2_m4d 0.823592f
Cbud_s2_365 x1_net6 x2_tail 0.823592f
Cbud_s2_366 x1_net6 ip 0.823592f
Cbud_s2_367 x1_net7 x2_foldn 0.823592f
Cbud_s2_368 x1_net7 x2_foldp 0.823592f
Cbud_s2_369 x1_net7 x2_m3d 0.823592f
Cbud_s2_370 x1_net7 x2_m4d 0.823592f
Cbud_s2_371 x1_net7 x2_tail 0.823592f
Cbud_s2_372 x1_net7 ip 0.823592f
Cbud_s2_373 x1_net8 x2_foldn 0.823592f
Cbud_s2_374 x1_net8 x2_foldp 0.823592f
Cbud_s2_375 x1_net8 x2_m3d 0.823592f
Cbud_s2_376 x1_net8 x2_m4d 0.823592f
Cbud_s2_377 x1_net8 x2_tail 0.823592f
Cbud_s2_378 x1_net8 ip 0.823592f
Cbud_s2_379 x1_net9 x2_foldn 0.823592f
Cbud_s2_380 x1_net9 x2_foldp 0.823592f
Cbud_s2_381 x1_net9 x2_m3d 0.823592f
Cbud_s2_382 x1_net9 x2_m4d 0.823592f
Cbud_s2_383 x1_net9 x2_tail 0.823592f
Cbud_s2_384 x1_net9 ip 0.823592f
Cbud_s2_385 x2_foldn x2_foldp 0.443556f
Cbud_s2_386 x2_foldn x2_m3d 1.00892f
Cbud_s2_387 x2_foldn x2_tail 1.77411f
Cbud_s2_388 x2_foldn ip 1.17686f
Cbud_s2_389 x2_foldn in 1.27025f
Cbud_s2_390 x2_foldp x2_m4d 0.996567f
Cbud_s2_391 x2_foldp x2_tail 1.77438f
Cbud_s2_392 x2_foldp ip 1.27025f
Cbud_s2_393 x2_foldp in 1.17686f
Cbud_s2_394 x2_m3d x2_m4d 14.4037f
Cbud_s2_395 x2_m3d x2_tail 14.7548f
Cbud_s2_396 x2_m3d ip 1.17686f
Cbud_s2_397 x2_m4d x2_tail 14.4037f
Cbud_s2_398 x2_m4d in 1.17686f
Cbud_s2_399 x2_tail in 2.41706f
XX1_M22 bias_b bias_c x1_m21d VDD sky130_fd_pr__pfet_01v8 L=0.6 W=1.4 NF=1 AD=0.406 AS=0.406 PD=3.38 PS=3.38 NRD=0.207143 NRS=0.207143 SA=0 SB=0 SD=0 MULT=6 M=6
XX1_M26 x1_m2d bias_c x1_m25d VDD sky130_fd_pr__pfet_01v8 L=0.6 W=1.4 NF=1 AD=0.406 AS=0.406 PD=3.38 PS=3.38 NRD=0.207143 NRS=0.207143 SA=0 SB=0 SD=0 MULT=6 M=6
XX1_M32 cm bias_c s1r_XX1_M32_s VDD sky130_fd_pr__pfet_01v8 L=0.6 W=1.4 NF=1 AD=0.406 AS=0.406 PD=3.38 PS=3.38 NRD=0.207143 NRS=0.207143 SA=0 SB=0 SD=0 MULT=6 M=6
Rpar_s1_XX1_M32_s s1r_XX1_M32_s x1_m31d 333.092
XX1_M21 x1_m21d bias_b VDD VDD sky130_fd_pr__pfet_01v8_lvt L=0.6 W=1.4 NF=1 AD=0.406 AS=0.406 PD=3.38 PS=3.38 NRD=0.207143 NRS=0.207143 SA=0 SB=0 SD=0 MULT=6 M=6
XX1_M25 s1r_XX1_M25_d bias_b s1r_XX1_M25_s VDD sky130_fd_pr__pfet_01v8_lvt L=0.6 W=1.4 NF=1 AD=0.406 AS=0.406 PD=3.38 PS=3.38 NRD=0.207143 NRS=0.207143 SA=0 SB=0 SD=0 MULT=6 M=6
Rpar_s1_XX1_M25_s s1r_XX1_M25_s VDD 157.028
Rpar_s1_XX1_M25_d s1r_XX1_M25_d x1_m25d 231.247
XX1_M31 s1r_XX1_M31_d bias_b VDD VDD sky130_fd_pr__pfet_01v8_lvt L=0.6 W=1.4 NF=1 AD=0.406 AS=0.406 PD=3.38 PS=3.38 NRD=0.207143 NRS=0.207143 SA=0 SB=0 SD=0 MULT=6 M=6
Rpar_s1_XX1_M31_d s1r_XX1_M31_d x1_m31d 333.092
XX1_M1 bias_b bias_b bias_c VSS sky130_fd_pr__nfet_01v8_lvt L=0.6 W=1.4 NF=1 AD=0.406 AS=0.406 PD=3.38 PS=3.38 NRD=0.207143 NRS=0.207143 SA=0 SB=0 SD=0 MULT=56 M=56
XX1_M2 s1r_XX1_M2_d x1_m2d bias_d VSS sky130_fd_pr__nfet_01v8 L=0.6 W=1.4 NF=1 AD=0.406 AS=0.406 PD=3.38 PS=3.38 NRD=0.207143 NRS=0.207143 SA=0 SB=0 SD=0 MULT=50 M=50
Rpar_s1_XX1_M2_d s1r_XX1_M2_d x1_m2d 580.525
XX1_M3 s1r_XX1_M3_d x1_m2d s1r_XX1_M3_s VSS sky130_fd_pr__nfet_01v8 L=0.6 W=1.4 NF=1 AD=0.406 AS=0.406 PD=3.38 PS=3.38 NRD=0.207143 NRS=0.207143 SA=0 SB=0 SD=0 MULT=2 M=2
Rpar_s1_XX1_M3_s s1r_XX1_M3_s bias_a 281.331
Rpar_s1_XX1_M3_d s1r_XX1_M3_d bias_d 108.169
XX1_M4 s1r_XX1_M4_d s1r_XX1_M4_g s1r_XX1_M4_s VSS sky130_fd_pr__nfet_01v8 L=0.6 W=1.4 NF=1 AD=0.406 AS=0.406 PD=3.38 PS=3.38 NRD=0.207143 NRS=0.207143 SA=0 SB=0 SD=0 MULT=18 M=18
Rpar_s1_XX1_M4_s s1r_XX1_M4_s x1_m5d 242.172
Rpar_s1_XX1_M4_g s1r_XX1_M4_g bias_d 265.057
Rpar_s1_XX1_M4_d s1r_XX1_M4_d bias_a 242.172
XX1_M5 s1r_XX1_M5_d bias_a s1r_XX1_M5_s VSS sky130_fd_pr__nfet_01v8 L=0.6 W=1.4 NF=1 AD=0.406 AS=0.406 PD=3.38 PS=3.38 NRD=0.207143 NRS=0.207143 SA=0 SB=0 SD=0 MULT=18 M=18
Rpar_s1_XX1_M5_s s1r_XX1_M5_s VSS 17.9519
Rpar_s1_XX1_M5_d s1r_XX1_M5_d x1_m5d 242.172
XX1_M6 s1r_XX1_M6_d i_bias VSS VSS sky130_fd_pr__nfet_01v8 L=0.6 W=1.4 NF=1 AD=0.406 AS=0.406 PD=3.38 PS=3.38 NRD=0.207143 NRS=0.207143 SA=0 SB=0 SD=0 MULT=18 M=18
Rpar_s1_XX1_M6_d s1r_XX1_M6_d bias_c 242.172
XX1_M7 s1r_XX1_M7_d i_bias VSS VSS sky130_fd_pr__nfet_01v8 L=0.6 W=1.4 NF=1 AD=0.406 AS=0.406 PD=3.38 PS=3.38 NRD=0.207143 NRS=0.207143 SA=0 SB=0 SD=0 MULT=18 M=18
Rpar_s1_XX1_M7_d s1r_XX1_M7_d i_bias 242.172
XX1_M33 cm cm x1_net1 VSS sky130_fd_pr__nfet_01v8 L=0.6 W=1.4 NF=1 AD=0.406 AS=0.406 PD=3.38 PS=3.38 NRD=0.207143 NRS=0.207143 SA=0 SB=0 SD=0 MULT=1 M=1
XX1_M49 x1_net1 cm x1_net2 VSS sky130_fd_pr__nfet_01v8 L=0.6 W=1.4 NF=1 AD=0.406 AS=0.406 PD=3.38 PS=3.38 NRD=0.207143 NRS=0.207143 SA=0 SB=0 SD=0 MULT=1 M=1
XX1_M50 x1_net2 cm x1_net3 VSS sky130_fd_pr__nfet_01v8 L=0.6 W=1.4 NF=1 AD=0.406 AS=0.406 PD=3.38 PS=3.38 NRD=0.207143 NRS=0.207143 SA=0 SB=0 SD=0 MULT=1 M=1
XX1_M63 x1_net3 cm VSS VSS sky130_fd_pr__nfet_01v8 L=0.6 W=1.4 NF=1 AD=0.406 AS=0.406 PD=3.38 PS=3.38 NRD=0.207143 NRS=0.207143 SA=0 SB=0 SD=0 MULT=1 M=1
XX1_M68 cm cm x1_net4 VSS sky130_fd_pr__nfet_01v8 L=0.6 W=1.4 NF=1 AD=0.406 AS=0.406 PD=3.38 PS=3.38 NRD=0.207143 NRS=0.207143 SA=0 SB=0 SD=0 MULT=1 M=1
XX1_M69 x1_net4 cm x1_net5 VSS sky130_fd_pr__nfet_01v8 L=0.6 W=1.4 NF=1 AD=0.406 AS=0.406 PD=3.38 PS=3.38 NRD=0.207143 NRS=0.207143 SA=0 SB=0 SD=0 MULT=1 M=1
XX1_M70 x1_net5 cm x1_net6 VSS sky130_fd_pr__nfet_01v8 L=0.6 W=1.4 NF=1 AD=0.406 AS=0.406 PD=3.38 PS=3.38 NRD=0.207143 NRS=0.207143 SA=0 SB=0 SD=0 MULT=1 M=1
XX1_M71 x1_net6 cm VSS VSS sky130_fd_pr__nfet_01v8 L=0.6 W=1.4 NF=1 AD=0.406 AS=0.406 PD=3.38 PS=3.38 NRD=0.207143 NRS=0.207143 SA=0 SB=0 SD=0 MULT=1 M=1
XX1_M72 cm cm x1_net7 VSS sky130_fd_pr__nfet_01v8 L=0.6 W=1.4 NF=1 AD=0.406 AS=0.406 PD=3.38 PS=3.38 NRD=0.207143 NRS=0.207143 SA=0 SB=0 SD=0 MULT=1 M=1
XX1_M73 x1_net7 cm x1_net8 VSS sky130_fd_pr__nfet_01v8 L=0.6 W=1.4 NF=1 AD=0.406 AS=0.406 PD=3.38 PS=3.38 NRD=0.207143 NRS=0.207143 SA=0 SB=0 SD=0 MULT=1 M=1
XX1_M74 x1_net8 cm x1_net9 VSS sky130_fd_pr__nfet_01v8 L=0.6 W=1.4 NF=1 AD=0.406 AS=0.406 PD=3.38 PS=3.38 NRD=0.207143 NRS=0.207143 SA=0 SB=0 SD=0 MULT=1 M=1
XX1_M75 x1_net9 cm VSS VSS sky130_fd_pr__nfet_01v8 L=0.6 W=1.4 NF=1 AD=0.406 AS=0.406 PD=3.38 PS=3.38 NRD=0.207143 NRS=0.207143 SA=0 SB=0 SD=0 MULT=1 M=1
XX1_M76 cm cm x1_net10 VSS sky130_fd_pr__nfet_01v8 L=0.6 W=1.4 NF=1 AD=0.406 AS=0.406 PD=3.38 PS=3.38 NRD=0.207143 NRS=0.207143 SA=0 SB=0 SD=0 MULT=1 M=1
XX1_M77 x1_net10 cm x1_net11 VSS sky130_fd_pr__nfet_01v8 L=0.6 W=1.4 NF=1 AD=0.406 AS=0.406 PD=3.38 PS=3.38 NRD=0.207143 NRS=0.207143 SA=0 SB=0 SD=0 MULT=1 M=1
XX1_M78 x1_net11 cm x1_net12 VSS sky130_fd_pr__nfet_01v8 L=0.6 W=1.4 NF=1 AD=0.406 AS=0.406 PD=3.38 PS=3.38 NRD=0.207143 NRS=0.207143 SA=0 SB=0 SD=0 MULT=1 M=1
XX1_M79 x1_net12 cm VSS VSS sky130_fd_pr__nfet_01v8 L=0.6 W=1.4 NF=1 AD=0.406 AS=0.406 PD=3.38 PS=3.38 NRD=0.207143 NRS=0.207143 SA=0 SB=0 SD=0 MULT=1 M=1
XX1_M64 cm cm x1_net13 VSS sky130_fd_pr__nfet_01v8 L=0.6 W=1.4 NF=1 AD=0.406 AS=0.406 PD=3.38 PS=3.38 NRD=0.207143 NRS=0.207143 SA=0 SB=0 SD=0 MULT=1 M=1
XX1_M65 x1_net13 cm x1_net14 VSS sky130_fd_pr__nfet_01v8 L=0.6 W=1.4 NF=1 AD=0.406 AS=0.406 PD=3.38 PS=3.38 NRD=0.207143 NRS=0.207143 SA=0 SB=0 SD=0 MULT=1 M=1
XX1_M66 x1_net14 cm x1_net15 VSS sky130_fd_pr__nfet_01v8 L=0.6 W=1.4 NF=1 AD=0.406 AS=0.406 PD=3.38 PS=3.38 NRD=0.207143 NRS=0.207143 SA=0 SB=0 SD=0 MULT=1 M=1
XX1_M67 x1_net15 cm VSS VSS sky130_fd_pr__nfet_01v8 L=0.6 W=1.4 NF=1 AD=0.406 AS=0.406 PD=3.38 PS=3.38 NRD=0.207143 NRS=0.207143 SA=0 SB=0 SD=0 MULT=1 M=1
XX1_M57 bias_b VDD VDD VDD sky130_fd_pr__pfet_01v8 L=0.6 W=1.4 NF=1 AD=0.406 AS=0.406 PD=3.38 PS=3.38 NRD=0.207143 NRS=0.207143 SA=0 SB=0 SD=0 MULT=2 M=2
XX1_M58 x1_m2d VDD VDD VDD sky130_fd_pr__pfet_01v8 L=0.6 W=1.4 NF=1 AD=0.406 AS=0.406 PD=3.38 PS=3.38 NRD=0.207143 NRS=0.207143 SA=0 SB=0 SD=0 MULT=2 M=2
XX1_M59 cm VDD VDD VDD sky130_fd_pr__pfet_01v8 L=0.6 W=1.4 NF=1 AD=0.406 AS=0.406 PD=3.38 PS=3.38 NRD=0.207143 NRS=0.207143 SA=0 SB=0 SD=0 MULT=2 M=2
XX1_M60 x1_m31d VDD VDD VDD sky130_fd_pr__pfet_01v8 L=0.6 W=1.4 NF=1 AD=0.406 AS=0.406 PD=3.38 PS=3.38 NRD=0.207143 NRS=0.207143 SA=0 SB=0 SD=0 MULT=2 M=2
XX1_M42 x1_m5d VSS VSS VSS sky130_fd_pr__nfet_01v8 L=0.6 W=1.4 NF=1 AD=0.406 AS=0.406 PD=3.38 PS=3.38 NRD=0.207143 NRS=0.207143 SA=0 SB=0 SD=0 MULT=6 M=6
XX1_M44 bias_c bias_c bias_c VSS sky130_fd_pr__nfet_01v8 L=0.6 W=1.4 NF=1 AD=0.406 AS=0.406 PD=3.38 PS=3.38 NRD=0.207143 NRS=0.207143 SA=0 SB=0 SD=0 MULT=2 M=2
XX1_M34 bias_d bias_d bias_d VSS sky130_fd_pr__nfet_01v8 L=0.6 W=1.4 NF=1 AD=0.406 AS=0.406 PD=3.38 PS=3.38 NRD=0.207143 NRS=0.207143 SA=0 SB=0 SD=0 MULT=8 M=8
XX1_M35 x1_m2d x1_m2d x1_m2d VSS sky130_fd_pr__nfet_01v8 L=0.6 W=1.4 NF=1 AD=0.406 AS=0.406 PD=3.38 PS=3.38 NRD=0.207143 NRS=0.207143 SA=0 SB=0 SD=0 MULT=2 M=2
XX1_M36 bias_a bias_a bias_a VSS sky130_fd_pr__nfet_01v8 L=0.6 W=1.4 NF=1 AD=0.406 AS=0.406 PD=3.38 PS=3.38 NRD=0.207143 NRS=0.207143 SA=0 SB=0 SD=0 MULT=4 M=4
XX1_M37 cm cm cm VSS sky130_fd_pr__nfet_01v8 L=0.6 W=1.4 NF=1 AD=0.406 AS=0.406 PD=3.38 PS=3.38 NRD=0.207143 NRS=0.207143 SA=0 SB=0 SD=0 MULT=8 M=8
XX1_M54 x1_m25d x1_m25d x1_m25d VDD sky130_fd_pr__pfet_01v8 L=0.6 W=1.4 NF=1 AD=0.406 AS=0.406 PD=3.38 PS=3.38 NRD=0.207143 NRS=0.207143 SA=0 SB=0 SD=0 MULT=2 M=2
XX1_M29 x1_m5d x1_m5d x1_m5d VSS sky130_fd_pr__nfet_01v8 L=0.6 W=1.4 NF=1 AD=0.406 AS=0.406 PD=3.38 PS=3.38 NRD=0.207143 NRS=0.207143 SA=0 SB=0 SD=0 MULT=6 M=6
XX1_M8 i_bias i_bias i_bias VSS sky130_fd_pr__nfet_01v8 L=0.6 W=1.4 NF=1 AD=0.406 AS=0.406 PD=3.38 PS=3.38 NRD=0.207143 NRS=0.207143 SA=0 SB=0 SD=0 MULT=2 M=2
XX1_M10 bias_c bias_c bias_c VSS sky130_fd_pr__nfet_01v8_lvt L=0.6 W=1.4 NF=1 AD=0.406 AS=0.406 PD=3.38 PS=3.38 NRD=0.207143 NRS=0.207143 SA=0 SB=0 SD=0 MULT=8 M=8
XX1_M27 bias_b bias_b bias_b VSS sky130_fd_pr__nfet_01v8_lvt L=0.6 W=1.4 NF=1 AD=0.406 AS=0.406 PD=3.38 PS=3.38 NRD=0.207143 NRS=0.207143 SA=0 SB=0 SD=0 MULT=8 M=8
XX1_M46 x1_m21d x1_m21d x1_m21d VDD sky130_fd_pr__pfet_01v8_lvt L=0.6 W=1.4 NF=1 AD=0.406 AS=0.406 PD=3.38 PS=3.38 NRD=0.207143 NRS=0.207143 SA=0 SB=0 SD=0 MULT=2 M=2
XX1_M47 x1_m25d x1_m25d x1_m25d VDD sky130_fd_pr__pfet_01v8_lvt L=0.6 W=1.4 NF=1 AD=0.406 AS=0.406 PD=3.38 PS=3.38 NRD=0.207143 NRS=0.207143 SA=0 SB=0 SD=0 MULT=2 M=2
XX1_M48 x1_m31d x1_m31d x1_m31d VDD sky130_fd_pr__pfet_01v8_lvt L=0.6 W=1.4 NF=1 AD=0.406 AS=0.406 PD=3.38 PS=3.38 NRD=0.207143 NRS=0.207143 SA=0 SB=0 SD=0 MULT=2 M=2
XX1_M51 x1_m21d x1_m21d x1_m21d VDD sky130_fd_pr__pfet_01v8 L=0.6 W=1.4 NF=1 AD=0.406 AS=0.406 PD=3.38 PS=3.38 NRD=0.207143 NRS=0.207143 SA=0 SB=0 SD=0 MULT=2 M=2
XX2_M1 s1r_XX2_M1_d s1r_XX2_M1_g s1r_XX2_M1_s VSS sky130_fd_pr__nfet_01v8_lvt L=0.2 W=1.2 NF=1 AD=0.348 AS=0.348 PD=2.98 PS=2.98 NRD=0.241667 NRS=0.241667 SA=0 SB=0 SD=0 MULT=6 M=6
Rpar_s1_XX2_M1_s s1r_XX2_M1_s x2_tail 2.53922
Rpar_s1_XX2_M1_g s1r_XX2_M1_g ip 100.033
Rpar_s1_XX2_M1_d s1r_XX2_M1_d x2_foldp 113.305
XX2_M2 s1r_XX2_M2_d s1r_XX2_M2_g s1r_XX2_M2_s VSS sky130_fd_pr__nfet_01v8_lvt L=0.2 W=1.2 NF=1 AD=0.348 AS=0.348 PD=2.98 PS=2.98 NRD=0.241667 NRS=0.241667 SA=0 SB=0 SD=0 MULT=6 M=6
Rpar_s1_XX2_M2_s s1r_XX2_M2_s x2_tail 2.53922
Rpar_s1_XX2_M2_g s1r_XX2_M2_g in 100.033
Rpar_s1_XX2_M2_d s1r_XX2_M2_d x2_foldn 113.305
XX2_M6 s1r_XX2_M6_d s1r_XX2_M6_g s1r_XX2_M6_s VSS sky130_fd_pr__nfet_01v8 L=0.6 W=1.4 NF=1 AD=0.406 AS=0.406 PD=3.38 PS=3.38 NRD=0.207143 NRS=0.207143 SA=0 SB=0 SD=0 MULT=96 M=96
Rpar_s1_XX2_M6_s s1r_XX2_M6_s VSS 40.4913
Rpar_s1_XX2_M6_g s1r_XX2_M6_g cmc 1091.48
Rpar_s1_XX2_M6_d s1r_XX2_M6_d x2_tail 494.136
XX2_M5 s1r_XX2_M5_d s1r_XX2_M5_g s1r_XX2_M5_s VSS sky130_fd_pr__nfet_01v8 L=0.6 W=1.4 NF=1 AD=0.406 AS=0.406 PD=3.38 PS=3.38 NRD=0.207143 NRS=0.207143 SA=0 SB=0 SD=0 MULT=96 M=96
Rpar_s1_XX2_M5_s s1r_XX2_M5_s VSS 37.2313
Rpar_s1_XX2_M5_g s1r_XX2_M5_g bias_a 1091.48
Rpar_s1_XX2_M5_d s1r_XX2_M5_d x2_tail 463.261
XX2_M11 s1r_XX2_M11_d s1r_XX2_M11_g s1r_XX2_M11_s VDD sky130_fd_pr__pfet_01v8_lvt L=0.6 W=1.4 NF=1 AD=0.406 AS=0.406 PD=3.38 PS=3.38 NRD=0.207143 NRS=0.207143 SA=0 SB=0 SD=0 MULT=24 M=24
Rpar_s1_XX2_M11_s s1r_XX2_M11_s VDD 21.4811
Rpar_s1_XX2_M11_g s1r_XX2_M11_g bias_b 329.875
Rpar_s1_XX2_M11_d s1r_XX2_M11_d x2_foldp 13.8312
XX2_M12 s1r_XX2_M12_d s1r_XX2_M12_g s1r_XX2_M12_s VDD sky130_fd_pr__pfet_01v8_lvt L=0.6 W=1.4 NF=1 AD=0.406 AS=0.406 PD=3.38 PS=3.38 NRD=0.207143 NRS=0.207143 SA=0 SB=0 SD=0 MULT=24 M=24
Rpar_s1_XX2_M12_s s1r_XX2_M12_s VDD 21.523
Rpar_s1_XX2_M12_g s1r_XX2_M12_g bias_b 329.875
Rpar_s1_XX2_M12_d s1r_XX2_M12_d x2_foldn 13.8319
XX2_M1A s1r_XX2_M1A_d s1r_XX2_M1A_g s1r_XX2_M1A_s VDD sky130_fd_pr__pfet_01v8 L=0.6 W=1.4 NF=1 AD=0.406 AS=0.406 PD=3.38 PS=3.38 NRD=0.207143 NRS=0.207143 SA=0 SB=0 SD=0 MULT=20 M=20
Rpar_s1_XX2_M1A_s s1r_XX2_M1A_s x2_foldp 20.0792
Rpar_s1_XX2_M1A_g s1r_XX2_M1A_g bias_c 112.107
Rpar_s1_XX2_M1A_d s1r_XX2_M1A_d on 184.775
XX2_M8 s1r_XX2_M8_d s1r_XX2_M8_g s1r_XX2_M8_s VDD sky130_fd_pr__pfet_01v8 L=0.6 W=1.4 NF=1 AD=0.406 AS=0.406 PD=3.38 PS=3.38 NRD=0.207143 NRS=0.207143 SA=0 SB=0 SD=0 MULT=20 M=20
Rpar_s1_XX2_M8_s s1r_XX2_M8_s x2_foldn 20.0434
Rpar_s1_XX2_M8_g s1r_XX2_M8_g bias_c 112.107
Rpar_s1_XX2_M8_d s1r_XX2_M8_d op 184.82
XX2_M3A s1r_XX2_M3A_d s1r_XX2_M3A_g x2_m3d VSS sky130_fd_pr__nfet_01v8 L=0.6 W=1.4 NF=1 AD=0.406 AS=0.406 PD=3.38 PS=3.38 NRD=0.207143 NRS=0.207143 SA=0 SB=0 SD=0 MULT=36 M=36
Rpar_s1_XX2_M3A_g s1r_XX2_M3A_g bias_d 440.14
Rpar_s1_XX2_M3A_d s1r_XX2_M3A_d on 428.697
XX2_M7 s1r_XX2_M7_d s1r_XX2_M7_g x2_m4d VSS sky130_fd_pr__nfet_01v8 L=0.6 W=1.4 NF=1 AD=0.406 AS=0.406 PD=3.38 PS=3.38 NRD=0.207143 NRS=0.207143 SA=0 SB=0 SD=0 MULT=36 M=36
Rpar_s1_XX2_M7_g s1r_XX2_M7_g bias_d 440.14
Rpar_s1_XX2_M7_d s1r_XX2_M7_d op 428.697
XX2_M3 x2_m3d s1r_XX2_M3_g VSS VSS sky130_fd_pr__nfet_01v8 L=0.6 W=1.4 NF=1 AD=0.406 AS=0.406 PD=3.38 PS=3.38 NRD=0.207143 NRS=0.207143 SA=0 SB=0 SD=0 MULT=36 M=36
Rpar_s1_XX2_M3_g s1r_XX2_M3_g bias_a 440.14
XX2_M4 x2_m4d s1r_XX2_M4_g VSS VSS sky130_fd_pr__nfet_01v8 L=0.6 W=1.4 NF=1 AD=0.406 AS=0.406 PD=3.38 PS=3.38 NRD=0.207143 NRS=0.207143 SA=0 SB=0 SD=0 MULT=36 M=36
Rpar_s1_XX2_M4_g s1r_XX2_M4_g bias_a 440.14
XX2_M82 x2_foldn x2_foldn x2_foldn VDD sky130_fd_pr__pfet_01v8 L=0.6 W=1.4 NF=1 AD=0.406 AS=0.406 PD=3.38 PS=3.38 NRD=0.207143 NRS=0.207143 SA=0 SB=0 SD=0 MULT=2 M=2
XX2_M83 x2_foldp x2_foldp x2_foldp VDD sky130_fd_pr__pfet_01v8 L=0.6 W=1.4 NF=1 AD=0.406 AS=0.406 PD=3.38 PS=3.38 NRD=0.207143 NRS=0.207143 SA=0 SB=0 SD=0 MULT=2 M=2
XX2_M55 x2_foldn VDD VDD VDD sky130_fd_pr__pfet_01v8 L=0.6 W=1.4 NF=1 AD=0.406 AS=0.406 PD=3.38 PS=3.38 NRD=0.207143 NRS=0.207143 SA=0 SB=0 SD=0 MULT=2 M=2
XX2_M56 op VDD VDD VDD sky130_fd_pr__pfet_01v8 L=0.6 W=1.4 NF=1 AD=0.406 AS=0.406 PD=3.38 PS=3.38 NRD=0.207143 NRS=0.207143 SA=0 SB=0 SD=0 MULT=4 M=4
XX2_M61 x2_foldp VDD VDD VDD sky130_fd_pr__pfet_01v8 L=0.6 W=1.4 NF=1 AD=0.406 AS=0.406 PD=3.38 PS=3.38 NRD=0.207143 NRS=0.207143 SA=0 SB=0 SD=0 MULT=2 M=2
XX2_M62 on VDD VDD VDD sky130_fd_pr__pfet_01v8 L=0.6 W=1.4 NF=1 AD=0.406 AS=0.406 PD=3.38 PS=3.38 NRD=0.207143 NRS=0.207143 SA=0 SB=0 SD=0 MULT=4 M=4
XX2_M40 x2_m4d VSS VSS VSS sky130_fd_pr__nfet_01v8 L=0.6 W=1.4 NF=1 AD=0.406 AS=0.406 PD=3.38 PS=3.38 NRD=0.207143 NRS=0.207143 SA=0 SB=0 SD=0 MULT=6 M=6
XX2_M41 x2_m3d VSS VSS VSS sky130_fd_pr__nfet_01v8 L=0.6 W=1.4 NF=1 AD=0.406 AS=0.406 PD=3.38 PS=3.38 NRD=0.207143 NRS=0.207143 SA=0 SB=0 SD=0 MULT=8 M=8
XX2_M38 op op op VSS sky130_fd_pr__nfet_01v8 L=0.6 W=1.4 NF=1 AD=0.406 AS=0.406 PD=3.38 PS=3.38 NRD=0.207143 NRS=0.207143 SA=0 SB=0 SD=0 MULT=2 M=2
XX2_M39 on on on VSS sky130_fd_pr__nfet_01v8 L=0.6 W=1.4 NF=1 AD=0.406 AS=0.406 PD=3.38 PS=3.38 NRD=0.207143 NRS=0.207143 SA=0 SB=0 SD=0 MULT=2 M=2
XX2_M30 x2_tail VSS VSS VSS sky130_fd_pr__nfet_01v8 L=0.6 W=1.4 NF=1 AD=0.406 AS=0.406 PD=3.38 PS=3.38 NRD=0.207143 NRS=0.207143 SA=0 SB=0 SD=0 MULT=2 M=2
XX2_M23 x2_foldp x2_foldp x2_foldp VSS sky130_fd_pr__nfet_01v8_lvt L=0.2 W=1.2 NF=1 AD=0.348 AS=0.348 PD=2.98 PS=2.98 NRD=0.241667 NRS=0.241667 SA=0 SB=0 SD=0 MULT=2 M=2
XX2_M24 x2_foldn x2_foldn x2_foldn VSS sky130_fd_pr__nfet_01v8_lvt L=0.2 W=1.2 NF=1 AD=0.348 AS=0.348 PD=2.98 PS=2.98 NRD=0.241667 NRS=0.241667 SA=0 SB=0 SD=0 MULT=2 M=2
XX2_M80 op VSS VSS VSS sky130_fd_pr__nfet_01v8 L=0.6 W=1.4 NF=1 AD=0.406 AS=0.406 PD=3.38 PS=3.38 NRD=0.207143 NRS=0.207143 SA=0 SB=0 SD=0 MULT=2 M=2
XX2_M81 on VSS VSS VSS sky130_fd_pr__nfet_01v8 L=0.6 W=1.4 NF=1 AD=0.406 AS=0.406 PD=3.38 PS=3.38 NRD=0.207143 NRS=0.207143 SA=0 SB=0 SD=0 MULT=2 M=2
XX2_M28 x2_tail x2_tail x2_tail VSS sky130_fd_pr__nfet_01v8 L=0.6 W=1.4 NF=1 AD=0.406 AS=0.406 PD=3.38 PS=3.38 NRD=0.207143 NRS=0.207143 SA=0 SB=0 SD=0 MULT=6 M=6
XM43 VDD VDD VDD VDD sky130_fd_pr__pfet_01v8_lvt L=0.6 W=1.4 NF=1 AD=0.406 AS=0.406 PD=3.38 PS=3.38 NRD=0.207143 NRS=0.207143 SA=0 SB=0 SD=0 MULT=8 M=8
XM45 VDD VDD VDD VDD sky130_fd_pr__pfet_01v8 L=0.6 W=1.4 NF=1 AD=0.406 AS=0.406 PD=3.38 PS=3.38 NRD=0.207143 NRS=0.207143 SA=0 SB=0 SD=0 MULT=6 M=6
XM9 VSS VSS VSS VSS sky130_fd_pr__nfet_01v8 L=0.6 W=1.4 NF=1 AD=0.406 AS=0.406 PD=3.38 PS=3.38 NRD=0.207143 NRS=0.207143 SA=0 SB=0 SD=0 MULT=23 M=23
Ibias_ext VDD i_bias 3e-05
XC3 op cmc sky130_fd_pr__cap_mim_m3_1 W=4.8 L=4.8 MF=4 M=4
XC4 on cmc sky130_fd_pr__cap_mim_m3_1 W=4.8 L=4.8 MF=4 M=4
.ends iadc_ota
.end
