* iadc_ota on dido_amp_AC
.lib $PDK_ROOT/sky130A/libs.tech/combined/sky130.lib.spice tt
.param VDD_V=1.8 VCM_V=0.9 CL_F=0.3p
.temp 27

**.subckt dido_amp_AC
x1 INP INN OUTN VDD 0 OUTP dut_amp
Vsup VDD 0 'VDD_V'
* AC drive through 1 F couplers; DC set by unity feedback through 1 GH chokes (OUTP->INN, OUTN->INP)
Vacp ACP 0 dc 0 ac 0.5
Vacn ACN 0 dc 0 ac -0.5
Cinp ACP INP 1
Cinn ACN INN 1
Lfbp OUTP INN 1G
Lfbn OUTN INP 1G
Cloadp OUTP 0 'CL_F'
Cloadn OUTN 0 'CL_F'
.control
  save all
  ac dec 40 1 1G
  let hsig = v(OUTP) - v(OUTN)
  let hdb = db(hsig)
  let gph_deg = 180/pi * cph(hsig)
  meas ac gain_db find hdb at=1
  meas ac gbw_hz  when hdb=0
  meas ac ph_dc   find gph_deg at=1
  meas ac ph_ugb  find gph_deg when hdb=0
  let gbw_mhz = gbw_hz / 1e6
  let pm_deg  = 180 + (ph_ugb - ph_dc)
  echo MEAS gain_db $&gain_db
  echo MEAS gbw_mhz $&gbw_mhz
  echo MEAS pm_deg $&pm_deg
  write
  quit 0
.endc
**.ends

.subckt dut_amp INP INN OUTN VDD VSS OUTP
XDUT INP INN OUTP OUTN VDD VSS cmc_w cm_w bias_a_w iadc_ota
* ideal CMFB: the steady-state law of the upstream switched-capacitor CMFB (ASSUMPTION)
Bcmfb cmc_w VSS V = v(bias_a_w) + (v(OUTP) + v(OUTN))/2 - v(cm_w)
.ends

.subckt iadc_ota ip in op on VDD VSS cmc cm bias_a
Cbud_s2_0 bias_d VSS 661.851f
Cbud_s2_1 i_bias VSS 281.759f
Cbud_s2_2 x1_m25d VSS 87.9203f
Cbud_s2_3 x1_m2d VSS 433.346f
Cbud_s2_4 x2_foldn VSS 0.00514275f
Cbud_s2_5 x2_foldp VSS 0.00514273f
Cbud_s2_6 x2_tail VSS 741.326f
Cbud_s2_7 bias_a bias_d 42.6198f
Cbud_s2_8 bias_a x1_m25d 6.38002f
Cbud_s2_9 bias_a x1_m2d 23.4901f
Cbud_s2_10 bias_a x1_m5d 33.2946f
Cbud_s2_11 bias_a x2_foldn 0.00515351f
Cbud_s2_12 bias_a x2_foldp 0.00513186f
Cbud_s2_13 bias_a ip 1.17686f
Cbud_s2_14 bias_b bias_d 31.0356f
Cbud_s2_15 bias_b x1_m25d 9.83482f
Cbud_s2_16 bias_b x1_m2d 22.3385f
Cbud_s2_17 bias_b x1_m31d 8.60366f
Cbud_s2_18 bias_b x2_foldn 0.00514403f
Cbud_s2_19 bias_b x2_foldp 0.00514111f
Cbud_s2_20 bias_b x2_tail 40.2841f
Cbud_s2_21 bias_b ip 1.17686f
Cbud_s2_22 bias_c bias_d 31.0356f
Cbud_s2_23 bias_c x1_m25d 9.83482f
Cbud_s2_24 bias_c x1_m2d 25.7933f
Cbud_s2_25 bias_c x2_foldn 0.00514457f
Cbud_s2_26 bias_c x2_foldp 0.00514074f
Cbud_s2_27 bias_c x2_tail 31.96f
Cbud_s2_28 bias_c ip 1.17686f
Cbud_s2_29 bias_d cm 17.1763f
Cbud_s2_30 bias_d i_bias 11.952f
Cbud_s2_31 bias_d x1_m21d 6.38002f
Cbud_s2_32 bias_d x1_m25d 6.38002f
Cbud_s2_33 bias_d x1_m2d 82.7751f
Cbud_s2_34 bias_d x1_m31d 5.14886f
Cbud_s2_35 bias_d x1_m5d 22.3164f
Cbud_s2_36 bias_d x1_net1 0.823592f
Cbud_s2_37 bias_d x1_net10 0.823592f
Cbud_s2_38 bias_d x1_net11 0.823592f
Cbud_s2_39 bias_d x1_net12 0.823592f
Cbud_s2_40 bias_d x1_net13 0.823592f
Cbud_s2_41 bias_d x1_net14 0.823592f
Cbud_s2_42 bias_d x1_net15 0.823592f
Cbud_s2_43 bias_d x1_net2 0.823592f
Cbud_s2_44 bias_d x1_net3 0.823592f
Cbud_s2_45 bias_d x1_net4 0.823592f
Cbud_s2_46 bias_d x1_net5 0.823592f
Cbud_s2_47 bias_d x1_net6 0.823592f
Cbud_s2_48 bias_d x1_net7 0.823592f
Cbud_s2_49 bias_d x1_net8 0.823592f
Cbud_s2_50 bias_d x1_net9 0.823592f
Cbud_s2_51 bias_d x2_foldn 0.00515465f
Cbud_s2_52 bias_d x2_foldp 0.00513061f
Cbud_s2_53 bias_d x2_tail 31.0356f
Cbud_s2_54 bias_d in 1.17686f
Cbud_s2_55 cm x1_m25d 6.38002f
Cbud_s2_56 cm x1_m2d 17.1763f
Cbud_s2_57 cm x2_foldn 0.00514255f
Cbud_s2_58 cm x2_foldp 0.00514251f
Cbud_s2_59 cm x2_tail 17.1763f
Cbud_s2_60 cm ip 1.17686f
Cbud_s2_61 i_bias x1_m25d 6.38002f
Cbud_s2_62 i_bias x1_m2d 11.952f
Cbud_s2_63 i_bias x1_net11 0.823592f
Cbud_s2_64 i_bias x1_net12 0.823592f
Cbud_s2_65 i_bias x1_net14 0.823592f
Cbud_s2_66 i_bias x1_net15 0.823592f
Cbud_s2_67 i_bias x1_net2 0.823592f
Cbud_s2_68 i_bias x1_net3 0.823592f
Cbud_s2_69 i_bias x1_net5 0.823592f
Cbud_s2_70 i_bias x1_net6 0.823592f
Cbud_s2_71 i_bias x1_net8 0.823592f
Cbud_s2_72 i_bias x1_net9 0.823592f
Cbud_s2_73 i_bias x2_foldn 0.00514165f
Cbud_s2_74 i_bias x2_foldp 0.00514392f
Cbud_s2_75 i_bias ip 1.17686f
Cbud_s2_76 on x2_foldn 0.00192177f
Cbud_s2_77 on x2_m3d 0.0205663f
Cbud_s2_78 on ip 0.011829f
Cbud_s2_79 op x2_foldp 0.0019218f
Cbud_s2_80 op x2_m4d 0.0203082f
Cbud_s2_81 op in 0.0118311f
Cbud_s2_82 x1_m21d x1_m25d 6.38002f
Cbud_s2_83 x1_m21d x1_m2d 6.38002f
Cbud_s2_84 x1_m21d x2_foldn 0.00514376f
Cbud_s2_85 x1_m21d x2_foldp 0.0051416f
Cbud_s2_86 x1_m21d x2_tail 6.38002f
Cbud_s2_87 x1_m21d in 1.17686f
Cbud_s2_88 x1_m25d x1_m2d 10.0394f
Cbud_s2_89 x1_m25d x1_m31d 5.14886f
Cbud_s2_90 x1_m25d x1_net1 0.823592f
Cbud_s2_91 x1_m25d x1_net10 0.823592f
Cbud_s2_92 x1_m25d x1_net11 0.823592f
Cbud_s2_93 x1_m25d x1_net12 0.823592f
Cbud_s2_94 x1_m25d x1_net13 0.823592f
Cbud_s2_95 x1_m25d x1_net14 0.823592f
Cbud_s2_96 x1_m25d x1_net15 0.823592f
Cbud_s2_97 x1_m25d x1_net2 0.823592f
Cbud_s2_98 x1_m25d x1_net3 0.823592f
Cbud_s2_99 x1_m25d x1_net4 0.823592f
Cbud_s2_100 x1_m25d x1_net5 0.823592f
Cbud_s2_101 x1_m25d x1_net6 0.823592f
Cbud_s2_102 x1_m25d x1_net7 0.823592f
Cbud_s2_103 x1_m25d x1_net8 0.823592f
Cbud_s2_104 x1_m25d x1_net9 0.823592f
Cbud_s2_105 x1_m25d x2_foldn 0.0051507f
Cbud_s2_106 x1_m25d x2_foldp 0.00513467f
Cbud_s2_107 x1_m25d x2_tail 6.38002f
Cbud_s2_108 x1_m25d in 1.17686f
Cbud_s2_109 x1_m2d x1_m31d 5.14886f
Cbud_s2_110 x1_m2d x1_m5d 11.952f
Cbud_s2_111 x1_m2d x1_net1 0.823592f
Cbud_s2_112 x1_m2d x1_net10 0.823592f
Cbud_s2_113 x1_m2d x1_net11 0.823592f
Cbud_s2_114 x1_m2d x1_net12 0.823592f
Cbud_s2_115 x1_m2d x1_net13 0.823592f
Cbud_s2_116 x1_m2d x1_net14 0.823592f
Cbud_s2_117 x1_m2d x1_net15 0.823592f
Cbud_s2_118 x1_m2d x1_net2 0.823592f
Cbud_s2_119 x1_m2d x1_net3 0.823592f
Cbud_s2_120 x1_m2d x1_net4 0.823592f
Cbud_s2_121 x1_m2d x1_net5 0.823592f
Cbud_s2_122 x1_m2d x1_net6 0.823592f
Cbud_s2_123 x1_m2d x1_net7 0.823592f
Cbud_s2_124 x1_m2d x1_net8 0.823592f
Cbud_s2_125 x1_m2d x1_net9 0.823592f
Cbud_s2_126 x1_m2d x2_foldn 0.00515689f
Cbud_s2_127 x1_m2d x2_foldp 0.00512831f
Cbud_s2_128 x1_m2d x2_tail 22.3385f
Cbud_s2_129 x1_m2d in 1.17686f
Cbud_s2_130 x1_m31d x2_foldn 0.00514292f
Cbud_s2_131 x1_m31d x2_foldp 0.00514274f
Cbud_s2_132 x1_m31d x2_tail 5.14886f
Cbud_s2_133 x1_m31d ip 1.17686f
Cbud_s2_134 x1_m5d x2_foldn 0.00517553f
Cbud_s2_135 x1_m5d x2_foldp 0.0051097f
Cbud_s2_136 x1_m5d ip 1.17686f
Cbud_s2_137 x1_net1 x1_net11 0.823592f
Cbud_s2_138 x1_net1 x1_net5 0.823592f
Cbud_s2_139 x1_net1 x2_foldn 0.00514354f
Cbud_s2_140 x1_net1 x2_foldp 0.0051435f
Cbud_s2_141 x1_net1 x2_tail 0.823592f
Cbud_s2_142 x1_net1 ip 0.823592f
Cbud_s2_143 x1_net10 x1_net8 0.823592f
Cbud_s2_144 x1_net10 x2_foldn 0.00514354f
Cbud_s2_145 x1_net10 x2_foldp 0.0051435f
Cbud_s2_146 x1_net10 x2_tail 0.823592f
Cbud_s2_147 x1_net10 ip 0.823592f
Cbud_s2_148 x1_net11 x1_net15 0.823592f
Cbud_s2_149 x1_net11 x1_net3 0.823592f
Cbud_s2_150 x1_net11 x1_net6 0.823592f
Cbud_s2_151 x1_net11 x1_net9 0.823592f
Cbud_s2_152 x1_net11 x2_foldn 0.00514339f
Cbud_s2_153 x1_net11 x2_foldp 0.00514336f
Cbud_s2_154 x1_net11 x2_tail 0.823592f
Cbud_s2_155 x1_net11 ip 0.823592f
Cbud_s2_156 x1_net12 x1_net14 0.823592f
Cbud_s2_157 x1_net12 x1_net2 0.823592f
Cbud_s2_158 x1_net12 x1_net5 0.823592f
Cbud_s2_159 x1_net12 x2_foldn 0.00514306f
Cbud_s2_160 x1_net12 x2_foldp 0.00514304f
Cbud_s2_161 x1_net12 x2_tail 0.823592f
Cbud_s2_162 x1_net12 ip 0.823592f
Cbud_s2_163 x1_net13 x1_net5 0.823592f
Cbud_s2_164 x1_net13 x2_foldn 0.00514354f
Cbud_s2_165 x1_net13 x2_foldp 0.0051435f
Cbud_s2_166 x1_net13 x2_tail 0.823592f
Cbud_s2_167 x1_net13 ip 0.823592f
Cbud_s2_168 x1_net14 x1_net3 0.823592f
Cbud_s2_169 x1_net14 x1_net6 0.823592f
Cbud_s2_170 x1_net14 x1_net7 0.823592f
Cbud_s2_171 x1_net14 x1_net9 0.823592f
Cbud_s2_172 x1_net14 x2_foldn 0.00514339f
Cbud_s2_173 x1_net14 x2_foldp 0.00514336f
Cbud_s2_174 x1_net14 x2_tail 0.823592f
Cbud_s2_175 x1_net14 ip 0.823592f
Cbud_s2_176 x1_net15 x1_net2 0.823592f
Cbud_s2_177 x1_net15 x1_net5 0.823592f
Cbud_s2_178 x1_net15 x2_foldn 0.00514306f
Cbud_s2_179 x1_net15 x2_foldp 0.00514304f
Cbud_s2_180 x1_net15 x2_tail 0.823592f
Cbud_s2_181 x1_net15 ip 0.823592f
Cbud_s2_182 x1_net2 x1_net6 0.823592f
Cbud_s2_183 x1_net2 x1_net7 0.823592f
Cbud_s2_184 x1_net2 x1_net9 0.823592f
Cbud_s2_185 x1_net2 x2_foldn 0.00514339f
Cbud_s2_186 x1_net2 x2_foldp 0.00514336f
Cbud_s2_187 x1_net2 x2_tail 0.823592f
Cbud_s2_188 x1_net2 ip 0.823592f
Cbud_s2_189 x1_net3 x1_net5 0.823592f
Cbud_s2_190 x1_net3 x2_foldn 0.00514306f
Cbud_s2_191 x1_net3 x2_foldp 0.00514304f
Cbud_s2_192 x1_net3 x2_tail 0.823592f
Cbud_s2_193 x1_net3 ip 0.823592f
Cbud_s2_194 x1_net4 x1_net8 0.823592f
Cbud_s2_195 x1_net4 x2_foldn 0.00514354f
Cbud_s2_196 x1_net4 x2_foldp 0.0051435f
Cbud_s2_197 x1_net4 x2_tail 0.823592f
Cbud_s2_198 x1_net4 ip 0.823592f
Cbud_s2_199 x1_net5 x2_foldn 0.00514339f
Cbud_s2_200 x1_net5 x2_foldp 0.00514336f
Cbud_s2_201 x1_net5 x2_tail 0.823592f
Cbud_s2_202 x1_net5 ip 0.823592f
Cbud_s2_203 x1_net6 x2_foldn 0.00514306f
Cbud_s2_204 x1_net6 x2_foldp 0.00514304f
Cbud_s2_205 x1_net6 x2_tail 0.823592f
Cbud_s2_206 x1_net6 ip 0.823592f
Cbud_s2_207 x1_net7 x2_foldn 0.00514354f
Cbud_s2_208 x1_net7 x2_foldp 0.0051435f
Cbud_s2_209 x1_net7 x2_tail 0.823592f
Cbud_s2_210 x1_net7 ip 0.823592f
Cbud_s2_211 x1_net8 x2_foldn 0.00514339f
Cbud_s2_212 x1_net8 x2_foldp 0.00514336f
Cbud_s2_213 x1_net8 x2_tail 0.823592f
Cbud_s2_214 x1_net8 ip 0.823592f
Cbud_s2_215 x1_net9 x2_foldn 0.00514306f
Cbud_s2_216 x1_net9 x2_foldp 0.00514304f
Cbud_s2_217 x1_net9 x2_tail 0.823592f
Cbud_s2_218 x1_net9 ip 0.823592f
Cbud_s2_219 x2_foldn x2_foldp 0.00128567f
Cbud_s2_220 x2_foldn x2_m3d 0.0029244f
Cbud_s2_221 x2_foldn x2_tail 0.00514236f
Cbud_s2_222 x2_foldn ip 0.00852539f
Cbud_s2_223 x2_foldn in 0.00368188f
Cbud_s2_224 x2_foldp x2_m4d 0.0028886f
Cbud_s2_225 x2_foldp x2_tail 0.00514312f
Cbud_s2_226 x2_foldp ip 0.00368189f
Cbud_s2_227 x2_foldp in 0.00852523f
Cbud_s2_228 x2_m3d ip 0.0128073f
Cbud_s2_229 x2_m4d in 0.0125852f
Cbud_s2_230 x2_tail in 2.41706f
XX1_M22 s1r_XX1_M22_d bias_c s1r_XX1_M22_s VDD sky130_fd_pr__pfet_01v8 L=0.6 W=1.4 NF=1 AD=0.406 AS=0.406 PD=3.38 PS=3.38 NRD=0.207143 NRS=0.207143 SA=0 SB=0 SD=0 MULT=6 M=6
Rpar_s1_XX1_M22_s s1r_XX1_M22_s x1_m21d 0.549657
Rpar_s1_XX1_M22_d s1r_XX1_M22_d bias_b 34.9282
XX1_M26 s1r_XX1_M26_d bias_c s1r_XX1_M26_s VDD sky130_fd_pr__pfet_01v8 L=0.6 W=1.4 NF=1 AD=0.406 AS=0.406 PD=3.38 PS=3.38 NRD=0.207143 NRS=0.207143 SA=0 SB=0 SD=0 MULT=6 M=6
Rpar_s1_XX1_M26_s s1r_XX1_M26_s x1_m25d 0.670282
Rpar_s1_XX1_M26_d s1r_XX1_M26_d x1_m2d 1.09556
XX1_M32 cm bias_c x1_m31d VDD sky130_fd_pr__pfet_01v8 L=0.6 W=1.4 NF=1 AD=0.406 AS=0.406 PD=3.38 PS=3.38 NRD=0.207143 NRS=0.207143 SA=0 SB=0 SD=0 MULT=6 M=6
XX1_M21 s1r_XX1_M21_d bias_b s1r_XX1_M21_s VDD sky130_fd_pr__pfet_01v8_lvt L=0.6 W=1.4 NF=1 AD=0.406 AS=0.406 PD=3.38 PS=3.38 NRD=0.207143 NRS=0.207143 SA=0 SB=0 SD=0 MULT=6 M=6
Rpar_s1_XX1_M21_s s1r_XX1_M21_s VDD 0.306022
Rpar_s1_XX1_M21_d s1r_XX1_M21_d x1_m21d 0.549657
XX1_M25 s1r_XX1_M25_d bias_b s1r_XX1_M25_s VDD sky130_fd_pr__pfet_01v8_lvt L=0.6 W=1.4 NF=1 AD=0.406 AS=0.406 PD=3.38 PS=3.38 NRD=0.207143 NRS=0.207143 SA=0 SB=0 SD=0 MULT=6 M=6
Rpar_s1_XX1_M25_s s1r_XX1_M25_s VDD 0.455154
Rpar_s1_XX1_M25_d s1r_XX1_M25_d x1_m25d 0.670282
XX1_M31 x1_m31d bias_b s1r_XX1_M31_s VDD sky130_fd_pr__pfet_01v8_lvt L=0.6 W=1.4 NF=1 AD=0.406 AS=0.406 PD=3.38 PS=3.38 NRD=0.207143 NRS=0.207143 SA=0 SB=0 SD=0 MULT=6 M=6
Rpar_s1_XX1_M31_s s1r_XX1_M31_s VDD 69.6179
XX1_M1 s1r_XX1_M1_d bias_b s1r_XX1_M1_s VSS sky130_fd_pr__nfet_01v8_lvt L=0.6 W=1.4 NF=1 AD=0.406 AS=0.406 PD=3.38 PS=3.38 NRD=0.207143 NRS=0.207143 SA=0 SB=0 SD=0 MULT=56 M=56
Rpar_s1_XX1_M1_s s1r_XX1_M1_s bias_c 0.488391
Rpar_s1_XX1_M1_d s1r_XX1_M1_d bias_b 37.356
XX1_M2 x1_m2d x1_m2d s1r_XX1_M2_s VSS sky130_fd_pr__nfet_01v8 L=0.6 W=1.4 NF=1 AD=0.406 AS=0.406 PD=3.38 PS=3.38 NRD=0.207143 NRS=0.207143 SA=0 SB=0 SD=0 MULT=50 M=50
Rpar_s1_XX1_M2_s s1r_XX1_M2_s bias_d 2.94414
XX1_M3 s1r_XX1_M3_d x1_m2d s1r_XX1_M3_s VSS sky130_fd_pr__nfet_01v8 L=0.6 W=1.4 NF=1 AD=0.406 AS=0.406 PD=3.38 PS=3.38 NRD=0.207143 NRS=0.207143 SA=0 SB=0 SD=0 MULT=2 M=2
Rpar_s1_XX1_M3_s s1r_XX1_M3_s bias_a 0.944263
Rpar_s1_XX1_M3_d s1r_XX1_M3_d bias_d 6.93029
XX1_M4 s1r_XX1_M4_d bias_d x1_m5d VSS sky130_fd_pr__nfet_01v8 L=0.6 W=1.4 NF=1 AD=0.406 AS=0.406 PD=3.38 PS=3.38 NRD=0.207143 NRS=0.207143 SA=0 SB=0 SD=0 MULT=18 M=18
Rpar_s1_XX1_M4_d s1r_XX1_M4_d bias_a 242.172
XX1_M5 x1_m5d bias_a VSS VSS sky130_fd_pr__nfet_01v8 L=0.6 W=1.4 NF=1 AD=0.406 AS=0.406 PD=3.38 PS=3.38 NRD=0.207143 NRS=0.207143 SA=0 SB=0 SD=0 MULT=18 M=18
XX1_M6 bias_c i_bias s1r_XX1_M6_s VSS sky130_fd_pr__nfet_01v8 L=0.6 W=1.4 NF=1 AD=0.406 AS=0.406 PD=3.38 PS=3.38 NRD=0.207143 NRS=0.207143 SA=0 SB=0 SD=0 MULT=18 M=18
Rpar_s1_XX1_M6_s s1r_XX1_M6_s VSS 5.41199
XX1_M7 i_bias i_bias s1r_XX1_M7_s VSS sky130_fd_pr__nfet_01v8 L=0.6 W=1.4 NF=1 AD=0.406 AS=0.406 PD=3.38 PS=3.38 NRD=0.207143 NRS=0.207143 SA=0 SB=0 SD=0 MULT=18 M=18
Rpar_s1_XX1_M7_s s1r_XX1_M7_s VSS 5.41199
XX1_M33 cm cm x1_net1 VSS sky130_fd_pr__nfet_01v8 L=0.6 W=1.4 NF=1 AD=0.406 AS=0.406 PD=3.38 PS=3.38 NRD=0.207143 NRS=0.207143 SA=0 SB=0 SD=0 MULT=1 M=1
XX1_M49 x1_net1 cm x1_net2 VSS sky130_fd_pr__nfet_01v8 L=0.6 W=1.4 NF=1 AD=0.406 AS=0.406 PD=3.38 PS=3.38 NRD=0.207143 NRS=0.207143 SA=0 SB=0 SD=0 MULT=1 M=1
XX1_M50 x1_net2 cm x1_net3 VSS sky130_fd_pr__nfet_01v8 L=0.6 W=1.4 NF=1 AD=0.406 AS=0.406 PD=3.38 PS=3.38 NRD=0.207143 NRS=0.207143 SA=0 SB=0 SD=0 MULT=1 M=1
XX1_M63 x1_net3 cm VSS VSS sky130_fd_pr__nfet_01v8 L=0.6 W=1.4 NF=1 AD=0.406 AS=0.406 PD=3.38 PS=3.38 NRD=0.207143 NRS=0.207143 SA=0 SB=0 SD=0 MULT=1 M=1
XX1_M68 cm cm x1_net4 VSS sky130_fd_pr__nfet_01v8 L=0.6 W=1.4 NF=1 AD=0.406 AS=0.406 PD=3.38 PS=3.38 NRD=0.207143 NRS=0.207143 SA=0 SB=0 SD=0 MULT=1 M=1
XX1_M69 x1_net4 cm x1_net5 VSS sky130_fd_pr__nfet_01v8 L=0.6 W=1.4 NF=1 AD=0.406 AS=0.406 PD=3.38 PS=3.38 NRD=0.207143 NRS=0.207143 SA=0 SB=0 SD=0 MULT=1 M=1
XX1_M70 x1_net5 cm x1_net6 VSS sky130_fd_pr__nfet_01v8 L=0.6 W=1.4 NF=1 AD=0.406 AS=0.406 PD=3.38 PS=3.38 NRD=0.207143 NRS=0.207143 SA=0 SB=0 SD=0 MULT=1 M=1
XX1_M71 x1_net6 cm VSS VSS sky130_fd_pr__nfet_01v8 L=0.6 W=1.4 NF=1 AD=0.406 AS=0.406 PD=3.38 PS=3.38 NRD=0.207143 NRS=0.207143 SA=0 SB=0 SD=0 MULT=1 M=1
XX1_M72 cm cm x1_net7 VSS sky130_fd_pr__nfet_01v8 L=0.6 W=1.4 NF=1 AD=0.406 AS=0.406 PD=3.38 PS=3.38 NRD=0.207143 NRS=0.207143 SA=0 SB=0 SD=0 MULT=1 M=1
XX1_M73 x1_net7 cm x1_net8 VSS sky130_fd_pr__nfet_01v8 L=0.6 W=1.4 NF=1 AD=0.406 AS=0.406 PD=3.38 PS=3.38 NRD=0.207143 NRS=0.207143 SA=0 SB=0 SD=0 MULT=1 M=1
XX1_M74 x1_net8 cm x1_net9 VSS sky130_fd_pr__nfet_01v8 L=0.6 W=1.4 NF=1 AD=0.406 AS=0.406 PD=3.38 PS=3.38 NRD=0.207143 NRS=0.207143 SA=0 SB=0 SD=0 MULT=1 M=1
XX1_M75 x1_net9 cm VSS VSS sky130_fd_pr__nfet_01v8 L=0.6 W=1.4 NF=1 AD=0.406 AS=0.406 PD=3.38 PS=3.38 NRD=0.207143 NRS=0.207143 SA=0 SB=0 SD=0 MULT=1 M=1
XX1_M76 cm cm x1_net10 VSS sky130_fd_pr__nfet_01v8 L=0.6 W=1.4 NF=1 AD=0.406 AS=0.406 PD=3.38 PS=3.38 NRD=0.207143 NRS=0.207143 SA=0 SB=0 SD=0 MULT=1 M=1
XX1_M77 x1_net10 cm x1_net11 VSS sky130_fd_pr__nfet_01v8 L=0.6 W=1.4 NF=1 AD=0.406 AS=0.406 PD=3.38 PS=3.38 NRD=0.207143 NRS=0.207143 SA=0 SB=0 SD=0 MULT=1 M=1
XX1_M78 x1_net11 cm x1_net12 VSS sky130_fd_pr__nfet_01v8 L=0.6 W=1.4 NF=1 AD=0.406 AS=0.406 PD=3.38 PS=3.38 NRD=0.207143 NRS=0.207143 SA=0 SB=0 SD=0 MULT=1 M=1
XX1_M79 x1_net12 cm VSS VSS sky130_fd_pr__nfet_01v8 L=0.6 W=1.4 NF=1 AD=0.406 AS=0.406 PD=3.38 PS=3.38 NRD=0.207143 NRS=0.207143 SA=0 SB=0 SD=0 MULT=1 M=1
XX1_M64 cm cm x1_net13 VSS sky130_fd_pr__nfet_01v8 L=0.6 W=1.4 NF=1 AD=0.406 AS=0.406 PD=3.38 PS=3.38 NRD=0.207143 NRS=0.207143 SA=0 SB=0 SD=0 MULT=1 M=1
XX1_M65 x1_net13 cm x1_net14 VSS sky130_fd_pr__nfet_01v8 L=0.6 W=1.4 NF=1 AD=0.406 AS=0.406 PD=3.38 PS=3.38 NRD=0.207143 NRS=0.207143 SA=0 SB=0 SD=0 MULT=1 M=1
XX1_M66 x1_net14 cm x1_net15 VSS sky130_fd_pr__nfet_01v8 L=0.6 W=1.4 NF=1 AD=0.406 AS=0.406 PD=3.38 PS=3.38 NRD=0.207143 NRS=0.207143 SA=0 SB=0 SD=0 MULT=1 M=1
XX1_M67 x1_net15 cm VSS VSS sky130_fd_pr__nfet_01v8 L=0.6 W=1.4 NF=1 AD=0.406 AS=0.406 PD=3.38 PS=3.38 NRD=0.207143 NRS=0.207143 SA=0 SB=0 SD=0 MULT=1 M=1
XX1_M57 bias_b VDD VDD VDD sky130_fd_pr__pfet_01v8 L=0.6 W=1.4 NF=1 AD=0.406 AS=0.406 PD=3.38 PS=3.38 NRD=0.207143 NRS=0.207143 SA=0 SB=0 SD=0 MULT=2 M=2
XX1_M58 x1_m2d VDD VDD VDD sky130_fd_pr__pfet_01v8 L=0.6 W=1.4 NF=1 AD=0.406 AS=0.406 PD=3.38 PS=3.38 NRD=0.207143 NRS=0.207143 SA=0 SB=0 SD=0 MULT=2 M=2
XX1_M59 cm VDD VDD VDD sky130_fd_pr__pfet_01v8 L=0.6 W=1.4 NF=1 AD=0.406 AS=0.406 PD=3.38 PS=3.38 NRD=0.207143 NRS=0.207143 SA=0 SB=0 SD=0 MULT=2 M=2
XX1_M60 x1_m31d VDD VDD VDD sky130_fd_pr__pfet_01v8 L=0.6 W=1.4 NF=1 AD=0.406 AS=0.406 PD=3.38 PS=3.38 NRD=0.207143 NRS=0.207143 SA=0 SB=0 SD=0 MULT=2 M=2
XX1_M42 x1_m5d VSS VSS VSS sky130_fd_pr__nfet_01v8 L=0.6 W=1.4 NF=1 AD=0.406 AS=0.406 PD=3.38 PS=3.38 NRD=0.207143 NRS=0.207143 SA=0 SB=0 SD=0 MULT=6 M=6
XX1_M44 bias_c bias_c bias_c VSS sky130_fd_pr__nfet_01v8 L=0.6 W=1.4 NF=1 AD=0.406 AS=0.406 PD=3.38 PS=3.38 NRD=0.207143 NRS=0.207143 SA=0 SB=0 SD=0 MULT=2 M=2
XX1_M34 bias_d bias_d bias_d VSS sky130_fd_pr__nfet_01v8 L=0.6 W=1.4 NF=1 AD=0.406 AS=0.406 PD=3.38 PS=3.38 NRD=0.207143 NRS=0.207143 SA=0 SB=0 SD=0 MULT=8 M=8
XX1_M35 x1_m2d x1_m2d x1_m2d VSS sky130_fd_pr__nfet_01v8 L=0.6 W=1.4 NF=1 AD=0.406 AS=0.406 PD=3.38 PS=3.38 NRD=0.207143 NRS=0.207143 SA=0 SB=0 SD=0 MULT=2 M=2
XX1_M36 bias_a bias_a bias_a VSS sky130_fd_pr__nfet_01v8 L=0.6 W=1.4 NF=1 AD=0.406 AS=0.406 PD=3.38 PS=3.38 NRD=0.207143 NRS=0.207143 SA=0 SB=0 SD=0 MULT=4 M=4
XX1_M37 cm cm cm VSS sky130_fd_pr__nfet_01v8 L=0.6 W=1.4 NF=1 AD=0.406 AS=0.406 PD=3.38 PS=3.38 NRD=0.207143 NRS=0.207143 SA=0 SB=0 SD=0 MULT=8 M=8
XX1_M54 x1_m25d x1_m25d x1_m25d VDD sky130_fd_pr__pfet_01v8 L=0.6 W=1.4 NF=1 AD=0.406 AS=0.406 PD=3.38 PS=3.38 NRD=0.207143 NRS=0.207143 SA=0 SB=0 SD=0 MULT=2 M=2
XX1_M29 x1_m5d x1_m5d x1_m5d VSS sky130_fd_pr__nfet_01v8 L=0.6 W=1.4 NF=1 AD=0.406 AS=0.406 PD=3.38 PS=3.38 NRD=0.207143 NRS=0.207143 SA=0 SB=0 SD=0 MULT=6 M=6
XX1_M8 i_bias i_bias i_bias VSS sky130_fd_pr__nfet_01v8 L=0.6 W=1.4 NF=1 AD=0.406 AS=0.406 PD=3.38 PS=3.38 NRD=0.207143 NRS=0.207143 SA=0 SB=0 SD=0 MULT=2 M=2
XX1_M10 bias_c bias_c bias_c VSS sky130_fd_pr__nfet_01v8_lvt L=0.6 W=1.4 NF=1 AD=0.406 AS=0.406 PD=3.38 PS=3.38 NRD=0.207143 NRS=0.207143 SA=0 SB=0 SD=0 MULT=8 M=8
XX1_M27 bias_b bias_b bias_b VSS sky130_fd_pr__nfet_01v8_lvt L=0.6 W=1.4 NF=1 AD=0.406 AS=0.406 PD=3.38 PS=3.38 NRD=0.207143 NRS=0.207143 SA=0 SB=0 SD=0 MULT=8 M=8
XX1_M46 x1_m21d x1_m21d x1_m21d VDD sky130_fd_pr__pfet_01v8_lvt L=0.6 W=1.4 NF=1 AD=0.406 AS=0.406 PD=3.38 PS=3.38 NRD=0.207143 NRS=0.207143 SA=0 SB=0 SD=0 MULT=2 M=2
XX1_M47 x1_m25d x1_m25d x1_m25d VDD sky130_fd_pr__pfet_01v8_lvt L=0.6 W=1.4 NF=1 AD=0.406 AS=0.406 PD=3.38 PS=3.38 NRD=0.207143 NRS=0.207143 SA=0 SB=0 SD=0 MULT=2 M=2
XX1_M48 x1_m31d x1_m31d x1_m31d VDD sky130_fd_pr__pfet_01v8_lvt L=0.6 W=1.4 NF=1 AD=0.406 AS=0.406 PD=3.38 PS=3.38 NRD=0.207143 NRS=0.207143 SA=0 SB=0 SD=0 MULT=2 M=2
XX1_M51 x1_m21d x1_m21d x1_m21d VDD sky130_fd_pr__pfet_01v8 L=0.6 W=1.4 NF=1 AD=0.406 AS=0.406 PD=3.38 PS=3.38 NRD=0.207143 NRS=0.207143 SA=0 SB=0 SD=0 MULT=2 M=2
XX2_M1 x2_foldp s1r_XX2_M1_g x2_tail VSS sky130_fd_pr__nfet_01v8_lvt L=0.2 W=1.2 NF=1 AD=0.348 AS=0.348 PD=2.98 PS=2.98 NRD=0.241667 NRS=0.241667 SA=0 SB=0 SD=0 MULT=6 M=6
Rpar_s1_XX2_M1_g s1r_XX2_M1_g ip 0.289952
XX2_M2 x2_foldn s1r_XX2_M2_g x2_tail VSS sky130_fd_pr__nfet_01v8_lvt L=0.2 W=1.2 NF=1 AD=0.348 AS=0.348 PD=2.98 PS=2.98 NRD=0.241667 NRS=0.241667 SA=0 SB=0 SD=0 MULT=6 M=6
Rpar_s1_XX2_M2_g s1r_XX2_M2_g in 0.289952
XX2_M6 x2_tail cmc VSS VSS sky130_fd_pr__nfet_01v8 L=0.6 W=1.4 NF=1 AD=0.406 AS=0.406 PD=3.38 PS=3.38 NRD=0.207143 NRS=0.207143 SA=0 SB=0 SD=0 MULT=96 M=96
XX2_M5 x2_tail bias_a VSS VSS sky130_fd_pr__nfet_01v8 L=0.6 W=1.4 NF=1 AD=0.406 AS=0.406 PD=3.38 PS=3.38 NRD=0.207143 NRS=0.207143 SA=0 SB=0 SD=0 MULT=96 M=96
XX2_M11 x2_foldp s1r_XX2_M11_g s1r_XX2_M11_s VDD sky130_fd_pr__pfet_01v8_lvt L=0.6 W=1.4 NF=1 AD=0.406 AS=0.406 PD=3.38 PS=3.38 NRD=0.207143 NRS=0.207143 SA=0 SB=0 SD=0 MULT=24 M=24
Rpar_s1_XX2_M11_s s1r_XX2_M11_s VDD 0.0603401
Rpar_s1_XX2_M11_g s1r_XX2_M11_g bias_b 4.50473
XX2_M12 x2_foldn s1r_XX2_M12_g s1r_XX2_M12_s VDD sky130_fd_pr__pfet_01v8_lvt L=0.6 W=1.4 NF=1 AD=0.406 AS=0.406 PD=3.38 PS=3.38 NRD=0.207143 NRS=0.207143 SA=0 SB=0 SD=0 MULT=24 M=24
Rpar_s1_XX2_M12_s s1r_XX2_M12_s VDD 0.0604577
Rpar_s1_XX2_M12_g s1r_XX2_M12_g bias_b 4.5031
XX2_M1A s1r_XX2_M1A_d s1r_XX2_M1A_g x2_foldp VDD sky130_fd_pr__pfet_01v8 L=0.6 W=1.4 NF=1 AD=0.406 AS=0.406 PD=3.38 PS=3.38 NRD=0.207143 NRS=0.207143 SA=0 SB=0 SD=0 MULT=20 M=20
Rpar_s1_XX2_M1A_g s1r_XX2_M1A_g bias_c 0.324949
Rpar_s1_XX2_M1A_d s1r_XX2_M1A_d on 0.535579
XX2_M8 s1r_XX2_M8_d s1r_XX2_M8_g x2_foldn VDD sky130_fd_pr__pfet_01v8 L=0.6 W=1.4 NF=1 AD=0.406 AS=0.406 PD=3.38 PS=3.38 NRD=0.207143 NRS=0.207143 SA=0 SB=0 SD=0 MULT=20 M=20
Rpar_s1_XX2_M8_g s1r_XX2_M8_g bias_c 0.324947
Rpar_s1_XX2_M8_d s1r_XX2_M8_d op 0.535709
XX2_M3A on s1r_XX2_M3A_g s1r_XX2_M3A_s VSS sky130_fd_pr__nfet_01v8 L=0.6 W=1.4 NF=1 AD=0.406 AS=0.406 PD=3.38 PS=3.38 NRD=0.207143 NRS=0.207143 SA=0 SB=0 SD=0 MULT=36 M=36
Rpar_s1_XX2_M3A_s s1r_XX2_M3A_s x2_m3d 2.28018
Rpar_s1_XX2_M3A_g s1r_XX2_M3A_g bias_d 12.1732
XX2_M7 op s1r_XX2_M7_g s1r_XX2_M7_s VSS sky130_fd_pr__nfet_01v8 L=0.6 W=1.4 NF=1 AD=0.406 AS=0.406 PD=3.38 PS=3.38 NRD=0.207143 NRS=0.207143 SA=0 SB=0 SD=0 MULT=36 M=36
Rpar_s1_XX2_M7_s s1r_XX2_M7_s x2_m4d 2.28018
Rpar_s1_XX2_M7_g s1r_XX2_M7_g bias_d 12.1214
XX2_M3 s1r_XX2_M3_d bias_a s1r_XX2_M3_s VSS sky130_fd_pr__nfet_01v8 L=0.6 W=1.4 NF=1 AD=0.406 AS=0.406 PD=3.38 PS=3.38 NRD=0.207143 NRS=0.207143 SA=0 SB=0 SD=0 MULT=36 M=36
Rpar_s1_XX2_M3_s s1r_XX2_M3_s VSS 0.100067
Rpar_s1_XX2_M3_d s1r_XX2_M3_d x2_m3d 2.28018
XX2_M4 s1r_XX2_M4_d bias_a s1r_XX2_M4_s VSS sky130_fd_pr__nfet_01v8 L=0.6 W=1.4 NF=1 AD=0.406 AS=0.406 PD=3.38 PS=3.38 NRD=0.207143 NRS=0.207143 SA=0 SB=0 SD=0 MULT=36 M=36
Rpar_s1_XX2_M4_s s1r_XX2_M4_s VSS 0.10007
Rpar_s1_XX2_M4_d s1r_XX2_M4_d x2_m4d 2.28018
XX2_M82 x2_foldn x2_foldn x2_foldn VDD sky130_fd_pr__pfet_01v8 L=0.6 W=1.4 NF=1 AD=0.406 AS=0.406 PD=3.38 PS=3.38 NRD=0.207143 NRS=0.207143 SA=0 SB=0 SD=0 MULT=2 M=2
XX2_M83 x2_foldp x2_foldp x2_foldp VDD sky130_fd_pr__pfet_01v8 L=0.6 W=1.4 NF=1 AD=0.406 AS=0.406 PD=3.38 PS=3.38 NRD=0.207143 NRS=0.207143 SA=0 SB=0 SD=0 MULT=2 M=2
XX2_M55 x2_foldn VDD VDD VDD sky130_fd_pr__pfet_01v8 L=0.6 W=1.4 NF=1 AD=0.406 AS=0.406 PD=3.38 PS=3.38 NRD=0.207143 NRS=0.207143 SA=0 SB=0 SD=0 MULT=2 M=2
XX2_M56 op VDD VDD VDD sky130_fd_pr__pfet_01v8 L=0.6 W=1.4 NF=1 AD=0.406 AS=0.406 PD=3.38 PS=3.38 NRD=0.207143 NRS=0.207143 SA=0 SB=0 SD=0 MULT=4 M=4
XX2_M61 x2_foldp VDD VDD VDD sky130_fd_pr__pfet_01v8 L=0.6 W=1.4 NF=1 AD=0.406 AS=0.406 PD=3.38 PS=3.38 NRD=0.207143 NRS=0.207143 SA=0 SB=0 SD=0 MULT=2 M=2
XX2_M62 on VDD VDD VDD sky130_fd_pr__pfet_01v8 L=0.6 W=1.4 NF=1 AD=0.406 AS=0.406 PD=3.38 PS=3.38 NRD=0.207143 NRS=0.207143 SA=0 SB=0 SD=0 MULT=4 M=4
XX2_M40 x2_m4d VSS VSS VSS sky130_fd_pr__nfet_01v8 L=0.6 W=1.4 NF=1 AD=0.406 AS=0.406 PD=3.38 PS=3.38 NRD=0.207143 NRS=0.207143 SA=0 SB=0 SD=0 MULT=6 M=6
XX2_M41 x2_m3d VSS VSS VSS sky130_fd_pr__nfet_01v8 L=0.6 W=1.4 NF=1 AD=0.406 AS=0.406 PD=3.38 PS=3.38 NRD=0.207143 NRS=0.207143 SA=0 SB=0 SD=0 MULT=8 M=8
XX2_M38 op op op VSS sky130_fd_pr__nfet_01v8 L=0.6 W=1.4 NF=1 AD=0.406 AS=0.406 PD=3.38 PS=3.38 NRD=0.207143 NRS=0.207143 SA=0 SB=0 SD=0 MULT=2 M=2
XX2_M39 on on on VSS sky130_fd_pr__nfet_01v8 L=0.6 W=1.4 NF=1 AD=0.406 AS=0.406 PD=3.38 PS=3.38 NRD=0.207143 NRS=0.207143 SA=0 SB=0 SD=0 MULT=2 M=2
XX2_M30 x2_tail VSS VSS VSS sky130_fd_pr__nfet_01v8 L=0.6 W=1.4 NF=1 AD=0.406 AS=0.406 PD=3.38 PS=3.38 NRD=0.207143 NRS=0.207143 SA=0 SB=0 SD=0 MULT=2 M=2
XX2_M23 x2_foldp x2_foldp x2_foldp VSS sky130_fd_pr__nfet_01v8_lvt L=0.2 W=1.2 NF=1 AD=0.348 AS=0.348 PD=2.98 PS=2.98 NRD=0.241667 NRS=0.241667 SA=0 SB=0 SD=0 MULT=2 M=2
XX2_M24 x2_foldn x2_foldn x2_foldn VSS sky130_fd_pr__nfet_01v8_lvt L=0.2 W=1.2 NF=1 AD=0.348 AS=0.348 PD=2.98 PS=2.98 NRD=0.241667 NRS=0.241667 SA=0 SB=0 SD=0 MULT=2 M=2
XX2_M80 op VSS VSS VSS sky130_fd_pr__nfet_01v8 L=0.6 W=1.4 NF=1 AD=0.406 AS=0.406 PD=3.38 PS=3.38 NRD=0.207143 NRS=0.207143 SA=0 SB=0 SD=0 MULT=2 M=2
XX2_M81 on VSS VSS VSS sky130_fd_pr__nfet_01v8 L=0.6 W=1.4 NF=1 AD=0.406 AS=0.406 PD=3.38 PS=3.38 NRD=0.207143 NRS=0.207143 SA=0 SB=0 SD=0 MULT=2 M=2
XX2_M28 x2_tail x2_tail x2_tail VSS sky130_fd_pr__nfet_01v8 L=0.6 W=1.4 NF=1 AD=0.406 AS=0.406 PD=3.38 PS=3.38 NRD=0.207143 NRS=0.207143 SA=0 SB=0 SD=0 MULT=6 M=6
XM43 VDD VDD VDD VDD sky130_fd_pr__pfet_01v8_lvt L=0.6 W=1.4 NF=1 AD=0.406 AS=0.406 PD=3.38 PS=3.38 NRD=0.207143 NRS=0.207143 SA=0 SB=0 SD=0 MULT=8 M=8
XM45 VDD VDD VDD VDD sky130_fd_pr__pfet_01v8 L=0.6 W=1.4 NF=1 AD=0.406 AS=0.406 PD=3.38 PS=3.38 NRD=0.207143 NRS=0.207143 SA=0 SB=0 SD=0 MULT=6 M=6
XM9 VSS VSS VSS VSS sky130_fd_pr__nfet_01v8 L=0.6 W=1.4 NF=1 AD=0.406 AS=0.406 PD=3.38 PS=3.38 NRD=0.207143 NRS=0.207143 SA=0 SB=0 SD=0 MULT=23 M=23
Ibias_ext VDD i_bias 3e-05
XC3 op cmc sky130_fd_pr__cap_mim_m3_1 W=4.8 L=4.8 MF=4 M=4
XC4 on cmc sky130_fd_pr__cap_mim_m3_1 W=4.8 L=4.8 MF=4 M=4
.ends iadc_ota
.end
