* iadc_ota on dido_amp_AC
.lib $PDK_ROOT/sky130A/libs.tech/combined/sky130.lib.spice tt
.param VDD_V=1.8 VCM_V=0.9 CL_F=0.3p
.temp 27

**.subckt dido_amp_AC
x1 INP INN OUTN VDD 0 OUTP dut_amp
Vsup VDD 0 'VDD_V'
* AC drive through 1 F couplers; DC set by unity feedback through 1 GH chokes (OUTP->INN, OUTN->INP)
Vacp ACP 0 dc 0 ac 0.5
Vacn ACN 0 dc 0 ac -0.5
Cinp ACP INP 1
Cinn ACN INN 1
Lfbp OUTP INN 1G
Lfbn OUTN INP 1G
Cloadp OUTP 0 'CL_F'
Cloadn OUTN 0 'CL_F'
.control
  save all
  ac dec 40 1 1G
  let hsig = v(OUTP) - v(OUTN)
  let hdb = db(hsig)
  let gph_deg = 180/pi * cph(hsig)
  meas ac gain_db find hdb at=1
  meas ac gbw_hz  when hdb=0
  meas ac ph_dc   find gph_deg at=1
  meas ac ph_ugb  find gph_deg when hdb=0
  let gbw_mhz = gbw_hz / 1e6
  let pm_deg  = 180 + (ph_ugb - ph_dc)
  echo MEAS gain_db $&gain_db
  echo MEAS gbw_mhz $&gbw_mhz
  echo MEAS pm_deg $&pm_deg
  write
  quit 0
.endc
**.ends

.subckt dut_amp INP INN OUTN VDD VSS OUTP
XDUT INP INN OUTP OUTN VDD VSS cmc_w cm_w bias_a_w iadc_ota
* ideal CMFB: the steady-state law of the upstream switched-capacitor CMFB (ASSUMPTION)
Bcmfb cmc_w VSS V = v(bias_a_w) + (v(OUTP) + v(OUTN))/2 - v(cm_w)
.ends

.subckt iadc_ota ip in op on VDD VSS cmc cm bias_a
Cbud_s2_0 on VSS 0.0109731f
Cbud_s2_1 op VSS 0.0109701f
Cbud_s2_2 bias_a on 0.0110021f
Cbud_s2_3 bias_a op 0.0109413f
Cbud_s2_4 bias_b on 0.0109719f
Cbud_s2_5 bias_b op 0.0109713f
Cbud_s2_6 bias_c on 0.0109718f
Cbud_s2_7 bias_c op 0.0109713f
Cbud_s2_8 bias_d on 0.0109116f
Cbud_s2_9 bias_d op 0.0110319f
Cbud_s2_10 cm on 0.0109731f
Cbud_s2_11 cm op 0.0109701f
Cbud_s2_12 i_bias on 0.010975f
Cbud_s2_13 i_bias op 0.0109682f
Cbud_s2_14 on op 0.00274289f
Cbud_s2_15 on x1_m21d 0.0109724f
Cbud_s2_16 on x1_m25d 0.0109602f
Cbud_s2_17 on x1_m2d 0.0109518f
Cbud_s2_18 on x1_m31d 0.0109734f
Cbud_s2_19 on x1_m5d 0.0109779f
Cbud_s2_20 on x1_net1 0.0109751f
Cbud_s2_21 on x1_net10 0.0109751f
Cbud_s2_22 on x1_net11 0.0109747f
Cbud_s2_23 on x1_net12 0.0109737f
Cbud_s2_24 on x1_net13 0.0109751f
Cbud_s2_25 on x1_net14 0.0109747f
Cbud_s2_26 on x1_net15 0.0109737f
Cbud_s2_27 on x1_net2 0.0109747f
Cbud_s2_28 on x1_net3 0.0109737f
Cbud_s2_29 on x1_net4 0.0109751f
Cbud_s2_30 on x1_net5 0.0109747f
Cbud_s2_31 on x1_net6 0.0109737f
Cbud_s2_32 on x1_net7 0.0109751f
Cbud_s2_33 on x1_net8 0.0109747f
Cbud_s2_34 on x1_net9 0.0109737f
Cbud_s2_35 on x2_foldn 0.00192177f
Cbud_s2_36 on x2_foldp 0.0121817f
Cbud_s2_37 on x2_m4d 0.00608139f
Cbud_s2_38 on x2_tail 0.0109731f
Cbud_s2_39 on ip 0.011829f
Cbud_s2_40 on in 0.00849399f
Cbud_s2_41 op x1_m21d 0.010971f
Cbud_s2_42 op x1_m25d 0.0109831f
Cbud_s2_43 op x1_m2d 0.0109913f
Cbud_s2_44 op x1_m31d 0.01097f
Cbud_s2_45 op x1_m5d 0.0109656f
Cbud_s2_46 op x1_net1 0.0109721f
Cbud_s2_47 op x1_net10 0.0109721f
Cbud_s2_48 op x1_net11 0.0109717f
Cbud_s2_49 op x1_net12 0.0109707f
Cbud_s2_50 op x1_net13 0.0109721f
Cbud_s2_51 op x1_net14 0.0109717f
Cbud_s2_52 op x1_net15 0.0109707f
Cbud_s2_53 op x1_net2 0.0109717f
Cbud_s2_54 op x1_net3 0.0109707f
Cbud_s2_55 op x1_net4 0.0109721f
Cbud_s2_56 op x1_net5 0.0109717f
Cbud_s2_57 op x1_net6 0.0109707f
Cbud_s2_58 op x1_net7 0.0109721f
Cbud_s2_59 op x1_net8 0.0109717f
Cbud_s2_60 op x1_net9 0.0109707f
Cbud_s2_61 op x2_foldn 0.0121793f
Cbud_s2_62 op x2_foldp 0.0019218f
Cbud_s2_63 op x2_m3d 0.00609904f
Cbud_s2_64 op x2_tail 0.0109702f
Cbud_s2_65 op ip 0.00849218f
Cbud_s2_66 op in 0.0118311f
XX1_M22 s1r_XX1_M22_d bias_c s1r_XX1_M22_s VDD sky130_fd_pr__pfet_01v8 L=0.6 W=1.4 NF=1 AD=0.406 AS=0.406 PD=3.38 PS=3.38 NRD=0.207143 NRS=0.207143 SA=0 SB=0 SD=0 MULT=6 M=6
Rpar_s1_XX1_M22_s s1r_XX1_M22_s x1_m21d 0.549657
Rpar_s1_XX1_M22_d s1r_XX1_M22_d bias_b 34.9282
XX1_M26 x1_m2d bias_c x1_m25d VDD sky130_fd_pr__pfet_01v8 L=0.6 W=1.4 NF=1 AD=0.406 AS=0.406 PD=3.38 PS=3.38 NRD=0.207143 NRS=0.207143 SA=0 SB=0 SD=0 MULT=6 M=6
XX1_M32 s1r_XX1_M32_d bias_c x1_m31d VDD sky130_fd_pr__pfet_01v8 L=0.6 W=1.4 NF=1 AD=0.406 AS=0.406 PD=3.38 PS=3.38 NRD=0.207143 NRS=0.207143 SA=0 SB=0 SD=0 MULT=6 M=6
Rpar_s1_XX1_M32_d s1r_XX1_M32_d cm 194.9
XX1_M21 s1r_XX1_M21_d bias_b s1r_XX1_M21_s VDD sky130_fd_pr__pfet_01v8_lvt L=0.6 W=1.4 NF=1 AD=0.406 AS=0.406 PD=3.38 PS=3.38 NRD=0.207143 NRS=0.207143 SA=0 SB=0 SD=0 MULT=6 M=6
Rpar_s1_XX1_M21_s s1r_XX1_M21_s VDD 0.306022
Rpar_s1_XX1_M21_d s1r_XX1_M21_d x1_m21d 0.549657
XX1_M25 x1_m25d bias_b VDD VDD sky130_fd_pr__pfet_01v8_lvt L=0.6 W=1.4 NF=1 AD=0.406 AS=0.406 PD=3.38 PS=3.38 NRD=0.207143 NRS=0.207143 SA=0 SB=0 SD=0 MULT=6 M=6
XX1_M31 x1_m31d bias_b VDD VDD sky130_fd_pr__pfet_01v8_lvt L=0.6 W=1.4 NF=1 AD=0.406 AS=0.406 PD=3.38 PS=3.38 NRD=0.207143 NRS=0.207143 SA=0 SB=0 SD=0 MULT=6 M=6
XX1_M1 bias_b bias_b bias_c VSS sky130_fd_pr__nfet_01v8_lvt L=0.6 W=1.4 NF=1 AD=0.406 AS=0.406 PD=3.38 PS=3.38 NRD=0.207143 NRS=0.207143 SA=0 SB=0 SD=0 MULT=56 M=56
XX1_M2 x1_m2d x1_m2d s1r_XX1_M2_s VSS sky130_fd_pr__nfet_01v8 L=0.6 W=1.4 NF=1 AD=0.406 AS=0.406 PD=3.38 PS=3.38 NRD=0.207143 NRS=0.207143 SA=0 SB=0 SD=0 MULT=50 M=50
Rpar_s1_XX1_M2_s s1r_XX1_M2_s bias_d 2.94414
XX1_M3 bias_d x1_m2d bias_a VSS sky130_fd_pr__nfet_01v8 L=0.6 W=1.4 NF=1 AD=0.406 AS=0.406 PD=3.38 PS=3.38 NRD=0.207143 NRS=0.207143 SA=0 SB=0 SD=0 MULT=2 M=2
XX1_M4 bias_a bias_d s1r_XX1_M4_s VSS sky130_fd_pr__nfet_01v8 L=0.6 W=1.4 NF=1 AD=0.406 AS=0.406 PD=3.38 PS=3.38 NRD=0.207143 NRS=0.207143 SA=0 SB=0 SD=0 MULT=18 M=18
Rpar_s1_XX1_M4_s s1r_XX1_M4_s x1_m5d 2.7641
XX1_M5 s1r_XX1_M5_d bias_a s1r_XX1_M5_s VSS sky130_fd_pr__nfet_01v8 L=0.6 W=1.4 NF=1 AD=0.406 AS=0.406 PD=3.38 PS=3.38 NRD=0.207143 NRS=0.207143 SA=0 SB=0 SD=0 MULT=18 M=18
Rpar_s1_XX1_M5_s s1r_XX1_M5_s VSS 0.0674882
Rpar_s1_XX1_M5_d s1r_XX1_M5_d x1_m5d 2.7641
XX1_M6 s1r_XX1_M6_d i_bias s1r_XX1_M6_s VSS sky130_fd_pr__nfet_01v8 L=0.6 W=1.4 NF=1 AD=0.406 AS=0.406 PD=3.38 PS=3.38 NRD=0.207143 NRS=0.207143 SA=0 SB=0 SD=0 MULT=18 M=18
Rpar_s1_XX1_M6_s s1r_XX1_M6_s VSS 5.41199
Rpar_s1_XX1_M6_d s1r_XX1_M6_d bias_c 12.609
XX1_M7 s1r_XX1_M7_d i_bias s1r_XX1_M7_s VSS sky130_fd_pr__nfet_01v8 L=0.6 W=1.4 NF=1 AD=0.406 AS=0.406 PD=3.38 PS=3.38 NRD=0.207143 NRS=0.207143 SA=0 SB=0 SD=0 MULT=18 M=18
Rpar_s1_XX1_M7_s s1r_XX1_M7_s VSS 5.41199
Rpar_s1_XX1_M7_d s1r_XX1_M7_d i_bias 12.609
XX1_M33 cm cm s1r_XX1_M33_s VSS sky130_fd_pr__nfet_01v8 L=0.6 W=1.4 NF=1 AD=0.406 AS=0.406 PD=3.38 PS=3.38 NRD=0.207143 NRS=0.207143 SA=0 SB=0 SD=0 MULT=1 M=1
Rpar_s1_XX1_M33_s s1r_XX1_M33_s x1_net1 40.4432
XX1_M49 s1r_XX1_M49_d cm s1r_XX1_M49_s VSS sky130_fd_pr__nfet_01v8 L=0.6 W=1.4 NF=1 AD=0.406 AS=0.406 PD=3.38 PS=3.38 NRD=0.207143 NRS=0.207143 SA=0 SB=0 SD=0 MULT=1 M=1
Rpar_s1_XX1_M49_s s1r_XX1_M49_s x1_net2 18.742
Rpar_s1_XX1_M49_d s1r_XX1_M49_d x1_net1 40.4432
XX1_M50 s1r_XX1_M50_d cm s1r_XX1_M50_s VSS sky130_fd_pr__nfet_01v8 L=0.6 W=1.4 NF=1 AD=0.406 AS=0.406 PD=3.38 PS=3.38 NRD=0.207143 NRS=0.207143 SA=0 SB=0 SD=0 MULT=1 M=1
Rpar_s1_XX1_M50_s s1r_XX1_M50_s x1_net3 19.7031
Rpar_s1_XX1_M50_d s1r_XX1_M50_d x1_net2 18.742
XX1_M63 s1r_XX1_M63_d cm s1r_XX1_M63_s VSS sky130_fd_pr__nfet_01v8 L=0.6 W=1.4 NF=1 AD=0.406 AS=0.406 PD=3.38 PS=3.38 NRD=0.207143 NRS=0.207143 SA=0 SB=0 SD=0 MULT=1 M=1
Rpar_s1_XX1_M63_s s1r_XX1_M63_s VSS 12.3939
Rpar_s1_XX1_M63_d s1r_XX1_M63_d x1_net3 19.7031
XX1_M68 cm cm s1r_XX1_M68_s VSS sky130_fd_pr__nfet_01v8 L=0.6 W=1.4 NF=1 AD=0.406 AS=0.406 PD=3.38 PS=3.38 NRD=0.207143 NRS=0.207143 SA=0 SB=0 SD=0 MULT=1 M=1
Rpar_s1_XX1_M68_s s1r_XX1_M68_s x1_net4 40.4432
XX1_M69 s1r_XX1_M69_d cm s1r_XX1_M69_s VSS sky130_fd_pr__nfet_01v8 L=0.6 W=1.4 NF=1 AD=0.406 AS=0.406 PD=3.38 PS=3.38 NRD=0.207143 NRS=0.207143 SA=0 SB=0 SD=0 MULT=1 M=1
Rpar_s1_XX1_M69_s s1r_XX1_M69_s x1_net5 18.742
Rpar_s1_XX1_M69_d s1r_XX1_M69_d x1_net4 40.4432
XX1_M70 s1r_XX1_M70_d cm s1r_XX1_M70_s VSS sky130_fd_pr__nfet_01v8 L=0.6 W=1.4 NF=1 AD=0.406 AS=0.406 PD=3.38 PS=3.38 NRD=0.207143 NRS=0.207143 SA=0 SB=0 SD=0 MULT=1 M=1
Rpar_s1_XX1_M70_s s1r_XX1_M70_s x1_net6 19.7031
Rpar_s1_XX1_M70_d s1r_XX1_M70_d x1_net5 18.742
XX1_M71 s1r_XX1_M71_d cm s1r_XX1_M71_s VSS sky130_fd_pr__nfet_01v8 L=0.6 W=1.4 NF=1 AD=0.406 AS=0.406 PD=3.38 PS=3.38 NRD=0.207143 NRS=0.207143 SA=0 SB=0 SD=0 MULT=1 M=1
Rpar_s1_XX1_M71_s s1r_XX1_M71_s VSS 12.3939
Rpar_s1_XX1_M71_d s1r_XX1_M71_d x1_net6 19.7031
XX1_M72 cm cm s1r_XX1_M72_s VSS sky130_fd_pr__nfet_01v8 L=0.6 W=1.4 NF=1 AD=0.406 AS=0.406 PD=3.38 PS=3.38 NRD=0.207143 NRS=0.207143 SA=0 SB=0 SD=0 MULT=1 M=1
Rpar_s1_XX1_M72_s s1r_XX1_M72_s x1_net7 40.4432
XX1_M73 s1r_XX1_M73_d cm s1r_XX1_M73_s VSS sky130_fd_pr__nfet_01v8 L=0.6 W=1.4 NF=1 AD=0.406 AS=0.406 PD=3.38 PS=3.38 NRD=0.207143 NRS=0.207143 SA=0 SB=0 SD=0 MULT=1 M=1
Rpar_s1_XX1_M73_s s1r_XX1_M73_s x1_net8 18.742
Rpar_s1_XX1_M73_d s1r_XX1_M73_d x1_net7 40.4432
XX1_M74 s1r_XX1_M74_d cm s1r_XX1_M74_s VSS sky130_fd_pr__nfet_01v8 L=0.6 W=1.4 NF=1 AD=0.406 AS=0.406 PD=3.38 PS=3.38 NRD=0.207143 NRS=0.207143 SA=0 SB=0 SD=0 MULT=1 M=1
Rpar_s1_XX1_M74_s s1r_XX1_M74_s x1_net9 19.7031
Rpar_s1_XX1_M74_d s1r_XX1_M74_d x1_net8 18.742
XX1_M75 s1r_XX1_M75_d cm s1r_XX1_M75_s VSS sky130_fd_pr__nfet_01v8 L=0.6 W=1.4 NF=1 AD=0.406 AS=0.406 PD=3.38 PS=3.38 NRD=0.207143 NRS=0.207143 SA=0 SB=0 SD=0 MULT=1 M=1
Rpar_s1_XX1_M75_s s1r_XX1_M75_s VSS 12.3939
Rpar_s1_XX1_M75_d s1r_XX1_M75_d x1_net9 19.7031
XX1_M76 cm cm s1r_XX1_M76_s VSS sky130_fd_pr__nfet_01v8 L=0.6 W=1.4 NF=1 AD=0.406 AS=0.406 PD=3.38 PS=3.38 NRD=0.207143 NRS=0.207143 SA=0 SB=0 SD=0 MULT=1 M=1
Rpar_s1_XX1_M76_s s1r_XX1_M76_s x1_net10 40.4432
XX1_M77 s1r_XX1_M77_d cm s1r_XX1_M77_s VSS sky130_fd_pr__nfet_01v8 L=0.6 W=1.4 NF=1 AD=0.406 AS=0.406 PD=3.38 PS=3.38 NRD=0.207143 NRS=0.207143 SA=0 SB=0 SD=0 MULT=1 M=1
Rpar_s1_XX1_M77_s s1r_XX1_M77_s x1_net11 18.742
Rpar_s1_XX1_M77_d s1r_XX1_M77_d x1_net10 40.4432
XX1_M78 s1r_XX1_M78_d cm s1r_XX1_M78_s VSS sky130_fd_pr__nfet_01v8 L=0.6 W=1.4 NF=1 AD=0.406 AS=0.406 PD=3.38 PS=3.38 NRD=0.207143 NRS=0.207143 SA=0 SB=0 SD=0 MULT=1 M=1
Rpar_s1_XX1_M78_s s1r_XX1_M78_s x1_net12 19.7031
Rpar_s1_XX1_M78_d s1r_XX1_M78_d x1_net11 18.742
XX1_M79 s1r_XX1_M79_d cm s1r_XX1_M79_s VSS sky130_fd_pr__nfet_01v8 L=0.6 W=1.4 NF=1 AD=0.406 AS=0.406 PD=3.38 PS=3.38 NRD=0.207143 NRS=0.207143 SA=0 SB=0 SD=0 MULT=1 M=1
Rpar_s1_XX1_M79_s s1r_XX1_M79_s VSS 12.3939
Rpar_s1_XX1_M79_d s1r_XX1_M79_d x1_net12 19.7031
XX1_M64 cm cm s1r_XX1_M64_s VSS sky130_fd_pr__nfet_01v8 L=0.6 W=1.4 NF=1 AD=0.406 AS=0.406 PD=3.38 PS=3.38 NRD=0.207143 NRS=0.207143 SA=0 SB=0 SD=0 MULT=1 M=1
Rpar_s1_XX1_M64_s s1r_XX1_M64_s x1_net13 40.4432
XX1_M65 s1r_XX1_M65_d cm s1r_XX1_M65_s VSS sky130_fd_pr__nfet_01v8 L=0.6 W=1.4 NF=1 AD=0.406 AS=0.406 PD=3.38 PS=3.38 NRD=0.207143 NRS=0.207143 SA=0 SB=0 SD=0 MULT=1 M=1
Rpar_s1_XX1_M65_s s1r_XX1_M65_s x1_net14 18.742
Rpar_s1_XX1_M65_d s1r_XX1_M65_d x1_net13 40.4432
XX1_M66 s1r_XX1_M66_d cm s1r_XX1_M66_s VSS sky130_fd_pr__nfet_01v8 L=0.6 W=1.4 NF=1 AD=0.406 AS=0.406 PD=3.38 PS=3.38 NRD=0.207143 NRS=0.207143 SA=0 SB=0 SD=0 MULT=1 M=1
Rpar_s1_XX1_M66_s s1r_XX1_M66_s x1_net15 19.7031
Rpar_s1_XX1_M66_d s1r_XX1_M66_d x1_net14 18.742
XX1_M67 s1r_XX1_M67_d cm s1r_XX1_M67_s VSS sky130_fd_pr__nfet_01v8 L=0.6 W=1.4 NF=1 AD=0.406 AS=0.406 PD=3.38 PS=3.38 NRD=0.207143 NRS=0.207143 SA=0 SB=0 SD=0 MULT=1 M=1
Rpar_s1_XX1_M67_s s1r_XX1_M67_s VSS 12.3939
Rpar_s1_XX1_M67_d s1r_XX1_M67_d x1_net15 19.7031
XX1_M57 bias_b VDD VDD VDD sky130_fd_pr__pfet_01v8 L=0.6 W=1.4 NF=1 AD=0.406 AS=0.406 PD=3.38 PS=3.38 NRD=0.207143 NRS=0.207143 SA=0 SB=0 SD=0 MULT=2 M=2
XX1_M58 x1_m2d VDD VDD VDD sky130_fd_pr__pfet_01v8 L=0.6 W=1.4 NF=1 AD=0.406 AS=0.406 PD=3.38 PS=3.38 NRD=0.207143 NRS=0.207143 SA=0 SB=0 SD=0 MULT=2 M=2
XX1_M59 cm VDD VDD VDD sky130_fd_pr__pfet_01v8 L=0.6 W=1.4 NF=1 AD=0.406 AS=0.406 PD=3.38 PS=3.38 NRD=0.207143 NRS=0.207143 SA=0 SB=0 SD=0 MULT=2 M=2
XX1_M60 x1_m31d VDD VDD VDD sky130_fd_pr__pfet_01v8 L=0.6 W=1.4 NF=1 AD=0.406 AS=0.406 PD=3.38 PS=3.38 NRD=0.207143 NRS=0.207143 SA=0 SB=0 SD=0 MULT=2 M=2
XX1_M42 x1_m5d VSS VSS VSS sky130_fd_pr__nfet_01v8 L=0.6 W=1.4 NF=1 AD=0.406 AS=0.406 PD=3.38 PS=3.38 NRD=0.207143 NRS=0.207143 SA=0 SB=0 SD=0 MULT=6 M=6
XX1_M44 bias_c bias_c bias_c VSS sky130_fd_pr__nfet_01v8 L=0.6 W=1.4 NF=1 AD=0.406 AS=0.406 PD=3.38 PS=3.38 NRD=0.207143 NRS=0.207143 SA=0 SB=0 SD=0 MULT=2 M=2
XX1_M34 bias_d bias_d bias_d VSS sky130_fd_pr__nfet_01v8 L=0.6 W=1.4 NF=1 AD=0.406 AS=0.406 PD=3.38 PS=3.38 NRD=0.207143 NRS=0.207143 SA=0 SB=0 SD=0 MULT=8 M=8
XX1_M35 x1_m2d x1_m2d x1_m2d VSS sky130_fd_pr__nfet_01v8 L=0.6 W=1.4 NF=1 AD=0.406 AS=0.406 PD=3.38 PS=3.38 NRD=0.207143 NRS=0.207143 SA=0 SB=0 SD=0 MULT=2 M=2
XX1_M36 bias_a bias_a bias_a VSS sky130_fd_pr__nfet_01v8 L=0.6 W=1.4 NF=1 AD=0.406 AS=0.406 PD=3.38 PS=3.38 NRD=0.207143 NRS=0.207143 SA=0 SB=0 SD=0 MULT=4 M=4
XX1_M37 cm cm cm VSS sky130_fd_pr__nfet_01v8 L=0.6 W=1.4 NF=1 AD=0.406 AS=0.406 PD=3.38 PS=3.38 NRD=0.207143 NRS=0.207143 SA=0 SB=0 SD=0 MULT=8 M=8
XX1_M54 x1_m25d x1_m25d x1_m25d VDD sky130_fd_pr__pfet_01v8 L=0.6 W=1.4 NF=1 AD=0.406 AS=0.406 PD=3.38 PS=3.38 NRD=0.207143 NRS=0.207143 SA=0 SB=0 SD=0 MULT=2 M=2
XX1_M29 x1_m5d x1_m5d x1_m5d VSS sky130_fd_pr__nfet_01v8 L=0.6 W=1.4 NF=1 AD=0.406 AS=0.406 PD=3.38 PS=3.38 NRD=0.207143 NRS=0.207143 SA=0 SB=0 SD=0 MULT=6 M=6
XX1_M8 i_bias i_bias i_bias VSS sky130_fd_pr__nfet_01v8 L=0.6 W=1.4 NF=1 AD=0.406 AS=0.406 PD=3.38 PS=3.38 NRD=0.207143 NRS=0.207143 SA=0 SB=0 SD=0 MULT=2 M=2
XX1_M10 bias_c bias_c bias_c VSS sky130_fd_pr__nfet_01v8_lvt L=0.6 W=1.4 NF=1 AD=0.406 AS=0.406 PD=3.38 PS=3.38 NRD=0.207143 NRS=0.207143 SA=0 SB=0 SD=0 MULT=8 M=8
XX1_M27 bias_b bias_b bias_b VSS sky130_fd_pr__nfet_01v8_lvt L=0.6 W=1.4 NF=1 AD=0.406 AS=0.406 PD=3.38 PS=3.38 NRD=0.207143 NRS=0.207143 SA=0 SB=0 SD=0 MULT=8 M=8
XX1_M46 x1_m21d x1_m21d x1_m21d VDD sky130_fd_pr__pfet_01v8_lvt L=0.6 W=1.4 NF=1 AD=0.406 AS=0.406 PD=3.38 PS=3.38 NRD=0.207143 NRS=0.207143 SA=0 SB=0 SD=0 MULT=2 M=2
XX1_M47 x1_m25d x1_m25d x1_m25d VDD sky130_fd_pr__pfet_01v8_lvt L=0.6 W=1.4 NF=1 AD=0.406 AS=0.406 PD=3.38 PS=3.38 NRD=0.207143 NRS=0.207143 SA=0 SB=0 SD=0 MULT=2 M=2
XX1_M48 x1_m31d x1_m31d x1_m31d VDD sky130_fd_pr__pfet_01v8_lvt L=0.6 W=1.4 NF=1 AD=0.406 AS=0.406 PD=3.38 PS=3.38 NRD=0.207143 NRS=0.207143 SA=0 SB=0 SD=0 MULT=2 M=2
XX1_M51 x1_m21d x1_m21d x1_m21d VDD sky130_fd_pr__pfet_01v8 L=0.6 W=1.4 NF=1 AD=0.406 AS=0.406 PD=3.38 PS=3.38 NRD=0.207143 NRS=0.207143 SA=0 SB=0 SD=0 MULT=2 M=2
XX2_M1 s1r_XX2_M1_d ip s1r_XX2_M1_s VSS sky130_fd_pr__nfet_01v8_lvt L=0.2 W=1.2 NF=1 AD=0.348 AS=0.348 PD=2.98 PS=2.98 NRD=0.241667 NRS=0.241667 SA=0 SB=0 SD=0 MULT=6 M=6
Rpar_s1_XX2_M1_s s1r_XX2_M1_s x2_tail 0.00713264
Rpar_s1_XX2_M1_d s1r_XX2_M1_d x2_foldp 0.322294
XX2_M2 s1r_XX2_M2_d in s1r_XX2_M2_s VSS sky130_fd_pr__nfet_01v8_lvt L=0.2 W=1.2 NF=1 AD=0.348 AS=0.348 PD=2.98 PS=2.98 NRD=0.241667 NRS=0.241667 SA=0 SB=0 SD=0 MULT=6 M=6
Rpar_s1_XX2_M2_s s1r_XX2_M2_s x2_tail 0.00713264
Rpar_s1_XX2_M2_d s1r_XX2_M2_d x2_foldn 0.322294
XX2_M6 s1r_XX2_M6_d cmc s1r_XX2_M6_s VSS sky130_fd_pr__nfet_01v8 L=0.6 W=1.4 NF=1 AD=0.406 AS=0.406 PD=3.38 PS=3.38 NRD=0.207143 NRS=0.207143 SA=0 SB=0 SD=0 MULT=96 M=96
Rpar_s1_XX2_M6_s s1r_XX2_M6_s VSS 0.152223
Rpar_s1_XX2_M6_d s1r_XX2_M6_d x2_tail 7.76183
XX2_M5 s1r_XX2_M5_d bias_a s1r_XX2_M5_s VSS sky130_fd_pr__nfet_01v8 L=0.6 W=1.4 NF=1 AD=0.406 AS=0.406 PD=3.38 PS=3.38 NRD=0.207143 NRS=0.207143 SA=0 SB=0 SD=0 MULT=96 M=96
Rpar_s1_XX2_M5_s s1r_XX2_M5_s VSS 0.139967
Rpar_s1_XX2_M5_d s1r_XX2_M5_d x2_tail 6.35059
XX2_M11 s1r_XX2_M11_d bias_b VDD VDD sky130_fd_pr__pfet_01v8_lvt L=0.6 W=1.4 NF=1 AD=0.406 AS=0.406 PD=3.38 PS=3.38 NRD=0.207143 NRS=0.207143 SA=0 SB=0 SD=0 MULT=24 M=24
Rpar_s1_XX2_M11_d s1r_XX2_M11_d x2_foldp 0.0388517
XX2_M12 s1r_XX2_M12_d bias_b VDD VDD sky130_fd_pr__pfet_01v8_lvt L=0.6 W=1.4 NF=1 AD=0.406 AS=0.406 PD=3.38 PS=3.38 NRD=0.207143 NRS=0.207143 SA=0 SB=0 SD=0 MULT=24 M=24
Rpar_s1_XX2_M12_d s1r_XX2_M12_d x2_foldn 0.0388537
XX2_M1A s1r_XX2_M1A_d bias_c s1r_XX2_M1A_s VDD sky130_fd_pr__pfet_01v8 L=0.6 W=1.4 NF=1 AD=0.406 AS=0.406 PD=3.38 PS=3.38 NRD=0.207143 NRS=0.207143 SA=0 SB=0 SD=0 MULT=20 M=20
Rpar_s1_XX2_M1A_s s1r_XX2_M1A_s x2_foldp 0.0564023
Rpar_s1_XX2_M1A_d s1r_XX2_M1A_d on 0.535579
XX2_M8 s1r_XX2_M8_d bias_c s1r_XX2_M8_s VDD sky130_fd_pr__pfet_01v8 L=0.6 W=1.4 NF=1 AD=0.406 AS=0.406 PD=3.38 PS=3.38 NRD=0.207143 NRS=0.207143 SA=0 SB=0 SD=0 MULT=20 M=20
Rpar_s1_XX2_M8_s s1r_XX2_M8_s x2_foldn 0.0563018
Rpar_s1_XX2_M8_d s1r_XX2_M8_d op 0.535709
XX2_M3A s1r_XX2_M3A_d bias_d s1r_XX2_M3A_s VSS sky130_fd_pr__nfet_01v8 L=0.6 W=1.4 NF=1 AD=0.406 AS=0.406 PD=3.38 PS=3.38 NRD=0.207143 NRS=0.207143 SA=0 SB=0 SD=0 MULT=36 M=36
Rpar_s1_XX2_M3A_s s1r_XX2_M3A_s x2_m3d 2.28018
Rpar_s1_XX2_M3A_d s1r_XX2_M3A_d on 19.2105
XX2_M7 s1r_XX2_M7_d bias_d s1r_XX2_M7_s VSS sky130_fd_pr__nfet_01v8 L=0.6 W=1.4 NF=1 AD=0.406 AS=0.406 PD=3.38 PS=3.38 NRD=0.207143 NRS=0.207143 SA=0 SB=0 SD=0 MULT=36 M=36
Rpar_s1_XX2_M7_s s1r_XX2_M7_s x2_m4d 2.28018
Rpar_s1_XX2_M7_d s1r_XX2_M7_d op 19.2105
XX2_M3 s1r_XX2_M3_d bias_a VSS VSS sky130_fd_pr__nfet_01v8 L=0.6 W=1.4 NF=1 AD=0.406 AS=0.406 PD=3.38 PS=3.38 NRD=0.207143 NRS=0.207143 SA=0 SB=0 SD=0 MULT=36 M=36
Rpar_s1_XX2_M3_d s1r_XX2_M3_d x2_m3d 2.28018
XX2_M4 s1r_XX2_M4_d bias_a VSS VSS sky130_fd_pr__nfet_01v8 L=0.6 W=1.4 NF=1 AD=0.406 AS=0.406 PD=3.38 PS=3.38 NRD=0.207143 NRS=0.207143 SA=0 SB=0 SD=0 MULT=36 M=36
Rpar_s1_XX2_M4_d s1r_XX2_M4_d x2_m4d 2.28018
XX2_M82 x2_foldn x2_foldn x2_foldn VDD sky130_fd_pr__pfet_01v8 L=0.6 W=1.4 NF=1 AD=0.406 AS=0.406 PD=3.38 PS=3.38 NRD=0.207143 NRS=0.207143 SA=0 SB=0 SD=0 MULT=2 M=2
XX2_M83 x2_foldp x2_foldp x2_foldp VDD sky130_fd_pr__pfet_01v8 L=0.6 W=1.4 NF=1 AD=0.406 AS=0.406 PD=3.38 PS=3.38 NRD=0.207143 NRS=0.207143 SA=0 SB=0 SD=0 MULT=2 M=2
XX2_M55 x2_foldn VDD VDD VDD sky130_fd_pr__pfet_01v8 L=0.6 W=1.4 NF=1 AD=0.406 AS=0.406 PD=3.38 PS=3.38 NRD=0.207143 NRS=0.207143 SA=0 SB=0 SD=0 MULT=2 M=2
XX2_M56 op VDD VDD VDD sky130_fd_pr__pfet_01v8 L=0.6 W=1.4 NF=1 AD=0.406 AS=0.406 PD=3.38 PS=3.38 NRD=0.207143 NRS=0.207143 SA=0 SB=0 SD=0 MULT=4 M=4
XX2_M61 x2_foldp VDD VDD VDD sky130_fd_pr__pfet_01v8 L=0.6 W=1.4 NF=1 AD=0.406 AS=0.406 PD=3.38 PS=3.38 NRD=0.207143 NRS=0.207143 SA=0 SB=0 SD=0 MULT=2 M=2
XX2_M62 on VDD VDD VDD sky130_fd_pr__pfet_01v8 L=0.6 W=1.4 NF=1 AD=0.406 AS=0.406 PD=3.38 PS=3.38 NRD=0.207143 NRS=0.207143 SA=0 SB=0 SD=0 MULT=4 M=4
XX2_M40 x2_m4d VSS VSS VSS sky130_fd_pr__nfet_01v8 L=0.6 W=1.4 NF=1 AD=0.406 AS=0.406 PD=3.38 PS=3.38 NRD=0.207143 NRS=0.207143 SA=0 SB=0 SD=0 MULT=6 M=6
XX2_M41 x2_m3d VSS VSS VSS sky130_fd_pr__nfet_01v8 L=0.6 W=1.4 NF=1 AD=0.406 AS=0.406 PD=3.38 PS=3.38 NRD=0.207143 NRS=0.207143 SA=0 SB=0 SD=0 MULT=8 M=8
XX2_M38 op op op VSS sky130_fd_pr__nfet_01v8 L=0.6 W=1.4 NF=1 AD=0.406 AS=0.406 PD=3.38 PS=3.38 NRD=0.207143 NRS=0.207143 SA=0 SB=0 SD=0 MULT=2 M=2
XX2_M39 on on on VSS sky130_fd_pr__nfet_01v8 L=0.6 W=1.4 NF=1 AD=0.406 AS=0.406 PD=3.38 PS=3.38 NRD=0.207143 NRS=0.207143 SA=0 SB=0 SD=0 MULT=2 M=2
XX2_M30 x2_tail VSS VSS VSS sky130_fd_pr__nfet_01v8 L=0.6 W=1.4 NF=1 AD=0.406 AS=0.406 PD=3.38 PS=3.38 NRD=0.207143 NRS=0.207143 SA=0 SB=0 SD=0 MULT=2 M=2
XX2_M23 x2_foldp x2_foldp x2_foldp VSS sky130_fd_pr__nfet_01v8_lvt L=0.2 W=1.2 NF=1 AD=0.348 AS=0.348 PD=2.98 PS=2.98 NRD=0.241667 NRS=0.241667 SA=0 SB=0 SD=0 MULT=2 M=2
XX2_M24 x2_foldn x2_foldn x2_foldn VSS sky130_fd_pr__nfet_01v8_lvt L=0.2 W=1.2 NF=1 AD=0.348 AS=0.348 PD=2.98 PS=2.98 NRD=0.241667 NRS=0.241667 SA=0 SB=0 SD=0 MULT=2 M=2
XX2_M80 op VSS VSS VSS sky130_fd_pr__nfet_01v8 L=0.6 W=1.4 NF=1 AD=0.406 AS=0.406 PD=3.38 PS=3.38 NRD=0.207143 NRS=0.207143 SA=0 SB=0 SD=0 MULT=2 M=2
XX2_M81 on VSS VSS VSS sky130_fd_pr__nfet_01v8 L=0.6 W=1.4 NF=1 AD=0.406 AS=0.406 PD=3.38 PS=3.38 NRD=0.207143 NRS=0.207143 SA=0 SB=0 SD=0 MULT=2 M=2
XX2_M28 x2_tail x2_tail x2_tail VSS sky130_fd_pr__nfet_01v8 L=0.6 W=1.4 NF=1 AD=0.406 AS=0.406 PD=3.38 PS=3.38 NRD=0.207143 NRS=0.207143 SA=0 SB=0 SD=0 MULT=6 M=6
XM43 VDD VDD VDD VDD sky130_fd_pr__pfet_01v8_lvt L=0.6 W=1.4 NF=1 AD=0.406 AS=0.406 PD=3.38 PS=3.38 NRD=0.207143 NRS=0.207143 SA=0 SB=0 SD=0 MULT=8 M=8
XM45 VDD VDD VDD VDD sky130_fd_pr__pfet_01v8 L=0.6 W=1.4 NF=1 AD=0.406 AS=0.406 PD=3.38 PS=3.38 NRD=0.207143 NRS=0.207143 SA=0 SB=0 SD=0 MULT=6 M=6
XM9 VSS VSS VSS VSS sky130_fd_pr__nfet_01v8 L=0.6 W=1.4 NF=1 AD=0.406 AS=0.406 PD=3.38 PS=3.38 NRD=0.207143 NRS=0.207143 SA=0 SB=0 SD=0 MULT=23 M=23
Ibias_ext VDD i_bias 3e-05
XC3 op cmc sky130_fd_pr__cap_mim_m3_1 W=4.8 L=4.8 MF=4 M=4
XC4 on cmc sky130_fd_pr__cap_mim_m3_1 W=4.8 L=4.8 MF=4 M=4
.ends iadc_ota
.end
