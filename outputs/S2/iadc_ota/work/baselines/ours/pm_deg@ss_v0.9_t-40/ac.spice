* iadc_ota on dido_amp_AC
.lib $PDK_ROOT/sky130A/libs.tech/combined/sky130.lib.spice ss
.param VDD_V=1.62 VCM_V=0.9 CL_F=0.3p
.temp -40

**.subckt dido_amp_AC
x1 INP INN OUTN VDD 0 OUTP dut_amp
Vsup VDD 0 'VDD_V'
* AC drive through 1 F couplers; DC set by unity feedback through 1 GH chokes (OUTP->INN, OUTN->INP)
Vacp ACP 0 dc 0 ac 0.5
Vacn ACN 0 dc 0 ac -0.5
Cinp ACP INP 1
Cinn ACN INN 1
Lfbp OUTP INN 1G
Lfbn OUTN INP 1G
Cloadp OUTP 0 'CL_F'
Cloadn OUTN 0 'CL_F'
.control
  save all
  ac dec 40 1 1G
  let hsig = v(OUTP) - v(OUTN)
  let hdb = db(hsig)
  let gph_deg = 180/pi * cph(hsig)
  meas ac gain_db find hdb at=1
  meas ac gbw_hz  when hdb=0
  meas ac ph_dc   find gph_deg at=1
  meas ac ph_ugb  find gph_deg when hdb=0
  let gbw_mhz = gbw_hz / 1e6
  let pm_deg  = 180 + (ph_ugb - ph_dc)
  echo MEAS gain_db $&gain_db
  echo MEAS gbw_mhz $&gbw_mhz
  echo MEAS pm_deg $&pm_deg
  write
  quit 0
.endc
**.ends

.subckt dut_amp INP INN OUTN VDD VSS OUTP
XDUT INP INN OUTP OUTN VDD VSS cmc_w cm_w bias_a_w iadc_ota
* ideal CMFB: the steady-state law of the upstream switched-capacitor CMFB (ASSUMPTION)
Bcmfb cmc_w VSS V = v(bias_a_w) + (v(OUTP) + v(OUTN))/2 - v(cm_w)
.ends

.subckt iadc_ota ip in op on VDD VSS cmc cm bias_a
Cbud_s2_0 bias_a VSS 1.87189f
Cbud_s2_1 bias_b VSS 1.52156f
Cbud_s2_2 bias_c VSS 1.02598f
Cbud_s2_3 x1_m21d VSS 0.146112f
Cbud_s2_4 x1_m31d VSS 0.119346f
Cbud_s2_5 x1_net1 VSS 0.013103f
Cbud_s2_6 x1_net10 VSS 0.0130157f
Cbud_s2_7 x1_net11 VSS 7.70745f
Cbud_s2_8 x1_net12 VSS 0.181332f
Cbud_s2_9 x1_net13 VSS 0.0130157f
Cbud_s2_10 x1_net15 VSS 0.181332f
Cbud_s2_11 x1_net3 VSS 0.181332f
Cbud_s2_12 x1_net4 VSS 0.013103f
Cbud_s2_13 x1_net5 VSS 0.0131735f
Cbud_s2_14 x1_net7 VSS 0.013103f
Cbud_s2_15 x1_net8 VSS 0.0130465f
Cbud_s2_16 x2_foldn VSS 0.310813f
Cbud_s2_17 x2_foldp VSS 0.310813f
Cbud_s2_18 bias_a bias_b 0.0669285f
Cbud_s2_19 bias_a bias_c 0.0530988f
Cbud_s2_20 bias_a cm 0.0285369f
Cbud_s2_21 bias_a i_bias 0.0198572f
Cbud_s2_22 bias_a x1_m21d 0.0105999f
Cbud_s2_23 bias_a x1_m31d 0.00855443f
Cbud_s2_24 bias_a x1_net1 0.00136837f
Cbud_s2_25 bias_a x1_net10 0.00136837f
Cbud_s2_26 bias_a x1_net11 0.00136838f
Cbud_s2_27 bias_a x1_net12 0.00136838f
Cbud_s2_28 bias_a x1_net13 0.00136837f
Cbud_s2_29 bias_a x1_net14 0.00136838f
Cbud_s2_30 bias_a x1_net15 0.00136838f
Cbud_s2_31 bias_a x1_net2 0.00136838f
Cbud_s2_32 bias_a x1_net3 0.00136838f
Cbud_s2_33 bias_a x1_net4 0.00136837f
Cbud_s2_34 bias_a x1_net5 0.00136838f
Cbud_s2_35 bias_a x1_net6 0.00136838f
Cbud_s2_36 bias_a x1_net7 0.00136837f
Cbud_s2_37 bias_a x1_net8 0.00136838f
Cbud_s2_38 bias_a x1_net9 0.00136838f
Cbud_s2_39 bias_a x2_foldn 0.0228281f
Cbud_s2_40 bias_a x2_foldp 0.0228281f
Cbud_s2_41 bias_a x2_tail 0.158962f
Cbud_s2_42 bias_a in 0.00195525f
Cbud_s2_43 bias_b bias_c 0.169367f
Cbud_s2_44 bias_b x1_m21d 0.0226837f
Cbud_s2_45 bias_b x1_net1 0.00158159f
Cbud_s2_46 bias_b x1_net10 0.00137589f
Cbud_s2_47 bias_b x1_net11 0.00162641f
Cbud_s2_48 bias_b x1_net12 0.00138759f
Cbud_s2_49 bias_b x1_net13 0.00158159f
Cbud_s2_50 bias_b x1_net14 0.00137938f
Cbud_s2_51 bias_b x1_net15 0.00138759f
Cbud_s2_52 bias_b x1_net2 0.00137938f
Cbud_s2_53 bias_b x1_net3 0.00138759f
Cbud_s2_54 bias_b x1_net4 0.00158159f
Cbud_s2_55 bias_b x1_net5 0.00143674f
Cbud_s2_56 bias_b x1_net6 0.00172958f
Cbud_s2_57 bias_b x1_net7 0.00158159f
Cbud_s2_58 bias_b x1_net8 0.00137938f
Cbud_s2_59 bias_b x1_net9 0.00172958f
Cbud_s2_60 bias_b x2_foldn 0.0457874f
Cbud_s2_61 bias_b x2_foldp 0.0457874f
Cbud_s2_62 bias_b in 0.00195525f
Cbud_s2_63 bias_c cm 0.034312f
Cbud_s2_64 bias_c i_bias 0.0370876f
Cbud_s2_65 bias_c x1_m21d 0.0163995f
Cbud_s2_66 bias_c x1_m31d 0.0143528f
Cbud_s2_67 bias_c x1_net1 0.00138806f
Cbud_s2_68 bias_c x1_net10 0.00138806f
Cbud_s2_69 bias_c x1_net11 0.00139417f
Cbud_s2_70 bias_c x1_net12 0.00138788f
Cbud_s2_71 bias_c x1_net13 0.00138806f
Cbud_s2_72 bias_c x1_net14 0.00140076f
Cbud_s2_73 bias_c x1_net15 0.00138788f
Cbud_s2_74 bias_c x1_net2 0.00140076f
Cbud_s2_75 bias_c x1_net3 0.00138788f
Cbud_s2_76 bias_c x1_net4 0.0013832f
Cbud_s2_77 bias_c x1_net5 0.00140076f
Cbud_s2_78 bias_c x1_net6 0.00138771f
Cbud_s2_79 bias_c x1_net7 0.0013832f
Cbud_s2_80 bias_c x1_net8 0.00139417f
Cbud_s2_81 bias_c x1_net9 0.00138771f
Cbud_s2_82 bias_c x2_foldn 0.0333381f
Cbud_s2_83 bias_c x2_foldp 0.0333381f
Cbud_s2_84 bias_c in 0.00195525f
Cbud_s2_85 bias_d x2_foldn 0.0228281f
Cbud_s2_86 bias_d x2_foldp 0.0228281f
Cbud_s2_87 bias_d in 0.00195525f
Cbud_s2_88 cm i_bias 0.0198768f
Cbud_s2_89 cm x1_m21d 0.0115278f
Cbud_s2_90 cm x1_m31d 0.0146458f
Cbud_s2_91 cm x1_net10 0.140053f
Cbud_s2_92 cm x1_net11 0.157216f
Cbud_s2_93 cm x1_net12 1.96735f
Cbud_s2_94 cm x1_net13 0.140053f
Cbud_s2_95 cm x1_net14 0.0698765f
Cbud_s2_96 cm x1_net15 1.96735f
Cbud_s2_97 cm x1_net2 0.0698765f
Cbud_s2_98 cm x1_net3 1.96735f
Cbud_s2_99 cm x1_net4 0.0693947f
Cbud_s2_100 cm x1_net6 1.96735f
Cbud_s2_101 cm x1_net7 0.0693947f
Cbud_s2_102 cm x1_net8 0.157216f
Cbud_s2_103 cm x1_net9 1.96735f
Cbud_s2_104 cm x2_foldn 0.0228281f
Cbud_s2_105 cm x2_foldp 0.0228281f
Cbud_s2_106 cm in 0.00195525f
Cbud_s2_107 i_bias x1_m21d 0.0106226f
Cbud_s2_108 i_bias x1_m31d 0.00859366f
Cbud_s2_109 i_bias x1_net1 0.00428087f
Cbud_s2_110 i_bias x1_net10 0.00428087f
Cbud_s2_111 i_bias x1_net11 0.00497466f
Cbud_s2_112 i_bias x1_net12 0.0058933f
Cbud_s2_113 i_bias x1_net13 0.00428087f
Cbud_s2_114 i_bias x1_net14 0.00473095f
Cbud_s2_115 i_bias x1_net15 0.0058933f
Cbud_s2_116 i_bias x1_net2 0.00473095f
Cbud_s2_117 i_bias x1_net3 0.0058933f
Cbud_s2_118 i_bias x1_net4 0.00428087f
Cbud_s2_119 i_bias x1_net5 0.0048556f
Cbud_s2_120 i_bias x1_net6 0.00589357f
Cbud_s2_121 i_bias x1_net7 0.00428088f
Cbud_s2_122 i_bias x1_net8 0.00497466f
Cbud_s2_123 i_bias x1_net9 0.00589384f
Cbud_s2_124 i_bias x2_foldn 0.0198571f
Cbud_s2_125 i_bias x2_foldp 0.0198571f
Cbud_s2_126 i_bias x2_tail 0.0198624f
Cbud_s2_127 i_bias ip 0.00195525f
Cbud_s2_128 on x2_foldn 0.0228281f
Cbud_s2_129 on x2_m3d 0.0609925f
Cbud_s2_130 on ip 0.00195525f
Cbud_s2_131 op x2_foldp 0.0228281f
Cbud_s2_132 op x2_m4d 0.060409f
Cbud_s2_133 op in 0.00195525f
Cbud_s2_134 x1_m21d x1_m31d 0.145422f
Cbud_s2_135 x1_m21d x1_net1 0.00548775f
Cbud_s2_136 x1_m21d x1_net10 0.00561701f
Cbud_s2_137 x1_m21d x1_net11 0.00190807f
Cbud_s2_138 x1_m21d x1_net12 0.00197157f
Cbud_s2_139 x1_m21d x1_net13 0.00548775f
Cbud_s2_140 x1_m21d x1_net14 0.00174873f
Cbud_s2_141 x1_m21d x1_net15 0.00197157f
Cbud_s2_142 x1_m21d x1_net2 0.00174873f
Cbud_s2_143 x1_m21d x1_net3 0.00197157f
Cbud_s2_144 x1_m21d x1_net4 0.00561701f
Cbud_s2_145 x1_m21d x1_net5 0.00174873f
Cbud_s2_146 x1_m21d x1_net6 0.00197157f
Cbud_s2_147 x1_m21d x1_net7 0.00548774f
Cbud_s2_148 x1_m21d x1_net8 0.00174399f
Cbud_s2_149 x1_m21d x1_net9 0.00197157f
Cbud_s2_150 x1_m21d x2_foldn 0.0105998f
Cbud_s2_151 x1_m21d x2_foldp 0.0105998f
Cbud_s2_152 x1_m21d in 0.00195525f
Cbud_s2_153 x1_m25d x1_m5d 0.0106001f
Cbud_s2_154 x1_m25d x2_foldn 0.0105998f
Cbud_s2_155 x1_m25d x2_foldp 0.0105998f
Cbud_s2_156 x1_m25d in 0.00195525f
Cbud_s2_157 x1_m2d x2_foldn 0.0228281f
Cbud_s2_158 x1_m2d x2_foldp 0.0228281f
Cbud_s2_159 x1_m2d in 0.00195525f
Cbud_s2_160 x1_m31d x1_net1 0.00609298f
Cbud_s2_161 x1_m31d x1_net10 0.00609298f
Cbud_s2_162 x1_m31d x1_net11 0.006783f
Cbud_s2_163 x1_m31d x1_net12 0.00829841f
Cbud_s2_164 x1_m31d x1_net13 0.00633146f
Cbud_s2_165 x1_m31d x1_net14 0.00708993f
Cbud_s2_166 x1_m31d x1_net15 0.00829841f
Cbud_s2_167 x1_m31d x1_net2 0.00708993f
Cbud_s2_168 x1_m31d x1_net3 0.00829841f
Cbud_s2_169 x1_m31d x1_net4 0.00620453f
Cbud_s2_170 x1_m31d x1_net5 0.00708993f
Cbud_s2_171 x1_m31d x1_net6 0.00743782f
Cbud_s2_172 x1_m31d x1_net7 0.00633146f
Cbud_s2_173 x1_m31d x1_net8 0.00708993f
Cbud_s2_174 x1_m31d x1_net9 0.00743782f
Cbud_s2_175 x1_m31d x2_foldn 0.00855437f
Cbud_s2_176 x1_m31d x2_foldp 0.00855437f
Cbud_s2_177 x1_m31d x2_tail 0.00860755f
Cbud_s2_178 x1_m31d ip 0.00195525f
Cbud_s2_179 x1_m5d x2_foldn 0.0198571f
Cbud_s2_180 x1_m5d x2_foldp 0.0198571f
Cbud_s2_181 x1_m5d in 0.00195525f
Cbud_s2_182 x1_net1 x1_net10 0.00651122f
Cbud_s2_183 x1_net1 x1_net13 0.00651122f
Cbud_s2_184 x1_net1 x1_net3 0.00651122f
Cbud_s2_185 x1_net1 x1_net4 0.00651122f
Cbud_s2_186 x1_net1 x1_net6 0.823374f
Cbud_s2_187 x1_net1 x1_net7 0.00637152f
Cbud_s2_188 x1_net1 x1_net9 0.823374f
Cbud_s2_189 x1_net1 x2_foldn 0.00136832f
Cbud_s2_190 x1_net1 x2_foldp 0.00136832f
Cbud_s2_191 x1_net1 in 0.00136832f
Cbud_s2_192 x1_net10 x1_net12 0.00633146f
Cbud_s2_193 x1_net10 x1_net15 0.823374f
Cbud_s2_194 x1_net10 x1_net3 0.823374f
Cbud_s2_195 x1_net10 x1_net4 0.00651122f
Cbud_s2_196 x1_net10 x1_net7 0.00637152f
Cbud_s2_197 x1_net10 x2_foldn 0.00136832f
Cbud_s2_198 x1_net10 x2_foldp 0.00136832f
Cbud_s2_199 x1_net10 in 0.00136832f
Cbud_s2_200 x1_net11 x2_foldn 0.00136832f
Cbud_s2_201 x1_net11 x2_foldp 0.00136832f
Cbud_s2_202 x1_net11 in 0.00136833f
Cbud_s2_203 x1_net12 x1_net13 0.823374f
Cbud_s2_204 x1_net12 x1_net4 0.00637152f
Cbud_s2_205 x1_net12 x1_net5 0.823374f
Cbud_s2_206 x1_net12 x1_net7 0.823374f
Cbud_s2_207 x1_net12 x1_net8 0.823374f
Cbud_s2_208 x1_net12 x2_foldn 0.00136832f
Cbud_s2_209 x1_net12 x2_foldp 0.00136832f
Cbud_s2_210 x1_net12 in 0.00136833f
Cbud_s2_211 x1_net13 x1_net14 0.00813622f
Cbud_s2_212 x1_net13 x1_net15 0.00633146f
Cbud_s2_213 x1_net13 x1_net3 0.823374f
Cbud_s2_214 x1_net13 x1_net4 0.00651122f
Cbud_s2_215 x1_net13 x2_foldn 0.00136832f
Cbud_s2_216 x1_net13 x2_foldp 0.00136832f
Cbud_s2_217 x1_net13 in 0.00136832f
Cbud_s2_218 x1_net14 x1_net15 0.00864078f
Cbud_s2_219 x1_net14 x1_net6 0.820324f
Cbud_s2_220 x1_net14 x1_net9 0.820324f
Cbud_s2_221 x1_net14 x2_foldn 0.00136832f
Cbud_s2_222 x1_net14 x2_foldp 0.00136832f
Cbud_s2_223 x1_net14 in 0.00136833f
Cbud_s2_224 x1_net15 x1_net4 0.00637152f
Cbud_s2_225 x1_net15 x1_net5 0.823374f
Cbud_s2_226 x1_net15 x1_net7 0.823374f
Cbud_s2_227 x1_net15 x1_net8 0.823374f
Cbud_s2_228 x1_net15 x2_foldn 0.00136832f
Cbud_s2_229 x1_net15 x2_foldp 0.00136832f
Cbud_s2_230 x1_net15 in 0.00136833f
Cbud_s2_231 x1_net2 x1_net3 0.00864078f
Cbud_s2_232 x1_net2 x1_net6 0.820324f
Cbud_s2_233 x1_net2 x1_net9 0.820324f
Cbud_s2_234 x1_net2 x2_foldn 0.00136832f
Cbud_s2_235 x1_net2 x2_foldp 0.00136832f
Cbud_s2_236 x1_net2 in 0.00136833f
Cbud_s2_237 x1_net3 x1_net4 0.00637152f
Cbud_s2_238 x1_net3 x1_net5 0.823374f
Cbud_s2_239 x1_net3 x1_net7 0.823374f
Cbud_s2_240 x1_net3 x1_net8 0.823374f
Cbud_s2_241 x1_net3 x2_foldn 0.00136832f
Cbud_s2_242 x1_net3 x2_foldp 0.00136832f
Cbud_s2_243 x1_net3 in 0.00136833f
Cbud_s2_244 x1_net4 x1_net5 0.00767651f
Cbud_s2_245 x1_net4 x1_net6 0.00637152f
Cbud_s2_246 x1_net4 x2_foldn 0.00136832f
Cbud_s2_247 x1_net4 x2_foldp 0.00136832f
Cbud_s2_248 x1_net4 in 0.00136832f
Cbud_s2_249 x1_net5 x1_net6 0.00813622f
Cbud_s2_250 x1_net5 x1_net8 0.006783f
Cbud_s2_251 x1_net5 x1_net9 0.006783f
Cbud_s2_252 x1_net5 x2_foldn 0.00136832f
Cbud_s2_253 x1_net5 x2_foldp 0.00136832f
Cbud_s2_254 x1_net5 in 0.00136833f
Cbud_s2_255 x1_net6 x1_net7 0.823374f
Cbud_s2_256 x1_net6 x1_net8 0.00651122f
Cbud_s2_257 x1_net6 x2_foldn 0.00136832f
Cbud_s2_258 x1_net6 x2_foldp 0.00136832f
Cbud_s2_259 x1_net6 in 0.00136833f
Cbud_s2_260 x1_net7 x1_net8 0.00813622f
Cbud_s2_261 x1_net7 x1_net9 0.00637152f
Cbud_s2_262 x1_net7 x2_foldn 0.00136832f
Cbud_s2_263 x1_net7 x2_foldp 0.00136832f
Cbud_s2_264 x1_net7 in 0.00136832f
Cbud_s2_265 x1_net8 x1_net9 0.00864078f
Cbud_s2_266 x1_net8 x2_foldn 0.00136832f
Cbud_s2_267 x1_net8 x2_foldp 0.00136832f
Cbud_s2_268 x1_net8 in 0.00136833f
Cbud_s2_269 x1_net9 x2_foldn 0.00136832f
Cbud_s2_270 x1_net9 x2_foldp 0.00136832f
Cbud_s2_271 x1_net9 in 0.00136833f
Cbud_s2_272 x2_foldn x2_foldp 0.0228281f
Cbud_s2_273 x2_foldn x2_m3d 0.0228281f
Cbud_s2_274 x2_foldn x2_m4d 0.0228281f
Cbud_s2_275 x2_foldn x2_tail 0.0280416f
Cbud_s2_276 x2_foldn ip 0.00195525f
Cbud_s2_277 x2_foldn in 0.00401573f
Cbud_s2_278 x2_foldp x2_m3d 0.0228281f
Cbud_s2_279 x2_foldp x2_m4d 0.0228281f
Cbud_s2_280 x2_foldp x2_tail 0.0280416f
Cbud_s2_281 x2_foldp ip 0.00401573f
Cbud_s2_282 x2_foldp in 0.00195525f
Cbud_s2_283 x2_m3d ip 0.00195525f
Cbud_s2_284 x2_m4d in 0.00195525f
Cbud_s2_285 x2_tail ip 0.00401573f
XX1_M22 s1r_XX1_M22_d s1r_XX1_M22_g s1r_XX1_M22_s VDD sky130_fd_pr__pfet_01v8 L=0.6 W=1.4 NF=1 AD=0.406 AS=0.406 PD=3.38 PS=3.38 NRD=0.207143 NRS=0.207143 SA=0 SB=0 SD=0 MULT=6 M=6
Rpar_s1_XX1_M22_s s1r_XX1_M22_s x1_m21d 0.553403
Rpar_s1_XX1_M22_g s1r_XX1_M22_g bias_c 0.391903
Rpar_s1_XX1_M22_d s1r_XX1_M22_d bias_b 0.553403
XX1_M26 s1r_XX1_M26_d bias_c s1r_XX1_M26_s VDD sky130_fd_pr__pfet_01v8 L=0.6 W=1.4 NF=1 AD=0.406 AS=0.406 PD=3.38 PS=3.38 NRD=0.207143 NRS=0.207143 SA=0 SB=0 SD=0 MULT=6 M=6
Rpar_s1_XX1_M26_s s1r_XX1_M26_s x1_m25d 0.553403
Rpar_s1_XX1_M26_d s1r_XX1_M26_d x1_m2d 0.553403
XX1_M32 s1r_XX1_M32_d bias_c x1_m31d VDD sky130_fd_pr__pfet_01v8 L=0.6 W=1.4 NF=1 AD=0.406 AS=0.406 PD=3.38 PS=3.38 NRD=0.207143 NRS=0.207143 SA=0 SB=0 SD=0 MULT=6 M=6
Rpar_s1_XX1_M32_d s1r_XX1_M32_d cm 3.86649
XX1_M21 s1r_XX1_M21_d bias_b s1r_XX1_M21_s VDD sky130_fd_pr__pfet_01v8_lvt L=0.6 W=1.4 NF=1 AD=0.406 AS=0.406 PD=3.38 PS=3.38 NRD=0.207143 NRS=0.207143 SA=0 SB=0 SD=0 MULT=6 M=6
Rpar_s1_XX1_M21_s s1r_XX1_M21_s VDD 0.553403
Rpar_s1_XX1_M21_d s1r_XX1_M21_d x1_m21d 0.553403
XX1_M25 s1r_XX1_M25_d bias_b s1r_XX1_M25_s VDD sky130_fd_pr__pfet_01v8_lvt L=0.6 W=1.4 NF=1 AD=0.406 AS=0.406 PD=3.38 PS=3.38 NRD=0.207143 NRS=0.207143 SA=0 SB=0 SD=0 MULT=6 M=6
Rpar_s1_XX1_M25_s s1r_XX1_M25_s VDD 0.553403
Rpar_s1_XX1_M25_d s1r_XX1_M25_d x1_m25d 0.553403
XX1_M31 x1_m31d bias_b s1r_XX1_M31_s VDD sky130_fd_pr__pfet_01v8_lvt L=0.6 W=1.4 NF=1 AD=0.406 AS=0.406 PD=3.38 PS=3.38 NRD=0.207143 NRS=0.207143 SA=0 SB=0 SD=0 MULT=6 M=6
Rpar_s1_XX1_M31_s s1r_XX1_M31_s VDD 0.553403
XX1_M1 s1r_XX1_M1_d bias_b s1r_XX1_M1_s VSS sky130_fd_pr__nfet_01v8_lvt L=0.6 W=1.4 NF=1 AD=0.406 AS=0.406 PD=3.38 PS=3.38 NRD=0.207143 NRS=0.207143 SA=0 SB=0 SD=0 MULT=56 M=56
Rpar_s1_XX1_M1_s s1r_XX1_M1_s bias_c 1.07356
Rpar_s1_XX1_M1_d s1r_XX1_M1_d bias_b 1.07356
XX1_M2 x1_m2d s1r_XX1_M2_g s1r_XX1_M2_s VSS sky130_fd_pr__nfet_01v8 L=0.6 W=1.4 NF=1 AD=0.406 AS=0.406 PD=3.38 PS=3.38 NRD=0.207143 NRS=0.207143 SA=0 SB=0 SD=0 MULT=50 M=50
Rpar_s1_XX1_M2_s s1r_XX1_M2_s bias_d 0.96449
Rpar_s1_XX1_M2_g s1r_XX1_M2_g x1_m2d 0.978178
XX1_M3 s1r_XX1_M3_d s1r_XX1_M3_g s1r_XX1_M3_s VSS sky130_fd_pr__nfet_01v8 L=0.6 W=1.4 NF=1 AD=0.406 AS=0.406 PD=3.38 PS=3.38 NRD=0.207143 NRS=0.207143 SA=0 SB=0 SD=0 MULT=2 M=2
Rpar_s1_XX1_M3_s s1r_XX1_M3_s bias_a 0.467406
Rpar_s1_XX1_M3_g s1r_XX1_M3_g x1_m2d 0.809609
Rpar_s1_XX1_M3_d s1r_XX1_M3_d bias_d 0.467406
XX1_M4 s1r_XX1_M4_d bias_d x1_m5d VSS sky130_fd_pr__nfet_01v8 L=0.6 W=1.4 NF=1 AD=0.406 AS=0.406 PD=3.38 PS=3.38 NRD=0.207143 NRS=0.207143 SA=0 SB=0 SD=0 MULT=18 M=18
Rpar_s1_XX1_M4_d s1r_XX1_M4_d bias_a 0.402347
XX1_M5 x1_m5d bias_a s1r_XX1_M5_s VSS sky130_fd_pr__nfet_01v8 L=0.6 W=1.4 NF=1 AD=0.406 AS=0.406 PD=3.38 PS=3.38 NRD=0.207143 NRS=0.207143 SA=0 SB=0 SD=0 MULT=18 M=18
Rpar_s1_XX1_M5_s s1r_XX1_M5_s VSS 0.402347
XX1_M6 bias_c i_bias s1r_XX1_M6_s VSS sky130_fd_pr__nfet_01v8 L=0.6 W=1.4 NF=1 AD=0.406 AS=0.406 PD=3.38 PS=3.38 NRD=0.207143 NRS=0.207143 SA=0 SB=0 SD=0 MULT=18 M=18
Rpar_s1_XX1_M6_s s1r_XX1_M6_s VSS 0.402347
XX1_M7 i_bias i_bias s1r_XX1_M7_s VSS sky130_fd_pr__nfet_01v8 L=0.6 W=1.4 NF=1 AD=0.406 AS=0.406 PD=3.38 PS=3.38 NRD=0.207143 NRS=0.207143 SA=0 SB=0 SD=0 MULT=18 M=18
Rpar_s1_XX1_M7_s s1r_XX1_M7_s VSS 0.402347
XX1_M33 cm cm x1_net1 VSS sky130_fd_pr__nfet_01v8 L=0.6 W=1.4 NF=1 AD=0.406 AS=0.406 PD=3.38 PS=3.38 NRD=0.207143 NRS=0.207143 SA=0 SB=0 SD=0 MULT=1 M=1
XX1_M49 x1_net1 s1r_XX1_M49_g x1_net2 VSS sky130_fd_pr__nfet_01v8 L=0.6 W=1.4 NF=1 AD=0.406 AS=0.406 PD=3.38 PS=3.38 NRD=0.207143 NRS=0.207143 SA=0 SB=0 SD=0 MULT=1 M=1
Rpar_s1_XX1_M49_g s1r_XX1_M49_g cm 1.53964
XX1_M50 x1_net2 cm x1_net3 VSS sky130_fd_pr__nfet_01v8 L=0.6 W=1.4 NF=1 AD=0.406 AS=0.406 PD=3.38 PS=3.38 NRD=0.207143 NRS=0.207143 SA=0 SB=0 SD=0 MULT=1 M=1
XX1_M63 s1r_XX1_M63_d s1r_XX1_M63_g s1r_XX1_M63_s VSS sky130_fd_pr__nfet_01v8 L=0.6 W=1.4 NF=1 AD=0.406 AS=0.406 PD=3.38 PS=3.38 NRD=0.207143 NRS=0.207143 SA=0 SB=0 SD=0 MULT=1 M=1
Rpar_s1_XX1_M63_s s1r_XX1_M63_s VSS 0.859161
Rpar_s1_XX1_M63_g s1r_XX1_M63_g cm 1.56413
Rpar_s1_XX1_M63_d s1r_XX1_M63_d x1_net3 0.867061
XX1_M68 cm cm s1r_XX1_M68_s VSS sky130_fd_pr__nfet_01v8 L=0.6 W=1.4 NF=1 AD=0.406 AS=0.406 PD=3.38 PS=3.38 NRD=0.207143 NRS=0.207143 SA=0 SB=0 SD=0 MULT=1 M=1
Rpar_s1_XX1_M68_s s1r_XX1_M68_s x1_net4 68.9365
XX1_M69 x1_net4 cm x1_net5 VSS sky130_fd_pr__nfet_01v8 L=0.6 W=1.4 NF=1 AD=0.406 AS=0.406 PD=3.38 PS=3.38 NRD=0.207143 NRS=0.207143 SA=0 SB=0 SD=0 MULT=1 M=1
XX1_M70 x1_net5 cm x1_net6 VSS sky130_fd_pr__nfet_01v8 L=0.6 W=1.4 NF=1 AD=0.406 AS=0.406 PD=3.38 PS=3.38 NRD=0.207143 NRS=0.207143 SA=0 SB=0 SD=0 MULT=1 M=1
XX1_M71 s1r_XX1_M71_d s1r_XX1_M71_g s1r_XX1_M71_s VSS sky130_fd_pr__nfet_01v8 L=0.6 W=1.4 NF=1 AD=0.406 AS=0.406 PD=3.38 PS=3.38 NRD=0.207143 NRS=0.207143 SA=0 SB=0 SD=0 MULT=1 M=1
Rpar_s1_XX1_M71_s s1r_XX1_M71_s VSS 0.859161
Rpar_s1_XX1_M71_g s1r_XX1_M71_g cm 1.56413
Rpar_s1_XX1_M71_d s1r_XX1_M71_d x1_net6 0.867061
XX1_M72 cm cm x1_net7 VSS sky130_fd_pr__nfet_01v8 L=0.6 W=1.4 NF=1 AD=0.406 AS=0.406 PD=3.38 PS=3.38 NRD=0.207143 NRS=0.207143 SA=0 SB=0 SD=0 MULT=1 M=1
XX1_M73 x1_net7 cm x1_net8 VSS sky130_fd_pr__nfet_01v8 L=0.6 W=1.4 NF=1 AD=0.406 AS=0.406 PD=3.38 PS=3.38 NRD=0.207143 NRS=0.207143 SA=0 SB=0 SD=0 MULT=1 M=1
XX1_M74 x1_net8 s1r_XX1_M74_g s1r_XX1_M74_s VSS sky130_fd_pr__nfet_01v8 L=0.6 W=1.4 NF=1 AD=0.406 AS=0.406 PD=3.38 PS=3.38 NRD=0.207143 NRS=0.207143 SA=0 SB=0 SD=0 MULT=1 M=1
Rpar_s1_XX1_M74_s s1r_XX1_M74_s x1_net9 0.867061
Rpar_s1_XX1_M74_g s1r_XX1_M74_g cm 1.53959
XX1_M75 x1_net9 cm s1r_XX1_M75_s VSS sky130_fd_pr__nfet_01v8 L=0.6 W=1.4 NF=1 AD=0.406 AS=0.406 PD=3.38 PS=3.38 NRD=0.207143 NRS=0.207143 SA=0 SB=0 SD=0 MULT=1 M=1
Rpar_s1_XX1_M75_s s1r_XX1_M75_s VSS 0.859161
XX1_M76 cm cm x1_net10 VSS sky130_fd_pr__nfet_01v8 L=0.6 W=1.4 NF=1 AD=0.406 AS=0.406 PD=3.38 PS=3.38 NRD=0.207143 NRS=0.207143 SA=0 SB=0 SD=0 MULT=1 M=1
XX1_M77 s1r_XX1_M77_d cm x1_net11 VSS sky130_fd_pr__nfet_01v8 L=0.6 W=1.4 NF=1 AD=0.406 AS=0.406 PD=3.38 PS=3.38 NRD=0.207143 NRS=0.207143 SA=0 SB=0 SD=0 MULT=1 M=1
Rpar_s1_XX1_M77_d s1r_XX1_M77_d x1_net10 0.867074
XX1_M78 x1_net11 cm x1_net12 VSS sky130_fd_pr__nfet_01v8 L=0.6 W=1.4 NF=1 AD=0.406 AS=0.406 PD=3.38 PS=3.38 NRD=0.207143 NRS=0.207143 SA=0 SB=0 SD=0 MULT=1 M=1
XX1_M79 x1_net12 s1r_XX1_M79_g s1r_XX1_M79_s VSS sky130_fd_pr__nfet_01v8 L=0.6 W=1.4 NF=1 AD=0.406 AS=0.406 PD=3.38 PS=3.38 NRD=0.207143 NRS=0.207143 SA=0 SB=0 SD=0 MULT=1 M=1
Rpar_s1_XX1_M79_s s1r_XX1_M79_s VSS 0.859161
Rpar_s1_XX1_M79_g s1r_XX1_M79_g cm 1.56413
XX1_M64 cm cm s1r_XX1_M64_s VSS sky130_fd_pr__nfet_01v8 L=0.6 W=1.4 NF=1 AD=0.406 AS=0.406 PD=3.38 PS=3.38 NRD=0.207143 NRS=0.207143 SA=0 SB=0 SD=0 MULT=1 M=1
Rpar_s1_XX1_M64_s s1r_XX1_M64_s x1_net13 68.9365
XX1_M65 x1_net13 s1r_XX1_M65_g x1_net14 VSS sky130_fd_pr__nfet_01v8 L=0.6 W=1.4 NF=1 AD=0.406 AS=0.406 PD=3.38 PS=3.38 NRD=0.207143 NRS=0.207143 SA=0 SB=0 SD=0 MULT=1 M=1
Rpar_s1_XX1_M65_g s1r_XX1_M65_g cm 1.53963
XX1_M66 x1_net14 cm x1_net15 VSS sky130_fd_pr__nfet_01v8 L=0.6 W=1.4 NF=1 AD=0.406 AS=0.406 PD=3.38 PS=3.38 NRD=0.207143 NRS=0.207143 SA=0 SB=0 SD=0 MULT=1 M=1
XX1_M67 s1r_XX1_M67_d s1r_XX1_M67_g s1r_XX1_M67_s VSS sky130_fd_pr__nfet_01v8 L=0.6 W=1.4 NF=1 AD=0.406 AS=0.406 PD=3.38 PS=3.38 NRD=0.207143 NRS=0.207143 SA=0 SB=0 SD=0 MULT=1 M=1
Rpar_s1_XX1_M67_s s1r_XX1_M67_s VSS 0.859161
Rpar_s1_XX1_M67_g s1r_XX1_M67_g cm 1.56413
Rpar_s1_XX1_M67_d s1r_XX1_M67_d x1_net15 0.867061
XX1_M57 bias_b VDD VDD VDD sky130_fd_pr__pfet_01v8 L=0.6 W=1.4 NF=1 AD=0.406 AS=0.406 PD=3.38 PS=3.38 NRD=0.207143 NRS=0.207143 SA=0 SB=0 SD=0 MULT=2 M=2
XX1_M58 x1_m2d VDD VDD VDD sky130_fd_pr__pfet_01v8 L=0.6 W=1.4 NF=1 AD=0.406 AS=0.406 PD=3.38 PS=3.38 NRD=0.207143 NRS=0.207143 SA=0 SB=0 SD=0 MULT=2 M=2
XX1_M59 cm VDD VDD VDD sky130_fd_pr__pfet_01v8 L=0.6 W=1.4 NF=1 AD=0.406 AS=0.406 PD=3.38 PS=3.38 NRD=0.207143 NRS=0.207143 SA=0 SB=0 SD=0 MULT=2 M=2
XX1_M60 x1_m31d VDD VDD VDD sky130_fd_pr__pfet_01v8 L=0.6 W=1.4 NF=1 AD=0.406 AS=0.406 PD=3.38 PS=3.38 NRD=0.207143 NRS=0.207143 SA=0 SB=0 SD=0 MULT=2 M=2
XX1_M42 x1_m5d VSS VSS VSS sky130_fd_pr__nfet_01v8 L=0.6 W=1.4 NF=1 AD=0.406 AS=0.406 PD=3.38 PS=3.38 NRD=0.207143 NRS=0.207143 SA=0 SB=0 SD=0 MULT=6 M=6
XX1_M44 bias_c bias_c bias_c VSS sky130_fd_pr__nfet_01v8 L=0.6 W=1.4 NF=1 AD=0.406 AS=0.406 PD=3.38 PS=3.38 NRD=0.207143 NRS=0.207143 SA=0 SB=0 SD=0 MULT=2 M=2
XX1_M34 bias_d bias_d bias_d VSS sky130_fd_pr__nfet_01v8 L=0.6 W=1.4 NF=1 AD=0.406 AS=0.406 PD=3.38 PS=3.38 NRD=0.207143 NRS=0.207143 SA=0 SB=0 SD=0 MULT=8 M=8
XX1_M35 x1_m2d x1_m2d x1_m2d VSS sky130_fd_pr__nfet_01v8 L=0.6 W=1.4 NF=1 AD=0.406 AS=0.406 PD=3.38 PS=3.38 NRD=0.207143 NRS=0.207143 SA=0 SB=0 SD=0 MULT=2 M=2
XX1_M36 bias_a bias_a bias_a VSS sky130_fd_pr__nfet_01v8 L=0.6 W=1.4 NF=1 AD=0.406 AS=0.406 PD=3.38 PS=3.38 NRD=0.207143 NRS=0.207143 SA=0 SB=0 SD=0 MULT=4 M=4
XX1_M37 cm cm cm VSS sky130_fd_pr__nfet_01v8 L=0.6 W=1.4 NF=1 AD=0.406 AS=0.406 PD=3.38 PS=3.38 NRD=0.207143 NRS=0.207143 SA=0 SB=0 SD=0 MULT=8 M=8
XX1_M54 x1_m25d x1_m25d x1_m25d VDD sky130_fd_pr__pfet_01v8 L=0.6 W=1.4 NF=1 AD=0.406 AS=0.406 PD=3.38 PS=3.38 NRD=0.207143 NRS=0.207143 SA=0 SB=0 SD=0 MULT=2 M=2
XX1_M29 x1_m5d x1_m5d x1_m5d VSS sky130_fd_pr__nfet_01v8 L=0.6 W=1.4 NF=1 AD=0.406 AS=0.406 PD=3.38 PS=3.38 NRD=0.207143 NRS=0.207143 SA=0 SB=0 SD=0 MULT=6 M=6
XX1_M8 i_bias i_bias i_bias VSS sky130_fd_pr__nfet_01v8 L=0.6 W=1.4 NF=1 AD=0.406 AS=0.406 PD=3.38 PS=3.38 NRD=0.207143 NRS=0.207143 SA=0 SB=0 SD=0 MULT=2 M=2
XX1_M10 bias_c bias_c bias_c VSS sky130_fd_pr__nfet_01v8_lvt L=0.6 W=1.4 NF=1 AD=0.406 AS=0.406 PD=3.38 PS=3.38 NRD=0.207143 NRS=0.207143 SA=0 SB=0 SD=0 MULT=8 M=8
XX1_M27 bias_b bias_b bias_b VSS sky130_fd_pr__nfet_01v8_lvt L=0.6 W=1.4 NF=1 AD=0.406 AS=0.406 PD=3.38 PS=3.38 NRD=0.207143 NRS=0.207143 SA=0 SB=0 SD=0 MULT=8 M=8
XX1_M46 x1_m21d x1_m21d x1_m21d VDD sky130_fd_pr__pfet_01v8_lvt L=0.6 W=1.4 NF=1 AD=0.406 AS=0.406 PD=3.38 PS=3.38 NRD=0.207143 NRS=0.207143 SA=0 SB=0 SD=0 MULT=2 M=2
XX1_M47 x1_m25d x1_m25d x1_m25d VDD sky130_fd_pr__pfet_01v8_lvt L=0.6 W=1.4 NF=1 AD=0.406 AS=0.406 PD=3.38 PS=3.38 NRD=0.207143 NRS=0.207143 SA=0 SB=0 SD=0 MULT=2 M=2
XX1_M48 x1_m31d x1_m31d x1_m31d VDD sky130_fd_pr__pfet_01v8_lvt L=0.6 W=1.4 NF=1 AD=0.406 AS=0.406 PD=3.38 PS=3.38 NRD=0.207143 NRS=0.207143 SA=0 SB=0 SD=0 MULT=2 M=2
XX1_M51 x1_m21d x1_m21d x1_m21d VDD sky130_fd_pr__pfet_01v8 L=0.6 W=1.4 NF=1 AD=0.406 AS=0.406 PD=3.38 PS=3.38 NRD=0.207143 NRS=0.207143 SA=0 SB=0 SD=0 MULT=2 M=2
XX2_M1 x2_foldp s1r_XX2_M1_g x2_tail VSS sky130_fd_pr__nfet_01v8_lvt L=0.2 W=1.2 NF=1 AD=0.348 AS=0.348 PD=2.98 PS=2.98 NRD=0.241667 NRS=0.241667 SA=0 SB=0 SD=0 MULT=6 M=6
Rpar_s1_XX2_M1_g s1r_XX2_M1_g ip 0.413845
XX2_M2 x2_foldn s1r_XX2_M2_g x2_tail VSS sky130_fd_pr__nfet_01v8_lvt L=0.2 W=1.2 NF=1 AD=0.348 AS=0.348 PD=2.98 PS=2.98 NRD=0.241667 NRS=0.241667 SA=0 SB=0 SD=0 MULT=6 M=6
Rpar_s1_XX2_M2_g s1r_XX2_M2_g in 0.413845
XX2_M6 x2_tail cmc s1r_XX2_M6_s VSS sky130_fd_pr__nfet_01v8 L=0.6 W=1.4 NF=1 AD=0.406 AS=0.406 PD=3.38 PS=3.38 NRD=0.207143 NRS=0.207143 SA=0 SB=0 SD=0 MULT=96 M=96
Rpar_s1_XX2_M6_s s1r_XX2_M6_s VSS 1.80626
XX2_M5 s1r_XX2_M5_d bias_a VSS VSS sky130_fd_pr__nfet_01v8 L=0.6 W=1.4 NF=1 AD=0.406 AS=0.406 PD=3.38 PS=3.38 NRD=0.207143 NRS=0.207143 SA=0 SB=0 SD=0 MULT=96 M=96
Rpar_s1_XX2_M5_d s1r_XX2_M5_d x2_tail 1.80626
XX2_M11 x2_foldp s1r_XX2_M11_g s1r_XX2_M11_s VDD sky130_fd_pr__pfet_01v8_lvt L=0.6 W=1.4 NF=1 AD=0.406 AS=0.406 PD=3.38 PS=3.38 NRD=0.207143 NRS=0.207143 SA=0 SB=0 SD=0 MULT=24 M=24
Rpar_s1_XX2_M11_s s1r_XX2_M11_s VDD 0.588767
Rpar_s1_XX2_M11_g s1r_XX2_M11_g bias_b 0.548058
XX2_M12 x2_foldn s1r_XX2_M12_g s1r_XX2_M12_s VDD sky130_fd_pr__pfet_01v8_lvt L=0.6 W=1.4 NF=1 AD=0.406 AS=0.406 PD=3.38 PS=3.38 NRD=0.207143 NRS=0.207143 SA=0 SB=0 SD=0 MULT=24 M=24
Rpar_s1_XX2_M12_s s1r_XX2_M12_s VDD 0.588767
Rpar_s1_XX2_M12_g s1r_XX2_M12_g bias_b 0.548058
XX2_M1A s1r_XX2_M1A_d s1r_XX2_M1A_g x2_foldp VDD sky130_fd_pr__pfet_01v8 L=0.6 W=1.4 NF=1 AD=0.406 AS=0.406 PD=3.38 PS=3.38 NRD=0.207143 NRS=0.207143 SA=0 SB=0 SD=0 MULT=20 M=20
Rpar_s1_XX2_M1A_g s1r_XX2_M1A_g bias_c 0.483979
Rpar_s1_XX2_M1A_d s1r_XX2_M1A_d on 0.656364
XX2_M8 s1r_XX2_M8_d s1r_XX2_M8_g x2_foldn VDD sky130_fd_pr__pfet_01v8 L=0.6 W=1.4 NF=1 AD=0.406 AS=0.406 PD=3.38 PS=3.38 NRD=0.207143 NRS=0.207143 SA=0 SB=0 SD=0 MULT=20 M=20
Rpar_s1_XX2_M8_g s1r_XX2_M8_g bias_c 0.483979
Rpar_s1_XX2_M8_d s1r_XX2_M8_d op 0.656364
XX2_M3A on s1r_XX2_M3A_g s1r_XX2_M3A_s VSS sky130_fd_pr__nfet_01v8 L=0.6 W=1.4 NF=1 AD=0.406 AS=0.406 PD=3.38 PS=3.38 NRD=0.207143 NRS=0.207143 SA=0 SB=0 SD=0 MULT=36 M=36
Rpar_s1_XX2_M3A_s s1r_XX2_M3A_s x2_m3d 0.712243
Rpar_s1_XX2_M3A_g s1r_XX2_M3A_g bias_d 0.731254
XX2_M7 op s1r_XX2_M7_g s1r_XX2_M7_s VSS sky130_fd_pr__nfet_01v8 L=0.6 W=1.4 NF=1 AD=0.406 AS=0.406 PD=3.38 PS=3.38 NRD=0.207143 NRS=0.207143 SA=0 SB=0 SD=0 MULT=36 M=36
Rpar_s1_XX2_M7_s s1r_XX2_M7_s x2_m4d 0.712243
Rpar_s1_XX2_M7_g s1r_XX2_M7_g bias_d 0.731254
XX2_M3 s1r_XX2_M3_d bias_a s1r_XX2_M3_s VSS sky130_fd_pr__nfet_01v8 L=0.6 W=1.4 NF=1 AD=0.406 AS=0.406 PD=3.38 PS=3.38 NRD=0.207143 NRS=0.207143 SA=0 SB=0 SD=0 MULT=36 M=36
Rpar_s1_XX2_M3_s s1r_XX2_M3_s VSS 0.712243
Rpar_s1_XX2_M3_d s1r_XX2_M3_d x2_m3d 0.712243
XX2_M4 s1r_XX2_M4_d bias_a s1r_XX2_M4_s VSS sky130_fd_pr__nfet_01v8 L=0.6 W=1.4 NF=1 AD=0.406 AS=0.406 PD=3.38 PS=3.38 NRD=0.207143 NRS=0.207143 SA=0 SB=0 SD=0 MULT=36 M=36
Rpar_s1_XX2_M4_s s1r_XX2_M4_s VSS 0.712243
Rpar_s1_XX2_M4_d s1r_XX2_M4_d x2_m4d 0.712243
XX2_M82 x2_foldn x2_foldn x2_foldn VDD sky130_fd_pr__pfet_01v8 L=0.6 W=1.4 NF=1 AD=0.406 AS=0.406 PD=3.38 PS=3.38 NRD=0.207143 NRS=0.207143 SA=0 SB=0 SD=0 MULT=2 M=2
XX2_M83 x2_foldp x2_foldp x2_foldp VDD sky130_fd_pr__pfet_01v8 L=0.6 W=1.4 NF=1 AD=0.406 AS=0.406 PD=3.38 PS=3.38 NRD=0.207143 NRS=0.207143 SA=0 SB=0 SD=0 MULT=2 M=2
XX2_M55 x2_foldn VDD VDD VDD sky130_fd_pr__pfet_01v8 L=0.6 W=1.4 NF=1 AD=0.406 AS=0.406 PD=3.38 PS=3.38 NRD=0.207143 NRS=0.207143 SA=0 SB=0 SD=0 MULT=2 M=2
XX2_M56 op VDD VDD VDD sky130_fd_pr__pfet_01v8 L=0.6 W=1.4 NF=1 AD=0.406 AS=0.406 PD=3.38 PS=3.38 NRD=0.207143 NRS=0.207143 SA=0 SB=0 SD=0 MULT=4 M=4
XX2_M61 x2_foldp VDD VDD VDD sky130_fd_pr__pfet_01v8 L=0.6 W=1.4 NF=1 AD=0.406 AS=0.406 PD=3.38 PS=3.38 NRD=0.207143 NRS=0.207143 SA=0 SB=0 SD=0 MULT=2 M=2
XX2_M62 on VDD VDD VDD sky130_fd_pr__pfet_01v8 L=0.6 W=1.4 NF=1 AD=0.406 AS=0.406 PD=3.38 PS=3.38 NRD=0.207143 NRS=0.207143 SA=0 SB=0 SD=0 MULT=4 M=4
XX2_M40 x2_m4d VSS VSS VSS sky130_fd_pr__nfet_01v8 L=0.6 W=1.4 NF=1 AD=0.406 AS=0.406 PD=3.38 PS=3.38 NRD=0.207143 NRS=0.207143 SA=0 SB=0 SD=0 MULT=6 M=6
XX2_M41 x2_m3d VSS VSS VSS sky130_fd_pr__nfet_01v8 L=0.6 W=1.4 NF=1 AD=0.406 AS=0.406 PD=3.38 PS=3.38 NRD=0.207143 NRS=0.207143 SA=0 SB=0 SD=0 MULT=8 M=8
XX2_M38 op op op VSS sky130_fd_pr__nfet_01v8 L=0.6 W=1.4 NF=1 AD=0.406 AS=0.406 PD=3.38 PS=3.38 NRD=0.207143 NRS=0.207143 SA=0 SB=0 SD=0 MULT=2 M=2
XX2_M39 on on on VSS sky130_fd_pr__nfet_01v8 L=0.6 W=1.4 NF=1 AD=0.406 AS=0.406 PD=3.38 PS=3.38 NRD=0.207143 NRS=0.207143 SA=0 SB=0 SD=0 MULT=2 M=2
XX2_M30 x2_tail VSS VSS VSS sky130_fd_pr__nfet_01v8 L=0.6 W=1.4 NF=1 AD=0.406 AS=0.406 PD=3.38 PS=3.38 NRD=0.207143 NRS=0.207143 SA=0 SB=0 SD=0 MULT=2 M=2
XX2_M23 x2_foldp x2_foldp x2_foldp VSS sky130_fd_pr__nfet_01v8_lvt L=0.2 W=1.2 NF=1 AD=0.348 AS=0.348 PD=2.98 PS=2.98 NRD=0.241667 NRS=0.241667 SA=0 SB=0 SD=0 MULT=2 M=2
XX2_M24 x2_foldn x2_foldn x2_foldn VSS sky130_fd_pr__nfet_01v8_lvt L=0.2 W=1.2 NF=1 AD=0.348 AS=0.348 PD=2.98 PS=2.98 NRD=0.241667 NRS=0.241667 SA=0 SB=0 SD=0 MULT=2 M=2
XX2_M80 op VSS VSS VSS sky130_fd_pr__nfet_01v8 L=0.6 W=1.4 NF=1 AD=0.406 AS=0.406 PD=3.38 PS=3.38 NRD=0.207143 NRS=0.207143 SA=0 SB=0 SD=0 MULT=2 M=2
XX2_M81 on VSS VSS VSS sky130_fd_pr__nfet_01v8 L=0.6 W=1.4 NF=1 AD=0.406 AS=0.406 PD=3.38 PS=3.38 NRD=0.207143 NRS=0.207143 SA=0 SB=0 SD=0 MULT=2 M=2
XX2_M28 x2_tail x2_tail x2_tail VSS sky130_fd_pr__nfet_01v8 L=0.6 W=1.4 NF=1 AD=0.406 AS=0.406 PD=3.38 PS=3.38 NRD=0.207143 NRS=0.207143 SA=0 SB=0 SD=0 MULT=6 M=6
XM43 VDD VDD VDD VDD sky130_fd_pr__pfet_01v8_lvt L=0.6 W=1.4 NF=1 AD=0.406 AS=0.406 PD=3.38 PS=3.38 NRD=0.207143 NRS=0.207143 SA=0 SB=0 SD=0 MULT=8 M=8
XM45 VDD VDD VDD VDD sky130_fd_pr__pfet_01v8 L=0.6 W=1.4 NF=1 AD=0.406 AS=0.406 PD=3.38 PS=3.38 NRD=0.207143 NRS=0.207143 SA=0 SB=0 SD=0 MULT=6 M=6
XM9 VSS VSS VSS VSS sky130_fd_pr__nfet_01v8 L=0.6 W=1.4 NF=1 AD=0.406 AS=0.406 PD=3.38 PS=3.38 NRD=0.207143 NRS=0.207143 SA=0 SB=0 SD=0 MULT=23 M=23
Ibias_ext VDD i_bias 3e-05
XC3 op cmc sky130_fd_pr__cap_mim_m3_1 W=4.8 L=4.8 MF=4 M=4
XC4 on cmc sky130_fd_pr__cap_mim_m3_1 W=4.8 L=4.8 MF=4 M=4
.ends iadc_ota
.end
