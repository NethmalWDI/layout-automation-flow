* example_ota_5t on diso_amp_OP
.lib $PDK_ROOT/sky130A/libs.tech/combined/sky130.lib.spice tt
.param VDD_V=1.8 VCM_V=0.9 CL_F=1p
.temp 27

** sch_path: /foss/designs/PROJECTS/llm-analog-sizing/testbenches/diso_amp_OP.sch
**.subckt diso_amp_OP
x1 INP INN net1 VDD 0 OUT dut_amp
Vinp INP 0 'VCM_V'
Vinn INN 0 'VCM_V'
Cload OUT 0 'CL_F'
* noconn #net1
Vsup VDD 0 'VDD_V'
**** begin user architecture code

.control
  save all
  op

  * supply current [uA], supply power [uW], output operating point [V]
  let isup    = abs(i(vsup))
  let isup_ua = isup * 1e6
  let power_uw = isup * v(VDD) * 1e6
  let vout_v  = v(OUT)

  echo MEAS isup_ua $&isup_ua
  echo MEAS power_uw $&power_uw
  echo MEAS vout_v $&vout_v

  write
  quit 0
.endc

**** end user architecture code
**.ends

* expanding   symbol:  dut_amp.sym # of pins=6
** sym_path: /foss/designs/PROJECTS/llm-analog-sizing/testbenches/dut_amp.sym
** sch_path: /foss/designs/PROJECTS/llm-analog-sizing/testbenches/dut_amp.sch
.subckt dut_amp INP INN OUTN VDD VSS OUTP
XDUT VDD OUTP INP INN VSS example_ota_5t_sized
.ends

.subckt example_ota_5t_sized VDD OUTP INP INN VSS
Cbud_s2_0 OUTP VSS 3.75937f
Cbud_s2_1 net1 VSS 8.74065f
Cbud_s2_2 net3 VSS 69.6592f
Cbud_s2_3 OUTP net1 2.63088f
Cbud_s2_4 OUTP net3 1.77375f
Cbud_s2_5 OUTP INP 1.0358f
Cbud_s2_6 OUTP INN 1.05615f
Cbud_s2_7 net1 net3 10.6462f
Cbud_s2_8 net1 INP 6.28604f
Cbud_s2_9 net1 INN 6.28604f
Cbud_s2_10 net3 INP 6.28604f
Cbud_s2_11 net3 INN 1.99834f
XM3 s1r_XM3_d s1r_XM3_g s1r_XM3_s VDD sky130_fd_pr__pfet_01v8 L=1 W=8 NF=1 AD=2.32 AS=2.32 PD=16.58 PS=16.58 NRD=0.03625 NRS=0.03625 SA=0 SB=0 SD=0 MULT=1
Rpar_s1_XM3_s s1r_XM3_s VDD 33.1773
Rpar_s1_XM3_g s1r_XM3_g net3 783.289
Rpar_s1_XM3_d s1r_XM3_d net3 331.773
XM4 s1r_XM4_d s1r_XM4_g s1r_XM4_s VDD sky130_fd_pr__pfet_01v8 L=1 W=8 NF=1 AD=2.32 AS=2.32 PD=16.58 PS=16.58 NRD=0.03625 NRS=0.03625 SA=0 SB=0 SD=0 MULT=1
Rpar_s1_XM4_s s1r_XM4_s VDD 33.1773
Rpar_s1_XM4_g s1r_XM4_g net3 783.289
Rpar_s1_XM4_d s1r_XM4_d OUTP 331.773
XM1 s1r_XM1_d s1r_XM1_g s1r_XM1_s VSS sky130_fd_pr__nfet_01v8 L=0.5 W=24 NF=1 AD=6.96 AS=6.96 PD=48.58 PS=48.58 NRD=0.0120833333333333 NRS=0.0120833333333333 SA=0 SB=0 SD=0 MULT=1
Rpar_s1_XM1_s s1r_XM1_s net1 20.6551
Rpar_s1_XM1_g s1r_XM1_g INP 286.102
Rpar_s1_XM1_d s1r_XM1_d net3 20.6551
XM2 s1r_XM2_d s1r_XM2_g s1r_XM2_s VSS sky130_fd_pr__nfet_01v8 L=0.5 W=24 NF=1 AD=6.96 AS=6.96 PD=48.58 PS=48.58 NRD=0.0120833333333333 NRS=0.0120833333333333 SA=0 SB=0 SD=0 MULT=1
Rpar_s1_XM2_s s1r_XM2_s net1 20.6551
Rpar_s1_XM2_g s1r_XM2_g INN 286.102
Rpar_s1_XM2_d s1r_XM2_d OUTP 20.6551
XM5 s1r_XM5_d s1r_XM5_g s1r_XM5_s VSS sky130_fd_pr__nfet_01v8 L=1 W=24 NF=1 AD=6.96 AS=6.96 PD=48.58 PS=48.58 NRD=0.0120833333333333 NRS=0.0120833333333333 SA=0 SB=0 SD=0 MULT=1
Rpar_s1_XM5_s s1r_XM5_s VSS 18.8703
Rpar_s1_XM5_g s1r_XM5_g net2 329.161
Rpar_s1_XM5_d s1r_XM5_d net1 24.8656
V1 net2 VSS 0.75
.ends example_ota_5t_sized
.end
