* example_ota_5t on diso_amp_NOISE
.lib $PDK_ROOT/sky130A/libs.tech/combined/sky130.lib.spice tt
.param VDD_V=1.8 VCM_V=0.9 CL_F=1p
.temp 27

** sch_path: /foss/designs/PROJECTS/llm-analog-sizing/testbenches/diso_amp_NOISE.sch
**.subckt diso_amp_NOISE
x1 INP INN net1 VDD 0 OUT dut_amp
Vsup VDD 0 'VDD_V'
Vinp INP 0 dc 'VCM_V' ac 1
Vinn INN 0 'VCM_V'
Cload OUT 0 'CL_F'
* noconn #net1
**** begin user architecture code

.control
  save all

  * sweep settings -- fspot must lie on the grid, which it does by construction
  let npd    = 20
  let fstart = 1
  let fstop  = 1e9
  let fspot  = 1e3

  noise v(OUT) Vinp dec 20 1 1e9

  * input-referred voltage noise density [nV/sqrt(Hz)] at fspot.
  * meas does not work on noise plots, so index the vector directly:
  * index = points-per-decade * log10(fspot / fstart).
  setplot noise1
  let idx = npd * log10(fspot/fstart)
  let vnoise_nv_rthz = inoise_spectrum[$&idx] * 1e9
  echo MEAS vnoise_nv_rthz $&vnoise_nv_rthz
  write
  set appendwrite

  * total input-referred noise integrated over the sweep [uVrms]
  setplot noise2
  let vnoise_rms_uv_rms = inoise_total * 1e6
  echo MEAS vnoise_rms_uv_rms $&vnoise_rms_uv_rms
  write

  quit 0
.endc

**** end user architecture code
**.ends

* expanding   symbol:  dut_amp.sym # of pins=6
** sym_path: /foss/designs/PROJECTS/llm-analog-sizing/testbenches/dut_amp.sym
** sch_path: /foss/designs/PROJECTS/llm-analog-sizing/testbenches/dut_amp.sch
.subckt dut_amp INP INN OUTN VDD VSS OUTP
XDUT VDD OUTP INP INN VSS example_ota_5t_sized
.ends

.subckt example_ota_5t_sized VDD OUTP INP INN VSS
Cbud_s2_0 net3 VSS 45.1568f
Cbud_s2_1 OUTP net3 5.5459f
Cbud_s2_2 OUTP INN 10.5238f
Cbud_s2_3 net1 net3 9.56761f
Cbud_s2_4 net1 INN 10.5238f
Cbud_s2_5 net3 INP 7.47495f
Cbud_s2_6 net3 INN 1.99834f
Cbud_s2_7 OUTP VSS 45.5512f
Cbud_s2_8 net1 VSS 111.427f
Cbud_s2_9 OUTP net1 14.5906f
Cbud_s2_10 OUTP INP 1.99834f
Cbud_s2_11 net1 INP 10.5238f
XM3 s1r_XM3_d s1r_XM3_g s1r_XM3_s VDD sky130_fd_pr__pfet_01v8 L=1 W=8 NF=1 AD=2.32 AS=2.32 PD=16.58 PS=16.58 NRD=0.03625 NRS=0.03625 SA=0 SB=0 SD=0 MULT=1
Rpar_s1_XM3_g s1r_XM3_g net3 783.289
Rpar_s1_XM3_d s1r_XM3_d net3 331.773
Rpar_s1_XM3_s s1r_XM3_s VDD 145.886
XM4 s1r_XM4_d s1r_XM4_g s1r_XM4_s VDD sky130_fd_pr__pfet_01v8 L=1 W=8 NF=1 AD=2.32 AS=2.32 PD=16.58 PS=16.58 NRD=0.03625 NRS=0.03625 SA=0 SB=0 SD=0 MULT=1
Rpar_s1_XM4_g s1r_XM4_g net3 783.289
Rpar_s1_XM4_d s1r_XM4_d OUTP 331.773
Rpar_s1_XM4_s s1r_XM4_s VDD 145.886
XM1 s1r_XM1_d s1r_XM1_g s1r_XM1_s VSS sky130_fd_pr__nfet_01v8 L=0.5 W=24 NF=1 AD=6.96 AS=6.96 PD=48.58 PS=48.58 NRD=0.0120833333333333 NRS=0.0120833333333333 SA=0 SB=0 SD=0 MULT=1
Rpar_s1_XM1_g s1r_XM1_g INP 1664.52
Rpar_s1_XM1_s s1r_XM1_s net1 84.7092
Rpar_s1_XM1_d s1r_XM1_d net3 177.006
XM2 s1r_XM2_d s1r_XM2_g s1r_XM2_s VSS sky130_fd_pr__nfet_01v8 L=0.5 W=24 NF=1 AD=6.96 AS=6.96 PD=48.58 PS=48.58 NRD=0.0120833333333333 NRS=0.0120833333333333 SA=0 SB=0 SD=0 MULT=1
Rpar_s1_XM2_g s1r_XM2_g INN 1664.52
Rpar_s1_XM2_s s1r_XM2_s net1 84.7092
Rpar_s1_XM2_d s1r_XM2_d OUTP 177.006
XM5 s1r_XM5_d s1r_XM5_g s1r_XM5_s VSS sky130_fd_pr__nfet_01v8 L=1 W=24 NF=1 AD=6.96 AS=6.96 PD=48.58 PS=48.58 NRD=0.0120833333333333 NRS=0.0120833333333333 SA=0 SB=0 SD=0 MULT=1
Rpar_s1_XM5_s s1r_XM5_s VSS 200.066
Rpar_s1_XM5_g s1r_XM5_g net2 1496
Rpar_s1_XM5_d s1r_XM5_d net1 75.8837
V1 net2 VSS 0.75
.ends example_ota_5t_sized
.end
