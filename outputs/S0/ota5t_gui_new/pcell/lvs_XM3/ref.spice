.subckt XM3 D G S B
XXM3 D G S B sky130_fd_pr__pfet_01v8 L=1 W=8 nf=1
.ends
