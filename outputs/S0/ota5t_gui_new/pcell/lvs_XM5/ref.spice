.subckt XM5 D G S B
XXM5 D G S B sky130_fd_pr__nfet_01v8 L=1 W=24 nf=1
.ends
