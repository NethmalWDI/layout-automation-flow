* NGSPICE file created from sky130_fd_pr__pfet_01v8_3MKYCW.ext - technology: sky130A

.subckt sky130_fd_pr__pfet_01v8_3MKYCW B D S G
X0 S G D B sky130_fd_pr__pfet_01v8 ad=2.32 pd=16.58 as=2.32 ps=16.58 w=8 l=1
.ends
