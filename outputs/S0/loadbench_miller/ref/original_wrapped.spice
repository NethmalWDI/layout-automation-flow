* loadbench_miller: LOADBench SimpleTwoStageOpAmp_SimpleOpAmp1_1, FinalPOFfull.csv row 546 (0-based), generated by scripts/make_loadbench_package.py
.subckt loadbench_miller in1 in2 out sourceNmos sourcePmos
*.ipin in1
*.ipin in2
*.opin out
*.iopin sourceNmos
*.iopin sourcePmos
XDiodeTransistorNmos1 FirstStageYout1 FirstStageYout1 sourceNmos sourceNmos sky130_fd_pr__nfet_01v8_lvt L=2.03 W=66.13 nf=1 ad=19.1777 as=19.1777 pd=132.84 ps=132.84 nrd=0.0043853 nrs=0.0043853 sa=0 sb=0 sd=0 mult=1
XDiodeTransistorPmos2 ibias ibias sourcePmos sourcePmos sky130_fd_pr__pfet_01v8_lvt L=0.74 W=37.3 nf=1 ad=10.817 as=10.817 pd=75.18 ps=75.18 nrd=0.0077748 nrs=0.0077748 sa=0 sb=0 sd=0 mult=1
XNormalTransistorNmos3 out outFirstStage sourceNmos sourceNmos sky130_fd_pr__nfet_01v8_lvt L=0.24 W=484.2 nf=1 ad=140.418 as=140.418 pd=968.98 ps=968.98 nrd=0.000598926 nrs=0.000598926 sa=0 sb=0 sd=0 mult=1
XNormalTransistorNmos4 outFirstStage FirstStageYout1 sourceNmos sourceNmos sky130_fd_pr__nfet_01v8_lvt L=2.03 W=66.13 nf=1 ad=19.1777 as=19.1777 pd=132.84 ps=132.84 nrd=0.0043853 nrs=0.0043853 sa=0 sb=0 sd=0 mult=1
XNormalTransistorPmos5 out ibias sourcePmos sourcePmos sky130_fd_pr__pfet_01v8_lvt L=0.74 W=887.03 nf=1 ad=257.239 as=257.239 pd=1774.64 ps=1774.64 nrd=0.000326934 nrs=0.000326934 sa=0 sb=0 sd=0 mult=1
XNormalTransistorPmos6 outFirstStage in2 FirstStageYsourceTransconductance FirstStageYsourceTransconductance sky130_fd_pr__pfet_01v8_lvt L=0.89 W=14.21 nf=1 ad=4.1209 as=4.1209 pd=29 ps=29 nrd=0.0204082 nrs=0.0204082 sa=0 sb=0 sd=0 mult=1
XNormalTransistorPmos7 FirstStageYout1 in1 FirstStageYsourceTransconductance FirstStageYsourceTransconductance sky130_fd_pr__pfet_01v8_lvt L=0.89 W=14.21 nf=1 ad=4.1209 as=4.1209 pd=29 ps=29 nrd=0.0204082 nrs=0.0204082 sa=0 sb=0 sd=0 mult=1
XNormalTransistorPmos8 FirstStageYsourceTransconductance ibias sourcePmos sourcePmos sky130_fd_pr__pfet_01v8_lvt L=0.74 W=90.63 nf=1 ad=26.2827 as=26.2827 pd=181.84 ps=181.84 nrd=0.00319982 nrs=0.00319982 sa=0 sb=0 sd=0 mult=1
Capacitor2 outFirstStage out 5e-13
Ibias ibias sourceNmos 1e-05
.ends loadbench_miller
