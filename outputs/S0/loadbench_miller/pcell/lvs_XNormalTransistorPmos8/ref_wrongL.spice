.subckt XNormalTransistorPmos8 D G S B
XXNormalTransistorPmos8 D G S B sky130_fd_pr__pfet_01v8_lvt L=0.84 W=90.63 nf=1
.ends
