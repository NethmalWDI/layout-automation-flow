.subckt XNormalTransistorPmos7 D G S B
XXNormalTransistorPmos7 D G S B sky130_fd_pr__pfet_01v8_lvt L=0.89 W=14.21 nf=1
.ends
