* NGSPICE file created from sky130_fd_pr__nfet_01v8_lvt_CB9SYW.ext - technology: sky130A

.subckt sky130_fd_pr__nfet_01v8_lvt_CB9SYW B D S G
X0 S G D B sky130_fd_pr__nfet_01v8_lvt ad=140.418 pd=968.97998 as=140.418 ps=968.97998 w=484.20001 l=0.24
.ends
