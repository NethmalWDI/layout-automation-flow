.subckt XNormalTransistorNmos3 D G S B
XXNormalTransistorNmos3 D G S B sky130_fd_pr__nfet_01v8_lvt L=0.34 W=484.2 nf=1
.ends
