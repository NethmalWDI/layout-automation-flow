.subckt XNormalTransistorPmos6 D G S B
XXNormalTransistorPmos6 D G S B sky130_fd_pr__pfet_01v8_lvt L=0.99 W=14.21 nf=1
.ends
