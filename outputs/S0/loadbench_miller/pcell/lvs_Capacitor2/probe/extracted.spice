* NGSPICE file created from sky130_fd_pr__cap_mim_m3_1_84GA9G.ext - technology: sky130A

.subckt sky130_fd_pr__cap_mim_m3_1_84GA9G C2 C1
X0 C1 C2 sky130_fd_pr__cap_mim_m3_1 l=15.66 w=15.66
.ends
