.subckt Capacitor2 C2 C1
X0 C1 C2 sky130_fd_pr__cap_mim_m3_1 W=15.66 L=16.66
.ends
