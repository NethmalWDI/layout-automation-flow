.subckt Capacitor2 C1 C2
XCapacitor2 C1 C2 sky130_fd_pr__cap_mim_m3_1 W=15.66 L=15.66
.ends
