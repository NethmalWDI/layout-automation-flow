* NGSPICE file created from sky130_fd_pr__nfet_01v8_lvt_MJG2JG.ext - technology: sky130A

.subckt sky130_fd_pr__nfet_01v8_lvt_MJG2JG B D S G
X0 S G D B sky130_fd_pr__nfet_01v8_lvt ad=19.1777 pd=132.84 as=19.1777 ps=132.84 w=66.13 l=2.03
.ends
