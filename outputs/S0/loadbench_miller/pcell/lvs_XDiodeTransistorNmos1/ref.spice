.subckt XDiodeTransistorNmos1 D G S B
XXDiodeTransistorNmos1 D G S B sky130_fd_pr__nfet_01v8_lvt L=2.03 W=66.13 nf=1
.ends
