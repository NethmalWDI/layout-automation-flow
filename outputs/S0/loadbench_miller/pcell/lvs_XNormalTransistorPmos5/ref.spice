.subckt XNormalTransistorPmos5 D G S B
XXNormalTransistorPmos5 D G S B sky130_fd_pr__pfet_01v8_lvt L=0.74 W=887.03 nf=1
.ends
