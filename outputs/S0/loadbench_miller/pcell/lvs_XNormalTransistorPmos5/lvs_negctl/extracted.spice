* NGSPICE file created from sky130_fd_pr__pfet_01v8_lvt_NJH8M9.ext - technology: sky130A

.subckt sky130_fd_pr__pfet_01v8_lvt_NJH8M9 B D S G
X0 S G D B sky130_fd_pr__pfet_01v8_lvt ad=257.23871 pd=1.77464k as=257.23871 ps=1.77464k w=887.03003 l=0.74
.ends
