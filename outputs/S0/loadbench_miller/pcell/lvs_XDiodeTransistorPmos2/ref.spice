.subckt XDiodeTransistorPmos2 D G S B
XXDiodeTransistorPmos2 D G S B sky130_fd_pr__pfet_01v8_lvt L=0.74 W=37.3 nf=1
.ends
