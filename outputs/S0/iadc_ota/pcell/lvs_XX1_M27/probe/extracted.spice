* NGSPICE file created from sky130_fd_pr__nfet_01v8_lvt_MXVJ7T.ext - technology: sky130A

.subckt sky130_fd_pr__nfet_01v8_lvt_MXVJ7T B D0 S0 G0 D1 S1 G1 D2 S2 G2 D3 S3 G3 D4
+ S4 G4 D5 S5 G5 D6 S6 G6 D7 S7 G7
X0 S0 G0 D0 B sky130_fd_pr__nfet_01v8_lvt ad=0.406 pd=3.38 as=0.406 ps=3.38 w=1.4 l=0.6
X1 S5 G5 D5 B sky130_fd_pr__nfet_01v8_lvt ad=0.406 pd=3.38 as=0.406 ps=3.38 w=1.4 l=0.6
X2 S7 G7 D7 B sky130_fd_pr__nfet_01v8_lvt ad=0.406 pd=3.38 as=0.406 ps=3.38 w=1.4 l=0.6
X3 S2 G2 D2 B sky130_fd_pr__nfet_01v8_lvt ad=0.406 pd=3.38 as=0.406 ps=3.38 w=1.4 l=0.6
X4 S1 G1 D1 B sky130_fd_pr__nfet_01v8_lvt ad=0.406 pd=3.38 as=0.406 ps=3.38 w=1.4 l=0.6
X5 S4 G4 D4 B sky130_fd_pr__nfet_01v8_lvt ad=0.406 pd=3.38 as=0.406 ps=3.38 w=1.4 l=0.6
X6 S6 G6 D6 B sky130_fd_pr__nfet_01v8_lvt ad=0.406 pd=3.38 as=0.406 ps=3.38 w=1.4 l=0.6
X7 S3 G3 D3 B sky130_fd_pr__nfet_01v8_lvt ad=0.406 pd=3.38 as=0.406 ps=3.38 w=1.4 l=0.6
.ends
