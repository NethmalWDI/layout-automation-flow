.subckt XX1_M74 D G S B
XXX1_M74 D G S B sky130_fd_pr__nfet_01v8 L=0.6 W=1.4 nf=1
.ends
