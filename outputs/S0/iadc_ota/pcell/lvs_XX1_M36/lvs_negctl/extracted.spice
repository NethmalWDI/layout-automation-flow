* NGSPICE file created from sky130_fd_pr__nfet_01v8_47F3GR.ext - technology: sky130A

.subckt sky130_fd_pr__nfet_01v8_47F3GR B D0 S0 G0 D1 S1 G1 D2 S2 G2 D3 S3 G3
X0 S1 G1 D1 B sky130_fd_pr__nfet_01v8 ad=0.406 pd=3.38 as=0.406 ps=3.38 w=1.4 l=0.6
X1 S3 G3 D3 B sky130_fd_pr__nfet_01v8 ad=0.406 pd=3.38 as=0.406 ps=3.38 w=1.4 l=0.6
X2 S0 G0 D0 B sky130_fd_pr__nfet_01v8 ad=0.406 pd=3.38 as=0.406 ps=3.38 w=1.4 l=0.6
X3 S2 G2 D2 B sky130_fd_pr__nfet_01v8 ad=0.406 pd=3.38 as=0.406 ps=3.38 w=1.4 l=0.6
.ends
