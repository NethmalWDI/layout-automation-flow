* NGSPICE file created from sky130_fd_pr__cap_mim_m3_1_MX4MQY.ext - technology: sky130A

.subckt sky130_fd_pr__cap_mim_m3_1_MX4MQY C2_0 C1_0 C2_1 C1_1 C2_2 C1_2 C2_3 C1_3
X0 C1_0 C2_0 sky130_fd_pr__cap_mim_m3_1 l=4.8 w=4.8
X1 C1_2 C2_2 sky130_fd_pr__cap_mim_m3_1 l=4.8 w=4.8
X2 C1_1 C2_1 sky130_fd_pr__cap_mim_m3_1 l=4.8 w=4.8
X3 C1_3 C2_3 sky130_fd_pr__cap_mim_m3_1 l=4.8 w=4.8
.ends
