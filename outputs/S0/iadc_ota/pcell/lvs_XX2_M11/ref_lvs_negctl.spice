.subckt XX2_M11 B D0 S0 G0 D1 S1 G1 D2 S2 G2 D3 S3 G3 D4 S4 G4 D5 S5 G5 D6 S6 G6 D7 S7 G7 D8 S8 G8 D9 S9 G9 D10 S10 G10 D11 S11 G11 D12 S12 G12 D13 S13 G13 D14 S14 G14 D15 S15 G15 D16 S16 G16 D17 S17 G17 D18 S18 G18 D19 S19 G19 D20 S20 G20 D21 S21 G21 D22 S22 G22 D23 S23 G23
X0 S12 G12 D12 B sky130_fd_pr__pfet_01v8_lvt W=1.4 L=0.7 nf=1
X1 S6 G6 D6 B sky130_fd_pr__pfet_01v8_lvt W=1.4 L=0.7 nf=1
X2 S3 G3 D3 B sky130_fd_pr__pfet_01v8_lvt W=1.4 L=0.7 nf=1
X3 S22 G22 D22 B sky130_fd_pr__pfet_01v8_lvt W=1.4 L=0.7 nf=1
X4 S11 G11 D11 B sky130_fd_pr__pfet_01v8_lvt W=1.4 L=0.7 nf=1
X5 S19 G19 D19 B sky130_fd_pr__pfet_01v8_lvt W=1.4 L=0.7 nf=1
X6 S16 G16 D16 B sky130_fd_pr__pfet_01v8_lvt W=1.4 L=0.7 nf=1
X7 S8 G8 D8 B sky130_fd_pr__pfet_01v8_lvt W=1.4 L=0.7 nf=1
X8 S0 G0 D0 B sky130_fd_pr__pfet_01v8_lvt W=1.4 L=0.7 nf=1
X9 S20 G20 D20 B sky130_fd_pr__pfet_01v8_lvt W=1.4 L=0.7 nf=1
X10 S17 G17 D17 B sky130_fd_pr__pfet_01v8_lvt W=1.4 L=0.7 nf=1
X11 S10 G10 D10 B sky130_fd_pr__pfet_01v8_lvt W=1.4 L=0.7 nf=1
X12 S14 G14 D14 B sky130_fd_pr__pfet_01v8_lvt W=1.4 L=0.7 nf=1
X13 S13 G13 D13 B sky130_fd_pr__pfet_01v8_lvt W=1.4 L=0.7 nf=1
X14 S5 G5 D5 B sky130_fd_pr__pfet_01v8_lvt W=1.4 L=0.7 nf=1
X15 S4 G4 D4 B sky130_fd_pr__pfet_01v8_lvt W=1.4 L=0.7 nf=1
X16 S2 G2 D2 B sky130_fd_pr__pfet_01v8_lvt W=1.4 L=0.7 nf=1
X17 S23 G23 D23 B sky130_fd_pr__pfet_01v8_lvt W=1.4 L=0.7 nf=1
X18 S18 G18 D18 B sky130_fd_pr__pfet_01v8_lvt W=1.4 L=0.7 nf=1
X19 S15 G15 D15 B sky130_fd_pr__pfet_01v8_lvt W=1.4 L=0.7 nf=1
X20 S1 G1 D1 B sky130_fd_pr__pfet_01v8_lvt W=1.4 L=0.7 nf=1
X21 S9 G9 D9 B sky130_fd_pr__pfet_01v8_lvt W=1.4 L=0.7 nf=1
X22 S7 G7 D7 B sky130_fd_pr__pfet_01v8_lvt W=1.4 L=0.7 nf=1
X23 S21 G21 D21 B sky130_fd_pr__pfet_01v8_lvt W=1.4 L=0.7 nf=1
.ends
