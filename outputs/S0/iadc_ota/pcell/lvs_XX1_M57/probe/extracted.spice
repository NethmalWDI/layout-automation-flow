* NGSPICE file created from sky130_fd_pr__pfet_01v8_RGP69F.ext - technology: sky130A

.subckt sky130_fd_pr__pfet_01v8_RGP69F B D0 S0 G0 D1 S1 G1
X0 S1 G1 D1 B sky130_fd_pr__pfet_01v8 ad=0.406 pd=3.38 as=0.406 ps=3.38 w=1.4 l=0.6
X1 S0 G0 D0 B sky130_fd_pr__pfet_01v8 ad=0.406 pd=3.38 as=0.406 ps=3.38 w=1.4 l=0.6
.ends
