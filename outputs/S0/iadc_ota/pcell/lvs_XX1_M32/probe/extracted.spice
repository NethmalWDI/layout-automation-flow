* NGSPICE file created from sky130_fd_pr__pfet_01v8_DUQYQ2.ext - technology: sky130A

.subckt sky130_fd_pr__pfet_01v8_DUQYQ2 B D0 S0 G0 D1 S1 G1 D2 S2 G2 D3 S3 G3 D4 S4
+ G4 D5 S5 G5
X0 S3 G3 D3 B sky130_fd_pr__pfet_01v8 ad=0.406 pd=3.38 as=0.406 ps=3.38 w=1.4 l=0.6
X1 S2 G2 D2 B sky130_fd_pr__pfet_01v8 ad=0.406 pd=3.38 as=0.406 ps=3.38 w=1.4 l=0.6
X2 S1 G1 D1 B sky130_fd_pr__pfet_01v8 ad=0.406 pd=3.38 as=0.406 ps=3.38 w=1.4 l=0.6
X3 S5 G5 D5 B sky130_fd_pr__pfet_01v8 ad=0.406 pd=3.38 as=0.406 ps=3.38 w=1.4 l=0.6
X4 S4 G4 D4 B sky130_fd_pr__pfet_01v8 ad=0.406 pd=3.38 as=0.406 ps=3.38 w=1.4 l=0.6
X5 S0 G0 D0 B sky130_fd_pr__pfet_01v8 ad=0.406 pd=3.38 as=0.406 ps=3.38 w=1.4 l=0.6
.ends
