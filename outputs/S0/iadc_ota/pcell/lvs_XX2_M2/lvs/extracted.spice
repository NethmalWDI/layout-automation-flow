* NGSPICE file created from sky130_fd_pr__nfet_01v8_lvt_B2YEUL.ext - technology: sky130A

.subckt sky130_fd_pr__nfet_01v8_lvt_B2YEUL B D0 S0 G0 D1 S1 G1 D2 S2 G2 D3 S3 G3 D4
+ S4 G4 D5 S5 G5
X0 S4 G4 D4 B sky130_fd_pr__nfet_01v8_lvt ad=0.348 pd=2.98 as=0.348 ps=2.98 w=1.2 l=0.2
X1 S2 G2 D2 B sky130_fd_pr__nfet_01v8_lvt ad=0.348 pd=2.98 as=0.348 ps=2.98 w=1.2 l=0.2
X2 S1 G1 D1 B sky130_fd_pr__nfet_01v8_lvt ad=0.348 pd=2.98 as=0.348 ps=2.98 w=1.2 l=0.2
X3 S0 G0 D0 B sky130_fd_pr__nfet_01v8_lvt ad=0.348 pd=2.98 as=0.348 ps=2.98 w=1.2 l=0.2
X4 S5 G5 D5 B sky130_fd_pr__nfet_01v8_lvt ad=0.348 pd=2.98 as=0.348 ps=2.98 w=1.2 l=0.2
X5 S3 G3 D3 B sky130_fd_pr__nfet_01v8_lvt ad=0.348 pd=2.98 as=0.348 ps=2.98 w=1.2 l=0.2
.ends
