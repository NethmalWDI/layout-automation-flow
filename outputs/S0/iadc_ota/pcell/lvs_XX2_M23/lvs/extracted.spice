* NGSPICE file created from sky130_fd_pr__nfet_01v8_lvt_RLUWJZ.ext - technology: sky130A

.subckt sky130_fd_pr__nfet_01v8_lvt_RLUWJZ B D0 S0 G0 D1 S1 G1
X0 S0 G0 D0 B sky130_fd_pr__nfet_01v8_lvt ad=0.348 pd=2.98 as=0.348 ps=2.98 w=1.2 l=0.2
X1 S1 G1 D1 B sky130_fd_pr__nfet_01v8_lvt ad=0.348 pd=2.98 as=0.348 ps=2.98 w=1.2 l=0.2
.ends
