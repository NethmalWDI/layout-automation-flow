.subckt XX1_M2 B D0 S0 G0 D1 S1 G1 D2 S2 G2 D3 S3 G3 D4 S4 G4 D5 S5 G5 D6 S6 G6 D7 S7 G7 D8 S8 G8 D9 S9 G9 D10 S10 G10 D11 S11 G11 D12 S12 G12 D13 S13 G13 D14 S14 G14 D15 S15 G15 D16 S16 G16 D17 S17 G17 D18 S18 G18 D19 S19 G19 D20 S20 G20 D21 S21 G21 D22 S22 G22 D23 S23 G23 D24 S24 G24 D25 S25 G25 D26 S26 G26 D27 S27 G27 D28 S28 G28 D29 S29 G29 D30 S30 G30 D31 S31 G31 D32 S32 G32 D33 S33 G33 D34 S34 G34 D35 S35 G35 D36 S36 G36 D37 S37 G37 D38 S38 G38 D39 S39 G39 D40 S40 G40 D41 S41 G41 D42 S42 G42 D43 S43 G43 D44 S44 G44 D45 S45 G45 D46 S46 G46 D47 S47 G47 D48 S48 G48 D49 S49 G49
X0 S35 G35 D35 B sky130_fd_pr__nfet_01v8 W=1.4 L=0.7 nf=1
X1 S24 G24 D24 B sky130_fd_pr__nfet_01v8 W=1.4 L=0.7 nf=1
X2 S11 G11 D11 B sky130_fd_pr__nfet_01v8 W=1.4 L=0.7 nf=1
X3 S31 G31 D31 B sky130_fd_pr__nfet_01v8 W=1.4 L=0.7 nf=1
X4 S15 G15 D15 B sky130_fd_pr__nfet_01v8 W=1.4 L=0.7 nf=1
X5 S43 G43 D43 B sky130_fd_pr__nfet_01v8 W=1.4 L=0.7 nf=1
X6 S8 G8 D8 B sky130_fd_pr__nfet_01v8 W=1.4 L=0.7 nf=1
X7 S1 G1 D1 B sky130_fd_pr__nfet_01v8 W=1.4 L=0.7 nf=1
X8 S48 G48 D48 B sky130_fd_pr__nfet_01v8 W=1.4 L=0.7 nf=1
X9 S39 G39 D39 B sky130_fd_pr__nfet_01v8 W=1.4 L=0.7 nf=1
X10 S12 G12 D12 B sky130_fd_pr__nfet_01v8 W=1.4 L=0.7 nf=1
X11 S30 G30 D30 B sky130_fd_pr__nfet_01v8 W=1.4 L=0.7 nf=1
X12 S42 G42 D42 B sky130_fd_pr__nfet_01v8 W=1.4 L=0.7 nf=1
X13 S16 G16 D16 B sky130_fd_pr__nfet_01v8 W=1.4 L=0.7 nf=1
X14 S9 G9 D9 B sky130_fd_pr__nfet_01v8 W=1.4 L=0.7 nf=1
X15 S2 G2 D2 B sky130_fd_pr__nfet_01v8 W=1.4 L=0.7 nf=1
X16 S47 G47 D47 B sky130_fd_pr__nfet_01v8 W=1.4 L=0.7 nf=1
X17 S38 G38 D38 B sky130_fd_pr__nfet_01v8 W=1.4 L=0.7 nf=1
X18 S20 G20 D20 B sky130_fd_pr__nfet_01v8 W=1.4 L=0.7 nf=1
X19 S13 G13 D13 B sky130_fd_pr__nfet_01v8 W=1.4 L=0.7 nf=1
X20 S34 G34 D34 B sky130_fd_pr__nfet_01v8 W=1.4 L=0.7 nf=1
X21 S17 G17 D17 B sky130_fd_pr__nfet_01v8 W=1.4 L=0.7 nf=1
X22 S41 G41 D41 B sky130_fd_pr__nfet_01v8 W=1.4 L=0.7 nf=1
X23 S5 G5 D5 B sky130_fd_pr__nfet_01v8 W=1.4 L=0.7 nf=1
X24 S46 G46 D46 B sky130_fd_pr__nfet_01v8 W=1.4 L=0.7 nf=1
X25 S29 G29 D29 B sky130_fd_pr__nfet_01v8 W=1.4 L=0.7 nf=1
X26 S3 G3 D3 B sky130_fd_pr__nfet_01v8 W=1.4 L=0.7 nf=1
X27 S21 G21 D21 B sky130_fd_pr__nfet_01v8 W=1.4 L=0.7 nf=1
X28 S37 G37 D37 B sky130_fd_pr__nfet_01v8 W=1.4 L=0.7 nf=1
X29 S14 G14 D14 B sky130_fd_pr__nfet_01v8 W=1.4 L=0.7 nf=1
X30 S26 G26 D26 B sky130_fd_pr__nfet_01v8 W=1.4 L=0.7 nf=1
X31 S40 G40 D40 B sky130_fd_pr__nfet_01v8 W=1.4 L=0.7 nf=1
X32 S33 G33 D33 B sky130_fd_pr__nfet_01v8 W=1.4 L=0.7 nf=1
X33 S28 G28 D28 B sky130_fd_pr__nfet_01v8 W=1.4 L=0.7 nf=1
X34 S18 G18 D18 B sky130_fd_pr__nfet_01v8 W=1.4 L=0.7 nf=1
X35 S6 G6 D6 B sky130_fd_pr__nfet_01v8 W=1.4 L=0.7 nf=1
X36 S45 G45 D45 B sky130_fd_pr__nfet_01v8 W=1.4 L=0.7 nf=1
X37 S4 G4 D4 B sky130_fd_pr__nfet_01v8 W=1.4 L=0.7 nf=1
X38 S36 G36 D36 B sky130_fd_pr__nfet_01v8 W=1.4 L=0.7 nf=1
X39 S23 G23 D23 B sky130_fd_pr__nfet_01v8 W=1.4 L=0.7 nf=1
X40 S22 G22 D22 B sky130_fd_pr__nfet_01v8 W=1.4 L=0.7 nf=1
X41 S10 G10 D10 B sky130_fd_pr__nfet_01v8 W=1.4 L=0.7 nf=1
X42 S32 G32 D32 B sky130_fd_pr__nfet_01v8 W=1.4 L=0.7 nf=1
X43 S25 G25 D25 B sky130_fd_pr__nfet_01v8 W=1.4 L=0.7 nf=1
X44 S19 G19 D19 B sky130_fd_pr__nfet_01v8 W=1.4 L=0.7 nf=1
X45 S44 G44 D44 B sky130_fd_pr__nfet_01v8 W=1.4 L=0.7 nf=1
X46 S27 G27 D27 B sky130_fd_pr__nfet_01v8 W=1.4 L=0.7 nf=1
X47 S7 G7 D7 B sky130_fd_pr__nfet_01v8 W=1.4 L=0.7 nf=1
X48 S0 G0 D0 B sky130_fd_pr__nfet_01v8 W=1.4 L=0.7 nf=1
X49 S49 G49 D49 B sky130_fd_pr__nfet_01v8 W=1.4 L=0.7 nf=1
.ends
