.subckt XX1_M10 B D0 S0 G0 D1 S1 G1 D2 S2 G2 D3 S3 G3 D4 S4 G4 D5 S5 G5 D6 S6 G6 D7 S7 G7
X0 S0 G0 D0 B sky130_fd_pr__nfet_01v8_lvt W=1.4 L=0.7 nf=1
X1 S5 G5 D5 B sky130_fd_pr__nfet_01v8_lvt W=1.4 L=0.7 nf=1
X2 S7 G7 D7 B sky130_fd_pr__nfet_01v8_lvt W=1.4 L=0.7 nf=1
X3 S2 G2 D2 B sky130_fd_pr__nfet_01v8_lvt W=1.4 L=0.7 nf=1
X4 S1 G1 D1 B sky130_fd_pr__nfet_01v8_lvt W=1.4 L=0.7 nf=1
X5 S4 G4 D4 B sky130_fd_pr__nfet_01v8_lvt W=1.4 L=0.7 nf=1
X6 S6 G6 D6 B sky130_fd_pr__nfet_01v8_lvt W=1.4 L=0.7 nf=1
X7 S3 G3 D3 B sky130_fd_pr__nfet_01v8_lvt W=1.4 L=0.7 nf=1
.ends
