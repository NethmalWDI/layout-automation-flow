* NGSPICE file created from sky130_fd_pr__nfet_01v8_YUCGQM.ext - technology: sky130A

.subckt sky130_fd_pr__nfet_01v8_YUCGQM B D S G
X0 S G D B sky130_fd_pr__nfet_01v8 ad=0.406 pd=3.38 as=0.406 ps=3.38 w=1.4 l=0.6
.ends
