.subckt XX2_M5 B D0 S0 G0 D1 S1 G1 D2 S2 G2 D3 S3 G3 D4 S4 G4 D5 S5 G5 D6 S6 G6 D7 S7 G7 D8 S8 G8 D9 S9 G9 D10 S10 G10 D11 S11 G11 D12 S12 G12 D13 S13 G13 D14 S14 G14 D15 S15 G15 D16 S16 G16 D17 S17 G17 D18 S18 G18 D19 S19 G19 D20 S20 G20 D21 S21 G21 D22 S22 G22 D23 S23 G23 D24 S24 G24 D25 S25 G25 D26 S26 G26 D27 S27 G27 D28 S28 G28 D29 S29 G29 D30 S30 G30 D31 S31 G31 D32 S32 G32 D33 S33 G33 D34 S34 G34 D35 S35 G35 D36 S36 G36 D37 S37 G37 D38 S38 G38 D39 S39 G39 D40 S40 G40 D41 S41 G41 D42 S42 G42 D43 S43 G43 D44 S44 G44 D45 S45 G45 D46 S46 G46 D47 S47 G47 D48 S48 G48 D49 S49 G49 D50 S50 G50 D51 S51 G51 D52 S52 G52 D53 S53 G53 D54 S54 G54 D55 S55 G55 D56 S56 G56 D57 S57 G57 D58 S58 G58 D59 S59 G59 D60 S60 G60 D61 S61 G61 D62 S62 G62 D63 S63 G63 D64 S64 G64 D65 S65 G65 D66 S66 G66 D67 S67 G67 D68 S68 G68 D69 S69 G69 D70 S70 G70 D71 S71 G71 D72 S72 G72 D73 S73 G73 D74 S74 G74 D75 S75 G75 D76 S76 G76 D77 S77 G77 D78 S78 G78 D79 S79 G79 D80 S80 G80 D81 S81 G81 D82 S82 G82 D83 S83 G83 D84 S84 G84 D85 S85 G85 D86 S86 G86 D87 S87 G87 D88 S88 G88 D89 S89 G89 D90 S90 G90 D91 S91 G91 D92 S92 G92 D93 S93 G93 D94 S94 G94 D95 S95 G95
X0 S58 G58 D58 B sky130_fd_pr__nfet_01v8 W=1.4 L=0.7 nf=1
X1 S47 G47 D47 B sky130_fd_pr__nfet_01v8 W=1.4 L=0.7 nf=1
X2 S34 G34 D34 B sky130_fd_pr__nfet_01v8 W=1.4 L=0.7 nf=1
X3 S20 G20 D20 B sky130_fd_pr__nfet_01v8 W=1.4 L=0.7 nf=1
X4 S75 G75 D75 B sky130_fd_pr__nfet_01v8 W=1.4 L=0.7 nf=1
X5 S54 G54 D54 B sky130_fd_pr__nfet_01v8 W=1.4 L=0.7 nf=1
X6 S38 G38 D38 B sky130_fd_pr__nfet_01v8 W=1.4 L=0.7 nf=1
X7 S87 G87 D87 B sky130_fd_pr__nfet_01v8 W=1.4 L=0.7 nf=1
X8 S8 G8 D8 B sky130_fd_pr__nfet_01v8 W=1.4 L=0.7 nf=1
X9 S2 G2 D2 B sky130_fd_pr__nfet_01v8 W=1.4 L=0.7 nf=1
X10 S66 G66 D66 B sky130_fd_pr__nfet_01v8 W=1.4 L=0.7 nf=1
X11 S31 G31 D31 B sky130_fd_pr__nfet_01v8 W=1.4 L=0.7 nf=1
X12 S24 G24 D24 B sky130_fd_pr__nfet_01v8 W=1.4 L=0.7 nf=1
X13 S88 G88 D88 B sky130_fd_pr__nfet_01v8 W=1.4 L=0.7 nf=1
X14 S71 G71 D71 B sky130_fd_pr__nfet_01v8 W=1.4 L=0.7 nf=1
X15 S7 G7 D7 B sky130_fd_pr__nfet_01v8 W=1.4 L=0.7 nf=1
X16 S78 G78 D78 B sky130_fd_pr__nfet_01v8 W=1.4 L=0.7 nf=1
X17 S62 G62 D62 B sky130_fd_pr__nfet_01v8 W=1.4 L=0.7 nf=1
X18 S17 G17 D17 B sky130_fd_pr__nfet_01v8 W=1.4 L=0.7 nf=1
X19 S35 G35 D35 B sky130_fd_pr__nfet_01v8 W=1.4 L=0.7 nf=1
X20 S53 G53 D53 B sky130_fd_pr__nfet_01v8 W=1.4 L=0.7 nf=1
X21 S21 G21 D21 B sky130_fd_pr__nfet_01v8 W=1.4 L=0.7 nf=1
X22 S74 G74 D74 B sky130_fd_pr__nfet_01v8 W=1.4 L=0.7 nf=1
X23 S65 G65 D65 B sky130_fd_pr__nfet_01v8 W=1.4 L=0.7 nf=1
X24 S39 G39 D39 B sky130_fd_pr__nfet_01v8 W=1.4 L=0.7 nf=1
X25 S86 G86 D86 B sky130_fd_pr__nfet_01v8 W=1.4 L=0.7 nf=1
X26 S32 G32 D32 B sky130_fd_pr__nfet_01v8 W=1.4 L=0.7 nf=1
X27 S9 G9 D9 B sky130_fd_pr__nfet_01v8 W=1.4 L=0.7 nf=1
X28 S25 G25 D25 B sky130_fd_pr__nfet_01v8 W=1.4 L=0.7 nf=1
X29 S3 G3 D3 B sky130_fd_pr__nfet_01v8 W=1.4 L=0.7 nf=1
X30 S92 G92 D92 B sky130_fd_pr__nfet_01v8 W=1.4 L=0.7 nf=1
X31 S70 G70 D70 B sky130_fd_pr__nfet_01v8 W=1.4 L=0.7 nf=1
X32 S61 G61 D61 B sky130_fd_pr__nfet_01v8 W=1.4 L=0.7 nf=1
X33 S43 G43 D43 B sky130_fd_pr__nfet_01v8 W=1.4 L=0.7 nf=1
X34 S36 G36 D36 B sky130_fd_pr__nfet_01v8 W=1.4 L=0.7 nf=1
X35 S13 G13 D13 B sky130_fd_pr__nfet_01v8 W=1.4 L=0.7 nf=1
X36 S82 G82 D82 B sky130_fd_pr__nfet_01v8 W=1.4 L=0.7 nf=1
X37 S22 G22 D22 B sky130_fd_pr__nfet_01v8 W=1.4 L=0.7 nf=1
X38 S95 G95 D95 B sky130_fd_pr__nfet_01v8 W=1.4 L=0.7 nf=1
X39 S73 G73 D73 B sky130_fd_pr__nfet_01v8 W=1.4 L=0.7 nf=1
X40 S57 G57 D57 B sky130_fd_pr__nfet_01v8 W=1.4 L=0.7 nf=1
X41 S40 G40 D40 B sky130_fd_pr__nfet_01v8 W=1.4 L=0.7 nf=1
X42 S10 G10 D10 B sky130_fd_pr__nfet_01v8 W=1.4 L=0.7 nf=1
X43 S85 G85 D85 B sky130_fd_pr__nfet_01v8 W=1.4 L=0.7 nf=1
X44 S64 G64 D64 B sky130_fd_pr__nfet_01v8 W=1.4 L=0.7 nf=1
X45 S28 G28 D28 B sky130_fd_pr__nfet_01v8 W=1.4 L=0.7 nf=1
X46 S69 G69 D69 B sky130_fd_pr__nfet_01v8 W=1.4 L=0.7 nf=1
X47 S52 G52 D52 B sky130_fd_pr__nfet_01v8 W=1.4 L=0.7 nf=1
X48 S26 G26 D26 B sky130_fd_pr__nfet_01v8 W=1.4 L=0.7 nf=1
X49 S4 G4 D4 B sky130_fd_pr__nfet_01v8 W=1.4 L=0.7 nf=1
X50 S91 G91 D91 B sky130_fd_pr__nfet_01v8 W=1.4 L=0.7 nf=1
X51 S44 G44 D44 B sky130_fd_pr__nfet_01v8 W=1.4 L=0.7 nf=1
X52 S14 G14 D14 B sky130_fd_pr__nfet_01v8 W=1.4 L=0.7 nf=1
X53 S81 G81 D81 B sky130_fd_pr__nfet_01v8 W=1.4 L=0.7 nf=1
X54 S60 G60 D60 B sky130_fd_pr__nfet_01v8 W=1.4 L=0.7 nf=1
X55 S37 G37 D37 B sky130_fd_pr__nfet_01v8 W=1.4 L=0.7 nf=1
X56 S49 G49 D49 B sky130_fd_pr__nfet_01v8 W=1.4 L=0.7 nf=1
X57 S77 G77 D77 B sky130_fd_pr__nfet_01v8 W=1.4 L=0.7 nf=1
X58 S18 G18 D18 B sky130_fd_pr__nfet_01v8 W=1.4 L=0.7 nf=1
X59 S94 G94 D94 B sky130_fd_pr__nfet_01v8 W=1.4 L=0.7 nf=1
X60 S63 G63 D63 B sky130_fd_pr__nfet_01v8 W=1.4 L=0.7 nf=1
X61 S56 G56 D56 B sky130_fd_pr__nfet_01v8 W=1.4 L=0.7 nf=1
X62 S51 G51 D51 B sky130_fd_pr__nfet_01v8 W=1.4 L=0.7 nf=1
X63 S41 G41 D41 B sky130_fd_pr__nfet_01v8 W=1.4 L=0.7 nf=1
X64 S11 G11 D11 B sky130_fd_pr__nfet_01v8 W=1.4 L=0.7 nf=1
X65 S0 G0 D0 B sky130_fd_pr__nfet_01v8 W=1.4 L=0.7 nf=1
X66 S84 G84 D84 B sky130_fd_pr__nfet_01v8 W=1.4 L=0.7 nf=1
X67 S29 G29 D29 B sky130_fd_pr__nfet_01v8 W=1.4 L=0.7 nf=1
X68 S68 G68 D68 B sky130_fd_pr__nfet_01v8 W=1.4 L=0.7 nf=1
X69 S27 G27 D27 B sky130_fd_pr__nfet_01v8 W=1.4 L=0.7 nf=1
X70 S5 G5 D5 B sky130_fd_pr__nfet_01v8 W=1.4 L=0.7 nf=1
X71 S90 G90 D90 B sky130_fd_pr__nfet_01v8 W=1.4 L=0.7 nf=1
X72 S59 G59 D59 B sky130_fd_pr__nfet_01v8 W=1.4 L=0.7 nf=1
X73 S46 G46 D46 B sky130_fd_pr__nfet_01v8 W=1.4 L=0.7 nf=1
X74 S45 G45 D45 B sky130_fd_pr__nfet_01v8 W=1.4 L=0.7 nf=1
X75 S15 G15 D15 B sky130_fd_pr__nfet_01v8 W=1.4 L=0.7 nf=1
X76 S80 G80 D80 B sky130_fd_pr__nfet_01v8 W=1.4 L=0.7 nf=1
X77 S33 G33 D33 B sky130_fd_pr__nfet_01v8 W=1.4 L=0.7 nf=1
X78 S55 G55 D55 B sky130_fd_pr__nfet_01v8 W=1.4 L=0.7 nf=1
X79 S93 G93 D93 B sky130_fd_pr__nfet_01v8 W=1.4 L=0.7 nf=1
X80 S83 G83 D83 B sky130_fd_pr__nfet_01v8 W=1.4 L=0.7 nf=1
X81 S76 G76 D76 B sky130_fd_pr__nfet_01v8 W=1.4 L=0.7 nf=1
X82 S48 G48 D48 B sky130_fd_pr__nfet_01v8 W=1.4 L=0.7 nf=1
X83 S42 G42 D42 B sky130_fd_pr__nfet_01v8 W=1.4 L=0.7 nf=1
X84 S19 G19 D19 B sky130_fd_pr__nfet_01v8 W=1.4 L=0.7 nf=1
X85 S12 G12 D12 B sky130_fd_pr__nfet_01v8 W=1.4 L=0.7 nf=1
X86 S67 G67 D67 B sky130_fd_pr__nfet_01v8 W=1.4 L=0.7 nf=1
X87 S50 G50 D50 B sky130_fd_pr__nfet_01v8 W=1.4 L=0.7 nf=1
X88 S30 G30 D30 B sky130_fd_pr__nfet_01v8 W=1.4 L=0.7 nf=1
X89 S1 G1 D1 B sky130_fd_pr__nfet_01v8 W=1.4 L=0.7 nf=1
X90 S89 G89 D89 B sky130_fd_pr__nfet_01v8 W=1.4 L=0.7 nf=1
X91 S23 G23 D23 B sky130_fd_pr__nfet_01v8 W=1.4 L=0.7 nf=1
X92 S6 G6 D6 B sky130_fd_pr__nfet_01v8 W=1.4 L=0.7 nf=1
X93 S79 G79 D79 B sky130_fd_pr__nfet_01v8 W=1.4 L=0.7 nf=1
X94 S72 G72 D72 B sky130_fd_pr__nfet_01v8 W=1.4 L=0.7 nf=1
X95 S16 G16 D16 B sky130_fd_pr__nfet_01v8 W=1.4 L=0.7 nf=1
.ends
