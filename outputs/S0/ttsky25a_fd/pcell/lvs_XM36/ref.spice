.subckt XM36 D G S B
XXM36 D G S B sky130_fd_pr__nfet_01v8_lvt L=2 W=5 nf=1 m=2
.ends
