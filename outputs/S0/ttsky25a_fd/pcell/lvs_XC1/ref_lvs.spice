.subckt XC1 C2_0 C1_0 C2_1 C1_1 C2_2 C1_2 C2_3 C1_3
XXC1 C2_0 C1_0 C2_1 C1_1 C2_2 C1_2 C2_3 C1_3 sky130_fd_pr__cap_mim_m3_1 W=10 L=10 MF=5
.ends
