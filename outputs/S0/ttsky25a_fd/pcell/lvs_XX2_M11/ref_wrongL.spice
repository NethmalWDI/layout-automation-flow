.subckt XX2_M11 D G S B
XXX2_M11 D G S B sky130_fd_pr__nfet_01v8_lvt L=1.1 W=0.6 nf=1 m=2
.ends
