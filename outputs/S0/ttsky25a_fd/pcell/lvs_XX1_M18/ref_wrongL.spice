.subckt XX1_M18 D G S B
XXX1_M18 D G S B sky130_fd_pr__nfet_01v8_lvt L=20.1 W=5 nf=1 m=2
.ends
