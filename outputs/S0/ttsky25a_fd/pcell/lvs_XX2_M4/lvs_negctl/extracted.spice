* NGSPICE file created from sky130_fd_pr__pfet_01v8_lvt_TH4544.ext - technology: sky130A

.subckt sky130_fd_pr__pfet_01v8_lvt_TH4544 B D0 S0 G0 D1 S1 G1 D2 S2 G2 D3 S3 G3 D4
+ S4 G4 D5 S5 G5 D6 S6 G6 D7 S7 G7 D8 S8 G8
X0 S0 G0 D0 B sky130_fd_pr__pfet_01v8_lvt ad=0.58 pd=4.58 as=0.58 ps=4.58 w=2 l=1
X1 S4 G4 D4 B sky130_fd_pr__pfet_01v8_lvt ad=0.58 pd=4.58 as=0.58 ps=4.58 w=2 l=1
X2 S8 G8 D8 B sky130_fd_pr__pfet_01v8_lvt ad=0.58 pd=4.58 as=0.58 ps=4.58 w=2 l=1
X3 S3 G3 D3 B sky130_fd_pr__pfet_01v8_lvt ad=0.58 pd=4.58 as=0.58 ps=4.58 w=2 l=1
X4 S2 G2 D2 B sky130_fd_pr__pfet_01v8_lvt ad=0.58 pd=4.58 as=0.58 ps=4.58 w=2 l=1
X5 S6 G6 D6 B sky130_fd_pr__pfet_01v8_lvt ad=0.58 pd=4.58 as=0.58 ps=4.58 w=2 l=1
X6 S1 G1 D1 B sky130_fd_pr__pfet_01v8_lvt ad=0.58 pd=4.58 as=0.58 ps=4.58 w=2 l=1
X7 S7 G7 D7 B sky130_fd_pr__pfet_01v8_lvt ad=0.58 pd=4.58 as=0.58 ps=4.58 w=2 l=1
X8 S5 G5 D5 B sky130_fd_pr__pfet_01v8_lvt ad=0.58 pd=4.58 as=0.58 ps=4.58 w=2 l=1
.ends
