.subckt XM35 D G S B
XXM35 D G S B sky130_fd_pr__nfet_01v8_lvt L=1.1 W=10 nf=1 m=2
.ends
