.subckt XX1_M25 D G S B
XXX1_M25 D G S B sky130_fd_pr__pfet_01v8_lvt L=10 W=1.5 nf=1 m=2
.ends
