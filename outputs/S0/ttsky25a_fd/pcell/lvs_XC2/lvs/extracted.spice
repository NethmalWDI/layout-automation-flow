* NGSPICE file created from sky130_fd_pr__cap_mim_m3_1_DHLNXX.ext - technology: sky130A

.subckt sky130_fd_pr__cap_mim_m3_1_DHLNXX C2_0 C1_0 C2_1 C1_1 C2_2 C1_2 C2_3 C1_3
+ C2_4 C1_4
X0 C1_0 C2_0 sky130_fd_pr__cap_mim_m3_1 l=10 w=10
X1 C1_2 C2_2 sky130_fd_pr__cap_mim_m3_1 l=10 w=10
X2 C1_3 C2_3 sky130_fd_pr__cap_mim_m3_1 l=10 w=10
X3 C1_1 C2_1 sky130_fd_pr__cap_mim_m3_1 l=10 w=10
X4 C1_4 C2_4 sky130_fd_pr__cap_mim_m3_1 l=10 w=10
.ends
