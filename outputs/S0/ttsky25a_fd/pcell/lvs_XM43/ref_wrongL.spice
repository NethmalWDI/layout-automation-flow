.subckt XM43 D G S B
XXM43 D G S B sky130_fd_pr__pfet_01v8_lvt L=1.1 W=5 nf=1 m=2
.ends
