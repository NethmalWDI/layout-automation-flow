.subckt XX2_X1_R10 B R1 R2
XXX2_X1_R10 B R1 R2 sky130_fd_pr__res_generic_po W=0.5 L=41
.ends
