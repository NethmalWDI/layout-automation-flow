.subckt XX2_M7 D G S B
XXX2_M7 D G S B sky130_fd_pr__pfet_01v8_lvt L=10.1 W=1 nf=1 m=2
.ends
