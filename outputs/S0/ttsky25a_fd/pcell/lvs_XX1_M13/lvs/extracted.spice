* NGSPICE file created from sky130_fd_pr__pfet_01v8_lvt_KLBTN5.ext - technology: sky130A

.subckt sky130_fd_pr__pfet_01v8_lvt_KLBTN5 B D0 S0 G0 D1 S1 G1 D2 S2 G2 D3 S3 G3
X0 S1 G1 D1 B sky130_fd_pr__pfet_01v8_lvt ad=0.58 pd=4.58 as=0.58 ps=4.58 w=2 l=5
X1 S0 G0 D0 B sky130_fd_pr__pfet_01v8_lvt ad=0.58 pd=4.58 as=0.58 ps=4.58 w=2 l=5
X2 S3 G3 D3 B sky130_fd_pr__pfet_01v8_lvt ad=0.58 pd=4.58 as=0.58 ps=4.58 w=2 l=5
X3 S2 G2 D2 B sky130_fd_pr__pfet_01v8_lvt ad=0.58 pd=4.58 as=0.58 ps=4.58 w=2 l=5
.ends
