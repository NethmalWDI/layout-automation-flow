.subckt XX1_M14 B D0 S0 G0 D1 S1 G1 D2 S2 G2 D3 S3 G3
X0 S1 G1 D1 B sky130_fd_pr__pfet_01v8_lvt W=2 L=5 nf=1
X1 S0 G0 D0 B sky130_fd_pr__pfet_01v8_lvt W=2 L=5 nf=1
X2 S3 G3 D3 B sky130_fd_pr__pfet_01v8_lvt W=2 L=5 nf=1
X3 S2 G2 D2 B sky130_fd_pr__pfet_01v8_lvt W=2 L=5 nf=1
.ends
