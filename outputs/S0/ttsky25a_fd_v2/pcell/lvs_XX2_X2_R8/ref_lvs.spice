.subckt XX2_X2_R8 B R1 R2
X0 R1 R2 sky130_fd_pr__res_generic_po W=0.5 L=40
.ends
