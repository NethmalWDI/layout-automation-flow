.subckt XX2_M10 B D0 S0 G0 D1 S1 G1
X0 S1 G1 D1 B sky130_fd_pr__nfet_01v8_lvt W=0.6 L=1.1 nf=1
X1 S0 G0 D0 B sky130_fd_pr__nfet_01v8_lvt W=0.6 L=1.1 nf=1
.ends
