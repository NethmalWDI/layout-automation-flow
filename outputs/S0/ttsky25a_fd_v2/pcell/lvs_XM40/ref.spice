.subckt XM40 D G S B
XXM40 D G S B sky130_fd_pr__nfet_01v8_lvt L=1 W=2 nf=1
.ends
