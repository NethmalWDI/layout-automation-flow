* NGSPICE file created from sky130_fd_pr__res_generic_po_AZWUY8.ext - technology: sky130A

.subckt sky130_fd_pr__res_generic_po_AZWUY8 B R1 R2
X0 R1 R2 sky130_fd_pr__res_generic_po w=0.5 l=40
.ends
