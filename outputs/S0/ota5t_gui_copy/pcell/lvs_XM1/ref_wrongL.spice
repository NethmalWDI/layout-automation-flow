.subckt XM1 D G S B
XXM1 D G S B sky130_fd_pr__nfet_01v8 L=0.6 W=24 nf=1
.ends
